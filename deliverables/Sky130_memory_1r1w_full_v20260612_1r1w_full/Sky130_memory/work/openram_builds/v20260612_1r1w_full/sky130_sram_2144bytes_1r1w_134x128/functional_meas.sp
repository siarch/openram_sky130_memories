.meas tran vdout1_0ck40 FIND v(dout1_0) AT=50.05n

.meas tran vdout1_1ck40 FIND v(dout1_1) AT=50.05n

.meas tran vdout1_2ck40 FIND v(dout1_2) AT=50.05n

.meas tran vdout1_3ck40 FIND v(dout1_3) AT=50.05n

.meas tran vdout1_4ck40 FIND v(dout1_4) AT=50.05n

.meas tran vdout1_5ck40 FIND v(dout1_5) AT=50.05n

.meas tran vdout1_6ck40 FIND v(dout1_6) AT=50.05n

.meas tran vdout1_7ck40 FIND v(dout1_7) AT=50.05n

.meas tran vdout1_8ck40 FIND v(dout1_8) AT=50.05n

.meas tran vdout1_9ck40 FIND v(dout1_9) AT=50.05n

.meas tran vdout1_10ck40 FIND v(dout1_10) AT=50.05n

.meas tran vdout1_11ck40 FIND v(dout1_11) AT=50.05n

.meas tran vdout1_12ck40 FIND v(dout1_12) AT=50.05n

.meas tran vdout1_13ck40 FIND v(dout1_13) AT=50.05n

.meas tran vdout1_14ck40 FIND v(dout1_14) AT=50.05n

.meas tran vdout1_15ck40 FIND v(dout1_15) AT=50.05n

.meas tran vdout1_16ck40 FIND v(dout1_16) AT=50.05n

.meas tran vdout1_17ck40 FIND v(dout1_17) AT=50.05n

.meas tran vdout1_18ck40 FIND v(dout1_18) AT=50.05n

.meas tran vdout1_19ck40 FIND v(dout1_19) AT=50.05n

.meas tran vdout1_20ck40 FIND v(dout1_20) AT=50.05n

.meas tran vdout1_21ck40 FIND v(dout1_21) AT=50.05n

.meas tran vdout1_22ck40 FIND v(dout1_22) AT=50.05n

.meas tran vdout1_23ck40 FIND v(dout1_23) AT=50.05n

.meas tran vdout1_24ck40 FIND v(dout1_24) AT=50.05n

.meas tran vdout1_25ck40 FIND v(dout1_25) AT=50.05n

.meas tran vdout1_26ck40 FIND v(dout1_26) AT=50.05n

.meas tran vdout1_27ck40 FIND v(dout1_27) AT=50.05n

.meas tran vdout1_28ck40 FIND v(dout1_28) AT=50.05n

.meas tran vdout1_29ck40 FIND v(dout1_29) AT=50.05n

.meas tran vdout1_30ck40 FIND v(dout1_30) AT=50.05n

.meas tran vdout1_31ck40 FIND v(dout1_31) AT=50.05n

.meas tran vdout1_32ck40 FIND v(dout1_32) AT=50.05n

.meas tran vdout1_33ck40 FIND v(dout1_33) AT=50.05n

.meas tran vdout1_34ck40 FIND v(dout1_34) AT=50.05n

.meas tran vdout1_35ck40 FIND v(dout1_35) AT=50.05n

.meas tran vdout1_36ck40 FIND v(dout1_36) AT=50.05n

.meas tran vdout1_37ck40 FIND v(dout1_37) AT=50.05n

.meas tran vdout1_38ck40 FIND v(dout1_38) AT=50.05n

.meas tran vdout1_39ck40 FIND v(dout1_39) AT=50.05n

.meas tran vdout1_40ck40 FIND v(dout1_40) AT=50.05n

.meas tran vdout1_41ck40 FIND v(dout1_41) AT=50.05n

.meas tran vdout1_42ck40 FIND v(dout1_42) AT=50.05n

.meas tran vdout1_43ck40 FIND v(dout1_43) AT=50.05n

.meas tran vdout1_44ck40 FIND v(dout1_44) AT=50.05n

.meas tran vdout1_45ck40 FIND v(dout1_45) AT=50.05n

.meas tran vdout1_46ck40 FIND v(dout1_46) AT=50.05n

.meas tran vdout1_47ck40 FIND v(dout1_47) AT=50.05n

.meas tran vdout1_48ck40 FIND v(dout1_48) AT=50.05n

.meas tran vdout1_49ck40 FIND v(dout1_49) AT=50.05n

.meas tran vdout1_50ck40 FIND v(dout1_50) AT=50.05n

.meas tran vdout1_51ck40 FIND v(dout1_51) AT=50.05n

.meas tran vdout1_52ck40 FIND v(dout1_52) AT=50.05n

.meas tran vdout1_53ck40 FIND v(dout1_53) AT=50.05n

.meas tran vdout1_54ck40 FIND v(dout1_54) AT=50.05n

.meas tran vdout1_55ck40 FIND v(dout1_55) AT=50.05n

.meas tran vdout1_56ck40 FIND v(dout1_56) AT=50.05n

.meas tran vdout1_57ck40 FIND v(dout1_57) AT=50.05n

.meas tran vdout1_58ck40 FIND v(dout1_58) AT=50.05n

.meas tran vdout1_59ck40 FIND v(dout1_59) AT=50.05n

.meas tran vdout1_60ck40 FIND v(dout1_60) AT=50.05n

.meas tran vdout1_61ck40 FIND v(dout1_61) AT=50.05n

.meas tran vdout1_62ck40 FIND v(dout1_62) AT=50.05n

.meas tran vdout1_63ck40 FIND v(dout1_63) AT=50.05n

.meas tran vdout1_64ck40 FIND v(dout1_64) AT=50.05n

.meas tran vdout1_65ck40 FIND v(dout1_65) AT=50.05n

.meas tran vdout1_66ck40 FIND v(dout1_66) AT=50.05n

.meas tran vdout1_67ck40 FIND v(dout1_67) AT=50.05n

.meas tran vdout1_68ck40 FIND v(dout1_68) AT=50.05n

.meas tran vdout1_69ck40 FIND v(dout1_69) AT=50.05n

.meas tran vdout1_70ck40 FIND v(dout1_70) AT=50.05n

.meas tran vdout1_71ck40 FIND v(dout1_71) AT=50.05n

.meas tran vdout1_72ck40 FIND v(dout1_72) AT=50.05n

.meas tran vdout1_73ck40 FIND v(dout1_73) AT=50.05n

.meas tran vdout1_74ck40 FIND v(dout1_74) AT=50.05n

.meas tran vdout1_75ck40 FIND v(dout1_75) AT=50.05n

.meas tran vdout1_76ck40 FIND v(dout1_76) AT=50.05n

.meas tran vdout1_77ck40 FIND v(dout1_77) AT=50.05n

.meas tran vdout1_78ck40 FIND v(dout1_78) AT=50.05n

.meas tran vdout1_79ck40 FIND v(dout1_79) AT=50.05n

.meas tran vdout1_80ck40 FIND v(dout1_80) AT=50.05n

.meas tran vdout1_81ck40 FIND v(dout1_81) AT=50.05n

.meas tran vdout1_82ck40 FIND v(dout1_82) AT=50.05n

.meas tran vdout1_83ck40 FIND v(dout1_83) AT=50.05n

.meas tran vdout1_84ck40 FIND v(dout1_84) AT=50.05n

.meas tran vdout1_85ck40 FIND v(dout1_85) AT=50.05n

.meas tran vdout1_86ck40 FIND v(dout1_86) AT=50.05n

.meas tran vdout1_87ck40 FIND v(dout1_87) AT=50.05n

.meas tran vdout1_88ck40 FIND v(dout1_88) AT=50.05n

.meas tran vdout1_89ck40 FIND v(dout1_89) AT=50.05n

.meas tran vdout1_90ck40 FIND v(dout1_90) AT=50.05n

.meas tran vdout1_91ck40 FIND v(dout1_91) AT=50.05n

.meas tran vdout1_92ck40 FIND v(dout1_92) AT=50.05n

.meas tran vdout1_93ck40 FIND v(dout1_93) AT=50.05n

.meas tran vdout1_94ck40 FIND v(dout1_94) AT=50.05n

.meas tran vdout1_95ck40 FIND v(dout1_95) AT=50.05n

.meas tran vdout1_96ck40 FIND v(dout1_96) AT=50.05n

.meas tran vdout1_97ck40 FIND v(dout1_97) AT=50.05n

.meas tran vdout1_98ck40 FIND v(dout1_98) AT=50.05n

.meas tran vdout1_99ck40 FIND v(dout1_99) AT=50.05n

.meas tran vdout1_100ck40 FIND v(dout1_100) AT=50.05n

.meas tran vdout1_101ck40 FIND v(dout1_101) AT=50.05n

.meas tran vdout1_102ck40 FIND v(dout1_102) AT=50.05n

.meas tran vdout1_103ck40 FIND v(dout1_103) AT=50.05n

.meas tran vdout1_104ck40 FIND v(dout1_104) AT=50.05n

.meas tran vdout1_105ck40 FIND v(dout1_105) AT=50.05n

.meas tran vdout1_106ck40 FIND v(dout1_106) AT=50.05n

.meas tran vdout1_107ck40 FIND v(dout1_107) AT=50.05n

.meas tran vdout1_108ck40 FIND v(dout1_108) AT=50.05n

.meas tran vdout1_109ck40 FIND v(dout1_109) AT=50.05n

.meas tran vdout1_110ck40 FIND v(dout1_110) AT=50.05n

.meas tran vdout1_111ck40 FIND v(dout1_111) AT=50.05n

.meas tran vdout1_112ck40 FIND v(dout1_112) AT=50.05n

.meas tran vdout1_113ck40 FIND v(dout1_113) AT=50.05n

.meas tran vdout1_114ck40 FIND v(dout1_114) AT=50.05n

.meas tran vdout1_115ck40 FIND v(dout1_115) AT=50.05n

.meas tran vdout1_116ck40 FIND v(dout1_116) AT=50.05n

.meas tran vdout1_117ck40 FIND v(dout1_117) AT=50.05n

.meas tran vdout1_118ck40 FIND v(dout1_118) AT=50.05n

.meas tran vdout1_119ck40 FIND v(dout1_119) AT=50.05n

.meas tran vdout1_120ck40 FIND v(dout1_120) AT=50.05n

.meas tran vdout1_121ck40 FIND v(dout1_121) AT=50.05n

.meas tran vdout1_122ck40 FIND v(dout1_122) AT=50.05n

.meas tran vdout1_123ck40 FIND v(dout1_123) AT=50.05n

.meas tran vdout1_124ck40 FIND v(dout1_124) AT=50.05n

.meas tran vdout1_125ck40 FIND v(dout1_125) AT=50.05n

.meas tran vdout1_126ck40 FIND v(dout1_126) AT=50.05n

.meas tran vdout1_127ck40 FIND v(dout1_127) AT=50.05n

.meas tran vdout1_128ck40 FIND v(dout1_128) AT=50.05n

.meas tran vdout1_129ck40 FIND v(dout1_129) AT=50.05n

.meas tran vdout1_130ck40 FIND v(dout1_130) AT=50.05n

.meas tran vdout1_131ck40 FIND v(dout1_131) AT=50.05n

.meas tran vdout1_132ck40 FIND v(dout1_132) AT=50.05n

.meas tran vdout1_133ck40 FIND v(dout1_133) AT=50.05n

.meas tran vdout1_134ck40 FIND v(dout1_134) AT=50.05n

.meas tran vdout1_0ck50 FIND v(dout1_0) AT=60.05n

.meas tran vdout1_1ck50 FIND v(dout1_1) AT=60.05n

.meas tran vdout1_2ck50 FIND v(dout1_2) AT=60.05n

.meas tran vdout1_3ck50 FIND v(dout1_3) AT=60.05n

.meas tran vdout1_4ck50 FIND v(dout1_4) AT=60.05n

.meas tran vdout1_5ck50 FIND v(dout1_5) AT=60.05n

.meas tran vdout1_6ck50 FIND v(dout1_6) AT=60.05n

.meas tran vdout1_7ck50 FIND v(dout1_7) AT=60.05n

.meas tran vdout1_8ck50 FIND v(dout1_8) AT=60.05n

.meas tran vdout1_9ck50 FIND v(dout1_9) AT=60.05n

.meas tran vdout1_10ck50 FIND v(dout1_10) AT=60.05n

.meas tran vdout1_11ck50 FIND v(dout1_11) AT=60.05n

.meas tran vdout1_12ck50 FIND v(dout1_12) AT=60.05n

.meas tran vdout1_13ck50 FIND v(dout1_13) AT=60.05n

.meas tran vdout1_14ck50 FIND v(dout1_14) AT=60.05n

.meas tran vdout1_15ck50 FIND v(dout1_15) AT=60.05n

.meas tran vdout1_16ck50 FIND v(dout1_16) AT=60.05n

.meas tran vdout1_17ck50 FIND v(dout1_17) AT=60.05n

.meas tran vdout1_18ck50 FIND v(dout1_18) AT=60.05n

.meas tran vdout1_19ck50 FIND v(dout1_19) AT=60.05n

.meas tran vdout1_20ck50 FIND v(dout1_20) AT=60.05n

.meas tran vdout1_21ck50 FIND v(dout1_21) AT=60.05n

.meas tran vdout1_22ck50 FIND v(dout1_22) AT=60.05n

.meas tran vdout1_23ck50 FIND v(dout1_23) AT=60.05n

.meas tran vdout1_24ck50 FIND v(dout1_24) AT=60.05n

.meas tran vdout1_25ck50 FIND v(dout1_25) AT=60.05n

.meas tran vdout1_26ck50 FIND v(dout1_26) AT=60.05n

.meas tran vdout1_27ck50 FIND v(dout1_27) AT=60.05n

.meas tran vdout1_28ck50 FIND v(dout1_28) AT=60.05n

.meas tran vdout1_29ck50 FIND v(dout1_29) AT=60.05n

.meas tran vdout1_30ck50 FIND v(dout1_30) AT=60.05n

.meas tran vdout1_31ck50 FIND v(dout1_31) AT=60.05n

.meas tran vdout1_32ck50 FIND v(dout1_32) AT=60.05n

.meas tran vdout1_33ck50 FIND v(dout1_33) AT=60.05n

.meas tran vdout1_34ck50 FIND v(dout1_34) AT=60.05n

.meas tran vdout1_35ck50 FIND v(dout1_35) AT=60.05n

.meas tran vdout1_36ck50 FIND v(dout1_36) AT=60.05n

.meas tran vdout1_37ck50 FIND v(dout1_37) AT=60.05n

.meas tran vdout1_38ck50 FIND v(dout1_38) AT=60.05n

.meas tran vdout1_39ck50 FIND v(dout1_39) AT=60.05n

.meas tran vdout1_40ck50 FIND v(dout1_40) AT=60.05n

.meas tran vdout1_41ck50 FIND v(dout1_41) AT=60.05n

.meas tran vdout1_42ck50 FIND v(dout1_42) AT=60.05n

.meas tran vdout1_43ck50 FIND v(dout1_43) AT=60.05n

.meas tran vdout1_44ck50 FIND v(dout1_44) AT=60.05n

.meas tran vdout1_45ck50 FIND v(dout1_45) AT=60.05n

.meas tran vdout1_46ck50 FIND v(dout1_46) AT=60.05n

.meas tran vdout1_47ck50 FIND v(dout1_47) AT=60.05n

.meas tran vdout1_48ck50 FIND v(dout1_48) AT=60.05n

.meas tran vdout1_49ck50 FIND v(dout1_49) AT=60.05n

.meas tran vdout1_50ck50 FIND v(dout1_50) AT=60.05n

.meas tran vdout1_51ck50 FIND v(dout1_51) AT=60.05n

.meas tran vdout1_52ck50 FIND v(dout1_52) AT=60.05n

.meas tran vdout1_53ck50 FIND v(dout1_53) AT=60.05n

.meas tran vdout1_54ck50 FIND v(dout1_54) AT=60.05n

.meas tran vdout1_55ck50 FIND v(dout1_55) AT=60.05n

.meas tran vdout1_56ck50 FIND v(dout1_56) AT=60.05n

.meas tran vdout1_57ck50 FIND v(dout1_57) AT=60.05n

.meas tran vdout1_58ck50 FIND v(dout1_58) AT=60.05n

.meas tran vdout1_59ck50 FIND v(dout1_59) AT=60.05n

.meas tran vdout1_60ck50 FIND v(dout1_60) AT=60.05n

.meas tran vdout1_61ck50 FIND v(dout1_61) AT=60.05n

.meas tran vdout1_62ck50 FIND v(dout1_62) AT=60.05n

.meas tran vdout1_63ck50 FIND v(dout1_63) AT=60.05n

.meas tran vdout1_64ck50 FIND v(dout1_64) AT=60.05n

.meas tran vdout1_65ck50 FIND v(dout1_65) AT=60.05n

.meas tran vdout1_66ck50 FIND v(dout1_66) AT=60.05n

.meas tran vdout1_67ck50 FIND v(dout1_67) AT=60.05n

.meas tran vdout1_68ck50 FIND v(dout1_68) AT=60.05n

.meas tran vdout1_69ck50 FIND v(dout1_69) AT=60.05n

.meas tran vdout1_70ck50 FIND v(dout1_70) AT=60.05n

.meas tran vdout1_71ck50 FIND v(dout1_71) AT=60.05n

.meas tran vdout1_72ck50 FIND v(dout1_72) AT=60.05n

.meas tran vdout1_73ck50 FIND v(dout1_73) AT=60.05n

.meas tran vdout1_74ck50 FIND v(dout1_74) AT=60.05n

.meas tran vdout1_75ck50 FIND v(dout1_75) AT=60.05n

.meas tran vdout1_76ck50 FIND v(dout1_76) AT=60.05n

.meas tran vdout1_77ck50 FIND v(dout1_77) AT=60.05n

.meas tran vdout1_78ck50 FIND v(dout1_78) AT=60.05n

.meas tran vdout1_79ck50 FIND v(dout1_79) AT=60.05n

.meas tran vdout1_80ck50 FIND v(dout1_80) AT=60.05n

.meas tran vdout1_81ck50 FIND v(dout1_81) AT=60.05n

.meas tran vdout1_82ck50 FIND v(dout1_82) AT=60.05n

.meas tran vdout1_83ck50 FIND v(dout1_83) AT=60.05n

.meas tran vdout1_84ck50 FIND v(dout1_84) AT=60.05n

.meas tran vdout1_85ck50 FIND v(dout1_85) AT=60.05n

.meas tran vdout1_86ck50 FIND v(dout1_86) AT=60.05n

.meas tran vdout1_87ck50 FIND v(dout1_87) AT=60.05n

.meas tran vdout1_88ck50 FIND v(dout1_88) AT=60.05n

.meas tran vdout1_89ck50 FIND v(dout1_89) AT=60.05n

.meas tran vdout1_90ck50 FIND v(dout1_90) AT=60.05n

.meas tran vdout1_91ck50 FIND v(dout1_91) AT=60.05n

.meas tran vdout1_92ck50 FIND v(dout1_92) AT=60.05n

.meas tran vdout1_93ck50 FIND v(dout1_93) AT=60.05n

.meas tran vdout1_94ck50 FIND v(dout1_94) AT=60.05n

.meas tran vdout1_95ck50 FIND v(dout1_95) AT=60.05n

.meas tran vdout1_96ck50 FIND v(dout1_96) AT=60.05n

.meas tran vdout1_97ck50 FIND v(dout1_97) AT=60.05n

.meas tran vdout1_98ck50 FIND v(dout1_98) AT=60.05n

.meas tran vdout1_99ck50 FIND v(dout1_99) AT=60.05n

.meas tran vdout1_100ck50 FIND v(dout1_100) AT=60.05n

.meas tran vdout1_101ck50 FIND v(dout1_101) AT=60.05n

.meas tran vdout1_102ck50 FIND v(dout1_102) AT=60.05n

.meas tran vdout1_103ck50 FIND v(dout1_103) AT=60.05n

.meas tran vdout1_104ck50 FIND v(dout1_104) AT=60.05n

.meas tran vdout1_105ck50 FIND v(dout1_105) AT=60.05n

.meas tran vdout1_106ck50 FIND v(dout1_106) AT=60.05n

.meas tran vdout1_107ck50 FIND v(dout1_107) AT=60.05n

.meas tran vdout1_108ck50 FIND v(dout1_108) AT=60.05n

.meas tran vdout1_109ck50 FIND v(dout1_109) AT=60.05n

.meas tran vdout1_110ck50 FIND v(dout1_110) AT=60.05n

.meas tran vdout1_111ck50 FIND v(dout1_111) AT=60.05n

.meas tran vdout1_112ck50 FIND v(dout1_112) AT=60.05n

.meas tran vdout1_113ck50 FIND v(dout1_113) AT=60.05n

.meas tran vdout1_114ck50 FIND v(dout1_114) AT=60.05n

.meas tran vdout1_115ck50 FIND v(dout1_115) AT=60.05n

.meas tran vdout1_116ck50 FIND v(dout1_116) AT=60.05n

.meas tran vdout1_117ck50 FIND v(dout1_117) AT=60.05n

.meas tran vdout1_118ck50 FIND v(dout1_118) AT=60.05n

.meas tran vdout1_119ck50 FIND v(dout1_119) AT=60.05n

.meas tran vdout1_120ck50 FIND v(dout1_120) AT=60.05n

.meas tran vdout1_121ck50 FIND v(dout1_121) AT=60.05n

.meas tran vdout1_122ck50 FIND v(dout1_122) AT=60.05n

.meas tran vdout1_123ck50 FIND v(dout1_123) AT=60.05n

.meas tran vdout1_124ck50 FIND v(dout1_124) AT=60.05n

.meas tran vdout1_125ck50 FIND v(dout1_125) AT=60.05n

.meas tran vdout1_126ck50 FIND v(dout1_126) AT=60.05n

.meas tran vdout1_127ck50 FIND v(dout1_127) AT=60.05n

.meas tran vdout1_128ck50 FIND v(dout1_128) AT=60.05n

.meas tran vdout1_129ck50 FIND v(dout1_129) AT=60.05n

.meas tran vdout1_130ck50 FIND v(dout1_130) AT=60.05n

.meas tran vdout1_131ck50 FIND v(dout1_131) AT=60.05n

.meas tran vdout1_132ck50 FIND v(dout1_132) AT=60.05n

.meas tran vdout1_133ck50 FIND v(dout1_133) AT=60.05n

.meas tran vdout1_134ck50 FIND v(dout1_134) AT=60.05n

.meas tran vdout1_0ck120 FIND v(dout1_0) AT=130.05n

.meas tran vdout1_1ck120 FIND v(dout1_1) AT=130.05n

.meas tran vdout1_2ck120 FIND v(dout1_2) AT=130.05n

.meas tran vdout1_3ck120 FIND v(dout1_3) AT=130.05n

.meas tran vdout1_4ck120 FIND v(dout1_4) AT=130.05n

.meas tran vdout1_5ck120 FIND v(dout1_5) AT=130.05n

.meas tran vdout1_6ck120 FIND v(dout1_6) AT=130.05n

.meas tran vdout1_7ck120 FIND v(dout1_7) AT=130.05n

.meas tran vdout1_8ck120 FIND v(dout1_8) AT=130.05n

.meas tran vdout1_9ck120 FIND v(dout1_9) AT=130.05n

.meas tran vdout1_10ck120 FIND v(dout1_10) AT=130.05n

.meas tran vdout1_11ck120 FIND v(dout1_11) AT=130.05n

.meas tran vdout1_12ck120 FIND v(dout1_12) AT=130.05n

.meas tran vdout1_13ck120 FIND v(dout1_13) AT=130.05n

.meas tran vdout1_14ck120 FIND v(dout1_14) AT=130.05n

.meas tran vdout1_15ck120 FIND v(dout1_15) AT=130.05n

.meas tran vdout1_16ck120 FIND v(dout1_16) AT=130.05n

.meas tran vdout1_17ck120 FIND v(dout1_17) AT=130.05n

.meas tran vdout1_18ck120 FIND v(dout1_18) AT=130.05n

.meas tran vdout1_19ck120 FIND v(dout1_19) AT=130.05n

.meas tran vdout1_20ck120 FIND v(dout1_20) AT=130.05n

.meas tran vdout1_21ck120 FIND v(dout1_21) AT=130.05n

.meas tran vdout1_22ck120 FIND v(dout1_22) AT=130.05n

.meas tran vdout1_23ck120 FIND v(dout1_23) AT=130.05n

.meas tran vdout1_24ck120 FIND v(dout1_24) AT=130.05n

.meas tran vdout1_25ck120 FIND v(dout1_25) AT=130.05n

.meas tran vdout1_26ck120 FIND v(dout1_26) AT=130.05n

.meas tran vdout1_27ck120 FIND v(dout1_27) AT=130.05n

.meas tran vdout1_28ck120 FIND v(dout1_28) AT=130.05n

.meas tran vdout1_29ck120 FIND v(dout1_29) AT=130.05n

.meas tran vdout1_30ck120 FIND v(dout1_30) AT=130.05n

.meas tran vdout1_31ck120 FIND v(dout1_31) AT=130.05n

.meas tran vdout1_32ck120 FIND v(dout1_32) AT=130.05n

.meas tran vdout1_33ck120 FIND v(dout1_33) AT=130.05n

.meas tran vdout1_34ck120 FIND v(dout1_34) AT=130.05n

.meas tran vdout1_35ck120 FIND v(dout1_35) AT=130.05n

.meas tran vdout1_36ck120 FIND v(dout1_36) AT=130.05n

.meas tran vdout1_37ck120 FIND v(dout1_37) AT=130.05n

.meas tran vdout1_38ck120 FIND v(dout1_38) AT=130.05n

.meas tran vdout1_39ck120 FIND v(dout1_39) AT=130.05n

.meas tran vdout1_40ck120 FIND v(dout1_40) AT=130.05n

.meas tran vdout1_41ck120 FIND v(dout1_41) AT=130.05n

.meas tran vdout1_42ck120 FIND v(dout1_42) AT=130.05n

.meas tran vdout1_43ck120 FIND v(dout1_43) AT=130.05n

.meas tran vdout1_44ck120 FIND v(dout1_44) AT=130.05n

.meas tran vdout1_45ck120 FIND v(dout1_45) AT=130.05n

.meas tran vdout1_46ck120 FIND v(dout1_46) AT=130.05n

.meas tran vdout1_47ck120 FIND v(dout1_47) AT=130.05n

.meas tran vdout1_48ck120 FIND v(dout1_48) AT=130.05n

.meas tran vdout1_49ck120 FIND v(dout1_49) AT=130.05n

.meas tran vdout1_50ck120 FIND v(dout1_50) AT=130.05n

.meas tran vdout1_51ck120 FIND v(dout1_51) AT=130.05n

.meas tran vdout1_52ck120 FIND v(dout1_52) AT=130.05n

.meas tran vdout1_53ck120 FIND v(dout1_53) AT=130.05n

.meas tran vdout1_54ck120 FIND v(dout1_54) AT=130.05n

.meas tran vdout1_55ck120 FIND v(dout1_55) AT=130.05n

.meas tran vdout1_56ck120 FIND v(dout1_56) AT=130.05n

.meas tran vdout1_57ck120 FIND v(dout1_57) AT=130.05n

.meas tran vdout1_58ck120 FIND v(dout1_58) AT=130.05n

.meas tran vdout1_59ck120 FIND v(dout1_59) AT=130.05n

.meas tran vdout1_60ck120 FIND v(dout1_60) AT=130.05n

.meas tran vdout1_61ck120 FIND v(dout1_61) AT=130.05n

.meas tran vdout1_62ck120 FIND v(dout1_62) AT=130.05n

.meas tran vdout1_63ck120 FIND v(dout1_63) AT=130.05n

.meas tran vdout1_64ck120 FIND v(dout1_64) AT=130.05n

.meas tran vdout1_65ck120 FIND v(dout1_65) AT=130.05n

.meas tran vdout1_66ck120 FIND v(dout1_66) AT=130.05n

.meas tran vdout1_67ck120 FIND v(dout1_67) AT=130.05n

.meas tran vdout1_68ck120 FIND v(dout1_68) AT=130.05n

.meas tran vdout1_69ck120 FIND v(dout1_69) AT=130.05n

.meas tran vdout1_70ck120 FIND v(dout1_70) AT=130.05n

.meas tran vdout1_71ck120 FIND v(dout1_71) AT=130.05n

.meas tran vdout1_72ck120 FIND v(dout1_72) AT=130.05n

.meas tran vdout1_73ck120 FIND v(dout1_73) AT=130.05n

.meas tran vdout1_74ck120 FIND v(dout1_74) AT=130.05n

.meas tran vdout1_75ck120 FIND v(dout1_75) AT=130.05n

.meas tran vdout1_76ck120 FIND v(dout1_76) AT=130.05n

.meas tran vdout1_77ck120 FIND v(dout1_77) AT=130.05n

.meas tran vdout1_78ck120 FIND v(dout1_78) AT=130.05n

.meas tran vdout1_79ck120 FIND v(dout1_79) AT=130.05n

.meas tran vdout1_80ck120 FIND v(dout1_80) AT=130.05n

.meas tran vdout1_81ck120 FIND v(dout1_81) AT=130.05n

.meas tran vdout1_82ck120 FIND v(dout1_82) AT=130.05n

.meas tran vdout1_83ck120 FIND v(dout1_83) AT=130.05n

.meas tran vdout1_84ck120 FIND v(dout1_84) AT=130.05n

.meas tran vdout1_85ck120 FIND v(dout1_85) AT=130.05n

.meas tran vdout1_86ck120 FIND v(dout1_86) AT=130.05n

.meas tran vdout1_87ck120 FIND v(dout1_87) AT=130.05n

.meas tran vdout1_88ck120 FIND v(dout1_88) AT=130.05n

.meas tran vdout1_89ck120 FIND v(dout1_89) AT=130.05n

.meas tran vdout1_90ck120 FIND v(dout1_90) AT=130.05n

.meas tran vdout1_91ck120 FIND v(dout1_91) AT=130.05n

.meas tran vdout1_92ck120 FIND v(dout1_92) AT=130.05n

.meas tran vdout1_93ck120 FIND v(dout1_93) AT=130.05n

.meas tran vdout1_94ck120 FIND v(dout1_94) AT=130.05n

.meas tran vdout1_95ck120 FIND v(dout1_95) AT=130.05n

.meas tran vdout1_96ck120 FIND v(dout1_96) AT=130.05n

.meas tran vdout1_97ck120 FIND v(dout1_97) AT=130.05n

.meas tran vdout1_98ck120 FIND v(dout1_98) AT=130.05n

.meas tran vdout1_99ck120 FIND v(dout1_99) AT=130.05n

.meas tran vdout1_100ck120 FIND v(dout1_100) AT=130.05n

.meas tran vdout1_101ck120 FIND v(dout1_101) AT=130.05n

.meas tran vdout1_102ck120 FIND v(dout1_102) AT=130.05n

.meas tran vdout1_103ck120 FIND v(dout1_103) AT=130.05n

.meas tran vdout1_104ck120 FIND v(dout1_104) AT=130.05n

.meas tran vdout1_105ck120 FIND v(dout1_105) AT=130.05n

.meas tran vdout1_106ck120 FIND v(dout1_106) AT=130.05n

.meas tran vdout1_107ck120 FIND v(dout1_107) AT=130.05n

.meas tran vdout1_108ck120 FIND v(dout1_108) AT=130.05n

.meas tran vdout1_109ck120 FIND v(dout1_109) AT=130.05n

.meas tran vdout1_110ck120 FIND v(dout1_110) AT=130.05n

.meas tran vdout1_111ck120 FIND v(dout1_111) AT=130.05n

.meas tran vdout1_112ck120 FIND v(dout1_112) AT=130.05n

.meas tran vdout1_113ck120 FIND v(dout1_113) AT=130.05n

.meas tran vdout1_114ck120 FIND v(dout1_114) AT=130.05n

.meas tran vdout1_115ck120 FIND v(dout1_115) AT=130.05n

.meas tran vdout1_116ck120 FIND v(dout1_116) AT=130.05n

.meas tran vdout1_117ck120 FIND v(dout1_117) AT=130.05n

.meas tran vdout1_118ck120 FIND v(dout1_118) AT=130.05n

.meas tran vdout1_119ck120 FIND v(dout1_119) AT=130.05n

.meas tran vdout1_120ck120 FIND v(dout1_120) AT=130.05n

.meas tran vdout1_121ck120 FIND v(dout1_121) AT=130.05n

.meas tran vdout1_122ck120 FIND v(dout1_122) AT=130.05n

.meas tran vdout1_123ck120 FIND v(dout1_123) AT=130.05n

.meas tran vdout1_124ck120 FIND v(dout1_124) AT=130.05n

.meas tran vdout1_125ck120 FIND v(dout1_125) AT=130.05n

.meas tran vdout1_126ck120 FIND v(dout1_126) AT=130.05n

.meas tran vdout1_127ck120 FIND v(dout1_127) AT=130.05n

.meas tran vdout1_128ck120 FIND v(dout1_128) AT=130.05n

.meas tran vdout1_129ck120 FIND v(dout1_129) AT=130.05n

.meas tran vdout1_130ck120 FIND v(dout1_130) AT=130.05n

.meas tran vdout1_131ck120 FIND v(dout1_131) AT=130.05n

.meas tran vdout1_132ck120 FIND v(dout1_132) AT=130.05n

.meas tran vdout1_133ck120 FIND v(dout1_133) AT=130.05n

.meas tran vdout1_134ck120 FIND v(dout1_134) AT=130.05n

.meas tran vdout1_0ck250 FIND v(dout1_0) AT=260.05n

.meas tran vdout1_1ck250 FIND v(dout1_1) AT=260.05n

.meas tran vdout1_2ck250 FIND v(dout1_2) AT=260.05n

.meas tran vdout1_3ck250 FIND v(dout1_3) AT=260.05n

.meas tran vdout1_4ck250 FIND v(dout1_4) AT=260.05n

.meas tran vdout1_5ck250 FIND v(dout1_5) AT=260.05n

.meas tran vdout1_6ck250 FIND v(dout1_6) AT=260.05n

.meas tran vdout1_7ck250 FIND v(dout1_7) AT=260.05n

.meas tran vdout1_8ck250 FIND v(dout1_8) AT=260.05n

.meas tran vdout1_9ck250 FIND v(dout1_9) AT=260.05n

.meas tran vdout1_10ck250 FIND v(dout1_10) AT=260.05n

.meas tran vdout1_11ck250 FIND v(dout1_11) AT=260.05n

.meas tran vdout1_12ck250 FIND v(dout1_12) AT=260.05n

.meas tran vdout1_13ck250 FIND v(dout1_13) AT=260.05n

.meas tran vdout1_14ck250 FIND v(dout1_14) AT=260.05n

.meas tran vdout1_15ck250 FIND v(dout1_15) AT=260.05n

.meas tran vdout1_16ck250 FIND v(dout1_16) AT=260.05n

.meas tran vdout1_17ck250 FIND v(dout1_17) AT=260.05n

.meas tran vdout1_18ck250 FIND v(dout1_18) AT=260.05n

.meas tran vdout1_19ck250 FIND v(dout1_19) AT=260.05n

.meas tran vdout1_20ck250 FIND v(dout1_20) AT=260.05n

.meas tran vdout1_21ck250 FIND v(dout1_21) AT=260.05n

.meas tran vdout1_22ck250 FIND v(dout1_22) AT=260.05n

.meas tran vdout1_23ck250 FIND v(dout1_23) AT=260.05n

.meas tran vdout1_24ck250 FIND v(dout1_24) AT=260.05n

.meas tran vdout1_25ck250 FIND v(dout1_25) AT=260.05n

.meas tran vdout1_26ck250 FIND v(dout1_26) AT=260.05n

.meas tran vdout1_27ck250 FIND v(dout1_27) AT=260.05n

.meas tran vdout1_28ck250 FIND v(dout1_28) AT=260.05n

.meas tran vdout1_29ck250 FIND v(dout1_29) AT=260.05n

.meas tran vdout1_30ck250 FIND v(dout1_30) AT=260.05n

.meas tran vdout1_31ck250 FIND v(dout1_31) AT=260.05n

.meas tran vdout1_32ck250 FIND v(dout1_32) AT=260.05n

.meas tran vdout1_33ck250 FIND v(dout1_33) AT=260.05n

.meas tran vdout1_34ck250 FIND v(dout1_34) AT=260.05n

.meas tran vdout1_35ck250 FIND v(dout1_35) AT=260.05n

.meas tran vdout1_36ck250 FIND v(dout1_36) AT=260.05n

.meas tran vdout1_37ck250 FIND v(dout1_37) AT=260.05n

.meas tran vdout1_38ck250 FIND v(dout1_38) AT=260.05n

.meas tran vdout1_39ck250 FIND v(dout1_39) AT=260.05n

.meas tran vdout1_40ck250 FIND v(dout1_40) AT=260.05n

.meas tran vdout1_41ck250 FIND v(dout1_41) AT=260.05n

.meas tran vdout1_42ck250 FIND v(dout1_42) AT=260.05n

.meas tran vdout1_43ck250 FIND v(dout1_43) AT=260.05n

.meas tran vdout1_44ck250 FIND v(dout1_44) AT=260.05n

.meas tran vdout1_45ck250 FIND v(dout1_45) AT=260.05n

.meas tran vdout1_46ck250 FIND v(dout1_46) AT=260.05n

.meas tran vdout1_47ck250 FIND v(dout1_47) AT=260.05n

.meas tran vdout1_48ck250 FIND v(dout1_48) AT=260.05n

.meas tran vdout1_49ck250 FIND v(dout1_49) AT=260.05n

.meas tran vdout1_50ck250 FIND v(dout1_50) AT=260.05n

.meas tran vdout1_51ck250 FIND v(dout1_51) AT=260.05n

.meas tran vdout1_52ck250 FIND v(dout1_52) AT=260.05n

.meas tran vdout1_53ck250 FIND v(dout1_53) AT=260.05n

.meas tran vdout1_54ck250 FIND v(dout1_54) AT=260.05n

.meas tran vdout1_55ck250 FIND v(dout1_55) AT=260.05n

.meas tran vdout1_56ck250 FIND v(dout1_56) AT=260.05n

.meas tran vdout1_57ck250 FIND v(dout1_57) AT=260.05n

.meas tran vdout1_58ck250 FIND v(dout1_58) AT=260.05n

.meas tran vdout1_59ck250 FIND v(dout1_59) AT=260.05n

.meas tran vdout1_60ck250 FIND v(dout1_60) AT=260.05n

.meas tran vdout1_61ck250 FIND v(dout1_61) AT=260.05n

.meas tran vdout1_62ck250 FIND v(dout1_62) AT=260.05n

.meas tran vdout1_63ck250 FIND v(dout1_63) AT=260.05n

.meas tran vdout1_64ck250 FIND v(dout1_64) AT=260.05n

.meas tran vdout1_65ck250 FIND v(dout1_65) AT=260.05n

.meas tran vdout1_66ck250 FIND v(dout1_66) AT=260.05n

.meas tran vdout1_67ck250 FIND v(dout1_67) AT=260.05n

.meas tran vdout1_68ck250 FIND v(dout1_68) AT=260.05n

.meas tran vdout1_69ck250 FIND v(dout1_69) AT=260.05n

.meas tran vdout1_70ck250 FIND v(dout1_70) AT=260.05n

.meas tran vdout1_71ck250 FIND v(dout1_71) AT=260.05n

.meas tran vdout1_72ck250 FIND v(dout1_72) AT=260.05n

.meas tran vdout1_73ck250 FIND v(dout1_73) AT=260.05n

.meas tran vdout1_74ck250 FIND v(dout1_74) AT=260.05n

.meas tran vdout1_75ck250 FIND v(dout1_75) AT=260.05n

.meas tran vdout1_76ck250 FIND v(dout1_76) AT=260.05n

.meas tran vdout1_77ck250 FIND v(dout1_77) AT=260.05n

.meas tran vdout1_78ck250 FIND v(dout1_78) AT=260.05n

.meas tran vdout1_79ck250 FIND v(dout1_79) AT=260.05n

.meas tran vdout1_80ck250 FIND v(dout1_80) AT=260.05n

.meas tran vdout1_81ck250 FIND v(dout1_81) AT=260.05n

.meas tran vdout1_82ck250 FIND v(dout1_82) AT=260.05n

.meas tran vdout1_83ck250 FIND v(dout1_83) AT=260.05n

.meas tran vdout1_84ck250 FIND v(dout1_84) AT=260.05n

.meas tran vdout1_85ck250 FIND v(dout1_85) AT=260.05n

.meas tran vdout1_86ck250 FIND v(dout1_86) AT=260.05n

.meas tran vdout1_87ck250 FIND v(dout1_87) AT=260.05n

.meas tran vdout1_88ck250 FIND v(dout1_88) AT=260.05n

.meas tran vdout1_89ck250 FIND v(dout1_89) AT=260.05n

.meas tran vdout1_90ck250 FIND v(dout1_90) AT=260.05n

.meas tran vdout1_91ck250 FIND v(dout1_91) AT=260.05n

.meas tran vdout1_92ck250 FIND v(dout1_92) AT=260.05n

.meas tran vdout1_93ck250 FIND v(dout1_93) AT=260.05n

.meas tran vdout1_94ck250 FIND v(dout1_94) AT=260.05n

.meas tran vdout1_95ck250 FIND v(dout1_95) AT=260.05n

.meas tran vdout1_96ck250 FIND v(dout1_96) AT=260.05n

.meas tran vdout1_97ck250 FIND v(dout1_97) AT=260.05n

.meas tran vdout1_98ck250 FIND v(dout1_98) AT=260.05n

.meas tran vdout1_99ck250 FIND v(dout1_99) AT=260.05n

.meas tran vdout1_100ck250 FIND v(dout1_100) AT=260.05n

.meas tran vdout1_101ck250 FIND v(dout1_101) AT=260.05n

.meas tran vdout1_102ck250 FIND v(dout1_102) AT=260.05n

.meas tran vdout1_103ck250 FIND v(dout1_103) AT=260.05n

.meas tran vdout1_104ck250 FIND v(dout1_104) AT=260.05n

.meas tran vdout1_105ck250 FIND v(dout1_105) AT=260.05n

.meas tran vdout1_106ck250 FIND v(dout1_106) AT=260.05n

.meas tran vdout1_107ck250 FIND v(dout1_107) AT=260.05n

.meas tran vdout1_108ck250 FIND v(dout1_108) AT=260.05n

.meas tran vdout1_109ck250 FIND v(dout1_109) AT=260.05n

.meas tran vdout1_110ck250 FIND v(dout1_110) AT=260.05n

.meas tran vdout1_111ck250 FIND v(dout1_111) AT=260.05n

.meas tran vdout1_112ck250 FIND v(dout1_112) AT=260.05n

.meas tran vdout1_113ck250 FIND v(dout1_113) AT=260.05n

.meas tran vdout1_114ck250 FIND v(dout1_114) AT=260.05n

.meas tran vdout1_115ck250 FIND v(dout1_115) AT=260.05n

.meas tran vdout1_116ck250 FIND v(dout1_116) AT=260.05n

.meas tran vdout1_117ck250 FIND v(dout1_117) AT=260.05n

.meas tran vdout1_118ck250 FIND v(dout1_118) AT=260.05n

.meas tran vdout1_119ck250 FIND v(dout1_119) AT=260.05n

.meas tran vdout1_120ck250 FIND v(dout1_120) AT=260.05n

.meas tran vdout1_121ck250 FIND v(dout1_121) AT=260.05n

.meas tran vdout1_122ck250 FIND v(dout1_122) AT=260.05n

.meas tran vdout1_123ck250 FIND v(dout1_123) AT=260.05n

.meas tran vdout1_124ck250 FIND v(dout1_124) AT=260.05n

.meas tran vdout1_125ck250 FIND v(dout1_125) AT=260.05n

.meas tran vdout1_126ck250 FIND v(dout1_126) AT=260.05n

.meas tran vdout1_127ck250 FIND v(dout1_127) AT=260.05n

.meas tran vdout1_128ck250 FIND v(dout1_128) AT=260.05n

.meas tran vdout1_129ck250 FIND v(dout1_129) AT=260.05n

.meas tran vdout1_130ck250 FIND v(dout1_130) AT=260.05n

.meas tran vdout1_131ck250 FIND v(dout1_131) AT=260.05n

.meas tran vdout1_132ck250 FIND v(dout1_132) AT=260.05n

.meas tran vdout1_133ck250 FIND v(dout1_133) AT=260.05n

.meas tran vdout1_134ck250 FIND v(dout1_134) AT=260.05n

.meas tran vdout1_0ck300 FIND v(dout1_0) AT=310.05n

.meas tran vdout1_1ck300 FIND v(dout1_1) AT=310.05n

.meas tran vdout1_2ck300 FIND v(dout1_2) AT=310.05n

.meas tran vdout1_3ck300 FIND v(dout1_3) AT=310.05n

.meas tran vdout1_4ck300 FIND v(dout1_4) AT=310.05n

.meas tran vdout1_5ck300 FIND v(dout1_5) AT=310.05n

.meas tran vdout1_6ck300 FIND v(dout1_6) AT=310.05n

.meas tran vdout1_7ck300 FIND v(dout1_7) AT=310.05n

.meas tran vdout1_8ck300 FIND v(dout1_8) AT=310.05n

.meas tran vdout1_9ck300 FIND v(dout1_9) AT=310.05n

.meas tran vdout1_10ck300 FIND v(dout1_10) AT=310.05n

.meas tran vdout1_11ck300 FIND v(dout1_11) AT=310.05n

.meas tran vdout1_12ck300 FIND v(dout1_12) AT=310.05n

.meas tran vdout1_13ck300 FIND v(dout1_13) AT=310.05n

.meas tran vdout1_14ck300 FIND v(dout1_14) AT=310.05n

.meas tran vdout1_15ck300 FIND v(dout1_15) AT=310.05n

.meas tran vdout1_16ck300 FIND v(dout1_16) AT=310.05n

.meas tran vdout1_17ck300 FIND v(dout1_17) AT=310.05n

.meas tran vdout1_18ck300 FIND v(dout1_18) AT=310.05n

.meas tran vdout1_19ck300 FIND v(dout1_19) AT=310.05n

.meas tran vdout1_20ck300 FIND v(dout1_20) AT=310.05n

.meas tran vdout1_21ck300 FIND v(dout1_21) AT=310.05n

.meas tran vdout1_22ck300 FIND v(dout1_22) AT=310.05n

.meas tran vdout1_23ck300 FIND v(dout1_23) AT=310.05n

.meas tran vdout1_24ck300 FIND v(dout1_24) AT=310.05n

.meas tran vdout1_25ck300 FIND v(dout1_25) AT=310.05n

.meas tran vdout1_26ck300 FIND v(dout1_26) AT=310.05n

.meas tran vdout1_27ck300 FIND v(dout1_27) AT=310.05n

.meas tran vdout1_28ck300 FIND v(dout1_28) AT=310.05n

.meas tran vdout1_29ck300 FIND v(dout1_29) AT=310.05n

.meas tran vdout1_30ck300 FIND v(dout1_30) AT=310.05n

.meas tran vdout1_31ck300 FIND v(dout1_31) AT=310.05n

.meas tran vdout1_32ck300 FIND v(dout1_32) AT=310.05n

.meas tran vdout1_33ck300 FIND v(dout1_33) AT=310.05n

.meas tran vdout1_34ck300 FIND v(dout1_34) AT=310.05n

.meas tran vdout1_35ck300 FIND v(dout1_35) AT=310.05n

.meas tran vdout1_36ck300 FIND v(dout1_36) AT=310.05n

.meas tran vdout1_37ck300 FIND v(dout1_37) AT=310.05n

.meas tran vdout1_38ck300 FIND v(dout1_38) AT=310.05n

.meas tran vdout1_39ck300 FIND v(dout1_39) AT=310.05n

.meas tran vdout1_40ck300 FIND v(dout1_40) AT=310.05n

.meas tran vdout1_41ck300 FIND v(dout1_41) AT=310.05n

.meas tran vdout1_42ck300 FIND v(dout1_42) AT=310.05n

.meas tran vdout1_43ck300 FIND v(dout1_43) AT=310.05n

.meas tran vdout1_44ck300 FIND v(dout1_44) AT=310.05n

.meas tran vdout1_45ck300 FIND v(dout1_45) AT=310.05n

.meas tran vdout1_46ck300 FIND v(dout1_46) AT=310.05n

.meas tran vdout1_47ck300 FIND v(dout1_47) AT=310.05n

.meas tran vdout1_48ck300 FIND v(dout1_48) AT=310.05n

.meas tran vdout1_49ck300 FIND v(dout1_49) AT=310.05n

.meas tran vdout1_50ck300 FIND v(dout1_50) AT=310.05n

.meas tran vdout1_51ck300 FIND v(dout1_51) AT=310.05n

.meas tran vdout1_52ck300 FIND v(dout1_52) AT=310.05n

.meas tran vdout1_53ck300 FIND v(dout1_53) AT=310.05n

.meas tran vdout1_54ck300 FIND v(dout1_54) AT=310.05n

.meas tran vdout1_55ck300 FIND v(dout1_55) AT=310.05n

.meas tran vdout1_56ck300 FIND v(dout1_56) AT=310.05n

.meas tran vdout1_57ck300 FIND v(dout1_57) AT=310.05n

.meas tran vdout1_58ck300 FIND v(dout1_58) AT=310.05n

.meas tran vdout1_59ck300 FIND v(dout1_59) AT=310.05n

.meas tran vdout1_60ck300 FIND v(dout1_60) AT=310.05n

.meas tran vdout1_61ck300 FIND v(dout1_61) AT=310.05n

.meas tran vdout1_62ck300 FIND v(dout1_62) AT=310.05n

.meas tran vdout1_63ck300 FIND v(dout1_63) AT=310.05n

.meas tran vdout1_64ck300 FIND v(dout1_64) AT=310.05n

.meas tran vdout1_65ck300 FIND v(dout1_65) AT=310.05n

.meas tran vdout1_66ck300 FIND v(dout1_66) AT=310.05n

.meas tran vdout1_67ck300 FIND v(dout1_67) AT=310.05n

.meas tran vdout1_68ck300 FIND v(dout1_68) AT=310.05n

.meas tran vdout1_69ck300 FIND v(dout1_69) AT=310.05n

.meas tran vdout1_70ck300 FIND v(dout1_70) AT=310.05n

.meas tran vdout1_71ck300 FIND v(dout1_71) AT=310.05n

.meas tran vdout1_72ck300 FIND v(dout1_72) AT=310.05n

.meas tran vdout1_73ck300 FIND v(dout1_73) AT=310.05n

.meas tran vdout1_74ck300 FIND v(dout1_74) AT=310.05n

.meas tran vdout1_75ck300 FIND v(dout1_75) AT=310.05n

.meas tran vdout1_76ck300 FIND v(dout1_76) AT=310.05n

.meas tran vdout1_77ck300 FIND v(dout1_77) AT=310.05n

.meas tran vdout1_78ck300 FIND v(dout1_78) AT=310.05n

.meas tran vdout1_79ck300 FIND v(dout1_79) AT=310.05n

.meas tran vdout1_80ck300 FIND v(dout1_80) AT=310.05n

.meas tran vdout1_81ck300 FIND v(dout1_81) AT=310.05n

.meas tran vdout1_82ck300 FIND v(dout1_82) AT=310.05n

.meas tran vdout1_83ck300 FIND v(dout1_83) AT=310.05n

.meas tran vdout1_84ck300 FIND v(dout1_84) AT=310.05n

.meas tran vdout1_85ck300 FIND v(dout1_85) AT=310.05n

.meas tran vdout1_86ck300 FIND v(dout1_86) AT=310.05n

.meas tran vdout1_87ck300 FIND v(dout1_87) AT=310.05n

.meas tran vdout1_88ck300 FIND v(dout1_88) AT=310.05n

.meas tran vdout1_89ck300 FIND v(dout1_89) AT=310.05n

.meas tran vdout1_90ck300 FIND v(dout1_90) AT=310.05n

.meas tran vdout1_91ck300 FIND v(dout1_91) AT=310.05n

.meas tran vdout1_92ck300 FIND v(dout1_92) AT=310.05n

.meas tran vdout1_93ck300 FIND v(dout1_93) AT=310.05n

.meas tran vdout1_94ck300 FIND v(dout1_94) AT=310.05n

.meas tran vdout1_95ck300 FIND v(dout1_95) AT=310.05n

.meas tran vdout1_96ck300 FIND v(dout1_96) AT=310.05n

.meas tran vdout1_97ck300 FIND v(dout1_97) AT=310.05n

.meas tran vdout1_98ck300 FIND v(dout1_98) AT=310.05n

.meas tran vdout1_99ck300 FIND v(dout1_99) AT=310.05n

.meas tran vdout1_100ck300 FIND v(dout1_100) AT=310.05n

.meas tran vdout1_101ck300 FIND v(dout1_101) AT=310.05n

.meas tran vdout1_102ck300 FIND v(dout1_102) AT=310.05n

.meas tran vdout1_103ck300 FIND v(dout1_103) AT=310.05n

.meas tran vdout1_104ck300 FIND v(dout1_104) AT=310.05n

.meas tran vdout1_105ck300 FIND v(dout1_105) AT=310.05n

.meas tran vdout1_106ck300 FIND v(dout1_106) AT=310.05n

.meas tran vdout1_107ck300 FIND v(dout1_107) AT=310.05n

.meas tran vdout1_108ck300 FIND v(dout1_108) AT=310.05n

.meas tran vdout1_109ck300 FIND v(dout1_109) AT=310.05n

.meas tran vdout1_110ck300 FIND v(dout1_110) AT=310.05n

.meas tran vdout1_111ck300 FIND v(dout1_111) AT=310.05n

.meas tran vdout1_112ck300 FIND v(dout1_112) AT=310.05n

.meas tran vdout1_113ck300 FIND v(dout1_113) AT=310.05n

.meas tran vdout1_114ck300 FIND v(dout1_114) AT=310.05n

.meas tran vdout1_115ck300 FIND v(dout1_115) AT=310.05n

.meas tran vdout1_116ck300 FIND v(dout1_116) AT=310.05n

.meas tran vdout1_117ck300 FIND v(dout1_117) AT=310.05n

.meas tran vdout1_118ck300 FIND v(dout1_118) AT=310.05n

.meas tran vdout1_119ck300 FIND v(dout1_119) AT=310.05n

.meas tran vdout1_120ck300 FIND v(dout1_120) AT=310.05n

.meas tran vdout1_121ck300 FIND v(dout1_121) AT=310.05n

.meas tran vdout1_122ck300 FIND v(dout1_122) AT=310.05n

.meas tran vdout1_123ck300 FIND v(dout1_123) AT=310.05n

.meas tran vdout1_124ck300 FIND v(dout1_124) AT=310.05n

.meas tran vdout1_125ck300 FIND v(dout1_125) AT=310.05n

.meas tran vdout1_126ck300 FIND v(dout1_126) AT=310.05n

.meas tran vdout1_127ck300 FIND v(dout1_127) AT=310.05n

.meas tran vdout1_128ck300 FIND v(dout1_128) AT=310.05n

.meas tran vdout1_129ck300 FIND v(dout1_129) AT=310.05n

.meas tran vdout1_130ck300 FIND v(dout1_130) AT=310.05n

.meas tran vdout1_131ck300 FIND v(dout1_131) AT=310.05n

.meas tran vdout1_132ck300 FIND v(dout1_132) AT=310.05n

.meas tran vdout1_133ck300 FIND v(dout1_133) AT=310.05n

.meas tran vdout1_134ck300 FIND v(dout1_134) AT=310.05n

.meas tran vdout1_0ck310 FIND v(dout1_0) AT=320.05n

.meas tran vdout1_1ck310 FIND v(dout1_1) AT=320.05n

.meas tran vdout1_2ck310 FIND v(dout1_2) AT=320.05n

.meas tran vdout1_3ck310 FIND v(dout1_3) AT=320.05n

.meas tran vdout1_4ck310 FIND v(dout1_4) AT=320.05n

.meas tran vdout1_5ck310 FIND v(dout1_5) AT=320.05n

.meas tran vdout1_6ck310 FIND v(dout1_6) AT=320.05n

.meas tran vdout1_7ck310 FIND v(dout1_7) AT=320.05n

.meas tran vdout1_8ck310 FIND v(dout1_8) AT=320.05n

.meas tran vdout1_9ck310 FIND v(dout1_9) AT=320.05n

.meas tran vdout1_10ck310 FIND v(dout1_10) AT=320.05n

.meas tran vdout1_11ck310 FIND v(dout1_11) AT=320.05n

.meas tran vdout1_12ck310 FIND v(dout1_12) AT=320.05n

.meas tran vdout1_13ck310 FIND v(dout1_13) AT=320.05n

.meas tran vdout1_14ck310 FIND v(dout1_14) AT=320.05n

.meas tran vdout1_15ck310 FIND v(dout1_15) AT=320.05n

.meas tran vdout1_16ck310 FIND v(dout1_16) AT=320.05n

.meas tran vdout1_17ck310 FIND v(dout1_17) AT=320.05n

.meas tran vdout1_18ck310 FIND v(dout1_18) AT=320.05n

.meas tran vdout1_19ck310 FIND v(dout1_19) AT=320.05n

.meas tran vdout1_20ck310 FIND v(dout1_20) AT=320.05n

.meas tran vdout1_21ck310 FIND v(dout1_21) AT=320.05n

.meas tran vdout1_22ck310 FIND v(dout1_22) AT=320.05n

.meas tran vdout1_23ck310 FIND v(dout1_23) AT=320.05n

.meas tran vdout1_24ck310 FIND v(dout1_24) AT=320.05n

.meas tran vdout1_25ck310 FIND v(dout1_25) AT=320.05n

.meas tran vdout1_26ck310 FIND v(dout1_26) AT=320.05n

.meas tran vdout1_27ck310 FIND v(dout1_27) AT=320.05n

.meas tran vdout1_28ck310 FIND v(dout1_28) AT=320.05n

.meas tran vdout1_29ck310 FIND v(dout1_29) AT=320.05n

.meas tran vdout1_30ck310 FIND v(dout1_30) AT=320.05n

.meas tran vdout1_31ck310 FIND v(dout1_31) AT=320.05n

.meas tran vdout1_32ck310 FIND v(dout1_32) AT=320.05n

.meas tran vdout1_33ck310 FIND v(dout1_33) AT=320.05n

.meas tran vdout1_34ck310 FIND v(dout1_34) AT=320.05n

.meas tran vdout1_35ck310 FIND v(dout1_35) AT=320.05n

.meas tran vdout1_36ck310 FIND v(dout1_36) AT=320.05n

.meas tran vdout1_37ck310 FIND v(dout1_37) AT=320.05n

.meas tran vdout1_38ck310 FIND v(dout1_38) AT=320.05n

.meas tran vdout1_39ck310 FIND v(dout1_39) AT=320.05n

.meas tran vdout1_40ck310 FIND v(dout1_40) AT=320.05n

.meas tran vdout1_41ck310 FIND v(dout1_41) AT=320.05n

.meas tran vdout1_42ck310 FIND v(dout1_42) AT=320.05n

.meas tran vdout1_43ck310 FIND v(dout1_43) AT=320.05n

.meas tran vdout1_44ck310 FIND v(dout1_44) AT=320.05n

.meas tran vdout1_45ck310 FIND v(dout1_45) AT=320.05n

.meas tran vdout1_46ck310 FIND v(dout1_46) AT=320.05n

.meas tran vdout1_47ck310 FIND v(dout1_47) AT=320.05n

.meas tran vdout1_48ck310 FIND v(dout1_48) AT=320.05n

.meas tran vdout1_49ck310 FIND v(dout1_49) AT=320.05n

.meas tran vdout1_50ck310 FIND v(dout1_50) AT=320.05n

.meas tran vdout1_51ck310 FIND v(dout1_51) AT=320.05n

.meas tran vdout1_52ck310 FIND v(dout1_52) AT=320.05n

.meas tran vdout1_53ck310 FIND v(dout1_53) AT=320.05n

.meas tran vdout1_54ck310 FIND v(dout1_54) AT=320.05n

.meas tran vdout1_55ck310 FIND v(dout1_55) AT=320.05n

.meas tran vdout1_56ck310 FIND v(dout1_56) AT=320.05n

.meas tran vdout1_57ck310 FIND v(dout1_57) AT=320.05n

.meas tran vdout1_58ck310 FIND v(dout1_58) AT=320.05n

.meas tran vdout1_59ck310 FIND v(dout1_59) AT=320.05n

.meas tran vdout1_60ck310 FIND v(dout1_60) AT=320.05n

.meas tran vdout1_61ck310 FIND v(dout1_61) AT=320.05n

.meas tran vdout1_62ck310 FIND v(dout1_62) AT=320.05n

.meas tran vdout1_63ck310 FIND v(dout1_63) AT=320.05n

.meas tran vdout1_64ck310 FIND v(dout1_64) AT=320.05n

.meas tran vdout1_65ck310 FIND v(dout1_65) AT=320.05n

.meas tran vdout1_66ck310 FIND v(dout1_66) AT=320.05n

.meas tran vdout1_67ck310 FIND v(dout1_67) AT=320.05n

.meas tran vdout1_68ck310 FIND v(dout1_68) AT=320.05n

.meas tran vdout1_69ck310 FIND v(dout1_69) AT=320.05n

.meas tran vdout1_70ck310 FIND v(dout1_70) AT=320.05n

.meas tran vdout1_71ck310 FIND v(dout1_71) AT=320.05n

.meas tran vdout1_72ck310 FIND v(dout1_72) AT=320.05n

.meas tran vdout1_73ck310 FIND v(dout1_73) AT=320.05n

.meas tran vdout1_74ck310 FIND v(dout1_74) AT=320.05n

.meas tran vdout1_75ck310 FIND v(dout1_75) AT=320.05n

.meas tran vdout1_76ck310 FIND v(dout1_76) AT=320.05n

.meas tran vdout1_77ck310 FIND v(dout1_77) AT=320.05n

.meas tran vdout1_78ck310 FIND v(dout1_78) AT=320.05n

.meas tran vdout1_79ck310 FIND v(dout1_79) AT=320.05n

.meas tran vdout1_80ck310 FIND v(dout1_80) AT=320.05n

.meas tran vdout1_81ck310 FIND v(dout1_81) AT=320.05n

.meas tran vdout1_82ck310 FIND v(dout1_82) AT=320.05n

.meas tran vdout1_83ck310 FIND v(dout1_83) AT=320.05n

.meas tran vdout1_84ck310 FIND v(dout1_84) AT=320.05n

.meas tran vdout1_85ck310 FIND v(dout1_85) AT=320.05n

.meas tran vdout1_86ck310 FIND v(dout1_86) AT=320.05n

.meas tran vdout1_87ck310 FIND v(dout1_87) AT=320.05n

.meas tran vdout1_88ck310 FIND v(dout1_88) AT=320.05n

.meas tran vdout1_89ck310 FIND v(dout1_89) AT=320.05n

.meas tran vdout1_90ck310 FIND v(dout1_90) AT=320.05n

.meas tran vdout1_91ck310 FIND v(dout1_91) AT=320.05n

.meas tran vdout1_92ck310 FIND v(dout1_92) AT=320.05n

.meas tran vdout1_93ck310 FIND v(dout1_93) AT=320.05n

.meas tran vdout1_94ck310 FIND v(dout1_94) AT=320.05n

.meas tran vdout1_95ck310 FIND v(dout1_95) AT=320.05n

.meas tran vdout1_96ck310 FIND v(dout1_96) AT=320.05n

.meas tran vdout1_97ck310 FIND v(dout1_97) AT=320.05n

.meas tran vdout1_98ck310 FIND v(dout1_98) AT=320.05n

.meas tran vdout1_99ck310 FIND v(dout1_99) AT=320.05n

.meas tran vdout1_100ck310 FIND v(dout1_100) AT=320.05n

.meas tran vdout1_101ck310 FIND v(dout1_101) AT=320.05n

.meas tran vdout1_102ck310 FIND v(dout1_102) AT=320.05n

.meas tran vdout1_103ck310 FIND v(dout1_103) AT=320.05n

.meas tran vdout1_104ck310 FIND v(dout1_104) AT=320.05n

.meas tran vdout1_105ck310 FIND v(dout1_105) AT=320.05n

.meas tran vdout1_106ck310 FIND v(dout1_106) AT=320.05n

.meas tran vdout1_107ck310 FIND v(dout1_107) AT=320.05n

.meas tran vdout1_108ck310 FIND v(dout1_108) AT=320.05n

.meas tran vdout1_109ck310 FIND v(dout1_109) AT=320.05n

.meas tran vdout1_110ck310 FIND v(dout1_110) AT=320.05n

.meas tran vdout1_111ck310 FIND v(dout1_111) AT=320.05n

.meas tran vdout1_112ck310 FIND v(dout1_112) AT=320.05n

.meas tran vdout1_113ck310 FIND v(dout1_113) AT=320.05n

.meas tran vdout1_114ck310 FIND v(dout1_114) AT=320.05n

.meas tran vdout1_115ck310 FIND v(dout1_115) AT=320.05n

.meas tran vdout1_116ck310 FIND v(dout1_116) AT=320.05n

.meas tran vdout1_117ck310 FIND v(dout1_117) AT=320.05n

.meas tran vdout1_118ck310 FIND v(dout1_118) AT=320.05n

.meas tran vdout1_119ck310 FIND v(dout1_119) AT=320.05n

.meas tran vdout1_120ck310 FIND v(dout1_120) AT=320.05n

.meas tran vdout1_121ck310 FIND v(dout1_121) AT=320.05n

.meas tran vdout1_122ck310 FIND v(dout1_122) AT=320.05n

.meas tran vdout1_123ck310 FIND v(dout1_123) AT=320.05n

.meas tran vdout1_124ck310 FIND v(dout1_124) AT=320.05n

.meas tran vdout1_125ck310 FIND v(dout1_125) AT=320.05n

.meas tran vdout1_126ck310 FIND v(dout1_126) AT=320.05n

.meas tran vdout1_127ck310 FIND v(dout1_127) AT=320.05n

.meas tran vdout1_128ck310 FIND v(dout1_128) AT=320.05n

.meas tran vdout1_129ck310 FIND v(dout1_129) AT=320.05n

.meas tran vdout1_130ck310 FIND v(dout1_130) AT=320.05n

.meas tran vdout1_131ck310 FIND v(dout1_131) AT=320.05n

.meas tran vdout1_132ck310 FIND v(dout1_132) AT=320.05n

.meas tran vdout1_133ck310 FIND v(dout1_133) AT=320.05n

.meas tran vdout1_134ck310 FIND v(dout1_134) AT=320.05n

.meas tran vdout1_0ck320 FIND v(dout1_0) AT=330.05n

.meas tran vdout1_1ck320 FIND v(dout1_1) AT=330.05n

.meas tran vdout1_2ck320 FIND v(dout1_2) AT=330.05n

.meas tran vdout1_3ck320 FIND v(dout1_3) AT=330.05n

.meas tran vdout1_4ck320 FIND v(dout1_4) AT=330.05n

.meas tran vdout1_5ck320 FIND v(dout1_5) AT=330.05n

.meas tran vdout1_6ck320 FIND v(dout1_6) AT=330.05n

.meas tran vdout1_7ck320 FIND v(dout1_7) AT=330.05n

.meas tran vdout1_8ck320 FIND v(dout1_8) AT=330.05n

.meas tran vdout1_9ck320 FIND v(dout1_9) AT=330.05n

.meas tran vdout1_10ck320 FIND v(dout1_10) AT=330.05n

.meas tran vdout1_11ck320 FIND v(dout1_11) AT=330.05n

.meas tran vdout1_12ck320 FIND v(dout1_12) AT=330.05n

.meas tran vdout1_13ck320 FIND v(dout1_13) AT=330.05n

.meas tran vdout1_14ck320 FIND v(dout1_14) AT=330.05n

.meas tran vdout1_15ck320 FIND v(dout1_15) AT=330.05n

.meas tran vdout1_16ck320 FIND v(dout1_16) AT=330.05n

.meas tran vdout1_17ck320 FIND v(dout1_17) AT=330.05n

.meas tran vdout1_18ck320 FIND v(dout1_18) AT=330.05n

.meas tran vdout1_19ck320 FIND v(dout1_19) AT=330.05n

.meas tran vdout1_20ck320 FIND v(dout1_20) AT=330.05n

.meas tran vdout1_21ck320 FIND v(dout1_21) AT=330.05n

.meas tran vdout1_22ck320 FIND v(dout1_22) AT=330.05n

.meas tran vdout1_23ck320 FIND v(dout1_23) AT=330.05n

.meas tran vdout1_24ck320 FIND v(dout1_24) AT=330.05n

.meas tran vdout1_25ck320 FIND v(dout1_25) AT=330.05n

.meas tran vdout1_26ck320 FIND v(dout1_26) AT=330.05n

.meas tran vdout1_27ck320 FIND v(dout1_27) AT=330.05n

.meas tran vdout1_28ck320 FIND v(dout1_28) AT=330.05n

.meas tran vdout1_29ck320 FIND v(dout1_29) AT=330.05n

.meas tran vdout1_30ck320 FIND v(dout1_30) AT=330.05n

.meas tran vdout1_31ck320 FIND v(dout1_31) AT=330.05n

.meas tran vdout1_32ck320 FIND v(dout1_32) AT=330.05n

.meas tran vdout1_33ck320 FIND v(dout1_33) AT=330.05n

.meas tran vdout1_34ck320 FIND v(dout1_34) AT=330.05n

.meas tran vdout1_35ck320 FIND v(dout1_35) AT=330.05n

.meas tran vdout1_36ck320 FIND v(dout1_36) AT=330.05n

.meas tran vdout1_37ck320 FIND v(dout1_37) AT=330.05n

.meas tran vdout1_38ck320 FIND v(dout1_38) AT=330.05n

.meas tran vdout1_39ck320 FIND v(dout1_39) AT=330.05n

.meas tran vdout1_40ck320 FIND v(dout1_40) AT=330.05n

.meas tran vdout1_41ck320 FIND v(dout1_41) AT=330.05n

.meas tran vdout1_42ck320 FIND v(dout1_42) AT=330.05n

.meas tran vdout1_43ck320 FIND v(dout1_43) AT=330.05n

.meas tran vdout1_44ck320 FIND v(dout1_44) AT=330.05n

.meas tran vdout1_45ck320 FIND v(dout1_45) AT=330.05n

.meas tran vdout1_46ck320 FIND v(dout1_46) AT=330.05n

.meas tran vdout1_47ck320 FIND v(dout1_47) AT=330.05n

.meas tran vdout1_48ck320 FIND v(dout1_48) AT=330.05n

.meas tran vdout1_49ck320 FIND v(dout1_49) AT=330.05n

.meas tran vdout1_50ck320 FIND v(dout1_50) AT=330.05n

.meas tran vdout1_51ck320 FIND v(dout1_51) AT=330.05n

.meas tran vdout1_52ck320 FIND v(dout1_52) AT=330.05n

.meas tran vdout1_53ck320 FIND v(dout1_53) AT=330.05n

.meas tran vdout1_54ck320 FIND v(dout1_54) AT=330.05n

.meas tran vdout1_55ck320 FIND v(dout1_55) AT=330.05n

.meas tran vdout1_56ck320 FIND v(dout1_56) AT=330.05n

.meas tran vdout1_57ck320 FIND v(dout1_57) AT=330.05n

.meas tran vdout1_58ck320 FIND v(dout1_58) AT=330.05n

.meas tran vdout1_59ck320 FIND v(dout1_59) AT=330.05n

.meas tran vdout1_60ck320 FIND v(dout1_60) AT=330.05n

.meas tran vdout1_61ck320 FIND v(dout1_61) AT=330.05n

.meas tran vdout1_62ck320 FIND v(dout1_62) AT=330.05n

.meas tran vdout1_63ck320 FIND v(dout1_63) AT=330.05n

.meas tran vdout1_64ck320 FIND v(dout1_64) AT=330.05n

.meas tran vdout1_65ck320 FIND v(dout1_65) AT=330.05n

.meas tran vdout1_66ck320 FIND v(dout1_66) AT=330.05n

.meas tran vdout1_67ck320 FIND v(dout1_67) AT=330.05n

.meas tran vdout1_68ck320 FIND v(dout1_68) AT=330.05n

.meas tran vdout1_69ck320 FIND v(dout1_69) AT=330.05n

.meas tran vdout1_70ck320 FIND v(dout1_70) AT=330.05n

.meas tran vdout1_71ck320 FIND v(dout1_71) AT=330.05n

.meas tran vdout1_72ck320 FIND v(dout1_72) AT=330.05n

.meas tran vdout1_73ck320 FIND v(dout1_73) AT=330.05n

.meas tran vdout1_74ck320 FIND v(dout1_74) AT=330.05n

.meas tran vdout1_75ck320 FIND v(dout1_75) AT=330.05n

.meas tran vdout1_76ck320 FIND v(dout1_76) AT=330.05n

.meas tran vdout1_77ck320 FIND v(dout1_77) AT=330.05n

.meas tran vdout1_78ck320 FIND v(dout1_78) AT=330.05n

.meas tran vdout1_79ck320 FIND v(dout1_79) AT=330.05n

.meas tran vdout1_80ck320 FIND v(dout1_80) AT=330.05n

.meas tran vdout1_81ck320 FIND v(dout1_81) AT=330.05n

.meas tran vdout1_82ck320 FIND v(dout1_82) AT=330.05n

.meas tran vdout1_83ck320 FIND v(dout1_83) AT=330.05n

.meas tran vdout1_84ck320 FIND v(dout1_84) AT=330.05n

.meas tran vdout1_85ck320 FIND v(dout1_85) AT=330.05n

.meas tran vdout1_86ck320 FIND v(dout1_86) AT=330.05n

.meas tran vdout1_87ck320 FIND v(dout1_87) AT=330.05n

.meas tran vdout1_88ck320 FIND v(dout1_88) AT=330.05n

.meas tran vdout1_89ck320 FIND v(dout1_89) AT=330.05n

.meas tran vdout1_90ck320 FIND v(dout1_90) AT=330.05n

.meas tran vdout1_91ck320 FIND v(dout1_91) AT=330.05n

.meas tran vdout1_92ck320 FIND v(dout1_92) AT=330.05n

.meas tran vdout1_93ck320 FIND v(dout1_93) AT=330.05n

.meas tran vdout1_94ck320 FIND v(dout1_94) AT=330.05n

.meas tran vdout1_95ck320 FIND v(dout1_95) AT=330.05n

.meas tran vdout1_96ck320 FIND v(dout1_96) AT=330.05n

.meas tran vdout1_97ck320 FIND v(dout1_97) AT=330.05n

.meas tran vdout1_98ck320 FIND v(dout1_98) AT=330.05n

.meas tran vdout1_99ck320 FIND v(dout1_99) AT=330.05n

.meas tran vdout1_100ck320 FIND v(dout1_100) AT=330.05n

.meas tran vdout1_101ck320 FIND v(dout1_101) AT=330.05n

.meas tran vdout1_102ck320 FIND v(dout1_102) AT=330.05n

.meas tran vdout1_103ck320 FIND v(dout1_103) AT=330.05n

.meas tran vdout1_104ck320 FIND v(dout1_104) AT=330.05n

.meas tran vdout1_105ck320 FIND v(dout1_105) AT=330.05n

.meas tran vdout1_106ck320 FIND v(dout1_106) AT=330.05n

.meas tran vdout1_107ck320 FIND v(dout1_107) AT=330.05n

.meas tran vdout1_108ck320 FIND v(dout1_108) AT=330.05n

.meas tran vdout1_109ck320 FIND v(dout1_109) AT=330.05n

.meas tran vdout1_110ck320 FIND v(dout1_110) AT=330.05n

.meas tran vdout1_111ck320 FIND v(dout1_111) AT=330.05n

.meas tran vdout1_112ck320 FIND v(dout1_112) AT=330.05n

.meas tran vdout1_113ck320 FIND v(dout1_113) AT=330.05n

.meas tran vdout1_114ck320 FIND v(dout1_114) AT=330.05n

.meas tran vdout1_115ck320 FIND v(dout1_115) AT=330.05n

.meas tran vdout1_116ck320 FIND v(dout1_116) AT=330.05n

.meas tran vdout1_117ck320 FIND v(dout1_117) AT=330.05n

.meas tran vdout1_118ck320 FIND v(dout1_118) AT=330.05n

.meas tran vdout1_119ck320 FIND v(dout1_119) AT=330.05n

.meas tran vdout1_120ck320 FIND v(dout1_120) AT=330.05n

.meas tran vdout1_121ck320 FIND v(dout1_121) AT=330.05n

.meas tran vdout1_122ck320 FIND v(dout1_122) AT=330.05n

.meas tran vdout1_123ck320 FIND v(dout1_123) AT=330.05n

.meas tran vdout1_124ck320 FIND v(dout1_124) AT=330.05n

.meas tran vdout1_125ck320 FIND v(dout1_125) AT=330.05n

.meas tran vdout1_126ck320 FIND v(dout1_126) AT=330.05n

.meas tran vdout1_127ck320 FIND v(dout1_127) AT=330.05n

.meas tran vdout1_128ck320 FIND v(dout1_128) AT=330.05n

.meas tran vdout1_129ck320 FIND v(dout1_129) AT=330.05n

.meas tran vdout1_130ck320 FIND v(dout1_130) AT=330.05n

.meas tran vdout1_131ck320 FIND v(dout1_131) AT=330.05n

.meas tran vdout1_132ck320 FIND v(dout1_132) AT=330.05n

.meas tran vdout1_133ck320 FIND v(dout1_133) AT=330.05n

.meas tran vdout1_134ck320 FIND v(dout1_134) AT=330.05n

.meas tran vdout1_0ck340 FIND v(dout1_0) AT=350.05n

.meas tran vdout1_1ck340 FIND v(dout1_1) AT=350.05n

.meas tran vdout1_2ck340 FIND v(dout1_2) AT=350.05n

.meas tran vdout1_3ck340 FIND v(dout1_3) AT=350.05n

.meas tran vdout1_4ck340 FIND v(dout1_4) AT=350.05n

.meas tran vdout1_5ck340 FIND v(dout1_5) AT=350.05n

.meas tran vdout1_6ck340 FIND v(dout1_6) AT=350.05n

.meas tran vdout1_7ck340 FIND v(dout1_7) AT=350.05n

.meas tran vdout1_8ck340 FIND v(dout1_8) AT=350.05n

.meas tran vdout1_9ck340 FIND v(dout1_9) AT=350.05n

.meas tran vdout1_10ck340 FIND v(dout1_10) AT=350.05n

.meas tran vdout1_11ck340 FIND v(dout1_11) AT=350.05n

.meas tran vdout1_12ck340 FIND v(dout1_12) AT=350.05n

.meas tran vdout1_13ck340 FIND v(dout1_13) AT=350.05n

.meas tran vdout1_14ck340 FIND v(dout1_14) AT=350.05n

.meas tran vdout1_15ck340 FIND v(dout1_15) AT=350.05n

.meas tran vdout1_16ck340 FIND v(dout1_16) AT=350.05n

.meas tran vdout1_17ck340 FIND v(dout1_17) AT=350.05n

.meas tran vdout1_18ck340 FIND v(dout1_18) AT=350.05n

.meas tran vdout1_19ck340 FIND v(dout1_19) AT=350.05n

.meas tran vdout1_20ck340 FIND v(dout1_20) AT=350.05n

.meas tran vdout1_21ck340 FIND v(dout1_21) AT=350.05n

.meas tran vdout1_22ck340 FIND v(dout1_22) AT=350.05n

.meas tran vdout1_23ck340 FIND v(dout1_23) AT=350.05n

.meas tran vdout1_24ck340 FIND v(dout1_24) AT=350.05n

.meas tran vdout1_25ck340 FIND v(dout1_25) AT=350.05n

.meas tran vdout1_26ck340 FIND v(dout1_26) AT=350.05n

.meas tran vdout1_27ck340 FIND v(dout1_27) AT=350.05n

.meas tran vdout1_28ck340 FIND v(dout1_28) AT=350.05n

.meas tran vdout1_29ck340 FIND v(dout1_29) AT=350.05n

.meas tran vdout1_30ck340 FIND v(dout1_30) AT=350.05n

.meas tran vdout1_31ck340 FIND v(dout1_31) AT=350.05n

.meas tran vdout1_32ck340 FIND v(dout1_32) AT=350.05n

.meas tran vdout1_33ck340 FIND v(dout1_33) AT=350.05n

.meas tran vdout1_34ck340 FIND v(dout1_34) AT=350.05n

.meas tran vdout1_35ck340 FIND v(dout1_35) AT=350.05n

.meas tran vdout1_36ck340 FIND v(dout1_36) AT=350.05n

.meas tran vdout1_37ck340 FIND v(dout1_37) AT=350.05n

.meas tran vdout1_38ck340 FIND v(dout1_38) AT=350.05n

.meas tran vdout1_39ck340 FIND v(dout1_39) AT=350.05n

.meas tran vdout1_40ck340 FIND v(dout1_40) AT=350.05n

.meas tran vdout1_41ck340 FIND v(dout1_41) AT=350.05n

.meas tran vdout1_42ck340 FIND v(dout1_42) AT=350.05n

.meas tran vdout1_43ck340 FIND v(dout1_43) AT=350.05n

.meas tran vdout1_44ck340 FIND v(dout1_44) AT=350.05n

.meas tran vdout1_45ck340 FIND v(dout1_45) AT=350.05n

.meas tran vdout1_46ck340 FIND v(dout1_46) AT=350.05n

.meas tran vdout1_47ck340 FIND v(dout1_47) AT=350.05n

.meas tran vdout1_48ck340 FIND v(dout1_48) AT=350.05n

.meas tran vdout1_49ck340 FIND v(dout1_49) AT=350.05n

.meas tran vdout1_50ck340 FIND v(dout1_50) AT=350.05n

.meas tran vdout1_51ck340 FIND v(dout1_51) AT=350.05n

.meas tran vdout1_52ck340 FIND v(dout1_52) AT=350.05n

.meas tran vdout1_53ck340 FIND v(dout1_53) AT=350.05n

.meas tran vdout1_54ck340 FIND v(dout1_54) AT=350.05n

.meas tran vdout1_55ck340 FIND v(dout1_55) AT=350.05n

.meas tran vdout1_56ck340 FIND v(dout1_56) AT=350.05n

.meas tran vdout1_57ck340 FIND v(dout1_57) AT=350.05n

.meas tran vdout1_58ck340 FIND v(dout1_58) AT=350.05n

.meas tran vdout1_59ck340 FIND v(dout1_59) AT=350.05n

.meas tran vdout1_60ck340 FIND v(dout1_60) AT=350.05n

.meas tran vdout1_61ck340 FIND v(dout1_61) AT=350.05n

.meas tran vdout1_62ck340 FIND v(dout1_62) AT=350.05n

.meas tran vdout1_63ck340 FIND v(dout1_63) AT=350.05n

.meas tran vdout1_64ck340 FIND v(dout1_64) AT=350.05n

.meas tran vdout1_65ck340 FIND v(dout1_65) AT=350.05n

.meas tran vdout1_66ck340 FIND v(dout1_66) AT=350.05n

.meas tran vdout1_67ck340 FIND v(dout1_67) AT=350.05n

.meas tran vdout1_68ck340 FIND v(dout1_68) AT=350.05n

.meas tran vdout1_69ck340 FIND v(dout1_69) AT=350.05n

.meas tran vdout1_70ck340 FIND v(dout1_70) AT=350.05n

.meas tran vdout1_71ck340 FIND v(dout1_71) AT=350.05n

.meas tran vdout1_72ck340 FIND v(dout1_72) AT=350.05n

.meas tran vdout1_73ck340 FIND v(dout1_73) AT=350.05n

.meas tran vdout1_74ck340 FIND v(dout1_74) AT=350.05n

.meas tran vdout1_75ck340 FIND v(dout1_75) AT=350.05n

.meas tran vdout1_76ck340 FIND v(dout1_76) AT=350.05n

.meas tran vdout1_77ck340 FIND v(dout1_77) AT=350.05n

.meas tran vdout1_78ck340 FIND v(dout1_78) AT=350.05n

.meas tran vdout1_79ck340 FIND v(dout1_79) AT=350.05n

.meas tran vdout1_80ck340 FIND v(dout1_80) AT=350.05n

.meas tran vdout1_81ck340 FIND v(dout1_81) AT=350.05n

.meas tran vdout1_82ck340 FIND v(dout1_82) AT=350.05n

.meas tran vdout1_83ck340 FIND v(dout1_83) AT=350.05n

.meas tran vdout1_84ck340 FIND v(dout1_84) AT=350.05n

.meas tran vdout1_85ck340 FIND v(dout1_85) AT=350.05n

.meas tran vdout1_86ck340 FIND v(dout1_86) AT=350.05n

.meas tran vdout1_87ck340 FIND v(dout1_87) AT=350.05n

.meas tran vdout1_88ck340 FIND v(dout1_88) AT=350.05n

.meas tran vdout1_89ck340 FIND v(dout1_89) AT=350.05n

.meas tran vdout1_90ck340 FIND v(dout1_90) AT=350.05n

.meas tran vdout1_91ck340 FIND v(dout1_91) AT=350.05n

.meas tran vdout1_92ck340 FIND v(dout1_92) AT=350.05n

.meas tran vdout1_93ck340 FIND v(dout1_93) AT=350.05n

.meas tran vdout1_94ck340 FIND v(dout1_94) AT=350.05n

.meas tran vdout1_95ck340 FIND v(dout1_95) AT=350.05n

.meas tran vdout1_96ck340 FIND v(dout1_96) AT=350.05n

.meas tran vdout1_97ck340 FIND v(dout1_97) AT=350.05n

.meas tran vdout1_98ck340 FIND v(dout1_98) AT=350.05n

.meas tran vdout1_99ck340 FIND v(dout1_99) AT=350.05n

.meas tran vdout1_100ck340 FIND v(dout1_100) AT=350.05n

.meas tran vdout1_101ck340 FIND v(dout1_101) AT=350.05n

.meas tran vdout1_102ck340 FIND v(dout1_102) AT=350.05n

.meas tran vdout1_103ck340 FIND v(dout1_103) AT=350.05n

.meas tran vdout1_104ck340 FIND v(dout1_104) AT=350.05n

.meas tran vdout1_105ck340 FIND v(dout1_105) AT=350.05n

.meas tran vdout1_106ck340 FIND v(dout1_106) AT=350.05n

.meas tran vdout1_107ck340 FIND v(dout1_107) AT=350.05n

.meas tran vdout1_108ck340 FIND v(dout1_108) AT=350.05n

.meas tran vdout1_109ck340 FIND v(dout1_109) AT=350.05n

.meas tran vdout1_110ck340 FIND v(dout1_110) AT=350.05n

.meas tran vdout1_111ck340 FIND v(dout1_111) AT=350.05n

.meas tran vdout1_112ck340 FIND v(dout1_112) AT=350.05n

.meas tran vdout1_113ck340 FIND v(dout1_113) AT=350.05n

.meas tran vdout1_114ck340 FIND v(dout1_114) AT=350.05n

.meas tran vdout1_115ck340 FIND v(dout1_115) AT=350.05n

.meas tran vdout1_116ck340 FIND v(dout1_116) AT=350.05n

.meas tran vdout1_117ck340 FIND v(dout1_117) AT=350.05n

.meas tran vdout1_118ck340 FIND v(dout1_118) AT=350.05n

.meas tran vdout1_119ck340 FIND v(dout1_119) AT=350.05n

.meas tran vdout1_120ck340 FIND v(dout1_120) AT=350.05n

.meas tran vdout1_121ck340 FIND v(dout1_121) AT=350.05n

.meas tran vdout1_122ck340 FIND v(dout1_122) AT=350.05n

.meas tran vdout1_123ck340 FIND v(dout1_123) AT=350.05n

.meas tran vdout1_124ck340 FIND v(dout1_124) AT=350.05n

.meas tran vdout1_125ck340 FIND v(dout1_125) AT=350.05n

.meas tran vdout1_126ck340 FIND v(dout1_126) AT=350.05n

.meas tran vdout1_127ck340 FIND v(dout1_127) AT=350.05n

.meas tran vdout1_128ck340 FIND v(dout1_128) AT=350.05n

.meas tran vdout1_129ck340 FIND v(dout1_129) AT=350.05n

.meas tran vdout1_130ck340 FIND v(dout1_130) AT=350.05n

.meas tran vdout1_131ck340 FIND v(dout1_131) AT=350.05n

.meas tran vdout1_132ck340 FIND v(dout1_132) AT=350.05n

.meas tran vdout1_133ck340 FIND v(dout1_133) AT=350.05n

.meas tran vdout1_134ck340 FIND v(dout1_134) AT=350.05n

.meas tran vdout1_0ck390 FIND v(dout1_0) AT=400.05n

.meas tran vdout1_1ck390 FIND v(dout1_1) AT=400.05n

.meas tran vdout1_2ck390 FIND v(dout1_2) AT=400.05n

.meas tran vdout1_3ck390 FIND v(dout1_3) AT=400.05n

.meas tran vdout1_4ck390 FIND v(dout1_4) AT=400.05n

.meas tran vdout1_5ck390 FIND v(dout1_5) AT=400.05n

.meas tran vdout1_6ck390 FIND v(dout1_6) AT=400.05n

.meas tran vdout1_7ck390 FIND v(dout1_7) AT=400.05n

.meas tran vdout1_8ck390 FIND v(dout1_8) AT=400.05n

.meas tran vdout1_9ck390 FIND v(dout1_9) AT=400.05n

.meas tran vdout1_10ck390 FIND v(dout1_10) AT=400.05n

.meas tran vdout1_11ck390 FIND v(dout1_11) AT=400.05n

.meas tran vdout1_12ck390 FIND v(dout1_12) AT=400.05n

.meas tran vdout1_13ck390 FIND v(dout1_13) AT=400.05n

.meas tran vdout1_14ck390 FIND v(dout1_14) AT=400.05n

.meas tran vdout1_15ck390 FIND v(dout1_15) AT=400.05n

.meas tran vdout1_16ck390 FIND v(dout1_16) AT=400.05n

.meas tran vdout1_17ck390 FIND v(dout1_17) AT=400.05n

.meas tran vdout1_18ck390 FIND v(dout1_18) AT=400.05n

.meas tran vdout1_19ck390 FIND v(dout1_19) AT=400.05n

.meas tran vdout1_20ck390 FIND v(dout1_20) AT=400.05n

.meas tran vdout1_21ck390 FIND v(dout1_21) AT=400.05n

.meas tran vdout1_22ck390 FIND v(dout1_22) AT=400.05n

.meas tran vdout1_23ck390 FIND v(dout1_23) AT=400.05n

.meas tran vdout1_24ck390 FIND v(dout1_24) AT=400.05n

.meas tran vdout1_25ck390 FIND v(dout1_25) AT=400.05n

.meas tran vdout1_26ck390 FIND v(dout1_26) AT=400.05n

.meas tran vdout1_27ck390 FIND v(dout1_27) AT=400.05n

.meas tran vdout1_28ck390 FIND v(dout1_28) AT=400.05n

.meas tran vdout1_29ck390 FIND v(dout1_29) AT=400.05n

.meas tran vdout1_30ck390 FIND v(dout1_30) AT=400.05n

.meas tran vdout1_31ck390 FIND v(dout1_31) AT=400.05n

.meas tran vdout1_32ck390 FIND v(dout1_32) AT=400.05n

.meas tran vdout1_33ck390 FIND v(dout1_33) AT=400.05n

.meas tran vdout1_34ck390 FIND v(dout1_34) AT=400.05n

.meas tran vdout1_35ck390 FIND v(dout1_35) AT=400.05n

.meas tran vdout1_36ck390 FIND v(dout1_36) AT=400.05n

.meas tran vdout1_37ck390 FIND v(dout1_37) AT=400.05n

.meas tran vdout1_38ck390 FIND v(dout1_38) AT=400.05n

.meas tran vdout1_39ck390 FIND v(dout1_39) AT=400.05n

.meas tran vdout1_40ck390 FIND v(dout1_40) AT=400.05n

.meas tran vdout1_41ck390 FIND v(dout1_41) AT=400.05n

.meas tran vdout1_42ck390 FIND v(dout1_42) AT=400.05n

.meas tran vdout1_43ck390 FIND v(dout1_43) AT=400.05n

.meas tran vdout1_44ck390 FIND v(dout1_44) AT=400.05n

.meas tran vdout1_45ck390 FIND v(dout1_45) AT=400.05n

.meas tran vdout1_46ck390 FIND v(dout1_46) AT=400.05n

.meas tran vdout1_47ck390 FIND v(dout1_47) AT=400.05n

.meas tran vdout1_48ck390 FIND v(dout1_48) AT=400.05n

.meas tran vdout1_49ck390 FIND v(dout1_49) AT=400.05n

.meas tran vdout1_50ck390 FIND v(dout1_50) AT=400.05n

.meas tran vdout1_51ck390 FIND v(dout1_51) AT=400.05n

.meas tran vdout1_52ck390 FIND v(dout1_52) AT=400.05n

.meas tran vdout1_53ck390 FIND v(dout1_53) AT=400.05n

.meas tran vdout1_54ck390 FIND v(dout1_54) AT=400.05n

.meas tran vdout1_55ck390 FIND v(dout1_55) AT=400.05n

.meas tran vdout1_56ck390 FIND v(dout1_56) AT=400.05n

.meas tran vdout1_57ck390 FIND v(dout1_57) AT=400.05n

.meas tran vdout1_58ck390 FIND v(dout1_58) AT=400.05n

.meas tran vdout1_59ck390 FIND v(dout1_59) AT=400.05n

.meas tran vdout1_60ck390 FIND v(dout1_60) AT=400.05n

.meas tran vdout1_61ck390 FIND v(dout1_61) AT=400.05n

.meas tran vdout1_62ck390 FIND v(dout1_62) AT=400.05n

.meas tran vdout1_63ck390 FIND v(dout1_63) AT=400.05n

.meas tran vdout1_64ck390 FIND v(dout1_64) AT=400.05n

.meas tran vdout1_65ck390 FIND v(dout1_65) AT=400.05n

.meas tran vdout1_66ck390 FIND v(dout1_66) AT=400.05n

.meas tran vdout1_67ck390 FIND v(dout1_67) AT=400.05n

.meas tran vdout1_68ck390 FIND v(dout1_68) AT=400.05n

.meas tran vdout1_69ck390 FIND v(dout1_69) AT=400.05n

.meas tran vdout1_70ck390 FIND v(dout1_70) AT=400.05n

.meas tran vdout1_71ck390 FIND v(dout1_71) AT=400.05n

.meas tran vdout1_72ck390 FIND v(dout1_72) AT=400.05n

.meas tran vdout1_73ck390 FIND v(dout1_73) AT=400.05n

.meas tran vdout1_74ck390 FIND v(dout1_74) AT=400.05n

.meas tran vdout1_75ck390 FIND v(dout1_75) AT=400.05n

.meas tran vdout1_76ck390 FIND v(dout1_76) AT=400.05n

.meas tran vdout1_77ck390 FIND v(dout1_77) AT=400.05n

.meas tran vdout1_78ck390 FIND v(dout1_78) AT=400.05n

.meas tran vdout1_79ck390 FIND v(dout1_79) AT=400.05n

.meas tran vdout1_80ck390 FIND v(dout1_80) AT=400.05n

.meas tran vdout1_81ck390 FIND v(dout1_81) AT=400.05n

.meas tran vdout1_82ck390 FIND v(dout1_82) AT=400.05n

.meas tran vdout1_83ck390 FIND v(dout1_83) AT=400.05n

.meas tran vdout1_84ck390 FIND v(dout1_84) AT=400.05n

.meas tran vdout1_85ck390 FIND v(dout1_85) AT=400.05n

.meas tran vdout1_86ck390 FIND v(dout1_86) AT=400.05n

.meas tran vdout1_87ck390 FIND v(dout1_87) AT=400.05n

.meas tran vdout1_88ck390 FIND v(dout1_88) AT=400.05n

.meas tran vdout1_89ck390 FIND v(dout1_89) AT=400.05n

.meas tran vdout1_90ck390 FIND v(dout1_90) AT=400.05n

.meas tran vdout1_91ck390 FIND v(dout1_91) AT=400.05n

.meas tran vdout1_92ck390 FIND v(dout1_92) AT=400.05n

.meas tran vdout1_93ck390 FIND v(dout1_93) AT=400.05n

.meas tran vdout1_94ck390 FIND v(dout1_94) AT=400.05n

.meas tran vdout1_95ck390 FIND v(dout1_95) AT=400.05n

.meas tran vdout1_96ck390 FIND v(dout1_96) AT=400.05n

.meas tran vdout1_97ck390 FIND v(dout1_97) AT=400.05n

.meas tran vdout1_98ck390 FIND v(dout1_98) AT=400.05n

.meas tran vdout1_99ck390 FIND v(dout1_99) AT=400.05n

.meas tran vdout1_100ck390 FIND v(dout1_100) AT=400.05n

.meas tran vdout1_101ck390 FIND v(dout1_101) AT=400.05n

.meas tran vdout1_102ck390 FIND v(dout1_102) AT=400.05n

.meas tran vdout1_103ck390 FIND v(dout1_103) AT=400.05n

.meas tran vdout1_104ck390 FIND v(dout1_104) AT=400.05n

.meas tran vdout1_105ck390 FIND v(dout1_105) AT=400.05n

.meas tran vdout1_106ck390 FIND v(dout1_106) AT=400.05n

.meas tran vdout1_107ck390 FIND v(dout1_107) AT=400.05n

.meas tran vdout1_108ck390 FIND v(dout1_108) AT=400.05n

.meas tran vdout1_109ck390 FIND v(dout1_109) AT=400.05n

.meas tran vdout1_110ck390 FIND v(dout1_110) AT=400.05n

.meas tran vdout1_111ck390 FIND v(dout1_111) AT=400.05n

.meas tran vdout1_112ck390 FIND v(dout1_112) AT=400.05n

.meas tran vdout1_113ck390 FIND v(dout1_113) AT=400.05n

.meas tran vdout1_114ck390 FIND v(dout1_114) AT=400.05n

.meas tran vdout1_115ck390 FIND v(dout1_115) AT=400.05n

.meas tran vdout1_116ck390 FIND v(dout1_116) AT=400.05n

.meas tran vdout1_117ck390 FIND v(dout1_117) AT=400.05n

.meas tran vdout1_118ck390 FIND v(dout1_118) AT=400.05n

.meas tran vdout1_119ck390 FIND v(dout1_119) AT=400.05n

.meas tran vdout1_120ck390 FIND v(dout1_120) AT=400.05n

.meas tran vdout1_121ck390 FIND v(dout1_121) AT=400.05n

.meas tran vdout1_122ck390 FIND v(dout1_122) AT=400.05n

.meas tran vdout1_123ck390 FIND v(dout1_123) AT=400.05n

.meas tran vdout1_124ck390 FIND v(dout1_124) AT=400.05n

.meas tran vdout1_125ck390 FIND v(dout1_125) AT=400.05n

.meas tran vdout1_126ck390 FIND v(dout1_126) AT=400.05n

.meas tran vdout1_127ck390 FIND v(dout1_127) AT=400.05n

.meas tran vdout1_128ck390 FIND v(dout1_128) AT=400.05n

.meas tran vdout1_129ck390 FIND v(dout1_129) AT=400.05n

.meas tran vdout1_130ck390 FIND v(dout1_130) AT=400.05n

.meas tran vdout1_131ck390 FIND v(dout1_131) AT=400.05n

.meas tran vdout1_132ck390 FIND v(dout1_132) AT=400.05n

.meas tran vdout1_133ck390 FIND v(dout1_133) AT=400.05n

.meas tran vdout1_134ck390 FIND v(dout1_134) AT=400.05n

.meas tran vdout1_0ck420 FIND v(dout1_0) AT=430.05n

.meas tran vdout1_1ck420 FIND v(dout1_1) AT=430.05n

.meas tran vdout1_2ck420 FIND v(dout1_2) AT=430.05n

.meas tran vdout1_3ck420 FIND v(dout1_3) AT=430.05n

.meas tran vdout1_4ck420 FIND v(dout1_4) AT=430.05n

.meas tran vdout1_5ck420 FIND v(dout1_5) AT=430.05n

.meas tran vdout1_6ck420 FIND v(dout1_6) AT=430.05n

.meas tran vdout1_7ck420 FIND v(dout1_7) AT=430.05n

.meas tran vdout1_8ck420 FIND v(dout1_8) AT=430.05n

.meas tran vdout1_9ck420 FIND v(dout1_9) AT=430.05n

.meas tran vdout1_10ck420 FIND v(dout1_10) AT=430.05n

.meas tran vdout1_11ck420 FIND v(dout1_11) AT=430.05n

.meas tran vdout1_12ck420 FIND v(dout1_12) AT=430.05n

.meas tran vdout1_13ck420 FIND v(dout1_13) AT=430.05n

.meas tran vdout1_14ck420 FIND v(dout1_14) AT=430.05n

.meas tran vdout1_15ck420 FIND v(dout1_15) AT=430.05n

.meas tran vdout1_16ck420 FIND v(dout1_16) AT=430.05n

.meas tran vdout1_17ck420 FIND v(dout1_17) AT=430.05n

.meas tran vdout1_18ck420 FIND v(dout1_18) AT=430.05n

.meas tran vdout1_19ck420 FIND v(dout1_19) AT=430.05n

.meas tran vdout1_20ck420 FIND v(dout1_20) AT=430.05n

.meas tran vdout1_21ck420 FIND v(dout1_21) AT=430.05n

.meas tran vdout1_22ck420 FIND v(dout1_22) AT=430.05n

.meas tran vdout1_23ck420 FIND v(dout1_23) AT=430.05n

.meas tran vdout1_24ck420 FIND v(dout1_24) AT=430.05n

.meas tran vdout1_25ck420 FIND v(dout1_25) AT=430.05n

.meas tran vdout1_26ck420 FIND v(dout1_26) AT=430.05n

.meas tran vdout1_27ck420 FIND v(dout1_27) AT=430.05n

.meas tran vdout1_28ck420 FIND v(dout1_28) AT=430.05n

.meas tran vdout1_29ck420 FIND v(dout1_29) AT=430.05n

.meas tran vdout1_30ck420 FIND v(dout1_30) AT=430.05n

.meas tran vdout1_31ck420 FIND v(dout1_31) AT=430.05n

.meas tran vdout1_32ck420 FIND v(dout1_32) AT=430.05n

.meas tran vdout1_33ck420 FIND v(dout1_33) AT=430.05n

.meas tran vdout1_34ck420 FIND v(dout1_34) AT=430.05n

.meas tran vdout1_35ck420 FIND v(dout1_35) AT=430.05n

.meas tran vdout1_36ck420 FIND v(dout1_36) AT=430.05n

.meas tran vdout1_37ck420 FIND v(dout1_37) AT=430.05n

.meas tran vdout1_38ck420 FIND v(dout1_38) AT=430.05n

.meas tran vdout1_39ck420 FIND v(dout1_39) AT=430.05n

.meas tran vdout1_40ck420 FIND v(dout1_40) AT=430.05n

.meas tran vdout1_41ck420 FIND v(dout1_41) AT=430.05n

.meas tran vdout1_42ck420 FIND v(dout1_42) AT=430.05n

.meas tran vdout1_43ck420 FIND v(dout1_43) AT=430.05n

.meas tran vdout1_44ck420 FIND v(dout1_44) AT=430.05n

.meas tran vdout1_45ck420 FIND v(dout1_45) AT=430.05n

.meas tran vdout1_46ck420 FIND v(dout1_46) AT=430.05n

.meas tran vdout1_47ck420 FIND v(dout1_47) AT=430.05n

.meas tran vdout1_48ck420 FIND v(dout1_48) AT=430.05n

.meas tran vdout1_49ck420 FIND v(dout1_49) AT=430.05n

.meas tran vdout1_50ck420 FIND v(dout1_50) AT=430.05n

.meas tran vdout1_51ck420 FIND v(dout1_51) AT=430.05n

.meas tran vdout1_52ck420 FIND v(dout1_52) AT=430.05n

.meas tran vdout1_53ck420 FIND v(dout1_53) AT=430.05n

.meas tran vdout1_54ck420 FIND v(dout1_54) AT=430.05n

.meas tran vdout1_55ck420 FIND v(dout1_55) AT=430.05n

.meas tran vdout1_56ck420 FIND v(dout1_56) AT=430.05n

.meas tran vdout1_57ck420 FIND v(dout1_57) AT=430.05n

.meas tran vdout1_58ck420 FIND v(dout1_58) AT=430.05n

.meas tran vdout1_59ck420 FIND v(dout1_59) AT=430.05n

.meas tran vdout1_60ck420 FIND v(dout1_60) AT=430.05n

.meas tran vdout1_61ck420 FIND v(dout1_61) AT=430.05n

.meas tran vdout1_62ck420 FIND v(dout1_62) AT=430.05n

.meas tran vdout1_63ck420 FIND v(dout1_63) AT=430.05n

.meas tran vdout1_64ck420 FIND v(dout1_64) AT=430.05n

.meas tran vdout1_65ck420 FIND v(dout1_65) AT=430.05n

.meas tran vdout1_66ck420 FIND v(dout1_66) AT=430.05n

.meas tran vdout1_67ck420 FIND v(dout1_67) AT=430.05n

.meas tran vdout1_68ck420 FIND v(dout1_68) AT=430.05n

.meas tran vdout1_69ck420 FIND v(dout1_69) AT=430.05n

.meas tran vdout1_70ck420 FIND v(dout1_70) AT=430.05n

.meas tran vdout1_71ck420 FIND v(dout1_71) AT=430.05n

.meas tran vdout1_72ck420 FIND v(dout1_72) AT=430.05n

.meas tran vdout1_73ck420 FIND v(dout1_73) AT=430.05n

.meas tran vdout1_74ck420 FIND v(dout1_74) AT=430.05n

.meas tran vdout1_75ck420 FIND v(dout1_75) AT=430.05n

.meas tran vdout1_76ck420 FIND v(dout1_76) AT=430.05n

.meas tran vdout1_77ck420 FIND v(dout1_77) AT=430.05n

.meas tran vdout1_78ck420 FIND v(dout1_78) AT=430.05n

.meas tran vdout1_79ck420 FIND v(dout1_79) AT=430.05n

.meas tran vdout1_80ck420 FIND v(dout1_80) AT=430.05n

.meas tran vdout1_81ck420 FIND v(dout1_81) AT=430.05n

.meas tran vdout1_82ck420 FIND v(dout1_82) AT=430.05n

.meas tran vdout1_83ck420 FIND v(dout1_83) AT=430.05n

.meas tran vdout1_84ck420 FIND v(dout1_84) AT=430.05n

.meas tran vdout1_85ck420 FIND v(dout1_85) AT=430.05n

.meas tran vdout1_86ck420 FIND v(dout1_86) AT=430.05n

.meas tran vdout1_87ck420 FIND v(dout1_87) AT=430.05n

.meas tran vdout1_88ck420 FIND v(dout1_88) AT=430.05n

.meas tran vdout1_89ck420 FIND v(dout1_89) AT=430.05n

.meas tran vdout1_90ck420 FIND v(dout1_90) AT=430.05n

.meas tran vdout1_91ck420 FIND v(dout1_91) AT=430.05n

.meas tran vdout1_92ck420 FIND v(dout1_92) AT=430.05n

.meas tran vdout1_93ck420 FIND v(dout1_93) AT=430.05n

.meas tran vdout1_94ck420 FIND v(dout1_94) AT=430.05n

.meas tran vdout1_95ck420 FIND v(dout1_95) AT=430.05n

.meas tran vdout1_96ck420 FIND v(dout1_96) AT=430.05n

.meas tran vdout1_97ck420 FIND v(dout1_97) AT=430.05n

.meas tran vdout1_98ck420 FIND v(dout1_98) AT=430.05n

.meas tran vdout1_99ck420 FIND v(dout1_99) AT=430.05n

.meas tran vdout1_100ck420 FIND v(dout1_100) AT=430.05n

.meas tran vdout1_101ck420 FIND v(dout1_101) AT=430.05n

.meas tran vdout1_102ck420 FIND v(dout1_102) AT=430.05n

.meas tran vdout1_103ck420 FIND v(dout1_103) AT=430.05n

.meas tran vdout1_104ck420 FIND v(dout1_104) AT=430.05n

.meas tran vdout1_105ck420 FIND v(dout1_105) AT=430.05n

.meas tran vdout1_106ck420 FIND v(dout1_106) AT=430.05n

.meas tran vdout1_107ck420 FIND v(dout1_107) AT=430.05n

.meas tran vdout1_108ck420 FIND v(dout1_108) AT=430.05n

.meas tran vdout1_109ck420 FIND v(dout1_109) AT=430.05n

.meas tran vdout1_110ck420 FIND v(dout1_110) AT=430.05n

.meas tran vdout1_111ck420 FIND v(dout1_111) AT=430.05n

.meas tran vdout1_112ck420 FIND v(dout1_112) AT=430.05n

.meas tran vdout1_113ck420 FIND v(dout1_113) AT=430.05n

.meas tran vdout1_114ck420 FIND v(dout1_114) AT=430.05n

.meas tran vdout1_115ck420 FIND v(dout1_115) AT=430.05n

.meas tran vdout1_116ck420 FIND v(dout1_116) AT=430.05n

.meas tran vdout1_117ck420 FIND v(dout1_117) AT=430.05n

.meas tran vdout1_118ck420 FIND v(dout1_118) AT=430.05n

.meas tran vdout1_119ck420 FIND v(dout1_119) AT=430.05n

.meas tran vdout1_120ck420 FIND v(dout1_120) AT=430.05n

.meas tran vdout1_121ck420 FIND v(dout1_121) AT=430.05n

.meas tran vdout1_122ck420 FIND v(dout1_122) AT=430.05n

.meas tran vdout1_123ck420 FIND v(dout1_123) AT=430.05n

.meas tran vdout1_124ck420 FIND v(dout1_124) AT=430.05n

.meas tran vdout1_125ck420 FIND v(dout1_125) AT=430.05n

.meas tran vdout1_126ck420 FIND v(dout1_126) AT=430.05n

.meas tran vdout1_127ck420 FIND v(dout1_127) AT=430.05n

.meas tran vdout1_128ck420 FIND v(dout1_128) AT=430.05n

.meas tran vdout1_129ck420 FIND v(dout1_129) AT=430.05n

.meas tran vdout1_130ck420 FIND v(dout1_130) AT=430.05n

.meas tran vdout1_131ck420 FIND v(dout1_131) AT=430.05n

.meas tran vdout1_132ck420 FIND v(dout1_132) AT=430.05n

.meas tran vdout1_133ck420 FIND v(dout1_133) AT=430.05n

.meas tran vdout1_134ck420 FIND v(dout1_134) AT=430.05n

.meas tran vdout1_0ck430 FIND v(dout1_0) AT=440.05n

.meas tran vdout1_1ck430 FIND v(dout1_1) AT=440.05n

.meas tran vdout1_2ck430 FIND v(dout1_2) AT=440.05n

.meas tran vdout1_3ck430 FIND v(dout1_3) AT=440.05n

.meas tran vdout1_4ck430 FIND v(dout1_4) AT=440.05n

.meas tran vdout1_5ck430 FIND v(dout1_5) AT=440.05n

.meas tran vdout1_6ck430 FIND v(dout1_6) AT=440.05n

.meas tran vdout1_7ck430 FIND v(dout1_7) AT=440.05n

.meas tran vdout1_8ck430 FIND v(dout1_8) AT=440.05n

.meas tran vdout1_9ck430 FIND v(dout1_9) AT=440.05n

.meas tran vdout1_10ck430 FIND v(dout1_10) AT=440.05n

.meas tran vdout1_11ck430 FIND v(dout1_11) AT=440.05n

.meas tran vdout1_12ck430 FIND v(dout1_12) AT=440.05n

.meas tran vdout1_13ck430 FIND v(dout1_13) AT=440.05n

.meas tran vdout1_14ck430 FIND v(dout1_14) AT=440.05n

.meas tran vdout1_15ck430 FIND v(dout1_15) AT=440.05n

.meas tran vdout1_16ck430 FIND v(dout1_16) AT=440.05n

.meas tran vdout1_17ck430 FIND v(dout1_17) AT=440.05n

.meas tran vdout1_18ck430 FIND v(dout1_18) AT=440.05n

.meas tran vdout1_19ck430 FIND v(dout1_19) AT=440.05n

.meas tran vdout1_20ck430 FIND v(dout1_20) AT=440.05n

.meas tran vdout1_21ck430 FIND v(dout1_21) AT=440.05n

.meas tran vdout1_22ck430 FIND v(dout1_22) AT=440.05n

.meas tran vdout1_23ck430 FIND v(dout1_23) AT=440.05n

.meas tran vdout1_24ck430 FIND v(dout1_24) AT=440.05n

.meas tran vdout1_25ck430 FIND v(dout1_25) AT=440.05n

.meas tran vdout1_26ck430 FIND v(dout1_26) AT=440.05n

.meas tran vdout1_27ck430 FIND v(dout1_27) AT=440.05n

.meas tran vdout1_28ck430 FIND v(dout1_28) AT=440.05n

.meas tran vdout1_29ck430 FIND v(dout1_29) AT=440.05n

.meas tran vdout1_30ck430 FIND v(dout1_30) AT=440.05n

.meas tran vdout1_31ck430 FIND v(dout1_31) AT=440.05n

.meas tran vdout1_32ck430 FIND v(dout1_32) AT=440.05n

.meas tran vdout1_33ck430 FIND v(dout1_33) AT=440.05n

.meas tran vdout1_34ck430 FIND v(dout1_34) AT=440.05n

.meas tran vdout1_35ck430 FIND v(dout1_35) AT=440.05n

.meas tran vdout1_36ck430 FIND v(dout1_36) AT=440.05n

.meas tran vdout1_37ck430 FIND v(dout1_37) AT=440.05n

.meas tran vdout1_38ck430 FIND v(dout1_38) AT=440.05n

.meas tran vdout1_39ck430 FIND v(dout1_39) AT=440.05n

.meas tran vdout1_40ck430 FIND v(dout1_40) AT=440.05n

.meas tran vdout1_41ck430 FIND v(dout1_41) AT=440.05n

.meas tran vdout1_42ck430 FIND v(dout1_42) AT=440.05n

.meas tran vdout1_43ck430 FIND v(dout1_43) AT=440.05n

.meas tran vdout1_44ck430 FIND v(dout1_44) AT=440.05n

.meas tran vdout1_45ck430 FIND v(dout1_45) AT=440.05n

.meas tran vdout1_46ck430 FIND v(dout1_46) AT=440.05n

.meas tran vdout1_47ck430 FIND v(dout1_47) AT=440.05n

.meas tran vdout1_48ck430 FIND v(dout1_48) AT=440.05n

.meas tran vdout1_49ck430 FIND v(dout1_49) AT=440.05n

.meas tran vdout1_50ck430 FIND v(dout1_50) AT=440.05n

.meas tran vdout1_51ck430 FIND v(dout1_51) AT=440.05n

.meas tran vdout1_52ck430 FIND v(dout1_52) AT=440.05n

.meas tran vdout1_53ck430 FIND v(dout1_53) AT=440.05n

.meas tran vdout1_54ck430 FIND v(dout1_54) AT=440.05n

.meas tran vdout1_55ck430 FIND v(dout1_55) AT=440.05n

.meas tran vdout1_56ck430 FIND v(dout1_56) AT=440.05n

.meas tran vdout1_57ck430 FIND v(dout1_57) AT=440.05n

.meas tran vdout1_58ck430 FIND v(dout1_58) AT=440.05n

.meas tran vdout1_59ck430 FIND v(dout1_59) AT=440.05n

.meas tran vdout1_60ck430 FIND v(dout1_60) AT=440.05n

.meas tran vdout1_61ck430 FIND v(dout1_61) AT=440.05n

.meas tran vdout1_62ck430 FIND v(dout1_62) AT=440.05n

.meas tran vdout1_63ck430 FIND v(dout1_63) AT=440.05n

.meas tran vdout1_64ck430 FIND v(dout1_64) AT=440.05n

.meas tran vdout1_65ck430 FIND v(dout1_65) AT=440.05n

.meas tran vdout1_66ck430 FIND v(dout1_66) AT=440.05n

.meas tran vdout1_67ck430 FIND v(dout1_67) AT=440.05n

.meas tran vdout1_68ck430 FIND v(dout1_68) AT=440.05n

.meas tran vdout1_69ck430 FIND v(dout1_69) AT=440.05n

.meas tran vdout1_70ck430 FIND v(dout1_70) AT=440.05n

.meas tran vdout1_71ck430 FIND v(dout1_71) AT=440.05n

.meas tran vdout1_72ck430 FIND v(dout1_72) AT=440.05n

.meas tran vdout1_73ck430 FIND v(dout1_73) AT=440.05n

.meas tran vdout1_74ck430 FIND v(dout1_74) AT=440.05n

.meas tran vdout1_75ck430 FIND v(dout1_75) AT=440.05n

.meas tran vdout1_76ck430 FIND v(dout1_76) AT=440.05n

.meas tran vdout1_77ck430 FIND v(dout1_77) AT=440.05n

.meas tran vdout1_78ck430 FIND v(dout1_78) AT=440.05n

.meas tran vdout1_79ck430 FIND v(dout1_79) AT=440.05n

.meas tran vdout1_80ck430 FIND v(dout1_80) AT=440.05n

.meas tran vdout1_81ck430 FIND v(dout1_81) AT=440.05n

.meas tran vdout1_82ck430 FIND v(dout1_82) AT=440.05n

.meas tran vdout1_83ck430 FIND v(dout1_83) AT=440.05n

.meas tran vdout1_84ck430 FIND v(dout1_84) AT=440.05n

.meas tran vdout1_85ck430 FIND v(dout1_85) AT=440.05n

.meas tran vdout1_86ck430 FIND v(dout1_86) AT=440.05n

.meas tran vdout1_87ck430 FIND v(dout1_87) AT=440.05n

.meas tran vdout1_88ck430 FIND v(dout1_88) AT=440.05n

.meas tran vdout1_89ck430 FIND v(dout1_89) AT=440.05n

.meas tran vdout1_90ck430 FIND v(dout1_90) AT=440.05n

.meas tran vdout1_91ck430 FIND v(dout1_91) AT=440.05n

.meas tran vdout1_92ck430 FIND v(dout1_92) AT=440.05n

.meas tran vdout1_93ck430 FIND v(dout1_93) AT=440.05n

.meas tran vdout1_94ck430 FIND v(dout1_94) AT=440.05n

.meas tran vdout1_95ck430 FIND v(dout1_95) AT=440.05n

.meas tran vdout1_96ck430 FIND v(dout1_96) AT=440.05n

.meas tran vdout1_97ck430 FIND v(dout1_97) AT=440.05n

.meas tran vdout1_98ck430 FIND v(dout1_98) AT=440.05n

.meas tran vdout1_99ck430 FIND v(dout1_99) AT=440.05n

.meas tran vdout1_100ck430 FIND v(dout1_100) AT=440.05n

.meas tran vdout1_101ck430 FIND v(dout1_101) AT=440.05n

.meas tran vdout1_102ck430 FIND v(dout1_102) AT=440.05n

.meas tran vdout1_103ck430 FIND v(dout1_103) AT=440.05n

.meas tran vdout1_104ck430 FIND v(dout1_104) AT=440.05n

.meas tran vdout1_105ck430 FIND v(dout1_105) AT=440.05n

.meas tran vdout1_106ck430 FIND v(dout1_106) AT=440.05n

.meas tran vdout1_107ck430 FIND v(dout1_107) AT=440.05n

.meas tran vdout1_108ck430 FIND v(dout1_108) AT=440.05n

.meas tran vdout1_109ck430 FIND v(dout1_109) AT=440.05n

.meas tran vdout1_110ck430 FIND v(dout1_110) AT=440.05n

.meas tran vdout1_111ck430 FIND v(dout1_111) AT=440.05n

.meas tran vdout1_112ck430 FIND v(dout1_112) AT=440.05n

.meas tran vdout1_113ck430 FIND v(dout1_113) AT=440.05n

.meas tran vdout1_114ck430 FIND v(dout1_114) AT=440.05n

.meas tran vdout1_115ck430 FIND v(dout1_115) AT=440.05n

.meas tran vdout1_116ck430 FIND v(dout1_116) AT=440.05n

.meas tran vdout1_117ck430 FIND v(dout1_117) AT=440.05n

.meas tran vdout1_118ck430 FIND v(dout1_118) AT=440.05n

.meas tran vdout1_119ck430 FIND v(dout1_119) AT=440.05n

.meas tran vdout1_120ck430 FIND v(dout1_120) AT=440.05n

.meas tran vdout1_121ck430 FIND v(dout1_121) AT=440.05n

.meas tran vdout1_122ck430 FIND v(dout1_122) AT=440.05n

.meas tran vdout1_123ck430 FIND v(dout1_123) AT=440.05n

.meas tran vdout1_124ck430 FIND v(dout1_124) AT=440.05n

.meas tran vdout1_125ck430 FIND v(dout1_125) AT=440.05n

.meas tran vdout1_126ck430 FIND v(dout1_126) AT=440.05n

.meas tran vdout1_127ck430 FIND v(dout1_127) AT=440.05n

.meas tran vdout1_128ck430 FIND v(dout1_128) AT=440.05n

.meas tran vdout1_129ck430 FIND v(dout1_129) AT=440.05n

.meas tran vdout1_130ck430 FIND v(dout1_130) AT=440.05n

.meas tran vdout1_131ck430 FIND v(dout1_131) AT=440.05n

.meas tran vdout1_132ck430 FIND v(dout1_132) AT=440.05n

.meas tran vdout1_133ck430 FIND v(dout1_133) AT=440.05n

.meas tran vdout1_134ck430 FIND v(dout1_134) AT=440.05n

.meas tran vdout1_0ck440 FIND v(dout1_0) AT=450.05n

.meas tran vdout1_1ck440 FIND v(dout1_1) AT=450.05n

.meas tran vdout1_2ck440 FIND v(dout1_2) AT=450.05n

.meas tran vdout1_3ck440 FIND v(dout1_3) AT=450.05n

.meas tran vdout1_4ck440 FIND v(dout1_4) AT=450.05n

.meas tran vdout1_5ck440 FIND v(dout1_5) AT=450.05n

.meas tran vdout1_6ck440 FIND v(dout1_6) AT=450.05n

.meas tran vdout1_7ck440 FIND v(dout1_7) AT=450.05n

.meas tran vdout1_8ck440 FIND v(dout1_8) AT=450.05n

.meas tran vdout1_9ck440 FIND v(dout1_9) AT=450.05n

.meas tran vdout1_10ck440 FIND v(dout1_10) AT=450.05n

.meas tran vdout1_11ck440 FIND v(dout1_11) AT=450.05n

.meas tran vdout1_12ck440 FIND v(dout1_12) AT=450.05n

.meas tran vdout1_13ck440 FIND v(dout1_13) AT=450.05n

.meas tran vdout1_14ck440 FIND v(dout1_14) AT=450.05n

.meas tran vdout1_15ck440 FIND v(dout1_15) AT=450.05n

.meas tran vdout1_16ck440 FIND v(dout1_16) AT=450.05n

.meas tran vdout1_17ck440 FIND v(dout1_17) AT=450.05n

.meas tran vdout1_18ck440 FIND v(dout1_18) AT=450.05n

.meas tran vdout1_19ck440 FIND v(dout1_19) AT=450.05n

.meas tran vdout1_20ck440 FIND v(dout1_20) AT=450.05n

.meas tran vdout1_21ck440 FIND v(dout1_21) AT=450.05n

.meas tran vdout1_22ck440 FIND v(dout1_22) AT=450.05n

.meas tran vdout1_23ck440 FIND v(dout1_23) AT=450.05n

.meas tran vdout1_24ck440 FIND v(dout1_24) AT=450.05n

.meas tran vdout1_25ck440 FIND v(dout1_25) AT=450.05n

.meas tran vdout1_26ck440 FIND v(dout1_26) AT=450.05n

.meas tran vdout1_27ck440 FIND v(dout1_27) AT=450.05n

.meas tran vdout1_28ck440 FIND v(dout1_28) AT=450.05n

.meas tran vdout1_29ck440 FIND v(dout1_29) AT=450.05n

.meas tran vdout1_30ck440 FIND v(dout1_30) AT=450.05n

.meas tran vdout1_31ck440 FIND v(dout1_31) AT=450.05n

.meas tran vdout1_32ck440 FIND v(dout1_32) AT=450.05n

.meas tran vdout1_33ck440 FIND v(dout1_33) AT=450.05n

.meas tran vdout1_34ck440 FIND v(dout1_34) AT=450.05n

.meas tran vdout1_35ck440 FIND v(dout1_35) AT=450.05n

.meas tran vdout1_36ck440 FIND v(dout1_36) AT=450.05n

.meas tran vdout1_37ck440 FIND v(dout1_37) AT=450.05n

.meas tran vdout1_38ck440 FIND v(dout1_38) AT=450.05n

.meas tran vdout1_39ck440 FIND v(dout1_39) AT=450.05n

.meas tran vdout1_40ck440 FIND v(dout1_40) AT=450.05n

.meas tran vdout1_41ck440 FIND v(dout1_41) AT=450.05n

.meas tran vdout1_42ck440 FIND v(dout1_42) AT=450.05n

.meas tran vdout1_43ck440 FIND v(dout1_43) AT=450.05n

.meas tran vdout1_44ck440 FIND v(dout1_44) AT=450.05n

.meas tran vdout1_45ck440 FIND v(dout1_45) AT=450.05n

.meas tran vdout1_46ck440 FIND v(dout1_46) AT=450.05n

.meas tran vdout1_47ck440 FIND v(dout1_47) AT=450.05n

.meas tran vdout1_48ck440 FIND v(dout1_48) AT=450.05n

.meas tran vdout1_49ck440 FIND v(dout1_49) AT=450.05n

.meas tran vdout1_50ck440 FIND v(dout1_50) AT=450.05n

.meas tran vdout1_51ck440 FIND v(dout1_51) AT=450.05n

.meas tran vdout1_52ck440 FIND v(dout1_52) AT=450.05n

.meas tran vdout1_53ck440 FIND v(dout1_53) AT=450.05n

.meas tran vdout1_54ck440 FIND v(dout1_54) AT=450.05n

.meas tran vdout1_55ck440 FIND v(dout1_55) AT=450.05n

.meas tran vdout1_56ck440 FIND v(dout1_56) AT=450.05n

.meas tran vdout1_57ck440 FIND v(dout1_57) AT=450.05n

.meas tran vdout1_58ck440 FIND v(dout1_58) AT=450.05n

.meas tran vdout1_59ck440 FIND v(dout1_59) AT=450.05n

.meas tran vdout1_60ck440 FIND v(dout1_60) AT=450.05n

.meas tran vdout1_61ck440 FIND v(dout1_61) AT=450.05n

.meas tran vdout1_62ck440 FIND v(dout1_62) AT=450.05n

.meas tran vdout1_63ck440 FIND v(dout1_63) AT=450.05n

.meas tran vdout1_64ck440 FIND v(dout1_64) AT=450.05n

.meas tran vdout1_65ck440 FIND v(dout1_65) AT=450.05n

.meas tran vdout1_66ck440 FIND v(dout1_66) AT=450.05n

.meas tran vdout1_67ck440 FIND v(dout1_67) AT=450.05n

.meas tran vdout1_68ck440 FIND v(dout1_68) AT=450.05n

.meas tran vdout1_69ck440 FIND v(dout1_69) AT=450.05n

.meas tran vdout1_70ck440 FIND v(dout1_70) AT=450.05n

.meas tran vdout1_71ck440 FIND v(dout1_71) AT=450.05n

.meas tran vdout1_72ck440 FIND v(dout1_72) AT=450.05n

.meas tran vdout1_73ck440 FIND v(dout1_73) AT=450.05n

.meas tran vdout1_74ck440 FIND v(dout1_74) AT=450.05n

.meas tran vdout1_75ck440 FIND v(dout1_75) AT=450.05n

.meas tran vdout1_76ck440 FIND v(dout1_76) AT=450.05n

.meas tran vdout1_77ck440 FIND v(dout1_77) AT=450.05n

.meas tran vdout1_78ck440 FIND v(dout1_78) AT=450.05n

.meas tran vdout1_79ck440 FIND v(dout1_79) AT=450.05n

.meas tran vdout1_80ck440 FIND v(dout1_80) AT=450.05n

.meas tran vdout1_81ck440 FIND v(dout1_81) AT=450.05n

.meas tran vdout1_82ck440 FIND v(dout1_82) AT=450.05n

.meas tran vdout1_83ck440 FIND v(dout1_83) AT=450.05n

.meas tran vdout1_84ck440 FIND v(dout1_84) AT=450.05n

.meas tran vdout1_85ck440 FIND v(dout1_85) AT=450.05n

.meas tran vdout1_86ck440 FIND v(dout1_86) AT=450.05n

.meas tran vdout1_87ck440 FIND v(dout1_87) AT=450.05n

.meas tran vdout1_88ck440 FIND v(dout1_88) AT=450.05n

.meas tran vdout1_89ck440 FIND v(dout1_89) AT=450.05n

.meas tran vdout1_90ck440 FIND v(dout1_90) AT=450.05n

.meas tran vdout1_91ck440 FIND v(dout1_91) AT=450.05n

.meas tran vdout1_92ck440 FIND v(dout1_92) AT=450.05n

.meas tran vdout1_93ck440 FIND v(dout1_93) AT=450.05n

.meas tran vdout1_94ck440 FIND v(dout1_94) AT=450.05n

.meas tran vdout1_95ck440 FIND v(dout1_95) AT=450.05n

.meas tran vdout1_96ck440 FIND v(dout1_96) AT=450.05n

.meas tran vdout1_97ck440 FIND v(dout1_97) AT=450.05n

.meas tran vdout1_98ck440 FIND v(dout1_98) AT=450.05n

.meas tran vdout1_99ck440 FIND v(dout1_99) AT=450.05n

.meas tran vdout1_100ck440 FIND v(dout1_100) AT=450.05n

.meas tran vdout1_101ck440 FIND v(dout1_101) AT=450.05n

.meas tran vdout1_102ck440 FIND v(dout1_102) AT=450.05n

.meas tran vdout1_103ck440 FIND v(dout1_103) AT=450.05n

.meas tran vdout1_104ck440 FIND v(dout1_104) AT=450.05n

.meas tran vdout1_105ck440 FIND v(dout1_105) AT=450.05n

.meas tran vdout1_106ck440 FIND v(dout1_106) AT=450.05n

.meas tran vdout1_107ck440 FIND v(dout1_107) AT=450.05n

.meas tran vdout1_108ck440 FIND v(dout1_108) AT=450.05n

.meas tran vdout1_109ck440 FIND v(dout1_109) AT=450.05n

.meas tran vdout1_110ck440 FIND v(dout1_110) AT=450.05n

.meas tran vdout1_111ck440 FIND v(dout1_111) AT=450.05n

.meas tran vdout1_112ck440 FIND v(dout1_112) AT=450.05n

.meas tran vdout1_113ck440 FIND v(dout1_113) AT=450.05n

.meas tran vdout1_114ck440 FIND v(dout1_114) AT=450.05n

.meas tran vdout1_115ck440 FIND v(dout1_115) AT=450.05n

.meas tran vdout1_116ck440 FIND v(dout1_116) AT=450.05n

.meas tran vdout1_117ck440 FIND v(dout1_117) AT=450.05n

.meas tran vdout1_118ck440 FIND v(dout1_118) AT=450.05n

.meas tran vdout1_119ck440 FIND v(dout1_119) AT=450.05n

.meas tran vdout1_120ck440 FIND v(dout1_120) AT=450.05n

.meas tran vdout1_121ck440 FIND v(dout1_121) AT=450.05n

.meas tran vdout1_122ck440 FIND v(dout1_122) AT=450.05n

.meas tran vdout1_123ck440 FIND v(dout1_123) AT=450.05n

.meas tran vdout1_124ck440 FIND v(dout1_124) AT=450.05n

.meas tran vdout1_125ck440 FIND v(dout1_125) AT=450.05n

.meas tran vdout1_126ck440 FIND v(dout1_126) AT=450.05n

.meas tran vdout1_127ck440 FIND v(dout1_127) AT=450.05n

.meas tran vdout1_128ck440 FIND v(dout1_128) AT=450.05n

.meas tran vdout1_129ck440 FIND v(dout1_129) AT=450.05n

.meas tran vdout1_130ck440 FIND v(dout1_130) AT=450.05n

.meas tran vdout1_131ck440 FIND v(dout1_131) AT=450.05n

.meas tran vdout1_132ck440 FIND v(dout1_132) AT=450.05n

.meas tran vdout1_133ck440 FIND v(dout1_133) AT=450.05n

.meas tran vdout1_134ck440 FIND v(dout1_134) AT=450.05n

.meas tran vdout1_0ck450 FIND v(dout1_0) AT=460.05n

.meas tran vdout1_1ck450 FIND v(dout1_1) AT=460.05n

.meas tran vdout1_2ck450 FIND v(dout1_2) AT=460.05n

.meas tran vdout1_3ck450 FIND v(dout1_3) AT=460.05n

.meas tran vdout1_4ck450 FIND v(dout1_4) AT=460.05n

.meas tran vdout1_5ck450 FIND v(dout1_5) AT=460.05n

.meas tran vdout1_6ck450 FIND v(dout1_6) AT=460.05n

.meas tran vdout1_7ck450 FIND v(dout1_7) AT=460.05n

.meas tran vdout1_8ck450 FIND v(dout1_8) AT=460.05n

.meas tran vdout1_9ck450 FIND v(dout1_9) AT=460.05n

.meas tran vdout1_10ck450 FIND v(dout1_10) AT=460.05n

.meas tran vdout1_11ck450 FIND v(dout1_11) AT=460.05n

.meas tran vdout1_12ck450 FIND v(dout1_12) AT=460.05n

.meas tran vdout1_13ck450 FIND v(dout1_13) AT=460.05n

.meas tran vdout1_14ck450 FIND v(dout1_14) AT=460.05n

.meas tran vdout1_15ck450 FIND v(dout1_15) AT=460.05n

.meas tran vdout1_16ck450 FIND v(dout1_16) AT=460.05n

.meas tran vdout1_17ck450 FIND v(dout1_17) AT=460.05n

.meas tran vdout1_18ck450 FIND v(dout1_18) AT=460.05n

.meas tran vdout1_19ck450 FIND v(dout1_19) AT=460.05n

.meas tran vdout1_20ck450 FIND v(dout1_20) AT=460.05n

.meas tran vdout1_21ck450 FIND v(dout1_21) AT=460.05n

.meas tran vdout1_22ck450 FIND v(dout1_22) AT=460.05n

.meas tran vdout1_23ck450 FIND v(dout1_23) AT=460.05n

.meas tran vdout1_24ck450 FIND v(dout1_24) AT=460.05n

.meas tran vdout1_25ck450 FIND v(dout1_25) AT=460.05n

.meas tran vdout1_26ck450 FIND v(dout1_26) AT=460.05n

.meas tran vdout1_27ck450 FIND v(dout1_27) AT=460.05n

.meas tran vdout1_28ck450 FIND v(dout1_28) AT=460.05n

.meas tran vdout1_29ck450 FIND v(dout1_29) AT=460.05n

.meas tran vdout1_30ck450 FIND v(dout1_30) AT=460.05n

.meas tran vdout1_31ck450 FIND v(dout1_31) AT=460.05n

.meas tran vdout1_32ck450 FIND v(dout1_32) AT=460.05n

.meas tran vdout1_33ck450 FIND v(dout1_33) AT=460.05n

.meas tran vdout1_34ck450 FIND v(dout1_34) AT=460.05n

.meas tran vdout1_35ck450 FIND v(dout1_35) AT=460.05n

.meas tran vdout1_36ck450 FIND v(dout1_36) AT=460.05n

.meas tran vdout1_37ck450 FIND v(dout1_37) AT=460.05n

.meas tran vdout1_38ck450 FIND v(dout1_38) AT=460.05n

.meas tran vdout1_39ck450 FIND v(dout1_39) AT=460.05n

.meas tran vdout1_40ck450 FIND v(dout1_40) AT=460.05n

.meas tran vdout1_41ck450 FIND v(dout1_41) AT=460.05n

.meas tran vdout1_42ck450 FIND v(dout1_42) AT=460.05n

.meas tran vdout1_43ck450 FIND v(dout1_43) AT=460.05n

.meas tran vdout1_44ck450 FIND v(dout1_44) AT=460.05n

.meas tran vdout1_45ck450 FIND v(dout1_45) AT=460.05n

.meas tran vdout1_46ck450 FIND v(dout1_46) AT=460.05n

.meas tran vdout1_47ck450 FIND v(dout1_47) AT=460.05n

.meas tran vdout1_48ck450 FIND v(dout1_48) AT=460.05n

.meas tran vdout1_49ck450 FIND v(dout1_49) AT=460.05n

.meas tran vdout1_50ck450 FIND v(dout1_50) AT=460.05n

.meas tran vdout1_51ck450 FIND v(dout1_51) AT=460.05n

.meas tran vdout1_52ck450 FIND v(dout1_52) AT=460.05n

.meas tran vdout1_53ck450 FIND v(dout1_53) AT=460.05n

.meas tran vdout1_54ck450 FIND v(dout1_54) AT=460.05n

.meas tran vdout1_55ck450 FIND v(dout1_55) AT=460.05n

.meas tran vdout1_56ck450 FIND v(dout1_56) AT=460.05n

.meas tran vdout1_57ck450 FIND v(dout1_57) AT=460.05n

.meas tran vdout1_58ck450 FIND v(dout1_58) AT=460.05n

.meas tran vdout1_59ck450 FIND v(dout1_59) AT=460.05n

.meas tran vdout1_60ck450 FIND v(dout1_60) AT=460.05n

.meas tran vdout1_61ck450 FIND v(dout1_61) AT=460.05n

.meas tran vdout1_62ck450 FIND v(dout1_62) AT=460.05n

.meas tran vdout1_63ck450 FIND v(dout1_63) AT=460.05n

.meas tran vdout1_64ck450 FIND v(dout1_64) AT=460.05n

.meas tran vdout1_65ck450 FIND v(dout1_65) AT=460.05n

.meas tran vdout1_66ck450 FIND v(dout1_66) AT=460.05n

.meas tran vdout1_67ck450 FIND v(dout1_67) AT=460.05n

.meas tran vdout1_68ck450 FIND v(dout1_68) AT=460.05n

.meas tran vdout1_69ck450 FIND v(dout1_69) AT=460.05n

.meas tran vdout1_70ck450 FIND v(dout1_70) AT=460.05n

.meas tran vdout1_71ck450 FIND v(dout1_71) AT=460.05n

.meas tran vdout1_72ck450 FIND v(dout1_72) AT=460.05n

.meas tran vdout1_73ck450 FIND v(dout1_73) AT=460.05n

.meas tran vdout1_74ck450 FIND v(dout1_74) AT=460.05n

.meas tran vdout1_75ck450 FIND v(dout1_75) AT=460.05n

.meas tran vdout1_76ck450 FIND v(dout1_76) AT=460.05n

.meas tran vdout1_77ck450 FIND v(dout1_77) AT=460.05n

.meas tran vdout1_78ck450 FIND v(dout1_78) AT=460.05n

.meas tran vdout1_79ck450 FIND v(dout1_79) AT=460.05n

.meas tran vdout1_80ck450 FIND v(dout1_80) AT=460.05n

.meas tran vdout1_81ck450 FIND v(dout1_81) AT=460.05n

.meas tran vdout1_82ck450 FIND v(dout1_82) AT=460.05n

.meas tran vdout1_83ck450 FIND v(dout1_83) AT=460.05n

.meas tran vdout1_84ck450 FIND v(dout1_84) AT=460.05n

.meas tran vdout1_85ck450 FIND v(dout1_85) AT=460.05n

.meas tran vdout1_86ck450 FIND v(dout1_86) AT=460.05n

.meas tran vdout1_87ck450 FIND v(dout1_87) AT=460.05n

.meas tran vdout1_88ck450 FIND v(dout1_88) AT=460.05n

.meas tran vdout1_89ck450 FIND v(dout1_89) AT=460.05n

.meas tran vdout1_90ck450 FIND v(dout1_90) AT=460.05n

.meas tran vdout1_91ck450 FIND v(dout1_91) AT=460.05n

.meas tran vdout1_92ck450 FIND v(dout1_92) AT=460.05n

.meas tran vdout1_93ck450 FIND v(dout1_93) AT=460.05n

.meas tran vdout1_94ck450 FIND v(dout1_94) AT=460.05n

.meas tran vdout1_95ck450 FIND v(dout1_95) AT=460.05n

.meas tran vdout1_96ck450 FIND v(dout1_96) AT=460.05n

.meas tran vdout1_97ck450 FIND v(dout1_97) AT=460.05n

.meas tran vdout1_98ck450 FIND v(dout1_98) AT=460.05n

.meas tran vdout1_99ck450 FIND v(dout1_99) AT=460.05n

.meas tran vdout1_100ck450 FIND v(dout1_100) AT=460.05n

.meas tran vdout1_101ck450 FIND v(dout1_101) AT=460.05n

.meas tran vdout1_102ck450 FIND v(dout1_102) AT=460.05n

.meas tran vdout1_103ck450 FIND v(dout1_103) AT=460.05n

.meas tran vdout1_104ck450 FIND v(dout1_104) AT=460.05n

.meas tran vdout1_105ck450 FIND v(dout1_105) AT=460.05n

.meas tran vdout1_106ck450 FIND v(dout1_106) AT=460.05n

.meas tran vdout1_107ck450 FIND v(dout1_107) AT=460.05n

.meas tran vdout1_108ck450 FIND v(dout1_108) AT=460.05n

.meas tran vdout1_109ck450 FIND v(dout1_109) AT=460.05n

.meas tran vdout1_110ck450 FIND v(dout1_110) AT=460.05n

.meas tran vdout1_111ck450 FIND v(dout1_111) AT=460.05n

.meas tran vdout1_112ck450 FIND v(dout1_112) AT=460.05n

.meas tran vdout1_113ck450 FIND v(dout1_113) AT=460.05n

.meas tran vdout1_114ck450 FIND v(dout1_114) AT=460.05n

.meas tran vdout1_115ck450 FIND v(dout1_115) AT=460.05n

.meas tran vdout1_116ck450 FIND v(dout1_116) AT=460.05n

.meas tran vdout1_117ck450 FIND v(dout1_117) AT=460.05n

.meas tran vdout1_118ck450 FIND v(dout1_118) AT=460.05n

.meas tran vdout1_119ck450 FIND v(dout1_119) AT=460.05n

.meas tran vdout1_120ck450 FIND v(dout1_120) AT=460.05n

.meas tran vdout1_121ck450 FIND v(dout1_121) AT=460.05n

.meas tran vdout1_122ck450 FIND v(dout1_122) AT=460.05n

.meas tran vdout1_123ck450 FIND v(dout1_123) AT=460.05n

.meas tran vdout1_124ck450 FIND v(dout1_124) AT=460.05n

.meas tran vdout1_125ck450 FIND v(dout1_125) AT=460.05n

.meas tran vdout1_126ck450 FIND v(dout1_126) AT=460.05n

.meas tran vdout1_127ck450 FIND v(dout1_127) AT=460.05n

.meas tran vdout1_128ck450 FIND v(dout1_128) AT=460.05n

.meas tran vdout1_129ck450 FIND v(dout1_129) AT=460.05n

.meas tran vdout1_130ck450 FIND v(dout1_130) AT=460.05n

.meas tran vdout1_131ck450 FIND v(dout1_131) AT=460.05n

.meas tran vdout1_132ck450 FIND v(dout1_132) AT=460.05n

.meas tran vdout1_133ck450 FIND v(dout1_133) AT=460.05n

.meas tran vdout1_134ck450 FIND v(dout1_134) AT=460.05n

.meas tran vdout1_0ck470 FIND v(dout1_0) AT=480.05n

.meas tran vdout1_1ck470 FIND v(dout1_1) AT=480.05n

.meas tran vdout1_2ck470 FIND v(dout1_2) AT=480.05n

.meas tran vdout1_3ck470 FIND v(dout1_3) AT=480.05n

.meas tran vdout1_4ck470 FIND v(dout1_4) AT=480.05n

.meas tran vdout1_5ck470 FIND v(dout1_5) AT=480.05n

.meas tran vdout1_6ck470 FIND v(dout1_6) AT=480.05n

.meas tran vdout1_7ck470 FIND v(dout1_7) AT=480.05n

.meas tran vdout1_8ck470 FIND v(dout1_8) AT=480.05n

.meas tran vdout1_9ck470 FIND v(dout1_9) AT=480.05n

.meas tran vdout1_10ck470 FIND v(dout1_10) AT=480.05n

.meas tran vdout1_11ck470 FIND v(dout1_11) AT=480.05n

.meas tran vdout1_12ck470 FIND v(dout1_12) AT=480.05n

.meas tran vdout1_13ck470 FIND v(dout1_13) AT=480.05n

.meas tran vdout1_14ck470 FIND v(dout1_14) AT=480.05n

.meas tran vdout1_15ck470 FIND v(dout1_15) AT=480.05n

.meas tran vdout1_16ck470 FIND v(dout1_16) AT=480.05n

.meas tran vdout1_17ck470 FIND v(dout1_17) AT=480.05n

.meas tran vdout1_18ck470 FIND v(dout1_18) AT=480.05n

.meas tran vdout1_19ck470 FIND v(dout1_19) AT=480.05n

.meas tran vdout1_20ck470 FIND v(dout1_20) AT=480.05n

.meas tran vdout1_21ck470 FIND v(dout1_21) AT=480.05n

.meas tran vdout1_22ck470 FIND v(dout1_22) AT=480.05n

.meas tran vdout1_23ck470 FIND v(dout1_23) AT=480.05n

.meas tran vdout1_24ck470 FIND v(dout1_24) AT=480.05n

.meas tran vdout1_25ck470 FIND v(dout1_25) AT=480.05n

.meas tran vdout1_26ck470 FIND v(dout1_26) AT=480.05n

.meas tran vdout1_27ck470 FIND v(dout1_27) AT=480.05n

.meas tran vdout1_28ck470 FIND v(dout1_28) AT=480.05n

.meas tran vdout1_29ck470 FIND v(dout1_29) AT=480.05n

.meas tran vdout1_30ck470 FIND v(dout1_30) AT=480.05n

.meas tran vdout1_31ck470 FIND v(dout1_31) AT=480.05n

.meas tran vdout1_32ck470 FIND v(dout1_32) AT=480.05n

.meas tran vdout1_33ck470 FIND v(dout1_33) AT=480.05n

.meas tran vdout1_34ck470 FIND v(dout1_34) AT=480.05n

.meas tran vdout1_35ck470 FIND v(dout1_35) AT=480.05n

.meas tran vdout1_36ck470 FIND v(dout1_36) AT=480.05n

.meas tran vdout1_37ck470 FIND v(dout1_37) AT=480.05n

.meas tran vdout1_38ck470 FIND v(dout1_38) AT=480.05n

.meas tran vdout1_39ck470 FIND v(dout1_39) AT=480.05n

.meas tran vdout1_40ck470 FIND v(dout1_40) AT=480.05n

.meas tran vdout1_41ck470 FIND v(dout1_41) AT=480.05n

.meas tran vdout1_42ck470 FIND v(dout1_42) AT=480.05n

.meas tran vdout1_43ck470 FIND v(dout1_43) AT=480.05n

.meas tran vdout1_44ck470 FIND v(dout1_44) AT=480.05n

.meas tran vdout1_45ck470 FIND v(dout1_45) AT=480.05n

.meas tran vdout1_46ck470 FIND v(dout1_46) AT=480.05n

.meas tran vdout1_47ck470 FIND v(dout1_47) AT=480.05n

.meas tran vdout1_48ck470 FIND v(dout1_48) AT=480.05n

.meas tran vdout1_49ck470 FIND v(dout1_49) AT=480.05n

.meas tran vdout1_50ck470 FIND v(dout1_50) AT=480.05n

.meas tran vdout1_51ck470 FIND v(dout1_51) AT=480.05n

.meas tran vdout1_52ck470 FIND v(dout1_52) AT=480.05n

.meas tran vdout1_53ck470 FIND v(dout1_53) AT=480.05n

.meas tran vdout1_54ck470 FIND v(dout1_54) AT=480.05n

.meas tran vdout1_55ck470 FIND v(dout1_55) AT=480.05n

.meas tran vdout1_56ck470 FIND v(dout1_56) AT=480.05n

.meas tran vdout1_57ck470 FIND v(dout1_57) AT=480.05n

.meas tran vdout1_58ck470 FIND v(dout1_58) AT=480.05n

.meas tran vdout1_59ck470 FIND v(dout1_59) AT=480.05n

.meas tran vdout1_60ck470 FIND v(dout1_60) AT=480.05n

.meas tran vdout1_61ck470 FIND v(dout1_61) AT=480.05n

.meas tran vdout1_62ck470 FIND v(dout1_62) AT=480.05n

.meas tran vdout1_63ck470 FIND v(dout1_63) AT=480.05n

.meas tran vdout1_64ck470 FIND v(dout1_64) AT=480.05n

.meas tran vdout1_65ck470 FIND v(dout1_65) AT=480.05n

.meas tran vdout1_66ck470 FIND v(dout1_66) AT=480.05n

.meas tran vdout1_67ck470 FIND v(dout1_67) AT=480.05n

.meas tran vdout1_68ck470 FIND v(dout1_68) AT=480.05n

.meas tran vdout1_69ck470 FIND v(dout1_69) AT=480.05n

.meas tran vdout1_70ck470 FIND v(dout1_70) AT=480.05n

.meas tran vdout1_71ck470 FIND v(dout1_71) AT=480.05n

.meas tran vdout1_72ck470 FIND v(dout1_72) AT=480.05n

.meas tran vdout1_73ck470 FIND v(dout1_73) AT=480.05n

.meas tran vdout1_74ck470 FIND v(dout1_74) AT=480.05n

.meas tran vdout1_75ck470 FIND v(dout1_75) AT=480.05n

.meas tran vdout1_76ck470 FIND v(dout1_76) AT=480.05n

.meas tran vdout1_77ck470 FIND v(dout1_77) AT=480.05n

.meas tran vdout1_78ck470 FIND v(dout1_78) AT=480.05n

.meas tran vdout1_79ck470 FIND v(dout1_79) AT=480.05n

.meas tran vdout1_80ck470 FIND v(dout1_80) AT=480.05n

.meas tran vdout1_81ck470 FIND v(dout1_81) AT=480.05n

.meas tran vdout1_82ck470 FIND v(dout1_82) AT=480.05n

.meas tran vdout1_83ck470 FIND v(dout1_83) AT=480.05n

.meas tran vdout1_84ck470 FIND v(dout1_84) AT=480.05n

.meas tran vdout1_85ck470 FIND v(dout1_85) AT=480.05n

.meas tran vdout1_86ck470 FIND v(dout1_86) AT=480.05n

.meas tran vdout1_87ck470 FIND v(dout1_87) AT=480.05n

.meas tran vdout1_88ck470 FIND v(dout1_88) AT=480.05n

.meas tran vdout1_89ck470 FIND v(dout1_89) AT=480.05n

.meas tran vdout1_90ck470 FIND v(dout1_90) AT=480.05n

.meas tran vdout1_91ck470 FIND v(dout1_91) AT=480.05n

.meas tran vdout1_92ck470 FIND v(dout1_92) AT=480.05n

.meas tran vdout1_93ck470 FIND v(dout1_93) AT=480.05n

.meas tran vdout1_94ck470 FIND v(dout1_94) AT=480.05n

.meas tran vdout1_95ck470 FIND v(dout1_95) AT=480.05n

.meas tran vdout1_96ck470 FIND v(dout1_96) AT=480.05n

.meas tran vdout1_97ck470 FIND v(dout1_97) AT=480.05n

.meas tran vdout1_98ck470 FIND v(dout1_98) AT=480.05n

.meas tran vdout1_99ck470 FIND v(dout1_99) AT=480.05n

.meas tran vdout1_100ck470 FIND v(dout1_100) AT=480.05n

.meas tran vdout1_101ck470 FIND v(dout1_101) AT=480.05n

.meas tran vdout1_102ck470 FIND v(dout1_102) AT=480.05n

.meas tran vdout1_103ck470 FIND v(dout1_103) AT=480.05n

.meas tran vdout1_104ck470 FIND v(dout1_104) AT=480.05n

.meas tran vdout1_105ck470 FIND v(dout1_105) AT=480.05n

.meas tran vdout1_106ck470 FIND v(dout1_106) AT=480.05n

.meas tran vdout1_107ck470 FIND v(dout1_107) AT=480.05n

.meas tran vdout1_108ck470 FIND v(dout1_108) AT=480.05n

.meas tran vdout1_109ck470 FIND v(dout1_109) AT=480.05n

.meas tran vdout1_110ck470 FIND v(dout1_110) AT=480.05n

.meas tran vdout1_111ck470 FIND v(dout1_111) AT=480.05n

.meas tran vdout1_112ck470 FIND v(dout1_112) AT=480.05n

.meas tran vdout1_113ck470 FIND v(dout1_113) AT=480.05n

.meas tran vdout1_114ck470 FIND v(dout1_114) AT=480.05n

.meas tran vdout1_115ck470 FIND v(dout1_115) AT=480.05n

.meas tran vdout1_116ck470 FIND v(dout1_116) AT=480.05n

.meas tran vdout1_117ck470 FIND v(dout1_117) AT=480.05n

.meas tran vdout1_118ck470 FIND v(dout1_118) AT=480.05n

.meas tran vdout1_119ck470 FIND v(dout1_119) AT=480.05n

.meas tran vdout1_120ck470 FIND v(dout1_120) AT=480.05n

.meas tran vdout1_121ck470 FIND v(dout1_121) AT=480.05n

.meas tran vdout1_122ck470 FIND v(dout1_122) AT=480.05n

.meas tran vdout1_123ck470 FIND v(dout1_123) AT=480.05n

.meas tran vdout1_124ck470 FIND v(dout1_124) AT=480.05n

.meas tran vdout1_125ck470 FIND v(dout1_125) AT=480.05n

.meas tran vdout1_126ck470 FIND v(dout1_126) AT=480.05n

.meas tran vdout1_127ck470 FIND v(dout1_127) AT=480.05n

.meas tran vdout1_128ck470 FIND v(dout1_128) AT=480.05n

.meas tran vdout1_129ck470 FIND v(dout1_129) AT=480.05n

.meas tran vdout1_130ck470 FIND v(dout1_130) AT=480.05n

.meas tran vdout1_131ck470 FIND v(dout1_131) AT=480.05n

.meas tran vdout1_132ck470 FIND v(dout1_132) AT=480.05n

.meas tran vdout1_133ck470 FIND v(dout1_133) AT=480.05n

.meas tran vdout1_134ck470 FIND v(dout1_134) AT=480.05n

.meas tran vdout1_0ck480 FIND v(dout1_0) AT=490.05n

.meas tran vdout1_1ck480 FIND v(dout1_1) AT=490.05n

.meas tran vdout1_2ck480 FIND v(dout1_2) AT=490.05n

.meas tran vdout1_3ck480 FIND v(dout1_3) AT=490.05n

.meas tran vdout1_4ck480 FIND v(dout1_4) AT=490.05n

.meas tran vdout1_5ck480 FIND v(dout1_5) AT=490.05n

.meas tran vdout1_6ck480 FIND v(dout1_6) AT=490.05n

.meas tran vdout1_7ck480 FIND v(dout1_7) AT=490.05n

.meas tran vdout1_8ck480 FIND v(dout1_8) AT=490.05n

.meas tran vdout1_9ck480 FIND v(dout1_9) AT=490.05n

.meas tran vdout1_10ck480 FIND v(dout1_10) AT=490.05n

.meas tran vdout1_11ck480 FIND v(dout1_11) AT=490.05n

.meas tran vdout1_12ck480 FIND v(dout1_12) AT=490.05n

.meas tran vdout1_13ck480 FIND v(dout1_13) AT=490.05n

.meas tran vdout1_14ck480 FIND v(dout1_14) AT=490.05n

.meas tran vdout1_15ck480 FIND v(dout1_15) AT=490.05n

.meas tran vdout1_16ck480 FIND v(dout1_16) AT=490.05n

.meas tran vdout1_17ck480 FIND v(dout1_17) AT=490.05n

.meas tran vdout1_18ck480 FIND v(dout1_18) AT=490.05n

.meas tran vdout1_19ck480 FIND v(dout1_19) AT=490.05n

.meas tran vdout1_20ck480 FIND v(dout1_20) AT=490.05n

.meas tran vdout1_21ck480 FIND v(dout1_21) AT=490.05n

.meas tran vdout1_22ck480 FIND v(dout1_22) AT=490.05n

.meas tran vdout1_23ck480 FIND v(dout1_23) AT=490.05n

.meas tran vdout1_24ck480 FIND v(dout1_24) AT=490.05n

.meas tran vdout1_25ck480 FIND v(dout1_25) AT=490.05n

.meas tran vdout1_26ck480 FIND v(dout1_26) AT=490.05n

.meas tran vdout1_27ck480 FIND v(dout1_27) AT=490.05n

.meas tran vdout1_28ck480 FIND v(dout1_28) AT=490.05n

.meas tran vdout1_29ck480 FIND v(dout1_29) AT=490.05n

.meas tran vdout1_30ck480 FIND v(dout1_30) AT=490.05n

.meas tran vdout1_31ck480 FIND v(dout1_31) AT=490.05n

.meas tran vdout1_32ck480 FIND v(dout1_32) AT=490.05n

.meas tran vdout1_33ck480 FIND v(dout1_33) AT=490.05n

.meas tran vdout1_34ck480 FIND v(dout1_34) AT=490.05n

.meas tran vdout1_35ck480 FIND v(dout1_35) AT=490.05n

.meas tran vdout1_36ck480 FIND v(dout1_36) AT=490.05n

.meas tran vdout1_37ck480 FIND v(dout1_37) AT=490.05n

.meas tran vdout1_38ck480 FIND v(dout1_38) AT=490.05n

.meas tran vdout1_39ck480 FIND v(dout1_39) AT=490.05n

.meas tran vdout1_40ck480 FIND v(dout1_40) AT=490.05n

.meas tran vdout1_41ck480 FIND v(dout1_41) AT=490.05n

.meas tran vdout1_42ck480 FIND v(dout1_42) AT=490.05n

.meas tran vdout1_43ck480 FIND v(dout1_43) AT=490.05n

.meas tran vdout1_44ck480 FIND v(dout1_44) AT=490.05n

.meas tran vdout1_45ck480 FIND v(dout1_45) AT=490.05n

.meas tran vdout1_46ck480 FIND v(dout1_46) AT=490.05n

.meas tran vdout1_47ck480 FIND v(dout1_47) AT=490.05n

.meas tran vdout1_48ck480 FIND v(dout1_48) AT=490.05n

.meas tran vdout1_49ck480 FIND v(dout1_49) AT=490.05n

.meas tran vdout1_50ck480 FIND v(dout1_50) AT=490.05n

.meas tran vdout1_51ck480 FIND v(dout1_51) AT=490.05n

.meas tran vdout1_52ck480 FIND v(dout1_52) AT=490.05n

.meas tran vdout1_53ck480 FIND v(dout1_53) AT=490.05n

.meas tran vdout1_54ck480 FIND v(dout1_54) AT=490.05n

.meas tran vdout1_55ck480 FIND v(dout1_55) AT=490.05n

.meas tran vdout1_56ck480 FIND v(dout1_56) AT=490.05n

.meas tran vdout1_57ck480 FIND v(dout1_57) AT=490.05n

.meas tran vdout1_58ck480 FIND v(dout1_58) AT=490.05n

.meas tran vdout1_59ck480 FIND v(dout1_59) AT=490.05n

.meas tran vdout1_60ck480 FIND v(dout1_60) AT=490.05n

.meas tran vdout1_61ck480 FIND v(dout1_61) AT=490.05n

.meas tran vdout1_62ck480 FIND v(dout1_62) AT=490.05n

.meas tran vdout1_63ck480 FIND v(dout1_63) AT=490.05n

.meas tran vdout1_64ck480 FIND v(dout1_64) AT=490.05n

.meas tran vdout1_65ck480 FIND v(dout1_65) AT=490.05n

.meas tran vdout1_66ck480 FIND v(dout1_66) AT=490.05n

.meas tran vdout1_67ck480 FIND v(dout1_67) AT=490.05n

.meas tran vdout1_68ck480 FIND v(dout1_68) AT=490.05n

.meas tran vdout1_69ck480 FIND v(dout1_69) AT=490.05n

.meas tran vdout1_70ck480 FIND v(dout1_70) AT=490.05n

.meas tran vdout1_71ck480 FIND v(dout1_71) AT=490.05n

.meas tran vdout1_72ck480 FIND v(dout1_72) AT=490.05n

.meas tran vdout1_73ck480 FIND v(dout1_73) AT=490.05n

.meas tran vdout1_74ck480 FIND v(dout1_74) AT=490.05n

.meas tran vdout1_75ck480 FIND v(dout1_75) AT=490.05n

.meas tran vdout1_76ck480 FIND v(dout1_76) AT=490.05n

.meas tran vdout1_77ck480 FIND v(dout1_77) AT=490.05n

.meas tran vdout1_78ck480 FIND v(dout1_78) AT=490.05n

.meas tran vdout1_79ck480 FIND v(dout1_79) AT=490.05n

.meas tran vdout1_80ck480 FIND v(dout1_80) AT=490.05n

.meas tran vdout1_81ck480 FIND v(dout1_81) AT=490.05n

.meas tran vdout1_82ck480 FIND v(dout1_82) AT=490.05n

.meas tran vdout1_83ck480 FIND v(dout1_83) AT=490.05n

.meas tran vdout1_84ck480 FIND v(dout1_84) AT=490.05n

.meas tran vdout1_85ck480 FIND v(dout1_85) AT=490.05n

.meas tran vdout1_86ck480 FIND v(dout1_86) AT=490.05n

.meas tran vdout1_87ck480 FIND v(dout1_87) AT=490.05n

.meas tran vdout1_88ck480 FIND v(dout1_88) AT=490.05n

.meas tran vdout1_89ck480 FIND v(dout1_89) AT=490.05n

.meas tran vdout1_90ck480 FIND v(dout1_90) AT=490.05n

.meas tran vdout1_91ck480 FIND v(dout1_91) AT=490.05n

.meas tran vdout1_92ck480 FIND v(dout1_92) AT=490.05n

.meas tran vdout1_93ck480 FIND v(dout1_93) AT=490.05n

.meas tran vdout1_94ck480 FIND v(dout1_94) AT=490.05n

.meas tran vdout1_95ck480 FIND v(dout1_95) AT=490.05n

.meas tran vdout1_96ck480 FIND v(dout1_96) AT=490.05n

.meas tran vdout1_97ck480 FIND v(dout1_97) AT=490.05n

.meas tran vdout1_98ck480 FIND v(dout1_98) AT=490.05n

.meas tran vdout1_99ck480 FIND v(dout1_99) AT=490.05n

.meas tran vdout1_100ck480 FIND v(dout1_100) AT=490.05n

.meas tran vdout1_101ck480 FIND v(dout1_101) AT=490.05n

.meas tran vdout1_102ck480 FIND v(dout1_102) AT=490.05n

.meas tran vdout1_103ck480 FIND v(dout1_103) AT=490.05n

.meas tran vdout1_104ck480 FIND v(dout1_104) AT=490.05n

.meas tran vdout1_105ck480 FIND v(dout1_105) AT=490.05n

.meas tran vdout1_106ck480 FIND v(dout1_106) AT=490.05n

.meas tran vdout1_107ck480 FIND v(dout1_107) AT=490.05n

.meas tran vdout1_108ck480 FIND v(dout1_108) AT=490.05n

.meas tran vdout1_109ck480 FIND v(dout1_109) AT=490.05n

.meas tran vdout1_110ck480 FIND v(dout1_110) AT=490.05n

.meas tran vdout1_111ck480 FIND v(dout1_111) AT=490.05n

.meas tran vdout1_112ck480 FIND v(dout1_112) AT=490.05n

.meas tran vdout1_113ck480 FIND v(dout1_113) AT=490.05n

.meas tran vdout1_114ck480 FIND v(dout1_114) AT=490.05n

.meas tran vdout1_115ck480 FIND v(dout1_115) AT=490.05n

.meas tran vdout1_116ck480 FIND v(dout1_116) AT=490.05n

.meas tran vdout1_117ck480 FIND v(dout1_117) AT=490.05n

.meas tran vdout1_118ck480 FIND v(dout1_118) AT=490.05n

.meas tran vdout1_119ck480 FIND v(dout1_119) AT=490.05n

.meas tran vdout1_120ck480 FIND v(dout1_120) AT=490.05n

.meas tran vdout1_121ck480 FIND v(dout1_121) AT=490.05n

.meas tran vdout1_122ck480 FIND v(dout1_122) AT=490.05n

.meas tran vdout1_123ck480 FIND v(dout1_123) AT=490.05n

.meas tran vdout1_124ck480 FIND v(dout1_124) AT=490.05n

.meas tran vdout1_125ck480 FIND v(dout1_125) AT=490.05n

.meas tran vdout1_126ck480 FIND v(dout1_126) AT=490.05n

.meas tran vdout1_127ck480 FIND v(dout1_127) AT=490.05n

.meas tran vdout1_128ck480 FIND v(dout1_128) AT=490.05n

.meas tran vdout1_129ck480 FIND v(dout1_129) AT=490.05n

.meas tran vdout1_130ck480 FIND v(dout1_130) AT=490.05n

.meas tran vdout1_131ck480 FIND v(dout1_131) AT=490.05n

.meas tran vdout1_132ck480 FIND v(dout1_132) AT=490.05n

.meas tran vdout1_133ck480 FIND v(dout1_133) AT=490.05n

.meas tran vdout1_134ck480 FIND v(dout1_134) AT=490.05n

.meas tran vdout1_0ck510 FIND v(dout1_0) AT=520.05n

.meas tran vdout1_1ck510 FIND v(dout1_1) AT=520.05n

.meas tran vdout1_2ck510 FIND v(dout1_2) AT=520.05n

.meas tran vdout1_3ck510 FIND v(dout1_3) AT=520.05n

.meas tran vdout1_4ck510 FIND v(dout1_4) AT=520.05n

.meas tran vdout1_5ck510 FIND v(dout1_5) AT=520.05n

.meas tran vdout1_6ck510 FIND v(dout1_6) AT=520.05n

.meas tran vdout1_7ck510 FIND v(dout1_7) AT=520.05n

.meas tran vdout1_8ck510 FIND v(dout1_8) AT=520.05n

.meas tran vdout1_9ck510 FIND v(dout1_9) AT=520.05n

.meas tran vdout1_10ck510 FIND v(dout1_10) AT=520.05n

.meas tran vdout1_11ck510 FIND v(dout1_11) AT=520.05n

.meas tran vdout1_12ck510 FIND v(dout1_12) AT=520.05n

.meas tran vdout1_13ck510 FIND v(dout1_13) AT=520.05n

.meas tran vdout1_14ck510 FIND v(dout1_14) AT=520.05n

.meas tran vdout1_15ck510 FIND v(dout1_15) AT=520.05n

.meas tran vdout1_16ck510 FIND v(dout1_16) AT=520.05n

.meas tran vdout1_17ck510 FIND v(dout1_17) AT=520.05n

.meas tran vdout1_18ck510 FIND v(dout1_18) AT=520.05n

.meas tran vdout1_19ck510 FIND v(dout1_19) AT=520.05n

.meas tran vdout1_20ck510 FIND v(dout1_20) AT=520.05n

.meas tran vdout1_21ck510 FIND v(dout1_21) AT=520.05n

.meas tran vdout1_22ck510 FIND v(dout1_22) AT=520.05n

.meas tran vdout1_23ck510 FIND v(dout1_23) AT=520.05n

.meas tran vdout1_24ck510 FIND v(dout1_24) AT=520.05n

.meas tran vdout1_25ck510 FIND v(dout1_25) AT=520.05n

.meas tran vdout1_26ck510 FIND v(dout1_26) AT=520.05n

.meas tran vdout1_27ck510 FIND v(dout1_27) AT=520.05n

.meas tran vdout1_28ck510 FIND v(dout1_28) AT=520.05n

.meas tran vdout1_29ck510 FIND v(dout1_29) AT=520.05n

.meas tran vdout1_30ck510 FIND v(dout1_30) AT=520.05n

.meas tran vdout1_31ck510 FIND v(dout1_31) AT=520.05n

.meas tran vdout1_32ck510 FIND v(dout1_32) AT=520.05n

.meas tran vdout1_33ck510 FIND v(dout1_33) AT=520.05n

.meas tran vdout1_34ck510 FIND v(dout1_34) AT=520.05n

.meas tran vdout1_35ck510 FIND v(dout1_35) AT=520.05n

.meas tran vdout1_36ck510 FIND v(dout1_36) AT=520.05n

.meas tran vdout1_37ck510 FIND v(dout1_37) AT=520.05n

.meas tran vdout1_38ck510 FIND v(dout1_38) AT=520.05n

.meas tran vdout1_39ck510 FIND v(dout1_39) AT=520.05n

.meas tran vdout1_40ck510 FIND v(dout1_40) AT=520.05n

.meas tran vdout1_41ck510 FIND v(dout1_41) AT=520.05n

.meas tran vdout1_42ck510 FIND v(dout1_42) AT=520.05n

.meas tran vdout1_43ck510 FIND v(dout1_43) AT=520.05n

.meas tran vdout1_44ck510 FIND v(dout1_44) AT=520.05n

.meas tran vdout1_45ck510 FIND v(dout1_45) AT=520.05n

.meas tran vdout1_46ck510 FIND v(dout1_46) AT=520.05n

.meas tran vdout1_47ck510 FIND v(dout1_47) AT=520.05n

.meas tran vdout1_48ck510 FIND v(dout1_48) AT=520.05n

.meas tran vdout1_49ck510 FIND v(dout1_49) AT=520.05n

.meas tran vdout1_50ck510 FIND v(dout1_50) AT=520.05n

.meas tran vdout1_51ck510 FIND v(dout1_51) AT=520.05n

.meas tran vdout1_52ck510 FIND v(dout1_52) AT=520.05n

.meas tran vdout1_53ck510 FIND v(dout1_53) AT=520.05n

.meas tran vdout1_54ck510 FIND v(dout1_54) AT=520.05n

.meas tran vdout1_55ck510 FIND v(dout1_55) AT=520.05n

.meas tran vdout1_56ck510 FIND v(dout1_56) AT=520.05n

.meas tran vdout1_57ck510 FIND v(dout1_57) AT=520.05n

.meas tran vdout1_58ck510 FIND v(dout1_58) AT=520.05n

.meas tran vdout1_59ck510 FIND v(dout1_59) AT=520.05n

.meas tran vdout1_60ck510 FIND v(dout1_60) AT=520.05n

.meas tran vdout1_61ck510 FIND v(dout1_61) AT=520.05n

.meas tran vdout1_62ck510 FIND v(dout1_62) AT=520.05n

.meas tran vdout1_63ck510 FIND v(dout1_63) AT=520.05n

.meas tran vdout1_64ck510 FIND v(dout1_64) AT=520.05n

.meas tran vdout1_65ck510 FIND v(dout1_65) AT=520.05n

.meas tran vdout1_66ck510 FIND v(dout1_66) AT=520.05n

.meas tran vdout1_67ck510 FIND v(dout1_67) AT=520.05n

.meas tran vdout1_68ck510 FIND v(dout1_68) AT=520.05n

.meas tran vdout1_69ck510 FIND v(dout1_69) AT=520.05n

.meas tran vdout1_70ck510 FIND v(dout1_70) AT=520.05n

.meas tran vdout1_71ck510 FIND v(dout1_71) AT=520.05n

.meas tran vdout1_72ck510 FIND v(dout1_72) AT=520.05n

.meas tran vdout1_73ck510 FIND v(dout1_73) AT=520.05n

.meas tran vdout1_74ck510 FIND v(dout1_74) AT=520.05n

.meas tran vdout1_75ck510 FIND v(dout1_75) AT=520.05n

.meas tran vdout1_76ck510 FIND v(dout1_76) AT=520.05n

.meas tran vdout1_77ck510 FIND v(dout1_77) AT=520.05n

.meas tran vdout1_78ck510 FIND v(dout1_78) AT=520.05n

.meas tran vdout1_79ck510 FIND v(dout1_79) AT=520.05n

.meas tran vdout1_80ck510 FIND v(dout1_80) AT=520.05n

.meas tran vdout1_81ck510 FIND v(dout1_81) AT=520.05n

.meas tran vdout1_82ck510 FIND v(dout1_82) AT=520.05n

.meas tran vdout1_83ck510 FIND v(dout1_83) AT=520.05n

.meas tran vdout1_84ck510 FIND v(dout1_84) AT=520.05n

.meas tran vdout1_85ck510 FIND v(dout1_85) AT=520.05n

.meas tran vdout1_86ck510 FIND v(dout1_86) AT=520.05n

.meas tran vdout1_87ck510 FIND v(dout1_87) AT=520.05n

.meas tran vdout1_88ck510 FIND v(dout1_88) AT=520.05n

.meas tran vdout1_89ck510 FIND v(dout1_89) AT=520.05n

.meas tran vdout1_90ck510 FIND v(dout1_90) AT=520.05n

.meas tran vdout1_91ck510 FIND v(dout1_91) AT=520.05n

.meas tran vdout1_92ck510 FIND v(dout1_92) AT=520.05n

.meas tran vdout1_93ck510 FIND v(dout1_93) AT=520.05n

.meas tran vdout1_94ck510 FIND v(dout1_94) AT=520.05n

.meas tran vdout1_95ck510 FIND v(dout1_95) AT=520.05n

.meas tran vdout1_96ck510 FIND v(dout1_96) AT=520.05n

.meas tran vdout1_97ck510 FIND v(dout1_97) AT=520.05n

.meas tran vdout1_98ck510 FIND v(dout1_98) AT=520.05n

.meas tran vdout1_99ck510 FIND v(dout1_99) AT=520.05n

.meas tran vdout1_100ck510 FIND v(dout1_100) AT=520.05n

.meas tran vdout1_101ck510 FIND v(dout1_101) AT=520.05n

.meas tran vdout1_102ck510 FIND v(dout1_102) AT=520.05n

.meas tran vdout1_103ck510 FIND v(dout1_103) AT=520.05n

.meas tran vdout1_104ck510 FIND v(dout1_104) AT=520.05n

.meas tran vdout1_105ck510 FIND v(dout1_105) AT=520.05n

.meas tran vdout1_106ck510 FIND v(dout1_106) AT=520.05n

.meas tran vdout1_107ck510 FIND v(dout1_107) AT=520.05n

.meas tran vdout1_108ck510 FIND v(dout1_108) AT=520.05n

.meas tran vdout1_109ck510 FIND v(dout1_109) AT=520.05n

.meas tran vdout1_110ck510 FIND v(dout1_110) AT=520.05n

.meas tran vdout1_111ck510 FIND v(dout1_111) AT=520.05n

.meas tran vdout1_112ck510 FIND v(dout1_112) AT=520.05n

.meas tran vdout1_113ck510 FIND v(dout1_113) AT=520.05n

.meas tran vdout1_114ck510 FIND v(dout1_114) AT=520.05n

.meas tran vdout1_115ck510 FIND v(dout1_115) AT=520.05n

.meas tran vdout1_116ck510 FIND v(dout1_116) AT=520.05n

.meas tran vdout1_117ck510 FIND v(dout1_117) AT=520.05n

.meas tran vdout1_118ck510 FIND v(dout1_118) AT=520.05n

.meas tran vdout1_119ck510 FIND v(dout1_119) AT=520.05n

.meas tran vdout1_120ck510 FIND v(dout1_120) AT=520.05n

.meas tran vdout1_121ck510 FIND v(dout1_121) AT=520.05n

.meas tran vdout1_122ck510 FIND v(dout1_122) AT=520.05n

.meas tran vdout1_123ck510 FIND v(dout1_123) AT=520.05n

.meas tran vdout1_124ck510 FIND v(dout1_124) AT=520.05n

.meas tran vdout1_125ck510 FIND v(dout1_125) AT=520.05n

.meas tran vdout1_126ck510 FIND v(dout1_126) AT=520.05n

.meas tran vdout1_127ck510 FIND v(dout1_127) AT=520.05n

.meas tran vdout1_128ck510 FIND v(dout1_128) AT=520.05n

.meas tran vdout1_129ck510 FIND v(dout1_129) AT=520.05n

.meas tran vdout1_130ck510 FIND v(dout1_130) AT=520.05n

.meas tran vdout1_131ck510 FIND v(dout1_131) AT=520.05n

.meas tran vdout1_132ck510 FIND v(dout1_132) AT=520.05n

.meas tran vdout1_133ck510 FIND v(dout1_133) AT=520.05n

.meas tran vdout1_134ck510 FIND v(dout1_134) AT=520.05n

.meas tran vdout1_0ck530 FIND v(dout1_0) AT=540.05n

.meas tran vdout1_1ck530 FIND v(dout1_1) AT=540.05n

.meas tran vdout1_2ck530 FIND v(dout1_2) AT=540.05n

.meas tran vdout1_3ck530 FIND v(dout1_3) AT=540.05n

.meas tran vdout1_4ck530 FIND v(dout1_4) AT=540.05n

.meas tran vdout1_5ck530 FIND v(dout1_5) AT=540.05n

.meas tran vdout1_6ck530 FIND v(dout1_6) AT=540.05n

.meas tran vdout1_7ck530 FIND v(dout1_7) AT=540.05n

.meas tran vdout1_8ck530 FIND v(dout1_8) AT=540.05n

.meas tran vdout1_9ck530 FIND v(dout1_9) AT=540.05n

.meas tran vdout1_10ck530 FIND v(dout1_10) AT=540.05n

.meas tran vdout1_11ck530 FIND v(dout1_11) AT=540.05n

.meas tran vdout1_12ck530 FIND v(dout1_12) AT=540.05n

.meas tran vdout1_13ck530 FIND v(dout1_13) AT=540.05n

.meas tran vdout1_14ck530 FIND v(dout1_14) AT=540.05n

.meas tran vdout1_15ck530 FIND v(dout1_15) AT=540.05n

.meas tran vdout1_16ck530 FIND v(dout1_16) AT=540.05n

.meas tran vdout1_17ck530 FIND v(dout1_17) AT=540.05n

.meas tran vdout1_18ck530 FIND v(dout1_18) AT=540.05n

.meas tran vdout1_19ck530 FIND v(dout1_19) AT=540.05n

.meas tran vdout1_20ck530 FIND v(dout1_20) AT=540.05n

.meas tran vdout1_21ck530 FIND v(dout1_21) AT=540.05n

.meas tran vdout1_22ck530 FIND v(dout1_22) AT=540.05n

.meas tran vdout1_23ck530 FIND v(dout1_23) AT=540.05n

.meas tran vdout1_24ck530 FIND v(dout1_24) AT=540.05n

.meas tran vdout1_25ck530 FIND v(dout1_25) AT=540.05n

.meas tran vdout1_26ck530 FIND v(dout1_26) AT=540.05n

.meas tran vdout1_27ck530 FIND v(dout1_27) AT=540.05n

.meas tran vdout1_28ck530 FIND v(dout1_28) AT=540.05n

.meas tran vdout1_29ck530 FIND v(dout1_29) AT=540.05n

.meas tran vdout1_30ck530 FIND v(dout1_30) AT=540.05n

.meas tran vdout1_31ck530 FIND v(dout1_31) AT=540.05n

.meas tran vdout1_32ck530 FIND v(dout1_32) AT=540.05n

.meas tran vdout1_33ck530 FIND v(dout1_33) AT=540.05n

.meas tran vdout1_34ck530 FIND v(dout1_34) AT=540.05n

.meas tran vdout1_35ck530 FIND v(dout1_35) AT=540.05n

.meas tran vdout1_36ck530 FIND v(dout1_36) AT=540.05n

.meas tran vdout1_37ck530 FIND v(dout1_37) AT=540.05n

.meas tran vdout1_38ck530 FIND v(dout1_38) AT=540.05n

.meas tran vdout1_39ck530 FIND v(dout1_39) AT=540.05n

.meas tran vdout1_40ck530 FIND v(dout1_40) AT=540.05n

.meas tran vdout1_41ck530 FIND v(dout1_41) AT=540.05n

.meas tran vdout1_42ck530 FIND v(dout1_42) AT=540.05n

.meas tran vdout1_43ck530 FIND v(dout1_43) AT=540.05n

.meas tran vdout1_44ck530 FIND v(dout1_44) AT=540.05n

.meas tran vdout1_45ck530 FIND v(dout1_45) AT=540.05n

.meas tran vdout1_46ck530 FIND v(dout1_46) AT=540.05n

.meas tran vdout1_47ck530 FIND v(dout1_47) AT=540.05n

.meas tran vdout1_48ck530 FIND v(dout1_48) AT=540.05n

.meas tran vdout1_49ck530 FIND v(dout1_49) AT=540.05n

.meas tran vdout1_50ck530 FIND v(dout1_50) AT=540.05n

.meas tran vdout1_51ck530 FIND v(dout1_51) AT=540.05n

.meas tran vdout1_52ck530 FIND v(dout1_52) AT=540.05n

.meas tran vdout1_53ck530 FIND v(dout1_53) AT=540.05n

.meas tran vdout1_54ck530 FIND v(dout1_54) AT=540.05n

.meas tran vdout1_55ck530 FIND v(dout1_55) AT=540.05n

.meas tran vdout1_56ck530 FIND v(dout1_56) AT=540.05n

.meas tran vdout1_57ck530 FIND v(dout1_57) AT=540.05n

.meas tran vdout1_58ck530 FIND v(dout1_58) AT=540.05n

.meas tran vdout1_59ck530 FIND v(dout1_59) AT=540.05n

.meas tran vdout1_60ck530 FIND v(dout1_60) AT=540.05n

.meas tran vdout1_61ck530 FIND v(dout1_61) AT=540.05n

.meas tran vdout1_62ck530 FIND v(dout1_62) AT=540.05n

.meas tran vdout1_63ck530 FIND v(dout1_63) AT=540.05n

.meas tran vdout1_64ck530 FIND v(dout1_64) AT=540.05n

.meas tran vdout1_65ck530 FIND v(dout1_65) AT=540.05n

.meas tran vdout1_66ck530 FIND v(dout1_66) AT=540.05n

.meas tran vdout1_67ck530 FIND v(dout1_67) AT=540.05n

.meas tran vdout1_68ck530 FIND v(dout1_68) AT=540.05n

.meas tran vdout1_69ck530 FIND v(dout1_69) AT=540.05n

.meas tran vdout1_70ck530 FIND v(dout1_70) AT=540.05n

.meas tran vdout1_71ck530 FIND v(dout1_71) AT=540.05n

.meas tran vdout1_72ck530 FIND v(dout1_72) AT=540.05n

.meas tran vdout1_73ck530 FIND v(dout1_73) AT=540.05n

.meas tran vdout1_74ck530 FIND v(dout1_74) AT=540.05n

.meas tran vdout1_75ck530 FIND v(dout1_75) AT=540.05n

.meas tran vdout1_76ck530 FIND v(dout1_76) AT=540.05n

.meas tran vdout1_77ck530 FIND v(dout1_77) AT=540.05n

.meas tran vdout1_78ck530 FIND v(dout1_78) AT=540.05n

.meas tran vdout1_79ck530 FIND v(dout1_79) AT=540.05n

.meas tran vdout1_80ck530 FIND v(dout1_80) AT=540.05n

.meas tran vdout1_81ck530 FIND v(dout1_81) AT=540.05n

.meas tran vdout1_82ck530 FIND v(dout1_82) AT=540.05n

.meas tran vdout1_83ck530 FIND v(dout1_83) AT=540.05n

.meas tran vdout1_84ck530 FIND v(dout1_84) AT=540.05n

.meas tran vdout1_85ck530 FIND v(dout1_85) AT=540.05n

.meas tran vdout1_86ck530 FIND v(dout1_86) AT=540.05n

.meas tran vdout1_87ck530 FIND v(dout1_87) AT=540.05n

.meas tran vdout1_88ck530 FIND v(dout1_88) AT=540.05n

.meas tran vdout1_89ck530 FIND v(dout1_89) AT=540.05n

.meas tran vdout1_90ck530 FIND v(dout1_90) AT=540.05n

.meas tran vdout1_91ck530 FIND v(dout1_91) AT=540.05n

.meas tran vdout1_92ck530 FIND v(dout1_92) AT=540.05n

.meas tran vdout1_93ck530 FIND v(dout1_93) AT=540.05n

.meas tran vdout1_94ck530 FIND v(dout1_94) AT=540.05n

.meas tran vdout1_95ck530 FIND v(dout1_95) AT=540.05n

.meas tran vdout1_96ck530 FIND v(dout1_96) AT=540.05n

.meas tran vdout1_97ck530 FIND v(dout1_97) AT=540.05n

.meas tran vdout1_98ck530 FIND v(dout1_98) AT=540.05n

.meas tran vdout1_99ck530 FIND v(dout1_99) AT=540.05n

.meas tran vdout1_100ck530 FIND v(dout1_100) AT=540.05n

.meas tran vdout1_101ck530 FIND v(dout1_101) AT=540.05n

.meas tran vdout1_102ck530 FIND v(dout1_102) AT=540.05n

.meas tran vdout1_103ck530 FIND v(dout1_103) AT=540.05n

.meas tran vdout1_104ck530 FIND v(dout1_104) AT=540.05n

.meas tran vdout1_105ck530 FIND v(dout1_105) AT=540.05n

.meas tran vdout1_106ck530 FIND v(dout1_106) AT=540.05n

.meas tran vdout1_107ck530 FIND v(dout1_107) AT=540.05n

.meas tran vdout1_108ck530 FIND v(dout1_108) AT=540.05n

.meas tran vdout1_109ck530 FIND v(dout1_109) AT=540.05n

.meas tran vdout1_110ck530 FIND v(dout1_110) AT=540.05n

.meas tran vdout1_111ck530 FIND v(dout1_111) AT=540.05n

.meas tran vdout1_112ck530 FIND v(dout1_112) AT=540.05n

.meas tran vdout1_113ck530 FIND v(dout1_113) AT=540.05n

.meas tran vdout1_114ck530 FIND v(dout1_114) AT=540.05n

.meas tran vdout1_115ck530 FIND v(dout1_115) AT=540.05n

.meas tran vdout1_116ck530 FIND v(dout1_116) AT=540.05n

.meas tran vdout1_117ck530 FIND v(dout1_117) AT=540.05n

.meas tran vdout1_118ck530 FIND v(dout1_118) AT=540.05n

.meas tran vdout1_119ck530 FIND v(dout1_119) AT=540.05n

.meas tran vdout1_120ck530 FIND v(dout1_120) AT=540.05n

.meas tran vdout1_121ck530 FIND v(dout1_121) AT=540.05n

.meas tran vdout1_122ck530 FIND v(dout1_122) AT=540.05n

.meas tran vdout1_123ck530 FIND v(dout1_123) AT=540.05n

.meas tran vdout1_124ck530 FIND v(dout1_124) AT=540.05n

.meas tran vdout1_125ck530 FIND v(dout1_125) AT=540.05n

.meas tran vdout1_126ck530 FIND v(dout1_126) AT=540.05n

.meas tran vdout1_127ck530 FIND v(dout1_127) AT=540.05n

.meas tran vdout1_128ck530 FIND v(dout1_128) AT=540.05n

.meas tran vdout1_129ck530 FIND v(dout1_129) AT=540.05n

.meas tran vdout1_130ck530 FIND v(dout1_130) AT=540.05n

.meas tran vdout1_131ck530 FIND v(dout1_131) AT=540.05n

.meas tran vdout1_132ck530 FIND v(dout1_132) AT=540.05n

.meas tran vdout1_133ck530 FIND v(dout1_133) AT=540.05n

.meas tran vdout1_134ck530 FIND v(dout1_134) AT=540.05n

.meas tran vdout1_0ck550 FIND v(dout1_0) AT=560.05n

.meas tran vdout1_1ck550 FIND v(dout1_1) AT=560.05n

.meas tran vdout1_2ck550 FIND v(dout1_2) AT=560.05n

.meas tran vdout1_3ck550 FIND v(dout1_3) AT=560.05n

.meas tran vdout1_4ck550 FIND v(dout1_4) AT=560.05n

.meas tran vdout1_5ck550 FIND v(dout1_5) AT=560.05n

.meas tran vdout1_6ck550 FIND v(dout1_6) AT=560.05n

.meas tran vdout1_7ck550 FIND v(dout1_7) AT=560.05n

.meas tran vdout1_8ck550 FIND v(dout1_8) AT=560.05n

.meas tran vdout1_9ck550 FIND v(dout1_9) AT=560.05n

.meas tran vdout1_10ck550 FIND v(dout1_10) AT=560.05n

.meas tran vdout1_11ck550 FIND v(dout1_11) AT=560.05n

.meas tran vdout1_12ck550 FIND v(dout1_12) AT=560.05n

.meas tran vdout1_13ck550 FIND v(dout1_13) AT=560.05n

.meas tran vdout1_14ck550 FIND v(dout1_14) AT=560.05n

.meas tran vdout1_15ck550 FIND v(dout1_15) AT=560.05n

.meas tran vdout1_16ck550 FIND v(dout1_16) AT=560.05n

.meas tran vdout1_17ck550 FIND v(dout1_17) AT=560.05n

.meas tran vdout1_18ck550 FIND v(dout1_18) AT=560.05n

.meas tran vdout1_19ck550 FIND v(dout1_19) AT=560.05n

.meas tran vdout1_20ck550 FIND v(dout1_20) AT=560.05n

.meas tran vdout1_21ck550 FIND v(dout1_21) AT=560.05n

.meas tran vdout1_22ck550 FIND v(dout1_22) AT=560.05n

.meas tran vdout1_23ck550 FIND v(dout1_23) AT=560.05n

.meas tran vdout1_24ck550 FIND v(dout1_24) AT=560.05n

.meas tran vdout1_25ck550 FIND v(dout1_25) AT=560.05n

.meas tran vdout1_26ck550 FIND v(dout1_26) AT=560.05n

.meas tran vdout1_27ck550 FIND v(dout1_27) AT=560.05n

.meas tran vdout1_28ck550 FIND v(dout1_28) AT=560.05n

.meas tran vdout1_29ck550 FIND v(dout1_29) AT=560.05n

.meas tran vdout1_30ck550 FIND v(dout1_30) AT=560.05n

.meas tran vdout1_31ck550 FIND v(dout1_31) AT=560.05n

.meas tran vdout1_32ck550 FIND v(dout1_32) AT=560.05n

.meas tran vdout1_33ck550 FIND v(dout1_33) AT=560.05n

.meas tran vdout1_34ck550 FIND v(dout1_34) AT=560.05n

.meas tran vdout1_35ck550 FIND v(dout1_35) AT=560.05n

.meas tran vdout1_36ck550 FIND v(dout1_36) AT=560.05n

.meas tran vdout1_37ck550 FIND v(dout1_37) AT=560.05n

.meas tran vdout1_38ck550 FIND v(dout1_38) AT=560.05n

.meas tran vdout1_39ck550 FIND v(dout1_39) AT=560.05n

.meas tran vdout1_40ck550 FIND v(dout1_40) AT=560.05n

.meas tran vdout1_41ck550 FIND v(dout1_41) AT=560.05n

.meas tran vdout1_42ck550 FIND v(dout1_42) AT=560.05n

.meas tran vdout1_43ck550 FIND v(dout1_43) AT=560.05n

.meas tran vdout1_44ck550 FIND v(dout1_44) AT=560.05n

.meas tran vdout1_45ck550 FIND v(dout1_45) AT=560.05n

.meas tran vdout1_46ck550 FIND v(dout1_46) AT=560.05n

.meas tran vdout1_47ck550 FIND v(dout1_47) AT=560.05n

.meas tran vdout1_48ck550 FIND v(dout1_48) AT=560.05n

.meas tran vdout1_49ck550 FIND v(dout1_49) AT=560.05n

.meas tran vdout1_50ck550 FIND v(dout1_50) AT=560.05n

.meas tran vdout1_51ck550 FIND v(dout1_51) AT=560.05n

.meas tran vdout1_52ck550 FIND v(dout1_52) AT=560.05n

.meas tran vdout1_53ck550 FIND v(dout1_53) AT=560.05n

.meas tran vdout1_54ck550 FIND v(dout1_54) AT=560.05n

.meas tran vdout1_55ck550 FIND v(dout1_55) AT=560.05n

.meas tran vdout1_56ck550 FIND v(dout1_56) AT=560.05n

.meas tran vdout1_57ck550 FIND v(dout1_57) AT=560.05n

.meas tran vdout1_58ck550 FIND v(dout1_58) AT=560.05n

.meas tran vdout1_59ck550 FIND v(dout1_59) AT=560.05n

.meas tran vdout1_60ck550 FIND v(dout1_60) AT=560.05n

.meas tran vdout1_61ck550 FIND v(dout1_61) AT=560.05n

.meas tran vdout1_62ck550 FIND v(dout1_62) AT=560.05n

.meas tran vdout1_63ck550 FIND v(dout1_63) AT=560.05n

.meas tran vdout1_64ck550 FIND v(dout1_64) AT=560.05n

.meas tran vdout1_65ck550 FIND v(dout1_65) AT=560.05n

.meas tran vdout1_66ck550 FIND v(dout1_66) AT=560.05n

.meas tran vdout1_67ck550 FIND v(dout1_67) AT=560.05n

.meas tran vdout1_68ck550 FIND v(dout1_68) AT=560.05n

.meas tran vdout1_69ck550 FIND v(dout1_69) AT=560.05n

.meas tran vdout1_70ck550 FIND v(dout1_70) AT=560.05n

.meas tran vdout1_71ck550 FIND v(dout1_71) AT=560.05n

.meas tran vdout1_72ck550 FIND v(dout1_72) AT=560.05n

.meas tran vdout1_73ck550 FIND v(dout1_73) AT=560.05n

.meas tran vdout1_74ck550 FIND v(dout1_74) AT=560.05n

.meas tran vdout1_75ck550 FIND v(dout1_75) AT=560.05n

.meas tran vdout1_76ck550 FIND v(dout1_76) AT=560.05n

.meas tran vdout1_77ck550 FIND v(dout1_77) AT=560.05n

.meas tran vdout1_78ck550 FIND v(dout1_78) AT=560.05n

.meas tran vdout1_79ck550 FIND v(dout1_79) AT=560.05n

.meas tran vdout1_80ck550 FIND v(dout1_80) AT=560.05n

.meas tran vdout1_81ck550 FIND v(dout1_81) AT=560.05n

.meas tran vdout1_82ck550 FIND v(dout1_82) AT=560.05n

.meas tran vdout1_83ck550 FIND v(dout1_83) AT=560.05n

.meas tran vdout1_84ck550 FIND v(dout1_84) AT=560.05n

.meas tran vdout1_85ck550 FIND v(dout1_85) AT=560.05n

.meas tran vdout1_86ck550 FIND v(dout1_86) AT=560.05n

.meas tran vdout1_87ck550 FIND v(dout1_87) AT=560.05n

.meas tran vdout1_88ck550 FIND v(dout1_88) AT=560.05n

.meas tran vdout1_89ck550 FIND v(dout1_89) AT=560.05n

.meas tran vdout1_90ck550 FIND v(dout1_90) AT=560.05n

.meas tran vdout1_91ck550 FIND v(dout1_91) AT=560.05n

.meas tran vdout1_92ck550 FIND v(dout1_92) AT=560.05n

.meas tran vdout1_93ck550 FIND v(dout1_93) AT=560.05n

.meas tran vdout1_94ck550 FIND v(dout1_94) AT=560.05n

.meas tran vdout1_95ck550 FIND v(dout1_95) AT=560.05n

.meas tran vdout1_96ck550 FIND v(dout1_96) AT=560.05n

.meas tran vdout1_97ck550 FIND v(dout1_97) AT=560.05n

.meas tran vdout1_98ck550 FIND v(dout1_98) AT=560.05n

.meas tran vdout1_99ck550 FIND v(dout1_99) AT=560.05n

.meas tran vdout1_100ck550 FIND v(dout1_100) AT=560.05n

.meas tran vdout1_101ck550 FIND v(dout1_101) AT=560.05n

.meas tran vdout1_102ck550 FIND v(dout1_102) AT=560.05n

.meas tran vdout1_103ck550 FIND v(dout1_103) AT=560.05n

.meas tran vdout1_104ck550 FIND v(dout1_104) AT=560.05n

.meas tran vdout1_105ck550 FIND v(dout1_105) AT=560.05n

.meas tran vdout1_106ck550 FIND v(dout1_106) AT=560.05n

.meas tran vdout1_107ck550 FIND v(dout1_107) AT=560.05n

.meas tran vdout1_108ck550 FIND v(dout1_108) AT=560.05n

.meas tran vdout1_109ck550 FIND v(dout1_109) AT=560.05n

.meas tran vdout1_110ck550 FIND v(dout1_110) AT=560.05n

.meas tran vdout1_111ck550 FIND v(dout1_111) AT=560.05n

.meas tran vdout1_112ck550 FIND v(dout1_112) AT=560.05n

.meas tran vdout1_113ck550 FIND v(dout1_113) AT=560.05n

.meas tran vdout1_114ck550 FIND v(dout1_114) AT=560.05n

.meas tran vdout1_115ck550 FIND v(dout1_115) AT=560.05n

.meas tran vdout1_116ck550 FIND v(dout1_116) AT=560.05n

.meas tran vdout1_117ck550 FIND v(dout1_117) AT=560.05n

.meas tran vdout1_118ck550 FIND v(dout1_118) AT=560.05n

.meas tran vdout1_119ck550 FIND v(dout1_119) AT=560.05n

.meas tran vdout1_120ck550 FIND v(dout1_120) AT=560.05n

.meas tran vdout1_121ck550 FIND v(dout1_121) AT=560.05n

.meas tran vdout1_122ck550 FIND v(dout1_122) AT=560.05n

.meas tran vdout1_123ck550 FIND v(dout1_123) AT=560.05n

.meas tran vdout1_124ck550 FIND v(dout1_124) AT=560.05n

.meas tran vdout1_125ck550 FIND v(dout1_125) AT=560.05n

.meas tran vdout1_126ck550 FIND v(dout1_126) AT=560.05n

.meas tran vdout1_127ck550 FIND v(dout1_127) AT=560.05n

.meas tran vdout1_128ck550 FIND v(dout1_128) AT=560.05n

.meas tran vdout1_129ck550 FIND v(dout1_129) AT=560.05n

.meas tran vdout1_130ck550 FIND v(dout1_130) AT=560.05n

.meas tran vdout1_131ck550 FIND v(dout1_131) AT=560.05n

.meas tran vdout1_132ck550 FIND v(dout1_132) AT=560.05n

.meas tran vdout1_133ck550 FIND v(dout1_133) AT=560.05n

.meas tran vdout1_134ck550 FIND v(dout1_134) AT=560.05n

.meas tran vdout1_0ck560 FIND v(dout1_0) AT=570.05n

.meas tran vdout1_1ck560 FIND v(dout1_1) AT=570.05n

.meas tran vdout1_2ck560 FIND v(dout1_2) AT=570.05n

.meas tran vdout1_3ck560 FIND v(dout1_3) AT=570.05n

.meas tran vdout1_4ck560 FIND v(dout1_4) AT=570.05n

.meas tran vdout1_5ck560 FIND v(dout1_5) AT=570.05n

.meas tran vdout1_6ck560 FIND v(dout1_6) AT=570.05n

.meas tran vdout1_7ck560 FIND v(dout1_7) AT=570.05n

.meas tran vdout1_8ck560 FIND v(dout1_8) AT=570.05n

.meas tran vdout1_9ck560 FIND v(dout1_9) AT=570.05n

.meas tran vdout1_10ck560 FIND v(dout1_10) AT=570.05n

.meas tran vdout1_11ck560 FIND v(dout1_11) AT=570.05n

.meas tran vdout1_12ck560 FIND v(dout1_12) AT=570.05n

.meas tran vdout1_13ck560 FIND v(dout1_13) AT=570.05n

.meas tran vdout1_14ck560 FIND v(dout1_14) AT=570.05n

.meas tran vdout1_15ck560 FIND v(dout1_15) AT=570.05n

.meas tran vdout1_16ck560 FIND v(dout1_16) AT=570.05n

.meas tran vdout1_17ck560 FIND v(dout1_17) AT=570.05n

.meas tran vdout1_18ck560 FIND v(dout1_18) AT=570.05n

.meas tran vdout1_19ck560 FIND v(dout1_19) AT=570.05n

.meas tran vdout1_20ck560 FIND v(dout1_20) AT=570.05n

.meas tran vdout1_21ck560 FIND v(dout1_21) AT=570.05n

.meas tran vdout1_22ck560 FIND v(dout1_22) AT=570.05n

.meas tran vdout1_23ck560 FIND v(dout1_23) AT=570.05n

.meas tran vdout1_24ck560 FIND v(dout1_24) AT=570.05n

.meas tran vdout1_25ck560 FIND v(dout1_25) AT=570.05n

.meas tran vdout1_26ck560 FIND v(dout1_26) AT=570.05n

.meas tran vdout1_27ck560 FIND v(dout1_27) AT=570.05n

.meas tran vdout1_28ck560 FIND v(dout1_28) AT=570.05n

.meas tran vdout1_29ck560 FIND v(dout1_29) AT=570.05n

.meas tran vdout1_30ck560 FIND v(dout1_30) AT=570.05n

.meas tran vdout1_31ck560 FIND v(dout1_31) AT=570.05n

.meas tran vdout1_32ck560 FIND v(dout1_32) AT=570.05n

.meas tran vdout1_33ck560 FIND v(dout1_33) AT=570.05n

.meas tran vdout1_34ck560 FIND v(dout1_34) AT=570.05n

.meas tran vdout1_35ck560 FIND v(dout1_35) AT=570.05n

.meas tran vdout1_36ck560 FIND v(dout1_36) AT=570.05n

.meas tran vdout1_37ck560 FIND v(dout1_37) AT=570.05n

.meas tran vdout1_38ck560 FIND v(dout1_38) AT=570.05n

.meas tran vdout1_39ck560 FIND v(dout1_39) AT=570.05n

.meas tran vdout1_40ck560 FIND v(dout1_40) AT=570.05n

.meas tran vdout1_41ck560 FIND v(dout1_41) AT=570.05n

.meas tran vdout1_42ck560 FIND v(dout1_42) AT=570.05n

.meas tran vdout1_43ck560 FIND v(dout1_43) AT=570.05n

.meas tran vdout1_44ck560 FIND v(dout1_44) AT=570.05n

.meas tran vdout1_45ck560 FIND v(dout1_45) AT=570.05n

.meas tran vdout1_46ck560 FIND v(dout1_46) AT=570.05n

.meas tran vdout1_47ck560 FIND v(dout1_47) AT=570.05n

.meas tran vdout1_48ck560 FIND v(dout1_48) AT=570.05n

.meas tran vdout1_49ck560 FIND v(dout1_49) AT=570.05n

.meas tran vdout1_50ck560 FIND v(dout1_50) AT=570.05n

.meas tran vdout1_51ck560 FIND v(dout1_51) AT=570.05n

.meas tran vdout1_52ck560 FIND v(dout1_52) AT=570.05n

.meas tran vdout1_53ck560 FIND v(dout1_53) AT=570.05n

.meas tran vdout1_54ck560 FIND v(dout1_54) AT=570.05n

.meas tran vdout1_55ck560 FIND v(dout1_55) AT=570.05n

.meas tran vdout1_56ck560 FIND v(dout1_56) AT=570.05n

.meas tran vdout1_57ck560 FIND v(dout1_57) AT=570.05n

.meas tran vdout1_58ck560 FIND v(dout1_58) AT=570.05n

.meas tran vdout1_59ck560 FIND v(dout1_59) AT=570.05n

.meas tran vdout1_60ck560 FIND v(dout1_60) AT=570.05n

.meas tran vdout1_61ck560 FIND v(dout1_61) AT=570.05n

.meas tran vdout1_62ck560 FIND v(dout1_62) AT=570.05n

.meas tran vdout1_63ck560 FIND v(dout1_63) AT=570.05n

.meas tran vdout1_64ck560 FIND v(dout1_64) AT=570.05n

.meas tran vdout1_65ck560 FIND v(dout1_65) AT=570.05n

.meas tran vdout1_66ck560 FIND v(dout1_66) AT=570.05n

.meas tran vdout1_67ck560 FIND v(dout1_67) AT=570.05n

.meas tran vdout1_68ck560 FIND v(dout1_68) AT=570.05n

.meas tran vdout1_69ck560 FIND v(dout1_69) AT=570.05n

.meas tran vdout1_70ck560 FIND v(dout1_70) AT=570.05n

.meas tran vdout1_71ck560 FIND v(dout1_71) AT=570.05n

.meas tran vdout1_72ck560 FIND v(dout1_72) AT=570.05n

.meas tran vdout1_73ck560 FIND v(dout1_73) AT=570.05n

.meas tran vdout1_74ck560 FIND v(dout1_74) AT=570.05n

.meas tran vdout1_75ck560 FIND v(dout1_75) AT=570.05n

.meas tran vdout1_76ck560 FIND v(dout1_76) AT=570.05n

.meas tran vdout1_77ck560 FIND v(dout1_77) AT=570.05n

.meas tran vdout1_78ck560 FIND v(dout1_78) AT=570.05n

.meas tran vdout1_79ck560 FIND v(dout1_79) AT=570.05n

.meas tran vdout1_80ck560 FIND v(dout1_80) AT=570.05n

.meas tran vdout1_81ck560 FIND v(dout1_81) AT=570.05n

.meas tran vdout1_82ck560 FIND v(dout1_82) AT=570.05n

.meas tran vdout1_83ck560 FIND v(dout1_83) AT=570.05n

.meas tran vdout1_84ck560 FIND v(dout1_84) AT=570.05n

.meas tran vdout1_85ck560 FIND v(dout1_85) AT=570.05n

.meas tran vdout1_86ck560 FIND v(dout1_86) AT=570.05n

.meas tran vdout1_87ck560 FIND v(dout1_87) AT=570.05n

.meas tran vdout1_88ck560 FIND v(dout1_88) AT=570.05n

.meas tran vdout1_89ck560 FIND v(dout1_89) AT=570.05n

.meas tran vdout1_90ck560 FIND v(dout1_90) AT=570.05n

.meas tran vdout1_91ck560 FIND v(dout1_91) AT=570.05n

.meas tran vdout1_92ck560 FIND v(dout1_92) AT=570.05n

.meas tran vdout1_93ck560 FIND v(dout1_93) AT=570.05n

.meas tran vdout1_94ck560 FIND v(dout1_94) AT=570.05n

.meas tran vdout1_95ck560 FIND v(dout1_95) AT=570.05n

.meas tran vdout1_96ck560 FIND v(dout1_96) AT=570.05n

.meas tran vdout1_97ck560 FIND v(dout1_97) AT=570.05n

.meas tran vdout1_98ck560 FIND v(dout1_98) AT=570.05n

.meas tran vdout1_99ck560 FIND v(dout1_99) AT=570.05n

.meas tran vdout1_100ck560 FIND v(dout1_100) AT=570.05n

.meas tran vdout1_101ck560 FIND v(dout1_101) AT=570.05n

.meas tran vdout1_102ck560 FIND v(dout1_102) AT=570.05n

.meas tran vdout1_103ck560 FIND v(dout1_103) AT=570.05n

.meas tran vdout1_104ck560 FIND v(dout1_104) AT=570.05n

.meas tran vdout1_105ck560 FIND v(dout1_105) AT=570.05n

.meas tran vdout1_106ck560 FIND v(dout1_106) AT=570.05n

.meas tran vdout1_107ck560 FIND v(dout1_107) AT=570.05n

.meas tran vdout1_108ck560 FIND v(dout1_108) AT=570.05n

.meas tran vdout1_109ck560 FIND v(dout1_109) AT=570.05n

.meas tran vdout1_110ck560 FIND v(dout1_110) AT=570.05n

.meas tran vdout1_111ck560 FIND v(dout1_111) AT=570.05n

.meas tran vdout1_112ck560 FIND v(dout1_112) AT=570.05n

.meas tran vdout1_113ck560 FIND v(dout1_113) AT=570.05n

.meas tran vdout1_114ck560 FIND v(dout1_114) AT=570.05n

.meas tran vdout1_115ck560 FIND v(dout1_115) AT=570.05n

.meas tran vdout1_116ck560 FIND v(dout1_116) AT=570.05n

.meas tran vdout1_117ck560 FIND v(dout1_117) AT=570.05n

.meas tran vdout1_118ck560 FIND v(dout1_118) AT=570.05n

.meas tran vdout1_119ck560 FIND v(dout1_119) AT=570.05n

.meas tran vdout1_120ck560 FIND v(dout1_120) AT=570.05n

.meas tran vdout1_121ck560 FIND v(dout1_121) AT=570.05n

.meas tran vdout1_122ck560 FIND v(dout1_122) AT=570.05n

.meas tran vdout1_123ck560 FIND v(dout1_123) AT=570.05n

.meas tran vdout1_124ck560 FIND v(dout1_124) AT=570.05n

.meas tran vdout1_125ck560 FIND v(dout1_125) AT=570.05n

.meas tran vdout1_126ck560 FIND v(dout1_126) AT=570.05n

.meas tran vdout1_127ck560 FIND v(dout1_127) AT=570.05n

.meas tran vdout1_128ck560 FIND v(dout1_128) AT=570.05n

.meas tran vdout1_129ck560 FIND v(dout1_129) AT=570.05n

.meas tran vdout1_130ck560 FIND v(dout1_130) AT=570.05n

.meas tran vdout1_131ck560 FIND v(dout1_131) AT=570.05n

.meas tran vdout1_132ck560 FIND v(dout1_132) AT=570.05n

.meas tran vdout1_133ck560 FIND v(dout1_133) AT=570.05n

.meas tran vdout1_134ck560 FIND v(dout1_134) AT=570.05n

.meas tran vdout1_0ck590 FIND v(dout1_0) AT=600.05n

.meas tran vdout1_1ck590 FIND v(dout1_1) AT=600.05n

.meas tran vdout1_2ck590 FIND v(dout1_2) AT=600.05n

.meas tran vdout1_3ck590 FIND v(dout1_3) AT=600.05n

.meas tran vdout1_4ck590 FIND v(dout1_4) AT=600.05n

.meas tran vdout1_5ck590 FIND v(dout1_5) AT=600.05n

.meas tran vdout1_6ck590 FIND v(dout1_6) AT=600.05n

.meas tran vdout1_7ck590 FIND v(dout1_7) AT=600.05n

.meas tran vdout1_8ck590 FIND v(dout1_8) AT=600.05n

.meas tran vdout1_9ck590 FIND v(dout1_9) AT=600.05n

.meas tran vdout1_10ck590 FIND v(dout1_10) AT=600.05n

.meas tran vdout1_11ck590 FIND v(dout1_11) AT=600.05n

.meas tran vdout1_12ck590 FIND v(dout1_12) AT=600.05n

.meas tran vdout1_13ck590 FIND v(dout1_13) AT=600.05n

.meas tran vdout1_14ck590 FIND v(dout1_14) AT=600.05n

.meas tran vdout1_15ck590 FIND v(dout1_15) AT=600.05n

.meas tran vdout1_16ck590 FIND v(dout1_16) AT=600.05n

.meas tran vdout1_17ck590 FIND v(dout1_17) AT=600.05n

.meas tran vdout1_18ck590 FIND v(dout1_18) AT=600.05n

.meas tran vdout1_19ck590 FIND v(dout1_19) AT=600.05n

.meas tran vdout1_20ck590 FIND v(dout1_20) AT=600.05n

.meas tran vdout1_21ck590 FIND v(dout1_21) AT=600.05n

.meas tran vdout1_22ck590 FIND v(dout1_22) AT=600.05n

.meas tran vdout1_23ck590 FIND v(dout1_23) AT=600.05n

.meas tran vdout1_24ck590 FIND v(dout1_24) AT=600.05n

.meas tran vdout1_25ck590 FIND v(dout1_25) AT=600.05n

.meas tran vdout1_26ck590 FIND v(dout1_26) AT=600.05n

.meas tran vdout1_27ck590 FIND v(dout1_27) AT=600.05n

.meas tran vdout1_28ck590 FIND v(dout1_28) AT=600.05n

.meas tran vdout1_29ck590 FIND v(dout1_29) AT=600.05n

.meas tran vdout1_30ck590 FIND v(dout1_30) AT=600.05n

.meas tran vdout1_31ck590 FIND v(dout1_31) AT=600.05n

.meas tran vdout1_32ck590 FIND v(dout1_32) AT=600.05n

.meas tran vdout1_33ck590 FIND v(dout1_33) AT=600.05n

.meas tran vdout1_34ck590 FIND v(dout1_34) AT=600.05n

.meas tran vdout1_35ck590 FIND v(dout1_35) AT=600.05n

.meas tran vdout1_36ck590 FIND v(dout1_36) AT=600.05n

.meas tran vdout1_37ck590 FIND v(dout1_37) AT=600.05n

.meas tran vdout1_38ck590 FIND v(dout1_38) AT=600.05n

.meas tran vdout1_39ck590 FIND v(dout1_39) AT=600.05n

.meas tran vdout1_40ck590 FIND v(dout1_40) AT=600.05n

.meas tran vdout1_41ck590 FIND v(dout1_41) AT=600.05n

.meas tran vdout1_42ck590 FIND v(dout1_42) AT=600.05n

.meas tran vdout1_43ck590 FIND v(dout1_43) AT=600.05n

.meas tran vdout1_44ck590 FIND v(dout1_44) AT=600.05n

.meas tran vdout1_45ck590 FIND v(dout1_45) AT=600.05n

.meas tran vdout1_46ck590 FIND v(dout1_46) AT=600.05n

.meas tran vdout1_47ck590 FIND v(dout1_47) AT=600.05n

.meas tran vdout1_48ck590 FIND v(dout1_48) AT=600.05n

.meas tran vdout1_49ck590 FIND v(dout1_49) AT=600.05n

.meas tran vdout1_50ck590 FIND v(dout1_50) AT=600.05n

.meas tran vdout1_51ck590 FIND v(dout1_51) AT=600.05n

.meas tran vdout1_52ck590 FIND v(dout1_52) AT=600.05n

.meas tran vdout1_53ck590 FIND v(dout1_53) AT=600.05n

.meas tran vdout1_54ck590 FIND v(dout1_54) AT=600.05n

.meas tran vdout1_55ck590 FIND v(dout1_55) AT=600.05n

.meas tran vdout1_56ck590 FIND v(dout1_56) AT=600.05n

.meas tran vdout1_57ck590 FIND v(dout1_57) AT=600.05n

.meas tran vdout1_58ck590 FIND v(dout1_58) AT=600.05n

.meas tran vdout1_59ck590 FIND v(dout1_59) AT=600.05n

.meas tran vdout1_60ck590 FIND v(dout1_60) AT=600.05n

.meas tran vdout1_61ck590 FIND v(dout1_61) AT=600.05n

.meas tran vdout1_62ck590 FIND v(dout1_62) AT=600.05n

.meas tran vdout1_63ck590 FIND v(dout1_63) AT=600.05n

.meas tran vdout1_64ck590 FIND v(dout1_64) AT=600.05n

.meas tran vdout1_65ck590 FIND v(dout1_65) AT=600.05n

.meas tran vdout1_66ck590 FIND v(dout1_66) AT=600.05n

.meas tran vdout1_67ck590 FIND v(dout1_67) AT=600.05n

.meas tran vdout1_68ck590 FIND v(dout1_68) AT=600.05n

.meas tran vdout1_69ck590 FIND v(dout1_69) AT=600.05n

.meas tran vdout1_70ck590 FIND v(dout1_70) AT=600.05n

.meas tran vdout1_71ck590 FIND v(dout1_71) AT=600.05n

.meas tran vdout1_72ck590 FIND v(dout1_72) AT=600.05n

.meas tran vdout1_73ck590 FIND v(dout1_73) AT=600.05n

.meas tran vdout1_74ck590 FIND v(dout1_74) AT=600.05n

.meas tran vdout1_75ck590 FIND v(dout1_75) AT=600.05n

.meas tran vdout1_76ck590 FIND v(dout1_76) AT=600.05n

.meas tran vdout1_77ck590 FIND v(dout1_77) AT=600.05n

.meas tran vdout1_78ck590 FIND v(dout1_78) AT=600.05n

.meas tran vdout1_79ck590 FIND v(dout1_79) AT=600.05n

.meas tran vdout1_80ck590 FIND v(dout1_80) AT=600.05n

.meas tran vdout1_81ck590 FIND v(dout1_81) AT=600.05n

.meas tran vdout1_82ck590 FIND v(dout1_82) AT=600.05n

.meas tran vdout1_83ck590 FIND v(dout1_83) AT=600.05n

.meas tran vdout1_84ck590 FIND v(dout1_84) AT=600.05n

.meas tran vdout1_85ck590 FIND v(dout1_85) AT=600.05n

.meas tran vdout1_86ck590 FIND v(dout1_86) AT=600.05n

.meas tran vdout1_87ck590 FIND v(dout1_87) AT=600.05n

.meas tran vdout1_88ck590 FIND v(dout1_88) AT=600.05n

.meas tran vdout1_89ck590 FIND v(dout1_89) AT=600.05n

.meas tran vdout1_90ck590 FIND v(dout1_90) AT=600.05n

.meas tran vdout1_91ck590 FIND v(dout1_91) AT=600.05n

.meas tran vdout1_92ck590 FIND v(dout1_92) AT=600.05n

.meas tran vdout1_93ck590 FIND v(dout1_93) AT=600.05n

.meas tran vdout1_94ck590 FIND v(dout1_94) AT=600.05n

.meas tran vdout1_95ck590 FIND v(dout1_95) AT=600.05n

.meas tran vdout1_96ck590 FIND v(dout1_96) AT=600.05n

.meas tran vdout1_97ck590 FIND v(dout1_97) AT=600.05n

.meas tran vdout1_98ck590 FIND v(dout1_98) AT=600.05n

.meas tran vdout1_99ck590 FIND v(dout1_99) AT=600.05n

.meas tran vdout1_100ck590 FIND v(dout1_100) AT=600.05n

.meas tran vdout1_101ck590 FIND v(dout1_101) AT=600.05n

.meas tran vdout1_102ck590 FIND v(dout1_102) AT=600.05n

.meas tran vdout1_103ck590 FIND v(dout1_103) AT=600.05n

.meas tran vdout1_104ck590 FIND v(dout1_104) AT=600.05n

.meas tran vdout1_105ck590 FIND v(dout1_105) AT=600.05n

.meas tran vdout1_106ck590 FIND v(dout1_106) AT=600.05n

.meas tran vdout1_107ck590 FIND v(dout1_107) AT=600.05n

.meas tran vdout1_108ck590 FIND v(dout1_108) AT=600.05n

.meas tran vdout1_109ck590 FIND v(dout1_109) AT=600.05n

.meas tran vdout1_110ck590 FIND v(dout1_110) AT=600.05n

.meas tran vdout1_111ck590 FIND v(dout1_111) AT=600.05n

.meas tran vdout1_112ck590 FIND v(dout1_112) AT=600.05n

.meas tran vdout1_113ck590 FIND v(dout1_113) AT=600.05n

.meas tran vdout1_114ck590 FIND v(dout1_114) AT=600.05n

.meas tran vdout1_115ck590 FIND v(dout1_115) AT=600.05n

.meas tran vdout1_116ck590 FIND v(dout1_116) AT=600.05n

.meas tran vdout1_117ck590 FIND v(dout1_117) AT=600.05n

.meas tran vdout1_118ck590 FIND v(dout1_118) AT=600.05n

.meas tran vdout1_119ck590 FIND v(dout1_119) AT=600.05n

.meas tran vdout1_120ck590 FIND v(dout1_120) AT=600.05n

.meas tran vdout1_121ck590 FIND v(dout1_121) AT=600.05n

.meas tran vdout1_122ck590 FIND v(dout1_122) AT=600.05n

.meas tran vdout1_123ck590 FIND v(dout1_123) AT=600.05n

.meas tran vdout1_124ck590 FIND v(dout1_124) AT=600.05n

.meas tran vdout1_125ck590 FIND v(dout1_125) AT=600.05n

.meas tran vdout1_126ck590 FIND v(dout1_126) AT=600.05n

.meas tran vdout1_127ck590 FIND v(dout1_127) AT=600.05n

.meas tran vdout1_128ck590 FIND v(dout1_128) AT=600.05n

.meas tran vdout1_129ck590 FIND v(dout1_129) AT=600.05n

.meas tran vdout1_130ck590 FIND v(dout1_130) AT=600.05n

.meas tran vdout1_131ck590 FIND v(dout1_131) AT=600.05n

.meas tran vdout1_132ck590 FIND v(dout1_132) AT=600.05n

.meas tran vdout1_133ck590 FIND v(dout1_133) AT=600.05n

.meas tran vdout1_134ck590 FIND v(dout1_134) AT=600.05n

.meas tran vdout1_0ck630 FIND v(dout1_0) AT=640.05n

.meas tran vdout1_1ck630 FIND v(dout1_1) AT=640.05n

.meas tran vdout1_2ck630 FIND v(dout1_2) AT=640.05n

.meas tran vdout1_3ck630 FIND v(dout1_3) AT=640.05n

.meas tran vdout1_4ck630 FIND v(dout1_4) AT=640.05n

.meas tran vdout1_5ck630 FIND v(dout1_5) AT=640.05n

.meas tran vdout1_6ck630 FIND v(dout1_6) AT=640.05n

.meas tran vdout1_7ck630 FIND v(dout1_7) AT=640.05n

.meas tran vdout1_8ck630 FIND v(dout1_8) AT=640.05n

.meas tran vdout1_9ck630 FIND v(dout1_9) AT=640.05n

.meas tran vdout1_10ck630 FIND v(dout1_10) AT=640.05n

.meas tran vdout1_11ck630 FIND v(dout1_11) AT=640.05n

.meas tran vdout1_12ck630 FIND v(dout1_12) AT=640.05n

.meas tran vdout1_13ck630 FIND v(dout1_13) AT=640.05n

.meas tran vdout1_14ck630 FIND v(dout1_14) AT=640.05n

.meas tran vdout1_15ck630 FIND v(dout1_15) AT=640.05n

.meas tran vdout1_16ck630 FIND v(dout1_16) AT=640.05n

.meas tran vdout1_17ck630 FIND v(dout1_17) AT=640.05n

.meas tran vdout1_18ck630 FIND v(dout1_18) AT=640.05n

.meas tran vdout1_19ck630 FIND v(dout1_19) AT=640.05n

.meas tran vdout1_20ck630 FIND v(dout1_20) AT=640.05n

.meas tran vdout1_21ck630 FIND v(dout1_21) AT=640.05n

.meas tran vdout1_22ck630 FIND v(dout1_22) AT=640.05n

.meas tran vdout1_23ck630 FIND v(dout1_23) AT=640.05n

.meas tran vdout1_24ck630 FIND v(dout1_24) AT=640.05n

.meas tran vdout1_25ck630 FIND v(dout1_25) AT=640.05n

.meas tran vdout1_26ck630 FIND v(dout1_26) AT=640.05n

.meas tran vdout1_27ck630 FIND v(dout1_27) AT=640.05n

.meas tran vdout1_28ck630 FIND v(dout1_28) AT=640.05n

.meas tran vdout1_29ck630 FIND v(dout1_29) AT=640.05n

.meas tran vdout1_30ck630 FIND v(dout1_30) AT=640.05n

.meas tran vdout1_31ck630 FIND v(dout1_31) AT=640.05n

.meas tran vdout1_32ck630 FIND v(dout1_32) AT=640.05n

.meas tran vdout1_33ck630 FIND v(dout1_33) AT=640.05n

.meas tran vdout1_34ck630 FIND v(dout1_34) AT=640.05n

.meas tran vdout1_35ck630 FIND v(dout1_35) AT=640.05n

.meas tran vdout1_36ck630 FIND v(dout1_36) AT=640.05n

.meas tran vdout1_37ck630 FIND v(dout1_37) AT=640.05n

.meas tran vdout1_38ck630 FIND v(dout1_38) AT=640.05n

.meas tran vdout1_39ck630 FIND v(dout1_39) AT=640.05n

.meas tran vdout1_40ck630 FIND v(dout1_40) AT=640.05n

.meas tran vdout1_41ck630 FIND v(dout1_41) AT=640.05n

.meas tran vdout1_42ck630 FIND v(dout1_42) AT=640.05n

.meas tran vdout1_43ck630 FIND v(dout1_43) AT=640.05n

.meas tran vdout1_44ck630 FIND v(dout1_44) AT=640.05n

.meas tran vdout1_45ck630 FIND v(dout1_45) AT=640.05n

.meas tran vdout1_46ck630 FIND v(dout1_46) AT=640.05n

.meas tran vdout1_47ck630 FIND v(dout1_47) AT=640.05n

.meas tran vdout1_48ck630 FIND v(dout1_48) AT=640.05n

.meas tran vdout1_49ck630 FIND v(dout1_49) AT=640.05n

.meas tran vdout1_50ck630 FIND v(dout1_50) AT=640.05n

.meas tran vdout1_51ck630 FIND v(dout1_51) AT=640.05n

.meas tran vdout1_52ck630 FIND v(dout1_52) AT=640.05n

.meas tran vdout1_53ck630 FIND v(dout1_53) AT=640.05n

.meas tran vdout1_54ck630 FIND v(dout1_54) AT=640.05n

.meas tran vdout1_55ck630 FIND v(dout1_55) AT=640.05n

.meas tran vdout1_56ck630 FIND v(dout1_56) AT=640.05n

.meas tran vdout1_57ck630 FIND v(dout1_57) AT=640.05n

.meas tran vdout1_58ck630 FIND v(dout1_58) AT=640.05n

.meas tran vdout1_59ck630 FIND v(dout1_59) AT=640.05n

.meas tran vdout1_60ck630 FIND v(dout1_60) AT=640.05n

.meas tran vdout1_61ck630 FIND v(dout1_61) AT=640.05n

.meas tran vdout1_62ck630 FIND v(dout1_62) AT=640.05n

.meas tran vdout1_63ck630 FIND v(dout1_63) AT=640.05n

.meas tran vdout1_64ck630 FIND v(dout1_64) AT=640.05n

.meas tran vdout1_65ck630 FIND v(dout1_65) AT=640.05n

.meas tran vdout1_66ck630 FIND v(dout1_66) AT=640.05n

.meas tran vdout1_67ck630 FIND v(dout1_67) AT=640.05n

.meas tran vdout1_68ck630 FIND v(dout1_68) AT=640.05n

.meas tran vdout1_69ck630 FIND v(dout1_69) AT=640.05n

.meas tran vdout1_70ck630 FIND v(dout1_70) AT=640.05n

.meas tran vdout1_71ck630 FIND v(dout1_71) AT=640.05n

.meas tran vdout1_72ck630 FIND v(dout1_72) AT=640.05n

.meas tran vdout1_73ck630 FIND v(dout1_73) AT=640.05n

.meas tran vdout1_74ck630 FIND v(dout1_74) AT=640.05n

.meas tran vdout1_75ck630 FIND v(dout1_75) AT=640.05n

.meas tran vdout1_76ck630 FIND v(dout1_76) AT=640.05n

.meas tran vdout1_77ck630 FIND v(dout1_77) AT=640.05n

.meas tran vdout1_78ck630 FIND v(dout1_78) AT=640.05n

.meas tran vdout1_79ck630 FIND v(dout1_79) AT=640.05n

.meas tran vdout1_80ck630 FIND v(dout1_80) AT=640.05n

.meas tran vdout1_81ck630 FIND v(dout1_81) AT=640.05n

.meas tran vdout1_82ck630 FIND v(dout1_82) AT=640.05n

.meas tran vdout1_83ck630 FIND v(dout1_83) AT=640.05n

.meas tran vdout1_84ck630 FIND v(dout1_84) AT=640.05n

.meas tran vdout1_85ck630 FIND v(dout1_85) AT=640.05n

.meas tran vdout1_86ck630 FIND v(dout1_86) AT=640.05n

.meas tran vdout1_87ck630 FIND v(dout1_87) AT=640.05n

.meas tran vdout1_88ck630 FIND v(dout1_88) AT=640.05n

.meas tran vdout1_89ck630 FIND v(dout1_89) AT=640.05n

.meas tran vdout1_90ck630 FIND v(dout1_90) AT=640.05n

.meas tran vdout1_91ck630 FIND v(dout1_91) AT=640.05n

.meas tran vdout1_92ck630 FIND v(dout1_92) AT=640.05n

.meas tran vdout1_93ck630 FIND v(dout1_93) AT=640.05n

.meas tran vdout1_94ck630 FIND v(dout1_94) AT=640.05n

.meas tran vdout1_95ck630 FIND v(dout1_95) AT=640.05n

.meas tran vdout1_96ck630 FIND v(dout1_96) AT=640.05n

.meas tran vdout1_97ck630 FIND v(dout1_97) AT=640.05n

.meas tran vdout1_98ck630 FIND v(dout1_98) AT=640.05n

.meas tran vdout1_99ck630 FIND v(dout1_99) AT=640.05n

.meas tran vdout1_100ck630 FIND v(dout1_100) AT=640.05n

.meas tran vdout1_101ck630 FIND v(dout1_101) AT=640.05n

.meas tran vdout1_102ck630 FIND v(dout1_102) AT=640.05n

.meas tran vdout1_103ck630 FIND v(dout1_103) AT=640.05n

.meas tran vdout1_104ck630 FIND v(dout1_104) AT=640.05n

.meas tran vdout1_105ck630 FIND v(dout1_105) AT=640.05n

.meas tran vdout1_106ck630 FIND v(dout1_106) AT=640.05n

.meas tran vdout1_107ck630 FIND v(dout1_107) AT=640.05n

.meas tran vdout1_108ck630 FIND v(dout1_108) AT=640.05n

.meas tran vdout1_109ck630 FIND v(dout1_109) AT=640.05n

.meas tran vdout1_110ck630 FIND v(dout1_110) AT=640.05n

.meas tran vdout1_111ck630 FIND v(dout1_111) AT=640.05n

.meas tran vdout1_112ck630 FIND v(dout1_112) AT=640.05n

.meas tran vdout1_113ck630 FIND v(dout1_113) AT=640.05n

.meas tran vdout1_114ck630 FIND v(dout1_114) AT=640.05n

.meas tran vdout1_115ck630 FIND v(dout1_115) AT=640.05n

.meas tran vdout1_116ck630 FIND v(dout1_116) AT=640.05n

.meas tran vdout1_117ck630 FIND v(dout1_117) AT=640.05n

.meas tran vdout1_118ck630 FIND v(dout1_118) AT=640.05n

.meas tran vdout1_119ck630 FIND v(dout1_119) AT=640.05n

.meas tran vdout1_120ck630 FIND v(dout1_120) AT=640.05n

.meas tran vdout1_121ck630 FIND v(dout1_121) AT=640.05n

.meas tran vdout1_122ck630 FIND v(dout1_122) AT=640.05n

.meas tran vdout1_123ck630 FIND v(dout1_123) AT=640.05n

.meas tran vdout1_124ck630 FIND v(dout1_124) AT=640.05n

.meas tran vdout1_125ck630 FIND v(dout1_125) AT=640.05n

.meas tran vdout1_126ck630 FIND v(dout1_126) AT=640.05n

.meas tran vdout1_127ck630 FIND v(dout1_127) AT=640.05n

.meas tran vdout1_128ck630 FIND v(dout1_128) AT=640.05n

.meas tran vdout1_129ck630 FIND v(dout1_129) AT=640.05n

.meas tran vdout1_130ck630 FIND v(dout1_130) AT=640.05n

.meas tran vdout1_131ck630 FIND v(dout1_131) AT=640.05n

.meas tran vdout1_132ck630 FIND v(dout1_132) AT=640.05n

.meas tran vdout1_133ck630 FIND v(dout1_133) AT=640.05n

.meas tran vdout1_134ck630 FIND v(dout1_134) AT=640.05n

.meas tran vdout1_0ck640 FIND v(dout1_0) AT=650.05n

.meas tran vdout1_1ck640 FIND v(dout1_1) AT=650.05n

.meas tran vdout1_2ck640 FIND v(dout1_2) AT=650.05n

.meas tran vdout1_3ck640 FIND v(dout1_3) AT=650.05n

.meas tran vdout1_4ck640 FIND v(dout1_4) AT=650.05n

.meas tran vdout1_5ck640 FIND v(dout1_5) AT=650.05n

.meas tran vdout1_6ck640 FIND v(dout1_6) AT=650.05n

.meas tran vdout1_7ck640 FIND v(dout1_7) AT=650.05n

.meas tran vdout1_8ck640 FIND v(dout1_8) AT=650.05n

.meas tran vdout1_9ck640 FIND v(dout1_9) AT=650.05n

.meas tran vdout1_10ck640 FIND v(dout1_10) AT=650.05n

.meas tran vdout1_11ck640 FIND v(dout1_11) AT=650.05n

.meas tran vdout1_12ck640 FIND v(dout1_12) AT=650.05n

.meas tran vdout1_13ck640 FIND v(dout1_13) AT=650.05n

.meas tran vdout1_14ck640 FIND v(dout1_14) AT=650.05n

.meas tran vdout1_15ck640 FIND v(dout1_15) AT=650.05n

.meas tran vdout1_16ck640 FIND v(dout1_16) AT=650.05n

.meas tran vdout1_17ck640 FIND v(dout1_17) AT=650.05n

.meas tran vdout1_18ck640 FIND v(dout1_18) AT=650.05n

.meas tran vdout1_19ck640 FIND v(dout1_19) AT=650.05n

.meas tran vdout1_20ck640 FIND v(dout1_20) AT=650.05n

.meas tran vdout1_21ck640 FIND v(dout1_21) AT=650.05n

.meas tran vdout1_22ck640 FIND v(dout1_22) AT=650.05n

.meas tran vdout1_23ck640 FIND v(dout1_23) AT=650.05n

.meas tran vdout1_24ck640 FIND v(dout1_24) AT=650.05n

.meas tran vdout1_25ck640 FIND v(dout1_25) AT=650.05n

.meas tran vdout1_26ck640 FIND v(dout1_26) AT=650.05n

.meas tran vdout1_27ck640 FIND v(dout1_27) AT=650.05n

.meas tran vdout1_28ck640 FIND v(dout1_28) AT=650.05n

.meas tran vdout1_29ck640 FIND v(dout1_29) AT=650.05n

.meas tran vdout1_30ck640 FIND v(dout1_30) AT=650.05n

.meas tran vdout1_31ck640 FIND v(dout1_31) AT=650.05n

.meas tran vdout1_32ck640 FIND v(dout1_32) AT=650.05n

.meas tran vdout1_33ck640 FIND v(dout1_33) AT=650.05n

.meas tran vdout1_34ck640 FIND v(dout1_34) AT=650.05n

.meas tran vdout1_35ck640 FIND v(dout1_35) AT=650.05n

.meas tran vdout1_36ck640 FIND v(dout1_36) AT=650.05n

.meas tran vdout1_37ck640 FIND v(dout1_37) AT=650.05n

.meas tran vdout1_38ck640 FIND v(dout1_38) AT=650.05n

.meas tran vdout1_39ck640 FIND v(dout1_39) AT=650.05n

.meas tran vdout1_40ck640 FIND v(dout1_40) AT=650.05n

.meas tran vdout1_41ck640 FIND v(dout1_41) AT=650.05n

.meas tran vdout1_42ck640 FIND v(dout1_42) AT=650.05n

.meas tran vdout1_43ck640 FIND v(dout1_43) AT=650.05n

.meas tran vdout1_44ck640 FIND v(dout1_44) AT=650.05n

.meas tran vdout1_45ck640 FIND v(dout1_45) AT=650.05n

.meas tran vdout1_46ck640 FIND v(dout1_46) AT=650.05n

.meas tran vdout1_47ck640 FIND v(dout1_47) AT=650.05n

.meas tran vdout1_48ck640 FIND v(dout1_48) AT=650.05n

.meas tran vdout1_49ck640 FIND v(dout1_49) AT=650.05n

.meas tran vdout1_50ck640 FIND v(dout1_50) AT=650.05n

.meas tran vdout1_51ck640 FIND v(dout1_51) AT=650.05n

.meas tran vdout1_52ck640 FIND v(dout1_52) AT=650.05n

.meas tran vdout1_53ck640 FIND v(dout1_53) AT=650.05n

.meas tran vdout1_54ck640 FIND v(dout1_54) AT=650.05n

.meas tran vdout1_55ck640 FIND v(dout1_55) AT=650.05n

.meas tran vdout1_56ck640 FIND v(dout1_56) AT=650.05n

.meas tran vdout1_57ck640 FIND v(dout1_57) AT=650.05n

.meas tran vdout1_58ck640 FIND v(dout1_58) AT=650.05n

.meas tran vdout1_59ck640 FIND v(dout1_59) AT=650.05n

.meas tran vdout1_60ck640 FIND v(dout1_60) AT=650.05n

.meas tran vdout1_61ck640 FIND v(dout1_61) AT=650.05n

.meas tran vdout1_62ck640 FIND v(dout1_62) AT=650.05n

.meas tran vdout1_63ck640 FIND v(dout1_63) AT=650.05n

.meas tran vdout1_64ck640 FIND v(dout1_64) AT=650.05n

.meas tran vdout1_65ck640 FIND v(dout1_65) AT=650.05n

.meas tran vdout1_66ck640 FIND v(dout1_66) AT=650.05n

.meas tran vdout1_67ck640 FIND v(dout1_67) AT=650.05n

.meas tran vdout1_68ck640 FIND v(dout1_68) AT=650.05n

.meas tran vdout1_69ck640 FIND v(dout1_69) AT=650.05n

.meas tran vdout1_70ck640 FIND v(dout1_70) AT=650.05n

.meas tran vdout1_71ck640 FIND v(dout1_71) AT=650.05n

.meas tran vdout1_72ck640 FIND v(dout1_72) AT=650.05n

.meas tran vdout1_73ck640 FIND v(dout1_73) AT=650.05n

.meas tran vdout1_74ck640 FIND v(dout1_74) AT=650.05n

.meas tran vdout1_75ck640 FIND v(dout1_75) AT=650.05n

.meas tran vdout1_76ck640 FIND v(dout1_76) AT=650.05n

.meas tran vdout1_77ck640 FIND v(dout1_77) AT=650.05n

.meas tran vdout1_78ck640 FIND v(dout1_78) AT=650.05n

.meas tran vdout1_79ck640 FIND v(dout1_79) AT=650.05n

.meas tran vdout1_80ck640 FIND v(dout1_80) AT=650.05n

.meas tran vdout1_81ck640 FIND v(dout1_81) AT=650.05n

.meas tran vdout1_82ck640 FIND v(dout1_82) AT=650.05n

.meas tran vdout1_83ck640 FIND v(dout1_83) AT=650.05n

.meas tran vdout1_84ck640 FIND v(dout1_84) AT=650.05n

.meas tran vdout1_85ck640 FIND v(dout1_85) AT=650.05n

.meas tran vdout1_86ck640 FIND v(dout1_86) AT=650.05n

.meas tran vdout1_87ck640 FIND v(dout1_87) AT=650.05n

.meas tran vdout1_88ck640 FIND v(dout1_88) AT=650.05n

.meas tran vdout1_89ck640 FIND v(dout1_89) AT=650.05n

.meas tran vdout1_90ck640 FIND v(dout1_90) AT=650.05n

.meas tran vdout1_91ck640 FIND v(dout1_91) AT=650.05n

.meas tran vdout1_92ck640 FIND v(dout1_92) AT=650.05n

.meas tran vdout1_93ck640 FIND v(dout1_93) AT=650.05n

.meas tran vdout1_94ck640 FIND v(dout1_94) AT=650.05n

.meas tran vdout1_95ck640 FIND v(dout1_95) AT=650.05n

.meas tran vdout1_96ck640 FIND v(dout1_96) AT=650.05n

.meas tran vdout1_97ck640 FIND v(dout1_97) AT=650.05n

.meas tran vdout1_98ck640 FIND v(dout1_98) AT=650.05n

.meas tran vdout1_99ck640 FIND v(dout1_99) AT=650.05n

.meas tran vdout1_100ck640 FIND v(dout1_100) AT=650.05n

.meas tran vdout1_101ck640 FIND v(dout1_101) AT=650.05n

.meas tran vdout1_102ck640 FIND v(dout1_102) AT=650.05n

.meas tran vdout1_103ck640 FIND v(dout1_103) AT=650.05n

.meas tran vdout1_104ck640 FIND v(dout1_104) AT=650.05n

.meas tran vdout1_105ck640 FIND v(dout1_105) AT=650.05n

.meas tran vdout1_106ck640 FIND v(dout1_106) AT=650.05n

.meas tran vdout1_107ck640 FIND v(dout1_107) AT=650.05n

.meas tran vdout1_108ck640 FIND v(dout1_108) AT=650.05n

.meas tran vdout1_109ck640 FIND v(dout1_109) AT=650.05n

.meas tran vdout1_110ck640 FIND v(dout1_110) AT=650.05n

.meas tran vdout1_111ck640 FIND v(dout1_111) AT=650.05n

.meas tran vdout1_112ck640 FIND v(dout1_112) AT=650.05n

.meas tran vdout1_113ck640 FIND v(dout1_113) AT=650.05n

.meas tran vdout1_114ck640 FIND v(dout1_114) AT=650.05n

.meas tran vdout1_115ck640 FIND v(dout1_115) AT=650.05n

.meas tran vdout1_116ck640 FIND v(dout1_116) AT=650.05n

.meas tran vdout1_117ck640 FIND v(dout1_117) AT=650.05n

.meas tran vdout1_118ck640 FIND v(dout1_118) AT=650.05n

.meas tran vdout1_119ck640 FIND v(dout1_119) AT=650.05n

.meas tran vdout1_120ck640 FIND v(dout1_120) AT=650.05n

.meas tran vdout1_121ck640 FIND v(dout1_121) AT=650.05n

.meas tran vdout1_122ck640 FIND v(dout1_122) AT=650.05n

.meas tran vdout1_123ck640 FIND v(dout1_123) AT=650.05n

.meas tran vdout1_124ck640 FIND v(dout1_124) AT=650.05n

.meas tran vdout1_125ck640 FIND v(dout1_125) AT=650.05n

.meas tran vdout1_126ck640 FIND v(dout1_126) AT=650.05n

.meas tran vdout1_127ck640 FIND v(dout1_127) AT=650.05n

.meas tran vdout1_128ck640 FIND v(dout1_128) AT=650.05n

.meas tran vdout1_129ck640 FIND v(dout1_129) AT=650.05n

.meas tran vdout1_130ck640 FIND v(dout1_130) AT=650.05n

.meas tran vdout1_131ck640 FIND v(dout1_131) AT=650.05n

.meas tran vdout1_132ck640 FIND v(dout1_132) AT=650.05n

.meas tran vdout1_133ck640 FIND v(dout1_133) AT=650.05n

.meas tran vdout1_134ck640 FIND v(dout1_134) AT=650.05n

.meas tran vdout1_0ck660 FIND v(dout1_0) AT=670.05n

.meas tran vdout1_1ck660 FIND v(dout1_1) AT=670.05n

.meas tran vdout1_2ck660 FIND v(dout1_2) AT=670.05n

.meas tran vdout1_3ck660 FIND v(dout1_3) AT=670.05n

.meas tran vdout1_4ck660 FIND v(dout1_4) AT=670.05n

.meas tran vdout1_5ck660 FIND v(dout1_5) AT=670.05n

.meas tran vdout1_6ck660 FIND v(dout1_6) AT=670.05n

.meas tran vdout1_7ck660 FIND v(dout1_7) AT=670.05n

.meas tran vdout1_8ck660 FIND v(dout1_8) AT=670.05n

.meas tran vdout1_9ck660 FIND v(dout1_9) AT=670.05n

.meas tran vdout1_10ck660 FIND v(dout1_10) AT=670.05n

.meas tran vdout1_11ck660 FIND v(dout1_11) AT=670.05n

.meas tran vdout1_12ck660 FIND v(dout1_12) AT=670.05n

.meas tran vdout1_13ck660 FIND v(dout1_13) AT=670.05n

.meas tran vdout1_14ck660 FIND v(dout1_14) AT=670.05n

.meas tran vdout1_15ck660 FIND v(dout1_15) AT=670.05n

.meas tran vdout1_16ck660 FIND v(dout1_16) AT=670.05n

.meas tran vdout1_17ck660 FIND v(dout1_17) AT=670.05n

.meas tran vdout1_18ck660 FIND v(dout1_18) AT=670.05n

.meas tran vdout1_19ck660 FIND v(dout1_19) AT=670.05n

.meas tran vdout1_20ck660 FIND v(dout1_20) AT=670.05n

.meas tran vdout1_21ck660 FIND v(dout1_21) AT=670.05n

.meas tran vdout1_22ck660 FIND v(dout1_22) AT=670.05n

.meas tran vdout1_23ck660 FIND v(dout1_23) AT=670.05n

.meas tran vdout1_24ck660 FIND v(dout1_24) AT=670.05n

.meas tran vdout1_25ck660 FIND v(dout1_25) AT=670.05n

.meas tran vdout1_26ck660 FIND v(dout1_26) AT=670.05n

.meas tran vdout1_27ck660 FIND v(dout1_27) AT=670.05n

.meas tran vdout1_28ck660 FIND v(dout1_28) AT=670.05n

.meas tran vdout1_29ck660 FIND v(dout1_29) AT=670.05n

.meas tran vdout1_30ck660 FIND v(dout1_30) AT=670.05n

.meas tran vdout1_31ck660 FIND v(dout1_31) AT=670.05n

.meas tran vdout1_32ck660 FIND v(dout1_32) AT=670.05n

.meas tran vdout1_33ck660 FIND v(dout1_33) AT=670.05n

.meas tran vdout1_34ck660 FIND v(dout1_34) AT=670.05n

.meas tran vdout1_35ck660 FIND v(dout1_35) AT=670.05n

.meas tran vdout1_36ck660 FIND v(dout1_36) AT=670.05n

.meas tran vdout1_37ck660 FIND v(dout1_37) AT=670.05n

.meas tran vdout1_38ck660 FIND v(dout1_38) AT=670.05n

.meas tran vdout1_39ck660 FIND v(dout1_39) AT=670.05n

.meas tran vdout1_40ck660 FIND v(dout1_40) AT=670.05n

.meas tran vdout1_41ck660 FIND v(dout1_41) AT=670.05n

.meas tran vdout1_42ck660 FIND v(dout1_42) AT=670.05n

.meas tran vdout1_43ck660 FIND v(dout1_43) AT=670.05n

.meas tran vdout1_44ck660 FIND v(dout1_44) AT=670.05n

.meas tran vdout1_45ck660 FIND v(dout1_45) AT=670.05n

.meas tran vdout1_46ck660 FIND v(dout1_46) AT=670.05n

.meas tran vdout1_47ck660 FIND v(dout1_47) AT=670.05n

.meas tran vdout1_48ck660 FIND v(dout1_48) AT=670.05n

.meas tran vdout1_49ck660 FIND v(dout1_49) AT=670.05n

.meas tran vdout1_50ck660 FIND v(dout1_50) AT=670.05n

.meas tran vdout1_51ck660 FIND v(dout1_51) AT=670.05n

.meas tran vdout1_52ck660 FIND v(dout1_52) AT=670.05n

.meas tran vdout1_53ck660 FIND v(dout1_53) AT=670.05n

.meas tran vdout1_54ck660 FIND v(dout1_54) AT=670.05n

.meas tran vdout1_55ck660 FIND v(dout1_55) AT=670.05n

.meas tran vdout1_56ck660 FIND v(dout1_56) AT=670.05n

.meas tran vdout1_57ck660 FIND v(dout1_57) AT=670.05n

.meas tran vdout1_58ck660 FIND v(dout1_58) AT=670.05n

.meas tran vdout1_59ck660 FIND v(dout1_59) AT=670.05n

.meas tran vdout1_60ck660 FIND v(dout1_60) AT=670.05n

.meas tran vdout1_61ck660 FIND v(dout1_61) AT=670.05n

.meas tran vdout1_62ck660 FIND v(dout1_62) AT=670.05n

.meas tran vdout1_63ck660 FIND v(dout1_63) AT=670.05n

.meas tran vdout1_64ck660 FIND v(dout1_64) AT=670.05n

.meas tran vdout1_65ck660 FIND v(dout1_65) AT=670.05n

.meas tran vdout1_66ck660 FIND v(dout1_66) AT=670.05n

.meas tran vdout1_67ck660 FIND v(dout1_67) AT=670.05n

.meas tran vdout1_68ck660 FIND v(dout1_68) AT=670.05n

.meas tran vdout1_69ck660 FIND v(dout1_69) AT=670.05n

.meas tran vdout1_70ck660 FIND v(dout1_70) AT=670.05n

.meas tran vdout1_71ck660 FIND v(dout1_71) AT=670.05n

.meas tran vdout1_72ck660 FIND v(dout1_72) AT=670.05n

.meas tran vdout1_73ck660 FIND v(dout1_73) AT=670.05n

.meas tran vdout1_74ck660 FIND v(dout1_74) AT=670.05n

.meas tran vdout1_75ck660 FIND v(dout1_75) AT=670.05n

.meas tran vdout1_76ck660 FIND v(dout1_76) AT=670.05n

.meas tran vdout1_77ck660 FIND v(dout1_77) AT=670.05n

.meas tran vdout1_78ck660 FIND v(dout1_78) AT=670.05n

.meas tran vdout1_79ck660 FIND v(dout1_79) AT=670.05n

.meas tran vdout1_80ck660 FIND v(dout1_80) AT=670.05n

.meas tran vdout1_81ck660 FIND v(dout1_81) AT=670.05n

.meas tran vdout1_82ck660 FIND v(dout1_82) AT=670.05n

.meas tran vdout1_83ck660 FIND v(dout1_83) AT=670.05n

.meas tran vdout1_84ck660 FIND v(dout1_84) AT=670.05n

.meas tran vdout1_85ck660 FIND v(dout1_85) AT=670.05n

.meas tran vdout1_86ck660 FIND v(dout1_86) AT=670.05n

.meas tran vdout1_87ck660 FIND v(dout1_87) AT=670.05n

.meas tran vdout1_88ck660 FIND v(dout1_88) AT=670.05n

.meas tran vdout1_89ck660 FIND v(dout1_89) AT=670.05n

.meas tran vdout1_90ck660 FIND v(dout1_90) AT=670.05n

.meas tran vdout1_91ck660 FIND v(dout1_91) AT=670.05n

.meas tran vdout1_92ck660 FIND v(dout1_92) AT=670.05n

.meas tran vdout1_93ck660 FIND v(dout1_93) AT=670.05n

.meas tran vdout1_94ck660 FIND v(dout1_94) AT=670.05n

.meas tran vdout1_95ck660 FIND v(dout1_95) AT=670.05n

.meas tran vdout1_96ck660 FIND v(dout1_96) AT=670.05n

.meas tran vdout1_97ck660 FIND v(dout1_97) AT=670.05n

.meas tran vdout1_98ck660 FIND v(dout1_98) AT=670.05n

.meas tran vdout1_99ck660 FIND v(dout1_99) AT=670.05n

.meas tran vdout1_100ck660 FIND v(dout1_100) AT=670.05n

.meas tran vdout1_101ck660 FIND v(dout1_101) AT=670.05n

.meas tran vdout1_102ck660 FIND v(dout1_102) AT=670.05n

.meas tran vdout1_103ck660 FIND v(dout1_103) AT=670.05n

.meas tran vdout1_104ck660 FIND v(dout1_104) AT=670.05n

.meas tran vdout1_105ck660 FIND v(dout1_105) AT=670.05n

.meas tran vdout1_106ck660 FIND v(dout1_106) AT=670.05n

.meas tran vdout1_107ck660 FIND v(dout1_107) AT=670.05n

.meas tran vdout1_108ck660 FIND v(dout1_108) AT=670.05n

.meas tran vdout1_109ck660 FIND v(dout1_109) AT=670.05n

.meas tran vdout1_110ck660 FIND v(dout1_110) AT=670.05n

.meas tran vdout1_111ck660 FIND v(dout1_111) AT=670.05n

.meas tran vdout1_112ck660 FIND v(dout1_112) AT=670.05n

.meas tran vdout1_113ck660 FIND v(dout1_113) AT=670.05n

.meas tran vdout1_114ck660 FIND v(dout1_114) AT=670.05n

.meas tran vdout1_115ck660 FIND v(dout1_115) AT=670.05n

.meas tran vdout1_116ck660 FIND v(dout1_116) AT=670.05n

.meas tran vdout1_117ck660 FIND v(dout1_117) AT=670.05n

.meas tran vdout1_118ck660 FIND v(dout1_118) AT=670.05n

.meas tran vdout1_119ck660 FIND v(dout1_119) AT=670.05n

.meas tran vdout1_120ck660 FIND v(dout1_120) AT=670.05n

.meas tran vdout1_121ck660 FIND v(dout1_121) AT=670.05n

.meas tran vdout1_122ck660 FIND v(dout1_122) AT=670.05n

.meas tran vdout1_123ck660 FIND v(dout1_123) AT=670.05n

.meas tran vdout1_124ck660 FIND v(dout1_124) AT=670.05n

.meas tran vdout1_125ck660 FIND v(dout1_125) AT=670.05n

.meas tran vdout1_126ck660 FIND v(dout1_126) AT=670.05n

.meas tran vdout1_127ck660 FIND v(dout1_127) AT=670.05n

.meas tran vdout1_128ck660 FIND v(dout1_128) AT=670.05n

.meas tran vdout1_129ck660 FIND v(dout1_129) AT=670.05n

.meas tran vdout1_130ck660 FIND v(dout1_130) AT=670.05n

.meas tran vdout1_131ck660 FIND v(dout1_131) AT=670.05n

.meas tran vdout1_132ck660 FIND v(dout1_132) AT=670.05n

.meas tran vdout1_133ck660 FIND v(dout1_133) AT=670.05n

.meas tran vdout1_134ck660 FIND v(dout1_134) AT=670.05n

.meas tran vdout1_0ck690 FIND v(dout1_0) AT=700.05n

.meas tran vdout1_1ck690 FIND v(dout1_1) AT=700.05n

.meas tran vdout1_2ck690 FIND v(dout1_2) AT=700.05n

.meas tran vdout1_3ck690 FIND v(dout1_3) AT=700.05n

.meas tran vdout1_4ck690 FIND v(dout1_4) AT=700.05n

.meas tran vdout1_5ck690 FIND v(dout1_5) AT=700.05n

.meas tran vdout1_6ck690 FIND v(dout1_6) AT=700.05n

.meas tran vdout1_7ck690 FIND v(dout1_7) AT=700.05n

.meas tran vdout1_8ck690 FIND v(dout1_8) AT=700.05n

.meas tran vdout1_9ck690 FIND v(dout1_9) AT=700.05n

.meas tran vdout1_10ck690 FIND v(dout1_10) AT=700.05n

.meas tran vdout1_11ck690 FIND v(dout1_11) AT=700.05n

.meas tran vdout1_12ck690 FIND v(dout1_12) AT=700.05n

.meas tran vdout1_13ck690 FIND v(dout1_13) AT=700.05n

.meas tran vdout1_14ck690 FIND v(dout1_14) AT=700.05n

.meas tran vdout1_15ck690 FIND v(dout1_15) AT=700.05n

.meas tran vdout1_16ck690 FIND v(dout1_16) AT=700.05n

.meas tran vdout1_17ck690 FIND v(dout1_17) AT=700.05n

.meas tran vdout1_18ck690 FIND v(dout1_18) AT=700.05n

.meas tran vdout1_19ck690 FIND v(dout1_19) AT=700.05n

.meas tran vdout1_20ck690 FIND v(dout1_20) AT=700.05n

.meas tran vdout1_21ck690 FIND v(dout1_21) AT=700.05n

.meas tran vdout1_22ck690 FIND v(dout1_22) AT=700.05n

.meas tran vdout1_23ck690 FIND v(dout1_23) AT=700.05n

.meas tran vdout1_24ck690 FIND v(dout1_24) AT=700.05n

.meas tran vdout1_25ck690 FIND v(dout1_25) AT=700.05n

.meas tran vdout1_26ck690 FIND v(dout1_26) AT=700.05n

.meas tran vdout1_27ck690 FIND v(dout1_27) AT=700.05n

.meas tran vdout1_28ck690 FIND v(dout1_28) AT=700.05n

.meas tran vdout1_29ck690 FIND v(dout1_29) AT=700.05n

.meas tran vdout1_30ck690 FIND v(dout1_30) AT=700.05n

.meas tran vdout1_31ck690 FIND v(dout1_31) AT=700.05n

.meas tran vdout1_32ck690 FIND v(dout1_32) AT=700.05n

.meas tran vdout1_33ck690 FIND v(dout1_33) AT=700.05n

.meas tran vdout1_34ck690 FIND v(dout1_34) AT=700.05n

.meas tran vdout1_35ck690 FIND v(dout1_35) AT=700.05n

.meas tran vdout1_36ck690 FIND v(dout1_36) AT=700.05n

.meas tran vdout1_37ck690 FIND v(dout1_37) AT=700.05n

.meas tran vdout1_38ck690 FIND v(dout1_38) AT=700.05n

.meas tran vdout1_39ck690 FIND v(dout1_39) AT=700.05n

.meas tran vdout1_40ck690 FIND v(dout1_40) AT=700.05n

.meas tran vdout1_41ck690 FIND v(dout1_41) AT=700.05n

.meas tran vdout1_42ck690 FIND v(dout1_42) AT=700.05n

.meas tran vdout1_43ck690 FIND v(dout1_43) AT=700.05n

.meas tran vdout1_44ck690 FIND v(dout1_44) AT=700.05n

.meas tran vdout1_45ck690 FIND v(dout1_45) AT=700.05n

.meas tran vdout1_46ck690 FIND v(dout1_46) AT=700.05n

.meas tran vdout1_47ck690 FIND v(dout1_47) AT=700.05n

.meas tran vdout1_48ck690 FIND v(dout1_48) AT=700.05n

.meas tran vdout1_49ck690 FIND v(dout1_49) AT=700.05n

.meas tran vdout1_50ck690 FIND v(dout1_50) AT=700.05n

.meas tran vdout1_51ck690 FIND v(dout1_51) AT=700.05n

.meas tran vdout1_52ck690 FIND v(dout1_52) AT=700.05n

.meas tran vdout1_53ck690 FIND v(dout1_53) AT=700.05n

.meas tran vdout1_54ck690 FIND v(dout1_54) AT=700.05n

.meas tran vdout1_55ck690 FIND v(dout1_55) AT=700.05n

.meas tran vdout1_56ck690 FIND v(dout1_56) AT=700.05n

.meas tran vdout1_57ck690 FIND v(dout1_57) AT=700.05n

.meas tran vdout1_58ck690 FIND v(dout1_58) AT=700.05n

.meas tran vdout1_59ck690 FIND v(dout1_59) AT=700.05n

.meas tran vdout1_60ck690 FIND v(dout1_60) AT=700.05n

.meas tran vdout1_61ck690 FIND v(dout1_61) AT=700.05n

.meas tran vdout1_62ck690 FIND v(dout1_62) AT=700.05n

.meas tran vdout1_63ck690 FIND v(dout1_63) AT=700.05n

.meas tran vdout1_64ck690 FIND v(dout1_64) AT=700.05n

.meas tran vdout1_65ck690 FIND v(dout1_65) AT=700.05n

.meas tran vdout1_66ck690 FIND v(dout1_66) AT=700.05n

.meas tran vdout1_67ck690 FIND v(dout1_67) AT=700.05n

.meas tran vdout1_68ck690 FIND v(dout1_68) AT=700.05n

.meas tran vdout1_69ck690 FIND v(dout1_69) AT=700.05n

.meas tran vdout1_70ck690 FIND v(dout1_70) AT=700.05n

.meas tran vdout1_71ck690 FIND v(dout1_71) AT=700.05n

.meas tran vdout1_72ck690 FIND v(dout1_72) AT=700.05n

.meas tran vdout1_73ck690 FIND v(dout1_73) AT=700.05n

.meas tran vdout1_74ck690 FIND v(dout1_74) AT=700.05n

.meas tran vdout1_75ck690 FIND v(dout1_75) AT=700.05n

.meas tran vdout1_76ck690 FIND v(dout1_76) AT=700.05n

.meas tran vdout1_77ck690 FIND v(dout1_77) AT=700.05n

.meas tran vdout1_78ck690 FIND v(dout1_78) AT=700.05n

.meas tran vdout1_79ck690 FIND v(dout1_79) AT=700.05n

.meas tran vdout1_80ck690 FIND v(dout1_80) AT=700.05n

.meas tran vdout1_81ck690 FIND v(dout1_81) AT=700.05n

.meas tran vdout1_82ck690 FIND v(dout1_82) AT=700.05n

.meas tran vdout1_83ck690 FIND v(dout1_83) AT=700.05n

.meas tran vdout1_84ck690 FIND v(dout1_84) AT=700.05n

.meas tran vdout1_85ck690 FIND v(dout1_85) AT=700.05n

.meas tran vdout1_86ck690 FIND v(dout1_86) AT=700.05n

.meas tran vdout1_87ck690 FIND v(dout1_87) AT=700.05n

.meas tran vdout1_88ck690 FIND v(dout1_88) AT=700.05n

.meas tran vdout1_89ck690 FIND v(dout1_89) AT=700.05n

.meas tran vdout1_90ck690 FIND v(dout1_90) AT=700.05n

.meas tran vdout1_91ck690 FIND v(dout1_91) AT=700.05n

.meas tran vdout1_92ck690 FIND v(dout1_92) AT=700.05n

.meas tran vdout1_93ck690 FIND v(dout1_93) AT=700.05n

.meas tran vdout1_94ck690 FIND v(dout1_94) AT=700.05n

.meas tran vdout1_95ck690 FIND v(dout1_95) AT=700.05n

.meas tran vdout1_96ck690 FIND v(dout1_96) AT=700.05n

.meas tran vdout1_97ck690 FIND v(dout1_97) AT=700.05n

.meas tran vdout1_98ck690 FIND v(dout1_98) AT=700.05n

.meas tran vdout1_99ck690 FIND v(dout1_99) AT=700.05n

.meas tran vdout1_100ck690 FIND v(dout1_100) AT=700.05n

.meas tran vdout1_101ck690 FIND v(dout1_101) AT=700.05n

.meas tran vdout1_102ck690 FIND v(dout1_102) AT=700.05n

.meas tran vdout1_103ck690 FIND v(dout1_103) AT=700.05n

.meas tran vdout1_104ck690 FIND v(dout1_104) AT=700.05n

.meas tran vdout1_105ck690 FIND v(dout1_105) AT=700.05n

.meas tran vdout1_106ck690 FIND v(dout1_106) AT=700.05n

.meas tran vdout1_107ck690 FIND v(dout1_107) AT=700.05n

.meas tran vdout1_108ck690 FIND v(dout1_108) AT=700.05n

.meas tran vdout1_109ck690 FIND v(dout1_109) AT=700.05n

.meas tran vdout1_110ck690 FIND v(dout1_110) AT=700.05n

.meas tran vdout1_111ck690 FIND v(dout1_111) AT=700.05n

.meas tran vdout1_112ck690 FIND v(dout1_112) AT=700.05n

.meas tran vdout1_113ck690 FIND v(dout1_113) AT=700.05n

.meas tran vdout1_114ck690 FIND v(dout1_114) AT=700.05n

.meas tran vdout1_115ck690 FIND v(dout1_115) AT=700.05n

.meas tran vdout1_116ck690 FIND v(dout1_116) AT=700.05n

.meas tran vdout1_117ck690 FIND v(dout1_117) AT=700.05n

.meas tran vdout1_118ck690 FIND v(dout1_118) AT=700.05n

.meas tran vdout1_119ck690 FIND v(dout1_119) AT=700.05n

.meas tran vdout1_120ck690 FIND v(dout1_120) AT=700.05n

.meas tran vdout1_121ck690 FIND v(dout1_121) AT=700.05n

.meas tran vdout1_122ck690 FIND v(dout1_122) AT=700.05n

.meas tran vdout1_123ck690 FIND v(dout1_123) AT=700.05n

.meas tran vdout1_124ck690 FIND v(dout1_124) AT=700.05n

.meas tran vdout1_125ck690 FIND v(dout1_125) AT=700.05n

.meas tran vdout1_126ck690 FIND v(dout1_126) AT=700.05n

.meas tran vdout1_127ck690 FIND v(dout1_127) AT=700.05n

.meas tran vdout1_128ck690 FIND v(dout1_128) AT=700.05n

.meas tran vdout1_129ck690 FIND v(dout1_129) AT=700.05n

.meas tran vdout1_130ck690 FIND v(dout1_130) AT=700.05n

.meas tran vdout1_131ck690 FIND v(dout1_131) AT=700.05n

.meas tran vdout1_132ck690 FIND v(dout1_132) AT=700.05n

.meas tran vdout1_133ck690 FIND v(dout1_133) AT=700.05n

.meas tran vdout1_134ck690 FIND v(dout1_134) AT=700.05n

.meas tran vdout1_0ck720 FIND v(dout1_0) AT=730.05n

.meas tran vdout1_1ck720 FIND v(dout1_1) AT=730.05n

.meas tran vdout1_2ck720 FIND v(dout1_2) AT=730.05n

.meas tran vdout1_3ck720 FIND v(dout1_3) AT=730.05n

.meas tran vdout1_4ck720 FIND v(dout1_4) AT=730.05n

.meas tran vdout1_5ck720 FIND v(dout1_5) AT=730.05n

.meas tran vdout1_6ck720 FIND v(dout1_6) AT=730.05n

.meas tran vdout1_7ck720 FIND v(dout1_7) AT=730.05n

.meas tran vdout1_8ck720 FIND v(dout1_8) AT=730.05n

.meas tran vdout1_9ck720 FIND v(dout1_9) AT=730.05n

.meas tran vdout1_10ck720 FIND v(dout1_10) AT=730.05n

.meas tran vdout1_11ck720 FIND v(dout1_11) AT=730.05n

.meas tran vdout1_12ck720 FIND v(dout1_12) AT=730.05n

.meas tran vdout1_13ck720 FIND v(dout1_13) AT=730.05n

.meas tran vdout1_14ck720 FIND v(dout1_14) AT=730.05n

.meas tran vdout1_15ck720 FIND v(dout1_15) AT=730.05n

.meas tran vdout1_16ck720 FIND v(dout1_16) AT=730.05n

.meas tran vdout1_17ck720 FIND v(dout1_17) AT=730.05n

.meas tran vdout1_18ck720 FIND v(dout1_18) AT=730.05n

.meas tran vdout1_19ck720 FIND v(dout1_19) AT=730.05n

.meas tran vdout1_20ck720 FIND v(dout1_20) AT=730.05n

.meas tran vdout1_21ck720 FIND v(dout1_21) AT=730.05n

.meas tran vdout1_22ck720 FIND v(dout1_22) AT=730.05n

.meas tran vdout1_23ck720 FIND v(dout1_23) AT=730.05n

.meas tran vdout1_24ck720 FIND v(dout1_24) AT=730.05n

.meas tran vdout1_25ck720 FIND v(dout1_25) AT=730.05n

.meas tran vdout1_26ck720 FIND v(dout1_26) AT=730.05n

.meas tran vdout1_27ck720 FIND v(dout1_27) AT=730.05n

.meas tran vdout1_28ck720 FIND v(dout1_28) AT=730.05n

.meas tran vdout1_29ck720 FIND v(dout1_29) AT=730.05n

.meas tran vdout1_30ck720 FIND v(dout1_30) AT=730.05n

.meas tran vdout1_31ck720 FIND v(dout1_31) AT=730.05n

.meas tran vdout1_32ck720 FIND v(dout1_32) AT=730.05n

.meas tran vdout1_33ck720 FIND v(dout1_33) AT=730.05n

.meas tran vdout1_34ck720 FIND v(dout1_34) AT=730.05n

.meas tran vdout1_35ck720 FIND v(dout1_35) AT=730.05n

.meas tran vdout1_36ck720 FIND v(dout1_36) AT=730.05n

.meas tran vdout1_37ck720 FIND v(dout1_37) AT=730.05n

.meas tran vdout1_38ck720 FIND v(dout1_38) AT=730.05n

.meas tran vdout1_39ck720 FIND v(dout1_39) AT=730.05n

.meas tran vdout1_40ck720 FIND v(dout1_40) AT=730.05n

.meas tran vdout1_41ck720 FIND v(dout1_41) AT=730.05n

.meas tran vdout1_42ck720 FIND v(dout1_42) AT=730.05n

.meas tran vdout1_43ck720 FIND v(dout1_43) AT=730.05n

.meas tran vdout1_44ck720 FIND v(dout1_44) AT=730.05n

.meas tran vdout1_45ck720 FIND v(dout1_45) AT=730.05n

.meas tran vdout1_46ck720 FIND v(dout1_46) AT=730.05n

.meas tran vdout1_47ck720 FIND v(dout1_47) AT=730.05n

.meas tran vdout1_48ck720 FIND v(dout1_48) AT=730.05n

.meas tran vdout1_49ck720 FIND v(dout1_49) AT=730.05n

.meas tran vdout1_50ck720 FIND v(dout1_50) AT=730.05n

.meas tran vdout1_51ck720 FIND v(dout1_51) AT=730.05n

.meas tran vdout1_52ck720 FIND v(dout1_52) AT=730.05n

.meas tran vdout1_53ck720 FIND v(dout1_53) AT=730.05n

.meas tran vdout1_54ck720 FIND v(dout1_54) AT=730.05n

.meas tran vdout1_55ck720 FIND v(dout1_55) AT=730.05n

.meas tran vdout1_56ck720 FIND v(dout1_56) AT=730.05n

.meas tran vdout1_57ck720 FIND v(dout1_57) AT=730.05n

.meas tran vdout1_58ck720 FIND v(dout1_58) AT=730.05n

.meas tran vdout1_59ck720 FIND v(dout1_59) AT=730.05n

.meas tran vdout1_60ck720 FIND v(dout1_60) AT=730.05n

.meas tran vdout1_61ck720 FIND v(dout1_61) AT=730.05n

.meas tran vdout1_62ck720 FIND v(dout1_62) AT=730.05n

.meas tran vdout1_63ck720 FIND v(dout1_63) AT=730.05n

.meas tran vdout1_64ck720 FIND v(dout1_64) AT=730.05n

.meas tran vdout1_65ck720 FIND v(dout1_65) AT=730.05n

.meas tran vdout1_66ck720 FIND v(dout1_66) AT=730.05n

.meas tran vdout1_67ck720 FIND v(dout1_67) AT=730.05n

.meas tran vdout1_68ck720 FIND v(dout1_68) AT=730.05n

.meas tran vdout1_69ck720 FIND v(dout1_69) AT=730.05n

.meas tran vdout1_70ck720 FIND v(dout1_70) AT=730.05n

.meas tran vdout1_71ck720 FIND v(dout1_71) AT=730.05n

.meas tran vdout1_72ck720 FIND v(dout1_72) AT=730.05n

.meas tran vdout1_73ck720 FIND v(dout1_73) AT=730.05n

.meas tran vdout1_74ck720 FIND v(dout1_74) AT=730.05n

.meas tran vdout1_75ck720 FIND v(dout1_75) AT=730.05n

.meas tran vdout1_76ck720 FIND v(dout1_76) AT=730.05n

.meas tran vdout1_77ck720 FIND v(dout1_77) AT=730.05n

.meas tran vdout1_78ck720 FIND v(dout1_78) AT=730.05n

.meas tran vdout1_79ck720 FIND v(dout1_79) AT=730.05n

.meas tran vdout1_80ck720 FIND v(dout1_80) AT=730.05n

.meas tran vdout1_81ck720 FIND v(dout1_81) AT=730.05n

.meas tran vdout1_82ck720 FIND v(dout1_82) AT=730.05n

.meas tran vdout1_83ck720 FIND v(dout1_83) AT=730.05n

.meas tran vdout1_84ck720 FIND v(dout1_84) AT=730.05n

.meas tran vdout1_85ck720 FIND v(dout1_85) AT=730.05n

.meas tran vdout1_86ck720 FIND v(dout1_86) AT=730.05n

.meas tran vdout1_87ck720 FIND v(dout1_87) AT=730.05n

.meas tran vdout1_88ck720 FIND v(dout1_88) AT=730.05n

.meas tran vdout1_89ck720 FIND v(dout1_89) AT=730.05n

.meas tran vdout1_90ck720 FIND v(dout1_90) AT=730.05n

.meas tran vdout1_91ck720 FIND v(dout1_91) AT=730.05n

.meas tran vdout1_92ck720 FIND v(dout1_92) AT=730.05n

.meas tran vdout1_93ck720 FIND v(dout1_93) AT=730.05n

.meas tran vdout1_94ck720 FIND v(dout1_94) AT=730.05n

.meas tran vdout1_95ck720 FIND v(dout1_95) AT=730.05n

.meas tran vdout1_96ck720 FIND v(dout1_96) AT=730.05n

.meas tran vdout1_97ck720 FIND v(dout1_97) AT=730.05n

.meas tran vdout1_98ck720 FIND v(dout1_98) AT=730.05n

.meas tran vdout1_99ck720 FIND v(dout1_99) AT=730.05n

.meas tran vdout1_100ck720 FIND v(dout1_100) AT=730.05n

.meas tran vdout1_101ck720 FIND v(dout1_101) AT=730.05n

.meas tran vdout1_102ck720 FIND v(dout1_102) AT=730.05n

.meas tran vdout1_103ck720 FIND v(dout1_103) AT=730.05n

.meas tran vdout1_104ck720 FIND v(dout1_104) AT=730.05n

.meas tran vdout1_105ck720 FIND v(dout1_105) AT=730.05n

.meas tran vdout1_106ck720 FIND v(dout1_106) AT=730.05n

.meas tran vdout1_107ck720 FIND v(dout1_107) AT=730.05n

.meas tran vdout1_108ck720 FIND v(dout1_108) AT=730.05n

.meas tran vdout1_109ck720 FIND v(dout1_109) AT=730.05n

.meas tran vdout1_110ck720 FIND v(dout1_110) AT=730.05n

.meas tran vdout1_111ck720 FIND v(dout1_111) AT=730.05n

.meas tran vdout1_112ck720 FIND v(dout1_112) AT=730.05n

.meas tran vdout1_113ck720 FIND v(dout1_113) AT=730.05n

.meas tran vdout1_114ck720 FIND v(dout1_114) AT=730.05n

.meas tran vdout1_115ck720 FIND v(dout1_115) AT=730.05n

.meas tran vdout1_116ck720 FIND v(dout1_116) AT=730.05n

.meas tran vdout1_117ck720 FIND v(dout1_117) AT=730.05n

.meas tran vdout1_118ck720 FIND v(dout1_118) AT=730.05n

.meas tran vdout1_119ck720 FIND v(dout1_119) AT=730.05n

.meas tran vdout1_120ck720 FIND v(dout1_120) AT=730.05n

.meas tran vdout1_121ck720 FIND v(dout1_121) AT=730.05n

.meas tran vdout1_122ck720 FIND v(dout1_122) AT=730.05n

.meas tran vdout1_123ck720 FIND v(dout1_123) AT=730.05n

.meas tran vdout1_124ck720 FIND v(dout1_124) AT=730.05n

.meas tran vdout1_125ck720 FIND v(dout1_125) AT=730.05n

.meas tran vdout1_126ck720 FIND v(dout1_126) AT=730.05n

.meas tran vdout1_127ck720 FIND v(dout1_127) AT=730.05n

.meas tran vdout1_128ck720 FIND v(dout1_128) AT=730.05n

.meas tran vdout1_129ck720 FIND v(dout1_129) AT=730.05n

.meas tran vdout1_130ck720 FIND v(dout1_130) AT=730.05n

.meas tran vdout1_131ck720 FIND v(dout1_131) AT=730.05n

.meas tran vdout1_132ck720 FIND v(dout1_132) AT=730.05n

.meas tran vdout1_133ck720 FIND v(dout1_133) AT=730.05n

.meas tran vdout1_134ck720 FIND v(dout1_134) AT=730.05n

.meas tran vdout1_0ck760 FIND v(dout1_0) AT=770.05n

.meas tran vdout1_1ck760 FIND v(dout1_1) AT=770.05n

.meas tran vdout1_2ck760 FIND v(dout1_2) AT=770.05n

.meas tran vdout1_3ck760 FIND v(dout1_3) AT=770.05n

.meas tran vdout1_4ck760 FIND v(dout1_4) AT=770.05n

.meas tran vdout1_5ck760 FIND v(dout1_5) AT=770.05n

.meas tran vdout1_6ck760 FIND v(dout1_6) AT=770.05n

.meas tran vdout1_7ck760 FIND v(dout1_7) AT=770.05n

.meas tran vdout1_8ck760 FIND v(dout1_8) AT=770.05n

.meas tran vdout1_9ck760 FIND v(dout1_9) AT=770.05n

.meas tran vdout1_10ck760 FIND v(dout1_10) AT=770.05n

.meas tran vdout1_11ck760 FIND v(dout1_11) AT=770.05n

.meas tran vdout1_12ck760 FIND v(dout1_12) AT=770.05n

.meas tran vdout1_13ck760 FIND v(dout1_13) AT=770.05n

.meas tran vdout1_14ck760 FIND v(dout1_14) AT=770.05n

.meas tran vdout1_15ck760 FIND v(dout1_15) AT=770.05n

.meas tran vdout1_16ck760 FIND v(dout1_16) AT=770.05n

.meas tran vdout1_17ck760 FIND v(dout1_17) AT=770.05n

.meas tran vdout1_18ck760 FIND v(dout1_18) AT=770.05n

.meas tran vdout1_19ck760 FIND v(dout1_19) AT=770.05n

.meas tran vdout1_20ck760 FIND v(dout1_20) AT=770.05n

.meas tran vdout1_21ck760 FIND v(dout1_21) AT=770.05n

.meas tran vdout1_22ck760 FIND v(dout1_22) AT=770.05n

.meas tran vdout1_23ck760 FIND v(dout1_23) AT=770.05n

.meas tran vdout1_24ck760 FIND v(dout1_24) AT=770.05n

.meas tran vdout1_25ck760 FIND v(dout1_25) AT=770.05n

.meas tran vdout1_26ck760 FIND v(dout1_26) AT=770.05n

.meas tran vdout1_27ck760 FIND v(dout1_27) AT=770.05n

.meas tran vdout1_28ck760 FIND v(dout1_28) AT=770.05n

.meas tran vdout1_29ck760 FIND v(dout1_29) AT=770.05n

.meas tran vdout1_30ck760 FIND v(dout1_30) AT=770.05n

.meas tran vdout1_31ck760 FIND v(dout1_31) AT=770.05n

.meas tran vdout1_32ck760 FIND v(dout1_32) AT=770.05n

.meas tran vdout1_33ck760 FIND v(dout1_33) AT=770.05n

.meas tran vdout1_34ck760 FIND v(dout1_34) AT=770.05n

.meas tran vdout1_35ck760 FIND v(dout1_35) AT=770.05n

.meas tran vdout1_36ck760 FIND v(dout1_36) AT=770.05n

.meas tran vdout1_37ck760 FIND v(dout1_37) AT=770.05n

.meas tran vdout1_38ck760 FIND v(dout1_38) AT=770.05n

.meas tran vdout1_39ck760 FIND v(dout1_39) AT=770.05n

.meas tran vdout1_40ck760 FIND v(dout1_40) AT=770.05n

.meas tran vdout1_41ck760 FIND v(dout1_41) AT=770.05n

.meas tran vdout1_42ck760 FIND v(dout1_42) AT=770.05n

.meas tran vdout1_43ck760 FIND v(dout1_43) AT=770.05n

.meas tran vdout1_44ck760 FIND v(dout1_44) AT=770.05n

.meas tran vdout1_45ck760 FIND v(dout1_45) AT=770.05n

.meas tran vdout1_46ck760 FIND v(dout1_46) AT=770.05n

.meas tran vdout1_47ck760 FIND v(dout1_47) AT=770.05n

.meas tran vdout1_48ck760 FIND v(dout1_48) AT=770.05n

.meas tran vdout1_49ck760 FIND v(dout1_49) AT=770.05n

.meas tran vdout1_50ck760 FIND v(dout1_50) AT=770.05n

.meas tran vdout1_51ck760 FIND v(dout1_51) AT=770.05n

.meas tran vdout1_52ck760 FIND v(dout1_52) AT=770.05n

.meas tran vdout1_53ck760 FIND v(dout1_53) AT=770.05n

.meas tran vdout1_54ck760 FIND v(dout1_54) AT=770.05n

.meas tran vdout1_55ck760 FIND v(dout1_55) AT=770.05n

.meas tran vdout1_56ck760 FIND v(dout1_56) AT=770.05n

.meas tran vdout1_57ck760 FIND v(dout1_57) AT=770.05n

.meas tran vdout1_58ck760 FIND v(dout1_58) AT=770.05n

.meas tran vdout1_59ck760 FIND v(dout1_59) AT=770.05n

.meas tran vdout1_60ck760 FIND v(dout1_60) AT=770.05n

.meas tran vdout1_61ck760 FIND v(dout1_61) AT=770.05n

.meas tran vdout1_62ck760 FIND v(dout1_62) AT=770.05n

.meas tran vdout1_63ck760 FIND v(dout1_63) AT=770.05n

.meas tran vdout1_64ck760 FIND v(dout1_64) AT=770.05n

.meas tran vdout1_65ck760 FIND v(dout1_65) AT=770.05n

.meas tran vdout1_66ck760 FIND v(dout1_66) AT=770.05n

.meas tran vdout1_67ck760 FIND v(dout1_67) AT=770.05n

.meas tran vdout1_68ck760 FIND v(dout1_68) AT=770.05n

.meas tran vdout1_69ck760 FIND v(dout1_69) AT=770.05n

.meas tran vdout1_70ck760 FIND v(dout1_70) AT=770.05n

.meas tran vdout1_71ck760 FIND v(dout1_71) AT=770.05n

.meas tran vdout1_72ck760 FIND v(dout1_72) AT=770.05n

.meas tran vdout1_73ck760 FIND v(dout1_73) AT=770.05n

.meas tran vdout1_74ck760 FIND v(dout1_74) AT=770.05n

.meas tran vdout1_75ck760 FIND v(dout1_75) AT=770.05n

.meas tran vdout1_76ck760 FIND v(dout1_76) AT=770.05n

.meas tran vdout1_77ck760 FIND v(dout1_77) AT=770.05n

.meas tran vdout1_78ck760 FIND v(dout1_78) AT=770.05n

.meas tran vdout1_79ck760 FIND v(dout1_79) AT=770.05n

.meas tran vdout1_80ck760 FIND v(dout1_80) AT=770.05n

.meas tran vdout1_81ck760 FIND v(dout1_81) AT=770.05n

.meas tran vdout1_82ck760 FIND v(dout1_82) AT=770.05n

.meas tran vdout1_83ck760 FIND v(dout1_83) AT=770.05n

.meas tran vdout1_84ck760 FIND v(dout1_84) AT=770.05n

.meas tran vdout1_85ck760 FIND v(dout1_85) AT=770.05n

.meas tran vdout1_86ck760 FIND v(dout1_86) AT=770.05n

.meas tran vdout1_87ck760 FIND v(dout1_87) AT=770.05n

.meas tran vdout1_88ck760 FIND v(dout1_88) AT=770.05n

.meas tran vdout1_89ck760 FIND v(dout1_89) AT=770.05n

.meas tran vdout1_90ck760 FIND v(dout1_90) AT=770.05n

.meas tran vdout1_91ck760 FIND v(dout1_91) AT=770.05n

.meas tran vdout1_92ck760 FIND v(dout1_92) AT=770.05n

.meas tran vdout1_93ck760 FIND v(dout1_93) AT=770.05n

.meas tran vdout1_94ck760 FIND v(dout1_94) AT=770.05n

.meas tran vdout1_95ck760 FIND v(dout1_95) AT=770.05n

.meas tran vdout1_96ck760 FIND v(dout1_96) AT=770.05n

.meas tran vdout1_97ck760 FIND v(dout1_97) AT=770.05n

.meas tran vdout1_98ck760 FIND v(dout1_98) AT=770.05n

.meas tran vdout1_99ck760 FIND v(dout1_99) AT=770.05n

.meas tran vdout1_100ck760 FIND v(dout1_100) AT=770.05n

.meas tran vdout1_101ck760 FIND v(dout1_101) AT=770.05n

.meas tran vdout1_102ck760 FIND v(dout1_102) AT=770.05n

.meas tran vdout1_103ck760 FIND v(dout1_103) AT=770.05n

.meas tran vdout1_104ck760 FIND v(dout1_104) AT=770.05n

.meas tran vdout1_105ck760 FIND v(dout1_105) AT=770.05n

.meas tran vdout1_106ck760 FIND v(dout1_106) AT=770.05n

.meas tran vdout1_107ck760 FIND v(dout1_107) AT=770.05n

.meas tran vdout1_108ck760 FIND v(dout1_108) AT=770.05n

.meas tran vdout1_109ck760 FIND v(dout1_109) AT=770.05n

.meas tran vdout1_110ck760 FIND v(dout1_110) AT=770.05n

.meas tran vdout1_111ck760 FIND v(dout1_111) AT=770.05n

.meas tran vdout1_112ck760 FIND v(dout1_112) AT=770.05n

.meas tran vdout1_113ck760 FIND v(dout1_113) AT=770.05n

.meas tran vdout1_114ck760 FIND v(dout1_114) AT=770.05n

.meas tran vdout1_115ck760 FIND v(dout1_115) AT=770.05n

.meas tran vdout1_116ck760 FIND v(dout1_116) AT=770.05n

.meas tran vdout1_117ck760 FIND v(dout1_117) AT=770.05n

.meas tran vdout1_118ck760 FIND v(dout1_118) AT=770.05n

.meas tran vdout1_119ck760 FIND v(dout1_119) AT=770.05n

.meas tran vdout1_120ck760 FIND v(dout1_120) AT=770.05n

.meas tran vdout1_121ck760 FIND v(dout1_121) AT=770.05n

.meas tran vdout1_122ck760 FIND v(dout1_122) AT=770.05n

.meas tran vdout1_123ck760 FIND v(dout1_123) AT=770.05n

.meas tran vdout1_124ck760 FIND v(dout1_124) AT=770.05n

.meas tran vdout1_125ck760 FIND v(dout1_125) AT=770.05n

.meas tran vdout1_126ck760 FIND v(dout1_126) AT=770.05n

.meas tran vdout1_127ck760 FIND v(dout1_127) AT=770.05n

.meas tran vdout1_128ck760 FIND v(dout1_128) AT=770.05n

.meas tran vdout1_129ck760 FIND v(dout1_129) AT=770.05n

.meas tran vdout1_130ck760 FIND v(dout1_130) AT=770.05n

.meas tran vdout1_131ck760 FIND v(dout1_131) AT=770.05n

.meas tran vdout1_132ck760 FIND v(dout1_132) AT=770.05n

.meas tran vdout1_133ck760 FIND v(dout1_133) AT=770.05n

.meas tran vdout1_134ck760 FIND v(dout1_134) AT=770.05n

.meas tran vdout1_0ck770 FIND v(dout1_0) AT=780.05n

.meas tran vdout1_1ck770 FIND v(dout1_1) AT=780.05n

.meas tran vdout1_2ck770 FIND v(dout1_2) AT=780.05n

.meas tran vdout1_3ck770 FIND v(dout1_3) AT=780.05n

.meas tran vdout1_4ck770 FIND v(dout1_4) AT=780.05n

.meas tran vdout1_5ck770 FIND v(dout1_5) AT=780.05n

.meas tran vdout1_6ck770 FIND v(dout1_6) AT=780.05n

.meas tran vdout1_7ck770 FIND v(dout1_7) AT=780.05n

.meas tran vdout1_8ck770 FIND v(dout1_8) AT=780.05n

.meas tran vdout1_9ck770 FIND v(dout1_9) AT=780.05n

.meas tran vdout1_10ck770 FIND v(dout1_10) AT=780.05n

.meas tran vdout1_11ck770 FIND v(dout1_11) AT=780.05n

.meas tran vdout1_12ck770 FIND v(dout1_12) AT=780.05n

.meas tran vdout1_13ck770 FIND v(dout1_13) AT=780.05n

.meas tran vdout1_14ck770 FIND v(dout1_14) AT=780.05n

.meas tran vdout1_15ck770 FIND v(dout1_15) AT=780.05n

.meas tran vdout1_16ck770 FIND v(dout1_16) AT=780.05n

.meas tran vdout1_17ck770 FIND v(dout1_17) AT=780.05n

.meas tran vdout1_18ck770 FIND v(dout1_18) AT=780.05n

.meas tran vdout1_19ck770 FIND v(dout1_19) AT=780.05n

.meas tran vdout1_20ck770 FIND v(dout1_20) AT=780.05n

.meas tran vdout1_21ck770 FIND v(dout1_21) AT=780.05n

.meas tran vdout1_22ck770 FIND v(dout1_22) AT=780.05n

.meas tran vdout1_23ck770 FIND v(dout1_23) AT=780.05n

.meas tran vdout1_24ck770 FIND v(dout1_24) AT=780.05n

.meas tran vdout1_25ck770 FIND v(dout1_25) AT=780.05n

.meas tran vdout1_26ck770 FIND v(dout1_26) AT=780.05n

.meas tran vdout1_27ck770 FIND v(dout1_27) AT=780.05n

.meas tran vdout1_28ck770 FIND v(dout1_28) AT=780.05n

.meas tran vdout1_29ck770 FIND v(dout1_29) AT=780.05n

.meas tran vdout1_30ck770 FIND v(dout1_30) AT=780.05n

.meas tran vdout1_31ck770 FIND v(dout1_31) AT=780.05n

.meas tran vdout1_32ck770 FIND v(dout1_32) AT=780.05n

.meas tran vdout1_33ck770 FIND v(dout1_33) AT=780.05n

.meas tran vdout1_34ck770 FIND v(dout1_34) AT=780.05n

.meas tran vdout1_35ck770 FIND v(dout1_35) AT=780.05n

.meas tran vdout1_36ck770 FIND v(dout1_36) AT=780.05n

.meas tran vdout1_37ck770 FIND v(dout1_37) AT=780.05n

.meas tran vdout1_38ck770 FIND v(dout1_38) AT=780.05n

.meas tran vdout1_39ck770 FIND v(dout1_39) AT=780.05n

.meas tran vdout1_40ck770 FIND v(dout1_40) AT=780.05n

.meas tran vdout1_41ck770 FIND v(dout1_41) AT=780.05n

.meas tran vdout1_42ck770 FIND v(dout1_42) AT=780.05n

.meas tran vdout1_43ck770 FIND v(dout1_43) AT=780.05n

.meas tran vdout1_44ck770 FIND v(dout1_44) AT=780.05n

.meas tran vdout1_45ck770 FIND v(dout1_45) AT=780.05n

.meas tran vdout1_46ck770 FIND v(dout1_46) AT=780.05n

.meas tran vdout1_47ck770 FIND v(dout1_47) AT=780.05n

.meas tran vdout1_48ck770 FIND v(dout1_48) AT=780.05n

.meas tran vdout1_49ck770 FIND v(dout1_49) AT=780.05n

.meas tran vdout1_50ck770 FIND v(dout1_50) AT=780.05n

.meas tran vdout1_51ck770 FIND v(dout1_51) AT=780.05n

.meas tran vdout1_52ck770 FIND v(dout1_52) AT=780.05n

.meas tran vdout1_53ck770 FIND v(dout1_53) AT=780.05n

.meas tran vdout1_54ck770 FIND v(dout1_54) AT=780.05n

.meas tran vdout1_55ck770 FIND v(dout1_55) AT=780.05n

.meas tran vdout1_56ck770 FIND v(dout1_56) AT=780.05n

.meas tran vdout1_57ck770 FIND v(dout1_57) AT=780.05n

.meas tran vdout1_58ck770 FIND v(dout1_58) AT=780.05n

.meas tran vdout1_59ck770 FIND v(dout1_59) AT=780.05n

.meas tran vdout1_60ck770 FIND v(dout1_60) AT=780.05n

.meas tran vdout1_61ck770 FIND v(dout1_61) AT=780.05n

.meas tran vdout1_62ck770 FIND v(dout1_62) AT=780.05n

.meas tran vdout1_63ck770 FIND v(dout1_63) AT=780.05n

.meas tran vdout1_64ck770 FIND v(dout1_64) AT=780.05n

.meas tran vdout1_65ck770 FIND v(dout1_65) AT=780.05n

.meas tran vdout1_66ck770 FIND v(dout1_66) AT=780.05n

.meas tran vdout1_67ck770 FIND v(dout1_67) AT=780.05n

.meas tran vdout1_68ck770 FIND v(dout1_68) AT=780.05n

.meas tran vdout1_69ck770 FIND v(dout1_69) AT=780.05n

.meas tran vdout1_70ck770 FIND v(dout1_70) AT=780.05n

.meas tran vdout1_71ck770 FIND v(dout1_71) AT=780.05n

.meas tran vdout1_72ck770 FIND v(dout1_72) AT=780.05n

.meas tran vdout1_73ck770 FIND v(dout1_73) AT=780.05n

.meas tran vdout1_74ck770 FIND v(dout1_74) AT=780.05n

.meas tran vdout1_75ck770 FIND v(dout1_75) AT=780.05n

.meas tran vdout1_76ck770 FIND v(dout1_76) AT=780.05n

.meas tran vdout1_77ck770 FIND v(dout1_77) AT=780.05n

.meas tran vdout1_78ck770 FIND v(dout1_78) AT=780.05n

.meas tran vdout1_79ck770 FIND v(dout1_79) AT=780.05n

.meas tran vdout1_80ck770 FIND v(dout1_80) AT=780.05n

.meas tran vdout1_81ck770 FIND v(dout1_81) AT=780.05n

.meas tran vdout1_82ck770 FIND v(dout1_82) AT=780.05n

.meas tran vdout1_83ck770 FIND v(dout1_83) AT=780.05n

.meas tran vdout1_84ck770 FIND v(dout1_84) AT=780.05n

.meas tran vdout1_85ck770 FIND v(dout1_85) AT=780.05n

.meas tran vdout1_86ck770 FIND v(dout1_86) AT=780.05n

.meas tran vdout1_87ck770 FIND v(dout1_87) AT=780.05n

.meas tran vdout1_88ck770 FIND v(dout1_88) AT=780.05n

.meas tran vdout1_89ck770 FIND v(dout1_89) AT=780.05n

.meas tran vdout1_90ck770 FIND v(dout1_90) AT=780.05n

.meas tran vdout1_91ck770 FIND v(dout1_91) AT=780.05n

.meas tran vdout1_92ck770 FIND v(dout1_92) AT=780.05n

.meas tran vdout1_93ck770 FIND v(dout1_93) AT=780.05n

.meas tran vdout1_94ck770 FIND v(dout1_94) AT=780.05n

.meas tran vdout1_95ck770 FIND v(dout1_95) AT=780.05n

.meas tran vdout1_96ck770 FIND v(dout1_96) AT=780.05n

.meas tran vdout1_97ck770 FIND v(dout1_97) AT=780.05n

.meas tran vdout1_98ck770 FIND v(dout1_98) AT=780.05n

.meas tran vdout1_99ck770 FIND v(dout1_99) AT=780.05n

.meas tran vdout1_100ck770 FIND v(dout1_100) AT=780.05n

.meas tran vdout1_101ck770 FIND v(dout1_101) AT=780.05n

.meas tran vdout1_102ck770 FIND v(dout1_102) AT=780.05n

.meas tran vdout1_103ck770 FIND v(dout1_103) AT=780.05n

.meas tran vdout1_104ck770 FIND v(dout1_104) AT=780.05n

.meas tran vdout1_105ck770 FIND v(dout1_105) AT=780.05n

.meas tran vdout1_106ck770 FIND v(dout1_106) AT=780.05n

.meas tran vdout1_107ck770 FIND v(dout1_107) AT=780.05n

.meas tran vdout1_108ck770 FIND v(dout1_108) AT=780.05n

.meas tran vdout1_109ck770 FIND v(dout1_109) AT=780.05n

.meas tran vdout1_110ck770 FIND v(dout1_110) AT=780.05n

.meas tran vdout1_111ck770 FIND v(dout1_111) AT=780.05n

.meas tran vdout1_112ck770 FIND v(dout1_112) AT=780.05n

.meas tran vdout1_113ck770 FIND v(dout1_113) AT=780.05n

.meas tran vdout1_114ck770 FIND v(dout1_114) AT=780.05n

.meas tran vdout1_115ck770 FIND v(dout1_115) AT=780.05n

.meas tran vdout1_116ck770 FIND v(dout1_116) AT=780.05n

.meas tran vdout1_117ck770 FIND v(dout1_117) AT=780.05n

.meas tran vdout1_118ck770 FIND v(dout1_118) AT=780.05n

.meas tran vdout1_119ck770 FIND v(dout1_119) AT=780.05n

.meas tran vdout1_120ck770 FIND v(dout1_120) AT=780.05n

.meas tran vdout1_121ck770 FIND v(dout1_121) AT=780.05n

.meas tran vdout1_122ck770 FIND v(dout1_122) AT=780.05n

.meas tran vdout1_123ck770 FIND v(dout1_123) AT=780.05n

.meas tran vdout1_124ck770 FIND v(dout1_124) AT=780.05n

.meas tran vdout1_125ck770 FIND v(dout1_125) AT=780.05n

.meas tran vdout1_126ck770 FIND v(dout1_126) AT=780.05n

.meas tran vdout1_127ck770 FIND v(dout1_127) AT=780.05n

.meas tran vdout1_128ck770 FIND v(dout1_128) AT=780.05n

.meas tran vdout1_129ck770 FIND v(dout1_129) AT=780.05n

.meas tran vdout1_130ck770 FIND v(dout1_130) AT=780.05n

.meas tran vdout1_131ck770 FIND v(dout1_131) AT=780.05n

.meas tran vdout1_132ck770 FIND v(dout1_132) AT=780.05n

.meas tran vdout1_133ck770 FIND v(dout1_133) AT=780.05n

.meas tran vdout1_134ck770 FIND v(dout1_134) AT=780.05n

.meas tran vdout1_0ck800 FIND v(dout1_0) AT=810.05n

.meas tran vdout1_1ck800 FIND v(dout1_1) AT=810.05n

.meas tran vdout1_2ck800 FIND v(dout1_2) AT=810.05n

.meas tran vdout1_3ck800 FIND v(dout1_3) AT=810.05n

.meas tran vdout1_4ck800 FIND v(dout1_4) AT=810.05n

.meas tran vdout1_5ck800 FIND v(dout1_5) AT=810.05n

.meas tran vdout1_6ck800 FIND v(dout1_6) AT=810.05n

.meas tran vdout1_7ck800 FIND v(dout1_7) AT=810.05n

.meas tran vdout1_8ck800 FIND v(dout1_8) AT=810.05n

.meas tran vdout1_9ck800 FIND v(dout1_9) AT=810.05n

.meas tran vdout1_10ck800 FIND v(dout1_10) AT=810.05n

.meas tran vdout1_11ck800 FIND v(dout1_11) AT=810.05n

.meas tran vdout1_12ck800 FIND v(dout1_12) AT=810.05n

.meas tran vdout1_13ck800 FIND v(dout1_13) AT=810.05n

.meas tran vdout1_14ck800 FIND v(dout1_14) AT=810.05n

.meas tran vdout1_15ck800 FIND v(dout1_15) AT=810.05n

.meas tran vdout1_16ck800 FIND v(dout1_16) AT=810.05n

.meas tran vdout1_17ck800 FIND v(dout1_17) AT=810.05n

.meas tran vdout1_18ck800 FIND v(dout1_18) AT=810.05n

.meas tran vdout1_19ck800 FIND v(dout1_19) AT=810.05n

.meas tran vdout1_20ck800 FIND v(dout1_20) AT=810.05n

.meas tran vdout1_21ck800 FIND v(dout1_21) AT=810.05n

.meas tran vdout1_22ck800 FIND v(dout1_22) AT=810.05n

.meas tran vdout1_23ck800 FIND v(dout1_23) AT=810.05n

.meas tran vdout1_24ck800 FIND v(dout1_24) AT=810.05n

.meas tran vdout1_25ck800 FIND v(dout1_25) AT=810.05n

.meas tran vdout1_26ck800 FIND v(dout1_26) AT=810.05n

.meas tran vdout1_27ck800 FIND v(dout1_27) AT=810.05n

.meas tran vdout1_28ck800 FIND v(dout1_28) AT=810.05n

.meas tran vdout1_29ck800 FIND v(dout1_29) AT=810.05n

.meas tran vdout1_30ck800 FIND v(dout1_30) AT=810.05n

.meas tran vdout1_31ck800 FIND v(dout1_31) AT=810.05n

.meas tran vdout1_32ck800 FIND v(dout1_32) AT=810.05n

.meas tran vdout1_33ck800 FIND v(dout1_33) AT=810.05n

.meas tran vdout1_34ck800 FIND v(dout1_34) AT=810.05n

.meas tran vdout1_35ck800 FIND v(dout1_35) AT=810.05n

.meas tran vdout1_36ck800 FIND v(dout1_36) AT=810.05n

.meas tran vdout1_37ck800 FIND v(dout1_37) AT=810.05n

.meas tran vdout1_38ck800 FIND v(dout1_38) AT=810.05n

.meas tran vdout1_39ck800 FIND v(dout1_39) AT=810.05n

.meas tran vdout1_40ck800 FIND v(dout1_40) AT=810.05n

.meas tran vdout1_41ck800 FIND v(dout1_41) AT=810.05n

.meas tran vdout1_42ck800 FIND v(dout1_42) AT=810.05n

.meas tran vdout1_43ck800 FIND v(dout1_43) AT=810.05n

.meas tran vdout1_44ck800 FIND v(dout1_44) AT=810.05n

.meas tran vdout1_45ck800 FIND v(dout1_45) AT=810.05n

.meas tran vdout1_46ck800 FIND v(dout1_46) AT=810.05n

.meas tran vdout1_47ck800 FIND v(dout1_47) AT=810.05n

.meas tran vdout1_48ck800 FIND v(dout1_48) AT=810.05n

.meas tran vdout1_49ck800 FIND v(dout1_49) AT=810.05n

.meas tran vdout1_50ck800 FIND v(dout1_50) AT=810.05n

.meas tran vdout1_51ck800 FIND v(dout1_51) AT=810.05n

.meas tran vdout1_52ck800 FIND v(dout1_52) AT=810.05n

.meas tran vdout1_53ck800 FIND v(dout1_53) AT=810.05n

.meas tran vdout1_54ck800 FIND v(dout1_54) AT=810.05n

.meas tran vdout1_55ck800 FIND v(dout1_55) AT=810.05n

.meas tran vdout1_56ck800 FIND v(dout1_56) AT=810.05n

.meas tran vdout1_57ck800 FIND v(dout1_57) AT=810.05n

.meas tran vdout1_58ck800 FIND v(dout1_58) AT=810.05n

.meas tran vdout1_59ck800 FIND v(dout1_59) AT=810.05n

.meas tran vdout1_60ck800 FIND v(dout1_60) AT=810.05n

.meas tran vdout1_61ck800 FIND v(dout1_61) AT=810.05n

.meas tran vdout1_62ck800 FIND v(dout1_62) AT=810.05n

.meas tran vdout1_63ck800 FIND v(dout1_63) AT=810.05n

.meas tran vdout1_64ck800 FIND v(dout1_64) AT=810.05n

.meas tran vdout1_65ck800 FIND v(dout1_65) AT=810.05n

.meas tran vdout1_66ck800 FIND v(dout1_66) AT=810.05n

.meas tran vdout1_67ck800 FIND v(dout1_67) AT=810.05n

.meas tran vdout1_68ck800 FIND v(dout1_68) AT=810.05n

.meas tran vdout1_69ck800 FIND v(dout1_69) AT=810.05n

.meas tran vdout1_70ck800 FIND v(dout1_70) AT=810.05n

.meas tran vdout1_71ck800 FIND v(dout1_71) AT=810.05n

.meas tran vdout1_72ck800 FIND v(dout1_72) AT=810.05n

.meas tran vdout1_73ck800 FIND v(dout1_73) AT=810.05n

.meas tran vdout1_74ck800 FIND v(dout1_74) AT=810.05n

.meas tran vdout1_75ck800 FIND v(dout1_75) AT=810.05n

.meas tran vdout1_76ck800 FIND v(dout1_76) AT=810.05n

.meas tran vdout1_77ck800 FIND v(dout1_77) AT=810.05n

.meas tran vdout1_78ck800 FIND v(dout1_78) AT=810.05n

.meas tran vdout1_79ck800 FIND v(dout1_79) AT=810.05n

.meas tran vdout1_80ck800 FIND v(dout1_80) AT=810.05n

.meas tran vdout1_81ck800 FIND v(dout1_81) AT=810.05n

.meas tran vdout1_82ck800 FIND v(dout1_82) AT=810.05n

.meas tran vdout1_83ck800 FIND v(dout1_83) AT=810.05n

.meas tran vdout1_84ck800 FIND v(dout1_84) AT=810.05n

.meas tran vdout1_85ck800 FIND v(dout1_85) AT=810.05n

.meas tran vdout1_86ck800 FIND v(dout1_86) AT=810.05n

.meas tran vdout1_87ck800 FIND v(dout1_87) AT=810.05n

.meas tran vdout1_88ck800 FIND v(dout1_88) AT=810.05n

.meas tran vdout1_89ck800 FIND v(dout1_89) AT=810.05n

.meas tran vdout1_90ck800 FIND v(dout1_90) AT=810.05n

.meas tran vdout1_91ck800 FIND v(dout1_91) AT=810.05n

.meas tran vdout1_92ck800 FIND v(dout1_92) AT=810.05n

.meas tran vdout1_93ck800 FIND v(dout1_93) AT=810.05n

.meas tran vdout1_94ck800 FIND v(dout1_94) AT=810.05n

.meas tran vdout1_95ck800 FIND v(dout1_95) AT=810.05n

.meas tran vdout1_96ck800 FIND v(dout1_96) AT=810.05n

.meas tran vdout1_97ck800 FIND v(dout1_97) AT=810.05n

.meas tran vdout1_98ck800 FIND v(dout1_98) AT=810.05n

.meas tran vdout1_99ck800 FIND v(dout1_99) AT=810.05n

.meas tran vdout1_100ck800 FIND v(dout1_100) AT=810.05n

.meas tran vdout1_101ck800 FIND v(dout1_101) AT=810.05n

.meas tran vdout1_102ck800 FIND v(dout1_102) AT=810.05n

.meas tran vdout1_103ck800 FIND v(dout1_103) AT=810.05n

.meas tran vdout1_104ck800 FIND v(dout1_104) AT=810.05n

.meas tran vdout1_105ck800 FIND v(dout1_105) AT=810.05n

.meas tran vdout1_106ck800 FIND v(dout1_106) AT=810.05n

.meas tran vdout1_107ck800 FIND v(dout1_107) AT=810.05n

.meas tran vdout1_108ck800 FIND v(dout1_108) AT=810.05n

.meas tran vdout1_109ck800 FIND v(dout1_109) AT=810.05n

.meas tran vdout1_110ck800 FIND v(dout1_110) AT=810.05n

.meas tran vdout1_111ck800 FIND v(dout1_111) AT=810.05n

.meas tran vdout1_112ck800 FIND v(dout1_112) AT=810.05n

.meas tran vdout1_113ck800 FIND v(dout1_113) AT=810.05n

.meas tran vdout1_114ck800 FIND v(dout1_114) AT=810.05n

.meas tran vdout1_115ck800 FIND v(dout1_115) AT=810.05n

.meas tran vdout1_116ck800 FIND v(dout1_116) AT=810.05n

.meas tran vdout1_117ck800 FIND v(dout1_117) AT=810.05n

.meas tran vdout1_118ck800 FIND v(dout1_118) AT=810.05n

.meas tran vdout1_119ck800 FIND v(dout1_119) AT=810.05n

.meas tran vdout1_120ck800 FIND v(dout1_120) AT=810.05n

.meas tran vdout1_121ck800 FIND v(dout1_121) AT=810.05n

.meas tran vdout1_122ck800 FIND v(dout1_122) AT=810.05n

.meas tran vdout1_123ck800 FIND v(dout1_123) AT=810.05n

.meas tran vdout1_124ck800 FIND v(dout1_124) AT=810.05n

.meas tran vdout1_125ck800 FIND v(dout1_125) AT=810.05n

.meas tran vdout1_126ck800 FIND v(dout1_126) AT=810.05n

.meas tran vdout1_127ck800 FIND v(dout1_127) AT=810.05n

.meas tran vdout1_128ck800 FIND v(dout1_128) AT=810.05n

.meas tran vdout1_129ck800 FIND v(dout1_129) AT=810.05n

.meas tran vdout1_130ck800 FIND v(dout1_130) AT=810.05n

.meas tran vdout1_131ck800 FIND v(dout1_131) AT=810.05n

.meas tran vdout1_132ck800 FIND v(dout1_132) AT=810.05n

.meas tran vdout1_133ck800 FIND v(dout1_133) AT=810.05n

.meas tran vdout1_134ck800 FIND v(dout1_134) AT=810.05n

.meas tran vdout1_0ck830 FIND v(dout1_0) AT=840.05n

.meas tran vdout1_1ck830 FIND v(dout1_1) AT=840.05n

.meas tran vdout1_2ck830 FIND v(dout1_2) AT=840.05n

.meas tran vdout1_3ck830 FIND v(dout1_3) AT=840.05n

.meas tran vdout1_4ck830 FIND v(dout1_4) AT=840.05n

.meas tran vdout1_5ck830 FIND v(dout1_5) AT=840.05n

.meas tran vdout1_6ck830 FIND v(dout1_6) AT=840.05n

.meas tran vdout1_7ck830 FIND v(dout1_7) AT=840.05n

.meas tran vdout1_8ck830 FIND v(dout1_8) AT=840.05n

.meas tran vdout1_9ck830 FIND v(dout1_9) AT=840.05n

.meas tran vdout1_10ck830 FIND v(dout1_10) AT=840.05n

.meas tran vdout1_11ck830 FIND v(dout1_11) AT=840.05n

.meas tran vdout1_12ck830 FIND v(dout1_12) AT=840.05n

.meas tran vdout1_13ck830 FIND v(dout1_13) AT=840.05n

.meas tran vdout1_14ck830 FIND v(dout1_14) AT=840.05n

.meas tran vdout1_15ck830 FIND v(dout1_15) AT=840.05n

.meas tran vdout1_16ck830 FIND v(dout1_16) AT=840.05n

.meas tran vdout1_17ck830 FIND v(dout1_17) AT=840.05n

.meas tran vdout1_18ck830 FIND v(dout1_18) AT=840.05n

.meas tran vdout1_19ck830 FIND v(dout1_19) AT=840.05n

.meas tran vdout1_20ck830 FIND v(dout1_20) AT=840.05n

.meas tran vdout1_21ck830 FIND v(dout1_21) AT=840.05n

.meas tran vdout1_22ck830 FIND v(dout1_22) AT=840.05n

.meas tran vdout1_23ck830 FIND v(dout1_23) AT=840.05n

.meas tran vdout1_24ck830 FIND v(dout1_24) AT=840.05n

.meas tran vdout1_25ck830 FIND v(dout1_25) AT=840.05n

.meas tran vdout1_26ck830 FIND v(dout1_26) AT=840.05n

.meas tran vdout1_27ck830 FIND v(dout1_27) AT=840.05n

.meas tran vdout1_28ck830 FIND v(dout1_28) AT=840.05n

.meas tran vdout1_29ck830 FIND v(dout1_29) AT=840.05n

.meas tran vdout1_30ck830 FIND v(dout1_30) AT=840.05n

.meas tran vdout1_31ck830 FIND v(dout1_31) AT=840.05n

.meas tran vdout1_32ck830 FIND v(dout1_32) AT=840.05n

.meas tran vdout1_33ck830 FIND v(dout1_33) AT=840.05n

.meas tran vdout1_34ck830 FIND v(dout1_34) AT=840.05n

.meas tran vdout1_35ck830 FIND v(dout1_35) AT=840.05n

.meas tran vdout1_36ck830 FIND v(dout1_36) AT=840.05n

.meas tran vdout1_37ck830 FIND v(dout1_37) AT=840.05n

.meas tran vdout1_38ck830 FIND v(dout1_38) AT=840.05n

.meas tran vdout1_39ck830 FIND v(dout1_39) AT=840.05n

.meas tran vdout1_40ck830 FIND v(dout1_40) AT=840.05n

.meas tran vdout1_41ck830 FIND v(dout1_41) AT=840.05n

.meas tran vdout1_42ck830 FIND v(dout1_42) AT=840.05n

.meas tran vdout1_43ck830 FIND v(dout1_43) AT=840.05n

.meas tran vdout1_44ck830 FIND v(dout1_44) AT=840.05n

.meas tran vdout1_45ck830 FIND v(dout1_45) AT=840.05n

.meas tran vdout1_46ck830 FIND v(dout1_46) AT=840.05n

.meas tran vdout1_47ck830 FIND v(dout1_47) AT=840.05n

.meas tran vdout1_48ck830 FIND v(dout1_48) AT=840.05n

.meas tran vdout1_49ck830 FIND v(dout1_49) AT=840.05n

.meas tran vdout1_50ck830 FIND v(dout1_50) AT=840.05n

.meas tran vdout1_51ck830 FIND v(dout1_51) AT=840.05n

.meas tran vdout1_52ck830 FIND v(dout1_52) AT=840.05n

.meas tran vdout1_53ck830 FIND v(dout1_53) AT=840.05n

.meas tran vdout1_54ck830 FIND v(dout1_54) AT=840.05n

.meas tran vdout1_55ck830 FIND v(dout1_55) AT=840.05n

.meas tran vdout1_56ck830 FIND v(dout1_56) AT=840.05n

.meas tran vdout1_57ck830 FIND v(dout1_57) AT=840.05n

.meas tran vdout1_58ck830 FIND v(dout1_58) AT=840.05n

.meas tran vdout1_59ck830 FIND v(dout1_59) AT=840.05n

.meas tran vdout1_60ck830 FIND v(dout1_60) AT=840.05n

.meas tran vdout1_61ck830 FIND v(dout1_61) AT=840.05n

.meas tran vdout1_62ck830 FIND v(dout1_62) AT=840.05n

.meas tran vdout1_63ck830 FIND v(dout1_63) AT=840.05n

.meas tran vdout1_64ck830 FIND v(dout1_64) AT=840.05n

.meas tran vdout1_65ck830 FIND v(dout1_65) AT=840.05n

.meas tran vdout1_66ck830 FIND v(dout1_66) AT=840.05n

.meas tran vdout1_67ck830 FIND v(dout1_67) AT=840.05n

.meas tran vdout1_68ck830 FIND v(dout1_68) AT=840.05n

.meas tran vdout1_69ck830 FIND v(dout1_69) AT=840.05n

.meas tran vdout1_70ck830 FIND v(dout1_70) AT=840.05n

.meas tran vdout1_71ck830 FIND v(dout1_71) AT=840.05n

.meas tran vdout1_72ck830 FIND v(dout1_72) AT=840.05n

.meas tran vdout1_73ck830 FIND v(dout1_73) AT=840.05n

.meas tran vdout1_74ck830 FIND v(dout1_74) AT=840.05n

.meas tran vdout1_75ck830 FIND v(dout1_75) AT=840.05n

.meas tran vdout1_76ck830 FIND v(dout1_76) AT=840.05n

.meas tran vdout1_77ck830 FIND v(dout1_77) AT=840.05n

.meas tran vdout1_78ck830 FIND v(dout1_78) AT=840.05n

.meas tran vdout1_79ck830 FIND v(dout1_79) AT=840.05n

.meas tran vdout1_80ck830 FIND v(dout1_80) AT=840.05n

.meas tran vdout1_81ck830 FIND v(dout1_81) AT=840.05n

.meas tran vdout1_82ck830 FIND v(dout1_82) AT=840.05n

.meas tran vdout1_83ck830 FIND v(dout1_83) AT=840.05n

.meas tran vdout1_84ck830 FIND v(dout1_84) AT=840.05n

.meas tran vdout1_85ck830 FIND v(dout1_85) AT=840.05n

.meas tran vdout1_86ck830 FIND v(dout1_86) AT=840.05n

.meas tran vdout1_87ck830 FIND v(dout1_87) AT=840.05n

.meas tran vdout1_88ck830 FIND v(dout1_88) AT=840.05n

.meas tran vdout1_89ck830 FIND v(dout1_89) AT=840.05n

.meas tran vdout1_90ck830 FIND v(dout1_90) AT=840.05n

.meas tran vdout1_91ck830 FIND v(dout1_91) AT=840.05n

.meas tran vdout1_92ck830 FIND v(dout1_92) AT=840.05n

.meas tran vdout1_93ck830 FIND v(dout1_93) AT=840.05n

.meas tran vdout1_94ck830 FIND v(dout1_94) AT=840.05n

.meas tran vdout1_95ck830 FIND v(dout1_95) AT=840.05n

.meas tran vdout1_96ck830 FIND v(dout1_96) AT=840.05n

.meas tran vdout1_97ck830 FIND v(dout1_97) AT=840.05n

.meas tran vdout1_98ck830 FIND v(dout1_98) AT=840.05n

.meas tran vdout1_99ck830 FIND v(dout1_99) AT=840.05n

.meas tran vdout1_100ck830 FIND v(dout1_100) AT=840.05n

.meas tran vdout1_101ck830 FIND v(dout1_101) AT=840.05n

.meas tran vdout1_102ck830 FIND v(dout1_102) AT=840.05n

.meas tran vdout1_103ck830 FIND v(dout1_103) AT=840.05n

.meas tran vdout1_104ck830 FIND v(dout1_104) AT=840.05n

.meas tran vdout1_105ck830 FIND v(dout1_105) AT=840.05n

.meas tran vdout1_106ck830 FIND v(dout1_106) AT=840.05n

.meas tran vdout1_107ck830 FIND v(dout1_107) AT=840.05n

.meas tran vdout1_108ck830 FIND v(dout1_108) AT=840.05n

.meas tran vdout1_109ck830 FIND v(dout1_109) AT=840.05n

.meas tran vdout1_110ck830 FIND v(dout1_110) AT=840.05n

.meas tran vdout1_111ck830 FIND v(dout1_111) AT=840.05n

.meas tran vdout1_112ck830 FIND v(dout1_112) AT=840.05n

.meas tran vdout1_113ck830 FIND v(dout1_113) AT=840.05n

.meas tran vdout1_114ck830 FIND v(dout1_114) AT=840.05n

.meas tran vdout1_115ck830 FIND v(dout1_115) AT=840.05n

.meas tran vdout1_116ck830 FIND v(dout1_116) AT=840.05n

.meas tran vdout1_117ck830 FIND v(dout1_117) AT=840.05n

.meas tran vdout1_118ck830 FIND v(dout1_118) AT=840.05n

.meas tran vdout1_119ck830 FIND v(dout1_119) AT=840.05n

.meas tran vdout1_120ck830 FIND v(dout1_120) AT=840.05n

.meas tran vdout1_121ck830 FIND v(dout1_121) AT=840.05n

.meas tran vdout1_122ck830 FIND v(dout1_122) AT=840.05n

.meas tran vdout1_123ck830 FIND v(dout1_123) AT=840.05n

.meas tran vdout1_124ck830 FIND v(dout1_124) AT=840.05n

.meas tran vdout1_125ck830 FIND v(dout1_125) AT=840.05n

.meas tran vdout1_126ck830 FIND v(dout1_126) AT=840.05n

.meas tran vdout1_127ck830 FIND v(dout1_127) AT=840.05n

.meas tran vdout1_128ck830 FIND v(dout1_128) AT=840.05n

.meas tran vdout1_129ck830 FIND v(dout1_129) AT=840.05n

.meas tran vdout1_130ck830 FIND v(dout1_130) AT=840.05n

.meas tran vdout1_131ck830 FIND v(dout1_131) AT=840.05n

.meas tran vdout1_132ck830 FIND v(dout1_132) AT=840.05n

.meas tran vdout1_133ck830 FIND v(dout1_133) AT=840.05n

.meas tran vdout1_134ck830 FIND v(dout1_134) AT=840.05n

.meas tran vdout1_0ck840 FIND v(dout1_0) AT=850.05n

.meas tran vdout1_1ck840 FIND v(dout1_1) AT=850.05n

.meas tran vdout1_2ck840 FIND v(dout1_2) AT=850.05n

.meas tran vdout1_3ck840 FIND v(dout1_3) AT=850.05n

.meas tran vdout1_4ck840 FIND v(dout1_4) AT=850.05n

.meas tran vdout1_5ck840 FIND v(dout1_5) AT=850.05n

.meas tran vdout1_6ck840 FIND v(dout1_6) AT=850.05n

.meas tran vdout1_7ck840 FIND v(dout1_7) AT=850.05n

.meas tran vdout1_8ck840 FIND v(dout1_8) AT=850.05n

.meas tran vdout1_9ck840 FIND v(dout1_9) AT=850.05n

.meas tran vdout1_10ck840 FIND v(dout1_10) AT=850.05n

.meas tran vdout1_11ck840 FIND v(dout1_11) AT=850.05n

.meas tran vdout1_12ck840 FIND v(dout1_12) AT=850.05n

.meas tran vdout1_13ck840 FIND v(dout1_13) AT=850.05n

.meas tran vdout1_14ck840 FIND v(dout1_14) AT=850.05n

.meas tran vdout1_15ck840 FIND v(dout1_15) AT=850.05n

.meas tran vdout1_16ck840 FIND v(dout1_16) AT=850.05n

.meas tran vdout1_17ck840 FIND v(dout1_17) AT=850.05n

.meas tran vdout1_18ck840 FIND v(dout1_18) AT=850.05n

.meas tran vdout1_19ck840 FIND v(dout1_19) AT=850.05n

.meas tran vdout1_20ck840 FIND v(dout1_20) AT=850.05n

.meas tran vdout1_21ck840 FIND v(dout1_21) AT=850.05n

.meas tran vdout1_22ck840 FIND v(dout1_22) AT=850.05n

.meas tran vdout1_23ck840 FIND v(dout1_23) AT=850.05n

.meas tran vdout1_24ck840 FIND v(dout1_24) AT=850.05n

.meas tran vdout1_25ck840 FIND v(dout1_25) AT=850.05n

.meas tran vdout1_26ck840 FIND v(dout1_26) AT=850.05n

.meas tran vdout1_27ck840 FIND v(dout1_27) AT=850.05n

.meas tran vdout1_28ck840 FIND v(dout1_28) AT=850.05n

.meas tran vdout1_29ck840 FIND v(dout1_29) AT=850.05n

.meas tran vdout1_30ck840 FIND v(dout1_30) AT=850.05n

.meas tran vdout1_31ck840 FIND v(dout1_31) AT=850.05n

.meas tran vdout1_32ck840 FIND v(dout1_32) AT=850.05n

.meas tran vdout1_33ck840 FIND v(dout1_33) AT=850.05n

.meas tran vdout1_34ck840 FIND v(dout1_34) AT=850.05n

.meas tran vdout1_35ck840 FIND v(dout1_35) AT=850.05n

.meas tran vdout1_36ck840 FIND v(dout1_36) AT=850.05n

.meas tran vdout1_37ck840 FIND v(dout1_37) AT=850.05n

.meas tran vdout1_38ck840 FIND v(dout1_38) AT=850.05n

.meas tran vdout1_39ck840 FIND v(dout1_39) AT=850.05n

.meas tran vdout1_40ck840 FIND v(dout1_40) AT=850.05n

.meas tran vdout1_41ck840 FIND v(dout1_41) AT=850.05n

.meas tran vdout1_42ck840 FIND v(dout1_42) AT=850.05n

.meas tran vdout1_43ck840 FIND v(dout1_43) AT=850.05n

.meas tran vdout1_44ck840 FIND v(dout1_44) AT=850.05n

.meas tran vdout1_45ck840 FIND v(dout1_45) AT=850.05n

.meas tran vdout1_46ck840 FIND v(dout1_46) AT=850.05n

.meas tran vdout1_47ck840 FIND v(dout1_47) AT=850.05n

.meas tran vdout1_48ck840 FIND v(dout1_48) AT=850.05n

.meas tran vdout1_49ck840 FIND v(dout1_49) AT=850.05n

.meas tran vdout1_50ck840 FIND v(dout1_50) AT=850.05n

.meas tran vdout1_51ck840 FIND v(dout1_51) AT=850.05n

.meas tran vdout1_52ck840 FIND v(dout1_52) AT=850.05n

.meas tran vdout1_53ck840 FIND v(dout1_53) AT=850.05n

.meas tran vdout1_54ck840 FIND v(dout1_54) AT=850.05n

.meas tran vdout1_55ck840 FIND v(dout1_55) AT=850.05n

.meas tran vdout1_56ck840 FIND v(dout1_56) AT=850.05n

.meas tran vdout1_57ck840 FIND v(dout1_57) AT=850.05n

.meas tran vdout1_58ck840 FIND v(dout1_58) AT=850.05n

.meas tran vdout1_59ck840 FIND v(dout1_59) AT=850.05n

.meas tran vdout1_60ck840 FIND v(dout1_60) AT=850.05n

.meas tran vdout1_61ck840 FIND v(dout1_61) AT=850.05n

.meas tran vdout1_62ck840 FIND v(dout1_62) AT=850.05n

.meas tran vdout1_63ck840 FIND v(dout1_63) AT=850.05n

.meas tran vdout1_64ck840 FIND v(dout1_64) AT=850.05n

.meas tran vdout1_65ck840 FIND v(dout1_65) AT=850.05n

.meas tran vdout1_66ck840 FIND v(dout1_66) AT=850.05n

.meas tran vdout1_67ck840 FIND v(dout1_67) AT=850.05n

.meas tran vdout1_68ck840 FIND v(dout1_68) AT=850.05n

.meas tran vdout1_69ck840 FIND v(dout1_69) AT=850.05n

.meas tran vdout1_70ck840 FIND v(dout1_70) AT=850.05n

.meas tran vdout1_71ck840 FIND v(dout1_71) AT=850.05n

.meas tran vdout1_72ck840 FIND v(dout1_72) AT=850.05n

.meas tran vdout1_73ck840 FIND v(dout1_73) AT=850.05n

.meas tran vdout1_74ck840 FIND v(dout1_74) AT=850.05n

.meas tran vdout1_75ck840 FIND v(dout1_75) AT=850.05n

.meas tran vdout1_76ck840 FIND v(dout1_76) AT=850.05n

.meas tran vdout1_77ck840 FIND v(dout1_77) AT=850.05n

.meas tran vdout1_78ck840 FIND v(dout1_78) AT=850.05n

.meas tran vdout1_79ck840 FIND v(dout1_79) AT=850.05n

.meas tran vdout1_80ck840 FIND v(dout1_80) AT=850.05n

.meas tran vdout1_81ck840 FIND v(dout1_81) AT=850.05n

.meas tran vdout1_82ck840 FIND v(dout1_82) AT=850.05n

.meas tran vdout1_83ck840 FIND v(dout1_83) AT=850.05n

.meas tran vdout1_84ck840 FIND v(dout1_84) AT=850.05n

.meas tran vdout1_85ck840 FIND v(dout1_85) AT=850.05n

.meas tran vdout1_86ck840 FIND v(dout1_86) AT=850.05n

.meas tran vdout1_87ck840 FIND v(dout1_87) AT=850.05n

.meas tran vdout1_88ck840 FIND v(dout1_88) AT=850.05n

.meas tran vdout1_89ck840 FIND v(dout1_89) AT=850.05n

.meas tran vdout1_90ck840 FIND v(dout1_90) AT=850.05n

.meas tran vdout1_91ck840 FIND v(dout1_91) AT=850.05n

.meas tran vdout1_92ck840 FIND v(dout1_92) AT=850.05n

.meas tran vdout1_93ck840 FIND v(dout1_93) AT=850.05n

.meas tran vdout1_94ck840 FIND v(dout1_94) AT=850.05n

.meas tran vdout1_95ck840 FIND v(dout1_95) AT=850.05n

.meas tran vdout1_96ck840 FIND v(dout1_96) AT=850.05n

.meas tran vdout1_97ck840 FIND v(dout1_97) AT=850.05n

.meas tran vdout1_98ck840 FIND v(dout1_98) AT=850.05n

.meas tran vdout1_99ck840 FIND v(dout1_99) AT=850.05n

.meas tran vdout1_100ck840 FIND v(dout1_100) AT=850.05n

.meas tran vdout1_101ck840 FIND v(dout1_101) AT=850.05n

.meas tran vdout1_102ck840 FIND v(dout1_102) AT=850.05n

.meas tran vdout1_103ck840 FIND v(dout1_103) AT=850.05n

.meas tran vdout1_104ck840 FIND v(dout1_104) AT=850.05n

.meas tran vdout1_105ck840 FIND v(dout1_105) AT=850.05n

.meas tran vdout1_106ck840 FIND v(dout1_106) AT=850.05n

.meas tran vdout1_107ck840 FIND v(dout1_107) AT=850.05n

.meas tran vdout1_108ck840 FIND v(dout1_108) AT=850.05n

.meas tran vdout1_109ck840 FIND v(dout1_109) AT=850.05n

.meas tran vdout1_110ck840 FIND v(dout1_110) AT=850.05n

.meas tran vdout1_111ck840 FIND v(dout1_111) AT=850.05n

.meas tran vdout1_112ck840 FIND v(dout1_112) AT=850.05n

.meas tran vdout1_113ck840 FIND v(dout1_113) AT=850.05n

.meas tran vdout1_114ck840 FIND v(dout1_114) AT=850.05n

.meas tran vdout1_115ck840 FIND v(dout1_115) AT=850.05n

.meas tran vdout1_116ck840 FIND v(dout1_116) AT=850.05n

.meas tran vdout1_117ck840 FIND v(dout1_117) AT=850.05n

.meas tran vdout1_118ck840 FIND v(dout1_118) AT=850.05n

.meas tran vdout1_119ck840 FIND v(dout1_119) AT=850.05n

.meas tran vdout1_120ck840 FIND v(dout1_120) AT=850.05n

.meas tran vdout1_121ck840 FIND v(dout1_121) AT=850.05n

.meas tran vdout1_122ck840 FIND v(dout1_122) AT=850.05n

.meas tran vdout1_123ck840 FIND v(dout1_123) AT=850.05n

.meas tran vdout1_124ck840 FIND v(dout1_124) AT=850.05n

.meas tran vdout1_125ck840 FIND v(dout1_125) AT=850.05n

.meas tran vdout1_126ck840 FIND v(dout1_126) AT=850.05n

.meas tran vdout1_127ck840 FIND v(dout1_127) AT=850.05n

.meas tran vdout1_128ck840 FIND v(dout1_128) AT=850.05n

.meas tran vdout1_129ck840 FIND v(dout1_129) AT=850.05n

.meas tran vdout1_130ck840 FIND v(dout1_130) AT=850.05n

.meas tran vdout1_131ck840 FIND v(dout1_131) AT=850.05n

.meas tran vdout1_132ck840 FIND v(dout1_132) AT=850.05n

.meas tran vdout1_133ck840 FIND v(dout1_133) AT=850.05n

.meas tran vdout1_134ck840 FIND v(dout1_134) AT=850.05n

.meas tran vdout1_0ck860 FIND v(dout1_0) AT=870.05n

.meas tran vdout1_1ck860 FIND v(dout1_1) AT=870.05n

.meas tran vdout1_2ck860 FIND v(dout1_2) AT=870.05n

.meas tran vdout1_3ck860 FIND v(dout1_3) AT=870.05n

.meas tran vdout1_4ck860 FIND v(dout1_4) AT=870.05n

.meas tran vdout1_5ck860 FIND v(dout1_5) AT=870.05n

.meas tran vdout1_6ck860 FIND v(dout1_6) AT=870.05n

.meas tran vdout1_7ck860 FIND v(dout1_7) AT=870.05n

.meas tran vdout1_8ck860 FIND v(dout1_8) AT=870.05n

.meas tran vdout1_9ck860 FIND v(dout1_9) AT=870.05n

.meas tran vdout1_10ck860 FIND v(dout1_10) AT=870.05n

.meas tran vdout1_11ck860 FIND v(dout1_11) AT=870.05n

.meas tran vdout1_12ck860 FIND v(dout1_12) AT=870.05n

.meas tran vdout1_13ck860 FIND v(dout1_13) AT=870.05n

.meas tran vdout1_14ck860 FIND v(dout1_14) AT=870.05n

.meas tran vdout1_15ck860 FIND v(dout1_15) AT=870.05n

.meas tran vdout1_16ck860 FIND v(dout1_16) AT=870.05n

.meas tran vdout1_17ck860 FIND v(dout1_17) AT=870.05n

.meas tran vdout1_18ck860 FIND v(dout1_18) AT=870.05n

.meas tran vdout1_19ck860 FIND v(dout1_19) AT=870.05n

.meas tran vdout1_20ck860 FIND v(dout1_20) AT=870.05n

.meas tran vdout1_21ck860 FIND v(dout1_21) AT=870.05n

.meas tran vdout1_22ck860 FIND v(dout1_22) AT=870.05n

.meas tran vdout1_23ck860 FIND v(dout1_23) AT=870.05n

.meas tran vdout1_24ck860 FIND v(dout1_24) AT=870.05n

.meas tran vdout1_25ck860 FIND v(dout1_25) AT=870.05n

.meas tran vdout1_26ck860 FIND v(dout1_26) AT=870.05n

.meas tran vdout1_27ck860 FIND v(dout1_27) AT=870.05n

.meas tran vdout1_28ck860 FIND v(dout1_28) AT=870.05n

.meas tran vdout1_29ck860 FIND v(dout1_29) AT=870.05n

.meas tran vdout1_30ck860 FIND v(dout1_30) AT=870.05n

.meas tran vdout1_31ck860 FIND v(dout1_31) AT=870.05n

.meas tran vdout1_32ck860 FIND v(dout1_32) AT=870.05n

.meas tran vdout1_33ck860 FIND v(dout1_33) AT=870.05n

.meas tran vdout1_34ck860 FIND v(dout1_34) AT=870.05n

.meas tran vdout1_35ck860 FIND v(dout1_35) AT=870.05n

.meas tran vdout1_36ck860 FIND v(dout1_36) AT=870.05n

.meas tran vdout1_37ck860 FIND v(dout1_37) AT=870.05n

.meas tran vdout1_38ck860 FIND v(dout1_38) AT=870.05n

.meas tran vdout1_39ck860 FIND v(dout1_39) AT=870.05n

.meas tran vdout1_40ck860 FIND v(dout1_40) AT=870.05n

.meas tran vdout1_41ck860 FIND v(dout1_41) AT=870.05n

.meas tran vdout1_42ck860 FIND v(dout1_42) AT=870.05n

.meas tran vdout1_43ck860 FIND v(dout1_43) AT=870.05n

.meas tran vdout1_44ck860 FIND v(dout1_44) AT=870.05n

.meas tran vdout1_45ck860 FIND v(dout1_45) AT=870.05n

.meas tran vdout1_46ck860 FIND v(dout1_46) AT=870.05n

.meas tran vdout1_47ck860 FIND v(dout1_47) AT=870.05n

.meas tran vdout1_48ck860 FIND v(dout1_48) AT=870.05n

.meas tran vdout1_49ck860 FIND v(dout1_49) AT=870.05n

.meas tran vdout1_50ck860 FIND v(dout1_50) AT=870.05n

.meas tran vdout1_51ck860 FIND v(dout1_51) AT=870.05n

.meas tran vdout1_52ck860 FIND v(dout1_52) AT=870.05n

.meas tran vdout1_53ck860 FIND v(dout1_53) AT=870.05n

.meas tran vdout1_54ck860 FIND v(dout1_54) AT=870.05n

.meas tran vdout1_55ck860 FIND v(dout1_55) AT=870.05n

.meas tran vdout1_56ck860 FIND v(dout1_56) AT=870.05n

.meas tran vdout1_57ck860 FIND v(dout1_57) AT=870.05n

.meas tran vdout1_58ck860 FIND v(dout1_58) AT=870.05n

.meas tran vdout1_59ck860 FIND v(dout1_59) AT=870.05n

.meas tran vdout1_60ck860 FIND v(dout1_60) AT=870.05n

.meas tran vdout1_61ck860 FIND v(dout1_61) AT=870.05n

.meas tran vdout1_62ck860 FIND v(dout1_62) AT=870.05n

.meas tran vdout1_63ck860 FIND v(dout1_63) AT=870.05n

.meas tran vdout1_64ck860 FIND v(dout1_64) AT=870.05n

.meas tran vdout1_65ck860 FIND v(dout1_65) AT=870.05n

.meas tran vdout1_66ck860 FIND v(dout1_66) AT=870.05n

.meas tran vdout1_67ck860 FIND v(dout1_67) AT=870.05n

.meas tran vdout1_68ck860 FIND v(dout1_68) AT=870.05n

.meas tran vdout1_69ck860 FIND v(dout1_69) AT=870.05n

.meas tran vdout1_70ck860 FIND v(dout1_70) AT=870.05n

.meas tran vdout1_71ck860 FIND v(dout1_71) AT=870.05n

.meas tran vdout1_72ck860 FIND v(dout1_72) AT=870.05n

.meas tran vdout1_73ck860 FIND v(dout1_73) AT=870.05n

.meas tran vdout1_74ck860 FIND v(dout1_74) AT=870.05n

.meas tran vdout1_75ck860 FIND v(dout1_75) AT=870.05n

.meas tran vdout1_76ck860 FIND v(dout1_76) AT=870.05n

.meas tran vdout1_77ck860 FIND v(dout1_77) AT=870.05n

.meas tran vdout1_78ck860 FIND v(dout1_78) AT=870.05n

.meas tran vdout1_79ck860 FIND v(dout1_79) AT=870.05n

.meas tran vdout1_80ck860 FIND v(dout1_80) AT=870.05n

.meas tran vdout1_81ck860 FIND v(dout1_81) AT=870.05n

.meas tran vdout1_82ck860 FIND v(dout1_82) AT=870.05n

.meas tran vdout1_83ck860 FIND v(dout1_83) AT=870.05n

.meas tran vdout1_84ck860 FIND v(dout1_84) AT=870.05n

.meas tran vdout1_85ck860 FIND v(dout1_85) AT=870.05n

.meas tran vdout1_86ck860 FIND v(dout1_86) AT=870.05n

.meas tran vdout1_87ck860 FIND v(dout1_87) AT=870.05n

.meas tran vdout1_88ck860 FIND v(dout1_88) AT=870.05n

.meas tran vdout1_89ck860 FIND v(dout1_89) AT=870.05n

.meas tran vdout1_90ck860 FIND v(dout1_90) AT=870.05n

.meas tran vdout1_91ck860 FIND v(dout1_91) AT=870.05n

.meas tran vdout1_92ck860 FIND v(dout1_92) AT=870.05n

.meas tran vdout1_93ck860 FIND v(dout1_93) AT=870.05n

.meas tran vdout1_94ck860 FIND v(dout1_94) AT=870.05n

.meas tran vdout1_95ck860 FIND v(dout1_95) AT=870.05n

.meas tran vdout1_96ck860 FIND v(dout1_96) AT=870.05n

.meas tran vdout1_97ck860 FIND v(dout1_97) AT=870.05n

.meas tran vdout1_98ck860 FIND v(dout1_98) AT=870.05n

.meas tran vdout1_99ck860 FIND v(dout1_99) AT=870.05n

.meas tran vdout1_100ck860 FIND v(dout1_100) AT=870.05n

.meas tran vdout1_101ck860 FIND v(dout1_101) AT=870.05n

.meas tran vdout1_102ck860 FIND v(dout1_102) AT=870.05n

.meas tran vdout1_103ck860 FIND v(dout1_103) AT=870.05n

.meas tran vdout1_104ck860 FIND v(dout1_104) AT=870.05n

.meas tran vdout1_105ck860 FIND v(dout1_105) AT=870.05n

.meas tran vdout1_106ck860 FIND v(dout1_106) AT=870.05n

.meas tran vdout1_107ck860 FIND v(dout1_107) AT=870.05n

.meas tran vdout1_108ck860 FIND v(dout1_108) AT=870.05n

.meas tran vdout1_109ck860 FIND v(dout1_109) AT=870.05n

.meas tran vdout1_110ck860 FIND v(dout1_110) AT=870.05n

.meas tran vdout1_111ck860 FIND v(dout1_111) AT=870.05n

.meas tran vdout1_112ck860 FIND v(dout1_112) AT=870.05n

.meas tran vdout1_113ck860 FIND v(dout1_113) AT=870.05n

.meas tran vdout1_114ck860 FIND v(dout1_114) AT=870.05n

.meas tran vdout1_115ck860 FIND v(dout1_115) AT=870.05n

.meas tran vdout1_116ck860 FIND v(dout1_116) AT=870.05n

.meas tran vdout1_117ck860 FIND v(dout1_117) AT=870.05n

.meas tran vdout1_118ck860 FIND v(dout1_118) AT=870.05n

.meas tran vdout1_119ck860 FIND v(dout1_119) AT=870.05n

.meas tran vdout1_120ck860 FIND v(dout1_120) AT=870.05n

.meas tran vdout1_121ck860 FIND v(dout1_121) AT=870.05n

.meas tran vdout1_122ck860 FIND v(dout1_122) AT=870.05n

.meas tran vdout1_123ck860 FIND v(dout1_123) AT=870.05n

.meas tran vdout1_124ck860 FIND v(dout1_124) AT=870.05n

.meas tran vdout1_125ck860 FIND v(dout1_125) AT=870.05n

.meas tran vdout1_126ck860 FIND v(dout1_126) AT=870.05n

.meas tran vdout1_127ck860 FIND v(dout1_127) AT=870.05n

.meas tran vdout1_128ck860 FIND v(dout1_128) AT=870.05n

.meas tran vdout1_129ck860 FIND v(dout1_129) AT=870.05n

.meas tran vdout1_130ck860 FIND v(dout1_130) AT=870.05n

.meas tran vdout1_131ck860 FIND v(dout1_131) AT=870.05n

.meas tran vdout1_132ck860 FIND v(dout1_132) AT=870.05n

.meas tran vdout1_133ck860 FIND v(dout1_133) AT=870.05n

.meas tran vdout1_134ck860 FIND v(dout1_134) AT=870.05n

.meas tran vdout1_0ck870 FIND v(dout1_0) AT=880.05n

.meas tran vdout1_1ck870 FIND v(dout1_1) AT=880.05n

.meas tran vdout1_2ck870 FIND v(dout1_2) AT=880.05n

.meas tran vdout1_3ck870 FIND v(dout1_3) AT=880.05n

.meas tran vdout1_4ck870 FIND v(dout1_4) AT=880.05n

.meas tran vdout1_5ck870 FIND v(dout1_5) AT=880.05n

.meas tran vdout1_6ck870 FIND v(dout1_6) AT=880.05n

.meas tran vdout1_7ck870 FIND v(dout1_7) AT=880.05n

.meas tran vdout1_8ck870 FIND v(dout1_8) AT=880.05n

.meas tran vdout1_9ck870 FIND v(dout1_9) AT=880.05n

.meas tran vdout1_10ck870 FIND v(dout1_10) AT=880.05n

.meas tran vdout1_11ck870 FIND v(dout1_11) AT=880.05n

.meas tran vdout1_12ck870 FIND v(dout1_12) AT=880.05n

.meas tran vdout1_13ck870 FIND v(dout1_13) AT=880.05n

.meas tran vdout1_14ck870 FIND v(dout1_14) AT=880.05n

.meas tran vdout1_15ck870 FIND v(dout1_15) AT=880.05n

.meas tran vdout1_16ck870 FIND v(dout1_16) AT=880.05n

.meas tran vdout1_17ck870 FIND v(dout1_17) AT=880.05n

.meas tran vdout1_18ck870 FIND v(dout1_18) AT=880.05n

.meas tran vdout1_19ck870 FIND v(dout1_19) AT=880.05n

.meas tran vdout1_20ck870 FIND v(dout1_20) AT=880.05n

.meas tran vdout1_21ck870 FIND v(dout1_21) AT=880.05n

.meas tran vdout1_22ck870 FIND v(dout1_22) AT=880.05n

.meas tran vdout1_23ck870 FIND v(dout1_23) AT=880.05n

.meas tran vdout1_24ck870 FIND v(dout1_24) AT=880.05n

.meas tran vdout1_25ck870 FIND v(dout1_25) AT=880.05n

.meas tran vdout1_26ck870 FIND v(dout1_26) AT=880.05n

.meas tran vdout1_27ck870 FIND v(dout1_27) AT=880.05n

.meas tran vdout1_28ck870 FIND v(dout1_28) AT=880.05n

.meas tran vdout1_29ck870 FIND v(dout1_29) AT=880.05n

.meas tran vdout1_30ck870 FIND v(dout1_30) AT=880.05n

.meas tran vdout1_31ck870 FIND v(dout1_31) AT=880.05n

.meas tran vdout1_32ck870 FIND v(dout1_32) AT=880.05n

.meas tran vdout1_33ck870 FIND v(dout1_33) AT=880.05n

.meas tran vdout1_34ck870 FIND v(dout1_34) AT=880.05n

.meas tran vdout1_35ck870 FIND v(dout1_35) AT=880.05n

.meas tran vdout1_36ck870 FIND v(dout1_36) AT=880.05n

.meas tran vdout1_37ck870 FIND v(dout1_37) AT=880.05n

.meas tran vdout1_38ck870 FIND v(dout1_38) AT=880.05n

.meas tran vdout1_39ck870 FIND v(dout1_39) AT=880.05n

.meas tran vdout1_40ck870 FIND v(dout1_40) AT=880.05n

.meas tran vdout1_41ck870 FIND v(dout1_41) AT=880.05n

.meas tran vdout1_42ck870 FIND v(dout1_42) AT=880.05n

.meas tran vdout1_43ck870 FIND v(dout1_43) AT=880.05n

.meas tran vdout1_44ck870 FIND v(dout1_44) AT=880.05n

.meas tran vdout1_45ck870 FIND v(dout1_45) AT=880.05n

.meas tran vdout1_46ck870 FIND v(dout1_46) AT=880.05n

.meas tran vdout1_47ck870 FIND v(dout1_47) AT=880.05n

.meas tran vdout1_48ck870 FIND v(dout1_48) AT=880.05n

.meas tran vdout1_49ck870 FIND v(dout1_49) AT=880.05n

.meas tran vdout1_50ck870 FIND v(dout1_50) AT=880.05n

.meas tran vdout1_51ck870 FIND v(dout1_51) AT=880.05n

.meas tran vdout1_52ck870 FIND v(dout1_52) AT=880.05n

.meas tran vdout1_53ck870 FIND v(dout1_53) AT=880.05n

.meas tran vdout1_54ck870 FIND v(dout1_54) AT=880.05n

.meas tran vdout1_55ck870 FIND v(dout1_55) AT=880.05n

.meas tran vdout1_56ck870 FIND v(dout1_56) AT=880.05n

.meas tran vdout1_57ck870 FIND v(dout1_57) AT=880.05n

.meas tran vdout1_58ck870 FIND v(dout1_58) AT=880.05n

.meas tran vdout1_59ck870 FIND v(dout1_59) AT=880.05n

.meas tran vdout1_60ck870 FIND v(dout1_60) AT=880.05n

.meas tran vdout1_61ck870 FIND v(dout1_61) AT=880.05n

.meas tran vdout1_62ck870 FIND v(dout1_62) AT=880.05n

.meas tran vdout1_63ck870 FIND v(dout1_63) AT=880.05n

.meas tran vdout1_64ck870 FIND v(dout1_64) AT=880.05n

.meas tran vdout1_65ck870 FIND v(dout1_65) AT=880.05n

.meas tran vdout1_66ck870 FIND v(dout1_66) AT=880.05n

.meas tran vdout1_67ck870 FIND v(dout1_67) AT=880.05n

.meas tran vdout1_68ck870 FIND v(dout1_68) AT=880.05n

.meas tran vdout1_69ck870 FIND v(dout1_69) AT=880.05n

.meas tran vdout1_70ck870 FIND v(dout1_70) AT=880.05n

.meas tran vdout1_71ck870 FIND v(dout1_71) AT=880.05n

.meas tran vdout1_72ck870 FIND v(dout1_72) AT=880.05n

.meas tran vdout1_73ck870 FIND v(dout1_73) AT=880.05n

.meas tran vdout1_74ck870 FIND v(dout1_74) AT=880.05n

.meas tran vdout1_75ck870 FIND v(dout1_75) AT=880.05n

.meas tran vdout1_76ck870 FIND v(dout1_76) AT=880.05n

.meas tran vdout1_77ck870 FIND v(dout1_77) AT=880.05n

.meas tran vdout1_78ck870 FIND v(dout1_78) AT=880.05n

.meas tran vdout1_79ck870 FIND v(dout1_79) AT=880.05n

.meas tran vdout1_80ck870 FIND v(dout1_80) AT=880.05n

.meas tran vdout1_81ck870 FIND v(dout1_81) AT=880.05n

.meas tran vdout1_82ck870 FIND v(dout1_82) AT=880.05n

.meas tran vdout1_83ck870 FIND v(dout1_83) AT=880.05n

.meas tran vdout1_84ck870 FIND v(dout1_84) AT=880.05n

.meas tran vdout1_85ck870 FIND v(dout1_85) AT=880.05n

.meas tran vdout1_86ck870 FIND v(dout1_86) AT=880.05n

.meas tran vdout1_87ck870 FIND v(dout1_87) AT=880.05n

.meas tran vdout1_88ck870 FIND v(dout1_88) AT=880.05n

.meas tran vdout1_89ck870 FIND v(dout1_89) AT=880.05n

.meas tran vdout1_90ck870 FIND v(dout1_90) AT=880.05n

.meas tran vdout1_91ck870 FIND v(dout1_91) AT=880.05n

.meas tran vdout1_92ck870 FIND v(dout1_92) AT=880.05n

.meas tran vdout1_93ck870 FIND v(dout1_93) AT=880.05n

.meas tran vdout1_94ck870 FIND v(dout1_94) AT=880.05n

.meas tran vdout1_95ck870 FIND v(dout1_95) AT=880.05n

.meas tran vdout1_96ck870 FIND v(dout1_96) AT=880.05n

.meas tran vdout1_97ck870 FIND v(dout1_97) AT=880.05n

.meas tran vdout1_98ck870 FIND v(dout1_98) AT=880.05n

.meas tran vdout1_99ck870 FIND v(dout1_99) AT=880.05n

.meas tran vdout1_100ck870 FIND v(dout1_100) AT=880.05n

.meas tran vdout1_101ck870 FIND v(dout1_101) AT=880.05n

.meas tran vdout1_102ck870 FIND v(dout1_102) AT=880.05n

.meas tran vdout1_103ck870 FIND v(dout1_103) AT=880.05n

.meas tran vdout1_104ck870 FIND v(dout1_104) AT=880.05n

.meas tran vdout1_105ck870 FIND v(dout1_105) AT=880.05n

.meas tran vdout1_106ck870 FIND v(dout1_106) AT=880.05n

.meas tran vdout1_107ck870 FIND v(dout1_107) AT=880.05n

.meas tran vdout1_108ck870 FIND v(dout1_108) AT=880.05n

.meas tran vdout1_109ck870 FIND v(dout1_109) AT=880.05n

.meas tran vdout1_110ck870 FIND v(dout1_110) AT=880.05n

.meas tran vdout1_111ck870 FIND v(dout1_111) AT=880.05n

.meas tran vdout1_112ck870 FIND v(dout1_112) AT=880.05n

.meas tran vdout1_113ck870 FIND v(dout1_113) AT=880.05n

.meas tran vdout1_114ck870 FIND v(dout1_114) AT=880.05n

.meas tran vdout1_115ck870 FIND v(dout1_115) AT=880.05n

.meas tran vdout1_116ck870 FIND v(dout1_116) AT=880.05n

.meas tran vdout1_117ck870 FIND v(dout1_117) AT=880.05n

.meas tran vdout1_118ck870 FIND v(dout1_118) AT=880.05n

.meas tran vdout1_119ck870 FIND v(dout1_119) AT=880.05n

.meas tran vdout1_120ck870 FIND v(dout1_120) AT=880.05n

.meas tran vdout1_121ck870 FIND v(dout1_121) AT=880.05n

.meas tran vdout1_122ck870 FIND v(dout1_122) AT=880.05n

.meas tran vdout1_123ck870 FIND v(dout1_123) AT=880.05n

.meas tran vdout1_124ck870 FIND v(dout1_124) AT=880.05n

.meas tran vdout1_125ck870 FIND v(dout1_125) AT=880.05n

.meas tran vdout1_126ck870 FIND v(dout1_126) AT=880.05n

.meas tran vdout1_127ck870 FIND v(dout1_127) AT=880.05n

.meas tran vdout1_128ck870 FIND v(dout1_128) AT=880.05n

.meas tran vdout1_129ck870 FIND v(dout1_129) AT=880.05n

.meas tran vdout1_130ck870 FIND v(dout1_130) AT=880.05n

.meas tran vdout1_131ck870 FIND v(dout1_131) AT=880.05n

.meas tran vdout1_132ck870 FIND v(dout1_132) AT=880.05n

.meas tran vdout1_133ck870 FIND v(dout1_133) AT=880.05n

.meas tran vdout1_134ck870 FIND v(dout1_134) AT=880.05n

.meas tran vdout1_0ck880 FIND v(dout1_0) AT=890.05n

.meas tran vdout1_1ck880 FIND v(dout1_1) AT=890.05n

.meas tran vdout1_2ck880 FIND v(dout1_2) AT=890.05n

.meas tran vdout1_3ck880 FIND v(dout1_3) AT=890.05n

.meas tran vdout1_4ck880 FIND v(dout1_4) AT=890.05n

.meas tran vdout1_5ck880 FIND v(dout1_5) AT=890.05n

.meas tran vdout1_6ck880 FIND v(dout1_6) AT=890.05n

.meas tran vdout1_7ck880 FIND v(dout1_7) AT=890.05n

.meas tran vdout1_8ck880 FIND v(dout1_8) AT=890.05n

.meas tran vdout1_9ck880 FIND v(dout1_9) AT=890.05n

.meas tran vdout1_10ck880 FIND v(dout1_10) AT=890.05n

.meas tran vdout1_11ck880 FIND v(dout1_11) AT=890.05n

.meas tran vdout1_12ck880 FIND v(dout1_12) AT=890.05n

.meas tran vdout1_13ck880 FIND v(dout1_13) AT=890.05n

.meas tran vdout1_14ck880 FIND v(dout1_14) AT=890.05n

.meas tran vdout1_15ck880 FIND v(dout1_15) AT=890.05n

.meas tran vdout1_16ck880 FIND v(dout1_16) AT=890.05n

.meas tran vdout1_17ck880 FIND v(dout1_17) AT=890.05n

.meas tran vdout1_18ck880 FIND v(dout1_18) AT=890.05n

.meas tran vdout1_19ck880 FIND v(dout1_19) AT=890.05n

.meas tran vdout1_20ck880 FIND v(dout1_20) AT=890.05n

.meas tran vdout1_21ck880 FIND v(dout1_21) AT=890.05n

.meas tran vdout1_22ck880 FIND v(dout1_22) AT=890.05n

.meas tran vdout1_23ck880 FIND v(dout1_23) AT=890.05n

.meas tran vdout1_24ck880 FIND v(dout1_24) AT=890.05n

.meas tran vdout1_25ck880 FIND v(dout1_25) AT=890.05n

.meas tran vdout1_26ck880 FIND v(dout1_26) AT=890.05n

.meas tran vdout1_27ck880 FIND v(dout1_27) AT=890.05n

.meas tran vdout1_28ck880 FIND v(dout1_28) AT=890.05n

.meas tran vdout1_29ck880 FIND v(dout1_29) AT=890.05n

.meas tran vdout1_30ck880 FIND v(dout1_30) AT=890.05n

.meas tran vdout1_31ck880 FIND v(dout1_31) AT=890.05n

.meas tran vdout1_32ck880 FIND v(dout1_32) AT=890.05n

.meas tran vdout1_33ck880 FIND v(dout1_33) AT=890.05n

.meas tran vdout1_34ck880 FIND v(dout1_34) AT=890.05n

.meas tran vdout1_35ck880 FIND v(dout1_35) AT=890.05n

.meas tran vdout1_36ck880 FIND v(dout1_36) AT=890.05n

.meas tran vdout1_37ck880 FIND v(dout1_37) AT=890.05n

.meas tran vdout1_38ck880 FIND v(dout1_38) AT=890.05n

.meas tran vdout1_39ck880 FIND v(dout1_39) AT=890.05n

.meas tran vdout1_40ck880 FIND v(dout1_40) AT=890.05n

.meas tran vdout1_41ck880 FIND v(dout1_41) AT=890.05n

.meas tran vdout1_42ck880 FIND v(dout1_42) AT=890.05n

.meas tran vdout1_43ck880 FIND v(dout1_43) AT=890.05n

.meas tran vdout1_44ck880 FIND v(dout1_44) AT=890.05n

.meas tran vdout1_45ck880 FIND v(dout1_45) AT=890.05n

.meas tran vdout1_46ck880 FIND v(dout1_46) AT=890.05n

.meas tran vdout1_47ck880 FIND v(dout1_47) AT=890.05n

.meas tran vdout1_48ck880 FIND v(dout1_48) AT=890.05n

.meas tran vdout1_49ck880 FIND v(dout1_49) AT=890.05n

.meas tran vdout1_50ck880 FIND v(dout1_50) AT=890.05n

.meas tran vdout1_51ck880 FIND v(dout1_51) AT=890.05n

.meas tran vdout1_52ck880 FIND v(dout1_52) AT=890.05n

.meas tran vdout1_53ck880 FIND v(dout1_53) AT=890.05n

.meas tran vdout1_54ck880 FIND v(dout1_54) AT=890.05n

.meas tran vdout1_55ck880 FIND v(dout1_55) AT=890.05n

.meas tran vdout1_56ck880 FIND v(dout1_56) AT=890.05n

.meas tran vdout1_57ck880 FIND v(dout1_57) AT=890.05n

.meas tran vdout1_58ck880 FIND v(dout1_58) AT=890.05n

.meas tran vdout1_59ck880 FIND v(dout1_59) AT=890.05n

.meas tran vdout1_60ck880 FIND v(dout1_60) AT=890.05n

.meas tran vdout1_61ck880 FIND v(dout1_61) AT=890.05n

.meas tran vdout1_62ck880 FIND v(dout1_62) AT=890.05n

.meas tran vdout1_63ck880 FIND v(dout1_63) AT=890.05n

.meas tran vdout1_64ck880 FIND v(dout1_64) AT=890.05n

.meas tran vdout1_65ck880 FIND v(dout1_65) AT=890.05n

.meas tran vdout1_66ck880 FIND v(dout1_66) AT=890.05n

.meas tran vdout1_67ck880 FIND v(dout1_67) AT=890.05n

.meas tran vdout1_68ck880 FIND v(dout1_68) AT=890.05n

.meas tran vdout1_69ck880 FIND v(dout1_69) AT=890.05n

.meas tran vdout1_70ck880 FIND v(dout1_70) AT=890.05n

.meas tran vdout1_71ck880 FIND v(dout1_71) AT=890.05n

.meas tran vdout1_72ck880 FIND v(dout1_72) AT=890.05n

.meas tran vdout1_73ck880 FIND v(dout1_73) AT=890.05n

.meas tran vdout1_74ck880 FIND v(dout1_74) AT=890.05n

.meas tran vdout1_75ck880 FIND v(dout1_75) AT=890.05n

.meas tran vdout1_76ck880 FIND v(dout1_76) AT=890.05n

.meas tran vdout1_77ck880 FIND v(dout1_77) AT=890.05n

.meas tran vdout1_78ck880 FIND v(dout1_78) AT=890.05n

.meas tran vdout1_79ck880 FIND v(dout1_79) AT=890.05n

.meas tran vdout1_80ck880 FIND v(dout1_80) AT=890.05n

.meas tran vdout1_81ck880 FIND v(dout1_81) AT=890.05n

.meas tran vdout1_82ck880 FIND v(dout1_82) AT=890.05n

.meas tran vdout1_83ck880 FIND v(dout1_83) AT=890.05n

.meas tran vdout1_84ck880 FIND v(dout1_84) AT=890.05n

.meas tran vdout1_85ck880 FIND v(dout1_85) AT=890.05n

.meas tran vdout1_86ck880 FIND v(dout1_86) AT=890.05n

.meas tran vdout1_87ck880 FIND v(dout1_87) AT=890.05n

.meas tran vdout1_88ck880 FIND v(dout1_88) AT=890.05n

.meas tran vdout1_89ck880 FIND v(dout1_89) AT=890.05n

.meas tran vdout1_90ck880 FIND v(dout1_90) AT=890.05n

.meas tran vdout1_91ck880 FIND v(dout1_91) AT=890.05n

.meas tran vdout1_92ck880 FIND v(dout1_92) AT=890.05n

.meas tran vdout1_93ck880 FIND v(dout1_93) AT=890.05n

.meas tran vdout1_94ck880 FIND v(dout1_94) AT=890.05n

.meas tran vdout1_95ck880 FIND v(dout1_95) AT=890.05n

.meas tran vdout1_96ck880 FIND v(dout1_96) AT=890.05n

.meas tran vdout1_97ck880 FIND v(dout1_97) AT=890.05n

.meas tran vdout1_98ck880 FIND v(dout1_98) AT=890.05n

.meas tran vdout1_99ck880 FIND v(dout1_99) AT=890.05n

.meas tran vdout1_100ck880 FIND v(dout1_100) AT=890.05n

.meas tran vdout1_101ck880 FIND v(dout1_101) AT=890.05n

.meas tran vdout1_102ck880 FIND v(dout1_102) AT=890.05n

.meas tran vdout1_103ck880 FIND v(dout1_103) AT=890.05n

.meas tran vdout1_104ck880 FIND v(dout1_104) AT=890.05n

.meas tran vdout1_105ck880 FIND v(dout1_105) AT=890.05n

.meas tran vdout1_106ck880 FIND v(dout1_106) AT=890.05n

.meas tran vdout1_107ck880 FIND v(dout1_107) AT=890.05n

.meas tran vdout1_108ck880 FIND v(dout1_108) AT=890.05n

.meas tran vdout1_109ck880 FIND v(dout1_109) AT=890.05n

.meas tran vdout1_110ck880 FIND v(dout1_110) AT=890.05n

.meas tran vdout1_111ck880 FIND v(dout1_111) AT=890.05n

.meas tran vdout1_112ck880 FIND v(dout1_112) AT=890.05n

.meas tran vdout1_113ck880 FIND v(dout1_113) AT=890.05n

.meas tran vdout1_114ck880 FIND v(dout1_114) AT=890.05n

.meas tran vdout1_115ck880 FIND v(dout1_115) AT=890.05n

.meas tran vdout1_116ck880 FIND v(dout1_116) AT=890.05n

.meas tran vdout1_117ck880 FIND v(dout1_117) AT=890.05n

.meas tran vdout1_118ck880 FIND v(dout1_118) AT=890.05n

.meas tran vdout1_119ck880 FIND v(dout1_119) AT=890.05n

.meas tran vdout1_120ck880 FIND v(dout1_120) AT=890.05n

.meas tran vdout1_121ck880 FIND v(dout1_121) AT=890.05n

.meas tran vdout1_122ck880 FIND v(dout1_122) AT=890.05n

.meas tran vdout1_123ck880 FIND v(dout1_123) AT=890.05n

.meas tran vdout1_124ck880 FIND v(dout1_124) AT=890.05n

.meas tran vdout1_125ck880 FIND v(dout1_125) AT=890.05n

.meas tran vdout1_126ck880 FIND v(dout1_126) AT=890.05n

.meas tran vdout1_127ck880 FIND v(dout1_127) AT=890.05n

.meas tran vdout1_128ck880 FIND v(dout1_128) AT=890.05n

.meas tran vdout1_129ck880 FIND v(dout1_129) AT=890.05n

.meas tran vdout1_130ck880 FIND v(dout1_130) AT=890.05n

.meas tran vdout1_131ck880 FIND v(dout1_131) AT=890.05n

.meas tran vdout1_132ck880 FIND v(dout1_132) AT=890.05n

.meas tran vdout1_133ck880 FIND v(dout1_133) AT=890.05n

.meas tran vdout1_134ck880 FIND v(dout1_134) AT=890.05n

.meas tran vdout1_0ck890 FIND v(dout1_0) AT=900.05n

.meas tran vdout1_1ck890 FIND v(dout1_1) AT=900.05n

.meas tran vdout1_2ck890 FIND v(dout1_2) AT=900.05n

.meas tran vdout1_3ck890 FIND v(dout1_3) AT=900.05n

.meas tran vdout1_4ck890 FIND v(dout1_4) AT=900.05n

.meas tran vdout1_5ck890 FIND v(dout1_5) AT=900.05n

.meas tran vdout1_6ck890 FIND v(dout1_6) AT=900.05n

.meas tran vdout1_7ck890 FIND v(dout1_7) AT=900.05n

.meas tran vdout1_8ck890 FIND v(dout1_8) AT=900.05n

.meas tran vdout1_9ck890 FIND v(dout1_9) AT=900.05n

.meas tran vdout1_10ck890 FIND v(dout1_10) AT=900.05n

.meas tran vdout1_11ck890 FIND v(dout1_11) AT=900.05n

.meas tran vdout1_12ck890 FIND v(dout1_12) AT=900.05n

.meas tran vdout1_13ck890 FIND v(dout1_13) AT=900.05n

.meas tran vdout1_14ck890 FIND v(dout1_14) AT=900.05n

.meas tran vdout1_15ck890 FIND v(dout1_15) AT=900.05n

.meas tran vdout1_16ck890 FIND v(dout1_16) AT=900.05n

.meas tran vdout1_17ck890 FIND v(dout1_17) AT=900.05n

.meas tran vdout1_18ck890 FIND v(dout1_18) AT=900.05n

.meas tran vdout1_19ck890 FIND v(dout1_19) AT=900.05n

.meas tran vdout1_20ck890 FIND v(dout1_20) AT=900.05n

.meas tran vdout1_21ck890 FIND v(dout1_21) AT=900.05n

.meas tran vdout1_22ck890 FIND v(dout1_22) AT=900.05n

.meas tran vdout1_23ck890 FIND v(dout1_23) AT=900.05n

.meas tran vdout1_24ck890 FIND v(dout1_24) AT=900.05n

.meas tran vdout1_25ck890 FIND v(dout1_25) AT=900.05n

.meas tran vdout1_26ck890 FIND v(dout1_26) AT=900.05n

.meas tran vdout1_27ck890 FIND v(dout1_27) AT=900.05n

.meas tran vdout1_28ck890 FIND v(dout1_28) AT=900.05n

.meas tran vdout1_29ck890 FIND v(dout1_29) AT=900.05n

.meas tran vdout1_30ck890 FIND v(dout1_30) AT=900.05n

.meas tran vdout1_31ck890 FIND v(dout1_31) AT=900.05n

.meas tran vdout1_32ck890 FIND v(dout1_32) AT=900.05n

.meas tran vdout1_33ck890 FIND v(dout1_33) AT=900.05n

.meas tran vdout1_34ck890 FIND v(dout1_34) AT=900.05n

.meas tran vdout1_35ck890 FIND v(dout1_35) AT=900.05n

.meas tran vdout1_36ck890 FIND v(dout1_36) AT=900.05n

.meas tran vdout1_37ck890 FIND v(dout1_37) AT=900.05n

.meas tran vdout1_38ck890 FIND v(dout1_38) AT=900.05n

.meas tran vdout1_39ck890 FIND v(dout1_39) AT=900.05n

.meas tran vdout1_40ck890 FIND v(dout1_40) AT=900.05n

.meas tran vdout1_41ck890 FIND v(dout1_41) AT=900.05n

.meas tran vdout1_42ck890 FIND v(dout1_42) AT=900.05n

.meas tran vdout1_43ck890 FIND v(dout1_43) AT=900.05n

.meas tran vdout1_44ck890 FIND v(dout1_44) AT=900.05n

.meas tran vdout1_45ck890 FIND v(dout1_45) AT=900.05n

.meas tran vdout1_46ck890 FIND v(dout1_46) AT=900.05n

.meas tran vdout1_47ck890 FIND v(dout1_47) AT=900.05n

.meas tran vdout1_48ck890 FIND v(dout1_48) AT=900.05n

.meas tran vdout1_49ck890 FIND v(dout1_49) AT=900.05n

.meas tran vdout1_50ck890 FIND v(dout1_50) AT=900.05n

.meas tran vdout1_51ck890 FIND v(dout1_51) AT=900.05n

.meas tran vdout1_52ck890 FIND v(dout1_52) AT=900.05n

.meas tran vdout1_53ck890 FIND v(dout1_53) AT=900.05n

.meas tran vdout1_54ck890 FIND v(dout1_54) AT=900.05n

.meas tran vdout1_55ck890 FIND v(dout1_55) AT=900.05n

.meas tran vdout1_56ck890 FIND v(dout1_56) AT=900.05n

.meas tran vdout1_57ck890 FIND v(dout1_57) AT=900.05n

.meas tran vdout1_58ck890 FIND v(dout1_58) AT=900.05n

.meas tran vdout1_59ck890 FIND v(dout1_59) AT=900.05n

.meas tran vdout1_60ck890 FIND v(dout1_60) AT=900.05n

.meas tran vdout1_61ck890 FIND v(dout1_61) AT=900.05n

.meas tran vdout1_62ck890 FIND v(dout1_62) AT=900.05n

.meas tran vdout1_63ck890 FIND v(dout1_63) AT=900.05n

.meas tran vdout1_64ck890 FIND v(dout1_64) AT=900.05n

.meas tran vdout1_65ck890 FIND v(dout1_65) AT=900.05n

.meas tran vdout1_66ck890 FIND v(dout1_66) AT=900.05n

.meas tran vdout1_67ck890 FIND v(dout1_67) AT=900.05n

.meas tran vdout1_68ck890 FIND v(dout1_68) AT=900.05n

.meas tran vdout1_69ck890 FIND v(dout1_69) AT=900.05n

.meas tran vdout1_70ck890 FIND v(dout1_70) AT=900.05n

.meas tran vdout1_71ck890 FIND v(dout1_71) AT=900.05n

.meas tran vdout1_72ck890 FIND v(dout1_72) AT=900.05n

.meas tran vdout1_73ck890 FIND v(dout1_73) AT=900.05n

.meas tran vdout1_74ck890 FIND v(dout1_74) AT=900.05n

.meas tran vdout1_75ck890 FIND v(dout1_75) AT=900.05n

.meas tran vdout1_76ck890 FIND v(dout1_76) AT=900.05n

.meas tran vdout1_77ck890 FIND v(dout1_77) AT=900.05n

.meas tran vdout1_78ck890 FIND v(dout1_78) AT=900.05n

.meas tran vdout1_79ck890 FIND v(dout1_79) AT=900.05n

.meas tran vdout1_80ck890 FIND v(dout1_80) AT=900.05n

.meas tran vdout1_81ck890 FIND v(dout1_81) AT=900.05n

.meas tran vdout1_82ck890 FIND v(dout1_82) AT=900.05n

.meas tran vdout1_83ck890 FIND v(dout1_83) AT=900.05n

.meas tran vdout1_84ck890 FIND v(dout1_84) AT=900.05n

.meas tran vdout1_85ck890 FIND v(dout1_85) AT=900.05n

.meas tran vdout1_86ck890 FIND v(dout1_86) AT=900.05n

.meas tran vdout1_87ck890 FIND v(dout1_87) AT=900.05n

.meas tran vdout1_88ck890 FIND v(dout1_88) AT=900.05n

.meas tran vdout1_89ck890 FIND v(dout1_89) AT=900.05n

.meas tran vdout1_90ck890 FIND v(dout1_90) AT=900.05n

.meas tran vdout1_91ck890 FIND v(dout1_91) AT=900.05n

.meas tran vdout1_92ck890 FIND v(dout1_92) AT=900.05n

.meas tran vdout1_93ck890 FIND v(dout1_93) AT=900.05n

.meas tran vdout1_94ck890 FIND v(dout1_94) AT=900.05n

.meas tran vdout1_95ck890 FIND v(dout1_95) AT=900.05n

.meas tran vdout1_96ck890 FIND v(dout1_96) AT=900.05n

.meas tran vdout1_97ck890 FIND v(dout1_97) AT=900.05n

.meas tran vdout1_98ck890 FIND v(dout1_98) AT=900.05n

.meas tran vdout1_99ck890 FIND v(dout1_99) AT=900.05n

.meas tran vdout1_100ck890 FIND v(dout1_100) AT=900.05n

.meas tran vdout1_101ck890 FIND v(dout1_101) AT=900.05n

.meas tran vdout1_102ck890 FIND v(dout1_102) AT=900.05n

.meas tran vdout1_103ck890 FIND v(dout1_103) AT=900.05n

.meas tran vdout1_104ck890 FIND v(dout1_104) AT=900.05n

.meas tran vdout1_105ck890 FIND v(dout1_105) AT=900.05n

.meas tran vdout1_106ck890 FIND v(dout1_106) AT=900.05n

.meas tran vdout1_107ck890 FIND v(dout1_107) AT=900.05n

.meas tran vdout1_108ck890 FIND v(dout1_108) AT=900.05n

.meas tran vdout1_109ck890 FIND v(dout1_109) AT=900.05n

.meas tran vdout1_110ck890 FIND v(dout1_110) AT=900.05n

.meas tran vdout1_111ck890 FIND v(dout1_111) AT=900.05n

.meas tran vdout1_112ck890 FIND v(dout1_112) AT=900.05n

.meas tran vdout1_113ck890 FIND v(dout1_113) AT=900.05n

.meas tran vdout1_114ck890 FIND v(dout1_114) AT=900.05n

.meas tran vdout1_115ck890 FIND v(dout1_115) AT=900.05n

.meas tran vdout1_116ck890 FIND v(dout1_116) AT=900.05n

.meas tran vdout1_117ck890 FIND v(dout1_117) AT=900.05n

.meas tran vdout1_118ck890 FIND v(dout1_118) AT=900.05n

.meas tran vdout1_119ck890 FIND v(dout1_119) AT=900.05n

.meas tran vdout1_120ck890 FIND v(dout1_120) AT=900.05n

.meas tran vdout1_121ck890 FIND v(dout1_121) AT=900.05n

.meas tran vdout1_122ck890 FIND v(dout1_122) AT=900.05n

.meas tran vdout1_123ck890 FIND v(dout1_123) AT=900.05n

.meas tran vdout1_124ck890 FIND v(dout1_124) AT=900.05n

.meas tran vdout1_125ck890 FIND v(dout1_125) AT=900.05n

.meas tran vdout1_126ck890 FIND v(dout1_126) AT=900.05n

.meas tran vdout1_127ck890 FIND v(dout1_127) AT=900.05n

.meas tran vdout1_128ck890 FIND v(dout1_128) AT=900.05n

.meas tran vdout1_129ck890 FIND v(dout1_129) AT=900.05n

.meas tran vdout1_130ck890 FIND v(dout1_130) AT=900.05n

.meas tran vdout1_131ck890 FIND v(dout1_131) AT=900.05n

.meas tran vdout1_132ck890 FIND v(dout1_132) AT=900.05n

.meas tran vdout1_133ck890 FIND v(dout1_133) AT=900.05n

.meas tran vdout1_134ck890 FIND v(dout1_134) AT=900.05n

.meas tran vdout1_0ck930 FIND v(dout1_0) AT=940.05n

.meas tran vdout1_1ck930 FIND v(dout1_1) AT=940.05n

.meas tran vdout1_2ck930 FIND v(dout1_2) AT=940.05n

.meas tran vdout1_3ck930 FIND v(dout1_3) AT=940.05n

.meas tran vdout1_4ck930 FIND v(dout1_4) AT=940.05n

.meas tran vdout1_5ck930 FIND v(dout1_5) AT=940.05n

.meas tran vdout1_6ck930 FIND v(dout1_6) AT=940.05n

.meas tran vdout1_7ck930 FIND v(dout1_7) AT=940.05n

.meas tran vdout1_8ck930 FIND v(dout1_8) AT=940.05n

.meas tran vdout1_9ck930 FIND v(dout1_9) AT=940.05n

.meas tran vdout1_10ck930 FIND v(dout1_10) AT=940.05n

.meas tran vdout1_11ck930 FIND v(dout1_11) AT=940.05n

.meas tran vdout1_12ck930 FIND v(dout1_12) AT=940.05n

.meas tran vdout1_13ck930 FIND v(dout1_13) AT=940.05n

.meas tran vdout1_14ck930 FIND v(dout1_14) AT=940.05n

.meas tran vdout1_15ck930 FIND v(dout1_15) AT=940.05n

.meas tran vdout1_16ck930 FIND v(dout1_16) AT=940.05n

.meas tran vdout1_17ck930 FIND v(dout1_17) AT=940.05n

.meas tran vdout1_18ck930 FIND v(dout1_18) AT=940.05n

.meas tran vdout1_19ck930 FIND v(dout1_19) AT=940.05n

.meas tran vdout1_20ck930 FIND v(dout1_20) AT=940.05n

.meas tran vdout1_21ck930 FIND v(dout1_21) AT=940.05n

.meas tran vdout1_22ck930 FIND v(dout1_22) AT=940.05n

.meas tran vdout1_23ck930 FIND v(dout1_23) AT=940.05n

.meas tran vdout1_24ck930 FIND v(dout1_24) AT=940.05n

.meas tran vdout1_25ck930 FIND v(dout1_25) AT=940.05n

.meas tran vdout1_26ck930 FIND v(dout1_26) AT=940.05n

.meas tran vdout1_27ck930 FIND v(dout1_27) AT=940.05n

.meas tran vdout1_28ck930 FIND v(dout1_28) AT=940.05n

.meas tran vdout1_29ck930 FIND v(dout1_29) AT=940.05n

.meas tran vdout1_30ck930 FIND v(dout1_30) AT=940.05n

.meas tran vdout1_31ck930 FIND v(dout1_31) AT=940.05n

.meas tran vdout1_32ck930 FIND v(dout1_32) AT=940.05n

.meas tran vdout1_33ck930 FIND v(dout1_33) AT=940.05n

.meas tran vdout1_34ck930 FIND v(dout1_34) AT=940.05n

.meas tran vdout1_35ck930 FIND v(dout1_35) AT=940.05n

.meas tran vdout1_36ck930 FIND v(dout1_36) AT=940.05n

.meas tran vdout1_37ck930 FIND v(dout1_37) AT=940.05n

.meas tran vdout1_38ck930 FIND v(dout1_38) AT=940.05n

.meas tran vdout1_39ck930 FIND v(dout1_39) AT=940.05n

.meas tran vdout1_40ck930 FIND v(dout1_40) AT=940.05n

.meas tran vdout1_41ck930 FIND v(dout1_41) AT=940.05n

.meas tran vdout1_42ck930 FIND v(dout1_42) AT=940.05n

.meas tran vdout1_43ck930 FIND v(dout1_43) AT=940.05n

.meas tran vdout1_44ck930 FIND v(dout1_44) AT=940.05n

.meas tran vdout1_45ck930 FIND v(dout1_45) AT=940.05n

.meas tran vdout1_46ck930 FIND v(dout1_46) AT=940.05n

.meas tran vdout1_47ck930 FIND v(dout1_47) AT=940.05n

.meas tran vdout1_48ck930 FIND v(dout1_48) AT=940.05n

.meas tran vdout1_49ck930 FIND v(dout1_49) AT=940.05n

.meas tran vdout1_50ck930 FIND v(dout1_50) AT=940.05n

.meas tran vdout1_51ck930 FIND v(dout1_51) AT=940.05n

.meas tran vdout1_52ck930 FIND v(dout1_52) AT=940.05n

.meas tran vdout1_53ck930 FIND v(dout1_53) AT=940.05n

.meas tran vdout1_54ck930 FIND v(dout1_54) AT=940.05n

.meas tran vdout1_55ck930 FIND v(dout1_55) AT=940.05n

.meas tran vdout1_56ck930 FIND v(dout1_56) AT=940.05n

.meas tran vdout1_57ck930 FIND v(dout1_57) AT=940.05n

.meas tran vdout1_58ck930 FIND v(dout1_58) AT=940.05n

.meas tran vdout1_59ck930 FIND v(dout1_59) AT=940.05n

.meas tran vdout1_60ck930 FIND v(dout1_60) AT=940.05n

.meas tran vdout1_61ck930 FIND v(dout1_61) AT=940.05n

.meas tran vdout1_62ck930 FIND v(dout1_62) AT=940.05n

.meas tran vdout1_63ck930 FIND v(dout1_63) AT=940.05n

.meas tran vdout1_64ck930 FIND v(dout1_64) AT=940.05n

.meas tran vdout1_65ck930 FIND v(dout1_65) AT=940.05n

.meas tran vdout1_66ck930 FIND v(dout1_66) AT=940.05n

.meas tran vdout1_67ck930 FIND v(dout1_67) AT=940.05n

.meas tran vdout1_68ck930 FIND v(dout1_68) AT=940.05n

.meas tran vdout1_69ck930 FIND v(dout1_69) AT=940.05n

.meas tran vdout1_70ck930 FIND v(dout1_70) AT=940.05n

.meas tran vdout1_71ck930 FIND v(dout1_71) AT=940.05n

.meas tran vdout1_72ck930 FIND v(dout1_72) AT=940.05n

.meas tran vdout1_73ck930 FIND v(dout1_73) AT=940.05n

.meas tran vdout1_74ck930 FIND v(dout1_74) AT=940.05n

.meas tran vdout1_75ck930 FIND v(dout1_75) AT=940.05n

.meas tran vdout1_76ck930 FIND v(dout1_76) AT=940.05n

.meas tran vdout1_77ck930 FIND v(dout1_77) AT=940.05n

.meas tran vdout1_78ck930 FIND v(dout1_78) AT=940.05n

.meas tran vdout1_79ck930 FIND v(dout1_79) AT=940.05n

.meas tran vdout1_80ck930 FIND v(dout1_80) AT=940.05n

.meas tran vdout1_81ck930 FIND v(dout1_81) AT=940.05n

.meas tran vdout1_82ck930 FIND v(dout1_82) AT=940.05n

.meas tran vdout1_83ck930 FIND v(dout1_83) AT=940.05n

.meas tran vdout1_84ck930 FIND v(dout1_84) AT=940.05n

.meas tran vdout1_85ck930 FIND v(dout1_85) AT=940.05n

.meas tran vdout1_86ck930 FIND v(dout1_86) AT=940.05n

.meas tran vdout1_87ck930 FIND v(dout1_87) AT=940.05n

.meas tran vdout1_88ck930 FIND v(dout1_88) AT=940.05n

.meas tran vdout1_89ck930 FIND v(dout1_89) AT=940.05n

.meas tran vdout1_90ck930 FIND v(dout1_90) AT=940.05n

.meas tran vdout1_91ck930 FIND v(dout1_91) AT=940.05n

.meas tran vdout1_92ck930 FIND v(dout1_92) AT=940.05n

.meas tran vdout1_93ck930 FIND v(dout1_93) AT=940.05n

.meas tran vdout1_94ck930 FIND v(dout1_94) AT=940.05n

.meas tran vdout1_95ck930 FIND v(dout1_95) AT=940.05n

.meas tran vdout1_96ck930 FIND v(dout1_96) AT=940.05n

.meas tran vdout1_97ck930 FIND v(dout1_97) AT=940.05n

.meas tran vdout1_98ck930 FIND v(dout1_98) AT=940.05n

.meas tran vdout1_99ck930 FIND v(dout1_99) AT=940.05n

.meas tran vdout1_100ck930 FIND v(dout1_100) AT=940.05n

.meas tran vdout1_101ck930 FIND v(dout1_101) AT=940.05n

.meas tran vdout1_102ck930 FIND v(dout1_102) AT=940.05n

.meas tran vdout1_103ck930 FIND v(dout1_103) AT=940.05n

.meas tran vdout1_104ck930 FIND v(dout1_104) AT=940.05n

.meas tran vdout1_105ck930 FIND v(dout1_105) AT=940.05n

.meas tran vdout1_106ck930 FIND v(dout1_106) AT=940.05n

.meas tran vdout1_107ck930 FIND v(dout1_107) AT=940.05n

.meas tran vdout1_108ck930 FIND v(dout1_108) AT=940.05n

.meas tran vdout1_109ck930 FIND v(dout1_109) AT=940.05n

.meas tran vdout1_110ck930 FIND v(dout1_110) AT=940.05n

.meas tran vdout1_111ck930 FIND v(dout1_111) AT=940.05n

.meas tran vdout1_112ck930 FIND v(dout1_112) AT=940.05n

.meas tran vdout1_113ck930 FIND v(dout1_113) AT=940.05n

.meas tran vdout1_114ck930 FIND v(dout1_114) AT=940.05n

.meas tran vdout1_115ck930 FIND v(dout1_115) AT=940.05n

.meas tran vdout1_116ck930 FIND v(dout1_116) AT=940.05n

.meas tran vdout1_117ck930 FIND v(dout1_117) AT=940.05n

.meas tran vdout1_118ck930 FIND v(dout1_118) AT=940.05n

.meas tran vdout1_119ck930 FIND v(dout1_119) AT=940.05n

.meas tran vdout1_120ck930 FIND v(dout1_120) AT=940.05n

.meas tran vdout1_121ck930 FIND v(dout1_121) AT=940.05n

.meas tran vdout1_122ck930 FIND v(dout1_122) AT=940.05n

.meas tran vdout1_123ck930 FIND v(dout1_123) AT=940.05n

.meas tran vdout1_124ck930 FIND v(dout1_124) AT=940.05n

.meas tran vdout1_125ck930 FIND v(dout1_125) AT=940.05n

.meas tran vdout1_126ck930 FIND v(dout1_126) AT=940.05n

.meas tran vdout1_127ck930 FIND v(dout1_127) AT=940.05n

.meas tran vdout1_128ck930 FIND v(dout1_128) AT=940.05n

.meas tran vdout1_129ck930 FIND v(dout1_129) AT=940.05n

.meas tran vdout1_130ck930 FIND v(dout1_130) AT=940.05n

.meas tran vdout1_131ck930 FIND v(dout1_131) AT=940.05n

.meas tran vdout1_132ck930 FIND v(dout1_132) AT=940.05n

.meas tran vdout1_133ck930 FIND v(dout1_133) AT=940.05n

.meas tran vdout1_134ck930 FIND v(dout1_134) AT=940.05n

.meas tran vdout1_0ck940 FIND v(dout1_0) AT=950.05n

.meas tran vdout1_1ck940 FIND v(dout1_1) AT=950.05n

.meas tran vdout1_2ck940 FIND v(dout1_2) AT=950.05n

.meas tran vdout1_3ck940 FIND v(dout1_3) AT=950.05n

.meas tran vdout1_4ck940 FIND v(dout1_4) AT=950.05n

.meas tran vdout1_5ck940 FIND v(dout1_5) AT=950.05n

.meas tran vdout1_6ck940 FIND v(dout1_6) AT=950.05n

.meas tran vdout1_7ck940 FIND v(dout1_7) AT=950.05n

.meas tran vdout1_8ck940 FIND v(dout1_8) AT=950.05n

.meas tran vdout1_9ck940 FIND v(dout1_9) AT=950.05n

.meas tran vdout1_10ck940 FIND v(dout1_10) AT=950.05n

.meas tran vdout1_11ck940 FIND v(dout1_11) AT=950.05n

.meas tran vdout1_12ck940 FIND v(dout1_12) AT=950.05n

.meas tran vdout1_13ck940 FIND v(dout1_13) AT=950.05n

.meas tran vdout1_14ck940 FIND v(dout1_14) AT=950.05n

.meas tran vdout1_15ck940 FIND v(dout1_15) AT=950.05n

.meas tran vdout1_16ck940 FIND v(dout1_16) AT=950.05n

.meas tran vdout1_17ck940 FIND v(dout1_17) AT=950.05n

.meas tran vdout1_18ck940 FIND v(dout1_18) AT=950.05n

.meas tran vdout1_19ck940 FIND v(dout1_19) AT=950.05n

.meas tran vdout1_20ck940 FIND v(dout1_20) AT=950.05n

.meas tran vdout1_21ck940 FIND v(dout1_21) AT=950.05n

.meas tran vdout1_22ck940 FIND v(dout1_22) AT=950.05n

.meas tran vdout1_23ck940 FIND v(dout1_23) AT=950.05n

.meas tran vdout1_24ck940 FIND v(dout1_24) AT=950.05n

.meas tran vdout1_25ck940 FIND v(dout1_25) AT=950.05n

.meas tran vdout1_26ck940 FIND v(dout1_26) AT=950.05n

.meas tran vdout1_27ck940 FIND v(dout1_27) AT=950.05n

.meas tran vdout1_28ck940 FIND v(dout1_28) AT=950.05n

.meas tran vdout1_29ck940 FIND v(dout1_29) AT=950.05n

.meas tran vdout1_30ck940 FIND v(dout1_30) AT=950.05n

.meas tran vdout1_31ck940 FIND v(dout1_31) AT=950.05n

.meas tran vdout1_32ck940 FIND v(dout1_32) AT=950.05n

.meas tran vdout1_33ck940 FIND v(dout1_33) AT=950.05n

.meas tran vdout1_34ck940 FIND v(dout1_34) AT=950.05n

.meas tran vdout1_35ck940 FIND v(dout1_35) AT=950.05n

.meas tran vdout1_36ck940 FIND v(dout1_36) AT=950.05n

.meas tran vdout1_37ck940 FIND v(dout1_37) AT=950.05n

.meas tran vdout1_38ck940 FIND v(dout1_38) AT=950.05n

.meas tran vdout1_39ck940 FIND v(dout1_39) AT=950.05n

.meas tran vdout1_40ck940 FIND v(dout1_40) AT=950.05n

.meas tran vdout1_41ck940 FIND v(dout1_41) AT=950.05n

.meas tran vdout1_42ck940 FIND v(dout1_42) AT=950.05n

.meas tran vdout1_43ck940 FIND v(dout1_43) AT=950.05n

.meas tran vdout1_44ck940 FIND v(dout1_44) AT=950.05n

.meas tran vdout1_45ck940 FIND v(dout1_45) AT=950.05n

.meas tran vdout1_46ck940 FIND v(dout1_46) AT=950.05n

.meas tran vdout1_47ck940 FIND v(dout1_47) AT=950.05n

.meas tran vdout1_48ck940 FIND v(dout1_48) AT=950.05n

.meas tran vdout1_49ck940 FIND v(dout1_49) AT=950.05n

.meas tran vdout1_50ck940 FIND v(dout1_50) AT=950.05n

.meas tran vdout1_51ck940 FIND v(dout1_51) AT=950.05n

.meas tran vdout1_52ck940 FIND v(dout1_52) AT=950.05n

.meas tran vdout1_53ck940 FIND v(dout1_53) AT=950.05n

.meas tran vdout1_54ck940 FIND v(dout1_54) AT=950.05n

.meas tran vdout1_55ck940 FIND v(dout1_55) AT=950.05n

.meas tran vdout1_56ck940 FIND v(dout1_56) AT=950.05n

.meas tran vdout1_57ck940 FIND v(dout1_57) AT=950.05n

.meas tran vdout1_58ck940 FIND v(dout1_58) AT=950.05n

.meas tran vdout1_59ck940 FIND v(dout1_59) AT=950.05n

.meas tran vdout1_60ck940 FIND v(dout1_60) AT=950.05n

.meas tran vdout1_61ck940 FIND v(dout1_61) AT=950.05n

.meas tran vdout1_62ck940 FIND v(dout1_62) AT=950.05n

.meas tran vdout1_63ck940 FIND v(dout1_63) AT=950.05n

.meas tran vdout1_64ck940 FIND v(dout1_64) AT=950.05n

.meas tran vdout1_65ck940 FIND v(dout1_65) AT=950.05n

.meas tran vdout1_66ck940 FIND v(dout1_66) AT=950.05n

.meas tran vdout1_67ck940 FIND v(dout1_67) AT=950.05n

.meas tran vdout1_68ck940 FIND v(dout1_68) AT=950.05n

.meas tran vdout1_69ck940 FIND v(dout1_69) AT=950.05n

.meas tran vdout1_70ck940 FIND v(dout1_70) AT=950.05n

.meas tran vdout1_71ck940 FIND v(dout1_71) AT=950.05n

.meas tran vdout1_72ck940 FIND v(dout1_72) AT=950.05n

.meas tran vdout1_73ck940 FIND v(dout1_73) AT=950.05n

.meas tran vdout1_74ck940 FIND v(dout1_74) AT=950.05n

.meas tran vdout1_75ck940 FIND v(dout1_75) AT=950.05n

.meas tran vdout1_76ck940 FIND v(dout1_76) AT=950.05n

.meas tran vdout1_77ck940 FIND v(dout1_77) AT=950.05n

.meas tran vdout1_78ck940 FIND v(dout1_78) AT=950.05n

.meas tran vdout1_79ck940 FIND v(dout1_79) AT=950.05n

.meas tran vdout1_80ck940 FIND v(dout1_80) AT=950.05n

.meas tran vdout1_81ck940 FIND v(dout1_81) AT=950.05n

.meas tran vdout1_82ck940 FIND v(dout1_82) AT=950.05n

.meas tran vdout1_83ck940 FIND v(dout1_83) AT=950.05n

.meas tran vdout1_84ck940 FIND v(dout1_84) AT=950.05n

.meas tran vdout1_85ck940 FIND v(dout1_85) AT=950.05n

.meas tran vdout1_86ck940 FIND v(dout1_86) AT=950.05n

.meas tran vdout1_87ck940 FIND v(dout1_87) AT=950.05n

.meas tran vdout1_88ck940 FIND v(dout1_88) AT=950.05n

.meas tran vdout1_89ck940 FIND v(dout1_89) AT=950.05n

.meas tran vdout1_90ck940 FIND v(dout1_90) AT=950.05n

.meas tran vdout1_91ck940 FIND v(dout1_91) AT=950.05n

.meas tran vdout1_92ck940 FIND v(dout1_92) AT=950.05n

.meas tran vdout1_93ck940 FIND v(dout1_93) AT=950.05n

.meas tran vdout1_94ck940 FIND v(dout1_94) AT=950.05n

.meas tran vdout1_95ck940 FIND v(dout1_95) AT=950.05n

.meas tran vdout1_96ck940 FIND v(dout1_96) AT=950.05n

.meas tran vdout1_97ck940 FIND v(dout1_97) AT=950.05n

.meas tran vdout1_98ck940 FIND v(dout1_98) AT=950.05n

.meas tran vdout1_99ck940 FIND v(dout1_99) AT=950.05n

.meas tran vdout1_100ck940 FIND v(dout1_100) AT=950.05n

.meas tran vdout1_101ck940 FIND v(dout1_101) AT=950.05n

.meas tran vdout1_102ck940 FIND v(dout1_102) AT=950.05n

.meas tran vdout1_103ck940 FIND v(dout1_103) AT=950.05n

.meas tran vdout1_104ck940 FIND v(dout1_104) AT=950.05n

.meas tran vdout1_105ck940 FIND v(dout1_105) AT=950.05n

.meas tran vdout1_106ck940 FIND v(dout1_106) AT=950.05n

.meas tran vdout1_107ck940 FIND v(dout1_107) AT=950.05n

.meas tran vdout1_108ck940 FIND v(dout1_108) AT=950.05n

.meas tran vdout1_109ck940 FIND v(dout1_109) AT=950.05n

.meas tran vdout1_110ck940 FIND v(dout1_110) AT=950.05n

.meas tran vdout1_111ck940 FIND v(dout1_111) AT=950.05n

.meas tran vdout1_112ck940 FIND v(dout1_112) AT=950.05n

.meas tran vdout1_113ck940 FIND v(dout1_113) AT=950.05n

.meas tran vdout1_114ck940 FIND v(dout1_114) AT=950.05n

.meas tran vdout1_115ck940 FIND v(dout1_115) AT=950.05n

.meas tran vdout1_116ck940 FIND v(dout1_116) AT=950.05n

.meas tran vdout1_117ck940 FIND v(dout1_117) AT=950.05n

.meas tran vdout1_118ck940 FIND v(dout1_118) AT=950.05n

.meas tran vdout1_119ck940 FIND v(dout1_119) AT=950.05n

.meas tran vdout1_120ck940 FIND v(dout1_120) AT=950.05n

.meas tran vdout1_121ck940 FIND v(dout1_121) AT=950.05n

.meas tran vdout1_122ck940 FIND v(dout1_122) AT=950.05n

.meas tran vdout1_123ck940 FIND v(dout1_123) AT=950.05n

.meas tran vdout1_124ck940 FIND v(dout1_124) AT=950.05n

.meas tran vdout1_125ck940 FIND v(dout1_125) AT=950.05n

.meas tran vdout1_126ck940 FIND v(dout1_126) AT=950.05n

.meas tran vdout1_127ck940 FIND v(dout1_127) AT=950.05n

.meas tran vdout1_128ck940 FIND v(dout1_128) AT=950.05n

.meas tran vdout1_129ck940 FIND v(dout1_129) AT=950.05n

.meas tran vdout1_130ck940 FIND v(dout1_130) AT=950.05n

.meas tran vdout1_131ck940 FIND v(dout1_131) AT=950.05n

.meas tran vdout1_132ck940 FIND v(dout1_132) AT=950.05n

.meas tran vdout1_133ck940 FIND v(dout1_133) AT=950.05n

.meas tran vdout1_134ck940 FIND v(dout1_134) AT=950.05n

.meas tran vdout1_0ck990 FIND v(dout1_0) AT=1000.05n

.meas tran vdout1_1ck990 FIND v(dout1_1) AT=1000.05n

.meas tran vdout1_2ck990 FIND v(dout1_2) AT=1000.05n

.meas tran vdout1_3ck990 FIND v(dout1_3) AT=1000.05n

.meas tran vdout1_4ck990 FIND v(dout1_4) AT=1000.05n

.meas tran vdout1_5ck990 FIND v(dout1_5) AT=1000.05n

.meas tran vdout1_6ck990 FIND v(dout1_6) AT=1000.05n

.meas tran vdout1_7ck990 FIND v(dout1_7) AT=1000.05n

.meas tran vdout1_8ck990 FIND v(dout1_8) AT=1000.05n

.meas tran vdout1_9ck990 FIND v(dout1_9) AT=1000.05n

.meas tran vdout1_10ck990 FIND v(dout1_10) AT=1000.05n

.meas tran vdout1_11ck990 FIND v(dout1_11) AT=1000.05n

.meas tran vdout1_12ck990 FIND v(dout1_12) AT=1000.05n

.meas tran vdout1_13ck990 FIND v(dout1_13) AT=1000.05n

.meas tran vdout1_14ck990 FIND v(dout1_14) AT=1000.05n

.meas tran vdout1_15ck990 FIND v(dout1_15) AT=1000.05n

.meas tran vdout1_16ck990 FIND v(dout1_16) AT=1000.05n

.meas tran vdout1_17ck990 FIND v(dout1_17) AT=1000.05n

.meas tran vdout1_18ck990 FIND v(dout1_18) AT=1000.05n

.meas tran vdout1_19ck990 FIND v(dout1_19) AT=1000.05n

.meas tran vdout1_20ck990 FIND v(dout1_20) AT=1000.05n

.meas tran vdout1_21ck990 FIND v(dout1_21) AT=1000.05n

.meas tran vdout1_22ck990 FIND v(dout1_22) AT=1000.05n

.meas tran vdout1_23ck990 FIND v(dout1_23) AT=1000.05n

.meas tran vdout1_24ck990 FIND v(dout1_24) AT=1000.05n

.meas tran vdout1_25ck990 FIND v(dout1_25) AT=1000.05n

.meas tran vdout1_26ck990 FIND v(dout1_26) AT=1000.05n

.meas tran vdout1_27ck990 FIND v(dout1_27) AT=1000.05n

.meas tran vdout1_28ck990 FIND v(dout1_28) AT=1000.05n

.meas tran vdout1_29ck990 FIND v(dout1_29) AT=1000.05n

.meas tran vdout1_30ck990 FIND v(dout1_30) AT=1000.05n

.meas tran vdout1_31ck990 FIND v(dout1_31) AT=1000.05n

.meas tran vdout1_32ck990 FIND v(dout1_32) AT=1000.05n

.meas tran vdout1_33ck990 FIND v(dout1_33) AT=1000.05n

.meas tran vdout1_34ck990 FIND v(dout1_34) AT=1000.05n

.meas tran vdout1_35ck990 FIND v(dout1_35) AT=1000.05n

.meas tran vdout1_36ck990 FIND v(dout1_36) AT=1000.05n

.meas tran vdout1_37ck990 FIND v(dout1_37) AT=1000.05n

.meas tran vdout1_38ck990 FIND v(dout1_38) AT=1000.05n

.meas tran vdout1_39ck990 FIND v(dout1_39) AT=1000.05n

.meas tran vdout1_40ck990 FIND v(dout1_40) AT=1000.05n

.meas tran vdout1_41ck990 FIND v(dout1_41) AT=1000.05n

.meas tran vdout1_42ck990 FIND v(dout1_42) AT=1000.05n

.meas tran vdout1_43ck990 FIND v(dout1_43) AT=1000.05n

.meas tran vdout1_44ck990 FIND v(dout1_44) AT=1000.05n

.meas tran vdout1_45ck990 FIND v(dout1_45) AT=1000.05n

.meas tran vdout1_46ck990 FIND v(dout1_46) AT=1000.05n

.meas tran vdout1_47ck990 FIND v(dout1_47) AT=1000.05n

.meas tran vdout1_48ck990 FIND v(dout1_48) AT=1000.05n

.meas tran vdout1_49ck990 FIND v(dout1_49) AT=1000.05n

.meas tran vdout1_50ck990 FIND v(dout1_50) AT=1000.05n

.meas tran vdout1_51ck990 FIND v(dout1_51) AT=1000.05n

.meas tran vdout1_52ck990 FIND v(dout1_52) AT=1000.05n

.meas tran vdout1_53ck990 FIND v(dout1_53) AT=1000.05n

.meas tran vdout1_54ck990 FIND v(dout1_54) AT=1000.05n

.meas tran vdout1_55ck990 FIND v(dout1_55) AT=1000.05n

.meas tran vdout1_56ck990 FIND v(dout1_56) AT=1000.05n

.meas tran vdout1_57ck990 FIND v(dout1_57) AT=1000.05n

.meas tran vdout1_58ck990 FIND v(dout1_58) AT=1000.05n

.meas tran vdout1_59ck990 FIND v(dout1_59) AT=1000.05n

.meas tran vdout1_60ck990 FIND v(dout1_60) AT=1000.05n

.meas tran vdout1_61ck990 FIND v(dout1_61) AT=1000.05n

.meas tran vdout1_62ck990 FIND v(dout1_62) AT=1000.05n

.meas tran vdout1_63ck990 FIND v(dout1_63) AT=1000.05n

.meas tran vdout1_64ck990 FIND v(dout1_64) AT=1000.05n

.meas tran vdout1_65ck990 FIND v(dout1_65) AT=1000.05n

.meas tran vdout1_66ck990 FIND v(dout1_66) AT=1000.05n

.meas tran vdout1_67ck990 FIND v(dout1_67) AT=1000.05n

.meas tran vdout1_68ck990 FIND v(dout1_68) AT=1000.05n

.meas tran vdout1_69ck990 FIND v(dout1_69) AT=1000.05n

.meas tran vdout1_70ck990 FIND v(dout1_70) AT=1000.05n

.meas tran vdout1_71ck990 FIND v(dout1_71) AT=1000.05n

.meas tran vdout1_72ck990 FIND v(dout1_72) AT=1000.05n

.meas tran vdout1_73ck990 FIND v(dout1_73) AT=1000.05n

.meas tran vdout1_74ck990 FIND v(dout1_74) AT=1000.05n

.meas tran vdout1_75ck990 FIND v(dout1_75) AT=1000.05n

.meas tran vdout1_76ck990 FIND v(dout1_76) AT=1000.05n

.meas tran vdout1_77ck990 FIND v(dout1_77) AT=1000.05n

.meas tran vdout1_78ck990 FIND v(dout1_78) AT=1000.05n

.meas tran vdout1_79ck990 FIND v(dout1_79) AT=1000.05n

.meas tran vdout1_80ck990 FIND v(dout1_80) AT=1000.05n

.meas tran vdout1_81ck990 FIND v(dout1_81) AT=1000.05n

.meas tran vdout1_82ck990 FIND v(dout1_82) AT=1000.05n

.meas tran vdout1_83ck990 FIND v(dout1_83) AT=1000.05n

.meas tran vdout1_84ck990 FIND v(dout1_84) AT=1000.05n

.meas tran vdout1_85ck990 FIND v(dout1_85) AT=1000.05n

.meas tran vdout1_86ck990 FIND v(dout1_86) AT=1000.05n

.meas tran vdout1_87ck990 FIND v(dout1_87) AT=1000.05n

.meas tran vdout1_88ck990 FIND v(dout1_88) AT=1000.05n

.meas tran vdout1_89ck990 FIND v(dout1_89) AT=1000.05n

.meas tran vdout1_90ck990 FIND v(dout1_90) AT=1000.05n

.meas tran vdout1_91ck990 FIND v(dout1_91) AT=1000.05n

.meas tran vdout1_92ck990 FIND v(dout1_92) AT=1000.05n

.meas tran vdout1_93ck990 FIND v(dout1_93) AT=1000.05n

.meas tran vdout1_94ck990 FIND v(dout1_94) AT=1000.05n

.meas tran vdout1_95ck990 FIND v(dout1_95) AT=1000.05n

.meas tran vdout1_96ck990 FIND v(dout1_96) AT=1000.05n

.meas tran vdout1_97ck990 FIND v(dout1_97) AT=1000.05n

.meas tran vdout1_98ck990 FIND v(dout1_98) AT=1000.05n

.meas tran vdout1_99ck990 FIND v(dout1_99) AT=1000.05n

.meas tran vdout1_100ck990 FIND v(dout1_100) AT=1000.05n

.meas tran vdout1_101ck990 FIND v(dout1_101) AT=1000.05n

.meas tran vdout1_102ck990 FIND v(dout1_102) AT=1000.05n

.meas tran vdout1_103ck990 FIND v(dout1_103) AT=1000.05n

.meas tran vdout1_104ck990 FIND v(dout1_104) AT=1000.05n

.meas tran vdout1_105ck990 FIND v(dout1_105) AT=1000.05n

.meas tran vdout1_106ck990 FIND v(dout1_106) AT=1000.05n

.meas tran vdout1_107ck990 FIND v(dout1_107) AT=1000.05n

.meas tran vdout1_108ck990 FIND v(dout1_108) AT=1000.05n

.meas tran vdout1_109ck990 FIND v(dout1_109) AT=1000.05n

.meas tran vdout1_110ck990 FIND v(dout1_110) AT=1000.05n

.meas tran vdout1_111ck990 FIND v(dout1_111) AT=1000.05n

.meas tran vdout1_112ck990 FIND v(dout1_112) AT=1000.05n

.meas tran vdout1_113ck990 FIND v(dout1_113) AT=1000.05n

.meas tran vdout1_114ck990 FIND v(dout1_114) AT=1000.05n

.meas tran vdout1_115ck990 FIND v(dout1_115) AT=1000.05n

.meas tran vdout1_116ck990 FIND v(dout1_116) AT=1000.05n

.meas tran vdout1_117ck990 FIND v(dout1_117) AT=1000.05n

.meas tran vdout1_118ck990 FIND v(dout1_118) AT=1000.05n

.meas tran vdout1_119ck990 FIND v(dout1_119) AT=1000.05n

.meas tran vdout1_120ck990 FIND v(dout1_120) AT=1000.05n

.meas tran vdout1_121ck990 FIND v(dout1_121) AT=1000.05n

.meas tran vdout1_122ck990 FIND v(dout1_122) AT=1000.05n

.meas tran vdout1_123ck990 FIND v(dout1_123) AT=1000.05n

.meas tran vdout1_124ck990 FIND v(dout1_124) AT=1000.05n

.meas tran vdout1_125ck990 FIND v(dout1_125) AT=1000.05n

.meas tran vdout1_126ck990 FIND v(dout1_126) AT=1000.05n

.meas tran vdout1_127ck990 FIND v(dout1_127) AT=1000.05n

.meas tran vdout1_128ck990 FIND v(dout1_128) AT=1000.05n

.meas tran vdout1_129ck990 FIND v(dout1_129) AT=1000.05n

.meas tran vdout1_130ck990 FIND v(dout1_130) AT=1000.05n

.meas tran vdout1_131ck990 FIND v(dout1_131) AT=1000.05n

.meas tran vdout1_132ck990 FIND v(dout1_132) AT=1000.05n

.meas tran vdout1_133ck990 FIND v(dout1_133) AT=1000.05n

.meas tran vdout1_134ck990 FIND v(dout1_134) AT=1000.05n

.meas tran vdout1_0ck1040 FIND v(dout1_0) AT=1050.05n

.meas tran vdout1_1ck1040 FIND v(dout1_1) AT=1050.05n

.meas tran vdout1_2ck1040 FIND v(dout1_2) AT=1050.05n

.meas tran vdout1_3ck1040 FIND v(dout1_3) AT=1050.05n

.meas tran vdout1_4ck1040 FIND v(dout1_4) AT=1050.05n

.meas tran vdout1_5ck1040 FIND v(dout1_5) AT=1050.05n

.meas tran vdout1_6ck1040 FIND v(dout1_6) AT=1050.05n

.meas tran vdout1_7ck1040 FIND v(dout1_7) AT=1050.05n

.meas tran vdout1_8ck1040 FIND v(dout1_8) AT=1050.05n

.meas tran vdout1_9ck1040 FIND v(dout1_9) AT=1050.05n

.meas tran vdout1_10ck1040 FIND v(dout1_10) AT=1050.05n

.meas tran vdout1_11ck1040 FIND v(dout1_11) AT=1050.05n

.meas tran vdout1_12ck1040 FIND v(dout1_12) AT=1050.05n

.meas tran vdout1_13ck1040 FIND v(dout1_13) AT=1050.05n

.meas tran vdout1_14ck1040 FIND v(dout1_14) AT=1050.05n

.meas tran vdout1_15ck1040 FIND v(dout1_15) AT=1050.05n

.meas tran vdout1_16ck1040 FIND v(dout1_16) AT=1050.05n

.meas tran vdout1_17ck1040 FIND v(dout1_17) AT=1050.05n

.meas tran vdout1_18ck1040 FIND v(dout1_18) AT=1050.05n

.meas tran vdout1_19ck1040 FIND v(dout1_19) AT=1050.05n

.meas tran vdout1_20ck1040 FIND v(dout1_20) AT=1050.05n

.meas tran vdout1_21ck1040 FIND v(dout1_21) AT=1050.05n

.meas tran vdout1_22ck1040 FIND v(dout1_22) AT=1050.05n

.meas tran vdout1_23ck1040 FIND v(dout1_23) AT=1050.05n

.meas tran vdout1_24ck1040 FIND v(dout1_24) AT=1050.05n

.meas tran vdout1_25ck1040 FIND v(dout1_25) AT=1050.05n

.meas tran vdout1_26ck1040 FIND v(dout1_26) AT=1050.05n

.meas tran vdout1_27ck1040 FIND v(dout1_27) AT=1050.05n

.meas tran vdout1_28ck1040 FIND v(dout1_28) AT=1050.05n

.meas tran vdout1_29ck1040 FIND v(dout1_29) AT=1050.05n

.meas tran vdout1_30ck1040 FIND v(dout1_30) AT=1050.05n

.meas tran vdout1_31ck1040 FIND v(dout1_31) AT=1050.05n

.meas tran vdout1_32ck1040 FIND v(dout1_32) AT=1050.05n

.meas tran vdout1_33ck1040 FIND v(dout1_33) AT=1050.05n

.meas tran vdout1_34ck1040 FIND v(dout1_34) AT=1050.05n

.meas tran vdout1_35ck1040 FIND v(dout1_35) AT=1050.05n

.meas tran vdout1_36ck1040 FIND v(dout1_36) AT=1050.05n

.meas tran vdout1_37ck1040 FIND v(dout1_37) AT=1050.05n

.meas tran vdout1_38ck1040 FIND v(dout1_38) AT=1050.05n

.meas tran vdout1_39ck1040 FIND v(dout1_39) AT=1050.05n

.meas tran vdout1_40ck1040 FIND v(dout1_40) AT=1050.05n

.meas tran vdout1_41ck1040 FIND v(dout1_41) AT=1050.05n

.meas tran vdout1_42ck1040 FIND v(dout1_42) AT=1050.05n

.meas tran vdout1_43ck1040 FIND v(dout1_43) AT=1050.05n

.meas tran vdout1_44ck1040 FIND v(dout1_44) AT=1050.05n

.meas tran vdout1_45ck1040 FIND v(dout1_45) AT=1050.05n

.meas tran vdout1_46ck1040 FIND v(dout1_46) AT=1050.05n

.meas tran vdout1_47ck1040 FIND v(dout1_47) AT=1050.05n

.meas tran vdout1_48ck1040 FIND v(dout1_48) AT=1050.05n

.meas tran vdout1_49ck1040 FIND v(dout1_49) AT=1050.05n

.meas tran vdout1_50ck1040 FIND v(dout1_50) AT=1050.05n

.meas tran vdout1_51ck1040 FIND v(dout1_51) AT=1050.05n

.meas tran vdout1_52ck1040 FIND v(dout1_52) AT=1050.05n

.meas tran vdout1_53ck1040 FIND v(dout1_53) AT=1050.05n

.meas tran vdout1_54ck1040 FIND v(dout1_54) AT=1050.05n

.meas tran vdout1_55ck1040 FIND v(dout1_55) AT=1050.05n

.meas tran vdout1_56ck1040 FIND v(dout1_56) AT=1050.05n

.meas tran vdout1_57ck1040 FIND v(dout1_57) AT=1050.05n

.meas tran vdout1_58ck1040 FIND v(dout1_58) AT=1050.05n

.meas tran vdout1_59ck1040 FIND v(dout1_59) AT=1050.05n

.meas tran vdout1_60ck1040 FIND v(dout1_60) AT=1050.05n

.meas tran vdout1_61ck1040 FIND v(dout1_61) AT=1050.05n

.meas tran vdout1_62ck1040 FIND v(dout1_62) AT=1050.05n

.meas tran vdout1_63ck1040 FIND v(dout1_63) AT=1050.05n

.meas tran vdout1_64ck1040 FIND v(dout1_64) AT=1050.05n

.meas tran vdout1_65ck1040 FIND v(dout1_65) AT=1050.05n

.meas tran vdout1_66ck1040 FIND v(dout1_66) AT=1050.05n

.meas tran vdout1_67ck1040 FIND v(dout1_67) AT=1050.05n

.meas tran vdout1_68ck1040 FIND v(dout1_68) AT=1050.05n

.meas tran vdout1_69ck1040 FIND v(dout1_69) AT=1050.05n

.meas tran vdout1_70ck1040 FIND v(dout1_70) AT=1050.05n

.meas tran vdout1_71ck1040 FIND v(dout1_71) AT=1050.05n

.meas tran vdout1_72ck1040 FIND v(dout1_72) AT=1050.05n

.meas tran vdout1_73ck1040 FIND v(dout1_73) AT=1050.05n

.meas tran vdout1_74ck1040 FIND v(dout1_74) AT=1050.05n

.meas tran vdout1_75ck1040 FIND v(dout1_75) AT=1050.05n

.meas tran vdout1_76ck1040 FIND v(dout1_76) AT=1050.05n

.meas tran vdout1_77ck1040 FIND v(dout1_77) AT=1050.05n

.meas tran vdout1_78ck1040 FIND v(dout1_78) AT=1050.05n

.meas tran vdout1_79ck1040 FIND v(dout1_79) AT=1050.05n

.meas tran vdout1_80ck1040 FIND v(dout1_80) AT=1050.05n

.meas tran vdout1_81ck1040 FIND v(dout1_81) AT=1050.05n

.meas tran vdout1_82ck1040 FIND v(dout1_82) AT=1050.05n

.meas tran vdout1_83ck1040 FIND v(dout1_83) AT=1050.05n

.meas tran vdout1_84ck1040 FIND v(dout1_84) AT=1050.05n

.meas tran vdout1_85ck1040 FIND v(dout1_85) AT=1050.05n

.meas tran vdout1_86ck1040 FIND v(dout1_86) AT=1050.05n

.meas tran vdout1_87ck1040 FIND v(dout1_87) AT=1050.05n

.meas tran vdout1_88ck1040 FIND v(dout1_88) AT=1050.05n

.meas tran vdout1_89ck1040 FIND v(dout1_89) AT=1050.05n

.meas tran vdout1_90ck1040 FIND v(dout1_90) AT=1050.05n

.meas tran vdout1_91ck1040 FIND v(dout1_91) AT=1050.05n

.meas tran vdout1_92ck1040 FIND v(dout1_92) AT=1050.05n

.meas tran vdout1_93ck1040 FIND v(dout1_93) AT=1050.05n

.meas tran vdout1_94ck1040 FIND v(dout1_94) AT=1050.05n

.meas tran vdout1_95ck1040 FIND v(dout1_95) AT=1050.05n

.meas tran vdout1_96ck1040 FIND v(dout1_96) AT=1050.05n

.meas tran vdout1_97ck1040 FIND v(dout1_97) AT=1050.05n

.meas tran vdout1_98ck1040 FIND v(dout1_98) AT=1050.05n

.meas tran vdout1_99ck1040 FIND v(dout1_99) AT=1050.05n

.meas tran vdout1_100ck1040 FIND v(dout1_100) AT=1050.05n

.meas tran vdout1_101ck1040 FIND v(dout1_101) AT=1050.05n

.meas tran vdout1_102ck1040 FIND v(dout1_102) AT=1050.05n

.meas tran vdout1_103ck1040 FIND v(dout1_103) AT=1050.05n

.meas tran vdout1_104ck1040 FIND v(dout1_104) AT=1050.05n

.meas tran vdout1_105ck1040 FIND v(dout1_105) AT=1050.05n

.meas tran vdout1_106ck1040 FIND v(dout1_106) AT=1050.05n

.meas tran vdout1_107ck1040 FIND v(dout1_107) AT=1050.05n

.meas tran vdout1_108ck1040 FIND v(dout1_108) AT=1050.05n

.meas tran vdout1_109ck1040 FIND v(dout1_109) AT=1050.05n

.meas tran vdout1_110ck1040 FIND v(dout1_110) AT=1050.05n

.meas tran vdout1_111ck1040 FIND v(dout1_111) AT=1050.05n

.meas tran vdout1_112ck1040 FIND v(dout1_112) AT=1050.05n

.meas tran vdout1_113ck1040 FIND v(dout1_113) AT=1050.05n

.meas tran vdout1_114ck1040 FIND v(dout1_114) AT=1050.05n

.meas tran vdout1_115ck1040 FIND v(dout1_115) AT=1050.05n

.meas tran vdout1_116ck1040 FIND v(dout1_116) AT=1050.05n

.meas tran vdout1_117ck1040 FIND v(dout1_117) AT=1050.05n

.meas tran vdout1_118ck1040 FIND v(dout1_118) AT=1050.05n

.meas tran vdout1_119ck1040 FIND v(dout1_119) AT=1050.05n

.meas tran vdout1_120ck1040 FIND v(dout1_120) AT=1050.05n

.meas tran vdout1_121ck1040 FIND v(dout1_121) AT=1050.05n

.meas tran vdout1_122ck1040 FIND v(dout1_122) AT=1050.05n

.meas tran vdout1_123ck1040 FIND v(dout1_123) AT=1050.05n

.meas tran vdout1_124ck1040 FIND v(dout1_124) AT=1050.05n

.meas tran vdout1_125ck1040 FIND v(dout1_125) AT=1050.05n

.meas tran vdout1_126ck1040 FIND v(dout1_126) AT=1050.05n

.meas tran vdout1_127ck1040 FIND v(dout1_127) AT=1050.05n

.meas tran vdout1_128ck1040 FIND v(dout1_128) AT=1050.05n

.meas tran vdout1_129ck1040 FIND v(dout1_129) AT=1050.05n

.meas tran vdout1_130ck1040 FIND v(dout1_130) AT=1050.05n

.meas tran vdout1_131ck1040 FIND v(dout1_131) AT=1050.05n

.meas tran vdout1_132ck1040 FIND v(dout1_132) AT=1050.05n

.meas tran vdout1_133ck1040 FIND v(dout1_133) AT=1050.05n

.meas tran vdout1_134ck1040 FIND v(dout1_134) AT=1050.05n

.meas tran vdout1_0ck1060 FIND v(dout1_0) AT=1070.05n

.meas tran vdout1_1ck1060 FIND v(dout1_1) AT=1070.05n

.meas tran vdout1_2ck1060 FIND v(dout1_2) AT=1070.05n

.meas tran vdout1_3ck1060 FIND v(dout1_3) AT=1070.05n

.meas tran vdout1_4ck1060 FIND v(dout1_4) AT=1070.05n

.meas tran vdout1_5ck1060 FIND v(dout1_5) AT=1070.05n

.meas tran vdout1_6ck1060 FIND v(dout1_6) AT=1070.05n

.meas tran vdout1_7ck1060 FIND v(dout1_7) AT=1070.05n

.meas tran vdout1_8ck1060 FIND v(dout1_8) AT=1070.05n

.meas tran vdout1_9ck1060 FIND v(dout1_9) AT=1070.05n

.meas tran vdout1_10ck1060 FIND v(dout1_10) AT=1070.05n

.meas tran vdout1_11ck1060 FIND v(dout1_11) AT=1070.05n

.meas tran vdout1_12ck1060 FIND v(dout1_12) AT=1070.05n

.meas tran vdout1_13ck1060 FIND v(dout1_13) AT=1070.05n

.meas tran vdout1_14ck1060 FIND v(dout1_14) AT=1070.05n

.meas tran vdout1_15ck1060 FIND v(dout1_15) AT=1070.05n

.meas tran vdout1_16ck1060 FIND v(dout1_16) AT=1070.05n

.meas tran vdout1_17ck1060 FIND v(dout1_17) AT=1070.05n

.meas tran vdout1_18ck1060 FIND v(dout1_18) AT=1070.05n

.meas tran vdout1_19ck1060 FIND v(dout1_19) AT=1070.05n

.meas tran vdout1_20ck1060 FIND v(dout1_20) AT=1070.05n

.meas tran vdout1_21ck1060 FIND v(dout1_21) AT=1070.05n

.meas tran vdout1_22ck1060 FIND v(dout1_22) AT=1070.05n

.meas tran vdout1_23ck1060 FIND v(dout1_23) AT=1070.05n

.meas tran vdout1_24ck1060 FIND v(dout1_24) AT=1070.05n

.meas tran vdout1_25ck1060 FIND v(dout1_25) AT=1070.05n

.meas tran vdout1_26ck1060 FIND v(dout1_26) AT=1070.05n

.meas tran vdout1_27ck1060 FIND v(dout1_27) AT=1070.05n

.meas tran vdout1_28ck1060 FIND v(dout1_28) AT=1070.05n

.meas tran vdout1_29ck1060 FIND v(dout1_29) AT=1070.05n

.meas tran vdout1_30ck1060 FIND v(dout1_30) AT=1070.05n

.meas tran vdout1_31ck1060 FIND v(dout1_31) AT=1070.05n

.meas tran vdout1_32ck1060 FIND v(dout1_32) AT=1070.05n

.meas tran vdout1_33ck1060 FIND v(dout1_33) AT=1070.05n

.meas tran vdout1_34ck1060 FIND v(dout1_34) AT=1070.05n

.meas tran vdout1_35ck1060 FIND v(dout1_35) AT=1070.05n

.meas tran vdout1_36ck1060 FIND v(dout1_36) AT=1070.05n

.meas tran vdout1_37ck1060 FIND v(dout1_37) AT=1070.05n

.meas tran vdout1_38ck1060 FIND v(dout1_38) AT=1070.05n

.meas tran vdout1_39ck1060 FIND v(dout1_39) AT=1070.05n

.meas tran vdout1_40ck1060 FIND v(dout1_40) AT=1070.05n

.meas tran vdout1_41ck1060 FIND v(dout1_41) AT=1070.05n

.meas tran vdout1_42ck1060 FIND v(dout1_42) AT=1070.05n

.meas tran vdout1_43ck1060 FIND v(dout1_43) AT=1070.05n

.meas tran vdout1_44ck1060 FIND v(dout1_44) AT=1070.05n

.meas tran vdout1_45ck1060 FIND v(dout1_45) AT=1070.05n

.meas tran vdout1_46ck1060 FIND v(dout1_46) AT=1070.05n

.meas tran vdout1_47ck1060 FIND v(dout1_47) AT=1070.05n

.meas tran vdout1_48ck1060 FIND v(dout1_48) AT=1070.05n

.meas tran vdout1_49ck1060 FIND v(dout1_49) AT=1070.05n

.meas tran vdout1_50ck1060 FIND v(dout1_50) AT=1070.05n

.meas tran vdout1_51ck1060 FIND v(dout1_51) AT=1070.05n

.meas tran vdout1_52ck1060 FIND v(dout1_52) AT=1070.05n

.meas tran vdout1_53ck1060 FIND v(dout1_53) AT=1070.05n

.meas tran vdout1_54ck1060 FIND v(dout1_54) AT=1070.05n

.meas tran vdout1_55ck1060 FIND v(dout1_55) AT=1070.05n

.meas tran vdout1_56ck1060 FIND v(dout1_56) AT=1070.05n

.meas tran vdout1_57ck1060 FIND v(dout1_57) AT=1070.05n

.meas tran vdout1_58ck1060 FIND v(dout1_58) AT=1070.05n

.meas tran vdout1_59ck1060 FIND v(dout1_59) AT=1070.05n

.meas tran vdout1_60ck1060 FIND v(dout1_60) AT=1070.05n

.meas tran vdout1_61ck1060 FIND v(dout1_61) AT=1070.05n

.meas tran vdout1_62ck1060 FIND v(dout1_62) AT=1070.05n

.meas tran vdout1_63ck1060 FIND v(dout1_63) AT=1070.05n

.meas tran vdout1_64ck1060 FIND v(dout1_64) AT=1070.05n

.meas tran vdout1_65ck1060 FIND v(dout1_65) AT=1070.05n

.meas tran vdout1_66ck1060 FIND v(dout1_66) AT=1070.05n

.meas tran vdout1_67ck1060 FIND v(dout1_67) AT=1070.05n

.meas tran vdout1_68ck1060 FIND v(dout1_68) AT=1070.05n

.meas tran vdout1_69ck1060 FIND v(dout1_69) AT=1070.05n

.meas tran vdout1_70ck1060 FIND v(dout1_70) AT=1070.05n

.meas tran vdout1_71ck1060 FIND v(dout1_71) AT=1070.05n

.meas tran vdout1_72ck1060 FIND v(dout1_72) AT=1070.05n

.meas tran vdout1_73ck1060 FIND v(dout1_73) AT=1070.05n

.meas tran vdout1_74ck1060 FIND v(dout1_74) AT=1070.05n

.meas tran vdout1_75ck1060 FIND v(dout1_75) AT=1070.05n

.meas tran vdout1_76ck1060 FIND v(dout1_76) AT=1070.05n

.meas tran vdout1_77ck1060 FIND v(dout1_77) AT=1070.05n

.meas tran vdout1_78ck1060 FIND v(dout1_78) AT=1070.05n

.meas tran vdout1_79ck1060 FIND v(dout1_79) AT=1070.05n

.meas tran vdout1_80ck1060 FIND v(dout1_80) AT=1070.05n

.meas tran vdout1_81ck1060 FIND v(dout1_81) AT=1070.05n

.meas tran vdout1_82ck1060 FIND v(dout1_82) AT=1070.05n

.meas tran vdout1_83ck1060 FIND v(dout1_83) AT=1070.05n

.meas tran vdout1_84ck1060 FIND v(dout1_84) AT=1070.05n

.meas tran vdout1_85ck1060 FIND v(dout1_85) AT=1070.05n

.meas tran vdout1_86ck1060 FIND v(dout1_86) AT=1070.05n

.meas tran vdout1_87ck1060 FIND v(dout1_87) AT=1070.05n

.meas tran vdout1_88ck1060 FIND v(dout1_88) AT=1070.05n

.meas tran vdout1_89ck1060 FIND v(dout1_89) AT=1070.05n

.meas tran vdout1_90ck1060 FIND v(dout1_90) AT=1070.05n

.meas tran vdout1_91ck1060 FIND v(dout1_91) AT=1070.05n

.meas tran vdout1_92ck1060 FIND v(dout1_92) AT=1070.05n

.meas tran vdout1_93ck1060 FIND v(dout1_93) AT=1070.05n

.meas tran vdout1_94ck1060 FIND v(dout1_94) AT=1070.05n

.meas tran vdout1_95ck1060 FIND v(dout1_95) AT=1070.05n

.meas tran vdout1_96ck1060 FIND v(dout1_96) AT=1070.05n

.meas tran vdout1_97ck1060 FIND v(dout1_97) AT=1070.05n

.meas tran vdout1_98ck1060 FIND v(dout1_98) AT=1070.05n

.meas tran vdout1_99ck1060 FIND v(dout1_99) AT=1070.05n

.meas tran vdout1_100ck1060 FIND v(dout1_100) AT=1070.05n

.meas tran vdout1_101ck1060 FIND v(dout1_101) AT=1070.05n

.meas tran vdout1_102ck1060 FIND v(dout1_102) AT=1070.05n

.meas tran vdout1_103ck1060 FIND v(dout1_103) AT=1070.05n

.meas tran vdout1_104ck1060 FIND v(dout1_104) AT=1070.05n

.meas tran vdout1_105ck1060 FIND v(dout1_105) AT=1070.05n

.meas tran vdout1_106ck1060 FIND v(dout1_106) AT=1070.05n

.meas tran vdout1_107ck1060 FIND v(dout1_107) AT=1070.05n

.meas tran vdout1_108ck1060 FIND v(dout1_108) AT=1070.05n

.meas tran vdout1_109ck1060 FIND v(dout1_109) AT=1070.05n

.meas tran vdout1_110ck1060 FIND v(dout1_110) AT=1070.05n

.meas tran vdout1_111ck1060 FIND v(dout1_111) AT=1070.05n

.meas tran vdout1_112ck1060 FIND v(dout1_112) AT=1070.05n

.meas tran vdout1_113ck1060 FIND v(dout1_113) AT=1070.05n

.meas tran vdout1_114ck1060 FIND v(dout1_114) AT=1070.05n

.meas tran vdout1_115ck1060 FIND v(dout1_115) AT=1070.05n

.meas tran vdout1_116ck1060 FIND v(dout1_116) AT=1070.05n

.meas tran vdout1_117ck1060 FIND v(dout1_117) AT=1070.05n

.meas tran vdout1_118ck1060 FIND v(dout1_118) AT=1070.05n

.meas tran vdout1_119ck1060 FIND v(dout1_119) AT=1070.05n

.meas tran vdout1_120ck1060 FIND v(dout1_120) AT=1070.05n

.meas tran vdout1_121ck1060 FIND v(dout1_121) AT=1070.05n

.meas tran vdout1_122ck1060 FIND v(dout1_122) AT=1070.05n

.meas tran vdout1_123ck1060 FIND v(dout1_123) AT=1070.05n

.meas tran vdout1_124ck1060 FIND v(dout1_124) AT=1070.05n

.meas tran vdout1_125ck1060 FIND v(dout1_125) AT=1070.05n

.meas tran vdout1_126ck1060 FIND v(dout1_126) AT=1070.05n

.meas tran vdout1_127ck1060 FIND v(dout1_127) AT=1070.05n

.meas tran vdout1_128ck1060 FIND v(dout1_128) AT=1070.05n

.meas tran vdout1_129ck1060 FIND v(dout1_129) AT=1070.05n

.meas tran vdout1_130ck1060 FIND v(dout1_130) AT=1070.05n

.meas tran vdout1_131ck1060 FIND v(dout1_131) AT=1070.05n

.meas tran vdout1_132ck1060 FIND v(dout1_132) AT=1070.05n

.meas tran vdout1_133ck1060 FIND v(dout1_133) AT=1070.05n

.meas tran vdout1_134ck1060 FIND v(dout1_134) AT=1070.05n

.meas tran vdout1_0ck1090 FIND v(dout1_0) AT=1100.05n

.meas tran vdout1_1ck1090 FIND v(dout1_1) AT=1100.05n

.meas tran vdout1_2ck1090 FIND v(dout1_2) AT=1100.05n

.meas tran vdout1_3ck1090 FIND v(dout1_3) AT=1100.05n

.meas tran vdout1_4ck1090 FIND v(dout1_4) AT=1100.05n

.meas tran vdout1_5ck1090 FIND v(dout1_5) AT=1100.05n

.meas tran vdout1_6ck1090 FIND v(dout1_6) AT=1100.05n

.meas tran vdout1_7ck1090 FIND v(dout1_7) AT=1100.05n

.meas tran vdout1_8ck1090 FIND v(dout1_8) AT=1100.05n

.meas tran vdout1_9ck1090 FIND v(dout1_9) AT=1100.05n

.meas tran vdout1_10ck1090 FIND v(dout1_10) AT=1100.05n

.meas tran vdout1_11ck1090 FIND v(dout1_11) AT=1100.05n

.meas tran vdout1_12ck1090 FIND v(dout1_12) AT=1100.05n

.meas tran vdout1_13ck1090 FIND v(dout1_13) AT=1100.05n

.meas tran vdout1_14ck1090 FIND v(dout1_14) AT=1100.05n

.meas tran vdout1_15ck1090 FIND v(dout1_15) AT=1100.05n

.meas tran vdout1_16ck1090 FIND v(dout1_16) AT=1100.05n

.meas tran vdout1_17ck1090 FIND v(dout1_17) AT=1100.05n

.meas tran vdout1_18ck1090 FIND v(dout1_18) AT=1100.05n

.meas tran vdout1_19ck1090 FIND v(dout1_19) AT=1100.05n

.meas tran vdout1_20ck1090 FIND v(dout1_20) AT=1100.05n

.meas tran vdout1_21ck1090 FIND v(dout1_21) AT=1100.05n

.meas tran vdout1_22ck1090 FIND v(dout1_22) AT=1100.05n

.meas tran vdout1_23ck1090 FIND v(dout1_23) AT=1100.05n

.meas tran vdout1_24ck1090 FIND v(dout1_24) AT=1100.05n

.meas tran vdout1_25ck1090 FIND v(dout1_25) AT=1100.05n

.meas tran vdout1_26ck1090 FIND v(dout1_26) AT=1100.05n

.meas tran vdout1_27ck1090 FIND v(dout1_27) AT=1100.05n

.meas tran vdout1_28ck1090 FIND v(dout1_28) AT=1100.05n

.meas tran vdout1_29ck1090 FIND v(dout1_29) AT=1100.05n

.meas tran vdout1_30ck1090 FIND v(dout1_30) AT=1100.05n

.meas tran vdout1_31ck1090 FIND v(dout1_31) AT=1100.05n

.meas tran vdout1_32ck1090 FIND v(dout1_32) AT=1100.05n

.meas tran vdout1_33ck1090 FIND v(dout1_33) AT=1100.05n

.meas tran vdout1_34ck1090 FIND v(dout1_34) AT=1100.05n

.meas tran vdout1_35ck1090 FIND v(dout1_35) AT=1100.05n

.meas tran vdout1_36ck1090 FIND v(dout1_36) AT=1100.05n

.meas tran vdout1_37ck1090 FIND v(dout1_37) AT=1100.05n

.meas tran vdout1_38ck1090 FIND v(dout1_38) AT=1100.05n

.meas tran vdout1_39ck1090 FIND v(dout1_39) AT=1100.05n

.meas tran vdout1_40ck1090 FIND v(dout1_40) AT=1100.05n

.meas tran vdout1_41ck1090 FIND v(dout1_41) AT=1100.05n

.meas tran vdout1_42ck1090 FIND v(dout1_42) AT=1100.05n

.meas tran vdout1_43ck1090 FIND v(dout1_43) AT=1100.05n

.meas tran vdout1_44ck1090 FIND v(dout1_44) AT=1100.05n

.meas tran vdout1_45ck1090 FIND v(dout1_45) AT=1100.05n

.meas tran vdout1_46ck1090 FIND v(dout1_46) AT=1100.05n

.meas tran vdout1_47ck1090 FIND v(dout1_47) AT=1100.05n

.meas tran vdout1_48ck1090 FIND v(dout1_48) AT=1100.05n

.meas tran vdout1_49ck1090 FIND v(dout1_49) AT=1100.05n

.meas tran vdout1_50ck1090 FIND v(dout1_50) AT=1100.05n

.meas tran vdout1_51ck1090 FIND v(dout1_51) AT=1100.05n

.meas tran vdout1_52ck1090 FIND v(dout1_52) AT=1100.05n

.meas tran vdout1_53ck1090 FIND v(dout1_53) AT=1100.05n

.meas tran vdout1_54ck1090 FIND v(dout1_54) AT=1100.05n

.meas tran vdout1_55ck1090 FIND v(dout1_55) AT=1100.05n

.meas tran vdout1_56ck1090 FIND v(dout1_56) AT=1100.05n

.meas tran vdout1_57ck1090 FIND v(dout1_57) AT=1100.05n

.meas tran vdout1_58ck1090 FIND v(dout1_58) AT=1100.05n

.meas tran vdout1_59ck1090 FIND v(dout1_59) AT=1100.05n

.meas tran vdout1_60ck1090 FIND v(dout1_60) AT=1100.05n

.meas tran vdout1_61ck1090 FIND v(dout1_61) AT=1100.05n

.meas tran vdout1_62ck1090 FIND v(dout1_62) AT=1100.05n

.meas tran vdout1_63ck1090 FIND v(dout1_63) AT=1100.05n

.meas tran vdout1_64ck1090 FIND v(dout1_64) AT=1100.05n

.meas tran vdout1_65ck1090 FIND v(dout1_65) AT=1100.05n

.meas tran vdout1_66ck1090 FIND v(dout1_66) AT=1100.05n

.meas tran vdout1_67ck1090 FIND v(dout1_67) AT=1100.05n

.meas tran vdout1_68ck1090 FIND v(dout1_68) AT=1100.05n

.meas tran vdout1_69ck1090 FIND v(dout1_69) AT=1100.05n

.meas tran vdout1_70ck1090 FIND v(dout1_70) AT=1100.05n

.meas tran vdout1_71ck1090 FIND v(dout1_71) AT=1100.05n

.meas tran vdout1_72ck1090 FIND v(dout1_72) AT=1100.05n

.meas tran vdout1_73ck1090 FIND v(dout1_73) AT=1100.05n

.meas tran vdout1_74ck1090 FIND v(dout1_74) AT=1100.05n

.meas tran vdout1_75ck1090 FIND v(dout1_75) AT=1100.05n

.meas tran vdout1_76ck1090 FIND v(dout1_76) AT=1100.05n

.meas tran vdout1_77ck1090 FIND v(dout1_77) AT=1100.05n

.meas tran vdout1_78ck1090 FIND v(dout1_78) AT=1100.05n

.meas tran vdout1_79ck1090 FIND v(dout1_79) AT=1100.05n

.meas tran vdout1_80ck1090 FIND v(dout1_80) AT=1100.05n

.meas tran vdout1_81ck1090 FIND v(dout1_81) AT=1100.05n

.meas tran vdout1_82ck1090 FIND v(dout1_82) AT=1100.05n

.meas tran vdout1_83ck1090 FIND v(dout1_83) AT=1100.05n

.meas tran vdout1_84ck1090 FIND v(dout1_84) AT=1100.05n

.meas tran vdout1_85ck1090 FIND v(dout1_85) AT=1100.05n

.meas tran vdout1_86ck1090 FIND v(dout1_86) AT=1100.05n

.meas tran vdout1_87ck1090 FIND v(dout1_87) AT=1100.05n

.meas tran vdout1_88ck1090 FIND v(dout1_88) AT=1100.05n

.meas tran vdout1_89ck1090 FIND v(dout1_89) AT=1100.05n

.meas tran vdout1_90ck1090 FIND v(dout1_90) AT=1100.05n

.meas tran vdout1_91ck1090 FIND v(dout1_91) AT=1100.05n

.meas tran vdout1_92ck1090 FIND v(dout1_92) AT=1100.05n

.meas tran vdout1_93ck1090 FIND v(dout1_93) AT=1100.05n

.meas tran vdout1_94ck1090 FIND v(dout1_94) AT=1100.05n

.meas tran vdout1_95ck1090 FIND v(dout1_95) AT=1100.05n

.meas tran vdout1_96ck1090 FIND v(dout1_96) AT=1100.05n

.meas tran vdout1_97ck1090 FIND v(dout1_97) AT=1100.05n

.meas tran vdout1_98ck1090 FIND v(dout1_98) AT=1100.05n

.meas tran vdout1_99ck1090 FIND v(dout1_99) AT=1100.05n

.meas tran vdout1_100ck1090 FIND v(dout1_100) AT=1100.05n

.meas tran vdout1_101ck1090 FIND v(dout1_101) AT=1100.05n

.meas tran vdout1_102ck1090 FIND v(dout1_102) AT=1100.05n

.meas tran vdout1_103ck1090 FIND v(dout1_103) AT=1100.05n

.meas tran vdout1_104ck1090 FIND v(dout1_104) AT=1100.05n

.meas tran vdout1_105ck1090 FIND v(dout1_105) AT=1100.05n

.meas tran vdout1_106ck1090 FIND v(dout1_106) AT=1100.05n

.meas tran vdout1_107ck1090 FIND v(dout1_107) AT=1100.05n

.meas tran vdout1_108ck1090 FIND v(dout1_108) AT=1100.05n

.meas tran vdout1_109ck1090 FIND v(dout1_109) AT=1100.05n

.meas tran vdout1_110ck1090 FIND v(dout1_110) AT=1100.05n

.meas tran vdout1_111ck1090 FIND v(dout1_111) AT=1100.05n

.meas tran vdout1_112ck1090 FIND v(dout1_112) AT=1100.05n

.meas tran vdout1_113ck1090 FIND v(dout1_113) AT=1100.05n

.meas tran vdout1_114ck1090 FIND v(dout1_114) AT=1100.05n

.meas tran vdout1_115ck1090 FIND v(dout1_115) AT=1100.05n

.meas tran vdout1_116ck1090 FIND v(dout1_116) AT=1100.05n

.meas tran vdout1_117ck1090 FIND v(dout1_117) AT=1100.05n

.meas tran vdout1_118ck1090 FIND v(dout1_118) AT=1100.05n

.meas tran vdout1_119ck1090 FIND v(dout1_119) AT=1100.05n

.meas tran vdout1_120ck1090 FIND v(dout1_120) AT=1100.05n

.meas tran vdout1_121ck1090 FIND v(dout1_121) AT=1100.05n

.meas tran vdout1_122ck1090 FIND v(dout1_122) AT=1100.05n

.meas tran vdout1_123ck1090 FIND v(dout1_123) AT=1100.05n

.meas tran vdout1_124ck1090 FIND v(dout1_124) AT=1100.05n

.meas tran vdout1_125ck1090 FIND v(dout1_125) AT=1100.05n

.meas tran vdout1_126ck1090 FIND v(dout1_126) AT=1100.05n

.meas tran vdout1_127ck1090 FIND v(dout1_127) AT=1100.05n

.meas tran vdout1_128ck1090 FIND v(dout1_128) AT=1100.05n

.meas tran vdout1_129ck1090 FIND v(dout1_129) AT=1100.05n

.meas tran vdout1_130ck1090 FIND v(dout1_130) AT=1100.05n

.meas tran vdout1_131ck1090 FIND v(dout1_131) AT=1100.05n

.meas tran vdout1_132ck1090 FIND v(dout1_132) AT=1100.05n

.meas tran vdout1_133ck1090 FIND v(dout1_133) AT=1100.05n

.meas tran vdout1_134ck1090 FIND v(dout1_134) AT=1100.05n

.meas tran vdout1_0ck1100 FIND v(dout1_0) AT=1110.05n

.meas tran vdout1_1ck1100 FIND v(dout1_1) AT=1110.05n

.meas tran vdout1_2ck1100 FIND v(dout1_2) AT=1110.05n

.meas tran vdout1_3ck1100 FIND v(dout1_3) AT=1110.05n

.meas tran vdout1_4ck1100 FIND v(dout1_4) AT=1110.05n

.meas tran vdout1_5ck1100 FIND v(dout1_5) AT=1110.05n

.meas tran vdout1_6ck1100 FIND v(dout1_6) AT=1110.05n

.meas tran vdout1_7ck1100 FIND v(dout1_7) AT=1110.05n

.meas tran vdout1_8ck1100 FIND v(dout1_8) AT=1110.05n

.meas tran vdout1_9ck1100 FIND v(dout1_9) AT=1110.05n

.meas tran vdout1_10ck1100 FIND v(dout1_10) AT=1110.05n

.meas tran vdout1_11ck1100 FIND v(dout1_11) AT=1110.05n

.meas tran vdout1_12ck1100 FIND v(dout1_12) AT=1110.05n

.meas tran vdout1_13ck1100 FIND v(dout1_13) AT=1110.05n

.meas tran vdout1_14ck1100 FIND v(dout1_14) AT=1110.05n

.meas tran vdout1_15ck1100 FIND v(dout1_15) AT=1110.05n

.meas tran vdout1_16ck1100 FIND v(dout1_16) AT=1110.05n

.meas tran vdout1_17ck1100 FIND v(dout1_17) AT=1110.05n

.meas tran vdout1_18ck1100 FIND v(dout1_18) AT=1110.05n

.meas tran vdout1_19ck1100 FIND v(dout1_19) AT=1110.05n

.meas tran vdout1_20ck1100 FIND v(dout1_20) AT=1110.05n

.meas tran vdout1_21ck1100 FIND v(dout1_21) AT=1110.05n

.meas tran vdout1_22ck1100 FIND v(dout1_22) AT=1110.05n

.meas tran vdout1_23ck1100 FIND v(dout1_23) AT=1110.05n

.meas tran vdout1_24ck1100 FIND v(dout1_24) AT=1110.05n

.meas tran vdout1_25ck1100 FIND v(dout1_25) AT=1110.05n

.meas tran vdout1_26ck1100 FIND v(dout1_26) AT=1110.05n

.meas tran vdout1_27ck1100 FIND v(dout1_27) AT=1110.05n

.meas tran vdout1_28ck1100 FIND v(dout1_28) AT=1110.05n

.meas tran vdout1_29ck1100 FIND v(dout1_29) AT=1110.05n

.meas tran vdout1_30ck1100 FIND v(dout1_30) AT=1110.05n

.meas tran vdout1_31ck1100 FIND v(dout1_31) AT=1110.05n

.meas tran vdout1_32ck1100 FIND v(dout1_32) AT=1110.05n

.meas tran vdout1_33ck1100 FIND v(dout1_33) AT=1110.05n

.meas tran vdout1_34ck1100 FIND v(dout1_34) AT=1110.05n

.meas tran vdout1_35ck1100 FIND v(dout1_35) AT=1110.05n

.meas tran vdout1_36ck1100 FIND v(dout1_36) AT=1110.05n

.meas tran vdout1_37ck1100 FIND v(dout1_37) AT=1110.05n

.meas tran vdout1_38ck1100 FIND v(dout1_38) AT=1110.05n

.meas tran vdout1_39ck1100 FIND v(dout1_39) AT=1110.05n

.meas tran vdout1_40ck1100 FIND v(dout1_40) AT=1110.05n

.meas tran vdout1_41ck1100 FIND v(dout1_41) AT=1110.05n

.meas tran vdout1_42ck1100 FIND v(dout1_42) AT=1110.05n

.meas tran vdout1_43ck1100 FIND v(dout1_43) AT=1110.05n

.meas tran vdout1_44ck1100 FIND v(dout1_44) AT=1110.05n

.meas tran vdout1_45ck1100 FIND v(dout1_45) AT=1110.05n

.meas tran vdout1_46ck1100 FIND v(dout1_46) AT=1110.05n

.meas tran vdout1_47ck1100 FIND v(dout1_47) AT=1110.05n

.meas tran vdout1_48ck1100 FIND v(dout1_48) AT=1110.05n

.meas tran vdout1_49ck1100 FIND v(dout1_49) AT=1110.05n

.meas tran vdout1_50ck1100 FIND v(dout1_50) AT=1110.05n

.meas tran vdout1_51ck1100 FIND v(dout1_51) AT=1110.05n

.meas tran vdout1_52ck1100 FIND v(dout1_52) AT=1110.05n

.meas tran vdout1_53ck1100 FIND v(dout1_53) AT=1110.05n

.meas tran vdout1_54ck1100 FIND v(dout1_54) AT=1110.05n

.meas tran vdout1_55ck1100 FIND v(dout1_55) AT=1110.05n

.meas tran vdout1_56ck1100 FIND v(dout1_56) AT=1110.05n

.meas tran vdout1_57ck1100 FIND v(dout1_57) AT=1110.05n

.meas tran vdout1_58ck1100 FIND v(dout1_58) AT=1110.05n

.meas tran vdout1_59ck1100 FIND v(dout1_59) AT=1110.05n

.meas tran vdout1_60ck1100 FIND v(dout1_60) AT=1110.05n

.meas tran vdout1_61ck1100 FIND v(dout1_61) AT=1110.05n

.meas tran vdout1_62ck1100 FIND v(dout1_62) AT=1110.05n

.meas tran vdout1_63ck1100 FIND v(dout1_63) AT=1110.05n

.meas tran vdout1_64ck1100 FIND v(dout1_64) AT=1110.05n

.meas tran vdout1_65ck1100 FIND v(dout1_65) AT=1110.05n

.meas tran vdout1_66ck1100 FIND v(dout1_66) AT=1110.05n

.meas tran vdout1_67ck1100 FIND v(dout1_67) AT=1110.05n

.meas tran vdout1_68ck1100 FIND v(dout1_68) AT=1110.05n

.meas tran vdout1_69ck1100 FIND v(dout1_69) AT=1110.05n

.meas tran vdout1_70ck1100 FIND v(dout1_70) AT=1110.05n

.meas tran vdout1_71ck1100 FIND v(dout1_71) AT=1110.05n

.meas tran vdout1_72ck1100 FIND v(dout1_72) AT=1110.05n

.meas tran vdout1_73ck1100 FIND v(dout1_73) AT=1110.05n

.meas tran vdout1_74ck1100 FIND v(dout1_74) AT=1110.05n

.meas tran vdout1_75ck1100 FIND v(dout1_75) AT=1110.05n

.meas tran vdout1_76ck1100 FIND v(dout1_76) AT=1110.05n

.meas tran vdout1_77ck1100 FIND v(dout1_77) AT=1110.05n

.meas tran vdout1_78ck1100 FIND v(dout1_78) AT=1110.05n

.meas tran vdout1_79ck1100 FIND v(dout1_79) AT=1110.05n

.meas tran vdout1_80ck1100 FIND v(dout1_80) AT=1110.05n

.meas tran vdout1_81ck1100 FIND v(dout1_81) AT=1110.05n

.meas tran vdout1_82ck1100 FIND v(dout1_82) AT=1110.05n

.meas tran vdout1_83ck1100 FIND v(dout1_83) AT=1110.05n

.meas tran vdout1_84ck1100 FIND v(dout1_84) AT=1110.05n

.meas tran vdout1_85ck1100 FIND v(dout1_85) AT=1110.05n

.meas tran vdout1_86ck1100 FIND v(dout1_86) AT=1110.05n

.meas tran vdout1_87ck1100 FIND v(dout1_87) AT=1110.05n

.meas tran vdout1_88ck1100 FIND v(dout1_88) AT=1110.05n

.meas tran vdout1_89ck1100 FIND v(dout1_89) AT=1110.05n

.meas tran vdout1_90ck1100 FIND v(dout1_90) AT=1110.05n

.meas tran vdout1_91ck1100 FIND v(dout1_91) AT=1110.05n

.meas tran vdout1_92ck1100 FIND v(dout1_92) AT=1110.05n

.meas tran vdout1_93ck1100 FIND v(dout1_93) AT=1110.05n

.meas tran vdout1_94ck1100 FIND v(dout1_94) AT=1110.05n

.meas tran vdout1_95ck1100 FIND v(dout1_95) AT=1110.05n

.meas tran vdout1_96ck1100 FIND v(dout1_96) AT=1110.05n

.meas tran vdout1_97ck1100 FIND v(dout1_97) AT=1110.05n

.meas tran vdout1_98ck1100 FIND v(dout1_98) AT=1110.05n

.meas tran vdout1_99ck1100 FIND v(dout1_99) AT=1110.05n

.meas tran vdout1_100ck1100 FIND v(dout1_100) AT=1110.05n

.meas tran vdout1_101ck1100 FIND v(dout1_101) AT=1110.05n

.meas tran vdout1_102ck1100 FIND v(dout1_102) AT=1110.05n

.meas tran vdout1_103ck1100 FIND v(dout1_103) AT=1110.05n

.meas tran vdout1_104ck1100 FIND v(dout1_104) AT=1110.05n

.meas tran vdout1_105ck1100 FIND v(dout1_105) AT=1110.05n

.meas tran vdout1_106ck1100 FIND v(dout1_106) AT=1110.05n

.meas tran vdout1_107ck1100 FIND v(dout1_107) AT=1110.05n

.meas tran vdout1_108ck1100 FIND v(dout1_108) AT=1110.05n

.meas tran vdout1_109ck1100 FIND v(dout1_109) AT=1110.05n

.meas tran vdout1_110ck1100 FIND v(dout1_110) AT=1110.05n

.meas tran vdout1_111ck1100 FIND v(dout1_111) AT=1110.05n

.meas tran vdout1_112ck1100 FIND v(dout1_112) AT=1110.05n

.meas tran vdout1_113ck1100 FIND v(dout1_113) AT=1110.05n

.meas tran vdout1_114ck1100 FIND v(dout1_114) AT=1110.05n

.meas tran vdout1_115ck1100 FIND v(dout1_115) AT=1110.05n

.meas tran vdout1_116ck1100 FIND v(dout1_116) AT=1110.05n

.meas tran vdout1_117ck1100 FIND v(dout1_117) AT=1110.05n

.meas tran vdout1_118ck1100 FIND v(dout1_118) AT=1110.05n

.meas tran vdout1_119ck1100 FIND v(dout1_119) AT=1110.05n

.meas tran vdout1_120ck1100 FIND v(dout1_120) AT=1110.05n

.meas tran vdout1_121ck1100 FIND v(dout1_121) AT=1110.05n

.meas tran vdout1_122ck1100 FIND v(dout1_122) AT=1110.05n

.meas tran vdout1_123ck1100 FIND v(dout1_123) AT=1110.05n

.meas tran vdout1_124ck1100 FIND v(dout1_124) AT=1110.05n

.meas tran vdout1_125ck1100 FIND v(dout1_125) AT=1110.05n

.meas tran vdout1_126ck1100 FIND v(dout1_126) AT=1110.05n

.meas tran vdout1_127ck1100 FIND v(dout1_127) AT=1110.05n

.meas tran vdout1_128ck1100 FIND v(dout1_128) AT=1110.05n

.meas tran vdout1_129ck1100 FIND v(dout1_129) AT=1110.05n

.meas tran vdout1_130ck1100 FIND v(dout1_130) AT=1110.05n

.meas tran vdout1_131ck1100 FIND v(dout1_131) AT=1110.05n

.meas tran vdout1_132ck1100 FIND v(dout1_132) AT=1110.05n

.meas tran vdout1_133ck1100 FIND v(dout1_133) AT=1110.05n

.meas tran vdout1_134ck1100 FIND v(dout1_134) AT=1110.05n

.meas tran vdout1_0ck1140 FIND v(dout1_0) AT=1150.05n

.meas tran vdout1_1ck1140 FIND v(dout1_1) AT=1150.05n

.meas tran vdout1_2ck1140 FIND v(dout1_2) AT=1150.05n

.meas tran vdout1_3ck1140 FIND v(dout1_3) AT=1150.05n

.meas tran vdout1_4ck1140 FIND v(dout1_4) AT=1150.05n

.meas tran vdout1_5ck1140 FIND v(dout1_5) AT=1150.05n

.meas tran vdout1_6ck1140 FIND v(dout1_6) AT=1150.05n

.meas tran vdout1_7ck1140 FIND v(dout1_7) AT=1150.05n

.meas tran vdout1_8ck1140 FIND v(dout1_8) AT=1150.05n

.meas tran vdout1_9ck1140 FIND v(dout1_9) AT=1150.05n

.meas tran vdout1_10ck1140 FIND v(dout1_10) AT=1150.05n

.meas tran vdout1_11ck1140 FIND v(dout1_11) AT=1150.05n

.meas tran vdout1_12ck1140 FIND v(dout1_12) AT=1150.05n

.meas tran vdout1_13ck1140 FIND v(dout1_13) AT=1150.05n

.meas tran vdout1_14ck1140 FIND v(dout1_14) AT=1150.05n

.meas tran vdout1_15ck1140 FIND v(dout1_15) AT=1150.05n

.meas tran vdout1_16ck1140 FIND v(dout1_16) AT=1150.05n

.meas tran vdout1_17ck1140 FIND v(dout1_17) AT=1150.05n

.meas tran vdout1_18ck1140 FIND v(dout1_18) AT=1150.05n

.meas tran vdout1_19ck1140 FIND v(dout1_19) AT=1150.05n

.meas tran vdout1_20ck1140 FIND v(dout1_20) AT=1150.05n

.meas tran vdout1_21ck1140 FIND v(dout1_21) AT=1150.05n

.meas tran vdout1_22ck1140 FIND v(dout1_22) AT=1150.05n

.meas tran vdout1_23ck1140 FIND v(dout1_23) AT=1150.05n

.meas tran vdout1_24ck1140 FIND v(dout1_24) AT=1150.05n

.meas tran vdout1_25ck1140 FIND v(dout1_25) AT=1150.05n

.meas tran vdout1_26ck1140 FIND v(dout1_26) AT=1150.05n

.meas tran vdout1_27ck1140 FIND v(dout1_27) AT=1150.05n

.meas tran vdout1_28ck1140 FIND v(dout1_28) AT=1150.05n

.meas tran vdout1_29ck1140 FIND v(dout1_29) AT=1150.05n

.meas tran vdout1_30ck1140 FIND v(dout1_30) AT=1150.05n

.meas tran vdout1_31ck1140 FIND v(dout1_31) AT=1150.05n

.meas tran vdout1_32ck1140 FIND v(dout1_32) AT=1150.05n

.meas tran vdout1_33ck1140 FIND v(dout1_33) AT=1150.05n

.meas tran vdout1_34ck1140 FIND v(dout1_34) AT=1150.05n

.meas tran vdout1_35ck1140 FIND v(dout1_35) AT=1150.05n

.meas tran vdout1_36ck1140 FIND v(dout1_36) AT=1150.05n

.meas tran vdout1_37ck1140 FIND v(dout1_37) AT=1150.05n

.meas tran vdout1_38ck1140 FIND v(dout1_38) AT=1150.05n

.meas tran vdout1_39ck1140 FIND v(dout1_39) AT=1150.05n

.meas tran vdout1_40ck1140 FIND v(dout1_40) AT=1150.05n

.meas tran vdout1_41ck1140 FIND v(dout1_41) AT=1150.05n

.meas tran vdout1_42ck1140 FIND v(dout1_42) AT=1150.05n

.meas tran vdout1_43ck1140 FIND v(dout1_43) AT=1150.05n

.meas tran vdout1_44ck1140 FIND v(dout1_44) AT=1150.05n

.meas tran vdout1_45ck1140 FIND v(dout1_45) AT=1150.05n

.meas tran vdout1_46ck1140 FIND v(dout1_46) AT=1150.05n

.meas tran vdout1_47ck1140 FIND v(dout1_47) AT=1150.05n

.meas tran vdout1_48ck1140 FIND v(dout1_48) AT=1150.05n

.meas tran vdout1_49ck1140 FIND v(dout1_49) AT=1150.05n

.meas tran vdout1_50ck1140 FIND v(dout1_50) AT=1150.05n

.meas tran vdout1_51ck1140 FIND v(dout1_51) AT=1150.05n

.meas tran vdout1_52ck1140 FIND v(dout1_52) AT=1150.05n

.meas tran vdout1_53ck1140 FIND v(dout1_53) AT=1150.05n

.meas tran vdout1_54ck1140 FIND v(dout1_54) AT=1150.05n

.meas tran vdout1_55ck1140 FIND v(dout1_55) AT=1150.05n

.meas tran vdout1_56ck1140 FIND v(dout1_56) AT=1150.05n

.meas tran vdout1_57ck1140 FIND v(dout1_57) AT=1150.05n

.meas tran vdout1_58ck1140 FIND v(dout1_58) AT=1150.05n

.meas tran vdout1_59ck1140 FIND v(dout1_59) AT=1150.05n

.meas tran vdout1_60ck1140 FIND v(dout1_60) AT=1150.05n

.meas tran vdout1_61ck1140 FIND v(dout1_61) AT=1150.05n

.meas tran vdout1_62ck1140 FIND v(dout1_62) AT=1150.05n

.meas tran vdout1_63ck1140 FIND v(dout1_63) AT=1150.05n

.meas tran vdout1_64ck1140 FIND v(dout1_64) AT=1150.05n

.meas tran vdout1_65ck1140 FIND v(dout1_65) AT=1150.05n

.meas tran vdout1_66ck1140 FIND v(dout1_66) AT=1150.05n

.meas tran vdout1_67ck1140 FIND v(dout1_67) AT=1150.05n

.meas tran vdout1_68ck1140 FIND v(dout1_68) AT=1150.05n

.meas tran vdout1_69ck1140 FIND v(dout1_69) AT=1150.05n

.meas tran vdout1_70ck1140 FIND v(dout1_70) AT=1150.05n

.meas tran vdout1_71ck1140 FIND v(dout1_71) AT=1150.05n

.meas tran vdout1_72ck1140 FIND v(dout1_72) AT=1150.05n

.meas tran vdout1_73ck1140 FIND v(dout1_73) AT=1150.05n

.meas tran vdout1_74ck1140 FIND v(dout1_74) AT=1150.05n

.meas tran vdout1_75ck1140 FIND v(dout1_75) AT=1150.05n

.meas tran vdout1_76ck1140 FIND v(dout1_76) AT=1150.05n

.meas tran vdout1_77ck1140 FIND v(dout1_77) AT=1150.05n

.meas tran vdout1_78ck1140 FIND v(dout1_78) AT=1150.05n

.meas tran vdout1_79ck1140 FIND v(dout1_79) AT=1150.05n

.meas tran vdout1_80ck1140 FIND v(dout1_80) AT=1150.05n

.meas tran vdout1_81ck1140 FIND v(dout1_81) AT=1150.05n

.meas tran vdout1_82ck1140 FIND v(dout1_82) AT=1150.05n

.meas tran vdout1_83ck1140 FIND v(dout1_83) AT=1150.05n

.meas tran vdout1_84ck1140 FIND v(dout1_84) AT=1150.05n

.meas tran vdout1_85ck1140 FIND v(dout1_85) AT=1150.05n

.meas tran vdout1_86ck1140 FIND v(dout1_86) AT=1150.05n

.meas tran vdout1_87ck1140 FIND v(dout1_87) AT=1150.05n

.meas tran vdout1_88ck1140 FIND v(dout1_88) AT=1150.05n

.meas tran vdout1_89ck1140 FIND v(dout1_89) AT=1150.05n

.meas tran vdout1_90ck1140 FIND v(dout1_90) AT=1150.05n

.meas tran vdout1_91ck1140 FIND v(dout1_91) AT=1150.05n

.meas tran vdout1_92ck1140 FIND v(dout1_92) AT=1150.05n

.meas tran vdout1_93ck1140 FIND v(dout1_93) AT=1150.05n

.meas tran vdout1_94ck1140 FIND v(dout1_94) AT=1150.05n

.meas tran vdout1_95ck1140 FIND v(dout1_95) AT=1150.05n

.meas tran vdout1_96ck1140 FIND v(dout1_96) AT=1150.05n

.meas tran vdout1_97ck1140 FIND v(dout1_97) AT=1150.05n

.meas tran vdout1_98ck1140 FIND v(dout1_98) AT=1150.05n

.meas tran vdout1_99ck1140 FIND v(dout1_99) AT=1150.05n

.meas tran vdout1_100ck1140 FIND v(dout1_100) AT=1150.05n

.meas tran vdout1_101ck1140 FIND v(dout1_101) AT=1150.05n

.meas tran vdout1_102ck1140 FIND v(dout1_102) AT=1150.05n

.meas tran vdout1_103ck1140 FIND v(dout1_103) AT=1150.05n

.meas tran vdout1_104ck1140 FIND v(dout1_104) AT=1150.05n

.meas tran vdout1_105ck1140 FIND v(dout1_105) AT=1150.05n

.meas tran vdout1_106ck1140 FIND v(dout1_106) AT=1150.05n

.meas tran vdout1_107ck1140 FIND v(dout1_107) AT=1150.05n

.meas tran vdout1_108ck1140 FIND v(dout1_108) AT=1150.05n

.meas tran vdout1_109ck1140 FIND v(dout1_109) AT=1150.05n

.meas tran vdout1_110ck1140 FIND v(dout1_110) AT=1150.05n

.meas tran vdout1_111ck1140 FIND v(dout1_111) AT=1150.05n

.meas tran vdout1_112ck1140 FIND v(dout1_112) AT=1150.05n

.meas tran vdout1_113ck1140 FIND v(dout1_113) AT=1150.05n

.meas tran vdout1_114ck1140 FIND v(dout1_114) AT=1150.05n

.meas tran vdout1_115ck1140 FIND v(dout1_115) AT=1150.05n

.meas tran vdout1_116ck1140 FIND v(dout1_116) AT=1150.05n

.meas tran vdout1_117ck1140 FIND v(dout1_117) AT=1150.05n

.meas tran vdout1_118ck1140 FIND v(dout1_118) AT=1150.05n

.meas tran vdout1_119ck1140 FIND v(dout1_119) AT=1150.05n

.meas tran vdout1_120ck1140 FIND v(dout1_120) AT=1150.05n

.meas tran vdout1_121ck1140 FIND v(dout1_121) AT=1150.05n

.meas tran vdout1_122ck1140 FIND v(dout1_122) AT=1150.05n

.meas tran vdout1_123ck1140 FIND v(dout1_123) AT=1150.05n

.meas tran vdout1_124ck1140 FIND v(dout1_124) AT=1150.05n

.meas tran vdout1_125ck1140 FIND v(dout1_125) AT=1150.05n

.meas tran vdout1_126ck1140 FIND v(dout1_126) AT=1150.05n

.meas tran vdout1_127ck1140 FIND v(dout1_127) AT=1150.05n

.meas tran vdout1_128ck1140 FIND v(dout1_128) AT=1150.05n

.meas tran vdout1_129ck1140 FIND v(dout1_129) AT=1150.05n

.meas tran vdout1_130ck1140 FIND v(dout1_130) AT=1150.05n

.meas tran vdout1_131ck1140 FIND v(dout1_131) AT=1150.05n

.meas tran vdout1_132ck1140 FIND v(dout1_132) AT=1150.05n

.meas tran vdout1_133ck1140 FIND v(dout1_133) AT=1150.05n

.meas tran vdout1_134ck1140 FIND v(dout1_134) AT=1150.05n

.meas tran vdout1_0ck1210 FIND v(dout1_0) AT=1220.05n

.meas tran vdout1_1ck1210 FIND v(dout1_1) AT=1220.05n

.meas tran vdout1_2ck1210 FIND v(dout1_2) AT=1220.05n

.meas tran vdout1_3ck1210 FIND v(dout1_3) AT=1220.05n

.meas tran vdout1_4ck1210 FIND v(dout1_4) AT=1220.05n

.meas tran vdout1_5ck1210 FIND v(dout1_5) AT=1220.05n

.meas tran vdout1_6ck1210 FIND v(dout1_6) AT=1220.05n

.meas tran vdout1_7ck1210 FIND v(dout1_7) AT=1220.05n

.meas tran vdout1_8ck1210 FIND v(dout1_8) AT=1220.05n

.meas tran vdout1_9ck1210 FIND v(dout1_9) AT=1220.05n

.meas tran vdout1_10ck1210 FIND v(dout1_10) AT=1220.05n

.meas tran vdout1_11ck1210 FIND v(dout1_11) AT=1220.05n

.meas tran vdout1_12ck1210 FIND v(dout1_12) AT=1220.05n

.meas tran vdout1_13ck1210 FIND v(dout1_13) AT=1220.05n

.meas tran vdout1_14ck1210 FIND v(dout1_14) AT=1220.05n

.meas tran vdout1_15ck1210 FIND v(dout1_15) AT=1220.05n

.meas tran vdout1_16ck1210 FIND v(dout1_16) AT=1220.05n

.meas tran vdout1_17ck1210 FIND v(dout1_17) AT=1220.05n

.meas tran vdout1_18ck1210 FIND v(dout1_18) AT=1220.05n

.meas tran vdout1_19ck1210 FIND v(dout1_19) AT=1220.05n

.meas tran vdout1_20ck1210 FIND v(dout1_20) AT=1220.05n

.meas tran vdout1_21ck1210 FIND v(dout1_21) AT=1220.05n

.meas tran vdout1_22ck1210 FIND v(dout1_22) AT=1220.05n

.meas tran vdout1_23ck1210 FIND v(dout1_23) AT=1220.05n

.meas tran vdout1_24ck1210 FIND v(dout1_24) AT=1220.05n

.meas tran vdout1_25ck1210 FIND v(dout1_25) AT=1220.05n

.meas tran vdout1_26ck1210 FIND v(dout1_26) AT=1220.05n

.meas tran vdout1_27ck1210 FIND v(dout1_27) AT=1220.05n

.meas tran vdout1_28ck1210 FIND v(dout1_28) AT=1220.05n

.meas tran vdout1_29ck1210 FIND v(dout1_29) AT=1220.05n

.meas tran vdout1_30ck1210 FIND v(dout1_30) AT=1220.05n

.meas tran vdout1_31ck1210 FIND v(dout1_31) AT=1220.05n

.meas tran vdout1_32ck1210 FIND v(dout1_32) AT=1220.05n

.meas tran vdout1_33ck1210 FIND v(dout1_33) AT=1220.05n

.meas tran vdout1_34ck1210 FIND v(dout1_34) AT=1220.05n

.meas tran vdout1_35ck1210 FIND v(dout1_35) AT=1220.05n

.meas tran vdout1_36ck1210 FIND v(dout1_36) AT=1220.05n

.meas tran vdout1_37ck1210 FIND v(dout1_37) AT=1220.05n

.meas tran vdout1_38ck1210 FIND v(dout1_38) AT=1220.05n

.meas tran vdout1_39ck1210 FIND v(dout1_39) AT=1220.05n

.meas tran vdout1_40ck1210 FIND v(dout1_40) AT=1220.05n

.meas tran vdout1_41ck1210 FIND v(dout1_41) AT=1220.05n

.meas tran vdout1_42ck1210 FIND v(dout1_42) AT=1220.05n

.meas tran vdout1_43ck1210 FIND v(dout1_43) AT=1220.05n

.meas tran vdout1_44ck1210 FIND v(dout1_44) AT=1220.05n

.meas tran vdout1_45ck1210 FIND v(dout1_45) AT=1220.05n

.meas tran vdout1_46ck1210 FIND v(dout1_46) AT=1220.05n

.meas tran vdout1_47ck1210 FIND v(dout1_47) AT=1220.05n

.meas tran vdout1_48ck1210 FIND v(dout1_48) AT=1220.05n

.meas tran vdout1_49ck1210 FIND v(dout1_49) AT=1220.05n

.meas tran vdout1_50ck1210 FIND v(dout1_50) AT=1220.05n

.meas tran vdout1_51ck1210 FIND v(dout1_51) AT=1220.05n

.meas tran vdout1_52ck1210 FIND v(dout1_52) AT=1220.05n

.meas tran vdout1_53ck1210 FIND v(dout1_53) AT=1220.05n

.meas tran vdout1_54ck1210 FIND v(dout1_54) AT=1220.05n

.meas tran vdout1_55ck1210 FIND v(dout1_55) AT=1220.05n

.meas tran vdout1_56ck1210 FIND v(dout1_56) AT=1220.05n

.meas tran vdout1_57ck1210 FIND v(dout1_57) AT=1220.05n

.meas tran vdout1_58ck1210 FIND v(dout1_58) AT=1220.05n

.meas tran vdout1_59ck1210 FIND v(dout1_59) AT=1220.05n

.meas tran vdout1_60ck1210 FIND v(dout1_60) AT=1220.05n

.meas tran vdout1_61ck1210 FIND v(dout1_61) AT=1220.05n

.meas tran vdout1_62ck1210 FIND v(dout1_62) AT=1220.05n

.meas tran vdout1_63ck1210 FIND v(dout1_63) AT=1220.05n

.meas tran vdout1_64ck1210 FIND v(dout1_64) AT=1220.05n

.meas tran vdout1_65ck1210 FIND v(dout1_65) AT=1220.05n

.meas tran vdout1_66ck1210 FIND v(dout1_66) AT=1220.05n

.meas tran vdout1_67ck1210 FIND v(dout1_67) AT=1220.05n

.meas tran vdout1_68ck1210 FIND v(dout1_68) AT=1220.05n

.meas tran vdout1_69ck1210 FIND v(dout1_69) AT=1220.05n

.meas tran vdout1_70ck1210 FIND v(dout1_70) AT=1220.05n

.meas tran vdout1_71ck1210 FIND v(dout1_71) AT=1220.05n

.meas tran vdout1_72ck1210 FIND v(dout1_72) AT=1220.05n

.meas tran vdout1_73ck1210 FIND v(dout1_73) AT=1220.05n

.meas tran vdout1_74ck1210 FIND v(dout1_74) AT=1220.05n

.meas tran vdout1_75ck1210 FIND v(dout1_75) AT=1220.05n

.meas tran vdout1_76ck1210 FIND v(dout1_76) AT=1220.05n

.meas tran vdout1_77ck1210 FIND v(dout1_77) AT=1220.05n

.meas tran vdout1_78ck1210 FIND v(dout1_78) AT=1220.05n

.meas tran vdout1_79ck1210 FIND v(dout1_79) AT=1220.05n

.meas tran vdout1_80ck1210 FIND v(dout1_80) AT=1220.05n

.meas tran vdout1_81ck1210 FIND v(dout1_81) AT=1220.05n

.meas tran vdout1_82ck1210 FIND v(dout1_82) AT=1220.05n

.meas tran vdout1_83ck1210 FIND v(dout1_83) AT=1220.05n

.meas tran vdout1_84ck1210 FIND v(dout1_84) AT=1220.05n

.meas tran vdout1_85ck1210 FIND v(dout1_85) AT=1220.05n

.meas tran vdout1_86ck1210 FIND v(dout1_86) AT=1220.05n

.meas tran vdout1_87ck1210 FIND v(dout1_87) AT=1220.05n

.meas tran vdout1_88ck1210 FIND v(dout1_88) AT=1220.05n

.meas tran vdout1_89ck1210 FIND v(dout1_89) AT=1220.05n

.meas tran vdout1_90ck1210 FIND v(dout1_90) AT=1220.05n

.meas tran vdout1_91ck1210 FIND v(dout1_91) AT=1220.05n

.meas tran vdout1_92ck1210 FIND v(dout1_92) AT=1220.05n

.meas tran vdout1_93ck1210 FIND v(dout1_93) AT=1220.05n

.meas tran vdout1_94ck1210 FIND v(dout1_94) AT=1220.05n

.meas tran vdout1_95ck1210 FIND v(dout1_95) AT=1220.05n

.meas tran vdout1_96ck1210 FIND v(dout1_96) AT=1220.05n

.meas tran vdout1_97ck1210 FIND v(dout1_97) AT=1220.05n

.meas tran vdout1_98ck1210 FIND v(dout1_98) AT=1220.05n

.meas tran vdout1_99ck1210 FIND v(dout1_99) AT=1220.05n

.meas tran vdout1_100ck1210 FIND v(dout1_100) AT=1220.05n

.meas tran vdout1_101ck1210 FIND v(dout1_101) AT=1220.05n

.meas tran vdout1_102ck1210 FIND v(dout1_102) AT=1220.05n

.meas tran vdout1_103ck1210 FIND v(dout1_103) AT=1220.05n

.meas tran vdout1_104ck1210 FIND v(dout1_104) AT=1220.05n

.meas tran vdout1_105ck1210 FIND v(dout1_105) AT=1220.05n

.meas tran vdout1_106ck1210 FIND v(dout1_106) AT=1220.05n

.meas tran vdout1_107ck1210 FIND v(dout1_107) AT=1220.05n

.meas tran vdout1_108ck1210 FIND v(dout1_108) AT=1220.05n

.meas tran vdout1_109ck1210 FIND v(dout1_109) AT=1220.05n

.meas tran vdout1_110ck1210 FIND v(dout1_110) AT=1220.05n

.meas tran vdout1_111ck1210 FIND v(dout1_111) AT=1220.05n

.meas tran vdout1_112ck1210 FIND v(dout1_112) AT=1220.05n

.meas tran vdout1_113ck1210 FIND v(dout1_113) AT=1220.05n

.meas tran vdout1_114ck1210 FIND v(dout1_114) AT=1220.05n

.meas tran vdout1_115ck1210 FIND v(dout1_115) AT=1220.05n

.meas tran vdout1_116ck1210 FIND v(dout1_116) AT=1220.05n

.meas tran vdout1_117ck1210 FIND v(dout1_117) AT=1220.05n

.meas tran vdout1_118ck1210 FIND v(dout1_118) AT=1220.05n

.meas tran vdout1_119ck1210 FIND v(dout1_119) AT=1220.05n

.meas tran vdout1_120ck1210 FIND v(dout1_120) AT=1220.05n

.meas tran vdout1_121ck1210 FIND v(dout1_121) AT=1220.05n

.meas tran vdout1_122ck1210 FIND v(dout1_122) AT=1220.05n

.meas tran vdout1_123ck1210 FIND v(dout1_123) AT=1220.05n

.meas tran vdout1_124ck1210 FIND v(dout1_124) AT=1220.05n

.meas tran vdout1_125ck1210 FIND v(dout1_125) AT=1220.05n

.meas tran vdout1_126ck1210 FIND v(dout1_126) AT=1220.05n

.meas tran vdout1_127ck1210 FIND v(dout1_127) AT=1220.05n

.meas tran vdout1_128ck1210 FIND v(dout1_128) AT=1220.05n

.meas tran vdout1_129ck1210 FIND v(dout1_129) AT=1220.05n

.meas tran vdout1_130ck1210 FIND v(dout1_130) AT=1220.05n

.meas tran vdout1_131ck1210 FIND v(dout1_131) AT=1220.05n

.meas tran vdout1_132ck1210 FIND v(dout1_132) AT=1220.05n

.meas tran vdout1_133ck1210 FIND v(dout1_133) AT=1220.05n

.meas tran vdout1_134ck1210 FIND v(dout1_134) AT=1220.05n

.meas tran vdout1_0ck1230 FIND v(dout1_0) AT=1240.05n

.meas tran vdout1_1ck1230 FIND v(dout1_1) AT=1240.05n

.meas tran vdout1_2ck1230 FIND v(dout1_2) AT=1240.05n

.meas tran vdout1_3ck1230 FIND v(dout1_3) AT=1240.05n

.meas tran vdout1_4ck1230 FIND v(dout1_4) AT=1240.05n

.meas tran vdout1_5ck1230 FIND v(dout1_5) AT=1240.05n

.meas tran vdout1_6ck1230 FIND v(dout1_6) AT=1240.05n

.meas tran vdout1_7ck1230 FIND v(dout1_7) AT=1240.05n

.meas tran vdout1_8ck1230 FIND v(dout1_8) AT=1240.05n

.meas tran vdout1_9ck1230 FIND v(dout1_9) AT=1240.05n

.meas tran vdout1_10ck1230 FIND v(dout1_10) AT=1240.05n

.meas tran vdout1_11ck1230 FIND v(dout1_11) AT=1240.05n

.meas tran vdout1_12ck1230 FIND v(dout1_12) AT=1240.05n

.meas tran vdout1_13ck1230 FIND v(dout1_13) AT=1240.05n

.meas tran vdout1_14ck1230 FIND v(dout1_14) AT=1240.05n

.meas tran vdout1_15ck1230 FIND v(dout1_15) AT=1240.05n

.meas tran vdout1_16ck1230 FIND v(dout1_16) AT=1240.05n

.meas tran vdout1_17ck1230 FIND v(dout1_17) AT=1240.05n

.meas tran vdout1_18ck1230 FIND v(dout1_18) AT=1240.05n

.meas tran vdout1_19ck1230 FIND v(dout1_19) AT=1240.05n

.meas tran vdout1_20ck1230 FIND v(dout1_20) AT=1240.05n

.meas tran vdout1_21ck1230 FIND v(dout1_21) AT=1240.05n

.meas tran vdout1_22ck1230 FIND v(dout1_22) AT=1240.05n

.meas tran vdout1_23ck1230 FIND v(dout1_23) AT=1240.05n

.meas tran vdout1_24ck1230 FIND v(dout1_24) AT=1240.05n

.meas tran vdout1_25ck1230 FIND v(dout1_25) AT=1240.05n

.meas tran vdout1_26ck1230 FIND v(dout1_26) AT=1240.05n

.meas tran vdout1_27ck1230 FIND v(dout1_27) AT=1240.05n

.meas tran vdout1_28ck1230 FIND v(dout1_28) AT=1240.05n

.meas tran vdout1_29ck1230 FIND v(dout1_29) AT=1240.05n

.meas tran vdout1_30ck1230 FIND v(dout1_30) AT=1240.05n

.meas tran vdout1_31ck1230 FIND v(dout1_31) AT=1240.05n

.meas tran vdout1_32ck1230 FIND v(dout1_32) AT=1240.05n

.meas tran vdout1_33ck1230 FIND v(dout1_33) AT=1240.05n

.meas tran vdout1_34ck1230 FIND v(dout1_34) AT=1240.05n

.meas tran vdout1_35ck1230 FIND v(dout1_35) AT=1240.05n

.meas tran vdout1_36ck1230 FIND v(dout1_36) AT=1240.05n

.meas tran vdout1_37ck1230 FIND v(dout1_37) AT=1240.05n

.meas tran vdout1_38ck1230 FIND v(dout1_38) AT=1240.05n

.meas tran vdout1_39ck1230 FIND v(dout1_39) AT=1240.05n

.meas tran vdout1_40ck1230 FIND v(dout1_40) AT=1240.05n

.meas tran vdout1_41ck1230 FIND v(dout1_41) AT=1240.05n

.meas tran vdout1_42ck1230 FIND v(dout1_42) AT=1240.05n

.meas tran vdout1_43ck1230 FIND v(dout1_43) AT=1240.05n

.meas tran vdout1_44ck1230 FIND v(dout1_44) AT=1240.05n

.meas tran vdout1_45ck1230 FIND v(dout1_45) AT=1240.05n

.meas tran vdout1_46ck1230 FIND v(dout1_46) AT=1240.05n

.meas tran vdout1_47ck1230 FIND v(dout1_47) AT=1240.05n

.meas tran vdout1_48ck1230 FIND v(dout1_48) AT=1240.05n

.meas tran vdout1_49ck1230 FIND v(dout1_49) AT=1240.05n

.meas tran vdout1_50ck1230 FIND v(dout1_50) AT=1240.05n

.meas tran vdout1_51ck1230 FIND v(dout1_51) AT=1240.05n

.meas tran vdout1_52ck1230 FIND v(dout1_52) AT=1240.05n

.meas tran vdout1_53ck1230 FIND v(dout1_53) AT=1240.05n

.meas tran vdout1_54ck1230 FIND v(dout1_54) AT=1240.05n

.meas tran vdout1_55ck1230 FIND v(dout1_55) AT=1240.05n

.meas tran vdout1_56ck1230 FIND v(dout1_56) AT=1240.05n

.meas tran vdout1_57ck1230 FIND v(dout1_57) AT=1240.05n

.meas tran vdout1_58ck1230 FIND v(dout1_58) AT=1240.05n

.meas tran vdout1_59ck1230 FIND v(dout1_59) AT=1240.05n

.meas tran vdout1_60ck1230 FIND v(dout1_60) AT=1240.05n

.meas tran vdout1_61ck1230 FIND v(dout1_61) AT=1240.05n

.meas tran vdout1_62ck1230 FIND v(dout1_62) AT=1240.05n

.meas tran vdout1_63ck1230 FIND v(dout1_63) AT=1240.05n

.meas tran vdout1_64ck1230 FIND v(dout1_64) AT=1240.05n

.meas tran vdout1_65ck1230 FIND v(dout1_65) AT=1240.05n

.meas tran vdout1_66ck1230 FIND v(dout1_66) AT=1240.05n

.meas tran vdout1_67ck1230 FIND v(dout1_67) AT=1240.05n

.meas tran vdout1_68ck1230 FIND v(dout1_68) AT=1240.05n

.meas tran vdout1_69ck1230 FIND v(dout1_69) AT=1240.05n

.meas tran vdout1_70ck1230 FIND v(dout1_70) AT=1240.05n

.meas tran vdout1_71ck1230 FIND v(dout1_71) AT=1240.05n

.meas tran vdout1_72ck1230 FIND v(dout1_72) AT=1240.05n

.meas tran vdout1_73ck1230 FIND v(dout1_73) AT=1240.05n

.meas tran vdout1_74ck1230 FIND v(dout1_74) AT=1240.05n

.meas tran vdout1_75ck1230 FIND v(dout1_75) AT=1240.05n

.meas tran vdout1_76ck1230 FIND v(dout1_76) AT=1240.05n

.meas tran vdout1_77ck1230 FIND v(dout1_77) AT=1240.05n

.meas tran vdout1_78ck1230 FIND v(dout1_78) AT=1240.05n

.meas tran vdout1_79ck1230 FIND v(dout1_79) AT=1240.05n

.meas tran vdout1_80ck1230 FIND v(dout1_80) AT=1240.05n

.meas tran vdout1_81ck1230 FIND v(dout1_81) AT=1240.05n

.meas tran vdout1_82ck1230 FIND v(dout1_82) AT=1240.05n

.meas tran vdout1_83ck1230 FIND v(dout1_83) AT=1240.05n

.meas tran vdout1_84ck1230 FIND v(dout1_84) AT=1240.05n

.meas tran vdout1_85ck1230 FIND v(dout1_85) AT=1240.05n

.meas tran vdout1_86ck1230 FIND v(dout1_86) AT=1240.05n

.meas tran vdout1_87ck1230 FIND v(dout1_87) AT=1240.05n

.meas tran vdout1_88ck1230 FIND v(dout1_88) AT=1240.05n

.meas tran vdout1_89ck1230 FIND v(dout1_89) AT=1240.05n

.meas tran vdout1_90ck1230 FIND v(dout1_90) AT=1240.05n

.meas tran vdout1_91ck1230 FIND v(dout1_91) AT=1240.05n

.meas tran vdout1_92ck1230 FIND v(dout1_92) AT=1240.05n

.meas tran vdout1_93ck1230 FIND v(dout1_93) AT=1240.05n

.meas tran vdout1_94ck1230 FIND v(dout1_94) AT=1240.05n

.meas tran vdout1_95ck1230 FIND v(dout1_95) AT=1240.05n

.meas tran vdout1_96ck1230 FIND v(dout1_96) AT=1240.05n

.meas tran vdout1_97ck1230 FIND v(dout1_97) AT=1240.05n

.meas tran vdout1_98ck1230 FIND v(dout1_98) AT=1240.05n

.meas tran vdout1_99ck1230 FIND v(dout1_99) AT=1240.05n

.meas tran vdout1_100ck1230 FIND v(dout1_100) AT=1240.05n

.meas tran vdout1_101ck1230 FIND v(dout1_101) AT=1240.05n

.meas tran vdout1_102ck1230 FIND v(dout1_102) AT=1240.05n

.meas tran vdout1_103ck1230 FIND v(dout1_103) AT=1240.05n

.meas tran vdout1_104ck1230 FIND v(dout1_104) AT=1240.05n

.meas tran vdout1_105ck1230 FIND v(dout1_105) AT=1240.05n

.meas tran vdout1_106ck1230 FIND v(dout1_106) AT=1240.05n

.meas tran vdout1_107ck1230 FIND v(dout1_107) AT=1240.05n

.meas tran vdout1_108ck1230 FIND v(dout1_108) AT=1240.05n

.meas tran vdout1_109ck1230 FIND v(dout1_109) AT=1240.05n

.meas tran vdout1_110ck1230 FIND v(dout1_110) AT=1240.05n

.meas tran vdout1_111ck1230 FIND v(dout1_111) AT=1240.05n

.meas tran vdout1_112ck1230 FIND v(dout1_112) AT=1240.05n

.meas tran vdout1_113ck1230 FIND v(dout1_113) AT=1240.05n

.meas tran vdout1_114ck1230 FIND v(dout1_114) AT=1240.05n

.meas tran vdout1_115ck1230 FIND v(dout1_115) AT=1240.05n

.meas tran vdout1_116ck1230 FIND v(dout1_116) AT=1240.05n

.meas tran vdout1_117ck1230 FIND v(dout1_117) AT=1240.05n

.meas tran vdout1_118ck1230 FIND v(dout1_118) AT=1240.05n

.meas tran vdout1_119ck1230 FIND v(dout1_119) AT=1240.05n

.meas tran vdout1_120ck1230 FIND v(dout1_120) AT=1240.05n

.meas tran vdout1_121ck1230 FIND v(dout1_121) AT=1240.05n

.meas tran vdout1_122ck1230 FIND v(dout1_122) AT=1240.05n

.meas tran vdout1_123ck1230 FIND v(dout1_123) AT=1240.05n

.meas tran vdout1_124ck1230 FIND v(dout1_124) AT=1240.05n

.meas tran vdout1_125ck1230 FIND v(dout1_125) AT=1240.05n

.meas tran vdout1_126ck1230 FIND v(dout1_126) AT=1240.05n

.meas tran vdout1_127ck1230 FIND v(dout1_127) AT=1240.05n

.meas tran vdout1_128ck1230 FIND v(dout1_128) AT=1240.05n

.meas tran vdout1_129ck1230 FIND v(dout1_129) AT=1240.05n

.meas tran vdout1_130ck1230 FIND v(dout1_130) AT=1240.05n

.meas tran vdout1_131ck1230 FIND v(dout1_131) AT=1240.05n

.meas tran vdout1_132ck1230 FIND v(dout1_132) AT=1240.05n

.meas tran vdout1_133ck1230 FIND v(dout1_133) AT=1240.05n

.meas tran vdout1_134ck1230 FIND v(dout1_134) AT=1240.05n

.meas tran vdout1_0ck1260 FIND v(dout1_0) AT=1270.05n

.meas tran vdout1_1ck1260 FIND v(dout1_1) AT=1270.05n

.meas tran vdout1_2ck1260 FIND v(dout1_2) AT=1270.05n

.meas tran vdout1_3ck1260 FIND v(dout1_3) AT=1270.05n

.meas tran vdout1_4ck1260 FIND v(dout1_4) AT=1270.05n

.meas tran vdout1_5ck1260 FIND v(dout1_5) AT=1270.05n

.meas tran vdout1_6ck1260 FIND v(dout1_6) AT=1270.05n

.meas tran vdout1_7ck1260 FIND v(dout1_7) AT=1270.05n

.meas tran vdout1_8ck1260 FIND v(dout1_8) AT=1270.05n

.meas tran vdout1_9ck1260 FIND v(dout1_9) AT=1270.05n

.meas tran vdout1_10ck1260 FIND v(dout1_10) AT=1270.05n

.meas tran vdout1_11ck1260 FIND v(dout1_11) AT=1270.05n

.meas tran vdout1_12ck1260 FIND v(dout1_12) AT=1270.05n

.meas tran vdout1_13ck1260 FIND v(dout1_13) AT=1270.05n

.meas tran vdout1_14ck1260 FIND v(dout1_14) AT=1270.05n

.meas tran vdout1_15ck1260 FIND v(dout1_15) AT=1270.05n

.meas tran vdout1_16ck1260 FIND v(dout1_16) AT=1270.05n

.meas tran vdout1_17ck1260 FIND v(dout1_17) AT=1270.05n

.meas tran vdout1_18ck1260 FIND v(dout1_18) AT=1270.05n

.meas tran vdout1_19ck1260 FIND v(dout1_19) AT=1270.05n

.meas tran vdout1_20ck1260 FIND v(dout1_20) AT=1270.05n

.meas tran vdout1_21ck1260 FIND v(dout1_21) AT=1270.05n

.meas tran vdout1_22ck1260 FIND v(dout1_22) AT=1270.05n

.meas tran vdout1_23ck1260 FIND v(dout1_23) AT=1270.05n

.meas tran vdout1_24ck1260 FIND v(dout1_24) AT=1270.05n

.meas tran vdout1_25ck1260 FIND v(dout1_25) AT=1270.05n

.meas tran vdout1_26ck1260 FIND v(dout1_26) AT=1270.05n

.meas tran vdout1_27ck1260 FIND v(dout1_27) AT=1270.05n

.meas tran vdout1_28ck1260 FIND v(dout1_28) AT=1270.05n

.meas tran vdout1_29ck1260 FIND v(dout1_29) AT=1270.05n

.meas tran vdout1_30ck1260 FIND v(dout1_30) AT=1270.05n

.meas tran vdout1_31ck1260 FIND v(dout1_31) AT=1270.05n

.meas tran vdout1_32ck1260 FIND v(dout1_32) AT=1270.05n

.meas tran vdout1_33ck1260 FIND v(dout1_33) AT=1270.05n

.meas tran vdout1_34ck1260 FIND v(dout1_34) AT=1270.05n

.meas tran vdout1_35ck1260 FIND v(dout1_35) AT=1270.05n

.meas tran vdout1_36ck1260 FIND v(dout1_36) AT=1270.05n

.meas tran vdout1_37ck1260 FIND v(dout1_37) AT=1270.05n

.meas tran vdout1_38ck1260 FIND v(dout1_38) AT=1270.05n

.meas tran vdout1_39ck1260 FIND v(dout1_39) AT=1270.05n

.meas tran vdout1_40ck1260 FIND v(dout1_40) AT=1270.05n

.meas tran vdout1_41ck1260 FIND v(dout1_41) AT=1270.05n

.meas tran vdout1_42ck1260 FIND v(dout1_42) AT=1270.05n

.meas tran vdout1_43ck1260 FIND v(dout1_43) AT=1270.05n

.meas tran vdout1_44ck1260 FIND v(dout1_44) AT=1270.05n

.meas tran vdout1_45ck1260 FIND v(dout1_45) AT=1270.05n

.meas tran vdout1_46ck1260 FIND v(dout1_46) AT=1270.05n

.meas tran vdout1_47ck1260 FIND v(dout1_47) AT=1270.05n

.meas tran vdout1_48ck1260 FIND v(dout1_48) AT=1270.05n

.meas tran vdout1_49ck1260 FIND v(dout1_49) AT=1270.05n

.meas tran vdout1_50ck1260 FIND v(dout1_50) AT=1270.05n

.meas tran vdout1_51ck1260 FIND v(dout1_51) AT=1270.05n

.meas tran vdout1_52ck1260 FIND v(dout1_52) AT=1270.05n

.meas tran vdout1_53ck1260 FIND v(dout1_53) AT=1270.05n

.meas tran vdout1_54ck1260 FIND v(dout1_54) AT=1270.05n

.meas tran vdout1_55ck1260 FIND v(dout1_55) AT=1270.05n

.meas tran vdout1_56ck1260 FIND v(dout1_56) AT=1270.05n

.meas tran vdout1_57ck1260 FIND v(dout1_57) AT=1270.05n

.meas tran vdout1_58ck1260 FIND v(dout1_58) AT=1270.05n

.meas tran vdout1_59ck1260 FIND v(dout1_59) AT=1270.05n

.meas tran vdout1_60ck1260 FIND v(dout1_60) AT=1270.05n

.meas tran vdout1_61ck1260 FIND v(dout1_61) AT=1270.05n

.meas tran vdout1_62ck1260 FIND v(dout1_62) AT=1270.05n

.meas tran vdout1_63ck1260 FIND v(dout1_63) AT=1270.05n

.meas tran vdout1_64ck1260 FIND v(dout1_64) AT=1270.05n

.meas tran vdout1_65ck1260 FIND v(dout1_65) AT=1270.05n

.meas tran vdout1_66ck1260 FIND v(dout1_66) AT=1270.05n

.meas tran vdout1_67ck1260 FIND v(dout1_67) AT=1270.05n

.meas tran vdout1_68ck1260 FIND v(dout1_68) AT=1270.05n

.meas tran vdout1_69ck1260 FIND v(dout1_69) AT=1270.05n

.meas tran vdout1_70ck1260 FIND v(dout1_70) AT=1270.05n

.meas tran vdout1_71ck1260 FIND v(dout1_71) AT=1270.05n

.meas tran vdout1_72ck1260 FIND v(dout1_72) AT=1270.05n

.meas tran vdout1_73ck1260 FIND v(dout1_73) AT=1270.05n

.meas tran vdout1_74ck1260 FIND v(dout1_74) AT=1270.05n

.meas tran vdout1_75ck1260 FIND v(dout1_75) AT=1270.05n

.meas tran vdout1_76ck1260 FIND v(dout1_76) AT=1270.05n

.meas tran vdout1_77ck1260 FIND v(dout1_77) AT=1270.05n

.meas tran vdout1_78ck1260 FIND v(dout1_78) AT=1270.05n

.meas tran vdout1_79ck1260 FIND v(dout1_79) AT=1270.05n

.meas tran vdout1_80ck1260 FIND v(dout1_80) AT=1270.05n

.meas tran vdout1_81ck1260 FIND v(dout1_81) AT=1270.05n

.meas tran vdout1_82ck1260 FIND v(dout1_82) AT=1270.05n

.meas tran vdout1_83ck1260 FIND v(dout1_83) AT=1270.05n

.meas tran vdout1_84ck1260 FIND v(dout1_84) AT=1270.05n

.meas tran vdout1_85ck1260 FIND v(dout1_85) AT=1270.05n

.meas tran vdout1_86ck1260 FIND v(dout1_86) AT=1270.05n

.meas tran vdout1_87ck1260 FIND v(dout1_87) AT=1270.05n

.meas tran vdout1_88ck1260 FIND v(dout1_88) AT=1270.05n

.meas tran vdout1_89ck1260 FIND v(dout1_89) AT=1270.05n

.meas tran vdout1_90ck1260 FIND v(dout1_90) AT=1270.05n

.meas tran vdout1_91ck1260 FIND v(dout1_91) AT=1270.05n

.meas tran vdout1_92ck1260 FIND v(dout1_92) AT=1270.05n

.meas tran vdout1_93ck1260 FIND v(dout1_93) AT=1270.05n

.meas tran vdout1_94ck1260 FIND v(dout1_94) AT=1270.05n

.meas tran vdout1_95ck1260 FIND v(dout1_95) AT=1270.05n

.meas tran vdout1_96ck1260 FIND v(dout1_96) AT=1270.05n

.meas tran vdout1_97ck1260 FIND v(dout1_97) AT=1270.05n

.meas tran vdout1_98ck1260 FIND v(dout1_98) AT=1270.05n

.meas tran vdout1_99ck1260 FIND v(dout1_99) AT=1270.05n

.meas tran vdout1_100ck1260 FIND v(dout1_100) AT=1270.05n

.meas tran vdout1_101ck1260 FIND v(dout1_101) AT=1270.05n

.meas tran vdout1_102ck1260 FIND v(dout1_102) AT=1270.05n

.meas tran vdout1_103ck1260 FIND v(dout1_103) AT=1270.05n

.meas tran vdout1_104ck1260 FIND v(dout1_104) AT=1270.05n

.meas tran vdout1_105ck1260 FIND v(dout1_105) AT=1270.05n

.meas tran vdout1_106ck1260 FIND v(dout1_106) AT=1270.05n

.meas tran vdout1_107ck1260 FIND v(dout1_107) AT=1270.05n

.meas tran vdout1_108ck1260 FIND v(dout1_108) AT=1270.05n

.meas tran vdout1_109ck1260 FIND v(dout1_109) AT=1270.05n

.meas tran vdout1_110ck1260 FIND v(dout1_110) AT=1270.05n

.meas tran vdout1_111ck1260 FIND v(dout1_111) AT=1270.05n

.meas tran vdout1_112ck1260 FIND v(dout1_112) AT=1270.05n

.meas tran vdout1_113ck1260 FIND v(dout1_113) AT=1270.05n

.meas tran vdout1_114ck1260 FIND v(dout1_114) AT=1270.05n

.meas tran vdout1_115ck1260 FIND v(dout1_115) AT=1270.05n

.meas tran vdout1_116ck1260 FIND v(dout1_116) AT=1270.05n

.meas tran vdout1_117ck1260 FIND v(dout1_117) AT=1270.05n

.meas tran vdout1_118ck1260 FIND v(dout1_118) AT=1270.05n

.meas tran vdout1_119ck1260 FIND v(dout1_119) AT=1270.05n

.meas tran vdout1_120ck1260 FIND v(dout1_120) AT=1270.05n

.meas tran vdout1_121ck1260 FIND v(dout1_121) AT=1270.05n

.meas tran vdout1_122ck1260 FIND v(dout1_122) AT=1270.05n

.meas tran vdout1_123ck1260 FIND v(dout1_123) AT=1270.05n

.meas tran vdout1_124ck1260 FIND v(dout1_124) AT=1270.05n

.meas tran vdout1_125ck1260 FIND v(dout1_125) AT=1270.05n

.meas tran vdout1_126ck1260 FIND v(dout1_126) AT=1270.05n

.meas tran vdout1_127ck1260 FIND v(dout1_127) AT=1270.05n

.meas tran vdout1_128ck1260 FIND v(dout1_128) AT=1270.05n

.meas tran vdout1_129ck1260 FIND v(dout1_129) AT=1270.05n

.meas tran vdout1_130ck1260 FIND v(dout1_130) AT=1270.05n

.meas tran vdout1_131ck1260 FIND v(dout1_131) AT=1270.05n

.meas tran vdout1_132ck1260 FIND v(dout1_132) AT=1270.05n

.meas tran vdout1_133ck1260 FIND v(dout1_133) AT=1270.05n

.meas tran vdout1_134ck1260 FIND v(dout1_134) AT=1270.05n

.meas tran vdout1_0ck1280 FIND v(dout1_0) AT=1290.05n

.meas tran vdout1_1ck1280 FIND v(dout1_1) AT=1290.05n

.meas tran vdout1_2ck1280 FIND v(dout1_2) AT=1290.05n

.meas tran vdout1_3ck1280 FIND v(dout1_3) AT=1290.05n

.meas tran vdout1_4ck1280 FIND v(dout1_4) AT=1290.05n

.meas tran vdout1_5ck1280 FIND v(dout1_5) AT=1290.05n

.meas tran vdout1_6ck1280 FIND v(dout1_6) AT=1290.05n

.meas tran vdout1_7ck1280 FIND v(dout1_7) AT=1290.05n

.meas tran vdout1_8ck1280 FIND v(dout1_8) AT=1290.05n

.meas tran vdout1_9ck1280 FIND v(dout1_9) AT=1290.05n

.meas tran vdout1_10ck1280 FIND v(dout1_10) AT=1290.05n

.meas tran vdout1_11ck1280 FIND v(dout1_11) AT=1290.05n

.meas tran vdout1_12ck1280 FIND v(dout1_12) AT=1290.05n

.meas tran vdout1_13ck1280 FIND v(dout1_13) AT=1290.05n

.meas tran vdout1_14ck1280 FIND v(dout1_14) AT=1290.05n

.meas tran vdout1_15ck1280 FIND v(dout1_15) AT=1290.05n

.meas tran vdout1_16ck1280 FIND v(dout1_16) AT=1290.05n

.meas tran vdout1_17ck1280 FIND v(dout1_17) AT=1290.05n

.meas tran vdout1_18ck1280 FIND v(dout1_18) AT=1290.05n

.meas tran vdout1_19ck1280 FIND v(dout1_19) AT=1290.05n

.meas tran vdout1_20ck1280 FIND v(dout1_20) AT=1290.05n

.meas tran vdout1_21ck1280 FIND v(dout1_21) AT=1290.05n

.meas tran vdout1_22ck1280 FIND v(dout1_22) AT=1290.05n

.meas tran vdout1_23ck1280 FIND v(dout1_23) AT=1290.05n

.meas tran vdout1_24ck1280 FIND v(dout1_24) AT=1290.05n

.meas tran vdout1_25ck1280 FIND v(dout1_25) AT=1290.05n

.meas tran vdout1_26ck1280 FIND v(dout1_26) AT=1290.05n

.meas tran vdout1_27ck1280 FIND v(dout1_27) AT=1290.05n

.meas tran vdout1_28ck1280 FIND v(dout1_28) AT=1290.05n

.meas tran vdout1_29ck1280 FIND v(dout1_29) AT=1290.05n

.meas tran vdout1_30ck1280 FIND v(dout1_30) AT=1290.05n

.meas tran vdout1_31ck1280 FIND v(dout1_31) AT=1290.05n

.meas tran vdout1_32ck1280 FIND v(dout1_32) AT=1290.05n

.meas tran vdout1_33ck1280 FIND v(dout1_33) AT=1290.05n

.meas tran vdout1_34ck1280 FIND v(dout1_34) AT=1290.05n

.meas tran vdout1_35ck1280 FIND v(dout1_35) AT=1290.05n

.meas tran vdout1_36ck1280 FIND v(dout1_36) AT=1290.05n

.meas tran vdout1_37ck1280 FIND v(dout1_37) AT=1290.05n

.meas tran vdout1_38ck1280 FIND v(dout1_38) AT=1290.05n

.meas tran vdout1_39ck1280 FIND v(dout1_39) AT=1290.05n

.meas tran vdout1_40ck1280 FIND v(dout1_40) AT=1290.05n

.meas tran vdout1_41ck1280 FIND v(dout1_41) AT=1290.05n

.meas tran vdout1_42ck1280 FIND v(dout1_42) AT=1290.05n

.meas tran vdout1_43ck1280 FIND v(dout1_43) AT=1290.05n

.meas tran vdout1_44ck1280 FIND v(dout1_44) AT=1290.05n

.meas tran vdout1_45ck1280 FIND v(dout1_45) AT=1290.05n

.meas tran vdout1_46ck1280 FIND v(dout1_46) AT=1290.05n

.meas tran vdout1_47ck1280 FIND v(dout1_47) AT=1290.05n

.meas tran vdout1_48ck1280 FIND v(dout1_48) AT=1290.05n

.meas tran vdout1_49ck1280 FIND v(dout1_49) AT=1290.05n

.meas tran vdout1_50ck1280 FIND v(dout1_50) AT=1290.05n

.meas tran vdout1_51ck1280 FIND v(dout1_51) AT=1290.05n

.meas tran vdout1_52ck1280 FIND v(dout1_52) AT=1290.05n

.meas tran vdout1_53ck1280 FIND v(dout1_53) AT=1290.05n

.meas tran vdout1_54ck1280 FIND v(dout1_54) AT=1290.05n

.meas tran vdout1_55ck1280 FIND v(dout1_55) AT=1290.05n

.meas tran vdout1_56ck1280 FIND v(dout1_56) AT=1290.05n

.meas tran vdout1_57ck1280 FIND v(dout1_57) AT=1290.05n

.meas tran vdout1_58ck1280 FIND v(dout1_58) AT=1290.05n

.meas tran vdout1_59ck1280 FIND v(dout1_59) AT=1290.05n

.meas tran vdout1_60ck1280 FIND v(dout1_60) AT=1290.05n

.meas tran vdout1_61ck1280 FIND v(dout1_61) AT=1290.05n

.meas tran vdout1_62ck1280 FIND v(dout1_62) AT=1290.05n

.meas tran vdout1_63ck1280 FIND v(dout1_63) AT=1290.05n

.meas tran vdout1_64ck1280 FIND v(dout1_64) AT=1290.05n

.meas tran vdout1_65ck1280 FIND v(dout1_65) AT=1290.05n

.meas tran vdout1_66ck1280 FIND v(dout1_66) AT=1290.05n

.meas tran vdout1_67ck1280 FIND v(dout1_67) AT=1290.05n

.meas tran vdout1_68ck1280 FIND v(dout1_68) AT=1290.05n

.meas tran vdout1_69ck1280 FIND v(dout1_69) AT=1290.05n

.meas tran vdout1_70ck1280 FIND v(dout1_70) AT=1290.05n

.meas tran vdout1_71ck1280 FIND v(dout1_71) AT=1290.05n

.meas tran vdout1_72ck1280 FIND v(dout1_72) AT=1290.05n

.meas tran vdout1_73ck1280 FIND v(dout1_73) AT=1290.05n

.meas tran vdout1_74ck1280 FIND v(dout1_74) AT=1290.05n

.meas tran vdout1_75ck1280 FIND v(dout1_75) AT=1290.05n

.meas tran vdout1_76ck1280 FIND v(dout1_76) AT=1290.05n

.meas tran vdout1_77ck1280 FIND v(dout1_77) AT=1290.05n

.meas tran vdout1_78ck1280 FIND v(dout1_78) AT=1290.05n

.meas tran vdout1_79ck1280 FIND v(dout1_79) AT=1290.05n

.meas tran vdout1_80ck1280 FIND v(dout1_80) AT=1290.05n

.meas tran vdout1_81ck1280 FIND v(dout1_81) AT=1290.05n

.meas tran vdout1_82ck1280 FIND v(dout1_82) AT=1290.05n

.meas tran vdout1_83ck1280 FIND v(dout1_83) AT=1290.05n

.meas tran vdout1_84ck1280 FIND v(dout1_84) AT=1290.05n

.meas tran vdout1_85ck1280 FIND v(dout1_85) AT=1290.05n

.meas tran vdout1_86ck1280 FIND v(dout1_86) AT=1290.05n

.meas tran vdout1_87ck1280 FIND v(dout1_87) AT=1290.05n

.meas tran vdout1_88ck1280 FIND v(dout1_88) AT=1290.05n

.meas tran vdout1_89ck1280 FIND v(dout1_89) AT=1290.05n

.meas tran vdout1_90ck1280 FIND v(dout1_90) AT=1290.05n

.meas tran vdout1_91ck1280 FIND v(dout1_91) AT=1290.05n

.meas tran vdout1_92ck1280 FIND v(dout1_92) AT=1290.05n

.meas tran vdout1_93ck1280 FIND v(dout1_93) AT=1290.05n

.meas tran vdout1_94ck1280 FIND v(dout1_94) AT=1290.05n

.meas tran vdout1_95ck1280 FIND v(dout1_95) AT=1290.05n

.meas tran vdout1_96ck1280 FIND v(dout1_96) AT=1290.05n

.meas tran vdout1_97ck1280 FIND v(dout1_97) AT=1290.05n

.meas tran vdout1_98ck1280 FIND v(dout1_98) AT=1290.05n

.meas tran vdout1_99ck1280 FIND v(dout1_99) AT=1290.05n

.meas tran vdout1_100ck1280 FIND v(dout1_100) AT=1290.05n

.meas tran vdout1_101ck1280 FIND v(dout1_101) AT=1290.05n

.meas tran vdout1_102ck1280 FIND v(dout1_102) AT=1290.05n

.meas tran vdout1_103ck1280 FIND v(dout1_103) AT=1290.05n

.meas tran vdout1_104ck1280 FIND v(dout1_104) AT=1290.05n

.meas tran vdout1_105ck1280 FIND v(dout1_105) AT=1290.05n

.meas tran vdout1_106ck1280 FIND v(dout1_106) AT=1290.05n

.meas tran vdout1_107ck1280 FIND v(dout1_107) AT=1290.05n

.meas tran vdout1_108ck1280 FIND v(dout1_108) AT=1290.05n

.meas tran vdout1_109ck1280 FIND v(dout1_109) AT=1290.05n

.meas tran vdout1_110ck1280 FIND v(dout1_110) AT=1290.05n

.meas tran vdout1_111ck1280 FIND v(dout1_111) AT=1290.05n

.meas tran vdout1_112ck1280 FIND v(dout1_112) AT=1290.05n

.meas tran vdout1_113ck1280 FIND v(dout1_113) AT=1290.05n

.meas tran vdout1_114ck1280 FIND v(dout1_114) AT=1290.05n

.meas tran vdout1_115ck1280 FIND v(dout1_115) AT=1290.05n

.meas tran vdout1_116ck1280 FIND v(dout1_116) AT=1290.05n

.meas tran vdout1_117ck1280 FIND v(dout1_117) AT=1290.05n

.meas tran vdout1_118ck1280 FIND v(dout1_118) AT=1290.05n

.meas tran vdout1_119ck1280 FIND v(dout1_119) AT=1290.05n

.meas tran vdout1_120ck1280 FIND v(dout1_120) AT=1290.05n

.meas tran vdout1_121ck1280 FIND v(dout1_121) AT=1290.05n

.meas tran vdout1_122ck1280 FIND v(dout1_122) AT=1290.05n

.meas tran vdout1_123ck1280 FIND v(dout1_123) AT=1290.05n

.meas tran vdout1_124ck1280 FIND v(dout1_124) AT=1290.05n

.meas tran vdout1_125ck1280 FIND v(dout1_125) AT=1290.05n

.meas tran vdout1_126ck1280 FIND v(dout1_126) AT=1290.05n

.meas tran vdout1_127ck1280 FIND v(dout1_127) AT=1290.05n

.meas tran vdout1_128ck1280 FIND v(dout1_128) AT=1290.05n

.meas tran vdout1_129ck1280 FIND v(dout1_129) AT=1290.05n

.meas tran vdout1_130ck1280 FIND v(dout1_130) AT=1290.05n

.meas tran vdout1_131ck1280 FIND v(dout1_131) AT=1290.05n

.meas tran vdout1_132ck1280 FIND v(dout1_132) AT=1290.05n

.meas tran vdout1_133ck1280 FIND v(dout1_133) AT=1290.05n

.meas tran vdout1_134ck1280 FIND v(dout1_134) AT=1290.05n

.meas tran vdout1_0ck1360 FIND v(dout1_0) AT=1370.05n

.meas tran vdout1_1ck1360 FIND v(dout1_1) AT=1370.05n

.meas tran vdout1_2ck1360 FIND v(dout1_2) AT=1370.05n

.meas tran vdout1_3ck1360 FIND v(dout1_3) AT=1370.05n

.meas tran vdout1_4ck1360 FIND v(dout1_4) AT=1370.05n

.meas tran vdout1_5ck1360 FIND v(dout1_5) AT=1370.05n

.meas tran vdout1_6ck1360 FIND v(dout1_6) AT=1370.05n

.meas tran vdout1_7ck1360 FIND v(dout1_7) AT=1370.05n

.meas tran vdout1_8ck1360 FIND v(dout1_8) AT=1370.05n

.meas tran vdout1_9ck1360 FIND v(dout1_9) AT=1370.05n

.meas tran vdout1_10ck1360 FIND v(dout1_10) AT=1370.05n

.meas tran vdout1_11ck1360 FIND v(dout1_11) AT=1370.05n

.meas tran vdout1_12ck1360 FIND v(dout1_12) AT=1370.05n

.meas tran vdout1_13ck1360 FIND v(dout1_13) AT=1370.05n

.meas tran vdout1_14ck1360 FIND v(dout1_14) AT=1370.05n

.meas tran vdout1_15ck1360 FIND v(dout1_15) AT=1370.05n

.meas tran vdout1_16ck1360 FIND v(dout1_16) AT=1370.05n

.meas tran vdout1_17ck1360 FIND v(dout1_17) AT=1370.05n

.meas tran vdout1_18ck1360 FIND v(dout1_18) AT=1370.05n

.meas tran vdout1_19ck1360 FIND v(dout1_19) AT=1370.05n

.meas tran vdout1_20ck1360 FIND v(dout1_20) AT=1370.05n

.meas tran vdout1_21ck1360 FIND v(dout1_21) AT=1370.05n

.meas tran vdout1_22ck1360 FIND v(dout1_22) AT=1370.05n

.meas tran vdout1_23ck1360 FIND v(dout1_23) AT=1370.05n

.meas tran vdout1_24ck1360 FIND v(dout1_24) AT=1370.05n

.meas tran vdout1_25ck1360 FIND v(dout1_25) AT=1370.05n

.meas tran vdout1_26ck1360 FIND v(dout1_26) AT=1370.05n

.meas tran vdout1_27ck1360 FIND v(dout1_27) AT=1370.05n

.meas tran vdout1_28ck1360 FIND v(dout1_28) AT=1370.05n

.meas tran vdout1_29ck1360 FIND v(dout1_29) AT=1370.05n

.meas tran vdout1_30ck1360 FIND v(dout1_30) AT=1370.05n

.meas tran vdout1_31ck1360 FIND v(dout1_31) AT=1370.05n

.meas tran vdout1_32ck1360 FIND v(dout1_32) AT=1370.05n

.meas tran vdout1_33ck1360 FIND v(dout1_33) AT=1370.05n

.meas tran vdout1_34ck1360 FIND v(dout1_34) AT=1370.05n

.meas tran vdout1_35ck1360 FIND v(dout1_35) AT=1370.05n

.meas tran vdout1_36ck1360 FIND v(dout1_36) AT=1370.05n

.meas tran vdout1_37ck1360 FIND v(dout1_37) AT=1370.05n

.meas tran vdout1_38ck1360 FIND v(dout1_38) AT=1370.05n

.meas tran vdout1_39ck1360 FIND v(dout1_39) AT=1370.05n

.meas tran vdout1_40ck1360 FIND v(dout1_40) AT=1370.05n

.meas tran vdout1_41ck1360 FIND v(dout1_41) AT=1370.05n

.meas tran vdout1_42ck1360 FIND v(dout1_42) AT=1370.05n

.meas tran vdout1_43ck1360 FIND v(dout1_43) AT=1370.05n

.meas tran vdout1_44ck1360 FIND v(dout1_44) AT=1370.05n

.meas tran vdout1_45ck1360 FIND v(dout1_45) AT=1370.05n

.meas tran vdout1_46ck1360 FIND v(dout1_46) AT=1370.05n

.meas tran vdout1_47ck1360 FIND v(dout1_47) AT=1370.05n

.meas tran vdout1_48ck1360 FIND v(dout1_48) AT=1370.05n

.meas tran vdout1_49ck1360 FIND v(dout1_49) AT=1370.05n

.meas tran vdout1_50ck1360 FIND v(dout1_50) AT=1370.05n

.meas tran vdout1_51ck1360 FIND v(dout1_51) AT=1370.05n

.meas tran vdout1_52ck1360 FIND v(dout1_52) AT=1370.05n

.meas tran vdout1_53ck1360 FIND v(dout1_53) AT=1370.05n

.meas tran vdout1_54ck1360 FIND v(dout1_54) AT=1370.05n

.meas tran vdout1_55ck1360 FIND v(dout1_55) AT=1370.05n

.meas tran vdout1_56ck1360 FIND v(dout1_56) AT=1370.05n

.meas tran vdout1_57ck1360 FIND v(dout1_57) AT=1370.05n

.meas tran vdout1_58ck1360 FIND v(dout1_58) AT=1370.05n

.meas tran vdout1_59ck1360 FIND v(dout1_59) AT=1370.05n

.meas tran vdout1_60ck1360 FIND v(dout1_60) AT=1370.05n

.meas tran vdout1_61ck1360 FIND v(dout1_61) AT=1370.05n

.meas tran vdout1_62ck1360 FIND v(dout1_62) AT=1370.05n

.meas tran vdout1_63ck1360 FIND v(dout1_63) AT=1370.05n

.meas tran vdout1_64ck1360 FIND v(dout1_64) AT=1370.05n

.meas tran vdout1_65ck1360 FIND v(dout1_65) AT=1370.05n

.meas tran vdout1_66ck1360 FIND v(dout1_66) AT=1370.05n

.meas tran vdout1_67ck1360 FIND v(dout1_67) AT=1370.05n

.meas tran vdout1_68ck1360 FIND v(dout1_68) AT=1370.05n

.meas tran vdout1_69ck1360 FIND v(dout1_69) AT=1370.05n

.meas tran vdout1_70ck1360 FIND v(dout1_70) AT=1370.05n

.meas tran vdout1_71ck1360 FIND v(dout1_71) AT=1370.05n

.meas tran vdout1_72ck1360 FIND v(dout1_72) AT=1370.05n

.meas tran vdout1_73ck1360 FIND v(dout1_73) AT=1370.05n

.meas tran vdout1_74ck1360 FIND v(dout1_74) AT=1370.05n

.meas tran vdout1_75ck1360 FIND v(dout1_75) AT=1370.05n

.meas tran vdout1_76ck1360 FIND v(dout1_76) AT=1370.05n

.meas tran vdout1_77ck1360 FIND v(dout1_77) AT=1370.05n

.meas tran vdout1_78ck1360 FIND v(dout1_78) AT=1370.05n

.meas tran vdout1_79ck1360 FIND v(dout1_79) AT=1370.05n

.meas tran vdout1_80ck1360 FIND v(dout1_80) AT=1370.05n

.meas tran vdout1_81ck1360 FIND v(dout1_81) AT=1370.05n

.meas tran vdout1_82ck1360 FIND v(dout1_82) AT=1370.05n

.meas tran vdout1_83ck1360 FIND v(dout1_83) AT=1370.05n

.meas tran vdout1_84ck1360 FIND v(dout1_84) AT=1370.05n

.meas tran vdout1_85ck1360 FIND v(dout1_85) AT=1370.05n

.meas tran vdout1_86ck1360 FIND v(dout1_86) AT=1370.05n

.meas tran vdout1_87ck1360 FIND v(dout1_87) AT=1370.05n

.meas tran vdout1_88ck1360 FIND v(dout1_88) AT=1370.05n

.meas tran vdout1_89ck1360 FIND v(dout1_89) AT=1370.05n

.meas tran vdout1_90ck1360 FIND v(dout1_90) AT=1370.05n

.meas tran vdout1_91ck1360 FIND v(dout1_91) AT=1370.05n

.meas tran vdout1_92ck1360 FIND v(dout1_92) AT=1370.05n

.meas tran vdout1_93ck1360 FIND v(dout1_93) AT=1370.05n

.meas tran vdout1_94ck1360 FIND v(dout1_94) AT=1370.05n

.meas tran vdout1_95ck1360 FIND v(dout1_95) AT=1370.05n

.meas tran vdout1_96ck1360 FIND v(dout1_96) AT=1370.05n

.meas tran vdout1_97ck1360 FIND v(dout1_97) AT=1370.05n

.meas tran vdout1_98ck1360 FIND v(dout1_98) AT=1370.05n

.meas tran vdout1_99ck1360 FIND v(dout1_99) AT=1370.05n

.meas tran vdout1_100ck1360 FIND v(dout1_100) AT=1370.05n

.meas tran vdout1_101ck1360 FIND v(dout1_101) AT=1370.05n

.meas tran vdout1_102ck1360 FIND v(dout1_102) AT=1370.05n

.meas tran vdout1_103ck1360 FIND v(dout1_103) AT=1370.05n

.meas tran vdout1_104ck1360 FIND v(dout1_104) AT=1370.05n

.meas tran vdout1_105ck1360 FIND v(dout1_105) AT=1370.05n

.meas tran vdout1_106ck1360 FIND v(dout1_106) AT=1370.05n

.meas tran vdout1_107ck1360 FIND v(dout1_107) AT=1370.05n

.meas tran vdout1_108ck1360 FIND v(dout1_108) AT=1370.05n

.meas tran vdout1_109ck1360 FIND v(dout1_109) AT=1370.05n

.meas tran vdout1_110ck1360 FIND v(dout1_110) AT=1370.05n

.meas tran vdout1_111ck1360 FIND v(dout1_111) AT=1370.05n

.meas tran vdout1_112ck1360 FIND v(dout1_112) AT=1370.05n

.meas tran vdout1_113ck1360 FIND v(dout1_113) AT=1370.05n

.meas tran vdout1_114ck1360 FIND v(dout1_114) AT=1370.05n

.meas tran vdout1_115ck1360 FIND v(dout1_115) AT=1370.05n

.meas tran vdout1_116ck1360 FIND v(dout1_116) AT=1370.05n

.meas tran vdout1_117ck1360 FIND v(dout1_117) AT=1370.05n

.meas tran vdout1_118ck1360 FIND v(dout1_118) AT=1370.05n

.meas tran vdout1_119ck1360 FIND v(dout1_119) AT=1370.05n

.meas tran vdout1_120ck1360 FIND v(dout1_120) AT=1370.05n

.meas tran vdout1_121ck1360 FIND v(dout1_121) AT=1370.05n

.meas tran vdout1_122ck1360 FIND v(dout1_122) AT=1370.05n

.meas tran vdout1_123ck1360 FIND v(dout1_123) AT=1370.05n

.meas tran vdout1_124ck1360 FIND v(dout1_124) AT=1370.05n

.meas tran vdout1_125ck1360 FIND v(dout1_125) AT=1370.05n

.meas tran vdout1_126ck1360 FIND v(dout1_126) AT=1370.05n

.meas tran vdout1_127ck1360 FIND v(dout1_127) AT=1370.05n

.meas tran vdout1_128ck1360 FIND v(dout1_128) AT=1370.05n

.meas tran vdout1_129ck1360 FIND v(dout1_129) AT=1370.05n

.meas tran vdout1_130ck1360 FIND v(dout1_130) AT=1370.05n

.meas tran vdout1_131ck1360 FIND v(dout1_131) AT=1370.05n

.meas tran vdout1_132ck1360 FIND v(dout1_132) AT=1370.05n

.meas tran vdout1_133ck1360 FIND v(dout1_133) AT=1370.05n

.meas tran vdout1_134ck1360 FIND v(dout1_134) AT=1370.05n

.meas tran vdout1_0ck1400 FIND v(dout1_0) AT=1410.05n

.meas tran vdout1_1ck1400 FIND v(dout1_1) AT=1410.05n

.meas tran vdout1_2ck1400 FIND v(dout1_2) AT=1410.05n

.meas tran vdout1_3ck1400 FIND v(dout1_3) AT=1410.05n

.meas tran vdout1_4ck1400 FIND v(dout1_4) AT=1410.05n

.meas tran vdout1_5ck1400 FIND v(dout1_5) AT=1410.05n

.meas tran vdout1_6ck1400 FIND v(dout1_6) AT=1410.05n

.meas tran vdout1_7ck1400 FIND v(dout1_7) AT=1410.05n

.meas tran vdout1_8ck1400 FIND v(dout1_8) AT=1410.05n

.meas tran vdout1_9ck1400 FIND v(dout1_9) AT=1410.05n

.meas tran vdout1_10ck1400 FIND v(dout1_10) AT=1410.05n

.meas tran vdout1_11ck1400 FIND v(dout1_11) AT=1410.05n

.meas tran vdout1_12ck1400 FIND v(dout1_12) AT=1410.05n

.meas tran vdout1_13ck1400 FIND v(dout1_13) AT=1410.05n

.meas tran vdout1_14ck1400 FIND v(dout1_14) AT=1410.05n

.meas tran vdout1_15ck1400 FIND v(dout1_15) AT=1410.05n

.meas tran vdout1_16ck1400 FIND v(dout1_16) AT=1410.05n

.meas tran vdout1_17ck1400 FIND v(dout1_17) AT=1410.05n

.meas tran vdout1_18ck1400 FIND v(dout1_18) AT=1410.05n

.meas tran vdout1_19ck1400 FIND v(dout1_19) AT=1410.05n

.meas tran vdout1_20ck1400 FIND v(dout1_20) AT=1410.05n

.meas tran vdout1_21ck1400 FIND v(dout1_21) AT=1410.05n

.meas tran vdout1_22ck1400 FIND v(dout1_22) AT=1410.05n

.meas tran vdout1_23ck1400 FIND v(dout1_23) AT=1410.05n

.meas tran vdout1_24ck1400 FIND v(dout1_24) AT=1410.05n

.meas tran vdout1_25ck1400 FIND v(dout1_25) AT=1410.05n

.meas tran vdout1_26ck1400 FIND v(dout1_26) AT=1410.05n

.meas tran vdout1_27ck1400 FIND v(dout1_27) AT=1410.05n

.meas tran vdout1_28ck1400 FIND v(dout1_28) AT=1410.05n

.meas tran vdout1_29ck1400 FIND v(dout1_29) AT=1410.05n

.meas tran vdout1_30ck1400 FIND v(dout1_30) AT=1410.05n

.meas tran vdout1_31ck1400 FIND v(dout1_31) AT=1410.05n

.meas tran vdout1_32ck1400 FIND v(dout1_32) AT=1410.05n

.meas tran vdout1_33ck1400 FIND v(dout1_33) AT=1410.05n

.meas tran vdout1_34ck1400 FIND v(dout1_34) AT=1410.05n

.meas tran vdout1_35ck1400 FIND v(dout1_35) AT=1410.05n

.meas tran vdout1_36ck1400 FIND v(dout1_36) AT=1410.05n

.meas tran vdout1_37ck1400 FIND v(dout1_37) AT=1410.05n

.meas tran vdout1_38ck1400 FIND v(dout1_38) AT=1410.05n

.meas tran vdout1_39ck1400 FIND v(dout1_39) AT=1410.05n

.meas tran vdout1_40ck1400 FIND v(dout1_40) AT=1410.05n

.meas tran vdout1_41ck1400 FIND v(dout1_41) AT=1410.05n

.meas tran vdout1_42ck1400 FIND v(dout1_42) AT=1410.05n

.meas tran vdout1_43ck1400 FIND v(dout1_43) AT=1410.05n

.meas tran vdout1_44ck1400 FIND v(dout1_44) AT=1410.05n

.meas tran vdout1_45ck1400 FIND v(dout1_45) AT=1410.05n

.meas tran vdout1_46ck1400 FIND v(dout1_46) AT=1410.05n

.meas tran vdout1_47ck1400 FIND v(dout1_47) AT=1410.05n

.meas tran vdout1_48ck1400 FIND v(dout1_48) AT=1410.05n

.meas tran vdout1_49ck1400 FIND v(dout1_49) AT=1410.05n

.meas tran vdout1_50ck1400 FIND v(dout1_50) AT=1410.05n

.meas tran vdout1_51ck1400 FIND v(dout1_51) AT=1410.05n

.meas tran vdout1_52ck1400 FIND v(dout1_52) AT=1410.05n

.meas tran vdout1_53ck1400 FIND v(dout1_53) AT=1410.05n

.meas tran vdout1_54ck1400 FIND v(dout1_54) AT=1410.05n

.meas tran vdout1_55ck1400 FIND v(dout1_55) AT=1410.05n

.meas tran vdout1_56ck1400 FIND v(dout1_56) AT=1410.05n

.meas tran vdout1_57ck1400 FIND v(dout1_57) AT=1410.05n

.meas tran vdout1_58ck1400 FIND v(dout1_58) AT=1410.05n

.meas tran vdout1_59ck1400 FIND v(dout1_59) AT=1410.05n

.meas tran vdout1_60ck1400 FIND v(dout1_60) AT=1410.05n

.meas tran vdout1_61ck1400 FIND v(dout1_61) AT=1410.05n

.meas tran vdout1_62ck1400 FIND v(dout1_62) AT=1410.05n

.meas tran vdout1_63ck1400 FIND v(dout1_63) AT=1410.05n

.meas tran vdout1_64ck1400 FIND v(dout1_64) AT=1410.05n

.meas tran vdout1_65ck1400 FIND v(dout1_65) AT=1410.05n

.meas tran vdout1_66ck1400 FIND v(dout1_66) AT=1410.05n

.meas tran vdout1_67ck1400 FIND v(dout1_67) AT=1410.05n

.meas tran vdout1_68ck1400 FIND v(dout1_68) AT=1410.05n

.meas tran vdout1_69ck1400 FIND v(dout1_69) AT=1410.05n

.meas tran vdout1_70ck1400 FIND v(dout1_70) AT=1410.05n

.meas tran vdout1_71ck1400 FIND v(dout1_71) AT=1410.05n

.meas tran vdout1_72ck1400 FIND v(dout1_72) AT=1410.05n

.meas tran vdout1_73ck1400 FIND v(dout1_73) AT=1410.05n

.meas tran vdout1_74ck1400 FIND v(dout1_74) AT=1410.05n

.meas tran vdout1_75ck1400 FIND v(dout1_75) AT=1410.05n

.meas tran vdout1_76ck1400 FIND v(dout1_76) AT=1410.05n

.meas tran vdout1_77ck1400 FIND v(dout1_77) AT=1410.05n

.meas tran vdout1_78ck1400 FIND v(dout1_78) AT=1410.05n

.meas tran vdout1_79ck1400 FIND v(dout1_79) AT=1410.05n

.meas tran vdout1_80ck1400 FIND v(dout1_80) AT=1410.05n

.meas tran vdout1_81ck1400 FIND v(dout1_81) AT=1410.05n

.meas tran vdout1_82ck1400 FIND v(dout1_82) AT=1410.05n

.meas tran vdout1_83ck1400 FIND v(dout1_83) AT=1410.05n

.meas tran vdout1_84ck1400 FIND v(dout1_84) AT=1410.05n

.meas tran vdout1_85ck1400 FIND v(dout1_85) AT=1410.05n

.meas tran vdout1_86ck1400 FIND v(dout1_86) AT=1410.05n

.meas tran vdout1_87ck1400 FIND v(dout1_87) AT=1410.05n

.meas tran vdout1_88ck1400 FIND v(dout1_88) AT=1410.05n

.meas tran vdout1_89ck1400 FIND v(dout1_89) AT=1410.05n

.meas tran vdout1_90ck1400 FIND v(dout1_90) AT=1410.05n

.meas tran vdout1_91ck1400 FIND v(dout1_91) AT=1410.05n

.meas tran vdout1_92ck1400 FIND v(dout1_92) AT=1410.05n

.meas tran vdout1_93ck1400 FIND v(dout1_93) AT=1410.05n

.meas tran vdout1_94ck1400 FIND v(dout1_94) AT=1410.05n

.meas tran vdout1_95ck1400 FIND v(dout1_95) AT=1410.05n

.meas tran vdout1_96ck1400 FIND v(dout1_96) AT=1410.05n

.meas tran vdout1_97ck1400 FIND v(dout1_97) AT=1410.05n

.meas tran vdout1_98ck1400 FIND v(dout1_98) AT=1410.05n

.meas tran vdout1_99ck1400 FIND v(dout1_99) AT=1410.05n

.meas tran vdout1_100ck1400 FIND v(dout1_100) AT=1410.05n

.meas tran vdout1_101ck1400 FIND v(dout1_101) AT=1410.05n

.meas tran vdout1_102ck1400 FIND v(dout1_102) AT=1410.05n

.meas tran vdout1_103ck1400 FIND v(dout1_103) AT=1410.05n

.meas tran vdout1_104ck1400 FIND v(dout1_104) AT=1410.05n

.meas tran vdout1_105ck1400 FIND v(dout1_105) AT=1410.05n

.meas tran vdout1_106ck1400 FIND v(dout1_106) AT=1410.05n

.meas tran vdout1_107ck1400 FIND v(dout1_107) AT=1410.05n

.meas tran vdout1_108ck1400 FIND v(dout1_108) AT=1410.05n

.meas tran vdout1_109ck1400 FIND v(dout1_109) AT=1410.05n

.meas tran vdout1_110ck1400 FIND v(dout1_110) AT=1410.05n

.meas tran vdout1_111ck1400 FIND v(dout1_111) AT=1410.05n

.meas tran vdout1_112ck1400 FIND v(dout1_112) AT=1410.05n

.meas tran vdout1_113ck1400 FIND v(dout1_113) AT=1410.05n

.meas tran vdout1_114ck1400 FIND v(dout1_114) AT=1410.05n

.meas tran vdout1_115ck1400 FIND v(dout1_115) AT=1410.05n

.meas tran vdout1_116ck1400 FIND v(dout1_116) AT=1410.05n

.meas tran vdout1_117ck1400 FIND v(dout1_117) AT=1410.05n

.meas tran vdout1_118ck1400 FIND v(dout1_118) AT=1410.05n

.meas tran vdout1_119ck1400 FIND v(dout1_119) AT=1410.05n

.meas tran vdout1_120ck1400 FIND v(dout1_120) AT=1410.05n

.meas tran vdout1_121ck1400 FIND v(dout1_121) AT=1410.05n

.meas tran vdout1_122ck1400 FIND v(dout1_122) AT=1410.05n

.meas tran vdout1_123ck1400 FIND v(dout1_123) AT=1410.05n

.meas tran vdout1_124ck1400 FIND v(dout1_124) AT=1410.05n

.meas tran vdout1_125ck1400 FIND v(dout1_125) AT=1410.05n

.meas tran vdout1_126ck1400 FIND v(dout1_126) AT=1410.05n

.meas tran vdout1_127ck1400 FIND v(dout1_127) AT=1410.05n

.meas tran vdout1_128ck1400 FIND v(dout1_128) AT=1410.05n

.meas tran vdout1_129ck1400 FIND v(dout1_129) AT=1410.05n

.meas tran vdout1_130ck1400 FIND v(dout1_130) AT=1410.05n

.meas tran vdout1_131ck1400 FIND v(dout1_131) AT=1410.05n

.meas tran vdout1_132ck1400 FIND v(dout1_132) AT=1410.05n

.meas tran vdout1_133ck1400 FIND v(dout1_133) AT=1410.05n

.meas tran vdout1_134ck1400 FIND v(dout1_134) AT=1410.05n

.meas tran vdout1_0ck1420 FIND v(dout1_0) AT=1430.05n

.meas tran vdout1_1ck1420 FIND v(dout1_1) AT=1430.05n

.meas tran vdout1_2ck1420 FIND v(dout1_2) AT=1430.05n

.meas tran vdout1_3ck1420 FIND v(dout1_3) AT=1430.05n

.meas tran vdout1_4ck1420 FIND v(dout1_4) AT=1430.05n

.meas tran vdout1_5ck1420 FIND v(dout1_5) AT=1430.05n

.meas tran vdout1_6ck1420 FIND v(dout1_6) AT=1430.05n

.meas tran vdout1_7ck1420 FIND v(dout1_7) AT=1430.05n

.meas tran vdout1_8ck1420 FIND v(dout1_8) AT=1430.05n

.meas tran vdout1_9ck1420 FIND v(dout1_9) AT=1430.05n

.meas tran vdout1_10ck1420 FIND v(dout1_10) AT=1430.05n

.meas tran vdout1_11ck1420 FIND v(dout1_11) AT=1430.05n

.meas tran vdout1_12ck1420 FIND v(dout1_12) AT=1430.05n

.meas tran vdout1_13ck1420 FIND v(dout1_13) AT=1430.05n

.meas tran vdout1_14ck1420 FIND v(dout1_14) AT=1430.05n

.meas tran vdout1_15ck1420 FIND v(dout1_15) AT=1430.05n

.meas tran vdout1_16ck1420 FIND v(dout1_16) AT=1430.05n

.meas tran vdout1_17ck1420 FIND v(dout1_17) AT=1430.05n

.meas tran vdout1_18ck1420 FIND v(dout1_18) AT=1430.05n

.meas tran vdout1_19ck1420 FIND v(dout1_19) AT=1430.05n

.meas tran vdout1_20ck1420 FIND v(dout1_20) AT=1430.05n

.meas tran vdout1_21ck1420 FIND v(dout1_21) AT=1430.05n

.meas tran vdout1_22ck1420 FIND v(dout1_22) AT=1430.05n

.meas tran vdout1_23ck1420 FIND v(dout1_23) AT=1430.05n

.meas tran vdout1_24ck1420 FIND v(dout1_24) AT=1430.05n

.meas tran vdout1_25ck1420 FIND v(dout1_25) AT=1430.05n

.meas tran vdout1_26ck1420 FIND v(dout1_26) AT=1430.05n

.meas tran vdout1_27ck1420 FIND v(dout1_27) AT=1430.05n

.meas tran vdout1_28ck1420 FIND v(dout1_28) AT=1430.05n

.meas tran vdout1_29ck1420 FIND v(dout1_29) AT=1430.05n

.meas tran vdout1_30ck1420 FIND v(dout1_30) AT=1430.05n

.meas tran vdout1_31ck1420 FIND v(dout1_31) AT=1430.05n

.meas tran vdout1_32ck1420 FIND v(dout1_32) AT=1430.05n

.meas tran vdout1_33ck1420 FIND v(dout1_33) AT=1430.05n

.meas tran vdout1_34ck1420 FIND v(dout1_34) AT=1430.05n

.meas tran vdout1_35ck1420 FIND v(dout1_35) AT=1430.05n

.meas tran vdout1_36ck1420 FIND v(dout1_36) AT=1430.05n

.meas tran vdout1_37ck1420 FIND v(dout1_37) AT=1430.05n

.meas tran vdout1_38ck1420 FIND v(dout1_38) AT=1430.05n

.meas tran vdout1_39ck1420 FIND v(dout1_39) AT=1430.05n

.meas tran vdout1_40ck1420 FIND v(dout1_40) AT=1430.05n

.meas tran vdout1_41ck1420 FIND v(dout1_41) AT=1430.05n

.meas tran vdout1_42ck1420 FIND v(dout1_42) AT=1430.05n

.meas tran vdout1_43ck1420 FIND v(dout1_43) AT=1430.05n

.meas tran vdout1_44ck1420 FIND v(dout1_44) AT=1430.05n

.meas tran vdout1_45ck1420 FIND v(dout1_45) AT=1430.05n

.meas tran vdout1_46ck1420 FIND v(dout1_46) AT=1430.05n

.meas tran vdout1_47ck1420 FIND v(dout1_47) AT=1430.05n

.meas tran vdout1_48ck1420 FIND v(dout1_48) AT=1430.05n

.meas tran vdout1_49ck1420 FIND v(dout1_49) AT=1430.05n

.meas tran vdout1_50ck1420 FIND v(dout1_50) AT=1430.05n

.meas tran vdout1_51ck1420 FIND v(dout1_51) AT=1430.05n

.meas tran vdout1_52ck1420 FIND v(dout1_52) AT=1430.05n

.meas tran vdout1_53ck1420 FIND v(dout1_53) AT=1430.05n

.meas tran vdout1_54ck1420 FIND v(dout1_54) AT=1430.05n

.meas tran vdout1_55ck1420 FIND v(dout1_55) AT=1430.05n

.meas tran vdout1_56ck1420 FIND v(dout1_56) AT=1430.05n

.meas tran vdout1_57ck1420 FIND v(dout1_57) AT=1430.05n

.meas tran vdout1_58ck1420 FIND v(dout1_58) AT=1430.05n

.meas tran vdout1_59ck1420 FIND v(dout1_59) AT=1430.05n

.meas tran vdout1_60ck1420 FIND v(dout1_60) AT=1430.05n

.meas tran vdout1_61ck1420 FIND v(dout1_61) AT=1430.05n

.meas tran vdout1_62ck1420 FIND v(dout1_62) AT=1430.05n

.meas tran vdout1_63ck1420 FIND v(dout1_63) AT=1430.05n

.meas tran vdout1_64ck1420 FIND v(dout1_64) AT=1430.05n

.meas tran vdout1_65ck1420 FIND v(dout1_65) AT=1430.05n

.meas tran vdout1_66ck1420 FIND v(dout1_66) AT=1430.05n

.meas tran vdout1_67ck1420 FIND v(dout1_67) AT=1430.05n

.meas tran vdout1_68ck1420 FIND v(dout1_68) AT=1430.05n

.meas tran vdout1_69ck1420 FIND v(dout1_69) AT=1430.05n

.meas tran vdout1_70ck1420 FIND v(dout1_70) AT=1430.05n

.meas tran vdout1_71ck1420 FIND v(dout1_71) AT=1430.05n

.meas tran vdout1_72ck1420 FIND v(dout1_72) AT=1430.05n

.meas tran vdout1_73ck1420 FIND v(dout1_73) AT=1430.05n

.meas tran vdout1_74ck1420 FIND v(dout1_74) AT=1430.05n

.meas tran vdout1_75ck1420 FIND v(dout1_75) AT=1430.05n

.meas tran vdout1_76ck1420 FIND v(dout1_76) AT=1430.05n

.meas tran vdout1_77ck1420 FIND v(dout1_77) AT=1430.05n

.meas tran vdout1_78ck1420 FIND v(dout1_78) AT=1430.05n

.meas tran vdout1_79ck1420 FIND v(dout1_79) AT=1430.05n

.meas tran vdout1_80ck1420 FIND v(dout1_80) AT=1430.05n

.meas tran vdout1_81ck1420 FIND v(dout1_81) AT=1430.05n

.meas tran vdout1_82ck1420 FIND v(dout1_82) AT=1430.05n

.meas tran vdout1_83ck1420 FIND v(dout1_83) AT=1430.05n

.meas tran vdout1_84ck1420 FIND v(dout1_84) AT=1430.05n

.meas tran vdout1_85ck1420 FIND v(dout1_85) AT=1430.05n

.meas tran vdout1_86ck1420 FIND v(dout1_86) AT=1430.05n

.meas tran vdout1_87ck1420 FIND v(dout1_87) AT=1430.05n

.meas tran vdout1_88ck1420 FIND v(dout1_88) AT=1430.05n

.meas tran vdout1_89ck1420 FIND v(dout1_89) AT=1430.05n

.meas tran vdout1_90ck1420 FIND v(dout1_90) AT=1430.05n

.meas tran vdout1_91ck1420 FIND v(dout1_91) AT=1430.05n

.meas tran vdout1_92ck1420 FIND v(dout1_92) AT=1430.05n

.meas tran vdout1_93ck1420 FIND v(dout1_93) AT=1430.05n

.meas tran vdout1_94ck1420 FIND v(dout1_94) AT=1430.05n

.meas tran vdout1_95ck1420 FIND v(dout1_95) AT=1430.05n

.meas tran vdout1_96ck1420 FIND v(dout1_96) AT=1430.05n

.meas tran vdout1_97ck1420 FIND v(dout1_97) AT=1430.05n

.meas tran vdout1_98ck1420 FIND v(dout1_98) AT=1430.05n

.meas tran vdout1_99ck1420 FIND v(dout1_99) AT=1430.05n

.meas tran vdout1_100ck1420 FIND v(dout1_100) AT=1430.05n

.meas tran vdout1_101ck1420 FIND v(dout1_101) AT=1430.05n

.meas tran vdout1_102ck1420 FIND v(dout1_102) AT=1430.05n

.meas tran vdout1_103ck1420 FIND v(dout1_103) AT=1430.05n

.meas tran vdout1_104ck1420 FIND v(dout1_104) AT=1430.05n

.meas tran vdout1_105ck1420 FIND v(dout1_105) AT=1430.05n

.meas tran vdout1_106ck1420 FIND v(dout1_106) AT=1430.05n

.meas tran vdout1_107ck1420 FIND v(dout1_107) AT=1430.05n

.meas tran vdout1_108ck1420 FIND v(dout1_108) AT=1430.05n

.meas tran vdout1_109ck1420 FIND v(dout1_109) AT=1430.05n

.meas tran vdout1_110ck1420 FIND v(dout1_110) AT=1430.05n

.meas tran vdout1_111ck1420 FIND v(dout1_111) AT=1430.05n

.meas tran vdout1_112ck1420 FIND v(dout1_112) AT=1430.05n

.meas tran vdout1_113ck1420 FIND v(dout1_113) AT=1430.05n

.meas tran vdout1_114ck1420 FIND v(dout1_114) AT=1430.05n

.meas tran vdout1_115ck1420 FIND v(dout1_115) AT=1430.05n

.meas tran vdout1_116ck1420 FIND v(dout1_116) AT=1430.05n

.meas tran vdout1_117ck1420 FIND v(dout1_117) AT=1430.05n

.meas tran vdout1_118ck1420 FIND v(dout1_118) AT=1430.05n

.meas tran vdout1_119ck1420 FIND v(dout1_119) AT=1430.05n

.meas tran vdout1_120ck1420 FIND v(dout1_120) AT=1430.05n

.meas tran vdout1_121ck1420 FIND v(dout1_121) AT=1430.05n

.meas tran vdout1_122ck1420 FIND v(dout1_122) AT=1430.05n

.meas tran vdout1_123ck1420 FIND v(dout1_123) AT=1430.05n

.meas tran vdout1_124ck1420 FIND v(dout1_124) AT=1430.05n

.meas tran vdout1_125ck1420 FIND v(dout1_125) AT=1430.05n

.meas tran vdout1_126ck1420 FIND v(dout1_126) AT=1430.05n

.meas tran vdout1_127ck1420 FIND v(dout1_127) AT=1430.05n

.meas tran vdout1_128ck1420 FIND v(dout1_128) AT=1430.05n

.meas tran vdout1_129ck1420 FIND v(dout1_129) AT=1430.05n

.meas tran vdout1_130ck1420 FIND v(dout1_130) AT=1430.05n

.meas tran vdout1_131ck1420 FIND v(dout1_131) AT=1430.05n

.meas tran vdout1_132ck1420 FIND v(dout1_132) AT=1430.05n

.meas tran vdout1_133ck1420 FIND v(dout1_133) AT=1430.05n

.meas tran vdout1_134ck1420 FIND v(dout1_134) AT=1430.05n

.meas tran vdout1_0ck1470 FIND v(dout1_0) AT=1480.05n

.meas tran vdout1_1ck1470 FIND v(dout1_1) AT=1480.05n

.meas tran vdout1_2ck1470 FIND v(dout1_2) AT=1480.05n

.meas tran vdout1_3ck1470 FIND v(dout1_3) AT=1480.05n

.meas tran vdout1_4ck1470 FIND v(dout1_4) AT=1480.05n

.meas tran vdout1_5ck1470 FIND v(dout1_5) AT=1480.05n

.meas tran vdout1_6ck1470 FIND v(dout1_6) AT=1480.05n

.meas tran vdout1_7ck1470 FIND v(dout1_7) AT=1480.05n

.meas tran vdout1_8ck1470 FIND v(dout1_8) AT=1480.05n

.meas tran vdout1_9ck1470 FIND v(dout1_9) AT=1480.05n

.meas tran vdout1_10ck1470 FIND v(dout1_10) AT=1480.05n

.meas tran vdout1_11ck1470 FIND v(dout1_11) AT=1480.05n

.meas tran vdout1_12ck1470 FIND v(dout1_12) AT=1480.05n

.meas tran vdout1_13ck1470 FIND v(dout1_13) AT=1480.05n

.meas tran vdout1_14ck1470 FIND v(dout1_14) AT=1480.05n

.meas tran vdout1_15ck1470 FIND v(dout1_15) AT=1480.05n

.meas tran vdout1_16ck1470 FIND v(dout1_16) AT=1480.05n

.meas tran vdout1_17ck1470 FIND v(dout1_17) AT=1480.05n

.meas tran vdout1_18ck1470 FIND v(dout1_18) AT=1480.05n

.meas tran vdout1_19ck1470 FIND v(dout1_19) AT=1480.05n

.meas tran vdout1_20ck1470 FIND v(dout1_20) AT=1480.05n

.meas tran vdout1_21ck1470 FIND v(dout1_21) AT=1480.05n

.meas tran vdout1_22ck1470 FIND v(dout1_22) AT=1480.05n

.meas tran vdout1_23ck1470 FIND v(dout1_23) AT=1480.05n

.meas tran vdout1_24ck1470 FIND v(dout1_24) AT=1480.05n

.meas tran vdout1_25ck1470 FIND v(dout1_25) AT=1480.05n

.meas tran vdout1_26ck1470 FIND v(dout1_26) AT=1480.05n

.meas tran vdout1_27ck1470 FIND v(dout1_27) AT=1480.05n

.meas tran vdout1_28ck1470 FIND v(dout1_28) AT=1480.05n

.meas tran vdout1_29ck1470 FIND v(dout1_29) AT=1480.05n

.meas tran vdout1_30ck1470 FIND v(dout1_30) AT=1480.05n

.meas tran vdout1_31ck1470 FIND v(dout1_31) AT=1480.05n

.meas tran vdout1_32ck1470 FIND v(dout1_32) AT=1480.05n

.meas tran vdout1_33ck1470 FIND v(dout1_33) AT=1480.05n

.meas tran vdout1_34ck1470 FIND v(dout1_34) AT=1480.05n

.meas tran vdout1_35ck1470 FIND v(dout1_35) AT=1480.05n

.meas tran vdout1_36ck1470 FIND v(dout1_36) AT=1480.05n

.meas tran vdout1_37ck1470 FIND v(dout1_37) AT=1480.05n

.meas tran vdout1_38ck1470 FIND v(dout1_38) AT=1480.05n

.meas tran vdout1_39ck1470 FIND v(dout1_39) AT=1480.05n

.meas tran vdout1_40ck1470 FIND v(dout1_40) AT=1480.05n

.meas tran vdout1_41ck1470 FIND v(dout1_41) AT=1480.05n

.meas tran vdout1_42ck1470 FIND v(dout1_42) AT=1480.05n

.meas tran vdout1_43ck1470 FIND v(dout1_43) AT=1480.05n

.meas tran vdout1_44ck1470 FIND v(dout1_44) AT=1480.05n

.meas tran vdout1_45ck1470 FIND v(dout1_45) AT=1480.05n

.meas tran vdout1_46ck1470 FIND v(dout1_46) AT=1480.05n

.meas tran vdout1_47ck1470 FIND v(dout1_47) AT=1480.05n

.meas tran vdout1_48ck1470 FIND v(dout1_48) AT=1480.05n

.meas tran vdout1_49ck1470 FIND v(dout1_49) AT=1480.05n

.meas tran vdout1_50ck1470 FIND v(dout1_50) AT=1480.05n

.meas tran vdout1_51ck1470 FIND v(dout1_51) AT=1480.05n

.meas tran vdout1_52ck1470 FIND v(dout1_52) AT=1480.05n

.meas tran vdout1_53ck1470 FIND v(dout1_53) AT=1480.05n

.meas tran vdout1_54ck1470 FIND v(dout1_54) AT=1480.05n

.meas tran vdout1_55ck1470 FIND v(dout1_55) AT=1480.05n

.meas tran vdout1_56ck1470 FIND v(dout1_56) AT=1480.05n

.meas tran vdout1_57ck1470 FIND v(dout1_57) AT=1480.05n

.meas tran vdout1_58ck1470 FIND v(dout1_58) AT=1480.05n

.meas tran vdout1_59ck1470 FIND v(dout1_59) AT=1480.05n

.meas tran vdout1_60ck1470 FIND v(dout1_60) AT=1480.05n

.meas tran vdout1_61ck1470 FIND v(dout1_61) AT=1480.05n

.meas tran vdout1_62ck1470 FIND v(dout1_62) AT=1480.05n

.meas tran vdout1_63ck1470 FIND v(dout1_63) AT=1480.05n

.meas tran vdout1_64ck1470 FIND v(dout1_64) AT=1480.05n

.meas tran vdout1_65ck1470 FIND v(dout1_65) AT=1480.05n

.meas tran vdout1_66ck1470 FIND v(dout1_66) AT=1480.05n

.meas tran vdout1_67ck1470 FIND v(dout1_67) AT=1480.05n

.meas tran vdout1_68ck1470 FIND v(dout1_68) AT=1480.05n

.meas tran vdout1_69ck1470 FIND v(dout1_69) AT=1480.05n

.meas tran vdout1_70ck1470 FIND v(dout1_70) AT=1480.05n

.meas tran vdout1_71ck1470 FIND v(dout1_71) AT=1480.05n

.meas tran vdout1_72ck1470 FIND v(dout1_72) AT=1480.05n

.meas tran vdout1_73ck1470 FIND v(dout1_73) AT=1480.05n

.meas tran vdout1_74ck1470 FIND v(dout1_74) AT=1480.05n

.meas tran vdout1_75ck1470 FIND v(dout1_75) AT=1480.05n

.meas tran vdout1_76ck1470 FIND v(dout1_76) AT=1480.05n

.meas tran vdout1_77ck1470 FIND v(dout1_77) AT=1480.05n

.meas tran vdout1_78ck1470 FIND v(dout1_78) AT=1480.05n

.meas tran vdout1_79ck1470 FIND v(dout1_79) AT=1480.05n

.meas tran vdout1_80ck1470 FIND v(dout1_80) AT=1480.05n

.meas tran vdout1_81ck1470 FIND v(dout1_81) AT=1480.05n

.meas tran vdout1_82ck1470 FIND v(dout1_82) AT=1480.05n

.meas tran vdout1_83ck1470 FIND v(dout1_83) AT=1480.05n

.meas tran vdout1_84ck1470 FIND v(dout1_84) AT=1480.05n

.meas tran vdout1_85ck1470 FIND v(dout1_85) AT=1480.05n

.meas tran vdout1_86ck1470 FIND v(dout1_86) AT=1480.05n

.meas tran vdout1_87ck1470 FIND v(dout1_87) AT=1480.05n

.meas tran vdout1_88ck1470 FIND v(dout1_88) AT=1480.05n

.meas tran vdout1_89ck1470 FIND v(dout1_89) AT=1480.05n

.meas tran vdout1_90ck1470 FIND v(dout1_90) AT=1480.05n

.meas tran vdout1_91ck1470 FIND v(dout1_91) AT=1480.05n

.meas tran vdout1_92ck1470 FIND v(dout1_92) AT=1480.05n

.meas tran vdout1_93ck1470 FIND v(dout1_93) AT=1480.05n

.meas tran vdout1_94ck1470 FIND v(dout1_94) AT=1480.05n

.meas tran vdout1_95ck1470 FIND v(dout1_95) AT=1480.05n

.meas tran vdout1_96ck1470 FIND v(dout1_96) AT=1480.05n

.meas tran vdout1_97ck1470 FIND v(dout1_97) AT=1480.05n

.meas tran vdout1_98ck1470 FIND v(dout1_98) AT=1480.05n

.meas tran vdout1_99ck1470 FIND v(dout1_99) AT=1480.05n

.meas tran vdout1_100ck1470 FIND v(dout1_100) AT=1480.05n

.meas tran vdout1_101ck1470 FIND v(dout1_101) AT=1480.05n

.meas tran vdout1_102ck1470 FIND v(dout1_102) AT=1480.05n

.meas tran vdout1_103ck1470 FIND v(dout1_103) AT=1480.05n

.meas tran vdout1_104ck1470 FIND v(dout1_104) AT=1480.05n

.meas tran vdout1_105ck1470 FIND v(dout1_105) AT=1480.05n

.meas tran vdout1_106ck1470 FIND v(dout1_106) AT=1480.05n

.meas tran vdout1_107ck1470 FIND v(dout1_107) AT=1480.05n

.meas tran vdout1_108ck1470 FIND v(dout1_108) AT=1480.05n

.meas tran vdout1_109ck1470 FIND v(dout1_109) AT=1480.05n

.meas tran vdout1_110ck1470 FIND v(dout1_110) AT=1480.05n

.meas tran vdout1_111ck1470 FIND v(dout1_111) AT=1480.05n

.meas tran vdout1_112ck1470 FIND v(dout1_112) AT=1480.05n

.meas tran vdout1_113ck1470 FIND v(dout1_113) AT=1480.05n

.meas tran vdout1_114ck1470 FIND v(dout1_114) AT=1480.05n

.meas tran vdout1_115ck1470 FIND v(dout1_115) AT=1480.05n

.meas tran vdout1_116ck1470 FIND v(dout1_116) AT=1480.05n

.meas tran vdout1_117ck1470 FIND v(dout1_117) AT=1480.05n

.meas tran vdout1_118ck1470 FIND v(dout1_118) AT=1480.05n

.meas tran vdout1_119ck1470 FIND v(dout1_119) AT=1480.05n

.meas tran vdout1_120ck1470 FIND v(dout1_120) AT=1480.05n

.meas tran vdout1_121ck1470 FIND v(dout1_121) AT=1480.05n

.meas tran vdout1_122ck1470 FIND v(dout1_122) AT=1480.05n

.meas tran vdout1_123ck1470 FIND v(dout1_123) AT=1480.05n

.meas tran vdout1_124ck1470 FIND v(dout1_124) AT=1480.05n

.meas tran vdout1_125ck1470 FIND v(dout1_125) AT=1480.05n

.meas tran vdout1_126ck1470 FIND v(dout1_126) AT=1480.05n

.meas tran vdout1_127ck1470 FIND v(dout1_127) AT=1480.05n

.meas tran vdout1_128ck1470 FIND v(dout1_128) AT=1480.05n

.meas tran vdout1_129ck1470 FIND v(dout1_129) AT=1480.05n

.meas tran vdout1_130ck1470 FIND v(dout1_130) AT=1480.05n

.meas tran vdout1_131ck1470 FIND v(dout1_131) AT=1480.05n

.meas tran vdout1_132ck1470 FIND v(dout1_132) AT=1480.05n

.meas tran vdout1_133ck1470 FIND v(dout1_133) AT=1480.05n

.meas tran vdout1_134ck1470 FIND v(dout1_134) AT=1480.05n

.meas tran vdout1_0ck1480 FIND v(dout1_0) AT=1490.05n

.meas tran vdout1_1ck1480 FIND v(dout1_1) AT=1490.05n

.meas tran vdout1_2ck1480 FIND v(dout1_2) AT=1490.05n

.meas tran vdout1_3ck1480 FIND v(dout1_3) AT=1490.05n

.meas tran vdout1_4ck1480 FIND v(dout1_4) AT=1490.05n

.meas tran vdout1_5ck1480 FIND v(dout1_5) AT=1490.05n

.meas tran vdout1_6ck1480 FIND v(dout1_6) AT=1490.05n

.meas tran vdout1_7ck1480 FIND v(dout1_7) AT=1490.05n

.meas tran vdout1_8ck1480 FIND v(dout1_8) AT=1490.05n

.meas tran vdout1_9ck1480 FIND v(dout1_9) AT=1490.05n

.meas tran vdout1_10ck1480 FIND v(dout1_10) AT=1490.05n

.meas tran vdout1_11ck1480 FIND v(dout1_11) AT=1490.05n

.meas tran vdout1_12ck1480 FIND v(dout1_12) AT=1490.05n

.meas tran vdout1_13ck1480 FIND v(dout1_13) AT=1490.05n

.meas tran vdout1_14ck1480 FIND v(dout1_14) AT=1490.05n

.meas tran vdout1_15ck1480 FIND v(dout1_15) AT=1490.05n

.meas tran vdout1_16ck1480 FIND v(dout1_16) AT=1490.05n

.meas tran vdout1_17ck1480 FIND v(dout1_17) AT=1490.05n

.meas tran vdout1_18ck1480 FIND v(dout1_18) AT=1490.05n

.meas tran vdout1_19ck1480 FIND v(dout1_19) AT=1490.05n

.meas tran vdout1_20ck1480 FIND v(dout1_20) AT=1490.05n

.meas tran vdout1_21ck1480 FIND v(dout1_21) AT=1490.05n

.meas tran vdout1_22ck1480 FIND v(dout1_22) AT=1490.05n

.meas tran vdout1_23ck1480 FIND v(dout1_23) AT=1490.05n

.meas tran vdout1_24ck1480 FIND v(dout1_24) AT=1490.05n

.meas tran vdout1_25ck1480 FIND v(dout1_25) AT=1490.05n

.meas tran vdout1_26ck1480 FIND v(dout1_26) AT=1490.05n

.meas tran vdout1_27ck1480 FIND v(dout1_27) AT=1490.05n

.meas tran vdout1_28ck1480 FIND v(dout1_28) AT=1490.05n

.meas tran vdout1_29ck1480 FIND v(dout1_29) AT=1490.05n

.meas tran vdout1_30ck1480 FIND v(dout1_30) AT=1490.05n

.meas tran vdout1_31ck1480 FIND v(dout1_31) AT=1490.05n

.meas tran vdout1_32ck1480 FIND v(dout1_32) AT=1490.05n

.meas tran vdout1_33ck1480 FIND v(dout1_33) AT=1490.05n

.meas tran vdout1_34ck1480 FIND v(dout1_34) AT=1490.05n

.meas tran vdout1_35ck1480 FIND v(dout1_35) AT=1490.05n

.meas tran vdout1_36ck1480 FIND v(dout1_36) AT=1490.05n

.meas tran vdout1_37ck1480 FIND v(dout1_37) AT=1490.05n

.meas tran vdout1_38ck1480 FIND v(dout1_38) AT=1490.05n

.meas tran vdout1_39ck1480 FIND v(dout1_39) AT=1490.05n

.meas tran vdout1_40ck1480 FIND v(dout1_40) AT=1490.05n

.meas tran vdout1_41ck1480 FIND v(dout1_41) AT=1490.05n

.meas tran vdout1_42ck1480 FIND v(dout1_42) AT=1490.05n

.meas tran vdout1_43ck1480 FIND v(dout1_43) AT=1490.05n

.meas tran vdout1_44ck1480 FIND v(dout1_44) AT=1490.05n

.meas tran vdout1_45ck1480 FIND v(dout1_45) AT=1490.05n

.meas tran vdout1_46ck1480 FIND v(dout1_46) AT=1490.05n

.meas tran vdout1_47ck1480 FIND v(dout1_47) AT=1490.05n

.meas tran vdout1_48ck1480 FIND v(dout1_48) AT=1490.05n

.meas tran vdout1_49ck1480 FIND v(dout1_49) AT=1490.05n

.meas tran vdout1_50ck1480 FIND v(dout1_50) AT=1490.05n

.meas tran vdout1_51ck1480 FIND v(dout1_51) AT=1490.05n

.meas tran vdout1_52ck1480 FIND v(dout1_52) AT=1490.05n

.meas tran vdout1_53ck1480 FIND v(dout1_53) AT=1490.05n

.meas tran vdout1_54ck1480 FIND v(dout1_54) AT=1490.05n

.meas tran vdout1_55ck1480 FIND v(dout1_55) AT=1490.05n

.meas tran vdout1_56ck1480 FIND v(dout1_56) AT=1490.05n

.meas tran vdout1_57ck1480 FIND v(dout1_57) AT=1490.05n

.meas tran vdout1_58ck1480 FIND v(dout1_58) AT=1490.05n

.meas tran vdout1_59ck1480 FIND v(dout1_59) AT=1490.05n

.meas tran vdout1_60ck1480 FIND v(dout1_60) AT=1490.05n

.meas tran vdout1_61ck1480 FIND v(dout1_61) AT=1490.05n

.meas tran vdout1_62ck1480 FIND v(dout1_62) AT=1490.05n

.meas tran vdout1_63ck1480 FIND v(dout1_63) AT=1490.05n

.meas tran vdout1_64ck1480 FIND v(dout1_64) AT=1490.05n

.meas tran vdout1_65ck1480 FIND v(dout1_65) AT=1490.05n

.meas tran vdout1_66ck1480 FIND v(dout1_66) AT=1490.05n

.meas tran vdout1_67ck1480 FIND v(dout1_67) AT=1490.05n

.meas tran vdout1_68ck1480 FIND v(dout1_68) AT=1490.05n

.meas tran vdout1_69ck1480 FIND v(dout1_69) AT=1490.05n

.meas tran vdout1_70ck1480 FIND v(dout1_70) AT=1490.05n

.meas tran vdout1_71ck1480 FIND v(dout1_71) AT=1490.05n

.meas tran vdout1_72ck1480 FIND v(dout1_72) AT=1490.05n

.meas tran vdout1_73ck1480 FIND v(dout1_73) AT=1490.05n

.meas tran vdout1_74ck1480 FIND v(dout1_74) AT=1490.05n

.meas tran vdout1_75ck1480 FIND v(dout1_75) AT=1490.05n

.meas tran vdout1_76ck1480 FIND v(dout1_76) AT=1490.05n

.meas tran vdout1_77ck1480 FIND v(dout1_77) AT=1490.05n

.meas tran vdout1_78ck1480 FIND v(dout1_78) AT=1490.05n

.meas tran vdout1_79ck1480 FIND v(dout1_79) AT=1490.05n

.meas tran vdout1_80ck1480 FIND v(dout1_80) AT=1490.05n

.meas tran vdout1_81ck1480 FIND v(dout1_81) AT=1490.05n

.meas tran vdout1_82ck1480 FIND v(dout1_82) AT=1490.05n

.meas tran vdout1_83ck1480 FIND v(dout1_83) AT=1490.05n

.meas tran vdout1_84ck1480 FIND v(dout1_84) AT=1490.05n

.meas tran vdout1_85ck1480 FIND v(dout1_85) AT=1490.05n

.meas tran vdout1_86ck1480 FIND v(dout1_86) AT=1490.05n

.meas tran vdout1_87ck1480 FIND v(dout1_87) AT=1490.05n

.meas tran vdout1_88ck1480 FIND v(dout1_88) AT=1490.05n

.meas tran vdout1_89ck1480 FIND v(dout1_89) AT=1490.05n

.meas tran vdout1_90ck1480 FIND v(dout1_90) AT=1490.05n

.meas tran vdout1_91ck1480 FIND v(dout1_91) AT=1490.05n

.meas tran vdout1_92ck1480 FIND v(dout1_92) AT=1490.05n

.meas tran vdout1_93ck1480 FIND v(dout1_93) AT=1490.05n

.meas tran vdout1_94ck1480 FIND v(dout1_94) AT=1490.05n

.meas tran vdout1_95ck1480 FIND v(dout1_95) AT=1490.05n

.meas tran vdout1_96ck1480 FIND v(dout1_96) AT=1490.05n

.meas tran vdout1_97ck1480 FIND v(dout1_97) AT=1490.05n

.meas tran vdout1_98ck1480 FIND v(dout1_98) AT=1490.05n

.meas tran vdout1_99ck1480 FIND v(dout1_99) AT=1490.05n

.meas tran vdout1_100ck1480 FIND v(dout1_100) AT=1490.05n

.meas tran vdout1_101ck1480 FIND v(dout1_101) AT=1490.05n

.meas tran vdout1_102ck1480 FIND v(dout1_102) AT=1490.05n

.meas tran vdout1_103ck1480 FIND v(dout1_103) AT=1490.05n

.meas tran vdout1_104ck1480 FIND v(dout1_104) AT=1490.05n

.meas tran vdout1_105ck1480 FIND v(dout1_105) AT=1490.05n

.meas tran vdout1_106ck1480 FIND v(dout1_106) AT=1490.05n

.meas tran vdout1_107ck1480 FIND v(dout1_107) AT=1490.05n

.meas tran vdout1_108ck1480 FIND v(dout1_108) AT=1490.05n

.meas tran vdout1_109ck1480 FIND v(dout1_109) AT=1490.05n

.meas tran vdout1_110ck1480 FIND v(dout1_110) AT=1490.05n

.meas tran vdout1_111ck1480 FIND v(dout1_111) AT=1490.05n

.meas tran vdout1_112ck1480 FIND v(dout1_112) AT=1490.05n

.meas tran vdout1_113ck1480 FIND v(dout1_113) AT=1490.05n

.meas tran vdout1_114ck1480 FIND v(dout1_114) AT=1490.05n

.meas tran vdout1_115ck1480 FIND v(dout1_115) AT=1490.05n

.meas tran vdout1_116ck1480 FIND v(dout1_116) AT=1490.05n

.meas tran vdout1_117ck1480 FIND v(dout1_117) AT=1490.05n

.meas tran vdout1_118ck1480 FIND v(dout1_118) AT=1490.05n

.meas tran vdout1_119ck1480 FIND v(dout1_119) AT=1490.05n

.meas tran vdout1_120ck1480 FIND v(dout1_120) AT=1490.05n

.meas tran vdout1_121ck1480 FIND v(dout1_121) AT=1490.05n

.meas tran vdout1_122ck1480 FIND v(dout1_122) AT=1490.05n

.meas tran vdout1_123ck1480 FIND v(dout1_123) AT=1490.05n

.meas tran vdout1_124ck1480 FIND v(dout1_124) AT=1490.05n

.meas tran vdout1_125ck1480 FIND v(dout1_125) AT=1490.05n

.meas tran vdout1_126ck1480 FIND v(dout1_126) AT=1490.05n

.meas tran vdout1_127ck1480 FIND v(dout1_127) AT=1490.05n

.meas tran vdout1_128ck1480 FIND v(dout1_128) AT=1490.05n

.meas tran vdout1_129ck1480 FIND v(dout1_129) AT=1490.05n

.meas tran vdout1_130ck1480 FIND v(dout1_130) AT=1490.05n

.meas tran vdout1_131ck1480 FIND v(dout1_131) AT=1490.05n

.meas tran vdout1_132ck1480 FIND v(dout1_132) AT=1490.05n

.meas tran vdout1_133ck1480 FIND v(dout1_133) AT=1490.05n

.meas tran vdout1_134ck1480 FIND v(dout1_134) AT=1490.05n

.meas tran vdout1_0ck1490 FIND v(dout1_0) AT=1500.05n

.meas tran vdout1_1ck1490 FIND v(dout1_1) AT=1500.05n

.meas tran vdout1_2ck1490 FIND v(dout1_2) AT=1500.05n

.meas tran vdout1_3ck1490 FIND v(dout1_3) AT=1500.05n

.meas tran vdout1_4ck1490 FIND v(dout1_4) AT=1500.05n

.meas tran vdout1_5ck1490 FIND v(dout1_5) AT=1500.05n

.meas tran vdout1_6ck1490 FIND v(dout1_6) AT=1500.05n

.meas tran vdout1_7ck1490 FIND v(dout1_7) AT=1500.05n

.meas tran vdout1_8ck1490 FIND v(dout1_8) AT=1500.05n

.meas tran vdout1_9ck1490 FIND v(dout1_9) AT=1500.05n

.meas tran vdout1_10ck1490 FIND v(dout1_10) AT=1500.05n

.meas tran vdout1_11ck1490 FIND v(dout1_11) AT=1500.05n

.meas tran vdout1_12ck1490 FIND v(dout1_12) AT=1500.05n

.meas tran vdout1_13ck1490 FIND v(dout1_13) AT=1500.05n

.meas tran vdout1_14ck1490 FIND v(dout1_14) AT=1500.05n

.meas tran vdout1_15ck1490 FIND v(dout1_15) AT=1500.05n

.meas tran vdout1_16ck1490 FIND v(dout1_16) AT=1500.05n

.meas tran vdout1_17ck1490 FIND v(dout1_17) AT=1500.05n

.meas tran vdout1_18ck1490 FIND v(dout1_18) AT=1500.05n

.meas tran vdout1_19ck1490 FIND v(dout1_19) AT=1500.05n

.meas tran vdout1_20ck1490 FIND v(dout1_20) AT=1500.05n

.meas tran vdout1_21ck1490 FIND v(dout1_21) AT=1500.05n

.meas tran vdout1_22ck1490 FIND v(dout1_22) AT=1500.05n

.meas tran vdout1_23ck1490 FIND v(dout1_23) AT=1500.05n

.meas tran vdout1_24ck1490 FIND v(dout1_24) AT=1500.05n

.meas tran vdout1_25ck1490 FIND v(dout1_25) AT=1500.05n

.meas tran vdout1_26ck1490 FIND v(dout1_26) AT=1500.05n

.meas tran vdout1_27ck1490 FIND v(dout1_27) AT=1500.05n

.meas tran vdout1_28ck1490 FIND v(dout1_28) AT=1500.05n

.meas tran vdout1_29ck1490 FIND v(dout1_29) AT=1500.05n

.meas tran vdout1_30ck1490 FIND v(dout1_30) AT=1500.05n

.meas tran vdout1_31ck1490 FIND v(dout1_31) AT=1500.05n

.meas tran vdout1_32ck1490 FIND v(dout1_32) AT=1500.05n

.meas tran vdout1_33ck1490 FIND v(dout1_33) AT=1500.05n

.meas tran vdout1_34ck1490 FIND v(dout1_34) AT=1500.05n

.meas tran vdout1_35ck1490 FIND v(dout1_35) AT=1500.05n

.meas tran vdout1_36ck1490 FIND v(dout1_36) AT=1500.05n

.meas tran vdout1_37ck1490 FIND v(dout1_37) AT=1500.05n

.meas tran vdout1_38ck1490 FIND v(dout1_38) AT=1500.05n

.meas tran vdout1_39ck1490 FIND v(dout1_39) AT=1500.05n

.meas tran vdout1_40ck1490 FIND v(dout1_40) AT=1500.05n

.meas tran vdout1_41ck1490 FIND v(dout1_41) AT=1500.05n

.meas tran vdout1_42ck1490 FIND v(dout1_42) AT=1500.05n

.meas tran vdout1_43ck1490 FIND v(dout1_43) AT=1500.05n

.meas tran vdout1_44ck1490 FIND v(dout1_44) AT=1500.05n

.meas tran vdout1_45ck1490 FIND v(dout1_45) AT=1500.05n

.meas tran vdout1_46ck1490 FIND v(dout1_46) AT=1500.05n

.meas tran vdout1_47ck1490 FIND v(dout1_47) AT=1500.05n

.meas tran vdout1_48ck1490 FIND v(dout1_48) AT=1500.05n

.meas tran vdout1_49ck1490 FIND v(dout1_49) AT=1500.05n

.meas tran vdout1_50ck1490 FIND v(dout1_50) AT=1500.05n

.meas tran vdout1_51ck1490 FIND v(dout1_51) AT=1500.05n

.meas tran vdout1_52ck1490 FIND v(dout1_52) AT=1500.05n

.meas tran vdout1_53ck1490 FIND v(dout1_53) AT=1500.05n

.meas tran vdout1_54ck1490 FIND v(dout1_54) AT=1500.05n

.meas tran vdout1_55ck1490 FIND v(dout1_55) AT=1500.05n

.meas tran vdout1_56ck1490 FIND v(dout1_56) AT=1500.05n

.meas tran vdout1_57ck1490 FIND v(dout1_57) AT=1500.05n

.meas tran vdout1_58ck1490 FIND v(dout1_58) AT=1500.05n

.meas tran vdout1_59ck1490 FIND v(dout1_59) AT=1500.05n

.meas tran vdout1_60ck1490 FIND v(dout1_60) AT=1500.05n

.meas tran vdout1_61ck1490 FIND v(dout1_61) AT=1500.05n

.meas tran vdout1_62ck1490 FIND v(dout1_62) AT=1500.05n

.meas tran vdout1_63ck1490 FIND v(dout1_63) AT=1500.05n

.meas tran vdout1_64ck1490 FIND v(dout1_64) AT=1500.05n

.meas tran vdout1_65ck1490 FIND v(dout1_65) AT=1500.05n

.meas tran vdout1_66ck1490 FIND v(dout1_66) AT=1500.05n

.meas tran vdout1_67ck1490 FIND v(dout1_67) AT=1500.05n

.meas tran vdout1_68ck1490 FIND v(dout1_68) AT=1500.05n

.meas tran vdout1_69ck1490 FIND v(dout1_69) AT=1500.05n

.meas tran vdout1_70ck1490 FIND v(dout1_70) AT=1500.05n

.meas tran vdout1_71ck1490 FIND v(dout1_71) AT=1500.05n

.meas tran vdout1_72ck1490 FIND v(dout1_72) AT=1500.05n

.meas tran vdout1_73ck1490 FIND v(dout1_73) AT=1500.05n

.meas tran vdout1_74ck1490 FIND v(dout1_74) AT=1500.05n

.meas tran vdout1_75ck1490 FIND v(dout1_75) AT=1500.05n

.meas tran vdout1_76ck1490 FIND v(dout1_76) AT=1500.05n

.meas tran vdout1_77ck1490 FIND v(dout1_77) AT=1500.05n

.meas tran vdout1_78ck1490 FIND v(dout1_78) AT=1500.05n

.meas tran vdout1_79ck1490 FIND v(dout1_79) AT=1500.05n

.meas tran vdout1_80ck1490 FIND v(dout1_80) AT=1500.05n

.meas tran vdout1_81ck1490 FIND v(dout1_81) AT=1500.05n

.meas tran vdout1_82ck1490 FIND v(dout1_82) AT=1500.05n

.meas tran vdout1_83ck1490 FIND v(dout1_83) AT=1500.05n

.meas tran vdout1_84ck1490 FIND v(dout1_84) AT=1500.05n

.meas tran vdout1_85ck1490 FIND v(dout1_85) AT=1500.05n

.meas tran vdout1_86ck1490 FIND v(dout1_86) AT=1500.05n

.meas tran vdout1_87ck1490 FIND v(dout1_87) AT=1500.05n

.meas tran vdout1_88ck1490 FIND v(dout1_88) AT=1500.05n

.meas tran vdout1_89ck1490 FIND v(dout1_89) AT=1500.05n

.meas tran vdout1_90ck1490 FIND v(dout1_90) AT=1500.05n

.meas tran vdout1_91ck1490 FIND v(dout1_91) AT=1500.05n

.meas tran vdout1_92ck1490 FIND v(dout1_92) AT=1500.05n

.meas tran vdout1_93ck1490 FIND v(dout1_93) AT=1500.05n

.meas tran vdout1_94ck1490 FIND v(dout1_94) AT=1500.05n

.meas tran vdout1_95ck1490 FIND v(dout1_95) AT=1500.05n

.meas tran vdout1_96ck1490 FIND v(dout1_96) AT=1500.05n

.meas tran vdout1_97ck1490 FIND v(dout1_97) AT=1500.05n

.meas tran vdout1_98ck1490 FIND v(dout1_98) AT=1500.05n

.meas tran vdout1_99ck1490 FIND v(dout1_99) AT=1500.05n

.meas tran vdout1_100ck1490 FIND v(dout1_100) AT=1500.05n

.meas tran vdout1_101ck1490 FIND v(dout1_101) AT=1500.05n

.meas tran vdout1_102ck1490 FIND v(dout1_102) AT=1500.05n

.meas tran vdout1_103ck1490 FIND v(dout1_103) AT=1500.05n

.meas tran vdout1_104ck1490 FIND v(dout1_104) AT=1500.05n

.meas tran vdout1_105ck1490 FIND v(dout1_105) AT=1500.05n

.meas tran vdout1_106ck1490 FIND v(dout1_106) AT=1500.05n

.meas tran vdout1_107ck1490 FIND v(dout1_107) AT=1500.05n

.meas tran vdout1_108ck1490 FIND v(dout1_108) AT=1500.05n

.meas tran vdout1_109ck1490 FIND v(dout1_109) AT=1500.05n

.meas tran vdout1_110ck1490 FIND v(dout1_110) AT=1500.05n

.meas tran vdout1_111ck1490 FIND v(dout1_111) AT=1500.05n

.meas tran vdout1_112ck1490 FIND v(dout1_112) AT=1500.05n

.meas tran vdout1_113ck1490 FIND v(dout1_113) AT=1500.05n

.meas tran vdout1_114ck1490 FIND v(dout1_114) AT=1500.05n

.meas tran vdout1_115ck1490 FIND v(dout1_115) AT=1500.05n

.meas tran vdout1_116ck1490 FIND v(dout1_116) AT=1500.05n

.meas tran vdout1_117ck1490 FIND v(dout1_117) AT=1500.05n

.meas tran vdout1_118ck1490 FIND v(dout1_118) AT=1500.05n

.meas tran vdout1_119ck1490 FIND v(dout1_119) AT=1500.05n

.meas tran vdout1_120ck1490 FIND v(dout1_120) AT=1500.05n

.meas tran vdout1_121ck1490 FIND v(dout1_121) AT=1500.05n

.meas tran vdout1_122ck1490 FIND v(dout1_122) AT=1500.05n

.meas tran vdout1_123ck1490 FIND v(dout1_123) AT=1500.05n

.meas tran vdout1_124ck1490 FIND v(dout1_124) AT=1500.05n

.meas tran vdout1_125ck1490 FIND v(dout1_125) AT=1500.05n

.meas tran vdout1_126ck1490 FIND v(dout1_126) AT=1500.05n

.meas tran vdout1_127ck1490 FIND v(dout1_127) AT=1500.05n

.meas tran vdout1_128ck1490 FIND v(dout1_128) AT=1500.05n

.meas tran vdout1_129ck1490 FIND v(dout1_129) AT=1500.05n

.meas tran vdout1_130ck1490 FIND v(dout1_130) AT=1500.05n

.meas tran vdout1_131ck1490 FIND v(dout1_131) AT=1500.05n

.meas tran vdout1_132ck1490 FIND v(dout1_132) AT=1500.05n

.meas tran vdout1_133ck1490 FIND v(dout1_133) AT=1500.05n

.meas tran vdout1_134ck1490 FIND v(dout1_134) AT=1500.05n

.meas tran vdout1_0ck1530 FIND v(dout1_0) AT=1540.05n

.meas tran vdout1_1ck1530 FIND v(dout1_1) AT=1540.05n

.meas tran vdout1_2ck1530 FIND v(dout1_2) AT=1540.05n

.meas tran vdout1_3ck1530 FIND v(dout1_3) AT=1540.05n

.meas tran vdout1_4ck1530 FIND v(dout1_4) AT=1540.05n

.meas tran vdout1_5ck1530 FIND v(dout1_5) AT=1540.05n

.meas tran vdout1_6ck1530 FIND v(dout1_6) AT=1540.05n

.meas tran vdout1_7ck1530 FIND v(dout1_7) AT=1540.05n

.meas tran vdout1_8ck1530 FIND v(dout1_8) AT=1540.05n

.meas tran vdout1_9ck1530 FIND v(dout1_9) AT=1540.05n

.meas tran vdout1_10ck1530 FIND v(dout1_10) AT=1540.05n

.meas tran vdout1_11ck1530 FIND v(dout1_11) AT=1540.05n

.meas tran vdout1_12ck1530 FIND v(dout1_12) AT=1540.05n

.meas tran vdout1_13ck1530 FIND v(dout1_13) AT=1540.05n

.meas tran vdout1_14ck1530 FIND v(dout1_14) AT=1540.05n

.meas tran vdout1_15ck1530 FIND v(dout1_15) AT=1540.05n

.meas tran vdout1_16ck1530 FIND v(dout1_16) AT=1540.05n

.meas tran vdout1_17ck1530 FIND v(dout1_17) AT=1540.05n

.meas tran vdout1_18ck1530 FIND v(dout1_18) AT=1540.05n

.meas tran vdout1_19ck1530 FIND v(dout1_19) AT=1540.05n

.meas tran vdout1_20ck1530 FIND v(dout1_20) AT=1540.05n

.meas tran vdout1_21ck1530 FIND v(dout1_21) AT=1540.05n

.meas tran vdout1_22ck1530 FIND v(dout1_22) AT=1540.05n

.meas tran vdout1_23ck1530 FIND v(dout1_23) AT=1540.05n

.meas tran vdout1_24ck1530 FIND v(dout1_24) AT=1540.05n

.meas tran vdout1_25ck1530 FIND v(dout1_25) AT=1540.05n

.meas tran vdout1_26ck1530 FIND v(dout1_26) AT=1540.05n

.meas tran vdout1_27ck1530 FIND v(dout1_27) AT=1540.05n

.meas tran vdout1_28ck1530 FIND v(dout1_28) AT=1540.05n

.meas tran vdout1_29ck1530 FIND v(dout1_29) AT=1540.05n

.meas tran vdout1_30ck1530 FIND v(dout1_30) AT=1540.05n

.meas tran vdout1_31ck1530 FIND v(dout1_31) AT=1540.05n

.meas tran vdout1_32ck1530 FIND v(dout1_32) AT=1540.05n

.meas tran vdout1_33ck1530 FIND v(dout1_33) AT=1540.05n

.meas tran vdout1_34ck1530 FIND v(dout1_34) AT=1540.05n

.meas tran vdout1_35ck1530 FIND v(dout1_35) AT=1540.05n

.meas tran vdout1_36ck1530 FIND v(dout1_36) AT=1540.05n

.meas tran vdout1_37ck1530 FIND v(dout1_37) AT=1540.05n

.meas tran vdout1_38ck1530 FIND v(dout1_38) AT=1540.05n

.meas tran vdout1_39ck1530 FIND v(dout1_39) AT=1540.05n

.meas tran vdout1_40ck1530 FIND v(dout1_40) AT=1540.05n

.meas tran vdout1_41ck1530 FIND v(dout1_41) AT=1540.05n

.meas tran vdout1_42ck1530 FIND v(dout1_42) AT=1540.05n

.meas tran vdout1_43ck1530 FIND v(dout1_43) AT=1540.05n

.meas tran vdout1_44ck1530 FIND v(dout1_44) AT=1540.05n

.meas tran vdout1_45ck1530 FIND v(dout1_45) AT=1540.05n

.meas tran vdout1_46ck1530 FIND v(dout1_46) AT=1540.05n

.meas tran vdout1_47ck1530 FIND v(dout1_47) AT=1540.05n

.meas tran vdout1_48ck1530 FIND v(dout1_48) AT=1540.05n

.meas tran vdout1_49ck1530 FIND v(dout1_49) AT=1540.05n

.meas tran vdout1_50ck1530 FIND v(dout1_50) AT=1540.05n

.meas tran vdout1_51ck1530 FIND v(dout1_51) AT=1540.05n

.meas tran vdout1_52ck1530 FIND v(dout1_52) AT=1540.05n

.meas tran vdout1_53ck1530 FIND v(dout1_53) AT=1540.05n

.meas tran vdout1_54ck1530 FIND v(dout1_54) AT=1540.05n

.meas tran vdout1_55ck1530 FIND v(dout1_55) AT=1540.05n

.meas tran vdout1_56ck1530 FIND v(dout1_56) AT=1540.05n

.meas tran vdout1_57ck1530 FIND v(dout1_57) AT=1540.05n

.meas tran vdout1_58ck1530 FIND v(dout1_58) AT=1540.05n

.meas tran vdout1_59ck1530 FIND v(dout1_59) AT=1540.05n

.meas tran vdout1_60ck1530 FIND v(dout1_60) AT=1540.05n

.meas tran vdout1_61ck1530 FIND v(dout1_61) AT=1540.05n

.meas tran vdout1_62ck1530 FIND v(dout1_62) AT=1540.05n

.meas tran vdout1_63ck1530 FIND v(dout1_63) AT=1540.05n

.meas tran vdout1_64ck1530 FIND v(dout1_64) AT=1540.05n

.meas tran vdout1_65ck1530 FIND v(dout1_65) AT=1540.05n

.meas tran vdout1_66ck1530 FIND v(dout1_66) AT=1540.05n

.meas tran vdout1_67ck1530 FIND v(dout1_67) AT=1540.05n

.meas tran vdout1_68ck1530 FIND v(dout1_68) AT=1540.05n

.meas tran vdout1_69ck1530 FIND v(dout1_69) AT=1540.05n

.meas tran vdout1_70ck1530 FIND v(dout1_70) AT=1540.05n

.meas tran vdout1_71ck1530 FIND v(dout1_71) AT=1540.05n

.meas tran vdout1_72ck1530 FIND v(dout1_72) AT=1540.05n

.meas tran vdout1_73ck1530 FIND v(dout1_73) AT=1540.05n

.meas tran vdout1_74ck1530 FIND v(dout1_74) AT=1540.05n

.meas tran vdout1_75ck1530 FIND v(dout1_75) AT=1540.05n

.meas tran vdout1_76ck1530 FIND v(dout1_76) AT=1540.05n

.meas tran vdout1_77ck1530 FIND v(dout1_77) AT=1540.05n

.meas tran vdout1_78ck1530 FIND v(dout1_78) AT=1540.05n

.meas tran vdout1_79ck1530 FIND v(dout1_79) AT=1540.05n

.meas tran vdout1_80ck1530 FIND v(dout1_80) AT=1540.05n

.meas tran vdout1_81ck1530 FIND v(dout1_81) AT=1540.05n

.meas tran vdout1_82ck1530 FIND v(dout1_82) AT=1540.05n

.meas tran vdout1_83ck1530 FIND v(dout1_83) AT=1540.05n

.meas tran vdout1_84ck1530 FIND v(dout1_84) AT=1540.05n

.meas tran vdout1_85ck1530 FIND v(dout1_85) AT=1540.05n

.meas tran vdout1_86ck1530 FIND v(dout1_86) AT=1540.05n

.meas tran vdout1_87ck1530 FIND v(dout1_87) AT=1540.05n

.meas tran vdout1_88ck1530 FIND v(dout1_88) AT=1540.05n

.meas tran vdout1_89ck1530 FIND v(dout1_89) AT=1540.05n

.meas tran vdout1_90ck1530 FIND v(dout1_90) AT=1540.05n

.meas tran vdout1_91ck1530 FIND v(dout1_91) AT=1540.05n

.meas tran vdout1_92ck1530 FIND v(dout1_92) AT=1540.05n

.meas tran vdout1_93ck1530 FIND v(dout1_93) AT=1540.05n

.meas tran vdout1_94ck1530 FIND v(dout1_94) AT=1540.05n

.meas tran vdout1_95ck1530 FIND v(dout1_95) AT=1540.05n

.meas tran vdout1_96ck1530 FIND v(dout1_96) AT=1540.05n

.meas tran vdout1_97ck1530 FIND v(dout1_97) AT=1540.05n

.meas tran vdout1_98ck1530 FIND v(dout1_98) AT=1540.05n

.meas tran vdout1_99ck1530 FIND v(dout1_99) AT=1540.05n

.meas tran vdout1_100ck1530 FIND v(dout1_100) AT=1540.05n

.meas tran vdout1_101ck1530 FIND v(dout1_101) AT=1540.05n

.meas tran vdout1_102ck1530 FIND v(dout1_102) AT=1540.05n

.meas tran vdout1_103ck1530 FIND v(dout1_103) AT=1540.05n

.meas tran vdout1_104ck1530 FIND v(dout1_104) AT=1540.05n

.meas tran vdout1_105ck1530 FIND v(dout1_105) AT=1540.05n

.meas tran vdout1_106ck1530 FIND v(dout1_106) AT=1540.05n

.meas tran vdout1_107ck1530 FIND v(dout1_107) AT=1540.05n

.meas tran vdout1_108ck1530 FIND v(dout1_108) AT=1540.05n

.meas tran vdout1_109ck1530 FIND v(dout1_109) AT=1540.05n

.meas tran vdout1_110ck1530 FIND v(dout1_110) AT=1540.05n

.meas tran vdout1_111ck1530 FIND v(dout1_111) AT=1540.05n

.meas tran vdout1_112ck1530 FIND v(dout1_112) AT=1540.05n

.meas tran vdout1_113ck1530 FIND v(dout1_113) AT=1540.05n

.meas tran vdout1_114ck1530 FIND v(dout1_114) AT=1540.05n

.meas tran vdout1_115ck1530 FIND v(dout1_115) AT=1540.05n

.meas tran vdout1_116ck1530 FIND v(dout1_116) AT=1540.05n

.meas tran vdout1_117ck1530 FIND v(dout1_117) AT=1540.05n

.meas tran vdout1_118ck1530 FIND v(dout1_118) AT=1540.05n

.meas tran vdout1_119ck1530 FIND v(dout1_119) AT=1540.05n

.meas tran vdout1_120ck1530 FIND v(dout1_120) AT=1540.05n

.meas tran vdout1_121ck1530 FIND v(dout1_121) AT=1540.05n

.meas tran vdout1_122ck1530 FIND v(dout1_122) AT=1540.05n

.meas tran vdout1_123ck1530 FIND v(dout1_123) AT=1540.05n

.meas tran vdout1_124ck1530 FIND v(dout1_124) AT=1540.05n

.meas tran vdout1_125ck1530 FIND v(dout1_125) AT=1540.05n

.meas tran vdout1_126ck1530 FIND v(dout1_126) AT=1540.05n

.meas tran vdout1_127ck1530 FIND v(dout1_127) AT=1540.05n

.meas tran vdout1_128ck1530 FIND v(dout1_128) AT=1540.05n

.meas tran vdout1_129ck1530 FIND v(dout1_129) AT=1540.05n

.meas tran vdout1_130ck1530 FIND v(dout1_130) AT=1540.05n

.meas tran vdout1_131ck1530 FIND v(dout1_131) AT=1540.05n

.meas tran vdout1_132ck1530 FIND v(dout1_132) AT=1540.05n

.meas tran vdout1_133ck1530 FIND v(dout1_133) AT=1540.05n

.meas tran vdout1_134ck1530 FIND v(dout1_134) AT=1540.05n

.meas tran vdout1_0ck1590 FIND v(dout1_0) AT=1600.05n

.meas tran vdout1_1ck1590 FIND v(dout1_1) AT=1600.05n

.meas tran vdout1_2ck1590 FIND v(dout1_2) AT=1600.05n

.meas tran vdout1_3ck1590 FIND v(dout1_3) AT=1600.05n

.meas tran vdout1_4ck1590 FIND v(dout1_4) AT=1600.05n

.meas tran vdout1_5ck1590 FIND v(dout1_5) AT=1600.05n

.meas tran vdout1_6ck1590 FIND v(dout1_6) AT=1600.05n

.meas tran vdout1_7ck1590 FIND v(dout1_7) AT=1600.05n

.meas tran vdout1_8ck1590 FIND v(dout1_8) AT=1600.05n

.meas tran vdout1_9ck1590 FIND v(dout1_9) AT=1600.05n

.meas tran vdout1_10ck1590 FIND v(dout1_10) AT=1600.05n

.meas tran vdout1_11ck1590 FIND v(dout1_11) AT=1600.05n

.meas tran vdout1_12ck1590 FIND v(dout1_12) AT=1600.05n

.meas tran vdout1_13ck1590 FIND v(dout1_13) AT=1600.05n

.meas tran vdout1_14ck1590 FIND v(dout1_14) AT=1600.05n

.meas tran vdout1_15ck1590 FIND v(dout1_15) AT=1600.05n

.meas tran vdout1_16ck1590 FIND v(dout1_16) AT=1600.05n

.meas tran vdout1_17ck1590 FIND v(dout1_17) AT=1600.05n

.meas tran vdout1_18ck1590 FIND v(dout1_18) AT=1600.05n

.meas tran vdout1_19ck1590 FIND v(dout1_19) AT=1600.05n

.meas tran vdout1_20ck1590 FIND v(dout1_20) AT=1600.05n

.meas tran vdout1_21ck1590 FIND v(dout1_21) AT=1600.05n

.meas tran vdout1_22ck1590 FIND v(dout1_22) AT=1600.05n

.meas tran vdout1_23ck1590 FIND v(dout1_23) AT=1600.05n

.meas tran vdout1_24ck1590 FIND v(dout1_24) AT=1600.05n

.meas tran vdout1_25ck1590 FIND v(dout1_25) AT=1600.05n

.meas tran vdout1_26ck1590 FIND v(dout1_26) AT=1600.05n

.meas tran vdout1_27ck1590 FIND v(dout1_27) AT=1600.05n

.meas tran vdout1_28ck1590 FIND v(dout1_28) AT=1600.05n

.meas tran vdout1_29ck1590 FIND v(dout1_29) AT=1600.05n

.meas tran vdout1_30ck1590 FIND v(dout1_30) AT=1600.05n

.meas tran vdout1_31ck1590 FIND v(dout1_31) AT=1600.05n

.meas tran vdout1_32ck1590 FIND v(dout1_32) AT=1600.05n

.meas tran vdout1_33ck1590 FIND v(dout1_33) AT=1600.05n

.meas tran vdout1_34ck1590 FIND v(dout1_34) AT=1600.05n

.meas tran vdout1_35ck1590 FIND v(dout1_35) AT=1600.05n

.meas tran vdout1_36ck1590 FIND v(dout1_36) AT=1600.05n

.meas tran vdout1_37ck1590 FIND v(dout1_37) AT=1600.05n

.meas tran vdout1_38ck1590 FIND v(dout1_38) AT=1600.05n

.meas tran vdout1_39ck1590 FIND v(dout1_39) AT=1600.05n

.meas tran vdout1_40ck1590 FIND v(dout1_40) AT=1600.05n

.meas tran vdout1_41ck1590 FIND v(dout1_41) AT=1600.05n

.meas tran vdout1_42ck1590 FIND v(dout1_42) AT=1600.05n

.meas tran vdout1_43ck1590 FIND v(dout1_43) AT=1600.05n

.meas tran vdout1_44ck1590 FIND v(dout1_44) AT=1600.05n

.meas tran vdout1_45ck1590 FIND v(dout1_45) AT=1600.05n

.meas tran vdout1_46ck1590 FIND v(dout1_46) AT=1600.05n

.meas tran vdout1_47ck1590 FIND v(dout1_47) AT=1600.05n

.meas tran vdout1_48ck1590 FIND v(dout1_48) AT=1600.05n

.meas tran vdout1_49ck1590 FIND v(dout1_49) AT=1600.05n

.meas tran vdout1_50ck1590 FIND v(dout1_50) AT=1600.05n

.meas tran vdout1_51ck1590 FIND v(dout1_51) AT=1600.05n

.meas tran vdout1_52ck1590 FIND v(dout1_52) AT=1600.05n

.meas tran vdout1_53ck1590 FIND v(dout1_53) AT=1600.05n

.meas tran vdout1_54ck1590 FIND v(dout1_54) AT=1600.05n

.meas tran vdout1_55ck1590 FIND v(dout1_55) AT=1600.05n

.meas tran vdout1_56ck1590 FIND v(dout1_56) AT=1600.05n

.meas tran vdout1_57ck1590 FIND v(dout1_57) AT=1600.05n

.meas tran vdout1_58ck1590 FIND v(dout1_58) AT=1600.05n

.meas tran vdout1_59ck1590 FIND v(dout1_59) AT=1600.05n

.meas tran vdout1_60ck1590 FIND v(dout1_60) AT=1600.05n

.meas tran vdout1_61ck1590 FIND v(dout1_61) AT=1600.05n

.meas tran vdout1_62ck1590 FIND v(dout1_62) AT=1600.05n

.meas tran vdout1_63ck1590 FIND v(dout1_63) AT=1600.05n

.meas tran vdout1_64ck1590 FIND v(dout1_64) AT=1600.05n

.meas tran vdout1_65ck1590 FIND v(dout1_65) AT=1600.05n

.meas tran vdout1_66ck1590 FIND v(dout1_66) AT=1600.05n

.meas tran vdout1_67ck1590 FIND v(dout1_67) AT=1600.05n

.meas tran vdout1_68ck1590 FIND v(dout1_68) AT=1600.05n

.meas tran vdout1_69ck1590 FIND v(dout1_69) AT=1600.05n

.meas tran vdout1_70ck1590 FIND v(dout1_70) AT=1600.05n

.meas tran vdout1_71ck1590 FIND v(dout1_71) AT=1600.05n

.meas tran vdout1_72ck1590 FIND v(dout1_72) AT=1600.05n

.meas tran vdout1_73ck1590 FIND v(dout1_73) AT=1600.05n

.meas tran vdout1_74ck1590 FIND v(dout1_74) AT=1600.05n

.meas tran vdout1_75ck1590 FIND v(dout1_75) AT=1600.05n

.meas tran vdout1_76ck1590 FIND v(dout1_76) AT=1600.05n

.meas tran vdout1_77ck1590 FIND v(dout1_77) AT=1600.05n

.meas tran vdout1_78ck1590 FIND v(dout1_78) AT=1600.05n

.meas tran vdout1_79ck1590 FIND v(dout1_79) AT=1600.05n

.meas tran vdout1_80ck1590 FIND v(dout1_80) AT=1600.05n

.meas tran vdout1_81ck1590 FIND v(dout1_81) AT=1600.05n

.meas tran vdout1_82ck1590 FIND v(dout1_82) AT=1600.05n

.meas tran vdout1_83ck1590 FIND v(dout1_83) AT=1600.05n

.meas tran vdout1_84ck1590 FIND v(dout1_84) AT=1600.05n

.meas tran vdout1_85ck1590 FIND v(dout1_85) AT=1600.05n

.meas tran vdout1_86ck1590 FIND v(dout1_86) AT=1600.05n

.meas tran vdout1_87ck1590 FIND v(dout1_87) AT=1600.05n

.meas tran vdout1_88ck1590 FIND v(dout1_88) AT=1600.05n

.meas tran vdout1_89ck1590 FIND v(dout1_89) AT=1600.05n

.meas tran vdout1_90ck1590 FIND v(dout1_90) AT=1600.05n

.meas tran vdout1_91ck1590 FIND v(dout1_91) AT=1600.05n

.meas tran vdout1_92ck1590 FIND v(dout1_92) AT=1600.05n

.meas tran vdout1_93ck1590 FIND v(dout1_93) AT=1600.05n

.meas tran vdout1_94ck1590 FIND v(dout1_94) AT=1600.05n

.meas tran vdout1_95ck1590 FIND v(dout1_95) AT=1600.05n

.meas tran vdout1_96ck1590 FIND v(dout1_96) AT=1600.05n

.meas tran vdout1_97ck1590 FIND v(dout1_97) AT=1600.05n

.meas tran vdout1_98ck1590 FIND v(dout1_98) AT=1600.05n

.meas tran vdout1_99ck1590 FIND v(dout1_99) AT=1600.05n

.meas tran vdout1_100ck1590 FIND v(dout1_100) AT=1600.05n

.meas tran vdout1_101ck1590 FIND v(dout1_101) AT=1600.05n

.meas tran vdout1_102ck1590 FIND v(dout1_102) AT=1600.05n

.meas tran vdout1_103ck1590 FIND v(dout1_103) AT=1600.05n

.meas tran vdout1_104ck1590 FIND v(dout1_104) AT=1600.05n

.meas tran vdout1_105ck1590 FIND v(dout1_105) AT=1600.05n

.meas tran vdout1_106ck1590 FIND v(dout1_106) AT=1600.05n

.meas tran vdout1_107ck1590 FIND v(dout1_107) AT=1600.05n

.meas tran vdout1_108ck1590 FIND v(dout1_108) AT=1600.05n

.meas tran vdout1_109ck1590 FIND v(dout1_109) AT=1600.05n

.meas tran vdout1_110ck1590 FIND v(dout1_110) AT=1600.05n

.meas tran vdout1_111ck1590 FIND v(dout1_111) AT=1600.05n

.meas tran vdout1_112ck1590 FIND v(dout1_112) AT=1600.05n

.meas tran vdout1_113ck1590 FIND v(dout1_113) AT=1600.05n

.meas tran vdout1_114ck1590 FIND v(dout1_114) AT=1600.05n

.meas tran vdout1_115ck1590 FIND v(dout1_115) AT=1600.05n

.meas tran vdout1_116ck1590 FIND v(dout1_116) AT=1600.05n

.meas tran vdout1_117ck1590 FIND v(dout1_117) AT=1600.05n

.meas tran vdout1_118ck1590 FIND v(dout1_118) AT=1600.05n

.meas tran vdout1_119ck1590 FIND v(dout1_119) AT=1600.05n

.meas tran vdout1_120ck1590 FIND v(dout1_120) AT=1600.05n

.meas tran vdout1_121ck1590 FIND v(dout1_121) AT=1600.05n

.meas tran vdout1_122ck1590 FIND v(dout1_122) AT=1600.05n

.meas tran vdout1_123ck1590 FIND v(dout1_123) AT=1600.05n

.meas tran vdout1_124ck1590 FIND v(dout1_124) AT=1600.05n

.meas tran vdout1_125ck1590 FIND v(dout1_125) AT=1600.05n

.meas tran vdout1_126ck1590 FIND v(dout1_126) AT=1600.05n

.meas tran vdout1_127ck1590 FIND v(dout1_127) AT=1600.05n

.meas tran vdout1_128ck1590 FIND v(dout1_128) AT=1600.05n

.meas tran vdout1_129ck1590 FIND v(dout1_129) AT=1600.05n

.meas tran vdout1_130ck1590 FIND v(dout1_130) AT=1600.05n

.meas tran vdout1_131ck1590 FIND v(dout1_131) AT=1600.05n

.meas tran vdout1_132ck1590 FIND v(dout1_132) AT=1600.05n

.meas tran vdout1_133ck1590 FIND v(dout1_133) AT=1600.05n

.meas tran vdout1_134ck1590 FIND v(dout1_134) AT=1600.05n

.meas tran vdout1_0ck1600 FIND v(dout1_0) AT=1610.05n

.meas tran vdout1_1ck1600 FIND v(dout1_1) AT=1610.05n

.meas tran vdout1_2ck1600 FIND v(dout1_2) AT=1610.05n

.meas tran vdout1_3ck1600 FIND v(dout1_3) AT=1610.05n

.meas tran vdout1_4ck1600 FIND v(dout1_4) AT=1610.05n

.meas tran vdout1_5ck1600 FIND v(dout1_5) AT=1610.05n

.meas tran vdout1_6ck1600 FIND v(dout1_6) AT=1610.05n

.meas tran vdout1_7ck1600 FIND v(dout1_7) AT=1610.05n

.meas tran vdout1_8ck1600 FIND v(dout1_8) AT=1610.05n

.meas tran vdout1_9ck1600 FIND v(dout1_9) AT=1610.05n

.meas tran vdout1_10ck1600 FIND v(dout1_10) AT=1610.05n

.meas tran vdout1_11ck1600 FIND v(dout1_11) AT=1610.05n

.meas tran vdout1_12ck1600 FIND v(dout1_12) AT=1610.05n

.meas tran vdout1_13ck1600 FIND v(dout1_13) AT=1610.05n

.meas tran vdout1_14ck1600 FIND v(dout1_14) AT=1610.05n

.meas tran vdout1_15ck1600 FIND v(dout1_15) AT=1610.05n

.meas tran vdout1_16ck1600 FIND v(dout1_16) AT=1610.05n

.meas tran vdout1_17ck1600 FIND v(dout1_17) AT=1610.05n

.meas tran vdout1_18ck1600 FIND v(dout1_18) AT=1610.05n

.meas tran vdout1_19ck1600 FIND v(dout1_19) AT=1610.05n

.meas tran vdout1_20ck1600 FIND v(dout1_20) AT=1610.05n

.meas tran vdout1_21ck1600 FIND v(dout1_21) AT=1610.05n

.meas tran vdout1_22ck1600 FIND v(dout1_22) AT=1610.05n

.meas tran vdout1_23ck1600 FIND v(dout1_23) AT=1610.05n

.meas tran vdout1_24ck1600 FIND v(dout1_24) AT=1610.05n

.meas tran vdout1_25ck1600 FIND v(dout1_25) AT=1610.05n

.meas tran vdout1_26ck1600 FIND v(dout1_26) AT=1610.05n

.meas tran vdout1_27ck1600 FIND v(dout1_27) AT=1610.05n

.meas tran vdout1_28ck1600 FIND v(dout1_28) AT=1610.05n

.meas tran vdout1_29ck1600 FIND v(dout1_29) AT=1610.05n

.meas tran vdout1_30ck1600 FIND v(dout1_30) AT=1610.05n

.meas tran vdout1_31ck1600 FIND v(dout1_31) AT=1610.05n

.meas tran vdout1_32ck1600 FIND v(dout1_32) AT=1610.05n

.meas tran vdout1_33ck1600 FIND v(dout1_33) AT=1610.05n

.meas tran vdout1_34ck1600 FIND v(dout1_34) AT=1610.05n

.meas tran vdout1_35ck1600 FIND v(dout1_35) AT=1610.05n

.meas tran vdout1_36ck1600 FIND v(dout1_36) AT=1610.05n

.meas tran vdout1_37ck1600 FIND v(dout1_37) AT=1610.05n

.meas tran vdout1_38ck1600 FIND v(dout1_38) AT=1610.05n

.meas tran vdout1_39ck1600 FIND v(dout1_39) AT=1610.05n

.meas tran vdout1_40ck1600 FIND v(dout1_40) AT=1610.05n

.meas tran vdout1_41ck1600 FIND v(dout1_41) AT=1610.05n

.meas tran vdout1_42ck1600 FIND v(dout1_42) AT=1610.05n

.meas tran vdout1_43ck1600 FIND v(dout1_43) AT=1610.05n

.meas tran vdout1_44ck1600 FIND v(dout1_44) AT=1610.05n

.meas tran vdout1_45ck1600 FIND v(dout1_45) AT=1610.05n

.meas tran vdout1_46ck1600 FIND v(dout1_46) AT=1610.05n

.meas tran vdout1_47ck1600 FIND v(dout1_47) AT=1610.05n

.meas tran vdout1_48ck1600 FIND v(dout1_48) AT=1610.05n

.meas tran vdout1_49ck1600 FIND v(dout1_49) AT=1610.05n

.meas tran vdout1_50ck1600 FIND v(dout1_50) AT=1610.05n

.meas tran vdout1_51ck1600 FIND v(dout1_51) AT=1610.05n

.meas tran vdout1_52ck1600 FIND v(dout1_52) AT=1610.05n

.meas tran vdout1_53ck1600 FIND v(dout1_53) AT=1610.05n

.meas tran vdout1_54ck1600 FIND v(dout1_54) AT=1610.05n

.meas tran vdout1_55ck1600 FIND v(dout1_55) AT=1610.05n

.meas tran vdout1_56ck1600 FIND v(dout1_56) AT=1610.05n

.meas tran vdout1_57ck1600 FIND v(dout1_57) AT=1610.05n

.meas tran vdout1_58ck1600 FIND v(dout1_58) AT=1610.05n

.meas tran vdout1_59ck1600 FIND v(dout1_59) AT=1610.05n

.meas tran vdout1_60ck1600 FIND v(dout1_60) AT=1610.05n

.meas tran vdout1_61ck1600 FIND v(dout1_61) AT=1610.05n

.meas tran vdout1_62ck1600 FIND v(dout1_62) AT=1610.05n

.meas tran vdout1_63ck1600 FIND v(dout1_63) AT=1610.05n

.meas tran vdout1_64ck1600 FIND v(dout1_64) AT=1610.05n

.meas tran vdout1_65ck1600 FIND v(dout1_65) AT=1610.05n

.meas tran vdout1_66ck1600 FIND v(dout1_66) AT=1610.05n

.meas tran vdout1_67ck1600 FIND v(dout1_67) AT=1610.05n

.meas tran vdout1_68ck1600 FIND v(dout1_68) AT=1610.05n

.meas tran vdout1_69ck1600 FIND v(dout1_69) AT=1610.05n

.meas tran vdout1_70ck1600 FIND v(dout1_70) AT=1610.05n

.meas tran vdout1_71ck1600 FIND v(dout1_71) AT=1610.05n

.meas tran vdout1_72ck1600 FIND v(dout1_72) AT=1610.05n

.meas tran vdout1_73ck1600 FIND v(dout1_73) AT=1610.05n

.meas tran vdout1_74ck1600 FIND v(dout1_74) AT=1610.05n

.meas tran vdout1_75ck1600 FIND v(dout1_75) AT=1610.05n

.meas tran vdout1_76ck1600 FIND v(dout1_76) AT=1610.05n

.meas tran vdout1_77ck1600 FIND v(dout1_77) AT=1610.05n

.meas tran vdout1_78ck1600 FIND v(dout1_78) AT=1610.05n

.meas tran vdout1_79ck1600 FIND v(dout1_79) AT=1610.05n

.meas tran vdout1_80ck1600 FIND v(dout1_80) AT=1610.05n

.meas tran vdout1_81ck1600 FIND v(dout1_81) AT=1610.05n

.meas tran vdout1_82ck1600 FIND v(dout1_82) AT=1610.05n

.meas tran vdout1_83ck1600 FIND v(dout1_83) AT=1610.05n

.meas tran vdout1_84ck1600 FIND v(dout1_84) AT=1610.05n

.meas tran vdout1_85ck1600 FIND v(dout1_85) AT=1610.05n

.meas tran vdout1_86ck1600 FIND v(dout1_86) AT=1610.05n

.meas tran vdout1_87ck1600 FIND v(dout1_87) AT=1610.05n

.meas tran vdout1_88ck1600 FIND v(dout1_88) AT=1610.05n

.meas tran vdout1_89ck1600 FIND v(dout1_89) AT=1610.05n

.meas tran vdout1_90ck1600 FIND v(dout1_90) AT=1610.05n

.meas tran vdout1_91ck1600 FIND v(dout1_91) AT=1610.05n

.meas tran vdout1_92ck1600 FIND v(dout1_92) AT=1610.05n

.meas tran vdout1_93ck1600 FIND v(dout1_93) AT=1610.05n

.meas tran vdout1_94ck1600 FIND v(dout1_94) AT=1610.05n

.meas tran vdout1_95ck1600 FIND v(dout1_95) AT=1610.05n

.meas tran vdout1_96ck1600 FIND v(dout1_96) AT=1610.05n

.meas tran vdout1_97ck1600 FIND v(dout1_97) AT=1610.05n

.meas tran vdout1_98ck1600 FIND v(dout1_98) AT=1610.05n

.meas tran vdout1_99ck1600 FIND v(dout1_99) AT=1610.05n

.meas tran vdout1_100ck1600 FIND v(dout1_100) AT=1610.05n

.meas tran vdout1_101ck1600 FIND v(dout1_101) AT=1610.05n

.meas tran vdout1_102ck1600 FIND v(dout1_102) AT=1610.05n

.meas tran vdout1_103ck1600 FIND v(dout1_103) AT=1610.05n

.meas tran vdout1_104ck1600 FIND v(dout1_104) AT=1610.05n

.meas tran vdout1_105ck1600 FIND v(dout1_105) AT=1610.05n

.meas tran vdout1_106ck1600 FIND v(dout1_106) AT=1610.05n

.meas tran vdout1_107ck1600 FIND v(dout1_107) AT=1610.05n

.meas tran vdout1_108ck1600 FIND v(dout1_108) AT=1610.05n

.meas tran vdout1_109ck1600 FIND v(dout1_109) AT=1610.05n

.meas tran vdout1_110ck1600 FIND v(dout1_110) AT=1610.05n

.meas tran vdout1_111ck1600 FIND v(dout1_111) AT=1610.05n

.meas tran vdout1_112ck1600 FIND v(dout1_112) AT=1610.05n

.meas tran vdout1_113ck1600 FIND v(dout1_113) AT=1610.05n

.meas tran vdout1_114ck1600 FIND v(dout1_114) AT=1610.05n

.meas tran vdout1_115ck1600 FIND v(dout1_115) AT=1610.05n

.meas tran vdout1_116ck1600 FIND v(dout1_116) AT=1610.05n

.meas tran vdout1_117ck1600 FIND v(dout1_117) AT=1610.05n

.meas tran vdout1_118ck1600 FIND v(dout1_118) AT=1610.05n

.meas tran vdout1_119ck1600 FIND v(dout1_119) AT=1610.05n

.meas tran vdout1_120ck1600 FIND v(dout1_120) AT=1610.05n

.meas tran vdout1_121ck1600 FIND v(dout1_121) AT=1610.05n

.meas tran vdout1_122ck1600 FIND v(dout1_122) AT=1610.05n

.meas tran vdout1_123ck1600 FIND v(dout1_123) AT=1610.05n

.meas tran vdout1_124ck1600 FIND v(dout1_124) AT=1610.05n

.meas tran vdout1_125ck1600 FIND v(dout1_125) AT=1610.05n

.meas tran vdout1_126ck1600 FIND v(dout1_126) AT=1610.05n

.meas tran vdout1_127ck1600 FIND v(dout1_127) AT=1610.05n

.meas tran vdout1_128ck1600 FIND v(dout1_128) AT=1610.05n

.meas tran vdout1_129ck1600 FIND v(dout1_129) AT=1610.05n

.meas tran vdout1_130ck1600 FIND v(dout1_130) AT=1610.05n

.meas tran vdout1_131ck1600 FIND v(dout1_131) AT=1610.05n

.meas tran vdout1_132ck1600 FIND v(dout1_132) AT=1610.05n

.meas tran vdout1_133ck1600 FIND v(dout1_133) AT=1610.05n

.meas tran vdout1_134ck1600 FIND v(dout1_134) AT=1610.05n

.meas tran vdout1_0ck1650 FIND v(dout1_0) AT=1660.05n

.meas tran vdout1_1ck1650 FIND v(dout1_1) AT=1660.05n

.meas tran vdout1_2ck1650 FIND v(dout1_2) AT=1660.05n

.meas tran vdout1_3ck1650 FIND v(dout1_3) AT=1660.05n

.meas tran vdout1_4ck1650 FIND v(dout1_4) AT=1660.05n

.meas tran vdout1_5ck1650 FIND v(dout1_5) AT=1660.05n

.meas tran vdout1_6ck1650 FIND v(dout1_6) AT=1660.05n

.meas tran vdout1_7ck1650 FIND v(dout1_7) AT=1660.05n

.meas tran vdout1_8ck1650 FIND v(dout1_8) AT=1660.05n

.meas tran vdout1_9ck1650 FIND v(dout1_9) AT=1660.05n

.meas tran vdout1_10ck1650 FIND v(dout1_10) AT=1660.05n

.meas tran vdout1_11ck1650 FIND v(dout1_11) AT=1660.05n

.meas tran vdout1_12ck1650 FIND v(dout1_12) AT=1660.05n

.meas tran vdout1_13ck1650 FIND v(dout1_13) AT=1660.05n

.meas tran vdout1_14ck1650 FIND v(dout1_14) AT=1660.05n

.meas tran vdout1_15ck1650 FIND v(dout1_15) AT=1660.05n

.meas tran vdout1_16ck1650 FIND v(dout1_16) AT=1660.05n

.meas tran vdout1_17ck1650 FIND v(dout1_17) AT=1660.05n

.meas tran vdout1_18ck1650 FIND v(dout1_18) AT=1660.05n

.meas tran vdout1_19ck1650 FIND v(dout1_19) AT=1660.05n

.meas tran vdout1_20ck1650 FIND v(dout1_20) AT=1660.05n

.meas tran vdout1_21ck1650 FIND v(dout1_21) AT=1660.05n

.meas tran vdout1_22ck1650 FIND v(dout1_22) AT=1660.05n

.meas tran vdout1_23ck1650 FIND v(dout1_23) AT=1660.05n

.meas tran vdout1_24ck1650 FIND v(dout1_24) AT=1660.05n

.meas tran vdout1_25ck1650 FIND v(dout1_25) AT=1660.05n

.meas tran vdout1_26ck1650 FIND v(dout1_26) AT=1660.05n

.meas tran vdout1_27ck1650 FIND v(dout1_27) AT=1660.05n

.meas tran vdout1_28ck1650 FIND v(dout1_28) AT=1660.05n

.meas tran vdout1_29ck1650 FIND v(dout1_29) AT=1660.05n

.meas tran vdout1_30ck1650 FIND v(dout1_30) AT=1660.05n

.meas tran vdout1_31ck1650 FIND v(dout1_31) AT=1660.05n

.meas tran vdout1_32ck1650 FIND v(dout1_32) AT=1660.05n

.meas tran vdout1_33ck1650 FIND v(dout1_33) AT=1660.05n

.meas tran vdout1_34ck1650 FIND v(dout1_34) AT=1660.05n

.meas tran vdout1_35ck1650 FIND v(dout1_35) AT=1660.05n

.meas tran vdout1_36ck1650 FIND v(dout1_36) AT=1660.05n

.meas tran vdout1_37ck1650 FIND v(dout1_37) AT=1660.05n

.meas tran vdout1_38ck1650 FIND v(dout1_38) AT=1660.05n

.meas tran vdout1_39ck1650 FIND v(dout1_39) AT=1660.05n

.meas tran vdout1_40ck1650 FIND v(dout1_40) AT=1660.05n

.meas tran vdout1_41ck1650 FIND v(dout1_41) AT=1660.05n

.meas tran vdout1_42ck1650 FIND v(dout1_42) AT=1660.05n

.meas tran vdout1_43ck1650 FIND v(dout1_43) AT=1660.05n

.meas tran vdout1_44ck1650 FIND v(dout1_44) AT=1660.05n

.meas tran vdout1_45ck1650 FIND v(dout1_45) AT=1660.05n

.meas tran vdout1_46ck1650 FIND v(dout1_46) AT=1660.05n

.meas tran vdout1_47ck1650 FIND v(dout1_47) AT=1660.05n

.meas tran vdout1_48ck1650 FIND v(dout1_48) AT=1660.05n

.meas tran vdout1_49ck1650 FIND v(dout1_49) AT=1660.05n

.meas tran vdout1_50ck1650 FIND v(dout1_50) AT=1660.05n

.meas tran vdout1_51ck1650 FIND v(dout1_51) AT=1660.05n

.meas tran vdout1_52ck1650 FIND v(dout1_52) AT=1660.05n

.meas tran vdout1_53ck1650 FIND v(dout1_53) AT=1660.05n

.meas tran vdout1_54ck1650 FIND v(dout1_54) AT=1660.05n

.meas tran vdout1_55ck1650 FIND v(dout1_55) AT=1660.05n

.meas tran vdout1_56ck1650 FIND v(dout1_56) AT=1660.05n

.meas tran vdout1_57ck1650 FIND v(dout1_57) AT=1660.05n

.meas tran vdout1_58ck1650 FIND v(dout1_58) AT=1660.05n

.meas tran vdout1_59ck1650 FIND v(dout1_59) AT=1660.05n

.meas tran vdout1_60ck1650 FIND v(dout1_60) AT=1660.05n

.meas tran vdout1_61ck1650 FIND v(dout1_61) AT=1660.05n

.meas tran vdout1_62ck1650 FIND v(dout1_62) AT=1660.05n

.meas tran vdout1_63ck1650 FIND v(dout1_63) AT=1660.05n

.meas tran vdout1_64ck1650 FIND v(dout1_64) AT=1660.05n

.meas tran vdout1_65ck1650 FIND v(dout1_65) AT=1660.05n

.meas tran vdout1_66ck1650 FIND v(dout1_66) AT=1660.05n

.meas tran vdout1_67ck1650 FIND v(dout1_67) AT=1660.05n

.meas tran vdout1_68ck1650 FIND v(dout1_68) AT=1660.05n

.meas tran vdout1_69ck1650 FIND v(dout1_69) AT=1660.05n

.meas tran vdout1_70ck1650 FIND v(dout1_70) AT=1660.05n

.meas tran vdout1_71ck1650 FIND v(dout1_71) AT=1660.05n

.meas tran vdout1_72ck1650 FIND v(dout1_72) AT=1660.05n

.meas tran vdout1_73ck1650 FIND v(dout1_73) AT=1660.05n

.meas tran vdout1_74ck1650 FIND v(dout1_74) AT=1660.05n

.meas tran vdout1_75ck1650 FIND v(dout1_75) AT=1660.05n

.meas tran vdout1_76ck1650 FIND v(dout1_76) AT=1660.05n

.meas tran vdout1_77ck1650 FIND v(dout1_77) AT=1660.05n

.meas tran vdout1_78ck1650 FIND v(dout1_78) AT=1660.05n

.meas tran vdout1_79ck1650 FIND v(dout1_79) AT=1660.05n

.meas tran vdout1_80ck1650 FIND v(dout1_80) AT=1660.05n

.meas tran vdout1_81ck1650 FIND v(dout1_81) AT=1660.05n

.meas tran vdout1_82ck1650 FIND v(dout1_82) AT=1660.05n

.meas tran vdout1_83ck1650 FIND v(dout1_83) AT=1660.05n

.meas tran vdout1_84ck1650 FIND v(dout1_84) AT=1660.05n

.meas tran vdout1_85ck1650 FIND v(dout1_85) AT=1660.05n

.meas tran vdout1_86ck1650 FIND v(dout1_86) AT=1660.05n

.meas tran vdout1_87ck1650 FIND v(dout1_87) AT=1660.05n

.meas tran vdout1_88ck1650 FIND v(dout1_88) AT=1660.05n

.meas tran vdout1_89ck1650 FIND v(dout1_89) AT=1660.05n

.meas tran vdout1_90ck1650 FIND v(dout1_90) AT=1660.05n

.meas tran vdout1_91ck1650 FIND v(dout1_91) AT=1660.05n

.meas tran vdout1_92ck1650 FIND v(dout1_92) AT=1660.05n

.meas tran vdout1_93ck1650 FIND v(dout1_93) AT=1660.05n

.meas tran vdout1_94ck1650 FIND v(dout1_94) AT=1660.05n

.meas tran vdout1_95ck1650 FIND v(dout1_95) AT=1660.05n

.meas tran vdout1_96ck1650 FIND v(dout1_96) AT=1660.05n

.meas tran vdout1_97ck1650 FIND v(dout1_97) AT=1660.05n

.meas tran vdout1_98ck1650 FIND v(dout1_98) AT=1660.05n

.meas tran vdout1_99ck1650 FIND v(dout1_99) AT=1660.05n

.meas tran vdout1_100ck1650 FIND v(dout1_100) AT=1660.05n

.meas tran vdout1_101ck1650 FIND v(dout1_101) AT=1660.05n

.meas tran vdout1_102ck1650 FIND v(dout1_102) AT=1660.05n

.meas tran vdout1_103ck1650 FIND v(dout1_103) AT=1660.05n

.meas tran vdout1_104ck1650 FIND v(dout1_104) AT=1660.05n

.meas tran vdout1_105ck1650 FIND v(dout1_105) AT=1660.05n

.meas tran vdout1_106ck1650 FIND v(dout1_106) AT=1660.05n

.meas tran vdout1_107ck1650 FIND v(dout1_107) AT=1660.05n

.meas tran vdout1_108ck1650 FIND v(dout1_108) AT=1660.05n

.meas tran vdout1_109ck1650 FIND v(dout1_109) AT=1660.05n

.meas tran vdout1_110ck1650 FIND v(dout1_110) AT=1660.05n

.meas tran vdout1_111ck1650 FIND v(dout1_111) AT=1660.05n

.meas tran vdout1_112ck1650 FIND v(dout1_112) AT=1660.05n

.meas tran vdout1_113ck1650 FIND v(dout1_113) AT=1660.05n

.meas tran vdout1_114ck1650 FIND v(dout1_114) AT=1660.05n

.meas tran vdout1_115ck1650 FIND v(dout1_115) AT=1660.05n

.meas tran vdout1_116ck1650 FIND v(dout1_116) AT=1660.05n

.meas tran vdout1_117ck1650 FIND v(dout1_117) AT=1660.05n

.meas tran vdout1_118ck1650 FIND v(dout1_118) AT=1660.05n

.meas tran vdout1_119ck1650 FIND v(dout1_119) AT=1660.05n

.meas tran vdout1_120ck1650 FIND v(dout1_120) AT=1660.05n

.meas tran vdout1_121ck1650 FIND v(dout1_121) AT=1660.05n

.meas tran vdout1_122ck1650 FIND v(dout1_122) AT=1660.05n

.meas tran vdout1_123ck1650 FIND v(dout1_123) AT=1660.05n

.meas tran vdout1_124ck1650 FIND v(dout1_124) AT=1660.05n

.meas tran vdout1_125ck1650 FIND v(dout1_125) AT=1660.05n

.meas tran vdout1_126ck1650 FIND v(dout1_126) AT=1660.05n

.meas tran vdout1_127ck1650 FIND v(dout1_127) AT=1660.05n

.meas tran vdout1_128ck1650 FIND v(dout1_128) AT=1660.05n

.meas tran vdout1_129ck1650 FIND v(dout1_129) AT=1660.05n

.meas tran vdout1_130ck1650 FIND v(dout1_130) AT=1660.05n

.meas tran vdout1_131ck1650 FIND v(dout1_131) AT=1660.05n

.meas tran vdout1_132ck1650 FIND v(dout1_132) AT=1660.05n

.meas tran vdout1_133ck1650 FIND v(dout1_133) AT=1660.05n

.meas tran vdout1_134ck1650 FIND v(dout1_134) AT=1660.05n

.meas tran vdout1_0ck1660 FIND v(dout1_0) AT=1670.05n

.meas tran vdout1_1ck1660 FIND v(dout1_1) AT=1670.05n

.meas tran vdout1_2ck1660 FIND v(dout1_2) AT=1670.05n

.meas tran vdout1_3ck1660 FIND v(dout1_3) AT=1670.05n

.meas tran vdout1_4ck1660 FIND v(dout1_4) AT=1670.05n

.meas tran vdout1_5ck1660 FIND v(dout1_5) AT=1670.05n

.meas tran vdout1_6ck1660 FIND v(dout1_6) AT=1670.05n

.meas tran vdout1_7ck1660 FIND v(dout1_7) AT=1670.05n

.meas tran vdout1_8ck1660 FIND v(dout1_8) AT=1670.05n

.meas tran vdout1_9ck1660 FIND v(dout1_9) AT=1670.05n

.meas tran vdout1_10ck1660 FIND v(dout1_10) AT=1670.05n

.meas tran vdout1_11ck1660 FIND v(dout1_11) AT=1670.05n

.meas tran vdout1_12ck1660 FIND v(dout1_12) AT=1670.05n

.meas tran vdout1_13ck1660 FIND v(dout1_13) AT=1670.05n

.meas tran vdout1_14ck1660 FIND v(dout1_14) AT=1670.05n

.meas tran vdout1_15ck1660 FIND v(dout1_15) AT=1670.05n

.meas tran vdout1_16ck1660 FIND v(dout1_16) AT=1670.05n

.meas tran vdout1_17ck1660 FIND v(dout1_17) AT=1670.05n

.meas tran vdout1_18ck1660 FIND v(dout1_18) AT=1670.05n

.meas tran vdout1_19ck1660 FIND v(dout1_19) AT=1670.05n

.meas tran vdout1_20ck1660 FIND v(dout1_20) AT=1670.05n

.meas tran vdout1_21ck1660 FIND v(dout1_21) AT=1670.05n

.meas tran vdout1_22ck1660 FIND v(dout1_22) AT=1670.05n

.meas tran vdout1_23ck1660 FIND v(dout1_23) AT=1670.05n

.meas tran vdout1_24ck1660 FIND v(dout1_24) AT=1670.05n

.meas tran vdout1_25ck1660 FIND v(dout1_25) AT=1670.05n

.meas tran vdout1_26ck1660 FIND v(dout1_26) AT=1670.05n

.meas tran vdout1_27ck1660 FIND v(dout1_27) AT=1670.05n

.meas tran vdout1_28ck1660 FIND v(dout1_28) AT=1670.05n

.meas tran vdout1_29ck1660 FIND v(dout1_29) AT=1670.05n

.meas tran vdout1_30ck1660 FIND v(dout1_30) AT=1670.05n

.meas tran vdout1_31ck1660 FIND v(dout1_31) AT=1670.05n

.meas tran vdout1_32ck1660 FIND v(dout1_32) AT=1670.05n

.meas tran vdout1_33ck1660 FIND v(dout1_33) AT=1670.05n

.meas tran vdout1_34ck1660 FIND v(dout1_34) AT=1670.05n

.meas tran vdout1_35ck1660 FIND v(dout1_35) AT=1670.05n

.meas tran vdout1_36ck1660 FIND v(dout1_36) AT=1670.05n

.meas tran vdout1_37ck1660 FIND v(dout1_37) AT=1670.05n

.meas tran vdout1_38ck1660 FIND v(dout1_38) AT=1670.05n

.meas tran vdout1_39ck1660 FIND v(dout1_39) AT=1670.05n

.meas tran vdout1_40ck1660 FIND v(dout1_40) AT=1670.05n

.meas tran vdout1_41ck1660 FIND v(dout1_41) AT=1670.05n

.meas tran vdout1_42ck1660 FIND v(dout1_42) AT=1670.05n

.meas tran vdout1_43ck1660 FIND v(dout1_43) AT=1670.05n

.meas tran vdout1_44ck1660 FIND v(dout1_44) AT=1670.05n

.meas tran vdout1_45ck1660 FIND v(dout1_45) AT=1670.05n

.meas tran vdout1_46ck1660 FIND v(dout1_46) AT=1670.05n

.meas tran vdout1_47ck1660 FIND v(dout1_47) AT=1670.05n

.meas tran vdout1_48ck1660 FIND v(dout1_48) AT=1670.05n

.meas tran vdout1_49ck1660 FIND v(dout1_49) AT=1670.05n

.meas tran vdout1_50ck1660 FIND v(dout1_50) AT=1670.05n

.meas tran vdout1_51ck1660 FIND v(dout1_51) AT=1670.05n

.meas tran vdout1_52ck1660 FIND v(dout1_52) AT=1670.05n

.meas tran vdout1_53ck1660 FIND v(dout1_53) AT=1670.05n

.meas tran vdout1_54ck1660 FIND v(dout1_54) AT=1670.05n

.meas tran vdout1_55ck1660 FIND v(dout1_55) AT=1670.05n

.meas tran vdout1_56ck1660 FIND v(dout1_56) AT=1670.05n

.meas tran vdout1_57ck1660 FIND v(dout1_57) AT=1670.05n

.meas tran vdout1_58ck1660 FIND v(dout1_58) AT=1670.05n

.meas tran vdout1_59ck1660 FIND v(dout1_59) AT=1670.05n

.meas tran vdout1_60ck1660 FIND v(dout1_60) AT=1670.05n

.meas tran vdout1_61ck1660 FIND v(dout1_61) AT=1670.05n

.meas tran vdout1_62ck1660 FIND v(dout1_62) AT=1670.05n

.meas tran vdout1_63ck1660 FIND v(dout1_63) AT=1670.05n

.meas tran vdout1_64ck1660 FIND v(dout1_64) AT=1670.05n

.meas tran vdout1_65ck1660 FIND v(dout1_65) AT=1670.05n

.meas tran vdout1_66ck1660 FIND v(dout1_66) AT=1670.05n

.meas tran vdout1_67ck1660 FIND v(dout1_67) AT=1670.05n

.meas tran vdout1_68ck1660 FIND v(dout1_68) AT=1670.05n

.meas tran vdout1_69ck1660 FIND v(dout1_69) AT=1670.05n

.meas tran vdout1_70ck1660 FIND v(dout1_70) AT=1670.05n

.meas tran vdout1_71ck1660 FIND v(dout1_71) AT=1670.05n

.meas tran vdout1_72ck1660 FIND v(dout1_72) AT=1670.05n

.meas tran vdout1_73ck1660 FIND v(dout1_73) AT=1670.05n

.meas tran vdout1_74ck1660 FIND v(dout1_74) AT=1670.05n

.meas tran vdout1_75ck1660 FIND v(dout1_75) AT=1670.05n

.meas tran vdout1_76ck1660 FIND v(dout1_76) AT=1670.05n

.meas tran vdout1_77ck1660 FIND v(dout1_77) AT=1670.05n

.meas tran vdout1_78ck1660 FIND v(dout1_78) AT=1670.05n

.meas tran vdout1_79ck1660 FIND v(dout1_79) AT=1670.05n

.meas tran vdout1_80ck1660 FIND v(dout1_80) AT=1670.05n

.meas tran vdout1_81ck1660 FIND v(dout1_81) AT=1670.05n

.meas tran vdout1_82ck1660 FIND v(dout1_82) AT=1670.05n

.meas tran vdout1_83ck1660 FIND v(dout1_83) AT=1670.05n

.meas tran vdout1_84ck1660 FIND v(dout1_84) AT=1670.05n

.meas tran vdout1_85ck1660 FIND v(dout1_85) AT=1670.05n

.meas tran vdout1_86ck1660 FIND v(dout1_86) AT=1670.05n

.meas tran vdout1_87ck1660 FIND v(dout1_87) AT=1670.05n

.meas tran vdout1_88ck1660 FIND v(dout1_88) AT=1670.05n

.meas tran vdout1_89ck1660 FIND v(dout1_89) AT=1670.05n

.meas tran vdout1_90ck1660 FIND v(dout1_90) AT=1670.05n

.meas tran vdout1_91ck1660 FIND v(dout1_91) AT=1670.05n

.meas tran vdout1_92ck1660 FIND v(dout1_92) AT=1670.05n

.meas tran vdout1_93ck1660 FIND v(dout1_93) AT=1670.05n

.meas tran vdout1_94ck1660 FIND v(dout1_94) AT=1670.05n

.meas tran vdout1_95ck1660 FIND v(dout1_95) AT=1670.05n

.meas tran vdout1_96ck1660 FIND v(dout1_96) AT=1670.05n

.meas tran vdout1_97ck1660 FIND v(dout1_97) AT=1670.05n

.meas tran vdout1_98ck1660 FIND v(dout1_98) AT=1670.05n

.meas tran vdout1_99ck1660 FIND v(dout1_99) AT=1670.05n

.meas tran vdout1_100ck1660 FIND v(dout1_100) AT=1670.05n

.meas tran vdout1_101ck1660 FIND v(dout1_101) AT=1670.05n

.meas tran vdout1_102ck1660 FIND v(dout1_102) AT=1670.05n

.meas tran vdout1_103ck1660 FIND v(dout1_103) AT=1670.05n

.meas tran vdout1_104ck1660 FIND v(dout1_104) AT=1670.05n

.meas tran vdout1_105ck1660 FIND v(dout1_105) AT=1670.05n

.meas tran vdout1_106ck1660 FIND v(dout1_106) AT=1670.05n

.meas tran vdout1_107ck1660 FIND v(dout1_107) AT=1670.05n

.meas tran vdout1_108ck1660 FIND v(dout1_108) AT=1670.05n

.meas tran vdout1_109ck1660 FIND v(dout1_109) AT=1670.05n

.meas tran vdout1_110ck1660 FIND v(dout1_110) AT=1670.05n

.meas tran vdout1_111ck1660 FIND v(dout1_111) AT=1670.05n

.meas tran vdout1_112ck1660 FIND v(dout1_112) AT=1670.05n

.meas tran vdout1_113ck1660 FIND v(dout1_113) AT=1670.05n

.meas tran vdout1_114ck1660 FIND v(dout1_114) AT=1670.05n

.meas tran vdout1_115ck1660 FIND v(dout1_115) AT=1670.05n

.meas tran vdout1_116ck1660 FIND v(dout1_116) AT=1670.05n

.meas tran vdout1_117ck1660 FIND v(dout1_117) AT=1670.05n

.meas tran vdout1_118ck1660 FIND v(dout1_118) AT=1670.05n

.meas tran vdout1_119ck1660 FIND v(dout1_119) AT=1670.05n

.meas tran vdout1_120ck1660 FIND v(dout1_120) AT=1670.05n

.meas tran vdout1_121ck1660 FIND v(dout1_121) AT=1670.05n

.meas tran vdout1_122ck1660 FIND v(dout1_122) AT=1670.05n

.meas tran vdout1_123ck1660 FIND v(dout1_123) AT=1670.05n

.meas tran vdout1_124ck1660 FIND v(dout1_124) AT=1670.05n

.meas tran vdout1_125ck1660 FIND v(dout1_125) AT=1670.05n

.meas tran vdout1_126ck1660 FIND v(dout1_126) AT=1670.05n

.meas tran vdout1_127ck1660 FIND v(dout1_127) AT=1670.05n

.meas tran vdout1_128ck1660 FIND v(dout1_128) AT=1670.05n

.meas tran vdout1_129ck1660 FIND v(dout1_129) AT=1670.05n

.meas tran vdout1_130ck1660 FIND v(dout1_130) AT=1670.05n

.meas tran vdout1_131ck1660 FIND v(dout1_131) AT=1670.05n

.meas tran vdout1_132ck1660 FIND v(dout1_132) AT=1670.05n

.meas tran vdout1_133ck1660 FIND v(dout1_133) AT=1670.05n

.meas tran vdout1_134ck1660 FIND v(dout1_134) AT=1670.05n

.meas tran vdout1_0ck1670 FIND v(dout1_0) AT=1680.05n

.meas tran vdout1_1ck1670 FIND v(dout1_1) AT=1680.05n

.meas tran vdout1_2ck1670 FIND v(dout1_2) AT=1680.05n

.meas tran vdout1_3ck1670 FIND v(dout1_3) AT=1680.05n

.meas tran vdout1_4ck1670 FIND v(dout1_4) AT=1680.05n

.meas tran vdout1_5ck1670 FIND v(dout1_5) AT=1680.05n

.meas tran vdout1_6ck1670 FIND v(dout1_6) AT=1680.05n

.meas tran vdout1_7ck1670 FIND v(dout1_7) AT=1680.05n

.meas tran vdout1_8ck1670 FIND v(dout1_8) AT=1680.05n

.meas tran vdout1_9ck1670 FIND v(dout1_9) AT=1680.05n

.meas tran vdout1_10ck1670 FIND v(dout1_10) AT=1680.05n

.meas tran vdout1_11ck1670 FIND v(dout1_11) AT=1680.05n

.meas tran vdout1_12ck1670 FIND v(dout1_12) AT=1680.05n

.meas tran vdout1_13ck1670 FIND v(dout1_13) AT=1680.05n

.meas tran vdout1_14ck1670 FIND v(dout1_14) AT=1680.05n

.meas tran vdout1_15ck1670 FIND v(dout1_15) AT=1680.05n

.meas tran vdout1_16ck1670 FIND v(dout1_16) AT=1680.05n

.meas tran vdout1_17ck1670 FIND v(dout1_17) AT=1680.05n

.meas tran vdout1_18ck1670 FIND v(dout1_18) AT=1680.05n

.meas tran vdout1_19ck1670 FIND v(dout1_19) AT=1680.05n

.meas tran vdout1_20ck1670 FIND v(dout1_20) AT=1680.05n

.meas tran vdout1_21ck1670 FIND v(dout1_21) AT=1680.05n

.meas tran vdout1_22ck1670 FIND v(dout1_22) AT=1680.05n

.meas tran vdout1_23ck1670 FIND v(dout1_23) AT=1680.05n

.meas tran vdout1_24ck1670 FIND v(dout1_24) AT=1680.05n

.meas tran vdout1_25ck1670 FIND v(dout1_25) AT=1680.05n

.meas tran vdout1_26ck1670 FIND v(dout1_26) AT=1680.05n

.meas tran vdout1_27ck1670 FIND v(dout1_27) AT=1680.05n

.meas tran vdout1_28ck1670 FIND v(dout1_28) AT=1680.05n

.meas tran vdout1_29ck1670 FIND v(dout1_29) AT=1680.05n

.meas tran vdout1_30ck1670 FIND v(dout1_30) AT=1680.05n

.meas tran vdout1_31ck1670 FIND v(dout1_31) AT=1680.05n

.meas tran vdout1_32ck1670 FIND v(dout1_32) AT=1680.05n

.meas tran vdout1_33ck1670 FIND v(dout1_33) AT=1680.05n

.meas tran vdout1_34ck1670 FIND v(dout1_34) AT=1680.05n

.meas tran vdout1_35ck1670 FIND v(dout1_35) AT=1680.05n

.meas tran vdout1_36ck1670 FIND v(dout1_36) AT=1680.05n

.meas tran vdout1_37ck1670 FIND v(dout1_37) AT=1680.05n

.meas tran vdout1_38ck1670 FIND v(dout1_38) AT=1680.05n

.meas tran vdout1_39ck1670 FIND v(dout1_39) AT=1680.05n

.meas tran vdout1_40ck1670 FIND v(dout1_40) AT=1680.05n

.meas tran vdout1_41ck1670 FIND v(dout1_41) AT=1680.05n

.meas tran vdout1_42ck1670 FIND v(dout1_42) AT=1680.05n

.meas tran vdout1_43ck1670 FIND v(dout1_43) AT=1680.05n

.meas tran vdout1_44ck1670 FIND v(dout1_44) AT=1680.05n

.meas tran vdout1_45ck1670 FIND v(dout1_45) AT=1680.05n

.meas tran vdout1_46ck1670 FIND v(dout1_46) AT=1680.05n

.meas tran vdout1_47ck1670 FIND v(dout1_47) AT=1680.05n

.meas tran vdout1_48ck1670 FIND v(dout1_48) AT=1680.05n

.meas tran vdout1_49ck1670 FIND v(dout1_49) AT=1680.05n

.meas tran vdout1_50ck1670 FIND v(dout1_50) AT=1680.05n

.meas tran vdout1_51ck1670 FIND v(dout1_51) AT=1680.05n

.meas tran vdout1_52ck1670 FIND v(dout1_52) AT=1680.05n

.meas tran vdout1_53ck1670 FIND v(dout1_53) AT=1680.05n

.meas tran vdout1_54ck1670 FIND v(dout1_54) AT=1680.05n

.meas tran vdout1_55ck1670 FIND v(dout1_55) AT=1680.05n

.meas tran vdout1_56ck1670 FIND v(dout1_56) AT=1680.05n

.meas tran vdout1_57ck1670 FIND v(dout1_57) AT=1680.05n

.meas tran vdout1_58ck1670 FIND v(dout1_58) AT=1680.05n

.meas tran vdout1_59ck1670 FIND v(dout1_59) AT=1680.05n

.meas tran vdout1_60ck1670 FIND v(dout1_60) AT=1680.05n

.meas tran vdout1_61ck1670 FIND v(dout1_61) AT=1680.05n

.meas tran vdout1_62ck1670 FIND v(dout1_62) AT=1680.05n

.meas tran vdout1_63ck1670 FIND v(dout1_63) AT=1680.05n

.meas tran vdout1_64ck1670 FIND v(dout1_64) AT=1680.05n

.meas tran vdout1_65ck1670 FIND v(dout1_65) AT=1680.05n

.meas tran vdout1_66ck1670 FIND v(dout1_66) AT=1680.05n

.meas tran vdout1_67ck1670 FIND v(dout1_67) AT=1680.05n

.meas tran vdout1_68ck1670 FIND v(dout1_68) AT=1680.05n

.meas tran vdout1_69ck1670 FIND v(dout1_69) AT=1680.05n

.meas tran vdout1_70ck1670 FIND v(dout1_70) AT=1680.05n

.meas tran vdout1_71ck1670 FIND v(dout1_71) AT=1680.05n

.meas tran vdout1_72ck1670 FIND v(dout1_72) AT=1680.05n

.meas tran vdout1_73ck1670 FIND v(dout1_73) AT=1680.05n

.meas tran vdout1_74ck1670 FIND v(dout1_74) AT=1680.05n

.meas tran vdout1_75ck1670 FIND v(dout1_75) AT=1680.05n

.meas tran vdout1_76ck1670 FIND v(dout1_76) AT=1680.05n

.meas tran vdout1_77ck1670 FIND v(dout1_77) AT=1680.05n

.meas tran vdout1_78ck1670 FIND v(dout1_78) AT=1680.05n

.meas tran vdout1_79ck1670 FIND v(dout1_79) AT=1680.05n

.meas tran vdout1_80ck1670 FIND v(dout1_80) AT=1680.05n

.meas tran vdout1_81ck1670 FIND v(dout1_81) AT=1680.05n

.meas tran vdout1_82ck1670 FIND v(dout1_82) AT=1680.05n

.meas tran vdout1_83ck1670 FIND v(dout1_83) AT=1680.05n

.meas tran vdout1_84ck1670 FIND v(dout1_84) AT=1680.05n

.meas tran vdout1_85ck1670 FIND v(dout1_85) AT=1680.05n

.meas tran vdout1_86ck1670 FIND v(dout1_86) AT=1680.05n

.meas tran vdout1_87ck1670 FIND v(dout1_87) AT=1680.05n

.meas tran vdout1_88ck1670 FIND v(dout1_88) AT=1680.05n

.meas tran vdout1_89ck1670 FIND v(dout1_89) AT=1680.05n

.meas tran vdout1_90ck1670 FIND v(dout1_90) AT=1680.05n

.meas tran vdout1_91ck1670 FIND v(dout1_91) AT=1680.05n

.meas tran vdout1_92ck1670 FIND v(dout1_92) AT=1680.05n

.meas tran vdout1_93ck1670 FIND v(dout1_93) AT=1680.05n

.meas tran vdout1_94ck1670 FIND v(dout1_94) AT=1680.05n

.meas tran vdout1_95ck1670 FIND v(dout1_95) AT=1680.05n

.meas tran vdout1_96ck1670 FIND v(dout1_96) AT=1680.05n

.meas tran vdout1_97ck1670 FIND v(dout1_97) AT=1680.05n

.meas tran vdout1_98ck1670 FIND v(dout1_98) AT=1680.05n

.meas tran vdout1_99ck1670 FIND v(dout1_99) AT=1680.05n

.meas tran vdout1_100ck1670 FIND v(dout1_100) AT=1680.05n

.meas tran vdout1_101ck1670 FIND v(dout1_101) AT=1680.05n

.meas tran vdout1_102ck1670 FIND v(dout1_102) AT=1680.05n

.meas tran vdout1_103ck1670 FIND v(dout1_103) AT=1680.05n

.meas tran vdout1_104ck1670 FIND v(dout1_104) AT=1680.05n

.meas tran vdout1_105ck1670 FIND v(dout1_105) AT=1680.05n

.meas tran vdout1_106ck1670 FIND v(dout1_106) AT=1680.05n

.meas tran vdout1_107ck1670 FIND v(dout1_107) AT=1680.05n

.meas tran vdout1_108ck1670 FIND v(dout1_108) AT=1680.05n

.meas tran vdout1_109ck1670 FIND v(dout1_109) AT=1680.05n

.meas tran vdout1_110ck1670 FIND v(dout1_110) AT=1680.05n

.meas tran vdout1_111ck1670 FIND v(dout1_111) AT=1680.05n

.meas tran vdout1_112ck1670 FIND v(dout1_112) AT=1680.05n

.meas tran vdout1_113ck1670 FIND v(dout1_113) AT=1680.05n

.meas tran vdout1_114ck1670 FIND v(dout1_114) AT=1680.05n

.meas tran vdout1_115ck1670 FIND v(dout1_115) AT=1680.05n

.meas tran vdout1_116ck1670 FIND v(dout1_116) AT=1680.05n

.meas tran vdout1_117ck1670 FIND v(dout1_117) AT=1680.05n

.meas tran vdout1_118ck1670 FIND v(dout1_118) AT=1680.05n

.meas tran vdout1_119ck1670 FIND v(dout1_119) AT=1680.05n

.meas tran vdout1_120ck1670 FIND v(dout1_120) AT=1680.05n

.meas tran vdout1_121ck1670 FIND v(dout1_121) AT=1680.05n

.meas tran vdout1_122ck1670 FIND v(dout1_122) AT=1680.05n

.meas tran vdout1_123ck1670 FIND v(dout1_123) AT=1680.05n

.meas tran vdout1_124ck1670 FIND v(dout1_124) AT=1680.05n

.meas tran vdout1_125ck1670 FIND v(dout1_125) AT=1680.05n

.meas tran vdout1_126ck1670 FIND v(dout1_126) AT=1680.05n

.meas tran vdout1_127ck1670 FIND v(dout1_127) AT=1680.05n

.meas tran vdout1_128ck1670 FIND v(dout1_128) AT=1680.05n

.meas tran vdout1_129ck1670 FIND v(dout1_129) AT=1680.05n

.meas tran vdout1_130ck1670 FIND v(dout1_130) AT=1680.05n

.meas tran vdout1_131ck1670 FIND v(dout1_131) AT=1680.05n

.meas tran vdout1_132ck1670 FIND v(dout1_132) AT=1680.05n

.meas tran vdout1_133ck1670 FIND v(dout1_133) AT=1680.05n

.meas tran vdout1_134ck1670 FIND v(dout1_134) AT=1680.05n

.meas tran vdout1_0ck1760 FIND v(dout1_0) AT=1770.05n

.meas tran vdout1_1ck1760 FIND v(dout1_1) AT=1770.05n

.meas tran vdout1_2ck1760 FIND v(dout1_2) AT=1770.05n

.meas tran vdout1_3ck1760 FIND v(dout1_3) AT=1770.05n

.meas tran vdout1_4ck1760 FIND v(dout1_4) AT=1770.05n

.meas tran vdout1_5ck1760 FIND v(dout1_5) AT=1770.05n

.meas tran vdout1_6ck1760 FIND v(dout1_6) AT=1770.05n

.meas tran vdout1_7ck1760 FIND v(dout1_7) AT=1770.05n

.meas tran vdout1_8ck1760 FIND v(dout1_8) AT=1770.05n

.meas tran vdout1_9ck1760 FIND v(dout1_9) AT=1770.05n

.meas tran vdout1_10ck1760 FIND v(dout1_10) AT=1770.05n

.meas tran vdout1_11ck1760 FIND v(dout1_11) AT=1770.05n

.meas tran vdout1_12ck1760 FIND v(dout1_12) AT=1770.05n

.meas tran vdout1_13ck1760 FIND v(dout1_13) AT=1770.05n

.meas tran vdout1_14ck1760 FIND v(dout1_14) AT=1770.05n

.meas tran vdout1_15ck1760 FIND v(dout1_15) AT=1770.05n

.meas tran vdout1_16ck1760 FIND v(dout1_16) AT=1770.05n

.meas tran vdout1_17ck1760 FIND v(dout1_17) AT=1770.05n

.meas tran vdout1_18ck1760 FIND v(dout1_18) AT=1770.05n

.meas tran vdout1_19ck1760 FIND v(dout1_19) AT=1770.05n

.meas tran vdout1_20ck1760 FIND v(dout1_20) AT=1770.05n

.meas tran vdout1_21ck1760 FIND v(dout1_21) AT=1770.05n

.meas tran vdout1_22ck1760 FIND v(dout1_22) AT=1770.05n

.meas tran vdout1_23ck1760 FIND v(dout1_23) AT=1770.05n

.meas tran vdout1_24ck1760 FIND v(dout1_24) AT=1770.05n

.meas tran vdout1_25ck1760 FIND v(dout1_25) AT=1770.05n

.meas tran vdout1_26ck1760 FIND v(dout1_26) AT=1770.05n

.meas tran vdout1_27ck1760 FIND v(dout1_27) AT=1770.05n

.meas tran vdout1_28ck1760 FIND v(dout1_28) AT=1770.05n

.meas tran vdout1_29ck1760 FIND v(dout1_29) AT=1770.05n

.meas tran vdout1_30ck1760 FIND v(dout1_30) AT=1770.05n

.meas tran vdout1_31ck1760 FIND v(dout1_31) AT=1770.05n

.meas tran vdout1_32ck1760 FIND v(dout1_32) AT=1770.05n

.meas tran vdout1_33ck1760 FIND v(dout1_33) AT=1770.05n

.meas tran vdout1_34ck1760 FIND v(dout1_34) AT=1770.05n

.meas tran vdout1_35ck1760 FIND v(dout1_35) AT=1770.05n

.meas tran vdout1_36ck1760 FIND v(dout1_36) AT=1770.05n

.meas tran vdout1_37ck1760 FIND v(dout1_37) AT=1770.05n

.meas tran vdout1_38ck1760 FIND v(dout1_38) AT=1770.05n

.meas tran vdout1_39ck1760 FIND v(dout1_39) AT=1770.05n

.meas tran vdout1_40ck1760 FIND v(dout1_40) AT=1770.05n

.meas tran vdout1_41ck1760 FIND v(dout1_41) AT=1770.05n

.meas tran vdout1_42ck1760 FIND v(dout1_42) AT=1770.05n

.meas tran vdout1_43ck1760 FIND v(dout1_43) AT=1770.05n

.meas tran vdout1_44ck1760 FIND v(dout1_44) AT=1770.05n

.meas tran vdout1_45ck1760 FIND v(dout1_45) AT=1770.05n

.meas tran vdout1_46ck1760 FIND v(dout1_46) AT=1770.05n

.meas tran vdout1_47ck1760 FIND v(dout1_47) AT=1770.05n

.meas tran vdout1_48ck1760 FIND v(dout1_48) AT=1770.05n

.meas tran vdout1_49ck1760 FIND v(dout1_49) AT=1770.05n

.meas tran vdout1_50ck1760 FIND v(dout1_50) AT=1770.05n

.meas tran vdout1_51ck1760 FIND v(dout1_51) AT=1770.05n

.meas tran vdout1_52ck1760 FIND v(dout1_52) AT=1770.05n

.meas tran vdout1_53ck1760 FIND v(dout1_53) AT=1770.05n

.meas tran vdout1_54ck1760 FIND v(dout1_54) AT=1770.05n

.meas tran vdout1_55ck1760 FIND v(dout1_55) AT=1770.05n

.meas tran vdout1_56ck1760 FIND v(dout1_56) AT=1770.05n

.meas tran vdout1_57ck1760 FIND v(dout1_57) AT=1770.05n

.meas tran vdout1_58ck1760 FIND v(dout1_58) AT=1770.05n

.meas tran vdout1_59ck1760 FIND v(dout1_59) AT=1770.05n

.meas tran vdout1_60ck1760 FIND v(dout1_60) AT=1770.05n

.meas tran vdout1_61ck1760 FIND v(dout1_61) AT=1770.05n

.meas tran vdout1_62ck1760 FIND v(dout1_62) AT=1770.05n

.meas tran vdout1_63ck1760 FIND v(dout1_63) AT=1770.05n

.meas tran vdout1_64ck1760 FIND v(dout1_64) AT=1770.05n

.meas tran vdout1_65ck1760 FIND v(dout1_65) AT=1770.05n

.meas tran vdout1_66ck1760 FIND v(dout1_66) AT=1770.05n

.meas tran vdout1_67ck1760 FIND v(dout1_67) AT=1770.05n

.meas tran vdout1_68ck1760 FIND v(dout1_68) AT=1770.05n

.meas tran vdout1_69ck1760 FIND v(dout1_69) AT=1770.05n

.meas tran vdout1_70ck1760 FIND v(dout1_70) AT=1770.05n

.meas tran vdout1_71ck1760 FIND v(dout1_71) AT=1770.05n

.meas tran vdout1_72ck1760 FIND v(dout1_72) AT=1770.05n

.meas tran vdout1_73ck1760 FIND v(dout1_73) AT=1770.05n

.meas tran vdout1_74ck1760 FIND v(dout1_74) AT=1770.05n

.meas tran vdout1_75ck1760 FIND v(dout1_75) AT=1770.05n

.meas tran vdout1_76ck1760 FIND v(dout1_76) AT=1770.05n

.meas tran vdout1_77ck1760 FIND v(dout1_77) AT=1770.05n

.meas tran vdout1_78ck1760 FIND v(dout1_78) AT=1770.05n

.meas tran vdout1_79ck1760 FIND v(dout1_79) AT=1770.05n

.meas tran vdout1_80ck1760 FIND v(dout1_80) AT=1770.05n

.meas tran vdout1_81ck1760 FIND v(dout1_81) AT=1770.05n

.meas tran vdout1_82ck1760 FIND v(dout1_82) AT=1770.05n

.meas tran vdout1_83ck1760 FIND v(dout1_83) AT=1770.05n

.meas tran vdout1_84ck1760 FIND v(dout1_84) AT=1770.05n

.meas tran vdout1_85ck1760 FIND v(dout1_85) AT=1770.05n

.meas tran vdout1_86ck1760 FIND v(dout1_86) AT=1770.05n

.meas tran vdout1_87ck1760 FIND v(dout1_87) AT=1770.05n

.meas tran vdout1_88ck1760 FIND v(dout1_88) AT=1770.05n

.meas tran vdout1_89ck1760 FIND v(dout1_89) AT=1770.05n

.meas tran vdout1_90ck1760 FIND v(dout1_90) AT=1770.05n

.meas tran vdout1_91ck1760 FIND v(dout1_91) AT=1770.05n

.meas tran vdout1_92ck1760 FIND v(dout1_92) AT=1770.05n

.meas tran vdout1_93ck1760 FIND v(dout1_93) AT=1770.05n

.meas tran vdout1_94ck1760 FIND v(dout1_94) AT=1770.05n

.meas tran vdout1_95ck1760 FIND v(dout1_95) AT=1770.05n

.meas tran vdout1_96ck1760 FIND v(dout1_96) AT=1770.05n

.meas tran vdout1_97ck1760 FIND v(dout1_97) AT=1770.05n

.meas tran vdout1_98ck1760 FIND v(dout1_98) AT=1770.05n

.meas tran vdout1_99ck1760 FIND v(dout1_99) AT=1770.05n

.meas tran vdout1_100ck1760 FIND v(dout1_100) AT=1770.05n

.meas tran vdout1_101ck1760 FIND v(dout1_101) AT=1770.05n

.meas tran vdout1_102ck1760 FIND v(dout1_102) AT=1770.05n

.meas tran vdout1_103ck1760 FIND v(dout1_103) AT=1770.05n

.meas tran vdout1_104ck1760 FIND v(dout1_104) AT=1770.05n

.meas tran vdout1_105ck1760 FIND v(dout1_105) AT=1770.05n

.meas tran vdout1_106ck1760 FIND v(dout1_106) AT=1770.05n

.meas tran vdout1_107ck1760 FIND v(dout1_107) AT=1770.05n

.meas tran vdout1_108ck1760 FIND v(dout1_108) AT=1770.05n

.meas tran vdout1_109ck1760 FIND v(dout1_109) AT=1770.05n

.meas tran vdout1_110ck1760 FIND v(dout1_110) AT=1770.05n

.meas tran vdout1_111ck1760 FIND v(dout1_111) AT=1770.05n

.meas tran vdout1_112ck1760 FIND v(dout1_112) AT=1770.05n

.meas tran vdout1_113ck1760 FIND v(dout1_113) AT=1770.05n

.meas tran vdout1_114ck1760 FIND v(dout1_114) AT=1770.05n

.meas tran vdout1_115ck1760 FIND v(dout1_115) AT=1770.05n

.meas tran vdout1_116ck1760 FIND v(dout1_116) AT=1770.05n

.meas tran vdout1_117ck1760 FIND v(dout1_117) AT=1770.05n

.meas tran vdout1_118ck1760 FIND v(dout1_118) AT=1770.05n

.meas tran vdout1_119ck1760 FIND v(dout1_119) AT=1770.05n

.meas tran vdout1_120ck1760 FIND v(dout1_120) AT=1770.05n

.meas tran vdout1_121ck1760 FIND v(dout1_121) AT=1770.05n

.meas tran vdout1_122ck1760 FIND v(dout1_122) AT=1770.05n

.meas tran vdout1_123ck1760 FIND v(dout1_123) AT=1770.05n

.meas tran vdout1_124ck1760 FIND v(dout1_124) AT=1770.05n

.meas tran vdout1_125ck1760 FIND v(dout1_125) AT=1770.05n

.meas tran vdout1_126ck1760 FIND v(dout1_126) AT=1770.05n

.meas tran vdout1_127ck1760 FIND v(dout1_127) AT=1770.05n

.meas tran vdout1_128ck1760 FIND v(dout1_128) AT=1770.05n

.meas tran vdout1_129ck1760 FIND v(dout1_129) AT=1770.05n

.meas tran vdout1_130ck1760 FIND v(dout1_130) AT=1770.05n

.meas tran vdout1_131ck1760 FIND v(dout1_131) AT=1770.05n

.meas tran vdout1_132ck1760 FIND v(dout1_132) AT=1770.05n

.meas tran vdout1_133ck1760 FIND v(dout1_133) AT=1770.05n

.meas tran vdout1_134ck1760 FIND v(dout1_134) AT=1770.05n

.meas tran vdout1_0ck1790 FIND v(dout1_0) AT=1800.05n

.meas tran vdout1_1ck1790 FIND v(dout1_1) AT=1800.05n

.meas tran vdout1_2ck1790 FIND v(dout1_2) AT=1800.05n

.meas tran vdout1_3ck1790 FIND v(dout1_3) AT=1800.05n

.meas tran vdout1_4ck1790 FIND v(dout1_4) AT=1800.05n

.meas tran vdout1_5ck1790 FIND v(dout1_5) AT=1800.05n

.meas tran vdout1_6ck1790 FIND v(dout1_6) AT=1800.05n

.meas tran vdout1_7ck1790 FIND v(dout1_7) AT=1800.05n

.meas tran vdout1_8ck1790 FIND v(dout1_8) AT=1800.05n

.meas tran vdout1_9ck1790 FIND v(dout1_9) AT=1800.05n

.meas tran vdout1_10ck1790 FIND v(dout1_10) AT=1800.05n

.meas tran vdout1_11ck1790 FIND v(dout1_11) AT=1800.05n

.meas tran vdout1_12ck1790 FIND v(dout1_12) AT=1800.05n

.meas tran vdout1_13ck1790 FIND v(dout1_13) AT=1800.05n

.meas tran vdout1_14ck1790 FIND v(dout1_14) AT=1800.05n

.meas tran vdout1_15ck1790 FIND v(dout1_15) AT=1800.05n

.meas tran vdout1_16ck1790 FIND v(dout1_16) AT=1800.05n

.meas tran vdout1_17ck1790 FIND v(dout1_17) AT=1800.05n

.meas tran vdout1_18ck1790 FIND v(dout1_18) AT=1800.05n

.meas tran vdout1_19ck1790 FIND v(dout1_19) AT=1800.05n

.meas tran vdout1_20ck1790 FIND v(dout1_20) AT=1800.05n

.meas tran vdout1_21ck1790 FIND v(dout1_21) AT=1800.05n

.meas tran vdout1_22ck1790 FIND v(dout1_22) AT=1800.05n

.meas tran vdout1_23ck1790 FIND v(dout1_23) AT=1800.05n

.meas tran vdout1_24ck1790 FIND v(dout1_24) AT=1800.05n

.meas tran vdout1_25ck1790 FIND v(dout1_25) AT=1800.05n

.meas tran vdout1_26ck1790 FIND v(dout1_26) AT=1800.05n

.meas tran vdout1_27ck1790 FIND v(dout1_27) AT=1800.05n

.meas tran vdout1_28ck1790 FIND v(dout1_28) AT=1800.05n

.meas tran vdout1_29ck1790 FIND v(dout1_29) AT=1800.05n

.meas tran vdout1_30ck1790 FIND v(dout1_30) AT=1800.05n

.meas tran vdout1_31ck1790 FIND v(dout1_31) AT=1800.05n

.meas tran vdout1_32ck1790 FIND v(dout1_32) AT=1800.05n

.meas tran vdout1_33ck1790 FIND v(dout1_33) AT=1800.05n

.meas tran vdout1_34ck1790 FIND v(dout1_34) AT=1800.05n

.meas tran vdout1_35ck1790 FIND v(dout1_35) AT=1800.05n

.meas tran vdout1_36ck1790 FIND v(dout1_36) AT=1800.05n

.meas tran vdout1_37ck1790 FIND v(dout1_37) AT=1800.05n

.meas tran vdout1_38ck1790 FIND v(dout1_38) AT=1800.05n

.meas tran vdout1_39ck1790 FIND v(dout1_39) AT=1800.05n

.meas tran vdout1_40ck1790 FIND v(dout1_40) AT=1800.05n

.meas tran vdout1_41ck1790 FIND v(dout1_41) AT=1800.05n

.meas tran vdout1_42ck1790 FIND v(dout1_42) AT=1800.05n

.meas tran vdout1_43ck1790 FIND v(dout1_43) AT=1800.05n

.meas tran vdout1_44ck1790 FIND v(dout1_44) AT=1800.05n

.meas tran vdout1_45ck1790 FIND v(dout1_45) AT=1800.05n

.meas tran vdout1_46ck1790 FIND v(dout1_46) AT=1800.05n

.meas tran vdout1_47ck1790 FIND v(dout1_47) AT=1800.05n

.meas tran vdout1_48ck1790 FIND v(dout1_48) AT=1800.05n

.meas tran vdout1_49ck1790 FIND v(dout1_49) AT=1800.05n

.meas tran vdout1_50ck1790 FIND v(dout1_50) AT=1800.05n

.meas tran vdout1_51ck1790 FIND v(dout1_51) AT=1800.05n

.meas tran vdout1_52ck1790 FIND v(dout1_52) AT=1800.05n

.meas tran vdout1_53ck1790 FIND v(dout1_53) AT=1800.05n

.meas tran vdout1_54ck1790 FIND v(dout1_54) AT=1800.05n

.meas tran vdout1_55ck1790 FIND v(dout1_55) AT=1800.05n

.meas tran vdout1_56ck1790 FIND v(dout1_56) AT=1800.05n

.meas tran vdout1_57ck1790 FIND v(dout1_57) AT=1800.05n

.meas tran vdout1_58ck1790 FIND v(dout1_58) AT=1800.05n

.meas tran vdout1_59ck1790 FIND v(dout1_59) AT=1800.05n

.meas tran vdout1_60ck1790 FIND v(dout1_60) AT=1800.05n

.meas tran vdout1_61ck1790 FIND v(dout1_61) AT=1800.05n

.meas tran vdout1_62ck1790 FIND v(dout1_62) AT=1800.05n

.meas tran vdout1_63ck1790 FIND v(dout1_63) AT=1800.05n

.meas tran vdout1_64ck1790 FIND v(dout1_64) AT=1800.05n

.meas tran vdout1_65ck1790 FIND v(dout1_65) AT=1800.05n

.meas tran vdout1_66ck1790 FIND v(dout1_66) AT=1800.05n

.meas tran vdout1_67ck1790 FIND v(dout1_67) AT=1800.05n

.meas tran vdout1_68ck1790 FIND v(dout1_68) AT=1800.05n

.meas tran vdout1_69ck1790 FIND v(dout1_69) AT=1800.05n

.meas tran vdout1_70ck1790 FIND v(dout1_70) AT=1800.05n

.meas tran vdout1_71ck1790 FIND v(dout1_71) AT=1800.05n

.meas tran vdout1_72ck1790 FIND v(dout1_72) AT=1800.05n

.meas tran vdout1_73ck1790 FIND v(dout1_73) AT=1800.05n

.meas tran vdout1_74ck1790 FIND v(dout1_74) AT=1800.05n

.meas tran vdout1_75ck1790 FIND v(dout1_75) AT=1800.05n

.meas tran vdout1_76ck1790 FIND v(dout1_76) AT=1800.05n

.meas tran vdout1_77ck1790 FIND v(dout1_77) AT=1800.05n

.meas tran vdout1_78ck1790 FIND v(dout1_78) AT=1800.05n

.meas tran vdout1_79ck1790 FIND v(dout1_79) AT=1800.05n

.meas tran vdout1_80ck1790 FIND v(dout1_80) AT=1800.05n

.meas tran vdout1_81ck1790 FIND v(dout1_81) AT=1800.05n

.meas tran vdout1_82ck1790 FIND v(dout1_82) AT=1800.05n

.meas tran vdout1_83ck1790 FIND v(dout1_83) AT=1800.05n

.meas tran vdout1_84ck1790 FIND v(dout1_84) AT=1800.05n

.meas tran vdout1_85ck1790 FIND v(dout1_85) AT=1800.05n

.meas tran vdout1_86ck1790 FIND v(dout1_86) AT=1800.05n

.meas tran vdout1_87ck1790 FIND v(dout1_87) AT=1800.05n

.meas tran vdout1_88ck1790 FIND v(dout1_88) AT=1800.05n

.meas tran vdout1_89ck1790 FIND v(dout1_89) AT=1800.05n

.meas tran vdout1_90ck1790 FIND v(dout1_90) AT=1800.05n

.meas tran vdout1_91ck1790 FIND v(dout1_91) AT=1800.05n

.meas tran vdout1_92ck1790 FIND v(dout1_92) AT=1800.05n

.meas tran vdout1_93ck1790 FIND v(dout1_93) AT=1800.05n

.meas tran vdout1_94ck1790 FIND v(dout1_94) AT=1800.05n

.meas tran vdout1_95ck1790 FIND v(dout1_95) AT=1800.05n

.meas tran vdout1_96ck1790 FIND v(dout1_96) AT=1800.05n

.meas tran vdout1_97ck1790 FIND v(dout1_97) AT=1800.05n

.meas tran vdout1_98ck1790 FIND v(dout1_98) AT=1800.05n

.meas tran vdout1_99ck1790 FIND v(dout1_99) AT=1800.05n

.meas tran vdout1_100ck1790 FIND v(dout1_100) AT=1800.05n

.meas tran vdout1_101ck1790 FIND v(dout1_101) AT=1800.05n

.meas tran vdout1_102ck1790 FIND v(dout1_102) AT=1800.05n

.meas tran vdout1_103ck1790 FIND v(dout1_103) AT=1800.05n

.meas tran vdout1_104ck1790 FIND v(dout1_104) AT=1800.05n

.meas tran vdout1_105ck1790 FIND v(dout1_105) AT=1800.05n

.meas tran vdout1_106ck1790 FIND v(dout1_106) AT=1800.05n

.meas tran vdout1_107ck1790 FIND v(dout1_107) AT=1800.05n

.meas tran vdout1_108ck1790 FIND v(dout1_108) AT=1800.05n

.meas tran vdout1_109ck1790 FIND v(dout1_109) AT=1800.05n

.meas tran vdout1_110ck1790 FIND v(dout1_110) AT=1800.05n

.meas tran vdout1_111ck1790 FIND v(dout1_111) AT=1800.05n

.meas tran vdout1_112ck1790 FIND v(dout1_112) AT=1800.05n

.meas tran vdout1_113ck1790 FIND v(dout1_113) AT=1800.05n

.meas tran vdout1_114ck1790 FIND v(dout1_114) AT=1800.05n

.meas tran vdout1_115ck1790 FIND v(dout1_115) AT=1800.05n

.meas tran vdout1_116ck1790 FIND v(dout1_116) AT=1800.05n

.meas tran vdout1_117ck1790 FIND v(dout1_117) AT=1800.05n

.meas tran vdout1_118ck1790 FIND v(dout1_118) AT=1800.05n

.meas tran vdout1_119ck1790 FIND v(dout1_119) AT=1800.05n

.meas tran vdout1_120ck1790 FIND v(dout1_120) AT=1800.05n

.meas tran vdout1_121ck1790 FIND v(dout1_121) AT=1800.05n

.meas tran vdout1_122ck1790 FIND v(dout1_122) AT=1800.05n

.meas tran vdout1_123ck1790 FIND v(dout1_123) AT=1800.05n

.meas tran vdout1_124ck1790 FIND v(dout1_124) AT=1800.05n

.meas tran vdout1_125ck1790 FIND v(dout1_125) AT=1800.05n

.meas tran vdout1_126ck1790 FIND v(dout1_126) AT=1800.05n

.meas tran vdout1_127ck1790 FIND v(dout1_127) AT=1800.05n

.meas tran vdout1_128ck1790 FIND v(dout1_128) AT=1800.05n

.meas tran vdout1_129ck1790 FIND v(dout1_129) AT=1800.05n

.meas tran vdout1_130ck1790 FIND v(dout1_130) AT=1800.05n

.meas tran vdout1_131ck1790 FIND v(dout1_131) AT=1800.05n

.meas tran vdout1_132ck1790 FIND v(dout1_132) AT=1800.05n

.meas tran vdout1_133ck1790 FIND v(dout1_133) AT=1800.05n

.meas tran vdout1_134ck1790 FIND v(dout1_134) AT=1800.05n

.meas tran vdout1_0ck1840 FIND v(dout1_0) AT=1850.05n

.meas tran vdout1_1ck1840 FIND v(dout1_1) AT=1850.05n

.meas tran vdout1_2ck1840 FIND v(dout1_2) AT=1850.05n

.meas tran vdout1_3ck1840 FIND v(dout1_3) AT=1850.05n

.meas tran vdout1_4ck1840 FIND v(dout1_4) AT=1850.05n

.meas tran vdout1_5ck1840 FIND v(dout1_5) AT=1850.05n

.meas tran vdout1_6ck1840 FIND v(dout1_6) AT=1850.05n

.meas tran vdout1_7ck1840 FIND v(dout1_7) AT=1850.05n

.meas tran vdout1_8ck1840 FIND v(dout1_8) AT=1850.05n

.meas tran vdout1_9ck1840 FIND v(dout1_9) AT=1850.05n

.meas tran vdout1_10ck1840 FIND v(dout1_10) AT=1850.05n

.meas tran vdout1_11ck1840 FIND v(dout1_11) AT=1850.05n

.meas tran vdout1_12ck1840 FIND v(dout1_12) AT=1850.05n

.meas tran vdout1_13ck1840 FIND v(dout1_13) AT=1850.05n

.meas tran vdout1_14ck1840 FIND v(dout1_14) AT=1850.05n

.meas tran vdout1_15ck1840 FIND v(dout1_15) AT=1850.05n

.meas tran vdout1_16ck1840 FIND v(dout1_16) AT=1850.05n

.meas tran vdout1_17ck1840 FIND v(dout1_17) AT=1850.05n

.meas tran vdout1_18ck1840 FIND v(dout1_18) AT=1850.05n

.meas tran vdout1_19ck1840 FIND v(dout1_19) AT=1850.05n

.meas tran vdout1_20ck1840 FIND v(dout1_20) AT=1850.05n

.meas tran vdout1_21ck1840 FIND v(dout1_21) AT=1850.05n

.meas tran vdout1_22ck1840 FIND v(dout1_22) AT=1850.05n

.meas tran vdout1_23ck1840 FIND v(dout1_23) AT=1850.05n

.meas tran vdout1_24ck1840 FIND v(dout1_24) AT=1850.05n

.meas tran vdout1_25ck1840 FIND v(dout1_25) AT=1850.05n

.meas tran vdout1_26ck1840 FIND v(dout1_26) AT=1850.05n

.meas tran vdout1_27ck1840 FIND v(dout1_27) AT=1850.05n

.meas tran vdout1_28ck1840 FIND v(dout1_28) AT=1850.05n

.meas tran vdout1_29ck1840 FIND v(dout1_29) AT=1850.05n

.meas tran vdout1_30ck1840 FIND v(dout1_30) AT=1850.05n

.meas tran vdout1_31ck1840 FIND v(dout1_31) AT=1850.05n

.meas tran vdout1_32ck1840 FIND v(dout1_32) AT=1850.05n

.meas tran vdout1_33ck1840 FIND v(dout1_33) AT=1850.05n

.meas tran vdout1_34ck1840 FIND v(dout1_34) AT=1850.05n

.meas tran vdout1_35ck1840 FIND v(dout1_35) AT=1850.05n

.meas tran vdout1_36ck1840 FIND v(dout1_36) AT=1850.05n

.meas tran vdout1_37ck1840 FIND v(dout1_37) AT=1850.05n

.meas tran vdout1_38ck1840 FIND v(dout1_38) AT=1850.05n

.meas tran vdout1_39ck1840 FIND v(dout1_39) AT=1850.05n

.meas tran vdout1_40ck1840 FIND v(dout1_40) AT=1850.05n

.meas tran vdout1_41ck1840 FIND v(dout1_41) AT=1850.05n

.meas tran vdout1_42ck1840 FIND v(dout1_42) AT=1850.05n

.meas tran vdout1_43ck1840 FIND v(dout1_43) AT=1850.05n

.meas tran vdout1_44ck1840 FIND v(dout1_44) AT=1850.05n

.meas tran vdout1_45ck1840 FIND v(dout1_45) AT=1850.05n

.meas tran vdout1_46ck1840 FIND v(dout1_46) AT=1850.05n

.meas tran vdout1_47ck1840 FIND v(dout1_47) AT=1850.05n

.meas tran vdout1_48ck1840 FIND v(dout1_48) AT=1850.05n

.meas tran vdout1_49ck1840 FIND v(dout1_49) AT=1850.05n

.meas tran vdout1_50ck1840 FIND v(dout1_50) AT=1850.05n

.meas tran vdout1_51ck1840 FIND v(dout1_51) AT=1850.05n

.meas tran vdout1_52ck1840 FIND v(dout1_52) AT=1850.05n

.meas tran vdout1_53ck1840 FIND v(dout1_53) AT=1850.05n

.meas tran vdout1_54ck1840 FIND v(dout1_54) AT=1850.05n

.meas tran vdout1_55ck1840 FIND v(dout1_55) AT=1850.05n

.meas tran vdout1_56ck1840 FIND v(dout1_56) AT=1850.05n

.meas tran vdout1_57ck1840 FIND v(dout1_57) AT=1850.05n

.meas tran vdout1_58ck1840 FIND v(dout1_58) AT=1850.05n

.meas tran vdout1_59ck1840 FIND v(dout1_59) AT=1850.05n

.meas tran vdout1_60ck1840 FIND v(dout1_60) AT=1850.05n

.meas tran vdout1_61ck1840 FIND v(dout1_61) AT=1850.05n

.meas tran vdout1_62ck1840 FIND v(dout1_62) AT=1850.05n

.meas tran vdout1_63ck1840 FIND v(dout1_63) AT=1850.05n

.meas tran vdout1_64ck1840 FIND v(dout1_64) AT=1850.05n

.meas tran vdout1_65ck1840 FIND v(dout1_65) AT=1850.05n

.meas tran vdout1_66ck1840 FIND v(dout1_66) AT=1850.05n

.meas tran vdout1_67ck1840 FIND v(dout1_67) AT=1850.05n

.meas tran vdout1_68ck1840 FIND v(dout1_68) AT=1850.05n

.meas tran vdout1_69ck1840 FIND v(dout1_69) AT=1850.05n

.meas tran vdout1_70ck1840 FIND v(dout1_70) AT=1850.05n

.meas tran vdout1_71ck1840 FIND v(dout1_71) AT=1850.05n

.meas tran vdout1_72ck1840 FIND v(dout1_72) AT=1850.05n

.meas tran vdout1_73ck1840 FIND v(dout1_73) AT=1850.05n

.meas tran vdout1_74ck1840 FIND v(dout1_74) AT=1850.05n

.meas tran vdout1_75ck1840 FIND v(dout1_75) AT=1850.05n

.meas tran vdout1_76ck1840 FIND v(dout1_76) AT=1850.05n

.meas tran vdout1_77ck1840 FIND v(dout1_77) AT=1850.05n

.meas tran vdout1_78ck1840 FIND v(dout1_78) AT=1850.05n

.meas tran vdout1_79ck1840 FIND v(dout1_79) AT=1850.05n

.meas tran vdout1_80ck1840 FIND v(dout1_80) AT=1850.05n

.meas tran vdout1_81ck1840 FIND v(dout1_81) AT=1850.05n

.meas tran vdout1_82ck1840 FIND v(dout1_82) AT=1850.05n

.meas tran vdout1_83ck1840 FIND v(dout1_83) AT=1850.05n

.meas tran vdout1_84ck1840 FIND v(dout1_84) AT=1850.05n

.meas tran vdout1_85ck1840 FIND v(dout1_85) AT=1850.05n

.meas tran vdout1_86ck1840 FIND v(dout1_86) AT=1850.05n

.meas tran vdout1_87ck1840 FIND v(dout1_87) AT=1850.05n

.meas tran vdout1_88ck1840 FIND v(dout1_88) AT=1850.05n

.meas tran vdout1_89ck1840 FIND v(dout1_89) AT=1850.05n

.meas tran vdout1_90ck1840 FIND v(dout1_90) AT=1850.05n

.meas tran vdout1_91ck1840 FIND v(dout1_91) AT=1850.05n

.meas tran vdout1_92ck1840 FIND v(dout1_92) AT=1850.05n

.meas tran vdout1_93ck1840 FIND v(dout1_93) AT=1850.05n

.meas tran vdout1_94ck1840 FIND v(dout1_94) AT=1850.05n

.meas tran vdout1_95ck1840 FIND v(dout1_95) AT=1850.05n

.meas tran vdout1_96ck1840 FIND v(dout1_96) AT=1850.05n

.meas tran vdout1_97ck1840 FIND v(dout1_97) AT=1850.05n

.meas tran vdout1_98ck1840 FIND v(dout1_98) AT=1850.05n

.meas tran vdout1_99ck1840 FIND v(dout1_99) AT=1850.05n

.meas tran vdout1_100ck1840 FIND v(dout1_100) AT=1850.05n

.meas tran vdout1_101ck1840 FIND v(dout1_101) AT=1850.05n

.meas tran vdout1_102ck1840 FIND v(dout1_102) AT=1850.05n

.meas tran vdout1_103ck1840 FIND v(dout1_103) AT=1850.05n

.meas tran vdout1_104ck1840 FIND v(dout1_104) AT=1850.05n

.meas tran vdout1_105ck1840 FIND v(dout1_105) AT=1850.05n

.meas tran vdout1_106ck1840 FIND v(dout1_106) AT=1850.05n

.meas tran vdout1_107ck1840 FIND v(dout1_107) AT=1850.05n

.meas tran vdout1_108ck1840 FIND v(dout1_108) AT=1850.05n

.meas tran vdout1_109ck1840 FIND v(dout1_109) AT=1850.05n

.meas tran vdout1_110ck1840 FIND v(dout1_110) AT=1850.05n

.meas tran vdout1_111ck1840 FIND v(dout1_111) AT=1850.05n

.meas tran vdout1_112ck1840 FIND v(dout1_112) AT=1850.05n

.meas tran vdout1_113ck1840 FIND v(dout1_113) AT=1850.05n

.meas tran vdout1_114ck1840 FIND v(dout1_114) AT=1850.05n

.meas tran vdout1_115ck1840 FIND v(dout1_115) AT=1850.05n

.meas tran vdout1_116ck1840 FIND v(dout1_116) AT=1850.05n

.meas tran vdout1_117ck1840 FIND v(dout1_117) AT=1850.05n

.meas tran vdout1_118ck1840 FIND v(dout1_118) AT=1850.05n

.meas tran vdout1_119ck1840 FIND v(dout1_119) AT=1850.05n

.meas tran vdout1_120ck1840 FIND v(dout1_120) AT=1850.05n

.meas tran vdout1_121ck1840 FIND v(dout1_121) AT=1850.05n

.meas tran vdout1_122ck1840 FIND v(dout1_122) AT=1850.05n

.meas tran vdout1_123ck1840 FIND v(dout1_123) AT=1850.05n

.meas tran vdout1_124ck1840 FIND v(dout1_124) AT=1850.05n

.meas tran vdout1_125ck1840 FIND v(dout1_125) AT=1850.05n

.meas tran vdout1_126ck1840 FIND v(dout1_126) AT=1850.05n

.meas tran vdout1_127ck1840 FIND v(dout1_127) AT=1850.05n

.meas tran vdout1_128ck1840 FIND v(dout1_128) AT=1850.05n

.meas tran vdout1_129ck1840 FIND v(dout1_129) AT=1850.05n

.meas tran vdout1_130ck1840 FIND v(dout1_130) AT=1850.05n

.meas tran vdout1_131ck1840 FIND v(dout1_131) AT=1850.05n

.meas tran vdout1_132ck1840 FIND v(dout1_132) AT=1850.05n

.meas tran vdout1_133ck1840 FIND v(dout1_133) AT=1850.05n

.meas tran vdout1_134ck1840 FIND v(dout1_134) AT=1850.05n

.meas tran vdout1_0ck1860 FIND v(dout1_0) AT=1870.05n

.meas tran vdout1_1ck1860 FIND v(dout1_1) AT=1870.05n

.meas tran vdout1_2ck1860 FIND v(dout1_2) AT=1870.05n

.meas tran vdout1_3ck1860 FIND v(dout1_3) AT=1870.05n

.meas tran vdout1_4ck1860 FIND v(dout1_4) AT=1870.05n

.meas tran vdout1_5ck1860 FIND v(dout1_5) AT=1870.05n

.meas tran vdout1_6ck1860 FIND v(dout1_6) AT=1870.05n

.meas tran vdout1_7ck1860 FIND v(dout1_7) AT=1870.05n

.meas tran vdout1_8ck1860 FIND v(dout1_8) AT=1870.05n

.meas tran vdout1_9ck1860 FIND v(dout1_9) AT=1870.05n

.meas tran vdout1_10ck1860 FIND v(dout1_10) AT=1870.05n

.meas tran vdout1_11ck1860 FIND v(dout1_11) AT=1870.05n

.meas tran vdout1_12ck1860 FIND v(dout1_12) AT=1870.05n

.meas tran vdout1_13ck1860 FIND v(dout1_13) AT=1870.05n

.meas tran vdout1_14ck1860 FIND v(dout1_14) AT=1870.05n

.meas tran vdout1_15ck1860 FIND v(dout1_15) AT=1870.05n

.meas tran vdout1_16ck1860 FIND v(dout1_16) AT=1870.05n

.meas tran vdout1_17ck1860 FIND v(dout1_17) AT=1870.05n

.meas tran vdout1_18ck1860 FIND v(dout1_18) AT=1870.05n

.meas tran vdout1_19ck1860 FIND v(dout1_19) AT=1870.05n

.meas tran vdout1_20ck1860 FIND v(dout1_20) AT=1870.05n

.meas tran vdout1_21ck1860 FIND v(dout1_21) AT=1870.05n

.meas tran vdout1_22ck1860 FIND v(dout1_22) AT=1870.05n

.meas tran vdout1_23ck1860 FIND v(dout1_23) AT=1870.05n

.meas tran vdout1_24ck1860 FIND v(dout1_24) AT=1870.05n

.meas tran vdout1_25ck1860 FIND v(dout1_25) AT=1870.05n

.meas tran vdout1_26ck1860 FIND v(dout1_26) AT=1870.05n

.meas tran vdout1_27ck1860 FIND v(dout1_27) AT=1870.05n

.meas tran vdout1_28ck1860 FIND v(dout1_28) AT=1870.05n

.meas tran vdout1_29ck1860 FIND v(dout1_29) AT=1870.05n

.meas tran vdout1_30ck1860 FIND v(dout1_30) AT=1870.05n

.meas tran vdout1_31ck1860 FIND v(dout1_31) AT=1870.05n

.meas tran vdout1_32ck1860 FIND v(dout1_32) AT=1870.05n

.meas tran vdout1_33ck1860 FIND v(dout1_33) AT=1870.05n

.meas tran vdout1_34ck1860 FIND v(dout1_34) AT=1870.05n

.meas tran vdout1_35ck1860 FIND v(dout1_35) AT=1870.05n

.meas tran vdout1_36ck1860 FIND v(dout1_36) AT=1870.05n

.meas tran vdout1_37ck1860 FIND v(dout1_37) AT=1870.05n

.meas tran vdout1_38ck1860 FIND v(dout1_38) AT=1870.05n

.meas tran vdout1_39ck1860 FIND v(dout1_39) AT=1870.05n

.meas tran vdout1_40ck1860 FIND v(dout1_40) AT=1870.05n

.meas tran vdout1_41ck1860 FIND v(dout1_41) AT=1870.05n

.meas tran vdout1_42ck1860 FIND v(dout1_42) AT=1870.05n

.meas tran vdout1_43ck1860 FIND v(dout1_43) AT=1870.05n

.meas tran vdout1_44ck1860 FIND v(dout1_44) AT=1870.05n

.meas tran vdout1_45ck1860 FIND v(dout1_45) AT=1870.05n

.meas tran vdout1_46ck1860 FIND v(dout1_46) AT=1870.05n

.meas tran vdout1_47ck1860 FIND v(dout1_47) AT=1870.05n

.meas tran vdout1_48ck1860 FIND v(dout1_48) AT=1870.05n

.meas tran vdout1_49ck1860 FIND v(dout1_49) AT=1870.05n

.meas tran vdout1_50ck1860 FIND v(dout1_50) AT=1870.05n

.meas tran vdout1_51ck1860 FIND v(dout1_51) AT=1870.05n

.meas tran vdout1_52ck1860 FIND v(dout1_52) AT=1870.05n

.meas tran vdout1_53ck1860 FIND v(dout1_53) AT=1870.05n

.meas tran vdout1_54ck1860 FIND v(dout1_54) AT=1870.05n

.meas tran vdout1_55ck1860 FIND v(dout1_55) AT=1870.05n

.meas tran vdout1_56ck1860 FIND v(dout1_56) AT=1870.05n

.meas tran vdout1_57ck1860 FIND v(dout1_57) AT=1870.05n

.meas tran vdout1_58ck1860 FIND v(dout1_58) AT=1870.05n

.meas tran vdout1_59ck1860 FIND v(dout1_59) AT=1870.05n

.meas tran vdout1_60ck1860 FIND v(dout1_60) AT=1870.05n

.meas tran vdout1_61ck1860 FIND v(dout1_61) AT=1870.05n

.meas tran vdout1_62ck1860 FIND v(dout1_62) AT=1870.05n

.meas tran vdout1_63ck1860 FIND v(dout1_63) AT=1870.05n

.meas tran vdout1_64ck1860 FIND v(dout1_64) AT=1870.05n

.meas tran vdout1_65ck1860 FIND v(dout1_65) AT=1870.05n

.meas tran vdout1_66ck1860 FIND v(dout1_66) AT=1870.05n

.meas tran vdout1_67ck1860 FIND v(dout1_67) AT=1870.05n

.meas tran vdout1_68ck1860 FIND v(dout1_68) AT=1870.05n

.meas tran vdout1_69ck1860 FIND v(dout1_69) AT=1870.05n

.meas tran vdout1_70ck1860 FIND v(dout1_70) AT=1870.05n

.meas tran vdout1_71ck1860 FIND v(dout1_71) AT=1870.05n

.meas tran vdout1_72ck1860 FIND v(dout1_72) AT=1870.05n

.meas tran vdout1_73ck1860 FIND v(dout1_73) AT=1870.05n

.meas tran vdout1_74ck1860 FIND v(dout1_74) AT=1870.05n

.meas tran vdout1_75ck1860 FIND v(dout1_75) AT=1870.05n

.meas tran vdout1_76ck1860 FIND v(dout1_76) AT=1870.05n

.meas tran vdout1_77ck1860 FIND v(dout1_77) AT=1870.05n

.meas tran vdout1_78ck1860 FIND v(dout1_78) AT=1870.05n

.meas tran vdout1_79ck1860 FIND v(dout1_79) AT=1870.05n

.meas tran vdout1_80ck1860 FIND v(dout1_80) AT=1870.05n

.meas tran vdout1_81ck1860 FIND v(dout1_81) AT=1870.05n

.meas tran vdout1_82ck1860 FIND v(dout1_82) AT=1870.05n

.meas tran vdout1_83ck1860 FIND v(dout1_83) AT=1870.05n

.meas tran vdout1_84ck1860 FIND v(dout1_84) AT=1870.05n

.meas tran vdout1_85ck1860 FIND v(dout1_85) AT=1870.05n

.meas tran vdout1_86ck1860 FIND v(dout1_86) AT=1870.05n

.meas tran vdout1_87ck1860 FIND v(dout1_87) AT=1870.05n

.meas tran vdout1_88ck1860 FIND v(dout1_88) AT=1870.05n

.meas tran vdout1_89ck1860 FIND v(dout1_89) AT=1870.05n

.meas tran vdout1_90ck1860 FIND v(dout1_90) AT=1870.05n

.meas tran vdout1_91ck1860 FIND v(dout1_91) AT=1870.05n

.meas tran vdout1_92ck1860 FIND v(dout1_92) AT=1870.05n

.meas tran vdout1_93ck1860 FIND v(dout1_93) AT=1870.05n

.meas tran vdout1_94ck1860 FIND v(dout1_94) AT=1870.05n

.meas tran vdout1_95ck1860 FIND v(dout1_95) AT=1870.05n

.meas tran vdout1_96ck1860 FIND v(dout1_96) AT=1870.05n

.meas tran vdout1_97ck1860 FIND v(dout1_97) AT=1870.05n

.meas tran vdout1_98ck1860 FIND v(dout1_98) AT=1870.05n

.meas tran vdout1_99ck1860 FIND v(dout1_99) AT=1870.05n

.meas tran vdout1_100ck1860 FIND v(dout1_100) AT=1870.05n

.meas tran vdout1_101ck1860 FIND v(dout1_101) AT=1870.05n

.meas tran vdout1_102ck1860 FIND v(dout1_102) AT=1870.05n

.meas tran vdout1_103ck1860 FIND v(dout1_103) AT=1870.05n

.meas tran vdout1_104ck1860 FIND v(dout1_104) AT=1870.05n

.meas tran vdout1_105ck1860 FIND v(dout1_105) AT=1870.05n

.meas tran vdout1_106ck1860 FIND v(dout1_106) AT=1870.05n

.meas tran vdout1_107ck1860 FIND v(dout1_107) AT=1870.05n

.meas tran vdout1_108ck1860 FIND v(dout1_108) AT=1870.05n

.meas tran vdout1_109ck1860 FIND v(dout1_109) AT=1870.05n

.meas tran vdout1_110ck1860 FIND v(dout1_110) AT=1870.05n

.meas tran vdout1_111ck1860 FIND v(dout1_111) AT=1870.05n

.meas tran vdout1_112ck1860 FIND v(dout1_112) AT=1870.05n

.meas tran vdout1_113ck1860 FIND v(dout1_113) AT=1870.05n

.meas tran vdout1_114ck1860 FIND v(dout1_114) AT=1870.05n

.meas tran vdout1_115ck1860 FIND v(dout1_115) AT=1870.05n

.meas tran vdout1_116ck1860 FIND v(dout1_116) AT=1870.05n

.meas tran vdout1_117ck1860 FIND v(dout1_117) AT=1870.05n

.meas tran vdout1_118ck1860 FIND v(dout1_118) AT=1870.05n

.meas tran vdout1_119ck1860 FIND v(dout1_119) AT=1870.05n

.meas tran vdout1_120ck1860 FIND v(dout1_120) AT=1870.05n

.meas tran vdout1_121ck1860 FIND v(dout1_121) AT=1870.05n

.meas tran vdout1_122ck1860 FIND v(dout1_122) AT=1870.05n

.meas tran vdout1_123ck1860 FIND v(dout1_123) AT=1870.05n

.meas tran vdout1_124ck1860 FIND v(dout1_124) AT=1870.05n

.meas tran vdout1_125ck1860 FIND v(dout1_125) AT=1870.05n

.meas tran vdout1_126ck1860 FIND v(dout1_126) AT=1870.05n

.meas tran vdout1_127ck1860 FIND v(dout1_127) AT=1870.05n

.meas tran vdout1_128ck1860 FIND v(dout1_128) AT=1870.05n

.meas tran vdout1_129ck1860 FIND v(dout1_129) AT=1870.05n

.meas tran vdout1_130ck1860 FIND v(dout1_130) AT=1870.05n

.meas tran vdout1_131ck1860 FIND v(dout1_131) AT=1870.05n

.meas tran vdout1_132ck1860 FIND v(dout1_132) AT=1870.05n

.meas tran vdout1_133ck1860 FIND v(dout1_133) AT=1870.05n

.meas tran vdout1_134ck1860 FIND v(dout1_134) AT=1870.05n

.meas tran vdout1_0ck1900 FIND v(dout1_0) AT=1910.05n

.meas tran vdout1_1ck1900 FIND v(dout1_1) AT=1910.05n

.meas tran vdout1_2ck1900 FIND v(dout1_2) AT=1910.05n

.meas tran vdout1_3ck1900 FIND v(dout1_3) AT=1910.05n

.meas tran vdout1_4ck1900 FIND v(dout1_4) AT=1910.05n

.meas tran vdout1_5ck1900 FIND v(dout1_5) AT=1910.05n

.meas tran vdout1_6ck1900 FIND v(dout1_6) AT=1910.05n

.meas tran vdout1_7ck1900 FIND v(dout1_7) AT=1910.05n

.meas tran vdout1_8ck1900 FIND v(dout1_8) AT=1910.05n

.meas tran vdout1_9ck1900 FIND v(dout1_9) AT=1910.05n

.meas tran vdout1_10ck1900 FIND v(dout1_10) AT=1910.05n

.meas tran vdout1_11ck1900 FIND v(dout1_11) AT=1910.05n

.meas tran vdout1_12ck1900 FIND v(dout1_12) AT=1910.05n

.meas tran vdout1_13ck1900 FIND v(dout1_13) AT=1910.05n

.meas tran vdout1_14ck1900 FIND v(dout1_14) AT=1910.05n

.meas tran vdout1_15ck1900 FIND v(dout1_15) AT=1910.05n

.meas tran vdout1_16ck1900 FIND v(dout1_16) AT=1910.05n

.meas tran vdout1_17ck1900 FIND v(dout1_17) AT=1910.05n

.meas tran vdout1_18ck1900 FIND v(dout1_18) AT=1910.05n

.meas tran vdout1_19ck1900 FIND v(dout1_19) AT=1910.05n

.meas tran vdout1_20ck1900 FIND v(dout1_20) AT=1910.05n

.meas tran vdout1_21ck1900 FIND v(dout1_21) AT=1910.05n

.meas tran vdout1_22ck1900 FIND v(dout1_22) AT=1910.05n

.meas tran vdout1_23ck1900 FIND v(dout1_23) AT=1910.05n

.meas tran vdout1_24ck1900 FIND v(dout1_24) AT=1910.05n

.meas tran vdout1_25ck1900 FIND v(dout1_25) AT=1910.05n

.meas tran vdout1_26ck1900 FIND v(dout1_26) AT=1910.05n

.meas tran vdout1_27ck1900 FIND v(dout1_27) AT=1910.05n

.meas tran vdout1_28ck1900 FIND v(dout1_28) AT=1910.05n

.meas tran vdout1_29ck1900 FIND v(dout1_29) AT=1910.05n

.meas tran vdout1_30ck1900 FIND v(dout1_30) AT=1910.05n

.meas tran vdout1_31ck1900 FIND v(dout1_31) AT=1910.05n

.meas tran vdout1_32ck1900 FIND v(dout1_32) AT=1910.05n

.meas tran vdout1_33ck1900 FIND v(dout1_33) AT=1910.05n

.meas tran vdout1_34ck1900 FIND v(dout1_34) AT=1910.05n

.meas tran vdout1_35ck1900 FIND v(dout1_35) AT=1910.05n

.meas tran vdout1_36ck1900 FIND v(dout1_36) AT=1910.05n

.meas tran vdout1_37ck1900 FIND v(dout1_37) AT=1910.05n

.meas tran vdout1_38ck1900 FIND v(dout1_38) AT=1910.05n

.meas tran vdout1_39ck1900 FIND v(dout1_39) AT=1910.05n

.meas tran vdout1_40ck1900 FIND v(dout1_40) AT=1910.05n

.meas tran vdout1_41ck1900 FIND v(dout1_41) AT=1910.05n

.meas tran vdout1_42ck1900 FIND v(dout1_42) AT=1910.05n

.meas tran vdout1_43ck1900 FIND v(dout1_43) AT=1910.05n

.meas tran vdout1_44ck1900 FIND v(dout1_44) AT=1910.05n

.meas tran vdout1_45ck1900 FIND v(dout1_45) AT=1910.05n

.meas tran vdout1_46ck1900 FIND v(dout1_46) AT=1910.05n

.meas tran vdout1_47ck1900 FIND v(dout1_47) AT=1910.05n

.meas tran vdout1_48ck1900 FIND v(dout1_48) AT=1910.05n

.meas tran vdout1_49ck1900 FIND v(dout1_49) AT=1910.05n

.meas tran vdout1_50ck1900 FIND v(dout1_50) AT=1910.05n

.meas tran vdout1_51ck1900 FIND v(dout1_51) AT=1910.05n

.meas tran vdout1_52ck1900 FIND v(dout1_52) AT=1910.05n

.meas tran vdout1_53ck1900 FIND v(dout1_53) AT=1910.05n

.meas tran vdout1_54ck1900 FIND v(dout1_54) AT=1910.05n

.meas tran vdout1_55ck1900 FIND v(dout1_55) AT=1910.05n

.meas tran vdout1_56ck1900 FIND v(dout1_56) AT=1910.05n

.meas tran vdout1_57ck1900 FIND v(dout1_57) AT=1910.05n

.meas tran vdout1_58ck1900 FIND v(dout1_58) AT=1910.05n

.meas tran vdout1_59ck1900 FIND v(dout1_59) AT=1910.05n

.meas tran vdout1_60ck1900 FIND v(dout1_60) AT=1910.05n

.meas tran vdout1_61ck1900 FIND v(dout1_61) AT=1910.05n

.meas tran vdout1_62ck1900 FIND v(dout1_62) AT=1910.05n

.meas tran vdout1_63ck1900 FIND v(dout1_63) AT=1910.05n

.meas tran vdout1_64ck1900 FIND v(dout1_64) AT=1910.05n

.meas tran vdout1_65ck1900 FIND v(dout1_65) AT=1910.05n

.meas tran vdout1_66ck1900 FIND v(dout1_66) AT=1910.05n

.meas tran vdout1_67ck1900 FIND v(dout1_67) AT=1910.05n

.meas tran vdout1_68ck1900 FIND v(dout1_68) AT=1910.05n

.meas tran vdout1_69ck1900 FIND v(dout1_69) AT=1910.05n

.meas tran vdout1_70ck1900 FIND v(dout1_70) AT=1910.05n

.meas tran vdout1_71ck1900 FIND v(dout1_71) AT=1910.05n

.meas tran vdout1_72ck1900 FIND v(dout1_72) AT=1910.05n

.meas tran vdout1_73ck1900 FIND v(dout1_73) AT=1910.05n

.meas tran vdout1_74ck1900 FIND v(dout1_74) AT=1910.05n

.meas tran vdout1_75ck1900 FIND v(dout1_75) AT=1910.05n

.meas tran vdout1_76ck1900 FIND v(dout1_76) AT=1910.05n

.meas tran vdout1_77ck1900 FIND v(dout1_77) AT=1910.05n

.meas tran vdout1_78ck1900 FIND v(dout1_78) AT=1910.05n

.meas tran vdout1_79ck1900 FIND v(dout1_79) AT=1910.05n

.meas tran vdout1_80ck1900 FIND v(dout1_80) AT=1910.05n

.meas tran vdout1_81ck1900 FIND v(dout1_81) AT=1910.05n

.meas tran vdout1_82ck1900 FIND v(dout1_82) AT=1910.05n

.meas tran vdout1_83ck1900 FIND v(dout1_83) AT=1910.05n

.meas tran vdout1_84ck1900 FIND v(dout1_84) AT=1910.05n

.meas tran vdout1_85ck1900 FIND v(dout1_85) AT=1910.05n

.meas tran vdout1_86ck1900 FIND v(dout1_86) AT=1910.05n

.meas tran vdout1_87ck1900 FIND v(dout1_87) AT=1910.05n

.meas tran vdout1_88ck1900 FIND v(dout1_88) AT=1910.05n

.meas tran vdout1_89ck1900 FIND v(dout1_89) AT=1910.05n

.meas tran vdout1_90ck1900 FIND v(dout1_90) AT=1910.05n

.meas tran vdout1_91ck1900 FIND v(dout1_91) AT=1910.05n

.meas tran vdout1_92ck1900 FIND v(dout1_92) AT=1910.05n

.meas tran vdout1_93ck1900 FIND v(dout1_93) AT=1910.05n

.meas tran vdout1_94ck1900 FIND v(dout1_94) AT=1910.05n

.meas tran vdout1_95ck1900 FIND v(dout1_95) AT=1910.05n

.meas tran vdout1_96ck1900 FIND v(dout1_96) AT=1910.05n

.meas tran vdout1_97ck1900 FIND v(dout1_97) AT=1910.05n

.meas tran vdout1_98ck1900 FIND v(dout1_98) AT=1910.05n

.meas tran vdout1_99ck1900 FIND v(dout1_99) AT=1910.05n

.meas tran vdout1_100ck1900 FIND v(dout1_100) AT=1910.05n

.meas tran vdout1_101ck1900 FIND v(dout1_101) AT=1910.05n

.meas tran vdout1_102ck1900 FIND v(dout1_102) AT=1910.05n

.meas tran vdout1_103ck1900 FIND v(dout1_103) AT=1910.05n

.meas tran vdout1_104ck1900 FIND v(dout1_104) AT=1910.05n

.meas tran vdout1_105ck1900 FIND v(dout1_105) AT=1910.05n

.meas tran vdout1_106ck1900 FIND v(dout1_106) AT=1910.05n

.meas tran vdout1_107ck1900 FIND v(dout1_107) AT=1910.05n

.meas tran vdout1_108ck1900 FIND v(dout1_108) AT=1910.05n

.meas tran vdout1_109ck1900 FIND v(dout1_109) AT=1910.05n

.meas tran vdout1_110ck1900 FIND v(dout1_110) AT=1910.05n

.meas tran vdout1_111ck1900 FIND v(dout1_111) AT=1910.05n

.meas tran vdout1_112ck1900 FIND v(dout1_112) AT=1910.05n

.meas tran vdout1_113ck1900 FIND v(dout1_113) AT=1910.05n

.meas tran vdout1_114ck1900 FIND v(dout1_114) AT=1910.05n

.meas tran vdout1_115ck1900 FIND v(dout1_115) AT=1910.05n

.meas tran vdout1_116ck1900 FIND v(dout1_116) AT=1910.05n

.meas tran vdout1_117ck1900 FIND v(dout1_117) AT=1910.05n

.meas tran vdout1_118ck1900 FIND v(dout1_118) AT=1910.05n

.meas tran vdout1_119ck1900 FIND v(dout1_119) AT=1910.05n

.meas tran vdout1_120ck1900 FIND v(dout1_120) AT=1910.05n

.meas tran vdout1_121ck1900 FIND v(dout1_121) AT=1910.05n

.meas tran vdout1_122ck1900 FIND v(dout1_122) AT=1910.05n

.meas tran vdout1_123ck1900 FIND v(dout1_123) AT=1910.05n

.meas tran vdout1_124ck1900 FIND v(dout1_124) AT=1910.05n

.meas tran vdout1_125ck1900 FIND v(dout1_125) AT=1910.05n

.meas tran vdout1_126ck1900 FIND v(dout1_126) AT=1910.05n

.meas tran vdout1_127ck1900 FIND v(dout1_127) AT=1910.05n

.meas tran vdout1_128ck1900 FIND v(dout1_128) AT=1910.05n

.meas tran vdout1_129ck1900 FIND v(dout1_129) AT=1910.05n

.meas tran vdout1_130ck1900 FIND v(dout1_130) AT=1910.05n

.meas tran vdout1_131ck1900 FIND v(dout1_131) AT=1910.05n

.meas tran vdout1_132ck1900 FIND v(dout1_132) AT=1910.05n

.meas tran vdout1_133ck1900 FIND v(dout1_133) AT=1910.05n

.meas tran vdout1_134ck1900 FIND v(dout1_134) AT=1910.05n

.meas tran vdout1_0ck1930 FIND v(dout1_0) AT=1940.05n

.meas tran vdout1_1ck1930 FIND v(dout1_1) AT=1940.05n

.meas tran vdout1_2ck1930 FIND v(dout1_2) AT=1940.05n

.meas tran vdout1_3ck1930 FIND v(dout1_3) AT=1940.05n

.meas tran vdout1_4ck1930 FIND v(dout1_4) AT=1940.05n

.meas tran vdout1_5ck1930 FIND v(dout1_5) AT=1940.05n

.meas tran vdout1_6ck1930 FIND v(dout1_6) AT=1940.05n

.meas tran vdout1_7ck1930 FIND v(dout1_7) AT=1940.05n

.meas tran vdout1_8ck1930 FIND v(dout1_8) AT=1940.05n

.meas tran vdout1_9ck1930 FIND v(dout1_9) AT=1940.05n

.meas tran vdout1_10ck1930 FIND v(dout1_10) AT=1940.05n

.meas tran vdout1_11ck1930 FIND v(dout1_11) AT=1940.05n

.meas tran vdout1_12ck1930 FIND v(dout1_12) AT=1940.05n

.meas tran vdout1_13ck1930 FIND v(dout1_13) AT=1940.05n

.meas tran vdout1_14ck1930 FIND v(dout1_14) AT=1940.05n

.meas tran vdout1_15ck1930 FIND v(dout1_15) AT=1940.05n

.meas tran vdout1_16ck1930 FIND v(dout1_16) AT=1940.05n

.meas tran vdout1_17ck1930 FIND v(dout1_17) AT=1940.05n

.meas tran vdout1_18ck1930 FIND v(dout1_18) AT=1940.05n

.meas tran vdout1_19ck1930 FIND v(dout1_19) AT=1940.05n

.meas tran vdout1_20ck1930 FIND v(dout1_20) AT=1940.05n

.meas tran vdout1_21ck1930 FIND v(dout1_21) AT=1940.05n

.meas tran vdout1_22ck1930 FIND v(dout1_22) AT=1940.05n

.meas tran vdout1_23ck1930 FIND v(dout1_23) AT=1940.05n

.meas tran vdout1_24ck1930 FIND v(dout1_24) AT=1940.05n

.meas tran vdout1_25ck1930 FIND v(dout1_25) AT=1940.05n

.meas tran vdout1_26ck1930 FIND v(dout1_26) AT=1940.05n

.meas tran vdout1_27ck1930 FIND v(dout1_27) AT=1940.05n

.meas tran vdout1_28ck1930 FIND v(dout1_28) AT=1940.05n

.meas tran vdout1_29ck1930 FIND v(dout1_29) AT=1940.05n

.meas tran vdout1_30ck1930 FIND v(dout1_30) AT=1940.05n

.meas tran vdout1_31ck1930 FIND v(dout1_31) AT=1940.05n

.meas tran vdout1_32ck1930 FIND v(dout1_32) AT=1940.05n

.meas tran vdout1_33ck1930 FIND v(dout1_33) AT=1940.05n

.meas tran vdout1_34ck1930 FIND v(dout1_34) AT=1940.05n

.meas tran vdout1_35ck1930 FIND v(dout1_35) AT=1940.05n

.meas tran vdout1_36ck1930 FIND v(dout1_36) AT=1940.05n

.meas tran vdout1_37ck1930 FIND v(dout1_37) AT=1940.05n

.meas tran vdout1_38ck1930 FIND v(dout1_38) AT=1940.05n

.meas tran vdout1_39ck1930 FIND v(dout1_39) AT=1940.05n

.meas tran vdout1_40ck1930 FIND v(dout1_40) AT=1940.05n

.meas tran vdout1_41ck1930 FIND v(dout1_41) AT=1940.05n

.meas tran vdout1_42ck1930 FIND v(dout1_42) AT=1940.05n

.meas tran vdout1_43ck1930 FIND v(dout1_43) AT=1940.05n

.meas tran vdout1_44ck1930 FIND v(dout1_44) AT=1940.05n

.meas tran vdout1_45ck1930 FIND v(dout1_45) AT=1940.05n

.meas tran vdout1_46ck1930 FIND v(dout1_46) AT=1940.05n

.meas tran vdout1_47ck1930 FIND v(dout1_47) AT=1940.05n

.meas tran vdout1_48ck1930 FIND v(dout1_48) AT=1940.05n

.meas tran vdout1_49ck1930 FIND v(dout1_49) AT=1940.05n

.meas tran vdout1_50ck1930 FIND v(dout1_50) AT=1940.05n

.meas tran vdout1_51ck1930 FIND v(dout1_51) AT=1940.05n

.meas tran vdout1_52ck1930 FIND v(dout1_52) AT=1940.05n

.meas tran vdout1_53ck1930 FIND v(dout1_53) AT=1940.05n

.meas tran vdout1_54ck1930 FIND v(dout1_54) AT=1940.05n

.meas tran vdout1_55ck1930 FIND v(dout1_55) AT=1940.05n

.meas tran vdout1_56ck1930 FIND v(dout1_56) AT=1940.05n

.meas tran vdout1_57ck1930 FIND v(dout1_57) AT=1940.05n

.meas tran vdout1_58ck1930 FIND v(dout1_58) AT=1940.05n

.meas tran vdout1_59ck1930 FIND v(dout1_59) AT=1940.05n

.meas tran vdout1_60ck1930 FIND v(dout1_60) AT=1940.05n

.meas tran vdout1_61ck1930 FIND v(dout1_61) AT=1940.05n

.meas tran vdout1_62ck1930 FIND v(dout1_62) AT=1940.05n

.meas tran vdout1_63ck1930 FIND v(dout1_63) AT=1940.05n

.meas tran vdout1_64ck1930 FIND v(dout1_64) AT=1940.05n

.meas tran vdout1_65ck1930 FIND v(dout1_65) AT=1940.05n

.meas tran vdout1_66ck1930 FIND v(dout1_66) AT=1940.05n

.meas tran vdout1_67ck1930 FIND v(dout1_67) AT=1940.05n

.meas tran vdout1_68ck1930 FIND v(dout1_68) AT=1940.05n

.meas tran vdout1_69ck1930 FIND v(dout1_69) AT=1940.05n

.meas tran vdout1_70ck1930 FIND v(dout1_70) AT=1940.05n

.meas tran vdout1_71ck1930 FIND v(dout1_71) AT=1940.05n

.meas tran vdout1_72ck1930 FIND v(dout1_72) AT=1940.05n

.meas tran vdout1_73ck1930 FIND v(dout1_73) AT=1940.05n

.meas tran vdout1_74ck1930 FIND v(dout1_74) AT=1940.05n

.meas tran vdout1_75ck1930 FIND v(dout1_75) AT=1940.05n

.meas tran vdout1_76ck1930 FIND v(dout1_76) AT=1940.05n

.meas tran vdout1_77ck1930 FIND v(dout1_77) AT=1940.05n

.meas tran vdout1_78ck1930 FIND v(dout1_78) AT=1940.05n

.meas tran vdout1_79ck1930 FIND v(dout1_79) AT=1940.05n

.meas tran vdout1_80ck1930 FIND v(dout1_80) AT=1940.05n

.meas tran vdout1_81ck1930 FIND v(dout1_81) AT=1940.05n

.meas tran vdout1_82ck1930 FIND v(dout1_82) AT=1940.05n

.meas tran vdout1_83ck1930 FIND v(dout1_83) AT=1940.05n

.meas tran vdout1_84ck1930 FIND v(dout1_84) AT=1940.05n

.meas tran vdout1_85ck1930 FIND v(dout1_85) AT=1940.05n

.meas tran vdout1_86ck1930 FIND v(dout1_86) AT=1940.05n

.meas tran vdout1_87ck1930 FIND v(dout1_87) AT=1940.05n

.meas tran vdout1_88ck1930 FIND v(dout1_88) AT=1940.05n

.meas tran vdout1_89ck1930 FIND v(dout1_89) AT=1940.05n

.meas tran vdout1_90ck1930 FIND v(dout1_90) AT=1940.05n

.meas tran vdout1_91ck1930 FIND v(dout1_91) AT=1940.05n

.meas tran vdout1_92ck1930 FIND v(dout1_92) AT=1940.05n

.meas tran vdout1_93ck1930 FIND v(dout1_93) AT=1940.05n

.meas tran vdout1_94ck1930 FIND v(dout1_94) AT=1940.05n

.meas tran vdout1_95ck1930 FIND v(dout1_95) AT=1940.05n

.meas tran vdout1_96ck1930 FIND v(dout1_96) AT=1940.05n

.meas tran vdout1_97ck1930 FIND v(dout1_97) AT=1940.05n

.meas tran vdout1_98ck1930 FIND v(dout1_98) AT=1940.05n

.meas tran vdout1_99ck1930 FIND v(dout1_99) AT=1940.05n

.meas tran vdout1_100ck1930 FIND v(dout1_100) AT=1940.05n

.meas tran vdout1_101ck1930 FIND v(dout1_101) AT=1940.05n

.meas tran vdout1_102ck1930 FIND v(dout1_102) AT=1940.05n

.meas tran vdout1_103ck1930 FIND v(dout1_103) AT=1940.05n

.meas tran vdout1_104ck1930 FIND v(dout1_104) AT=1940.05n

.meas tran vdout1_105ck1930 FIND v(dout1_105) AT=1940.05n

.meas tran vdout1_106ck1930 FIND v(dout1_106) AT=1940.05n

.meas tran vdout1_107ck1930 FIND v(dout1_107) AT=1940.05n

.meas tran vdout1_108ck1930 FIND v(dout1_108) AT=1940.05n

.meas tran vdout1_109ck1930 FIND v(dout1_109) AT=1940.05n

.meas tran vdout1_110ck1930 FIND v(dout1_110) AT=1940.05n

.meas tran vdout1_111ck1930 FIND v(dout1_111) AT=1940.05n

.meas tran vdout1_112ck1930 FIND v(dout1_112) AT=1940.05n

.meas tran vdout1_113ck1930 FIND v(dout1_113) AT=1940.05n

.meas tran vdout1_114ck1930 FIND v(dout1_114) AT=1940.05n

.meas tran vdout1_115ck1930 FIND v(dout1_115) AT=1940.05n

.meas tran vdout1_116ck1930 FIND v(dout1_116) AT=1940.05n

.meas tran vdout1_117ck1930 FIND v(dout1_117) AT=1940.05n

.meas tran vdout1_118ck1930 FIND v(dout1_118) AT=1940.05n

.meas tran vdout1_119ck1930 FIND v(dout1_119) AT=1940.05n

.meas tran vdout1_120ck1930 FIND v(dout1_120) AT=1940.05n

.meas tran vdout1_121ck1930 FIND v(dout1_121) AT=1940.05n

.meas tran vdout1_122ck1930 FIND v(dout1_122) AT=1940.05n

.meas tran vdout1_123ck1930 FIND v(dout1_123) AT=1940.05n

.meas tran vdout1_124ck1930 FIND v(dout1_124) AT=1940.05n

.meas tran vdout1_125ck1930 FIND v(dout1_125) AT=1940.05n

.meas tran vdout1_126ck1930 FIND v(dout1_126) AT=1940.05n

.meas tran vdout1_127ck1930 FIND v(dout1_127) AT=1940.05n

.meas tran vdout1_128ck1930 FIND v(dout1_128) AT=1940.05n

.meas tran vdout1_129ck1930 FIND v(dout1_129) AT=1940.05n

.meas tran vdout1_130ck1930 FIND v(dout1_130) AT=1940.05n

.meas tran vdout1_131ck1930 FIND v(dout1_131) AT=1940.05n

.meas tran vdout1_132ck1930 FIND v(dout1_132) AT=1940.05n

.meas tran vdout1_133ck1930 FIND v(dout1_133) AT=1940.05n

.meas tran vdout1_134ck1930 FIND v(dout1_134) AT=1940.05n

.meas tran vdout1_0ck1960 FIND v(dout1_0) AT=1970.05n

.meas tran vdout1_1ck1960 FIND v(dout1_1) AT=1970.05n

.meas tran vdout1_2ck1960 FIND v(dout1_2) AT=1970.05n

.meas tran vdout1_3ck1960 FIND v(dout1_3) AT=1970.05n

.meas tran vdout1_4ck1960 FIND v(dout1_4) AT=1970.05n

.meas tran vdout1_5ck1960 FIND v(dout1_5) AT=1970.05n

.meas tran vdout1_6ck1960 FIND v(dout1_6) AT=1970.05n

.meas tran vdout1_7ck1960 FIND v(dout1_7) AT=1970.05n

.meas tran vdout1_8ck1960 FIND v(dout1_8) AT=1970.05n

.meas tran vdout1_9ck1960 FIND v(dout1_9) AT=1970.05n

.meas tran vdout1_10ck1960 FIND v(dout1_10) AT=1970.05n

.meas tran vdout1_11ck1960 FIND v(dout1_11) AT=1970.05n

.meas tran vdout1_12ck1960 FIND v(dout1_12) AT=1970.05n

.meas tran vdout1_13ck1960 FIND v(dout1_13) AT=1970.05n

.meas tran vdout1_14ck1960 FIND v(dout1_14) AT=1970.05n

.meas tran vdout1_15ck1960 FIND v(dout1_15) AT=1970.05n

.meas tran vdout1_16ck1960 FIND v(dout1_16) AT=1970.05n

.meas tran vdout1_17ck1960 FIND v(dout1_17) AT=1970.05n

.meas tran vdout1_18ck1960 FIND v(dout1_18) AT=1970.05n

.meas tran vdout1_19ck1960 FIND v(dout1_19) AT=1970.05n

.meas tran vdout1_20ck1960 FIND v(dout1_20) AT=1970.05n

.meas tran vdout1_21ck1960 FIND v(dout1_21) AT=1970.05n

.meas tran vdout1_22ck1960 FIND v(dout1_22) AT=1970.05n

.meas tran vdout1_23ck1960 FIND v(dout1_23) AT=1970.05n

.meas tran vdout1_24ck1960 FIND v(dout1_24) AT=1970.05n

.meas tran vdout1_25ck1960 FIND v(dout1_25) AT=1970.05n

.meas tran vdout1_26ck1960 FIND v(dout1_26) AT=1970.05n

.meas tran vdout1_27ck1960 FIND v(dout1_27) AT=1970.05n

.meas tran vdout1_28ck1960 FIND v(dout1_28) AT=1970.05n

.meas tran vdout1_29ck1960 FIND v(dout1_29) AT=1970.05n

.meas tran vdout1_30ck1960 FIND v(dout1_30) AT=1970.05n

.meas tran vdout1_31ck1960 FIND v(dout1_31) AT=1970.05n

.meas tran vdout1_32ck1960 FIND v(dout1_32) AT=1970.05n

.meas tran vdout1_33ck1960 FIND v(dout1_33) AT=1970.05n

.meas tran vdout1_34ck1960 FIND v(dout1_34) AT=1970.05n

.meas tran vdout1_35ck1960 FIND v(dout1_35) AT=1970.05n

.meas tran vdout1_36ck1960 FIND v(dout1_36) AT=1970.05n

.meas tran vdout1_37ck1960 FIND v(dout1_37) AT=1970.05n

.meas tran vdout1_38ck1960 FIND v(dout1_38) AT=1970.05n

.meas tran vdout1_39ck1960 FIND v(dout1_39) AT=1970.05n

.meas tran vdout1_40ck1960 FIND v(dout1_40) AT=1970.05n

.meas tran vdout1_41ck1960 FIND v(dout1_41) AT=1970.05n

.meas tran vdout1_42ck1960 FIND v(dout1_42) AT=1970.05n

.meas tran vdout1_43ck1960 FIND v(dout1_43) AT=1970.05n

.meas tran vdout1_44ck1960 FIND v(dout1_44) AT=1970.05n

.meas tran vdout1_45ck1960 FIND v(dout1_45) AT=1970.05n

.meas tran vdout1_46ck1960 FIND v(dout1_46) AT=1970.05n

.meas tran vdout1_47ck1960 FIND v(dout1_47) AT=1970.05n

.meas tran vdout1_48ck1960 FIND v(dout1_48) AT=1970.05n

.meas tran vdout1_49ck1960 FIND v(dout1_49) AT=1970.05n

.meas tran vdout1_50ck1960 FIND v(dout1_50) AT=1970.05n

.meas tran vdout1_51ck1960 FIND v(dout1_51) AT=1970.05n

.meas tran vdout1_52ck1960 FIND v(dout1_52) AT=1970.05n

.meas tran vdout1_53ck1960 FIND v(dout1_53) AT=1970.05n

.meas tran vdout1_54ck1960 FIND v(dout1_54) AT=1970.05n

.meas tran vdout1_55ck1960 FIND v(dout1_55) AT=1970.05n

.meas tran vdout1_56ck1960 FIND v(dout1_56) AT=1970.05n

.meas tran vdout1_57ck1960 FIND v(dout1_57) AT=1970.05n

.meas tran vdout1_58ck1960 FIND v(dout1_58) AT=1970.05n

.meas tran vdout1_59ck1960 FIND v(dout1_59) AT=1970.05n

.meas tran vdout1_60ck1960 FIND v(dout1_60) AT=1970.05n

.meas tran vdout1_61ck1960 FIND v(dout1_61) AT=1970.05n

.meas tran vdout1_62ck1960 FIND v(dout1_62) AT=1970.05n

.meas tran vdout1_63ck1960 FIND v(dout1_63) AT=1970.05n

.meas tran vdout1_64ck1960 FIND v(dout1_64) AT=1970.05n

.meas tran vdout1_65ck1960 FIND v(dout1_65) AT=1970.05n

.meas tran vdout1_66ck1960 FIND v(dout1_66) AT=1970.05n

.meas tran vdout1_67ck1960 FIND v(dout1_67) AT=1970.05n

.meas tran vdout1_68ck1960 FIND v(dout1_68) AT=1970.05n

.meas tran vdout1_69ck1960 FIND v(dout1_69) AT=1970.05n

.meas tran vdout1_70ck1960 FIND v(dout1_70) AT=1970.05n

.meas tran vdout1_71ck1960 FIND v(dout1_71) AT=1970.05n

.meas tran vdout1_72ck1960 FIND v(dout1_72) AT=1970.05n

.meas tran vdout1_73ck1960 FIND v(dout1_73) AT=1970.05n

.meas tran vdout1_74ck1960 FIND v(dout1_74) AT=1970.05n

.meas tran vdout1_75ck1960 FIND v(dout1_75) AT=1970.05n

.meas tran vdout1_76ck1960 FIND v(dout1_76) AT=1970.05n

.meas tran vdout1_77ck1960 FIND v(dout1_77) AT=1970.05n

.meas tran vdout1_78ck1960 FIND v(dout1_78) AT=1970.05n

.meas tran vdout1_79ck1960 FIND v(dout1_79) AT=1970.05n

.meas tran vdout1_80ck1960 FIND v(dout1_80) AT=1970.05n

.meas tran vdout1_81ck1960 FIND v(dout1_81) AT=1970.05n

.meas tran vdout1_82ck1960 FIND v(dout1_82) AT=1970.05n

.meas tran vdout1_83ck1960 FIND v(dout1_83) AT=1970.05n

.meas tran vdout1_84ck1960 FIND v(dout1_84) AT=1970.05n

.meas tran vdout1_85ck1960 FIND v(dout1_85) AT=1970.05n

.meas tran vdout1_86ck1960 FIND v(dout1_86) AT=1970.05n

.meas tran vdout1_87ck1960 FIND v(dout1_87) AT=1970.05n

.meas tran vdout1_88ck1960 FIND v(dout1_88) AT=1970.05n

.meas tran vdout1_89ck1960 FIND v(dout1_89) AT=1970.05n

.meas tran vdout1_90ck1960 FIND v(dout1_90) AT=1970.05n

.meas tran vdout1_91ck1960 FIND v(dout1_91) AT=1970.05n

.meas tran vdout1_92ck1960 FIND v(dout1_92) AT=1970.05n

.meas tran vdout1_93ck1960 FIND v(dout1_93) AT=1970.05n

.meas tran vdout1_94ck1960 FIND v(dout1_94) AT=1970.05n

.meas tran vdout1_95ck1960 FIND v(dout1_95) AT=1970.05n

.meas tran vdout1_96ck1960 FIND v(dout1_96) AT=1970.05n

.meas tran vdout1_97ck1960 FIND v(dout1_97) AT=1970.05n

.meas tran vdout1_98ck1960 FIND v(dout1_98) AT=1970.05n

.meas tran vdout1_99ck1960 FIND v(dout1_99) AT=1970.05n

.meas tran vdout1_100ck1960 FIND v(dout1_100) AT=1970.05n

.meas tran vdout1_101ck1960 FIND v(dout1_101) AT=1970.05n

.meas tran vdout1_102ck1960 FIND v(dout1_102) AT=1970.05n

.meas tran vdout1_103ck1960 FIND v(dout1_103) AT=1970.05n

.meas tran vdout1_104ck1960 FIND v(dout1_104) AT=1970.05n

.meas tran vdout1_105ck1960 FIND v(dout1_105) AT=1970.05n

.meas tran vdout1_106ck1960 FIND v(dout1_106) AT=1970.05n

.meas tran vdout1_107ck1960 FIND v(dout1_107) AT=1970.05n

.meas tran vdout1_108ck1960 FIND v(dout1_108) AT=1970.05n

.meas tran vdout1_109ck1960 FIND v(dout1_109) AT=1970.05n

.meas tran vdout1_110ck1960 FIND v(dout1_110) AT=1970.05n

.meas tran vdout1_111ck1960 FIND v(dout1_111) AT=1970.05n

.meas tran vdout1_112ck1960 FIND v(dout1_112) AT=1970.05n

.meas tran vdout1_113ck1960 FIND v(dout1_113) AT=1970.05n

.meas tran vdout1_114ck1960 FIND v(dout1_114) AT=1970.05n

.meas tran vdout1_115ck1960 FIND v(dout1_115) AT=1970.05n

.meas tran vdout1_116ck1960 FIND v(dout1_116) AT=1970.05n

.meas tran vdout1_117ck1960 FIND v(dout1_117) AT=1970.05n

.meas tran vdout1_118ck1960 FIND v(dout1_118) AT=1970.05n

.meas tran vdout1_119ck1960 FIND v(dout1_119) AT=1970.05n

.meas tran vdout1_120ck1960 FIND v(dout1_120) AT=1970.05n

.meas tran vdout1_121ck1960 FIND v(dout1_121) AT=1970.05n

.meas tran vdout1_122ck1960 FIND v(dout1_122) AT=1970.05n

.meas tran vdout1_123ck1960 FIND v(dout1_123) AT=1970.05n

.meas tran vdout1_124ck1960 FIND v(dout1_124) AT=1970.05n

.meas tran vdout1_125ck1960 FIND v(dout1_125) AT=1970.05n

.meas tran vdout1_126ck1960 FIND v(dout1_126) AT=1970.05n

.meas tran vdout1_127ck1960 FIND v(dout1_127) AT=1970.05n

.meas tran vdout1_128ck1960 FIND v(dout1_128) AT=1970.05n

.meas tran vdout1_129ck1960 FIND v(dout1_129) AT=1970.05n

.meas tran vdout1_130ck1960 FIND v(dout1_130) AT=1970.05n

.meas tran vdout1_131ck1960 FIND v(dout1_131) AT=1970.05n

.meas tran vdout1_132ck1960 FIND v(dout1_132) AT=1970.05n

.meas tran vdout1_133ck1960 FIND v(dout1_133) AT=1970.05n

.meas tran vdout1_134ck1960 FIND v(dout1_134) AT=1970.05n

.meas tran vdout1_0ck1990 FIND v(dout1_0) AT=2000.05n

.meas tran vdout1_1ck1990 FIND v(dout1_1) AT=2000.05n

.meas tran vdout1_2ck1990 FIND v(dout1_2) AT=2000.05n

.meas tran vdout1_3ck1990 FIND v(dout1_3) AT=2000.05n

.meas tran vdout1_4ck1990 FIND v(dout1_4) AT=2000.05n

.meas tran vdout1_5ck1990 FIND v(dout1_5) AT=2000.05n

.meas tran vdout1_6ck1990 FIND v(dout1_6) AT=2000.05n

.meas tran vdout1_7ck1990 FIND v(dout1_7) AT=2000.05n

.meas tran vdout1_8ck1990 FIND v(dout1_8) AT=2000.05n

.meas tran vdout1_9ck1990 FIND v(dout1_9) AT=2000.05n

.meas tran vdout1_10ck1990 FIND v(dout1_10) AT=2000.05n

.meas tran vdout1_11ck1990 FIND v(dout1_11) AT=2000.05n

.meas tran vdout1_12ck1990 FIND v(dout1_12) AT=2000.05n

.meas tran vdout1_13ck1990 FIND v(dout1_13) AT=2000.05n

.meas tran vdout1_14ck1990 FIND v(dout1_14) AT=2000.05n

.meas tran vdout1_15ck1990 FIND v(dout1_15) AT=2000.05n

.meas tran vdout1_16ck1990 FIND v(dout1_16) AT=2000.05n

.meas tran vdout1_17ck1990 FIND v(dout1_17) AT=2000.05n

.meas tran vdout1_18ck1990 FIND v(dout1_18) AT=2000.05n

.meas tran vdout1_19ck1990 FIND v(dout1_19) AT=2000.05n

.meas tran vdout1_20ck1990 FIND v(dout1_20) AT=2000.05n

.meas tran vdout1_21ck1990 FIND v(dout1_21) AT=2000.05n

.meas tran vdout1_22ck1990 FIND v(dout1_22) AT=2000.05n

.meas tran vdout1_23ck1990 FIND v(dout1_23) AT=2000.05n

.meas tran vdout1_24ck1990 FIND v(dout1_24) AT=2000.05n

.meas tran vdout1_25ck1990 FIND v(dout1_25) AT=2000.05n

.meas tran vdout1_26ck1990 FIND v(dout1_26) AT=2000.05n

.meas tran vdout1_27ck1990 FIND v(dout1_27) AT=2000.05n

.meas tran vdout1_28ck1990 FIND v(dout1_28) AT=2000.05n

.meas tran vdout1_29ck1990 FIND v(dout1_29) AT=2000.05n

.meas tran vdout1_30ck1990 FIND v(dout1_30) AT=2000.05n

.meas tran vdout1_31ck1990 FIND v(dout1_31) AT=2000.05n

.meas tran vdout1_32ck1990 FIND v(dout1_32) AT=2000.05n

.meas tran vdout1_33ck1990 FIND v(dout1_33) AT=2000.05n

.meas tran vdout1_34ck1990 FIND v(dout1_34) AT=2000.05n

.meas tran vdout1_35ck1990 FIND v(dout1_35) AT=2000.05n

.meas tran vdout1_36ck1990 FIND v(dout1_36) AT=2000.05n

.meas tran vdout1_37ck1990 FIND v(dout1_37) AT=2000.05n

.meas tran vdout1_38ck1990 FIND v(dout1_38) AT=2000.05n

.meas tran vdout1_39ck1990 FIND v(dout1_39) AT=2000.05n

.meas tran vdout1_40ck1990 FIND v(dout1_40) AT=2000.05n

.meas tran vdout1_41ck1990 FIND v(dout1_41) AT=2000.05n

.meas tran vdout1_42ck1990 FIND v(dout1_42) AT=2000.05n

.meas tran vdout1_43ck1990 FIND v(dout1_43) AT=2000.05n

.meas tran vdout1_44ck1990 FIND v(dout1_44) AT=2000.05n

.meas tran vdout1_45ck1990 FIND v(dout1_45) AT=2000.05n

.meas tran vdout1_46ck1990 FIND v(dout1_46) AT=2000.05n

.meas tran vdout1_47ck1990 FIND v(dout1_47) AT=2000.05n

.meas tran vdout1_48ck1990 FIND v(dout1_48) AT=2000.05n

.meas tran vdout1_49ck1990 FIND v(dout1_49) AT=2000.05n

.meas tran vdout1_50ck1990 FIND v(dout1_50) AT=2000.05n

.meas tran vdout1_51ck1990 FIND v(dout1_51) AT=2000.05n

.meas tran vdout1_52ck1990 FIND v(dout1_52) AT=2000.05n

.meas tran vdout1_53ck1990 FIND v(dout1_53) AT=2000.05n

.meas tran vdout1_54ck1990 FIND v(dout1_54) AT=2000.05n

.meas tran vdout1_55ck1990 FIND v(dout1_55) AT=2000.05n

.meas tran vdout1_56ck1990 FIND v(dout1_56) AT=2000.05n

.meas tran vdout1_57ck1990 FIND v(dout1_57) AT=2000.05n

.meas tran vdout1_58ck1990 FIND v(dout1_58) AT=2000.05n

.meas tran vdout1_59ck1990 FIND v(dout1_59) AT=2000.05n

.meas tran vdout1_60ck1990 FIND v(dout1_60) AT=2000.05n

.meas tran vdout1_61ck1990 FIND v(dout1_61) AT=2000.05n

.meas tran vdout1_62ck1990 FIND v(dout1_62) AT=2000.05n

.meas tran vdout1_63ck1990 FIND v(dout1_63) AT=2000.05n

.meas tran vdout1_64ck1990 FIND v(dout1_64) AT=2000.05n

.meas tran vdout1_65ck1990 FIND v(dout1_65) AT=2000.05n

.meas tran vdout1_66ck1990 FIND v(dout1_66) AT=2000.05n

.meas tran vdout1_67ck1990 FIND v(dout1_67) AT=2000.05n

.meas tran vdout1_68ck1990 FIND v(dout1_68) AT=2000.05n

.meas tran vdout1_69ck1990 FIND v(dout1_69) AT=2000.05n

.meas tran vdout1_70ck1990 FIND v(dout1_70) AT=2000.05n

.meas tran vdout1_71ck1990 FIND v(dout1_71) AT=2000.05n

.meas tran vdout1_72ck1990 FIND v(dout1_72) AT=2000.05n

.meas tran vdout1_73ck1990 FIND v(dout1_73) AT=2000.05n

.meas tran vdout1_74ck1990 FIND v(dout1_74) AT=2000.05n

.meas tran vdout1_75ck1990 FIND v(dout1_75) AT=2000.05n

.meas tran vdout1_76ck1990 FIND v(dout1_76) AT=2000.05n

.meas tran vdout1_77ck1990 FIND v(dout1_77) AT=2000.05n

.meas tran vdout1_78ck1990 FIND v(dout1_78) AT=2000.05n

.meas tran vdout1_79ck1990 FIND v(dout1_79) AT=2000.05n

.meas tran vdout1_80ck1990 FIND v(dout1_80) AT=2000.05n

.meas tran vdout1_81ck1990 FIND v(dout1_81) AT=2000.05n

.meas tran vdout1_82ck1990 FIND v(dout1_82) AT=2000.05n

.meas tran vdout1_83ck1990 FIND v(dout1_83) AT=2000.05n

.meas tran vdout1_84ck1990 FIND v(dout1_84) AT=2000.05n

.meas tran vdout1_85ck1990 FIND v(dout1_85) AT=2000.05n

.meas tran vdout1_86ck1990 FIND v(dout1_86) AT=2000.05n

.meas tran vdout1_87ck1990 FIND v(dout1_87) AT=2000.05n

.meas tran vdout1_88ck1990 FIND v(dout1_88) AT=2000.05n

.meas tran vdout1_89ck1990 FIND v(dout1_89) AT=2000.05n

.meas tran vdout1_90ck1990 FIND v(dout1_90) AT=2000.05n

.meas tran vdout1_91ck1990 FIND v(dout1_91) AT=2000.05n

.meas tran vdout1_92ck1990 FIND v(dout1_92) AT=2000.05n

.meas tran vdout1_93ck1990 FIND v(dout1_93) AT=2000.05n

.meas tran vdout1_94ck1990 FIND v(dout1_94) AT=2000.05n

.meas tran vdout1_95ck1990 FIND v(dout1_95) AT=2000.05n

.meas tran vdout1_96ck1990 FIND v(dout1_96) AT=2000.05n

.meas tran vdout1_97ck1990 FIND v(dout1_97) AT=2000.05n

.meas tran vdout1_98ck1990 FIND v(dout1_98) AT=2000.05n

.meas tran vdout1_99ck1990 FIND v(dout1_99) AT=2000.05n

.meas tran vdout1_100ck1990 FIND v(dout1_100) AT=2000.05n

.meas tran vdout1_101ck1990 FIND v(dout1_101) AT=2000.05n

.meas tran vdout1_102ck1990 FIND v(dout1_102) AT=2000.05n

.meas tran vdout1_103ck1990 FIND v(dout1_103) AT=2000.05n

.meas tran vdout1_104ck1990 FIND v(dout1_104) AT=2000.05n

.meas tran vdout1_105ck1990 FIND v(dout1_105) AT=2000.05n

.meas tran vdout1_106ck1990 FIND v(dout1_106) AT=2000.05n

.meas tran vdout1_107ck1990 FIND v(dout1_107) AT=2000.05n

.meas tran vdout1_108ck1990 FIND v(dout1_108) AT=2000.05n

.meas tran vdout1_109ck1990 FIND v(dout1_109) AT=2000.05n

.meas tran vdout1_110ck1990 FIND v(dout1_110) AT=2000.05n

.meas tran vdout1_111ck1990 FIND v(dout1_111) AT=2000.05n

.meas tran vdout1_112ck1990 FIND v(dout1_112) AT=2000.05n

.meas tran vdout1_113ck1990 FIND v(dout1_113) AT=2000.05n

.meas tran vdout1_114ck1990 FIND v(dout1_114) AT=2000.05n

.meas tran vdout1_115ck1990 FIND v(dout1_115) AT=2000.05n

.meas tran vdout1_116ck1990 FIND v(dout1_116) AT=2000.05n

.meas tran vdout1_117ck1990 FIND v(dout1_117) AT=2000.05n

.meas tran vdout1_118ck1990 FIND v(dout1_118) AT=2000.05n

.meas tran vdout1_119ck1990 FIND v(dout1_119) AT=2000.05n

.meas tran vdout1_120ck1990 FIND v(dout1_120) AT=2000.05n

.meas tran vdout1_121ck1990 FIND v(dout1_121) AT=2000.05n

.meas tran vdout1_122ck1990 FIND v(dout1_122) AT=2000.05n

.meas tran vdout1_123ck1990 FIND v(dout1_123) AT=2000.05n

.meas tran vdout1_124ck1990 FIND v(dout1_124) AT=2000.05n

.meas tran vdout1_125ck1990 FIND v(dout1_125) AT=2000.05n

.meas tran vdout1_126ck1990 FIND v(dout1_126) AT=2000.05n

.meas tran vdout1_127ck1990 FIND v(dout1_127) AT=2000.05n

.meas tran vdout1_128ck1990 FIND v(dout1_128) AT=2000.05n

.meas tran vdout1_129ck1990 FIND v(dout1_129) AT=2000.05n

.meas tran vdout1_130ck1990 FIND v(dout1_130) AT=2000.05n

.meas tran vdout1_131ck1990 FIND v(dout1_131) AT=2000.05n

.meas tran vdout1_132ck1990 FIND v(dout1_132) AT=2000.05n

.meas tran vdout1_133ck1990 FIND v(dout1_133) AT=2000.05n

.meas tran vdout1_134ck1990 FIND v(dout1_134) AT=2000.05n

.meas tran vdout1_0ck2000 FIND v(dout1_0) AT=2010.05n

.meas tran vdout1_1ck2000 FIND v(dout1_1) AT=2010.05n

.meas tran vdout1_2ck2000 FIND v(dout1_2) AT=2010.05n

.meas tran vdout1_3ck2000 FIND v(dout1_3) AT=2010.05n

.meas tran vdout1_4ck2000 FIND v(dout1_4) AT=2010.05n

.meas tran vdout1_5ck2000 FIND v(dout1_5) AT=2010.05n

.meas tran vdout1_6ck2000 FIND v(dout1_6) AT=2010.05n

.meas tran vdout1_7ck2000 FIND v(dout1_7) AT=2010.05n

.meas tran vdout1_8ck2000 FIND v(dout1_8) AT=2010.05n

.meas tran vdout1_9ck2000 FIND v(dout1_9) AT=2010.05n

.meas tran vdout1_10ck2000 FIND v(dout1_10) AT=2010.05n

.meas tran vdout1_11ck2000 FIND v(dout1_11) AT=2010.05n

.meas tran vdout1_12ck2000 FIND v(dout1_12) AT=2010.05n

.meas tran vdout1_13ck2000 FIND v(dout1_13) AT=2010.05n

.meas tran vdout1_14ck2000 FIND v(dout1_14) AT=2010.05n

.meas tran vdout1_15ck2000 FIND v(dout1_15) AT=2010.05n

.meas tran vdout1_16ck2000 FIND v(dout1_16) AT=2010.05n

.meas tran vdout1_17ck2000 FIND v(dout1_17) AT=2010.05n

.meas tran vdout1_18ck2000 FIND v(dout1_18) AT=2010.05n

.meas tran vdout1_19ck2000 FIND v(dout1_19) AT=2010.05n

.meas tran vdout1_20ck2000 FIND v(dout1_20) AT=2010.05n

.meas tran vdout1_21ck2000 FIND v(dout1_21) AT=2010.05n

.meas tran vdout1_22ck2000 FIND v(dout1_22) AT=2010.05n

.meas tran vdout1_23ck2000 FIND v(dout1_23) AT=2010.05n

.meas tran vdout1_24ck2000 FIND v(dout1_24) AT=2010.05n

.meas tran vdout1_25ck2000 FIND v(dout1_25) AT=2010.05n

.meas tran vdout1_26ck2000 FIND v(dout1_26) AT=2010.05n

.meas tran vdout1_27ck2000 FIND v(dout1_27) AT=2010.05n

.meas tran vdout1_28ck2000 FIND v(dout1_28) AT=2010.05n

.meas tran vdout1_29ck2000 FIND v(dout1_29) AT=2010.05n

.meas tran vdout1_30ck2000 FIND v(dout1_30) AT=2010.05n

.meas tran vdout1_31ck2000 FIND v(dout1_31) AT=2010.05n

.meas tran vdout1_32ck2000 FIND v(dout1_32) AT=2010.05n

.meas tran vdout1_33ck2000 FIND v(dout1_33) AT=2010.05n

.meas tran vdout1_34ck2000 FIND v(dout1_34) AT=2010.05n

.meas tran vdout1_35ck2000 FIND v(dout1_35) AT=2010.05n

.meas tran vdout1_36ck2000 FIND v(dout1_36) AT=2010.05n

.meas tran vdout1_37ck2000 FIND v(dout1_37) AT=2010.05n

.meas tran vdout1_38ck2000 FIND v(dout1_38) AT=2010.05n

.meas tran vdout1_39ck2000 FIND v(dout1_39) AT=2010.05n

.meas tran vdout1_40ck2000 FIND v(dout1_40) AT=2010.05n

.meas tran vdout1_41ck2000 FIND v(dout1_41) AT=2010.05n

.meas tran vdout1_42ck2000 FIND v(dout1_42) AT=2010.05n

.meas tran vdout1_43ck2000 FIND v(dout1_43) AT=2010.05n

.meas tran vdout1_44ck2000 FIND v(dout1_44) AT=2010.05n

.meas tran vdout1_45ck2000 FIND v(dout1_45) AT=2010.05n

.meas tran vdout1_46ck2000 FIND v(dout1_46) AT=2010.05n

.meas tran vdout1_47ck2000 FIND v(dout1_47) AT=2010.05n

.meas tran vdout1_48ck2000 FIND v(dout1_48) AT=2010.05n

.meas tran vdout1_49ck2000 FIND v(dout1_49) AT=2010.05n

.meas tran vdout1_50ck2000 FIND v(dout1_50) AT=2010.05n

.meas tran vdout1_51ck2000 FIND v(dout1_51) AT=2010.05n

.meas tran vdout1_52ck2000 FIND v(dout1_52) AT=2010.05n

.meas tran vdout1_53ck2000 FIND v(dout1_53) AT=2010.05n

.meas tran vdout1_54ck2000 FIND v(dout1_54) AT=2010.05n

.meas tran vdout1_55ck2000 FIND v(dout1_55) AT=2010.05n

.meas tran vdout1_56ck2000 FIND v(dout1_56) AT=2010.05n

.meas tran vdout1_57ck2000 FIND v(dout1_57) AT=2010.05n

.meas tran vdout1_58ck2000 FIND v(dout1_58) AT=2010.05n

.meas tran vdout1_59ck2000 FIND v(dout1_59) AT=2010.05n

.meas tran vdout1_60ck2000 FIND v(dout1_60) AT=2010.05n

.meas tran vdout1_61ck2000 FIND v(dout1_61) AT=2010.05n

.meas tran vdout1_62ck2000 FIND v(dout1_62) AT=2010.05n

.meas tran vdout1_63ck2000 FIND v(dout1_63) AT=2010.05n

.meas tran vdout1_64ck2000 FIND v(dout1_64) AT=2010.05n

.meas tran vdout1_65ck2000 FIND v(dout1_65) AT=2010.05n

.meas tran vdout1_66ck2000 FIND v(dout1_66) AT=2010.05n

.meas tran vdout1_67ck2000 FIND v(dout1_67) AT=2010.05n

.meas tran vdout1_68ck2000 FIND v(dout1_68) AT=2010.05n

.meas tran vdout1_69ck2000 FIND v(dout1_69) AT=2010.05n

.meas tran vdout1_70ck2000 FIND v(dout1_70) AT=2010.05n

.meas tran vdout1_71ck2000 FIND v(dout1_71) AT=2010.05n

.meas tran vdout1_72ck2000 FIND v(dout1_72) AT=2010.05n

.meas tran vdout1_73ck2000 FIND v(dout1_73) AT=2010.05n

.meas tran vdout1_74ck2000 FIND v(dout1_74) AT=2010.05n

.meas tran vdout1_75ck2000 FIND v(dout1_75) AT=2010.05n

.meas tran vdout1_76ck2000 FIND v(dout1_76) AT=2010.05n

.meas tran vdout1_77ck2000 FIND v(dout1_77) AT=2010.05n

.meas tran vdout1_78ck2000 FIND v(dout1_78) AT=2010.05n

.meas tran vdout1_79ck2000 FIND v(dout1_79) AT=2010.05n

.meas tran vdout1_80ck2000 FIND v(dout1_80) AT=2010.05n

.meas tran vdout1_81ck2000 FIND v(dout1_81) AT=2010.05n

.meas tran vdout1_82ck2000 FIND v(dout1_82) AT=2010.05n

.meas tran vdout1_83ck2000 FIND v(dout1_83) AT=2010.05n

.meas tran vdout1_84ck2000 FIND v(dout1_84) AT=2010.05n

.meas tran vdout1_85ck2000 FIND v(dout1_85) AT=2010.05n

.meas tran vdout1_86ck2000 FIND v(dout1_86) AT=2010.05n

.meas tran vdout1_87ck2000 FIND v(dout1_87) AT=2010.05n

.meas tran vdout1_88ck2000 FIND v(dout1_88) AT=2010.05n

.meas tran vdout1_89ck2000 FIND v(dout1_89) AT=2010.05n

.meas tran vdout1_90ck2000 FIND v(dout1_90) AT=2010.05n

.meas tran vdout1_91ck2000 FIND v(dout1_91) AT=2010.05n

.meas tran vdout1_92ck2000 FIND v(dout1_92) AT=2010.05n

.meas tran vdout1_93ck2000 FIND v(dout1_93) AT=2010.05n

.meas tran vdout1_94ck2000 FIND v(dout1_94) AT=2010.05n

.meas tran vdout1_95ck2000 FIND v(dout1_95) AT=2010.05n

.meas tran vdout1_96ck2000 FIND v(dout1_96) AT=2010.05n

.meas tran vdout1_97ck2000 FIND v(dout1_97) AT=2010.05n

.meas tran vdout1_98ck2000 FIND v(dout1_98) AT=2010.05n

.meas tran vdout1_99ck2000 FIND v(dout1_99) AT=2010.05n

.meas tran vdout1_100ck2000 FIND v(dout1_100) AT=2010.05n

.meas tran vdout1_101ck2000 FIND v(dout1_101) AT=2010.05n

.meas tran vdout1_102ck2000 FIND v(dout1_102) AT=2010.05n

.meas tran vdout1_103ck2000 FIND v(dout1_103) AT=2010.05n

.meas tran vdout1_104ck2000 FIND v(dout1_104) AT=2010.05n

.meas tran vdout1_105ck2000 FIND v(dout1_105) AT=2010.05n

.meas tran vdout1_106ck2000 FIND v(dout1_106) AT=2010.05n

.meas tran vdout1_107ck2000 FIND v(dout1_107) AT=2010.05n

.meas tran vdout1_108ck2000 FIND v(dout1_108) AT=2010.05n

.meas tran vdout1_109ck2000 FIND v(dout1_109) AT=2010.05n

.meas tran vdout1_110ck2000 FIND v(dout1_110) AT=2010.05n

.meas tran vdout1_111ck2000 FIND v(dout1_111) AT=2010.05n

.meas tran vdout1_112ck2000 FIND v(dout1_112) AT=2010.05n

.meas tran vdout1_113ck2000 FIND v(dout1_113) AT=2010.05n

.meas tran vdout1_114ck2000 FIND v(dout1_114) AT=2010.05n

.meas tran vdout1_115ck2000 FIND v(dout1_115) AT=2010.05n

.meas tran vdout1_116ck2000 FIND v(dout1_116) AT=2010.05n

.meas tran vdout1_117ck2000 FIND v(dout1_117) AT=2010.05n

.meas tran vdout1_118ck2000 FIND v(dout1_118) AT=2010.05n

.meas tran vdout1_119ck2000 FIND v(dout1_119) AT=2010.05n

.meas tran vdout1_120ck2000 FIND v(dout1_120) AT=2010.05n

.meas tran vdout1_121ck2000 FIND v(dout1_121) AT=2010.05n

.meas tran vdout1_122ck2000 FIND v(dout1_122) AT=2010.05n

.meas tran vdout1_123ck2000 FIND v(dout1_123) AT=2010.05n

.meas tran vdout1_124ck2000 FIND v(dout1_124) AT=2010.05n

.meas tran vdout1_125ck2000 FIND v(dout1_125) AT=2010.05n

.meas tran vdout1_126ck2000 FIND v(dout1_126) AT=2010.05n

.meas tran vdout1_127ck2000 FIND v(dout1_127) AT=2010.05n

.meas tran vdout1_128ck2000 FIND v(dout1_128) AT=2010.05n

.meas tran vdout1_129ck2000 FIND v(dout1_129) AT=2010.05n

.meas tran vdout1_130ck2000 FIND v(dout1_130) AT=2010.05n

.meas tran vdout1_131ck2000 FIND v(dout1_131) AT=2010.05n

.meas tran vdout1_132ck2000 FIND v(dout1_132) AT=2010.05n

.meas tran vdout1_133ck2000 FIND v(dout1_133) AT=2010.05n

.meas tran vdout1_134ck2000 FIND v(dout1_134) AT=2010.05n

.meas tran vdout1_0ck2030 FIND v(dout1_0) AT=2040.05n

.meas tran vdout1_1ck2030 FIND v(dout1_1) AT=2040.05n

.meas tran vdout1_2ck2030 FIND v(dout1_2) AT=2040.05n

.meas tran vdout1_3ck2030 FIND v(dout1_3) AT=2040.05n

.meas tran vdout1_4ck2030 FIND v(dout1_4) AT=2040.05n

.meas tran vdout1_5ck2030 FIND v(dout1_5) AT=2040.05n

.meas tran vdout1_6ck2030 FIND v(dout1_6) AT=2040.05n

.meas tran vdout1_7ck2030 FIND v(dout1_7) AT=2040.05n

.meas tran vdout1_8ck2030 FIND v(dout1_8) AT=2040.05n

.meas tran vdout1_9ck2030 FIND v(dout1_9) AT=2040.05n

.meas tran vdout1_10ck2030 FIND v(dout1_10) AT=2040.05n

.meas tran vdout1_11ck2030 FIND v(dout1_11) AT=2040.05n

.meas tran vdout1_12ck2030 FIND v(dout1_12) AT=2040.05n

.meas tran vdout1_13ck2030 FIND v(dout1_13) AT=2040.05n

.meas tran vdout1_14ck2030 FIND v(dout1_14) AT=2040.05n

.meas tran vdout1_15ck2030 FIND v(dout1_15) AT=2040.05n

.meas tran vdout1_16ck2030 FIND v(dout1_16) AT=2040.05n

.meas tran vdout1_17ck2030 FIND v(dout1_17) AT=2040.05n

.meas tran vdout1_18ck2030 FIND v(dout1_18) AT=2040.05n

.meas tran vdout1_19ck2030 FIND v(dout1_19) AT=2040.05n

.meas tran vdout1_20ck2030 FIND v(dout1_20) AT=2040.05n

.meas tran vdout1_21ck2030 FIND v(dout1_21) AT=2040.05n

.meas tran vdout1_22ck2030 FIND v(dout1_22) AT=2040.05n

.meas tran vdout1_23ck2030 FIND v(dout1_23) AT=2040.05n

.meas tran vdout1_24ck2030 FIND v(dout1_24) AT=2040.05n

.meas tran vdout1_25ck2030 FIND v(dout1_25) AT=2040.05n

.meas tran vdout1_26ck2030 FIND v(dout1_26) AT=2040.05n

.meas tran vdout1_27ck2030 FIND v(dout1_27) AT=2040.05n

.meas tran vdout1_28ck2030 FIND v(dout1_28) AT=2040.05n

.meas tran vdout1_29ck2030 FIND v(dout1_29) AT=2040.05n

.meas tran vdout1_30ck2030 FIND v(dout1_30) AT=2040.05n

.meas tran vdout1_31ck2030 FIND v(dout1_31) AT=2040.05n

.meas tran vdout1_32ck2030 FIND v(dout1_32) AT=2040.05n

.meas tran vdout1_33ck2030 FIND v(dout1_33) AT=2040.05n

.meas tran vdout1_34ck2030 FIND v(dout1_34) AT=2040.05n

.meas tran vdout1_35ck2030 FIND v(dout1_35) AT=2040.05n

.meas tran vdout1_36ck2030 FIND v(dout1_36) AT=2040.05n

.meas tran vdout1_37ck2030 FIND v(dout1_37) AT=2040.05n

.meas tran vdout1_38ck2030 FIND v(dout1_38) AT=2040.05n

.meas tran vdout1_39ck2030 FIND v(dout1_39) AT=2040.05n

.meas tran vdout1_40ck2030 FIND v(dout1_40) AT=2040.05n

.meas tran vdout1_41ck2030 FIND v(dout1_41) AT=2040.05n

.meas tran vdout1_42ck2030 FIND v(dout1_42) AT=2040.05n

.meas tran vdout1_43ck2030 FIND v(dout1_43) AT=2040.05n

.meas tran vdout1_44ck2030 FIND v(dout1_44) AT=2040.05n

.meas tran vdout1_45ck2030 FIND v(dout1_45) AT=2040.05n

.meas tran vdout1_46ck2030 FIND v(dout1_46) AT=2040.05n

.meas tran vdout1_47ck2030 FIND v(dout1_47) AT=2040.05n

.meas tran vdout1_48ck2030 FIND v(dout1_48) AT=2040.05n

.meas tran vdout1_49ck2030 FIND v(dout1_49) AT=2040.05n

.meas tran vdout1_50ck2030 FIND v(dout1_50) AT=2040.05n

.meas tran vdout1_51ck2030 FIND v(dout1_51) AT=2040.05n

.meas tran vdout1_52ck2030 FIND v(dout1_52) AT=2040.05n

.meas tran vdout1_53ck2030 FIND v(dout1_53) AT=2040.05n

.meas tran vdout1_54ck2030 FIND v(dout1_54) AT=2040.05n

.meas tran vdout1_55ck2030 FIND v(dout1_55) AT=2040.05n

.meas tran vdout1_56ck2030 FIND v(dout1_56) AT=2040.05n

.meas tran vdout1_57ck2030 FIND v(dout1_57) AT=2040.05n

.meas tran vdout1_58ck2030 FIND v(dout1_58) AT=2040.05n

.meas tran vdout1_59ck2030 FIND v(dout1_59) AT=2040.05n

.meas tran vdout1_60ck2030 FIND v(dout1_60) AT=2040.05n

.meas tran vdout1_61ck2030 FIND v(dout1_61) AT=2040.05n

.meas tran vdout1_62ck2030 FIND v(dout1_62) AT=2040.05n

.meas tran vdout1_63ck2030 FIND v(dout1_63) AT=2040.05n

.meas tran vdout1_64ck2030 FIND v(dout1_64) AT=2040.05n

.meas tran vdout1_65ck2030 FIND v(dout1_65) AT=2040.05n

.meas tran vdout1_66ck2030 FIND v(dout1_66) AT=2040.05n

.meas tran vdout1_67ck2030 FIND v(dout1_67) AT=2040.05n

.meas tran vdout1_68ck2030 FIND v(dout1_68) AT=2040.05n

.meas tran vdout1_69ck2030 FIND v(dout1_69) AT=2040.05n

.meas tran vdout1_70ck2030 FIND v(dout1_70) AT=2040.05n

.meas tran vdout1_71ck2030 FIND v(dout1_71) AT=2040.05n

.meas tran vdout1_72ck2030 FIND v(dout1_72) AT=2040.05n

.meas tran vdout1_73ck2030 FIND v(dout1_73) AT=2040.05n

.meas tran vdout1_74ck2030 FIND v(dout1_74) AT=2040.05n

.meas tran vdout1_75ck2030 FIND v(dout1_75) AT=2040.05n

.meas tran vdout1_76ck2030 FIND v(dout1_76) AT=2040.05n

.meas tran vdout1_77ck2030 FIND v(dout1_77) AT=2040.05n

.meas tran vdout1_78ck2030 FIND v(dout1_78) AT=2040.05n

.meas tran vdout1_79ck2030 FIND v(dout1_79) AT=2040.05n

.meas tran vdout1_80ck2030 FIND v(dout1_80) AT=2040.05n

.meas tran vdout1_81ck2030 FIND v(dout1_81) AT=2040.05n

.meas tran vdout1_82ck2030 FIND v(dout1_82) AT=2040.05n

.meas tran vdout1_83ck2030 FIND v(dout1_83) AT=2040.05n

.meas tran vdout1_84ck2030 FIND v(dout1_84) AT=2040.05n

.meas tran vdout1_85ck2030 FIND v(dout1_85) AT=2040.05n

.meas tran vdout1_86ck2030 FIND v(dout1_86) AT=2040.05n

.meas tran vdout1_87ck2030 FIND v(dout1_87) AT=2040.05n

.meas tran vdout1_88ck2030 FIND v(dout1_88) AT=2040.05n

.meas tran vdout1_89ck2030 FIND v(dout1_89) AT=2040.05n

.meas tran vdout1_90ck2030 FIND v(dout1_90) AT=2040.05n

.meas tran vdout1_91ck2030 FIND v(dout1_91) AT=2040.05n

.meas tran vdout1_92ck2030 FIND v(dout1_92) AT=2040.05n

.meas tran vdout1_93ck2030 FIND v(dout1_93) AT=2040.05n

.meas tran vdout1_94ck2030 FIND v(dout1_94) AT=2040.05n

.meas tran vdout1_95ck2030 FIND v(dout1_95) AT=2040.05n

.meas tran vdout1_96ck2030 FIND v(dout1_96) AT=2040.05n

.meas tran vdout1_97ck2030 FIND v(dout1_97) AT=2040.05n

.meas tran vdout1_98ck2030 FIND v(dout1_98) AT=2040.05n

.meas tran vdout1_99ck2030 FIND v(dout1_99) AT=2040.05n

.meas tran vdout1_100ck2030 FIND v(dout1_100) AT=2040.05n

.meas tran vdout1_101ck2030 FIND v(dout1_101) AT=2040.05n

.meas tran vdout1_102ck2030 FIND v(dout1_102) AT=2040.05n

.meas tran vdout1_103ck2030 FIND v(dout1_103) AT=2040.05n

.meas tran vdout1_104ck2030 FIND v(dout1_104) AT=2040.05n

.meas tran vdout1_105ck2030 FIND v(dout1_105) AT=2040.05n

.meas tran vdout1_106ck2030 FIND v(dout1_106) AT=2040.05n

.meas tran vdout1_107ck2030 FIND v(dout1_107) AT=2040.05n

.meas tran vdout1_108ck2030 FIND v(dout1_108) AT=2040.05n

.meas tran vdout1_109ck2030 FIND v(dout1_109) AT=2040.05n

.meas tran vdout1_110ck2030 FIND v(dout1_110) AT=2040.05n

.meas tran vdout1_111ck2030 FIND v(dout1_111) AT=2040.05n

.meas tran vdout1_112ck2030 FIND v(dout1_112) AT=2040.05n

.meas tran vdout1_113ck2030 FIND v(dout1_113) AT=2040.05n

.meas tran vdout1_114ck2030 FIND v(dout1_114) AT=2040.05n

.meas tran vdout1_115ck2030 FIND v(dout1_115) AT=2040.05n

.meas tran vdout1_116ck2030 FIND v(dout1_116) AT=2040.05n

.meas tran vdout1_117ck2030 FIND v(dout1_117) AT=2040.05n

.meas tran vdout1_118ck2030 FIND v(dout1_118) AT=2040.05n

.meas tran vdout1_119ck2030 FIND v(dout1_119) AT=2040.05n

.meas tran vdout1_120ck2030 FIND v(dout1_120) AT=2040.05n

.meas tran vdout1_121ck2030 FIND v(dout1_121) AT=2040.05n

.meas tran vdout1_122ck2030 FIND v(dout1_122) AT=2040.05n

.meas tran vdout1_123ck2030 FIND v(dout1_123) AT=2040.05n

.meas tran vdout1_124ck2030 FIND v(dout1_124) AT=2040.05n

.meas tran vdout1_125ck2030 FIND v(dout1_125) AT=2040.05n

.meas tran vdout1_126ck2030 FIND v(dout1_126) AT=2040.05n

.meas tran vdout1_127ck2030 FIND v(dout1_127) AT=2040.05n

.meas tran vdout1_128ck2030 FIND v(dout1_128) AT=2040.05n

.meas tran vdout1_129ck2030 FIND v(dout1_129) AT=2040.05n

.meas tran vdout1_130ck2030 FIND v(dout1_130) AT=2040.05n

.meas tran vdout1_131ck2030 FIND v(dout1_131) AT=2040.05n

.meas tran vdout1_132ck2030 FIND v(dout1_132) AT=2040.05n

.meas tran vdout1_133ck2030 FIND v(dout1_133) AT=2040.05n

.meas tran vdout1_134ck2030 FIND v(dout1_134) AT=2040.05n
