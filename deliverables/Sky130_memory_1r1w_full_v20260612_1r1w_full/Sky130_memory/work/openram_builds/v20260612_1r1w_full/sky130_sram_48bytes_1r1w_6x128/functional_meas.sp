.meas tran vdout1_0ck40 FIND v(dout1_0) AT=50.05n

.meas tran vdout1_1ck40 FIND v(dout1_1) AT=50.05n

.meas tran vdout1_2ck40 FIND v(dout1_2) AT=50.05n

.meas tran vdout1_3ck40 FIND v(dout1_3) AT=50.05n

.meas tran vdout1_4ck40 FIND v(dout1_4) AT=50.05n

.meas tran vdout1_5ck40 FIND v(dout1_5) AT=50.05n

.meas tran vdout1_6ck40 FIND v(dout1_6) AT=50.05n

.meas tran vdout1_0ck50 FIND v(dout1_0) AT=60.05n

.meas tran vdout1_1ck50 FIND v(dout1_1) AT=60.05n

.meas tran vdout1_2ck50 FIND v(dout1_2) AT=60.05n

.meas tran vdout1_3ck50 FIND v(dout1_3) AT=60.05n

.meas tran vdout1_4ck50 FIND v(dout1_4) AT=60.05n

.meas tran vdout1_5ck50 FIND v(dout1_5) AT=60.05n

.meas tran vdout1_6ck50 FIND v(dout1_6) AT=60.05n

.meas tran vdout1_0ck60 FIND v(dout1_0) AT=70.05n

.meas tran vdout1_1ck60 FIND v(dout1_1) AT=70.05n

.meas tran vdout1_2ck60 FIND v(dout1_2) AT=70.05n

.meas tran vdout1_3ck60 FIND v(dout1_3) AT=70.05n

.meas tran vdout1_4ck60 FIND v(dout1_4) AT=70.05n

.meas tran vdout1_5ck60 FIND v(dout1_5) AT=70.05n

.meas tran vdout1_6ck60 FIND v(dout1_6) AT=70.05n

.meas tran vdout1_0ck100 FIND v(dout1_0) AT=110.05n

.meas tran vdout1_1ck100 FIND v(dout1_1) AT=110.05n

.meas tran vdout1_2ck100 FIND v(dout1_2) AT=110.05n

.meas tran vdout1_3ck100 FIND v(dout1_3) AT=110.05n

.meas tran vdout1_4ck100 FIND v(dout1_4) AT=110.05n

.meas tran vdout1_5ck100 FIND v(dout1_5) AT=110.05n

.meas tran vdout1_6ck100 FIND v(dout1_6) AT=110.05n

.meas tran vdout1_0ck130 FIND v(dout1_0) AT=140.05n

.meas tran vdout1_1ck130 FIND v(dout1_1) AT=140.05n

.meas tran vdout1_2ck130 FIND v(dout1_2) AT=140.05n

.meas tran vdout1_3ck130 FIND v(dout1_3) AT=140.05n

.meas tran vdout1_4ck130 FIND v(dout1_4) AT=140.05n

.meas tran vdout1_5ck130 FIND v(dout1_5) AT=140.05n

.meas tran vdout1_6ck130 FIND v(dout1_6) AT=140.05n

.meas tran vdout1_0ck150 FIND v(dout1_0) AT=160.05n

.meas tran vdout1_1ck150 FIND v(dout1_1) AT=160.05n

.meas tran vdout1_2ck150 FIND v(dout1_2) AT=160.05n

.meas tran vdout1_3ck150 FIND v(dout1_3) AT=160.05n

.meas tran vdout1_4ck150 FIND v(dout1_4) AT=160.05n

.meas tran vdout1_5ck150 FIND v(dout1_5) AT=160.05n

.meas tran vdout1_6ck150 FIND v(dout1_6) AT=160.05n

.meas tran vdout1_0ck160 FIND v(dout1_0) AT=170.05n

.meas tran vdout1_1ck160 FIND v(dout1_1) AT=170.05n

.meas tran vdout1_2ck160 FIND v(dout1_2) AT=170.05n

.meas tran vdout1_3ck160 FIND v(dout1_3) AT=170.05n

.meas tran vdout1_4ck160 FIND v(dout1_4) AT=170.05n

.meas tran vdout1_5ck160 FIND v(dout1_5) AT=170.05n

.meas tran vdout1_6ck160 FIND v(dout1_6) AT=170.05n

.meas tran vdout1_0ck170 FIND v(dout1_0) AT=180.05n

.meas tran vdout1_1ck170 FIND v(dout1_1) AT=180.05n

.meas tran vdout1_2ck170 FIND v(dout1_2) AT=180.05n

.meas tran vdout1_3ck170 FIND v(dout1_3) AT=180.05n

.meas tran vdout1_4ck170 FIND v(dout1_4) AT=180.05n

.meas tran vdout1_5ck170 FIND v(dout1_5) AT=180.05n

.meas tran vdout1_6ck170 FIND v(dout1_6) AT=180.05n

.meas tran vdout1_0ck200 FIND v(dout1_0) AT=210.05n

.meas tran vdout1_1ck200 FIND v(dout1_1) AT=210.05n

.meas tran vdout1_2ck200 FIND v(dout1_2) AT=210.05n

.meas tran vdout1_3ck200 FIND v(dout1_3) AT=210.05n

.meas tran vdout1_4ck200 FIND v(dout1_4) AT=210.05n

.meas tran vdout1_5ck200 FIND v(dout1_5) AT=210.05n

.meas tran vdout1_6ck200 FIND v(dout1_6) AT=210.05n

.meas tran vdout1_0ck230 FIND v(dout1_0) AT=240.05n

.meas tran vdout1_1ck230 FIND v(dout1_1) AT=240.05n

.meas tran vdout1_2ck230 FIND v(dout1_2) AT=240.05n

.meas tran vdout1_3ck230 FIND v(dout1_3) AT=240.05n

.meas tran vdout1_4ck230 FIND v(dout1_4) AT=240.05n

.meas tran vdout1_5ck230 FIND v(dout1_5) AT=240.05n

.meas tran vdout1_6ck230 FIND v(dout1_6) AT=240.05n

.meas tran vdout1_0ck240 FIND v(dout1_0) AT=250.05n

.meas tran vdout1_1ck240 FIND v(dout1_1) AT=250.05n

.meas tran vdout1_2ck240 FIND v(dout1_2) AT=250.05n

.meas tran vdout1_3ck240 FIND v(dout1_3) AT=250.05n

.meas tran vdout1_4ck240 FIND v(dout1_4) AT=250.05n

.meas tran vdout1_5ck240 FIND v(dout1_5) AT=250.05n

.meas tran vdout1_6ck240 FIND v(dout1_6) AT=250.05n

.meas tran vdout1_0ck250 FIND v(dout1_0) AT=260.05n

.meas tran vdout1_1ck250 FIND v(dout1_1) AT=260.05n

.meas tran vdout1_2ck250 FIND v(dout1_2) AT=260.05n

.meas tran vdout1_3ck250 FIND v(dout1_3) AT=260.05n

.meas tran vdout1_4ck250 FIND v(dout1_4) AT=260.05n

.meas tran vdout1_5ck250 FIND v(dout1_5) AT=260.05n

.meas tran vdout1_6ck250 FIND v(dout1_6) AT=260.05n

.meas tran vdout1_0ck270 FIND v(dout1_0) AT=280.05n

.meas tran vdout1_1ck270 FIND v(dout1_1) AT=280.05n

.meas tran vdout1_2ck270 FIND v(dout1_2) AT=280.05n

.meas tran vdout1_3ck270 FIND v(dout1_3) AT=280.05n

.meas tran vdout1_4ck270 FIND v(dout1_4) AT=280.05n

.meas tran vdout1_5ck270 FIND v(dout1_5) AT=280.05n

.meas tran vdout1_6ck270 FIND v(dout1_6) AT=280.05n

.meas tran vdout1_0ck290 FIND v(dout1_0) AT=300.05n

.meas tran vdout1_1ck290 FIND v(dout1_1) AT=300.05n

.meas tran vdout1_2ck290 FIND v(dout1_2) AT=300.05n

.meas tran vdout1_3ck290 FIND v(dout1_3) AT=300.05n

.meas tran vdout1_4ck290 FIND v(dout1_4) AT=300.05n

.meas tran vdout1_5ck290 FIND v(dout1_5) AT=300.05n

.meas tran vdout1_6ck290 FIND v(dout1_6) AT=300.05n

.meas tran vdout1_0ck300 FIND v(dout1_0) AT=310.05n

.meas tran vdout1_1ck300 FIND v(dout1_1) AT=310.05n

.meas tran vdout1_2ck300 FIND v(dout1_2) AT=310.05n

.meas tran vdout1_3ck300 FIND v(dout1_3) AT=310.05n

.meas tran vdout1_4ck300 FIND v(dout1_4) AT=310.05n

.meas tran vdout1_5ck300 FIND v(dout1_5) AT=310.05n

.meas tran vdout1_6ck300 FIND v(dout1_6) AT=310.05n

.meas tran vdout1_0ck330 FIND v(dout1_0) AT=340.05n

.meas tran vdout1_1ck330 FIND v(dout1_1) AT=340.05n

.meas tran vdout1_2ck330 FIND v(dout1_2) AT=340.05n

.meas tran vdout1_3ck330 FIND v(dout1_3) AT=340.05n

.meas tran vdout1_4ck330 FIND v(dout1_4) AT=340.05n

.meas tran vdout1_5ck330 FIND v(dout1_5) AT=340.05n

.meas tran vdout1_6ck330 FIND v(dout1_6) AT=340.05n

.meas tran vdout1_0ck370 FIND v(dout1_0) AT=380.05n

.meas tran vdout1_1ck370 FIND v(dout1_1) AT=380.05n

.meas tran vdout1_2ck370 FIND v(dout1_2) AT=380.05n

.meas tran vdout1_3ck370 FIND v(dout1_3) AT=380.05n

.meas tran vdout1_4ck370 FIND v(dout1_4) AT=380.05n

.meas tran vdout1_5ck370 FIND v(dout1_5) AT=380.05n

.meas tran vdout1_6ck370 FIND v(dout1_6) AT=380.05n

.meas tran vdout1_0ck380 FIND v(dout1_0) AT=390.05n

.meas tran vdout1_1ck380 FIND v(dout1_1) AT=390.05n

.meas tran vdout1_2ck380 FIND v(dout1_2) AT=390.05n

.meas tran vdout1_3ck380 FIND v(dout1_3) AT=390.05n

.meas tran vdout1_4ck380 FIND v(dout1_4) AT=390.05n

.meas tran vdout1_5ck380 FIND v(dout1_5) AT=390.05n

.meas tran vdout1_6ck380 FIND v(dout1_6) AT=390.05n

.meas tran vdout1_0ck410 FIND v(dout1_0) AT=420.05n

.meas tran vdout1_1ck410 FIND v(dout1_1) AT=420.05n

.meas tran vdout1_2ck410 FIND v(dout1_2) AT=420.05n

.meas tran vdout1_3ck410 FIND v(dout1_3) AT=420.05n

.meas tran vdout1_4ck410 FIND v(dout1_4) AT=420.05n

.meas tran vdout1_5ck410 FIND v(dout1_5) AT=420.05n

.meas tran vdout1_6ck410 FIND v(dout1_6) AT=420.05n

.meas tran vdout1_0ck430 FIND v(dout1_0) AT=440.05n

.meas tran vdout1_1ck430 FIND v(dout1_1) AT=440.05n

.meas tran vdout1_2ck430 FIND v(dout1_2) AT=440.05n

.meas tran vdout1_3ck430 FIND v(dout1_3) AT=440.05n

.meas tran vdout1_4ck430 FIND v(dout1_4) AT=440.05n

.meas tran vdout1_5ck430 FIND v(dout1_5) AT=440.05n

.meas tran vdout1_6ck430 FIND v(dout1_6) AT=440.05n

.meas tran vdout1_0ck490 FIND v(dout1_0) AT=500.05n

.meas tran vdout1_1ck490 FIND v(dout1_1) AT=500.05n

.meas tran vdout1_2ck490 FIND v(dout1_2) AT=500.05n

.meas tran vdout1_3ck490 FIND v(dout1_3) AT=500.05n

.meas tran vdout1_4ck490 FIND v(dout1_4) AT=500.05n

.meas tran vdout1_5ck490 FIND v(dout1_5) AT=500.05n

.meas tran vdout1_6ck490 FIND v(dout1_6) AT=500.05n

.meas tran vdout1_0ck500 FIND v(dout1_0) AT=510.05n

.meas tran vdout1_1ck500 FIND v(dout1_1) AT=510.05n

.meas tran vdout1_2ck500 FIND v(dout1_2) AT=510.05n

.meas tran vdout1_3ck500 FIND v(dout1_3) AT=510.05n

.meas tran vdout1_4ck500 FIND v(dout1_4) AT=510.05n

.meas tran vdout1_5ck500 FIND v(dout1_5) AT=510.05n

.meas tran vdout1_6ck500 FIND v(dout1_6) AT=510.05n

.meas tran vdout1_0ck510 FIND v(dout1_0) AT=520.05n

.meas tran vdout1_1ck510 FIND v(dout1_1) AT=520.05n

.meas tran vdout1_2ck510 FIND v(dout1_2) AT=520.05n

.meas tran vdout1_3ck510 FIND v(dout1_3) AT=520.05n

.meas tran vdout1_4ck510 FIND v(dout1_4) AT=520.05n

.meas tran vdout1_5ck510 FIND v(dout1_5) AT=520.05n

.meas tran vdout1_6ck510 FIND v(dout1_6) AT=520.05n

.meas tran vdout1_0ck530 FIND v(dout1_0) AT=540.05n

.meas tran vdout1_1ck530 FIND v(dout1_1) AT=540.05n

.meas tran vdout1_2ck530 FIND v(dout1_2) AT=540.05n

.meas tran vdout1_3ck530 FIND v(dout1_3) AT=540.05n

.meas tran vdout1_4ck530 FIND v(dout1_4) AT=540.05n

.meas tran vdout1_5ck530 FIND v(dout1_5) AT=540.05n

.meas tran vdout1_6ck530 FIND v(dout1_6) AT=540.05n

.meas tran vdout1_0ck540 FIND v(dout1_0) AT=550.05n

.meas tran vdout1_1ck540 FIND v(dout1_1) AT=550.05n

.meas tran vdout1_2ck540 FIND v(dout1_2) AT=550.05n

.meas tran vdout1_3ck540 FIND v(dout1_3) AT=550.05n

.meas tran vdout1_4ck540 FIND v(dout1_4) AT=550.05n

.meas tran vdout1_5ck540 FIND v(dout1_5) AT=550.05n

.meas tran vdout1_6ck540 FIND v(dout1_6) AT=550.05n

.meas tran vdout1_0ck550 FIND v(dout1_0) AT=560.05n

.meas tran vdout1_1ck550 FIND v(dout1_1) AT=560.05n

.meas tran vdout1_2ck550 FIND v(dout1_2) AT=560.05n

.meas tran vdout1_3ck550 FIND v(dout1_3) AT=560.05n

.meas tran vdout1_4ck550 FIND v(dout1_4) AT=560.05n

.meas tran vdout1_5ck550 FIND v(dout1_5) AT=560.05n

.meas tran vdout1_6ck550 FIND v(dout1_6) AT=560.05n

.meas tran vdout1_0ck590 FIND v(dout1_0) AT=600.05n

.meas tran vdout1_1ck590 FIND v(dout1_1) AT=600.05n

.meas tran vdout1_2ck590 FIND v(dout1_2) AT=600.05n

.meas tran vdout1_3ck590 FIND v(dout1_3) AT=600.05n

.meas tran vdout1_4ck590 FIND v(dout1_4) AT=600.05n

.meas tran vdout1_5ck590 FIND v(dout1_5) AT=600.05n

.meas tran vdout1_6ck590 FIND v(dout1_6) AT=600.05n

.meas tran vdout1_0ck630 FIND v(dout1_0) AT=640.05n

.meas tran vdout1_1ck630 FIND v(dout1_1) AT=640.05n

.meas tran vdout1_2ck630 FIND v(dout1_2) AT=640.05n

.meas tran vdout1_3ck630 FIND v(dout1_3) AT=640.05n

.meas tran vdout1_4ck630 FIND v(dout1_4) AT=640.05n

.meas tran vdout1_5ck630 FIND v(dout1_5) AT=640.05n

.meas tran vdout1_6ck630 FIND v(dout1_6) AT=640.05n

.meas tran vdout1_0ck670 FIND v(dout1_0) AT=680.05n

.meas tran vdout1_1ck670 FIND v(dout1_1) AT=680.05n

.meas tran vdout1_2ck670 FIND v(dout1_2) AT=680.05n

.meas tran vdout1_3ck670 FIND v(dout1_3) AT=680.05n

.meas tran vdout1_4ck670 FIND v(dout1_4) AT=680.05n

.meas tran vdout1_5ck670 FIND v(dout1_5) AT=680.05n

.meas tran vdout1_6ck670 FIND v(dout1_6) AT=680.05n

.meas tran vdout1_0ck680 FIND v(dout1_0) AT=690.05n

.meas tran vdout1_1ck680 FIND v(dout1_1) AT=690.05n

.meas tran vdout1_2ck680 FIND v(dout1_2) AT=690.05n

.meas tran vdout1_3ck680 FIND v(dout1_3) AT=690.05n

.meas tran vdout1_4ck680 FIND v(dout1_4) AT=690.05n

.meas tran vdout1_5ck680 FIND v(dout1_5) AT=690.05n

.meas tran vdout1_6ck680 FIND v(dout1_6) AT=690.05n

.meas tran vdout1_0ck720 FIND v(dout1_0) AT=730.05n

.meas tran vdout1_1ck720 FIND v(dout1_1) AT=730.05n

.meas tran vdout1_2ck720 FIND v(dout1_2) AT=730.05n

.meas tran vdout1_3ck720 FIND v(dout1_3) AT=730.05n

.meas tran vdout1_4ck720 FIND v(dout1_4) AT=730.05n

.meas tran vdout1_5ck720 FIND v(dout1_5) AT=730.05n

.meas tran vdout1_6ck720 FIND v(dout1_6) AT=730.05n

.meas tran vdout1_0ck740 FIND v(dout1_0) AT=750.05n

.meas tran vdout1_1ck740 FIND v(dout1_1) AT=750.05n

.meas tran vdout1_2ck740 FIND v(dout1_2) AT=750.05n

.meas tran vdout1_3ck740 FIND v(dout1_3) AT=750.05n

.meas tran vdout1_4ck740 FIND v(dout1_4) AT=750.05n

.meas tran vdout1_5ck740 FIND v(dout1_5) AT=750.05n

.meas tran vdout1_6ck740 FIND v(dout1_6) AT=750.05n

.meas tran vdout1_0ck750 FIND v(dout1_0) AT=760.05n

.meas tran vdout1_1ck750 FIND v(dout1_1) AT=760.05n

.meas tran vdout1_2ck750 FIND v(dout1_2) AT=760.05n

.meas tran vdout1_3ck750 FIND v(dout1_3) AT=760.05n

.meas tran vdout1_4ck750 FIND v(dout1_4) AT=760.05n

.meas tran vdout1_5ck750 FIND v(dout1_5) AT=760.05n

.meas tran vdout1_6ck750 FIND v(dout1_6) AT=760.05n

.meas tran vdout1_0ck800 FIND v(dout1_0) AT=810.05n

.meas tran vdout1_1ck800 FIND v(dout1_1) AT=810.05n

.meas tran vdout1_2ck800 FIND v(dout1_2) AT=810.05n

.meas tran vdout1_3ck800 FIND v(dout1_3) AT=810.05n

.meas tran vdout1_4ck800 FIND v(dout1_4) AT=810.05n

.meas tran vdout1_5ck800 FIND v(dout1_5) AT=810.05n

.meas tran vdout1_6ck800 FIND v(dout1_6) AT=810.05n

.meas tran vdout1_0ck820 FIND v(dout1_0) AT=830.05n

.meas tran vdout1_1ck820 FIND v(dout1_1) AT=830.05n

.meas tran vdout1_2ck820 FIND v(dout1_2) AT=830.05n

.meas tran vdout1_3ck820 FIND v(dout1_3) AT=830.05n

.meas tran vdout1_4ck820 FIND v(dout1_4) AT=830.05n

.meas tran vdout1_5ck820 FIND v(dout1_5) AT=830.05n

.meas tran vdout1_6ck820 FIND v(dout1_6) AT=830.05n

.meas tran vdout1_0ck850 FIND v(dout1_0) AT=860.05n

.meas tran vdout1_1ck850 FIND v(dout1_1) AT=860.05n

.meas tran vdout1_2ck850 FIND v(dout1_2) AT=860.05n

.meas tran vdout1_3ck850 FIND v(dout1_3) AT=860.05n

.meas tran vdout1_4ck850 FIND v(dout1_4) AT=860.05n

.meas tran vdout1_5ck850 FIND v(dout1_5) AT=860.05n

.meas tran vdout1_6ck850 FIND v(dout1_6) AT=860.05n

.meas tran vdout1_0ck860 FIND v(dout1_0) AT=870.05n

.meas tran vdout1_1ck860 FIND v(dout1_1) AT=870.05n

.meas tran vdout1_2ck860 FIND v(dout1_2) AT=870.05n

.meas tran vdout1_3ck860 FIND v(dout1_3) AT=870.05n

.meas tran vdout1_4ck860 FIND v(dout1_4) AT=870.05n

.meas tran vdout1_5ck860 FIND v(dout1_5) AT=870.05n

.meas tran vdout1_6ck860 FIND v(dout1_6) AT=870.05n

.meas tran vdout1_0ck880 FIND v(dout1_0) AT=890.05n

.meas tran vdout1_1ck880 FIND v(dout1_1) AT=890.05n

.meas tran vdout1_2ck880 FIND v(dout1_2) AT=890.05n

.meas tran vdout1_3ck880 FIND v(dout1_3) AT=890.05n

.meas tran vdout1_4ck880 FIND v(dout1_4) AT=890.05n

.meas tran vdout1_5ck880 FIND v(dout1_5) AT=890.05n

.meas tran vdout1_6ck880 FIND v(dout1_6) AT=890.05n

.meas tran vdout1_0ck890 FIND v(dout1_0) AT=900.05n

.meas tran vdout1_1ck890 FIND v(dout1_1) AT=900.05n

.meas tran vdout1_2ck890 FIND v(dout1_2) AT=900.05n

.meas tran vdout1_3ck890 FIND v(dout1_3) AT=900.05n

.meas tran vdout1_4ck890 FIND v(dout1_4) AT=900.05n

.meas tran vdout1_5ck890 FIND v(dout1_5) AT=900.05n

.meas tran vdout1_6ck890 FIND v(dout1_6) AT=900.05n

.meas tran vdout1_0ck900 FIND v(dout1_0) AT=910.05n

.meas tran vdout1_1ck900 FIND v(dout1_1) AT=910.05n

.meas tran vdout1_2ck900 FIND v(dout1_2) AT=910.05n

.meas tran vdout1_3ck900 FIND v(dout1_3) AT=910.05n

.meas tran vdout1_4ck900 FIND v(dout1_4) AT=910.05n

.meas tran vdout1_5ck900 FIND v(dout1_5) AT=910.05n

.meas tran vdout1_6ck900 FIND v(dout1_6) AT=910.05n

.meas tran vdout1_0ck910 FIND v(dout1_0) AT=920.05n

.meas tran vdout1_1ck910 FIND v(dout1_1) AT=920.05n

.meas tran vdout1_2ck910 FIND v(dout1_2) AT=920.05n

.meas tran vdout1_3ck910 FIND v(dout1_3) AT=920.05n

.meas tran vdout1_4ck910 FIND v(dout1_4) AT=920.05n

.meas tran vdout1_5ck910 FIND v(dout1_5) AT=920.05n

.meas tran vdout1_6ck910 FIND v(dout1_6) AT=920.05n

.meas tran vdout1_0ck940 FIND v(dout1_0) AT=950.05n

.meas tran vdout1_1ck940 FIND v(dout1_1) AT=950.05n

.meas tran vdout1_2ck940 FIND v(dout1_2) AT=950.05n

.meas tran vdout1_3ck940 FIND v(dout1_3) AT=950.05n

.meas tran vdout1_4ck940 FIND v(dout1_4) AT=950.05n

.meas tran vdout1_5ck940 FIND v(dout1_5) AT=950.05n

.meas tran vdout1_6ck940 FIND v(dout1_6) AT=950.05n

.meas tran vdout1_0ck950 FIND v(dout1_0) AT=960.05n

.meas tran vdout1_1ck950 FIND v(dout1_1) AT=960.05n

.meas tran vdout1_2ck950 FIND v(dout1_2) AT=960.05n

.meas tran vdout1_3ck950 FIND v(dout1_3) AT=960.05n

.meas tran vdout1_4ck950 FIND v(dout1_4) AT=960.05n

.meas tran vdout1_5ck950 FIND v(dout1_5) AT=960.05n

.meas tran vdout1_6ck950 FIND v(dout1_6) AT=960.05n

.meas tran vdout1_0ck970 FIND v(dout1_0) AT=980.05n

.meas tran vdout1_1ck970 FIND v(dout1_1) AT=980.05n

.meas tran vdout1_2ck970 FIND v(dout1_2) AT=980.05n

.meas tran vdout1_3ck970 FIND v(dout1_3) AT=980.05n

.meas tran vdout1_4ck970 FIND v(dout1_4) AT=980.05n

.meas tran vdout1_5ck970 FIND v(dout1_5) AT=980.05n

.meas tran vdout1_6ck970 FIND v(dout1_6) AT=980.05n

.meas tran vdout1_0ck980 FIND v(dout1_0) AT=990.05n

.meas tran vdout1_1ck980 FIND v(dout1_1) AT=990.05n

.meas tran vdout1_2ck980 FIND v(dout1_2) AT=990.05n

.meas tran vdout1_3ck980 FIND v(dout1_3) AT=990.05n

.meas tran vdout1_4ck980 FIND v(dout1_4) AT=990.05n

.meas tran vdout1_5ck980 FIND v(dout1_5) AT=990.05n

.meas tran vdout1_6ck980 FIND v(dout1_6) AT=990.05n

.meas tran vdout1_0ck1000 FIND v(dout1_0) AT=1010.05n

.meas tran vdout1_1ck1000 FIND v(dout1_1) AT=1010.05n

.meas tran vdout1_2ck1000 FIND v(dout1_2) AT=1010.05n

.meas tran vdout1_3ck1000 FIND v(dout1_3) AT=1010.05n

.meas tran vdout1_4ck1000 FIND v(dout1_4) AT=1010.05n

.meas tran vdout1_5ck1000 FIND v(dout1_5) AT=1010.05n

.meas tran vdout1_6ck1000 FIND v(dout1_6) AT=1010.05n

.meas tran vdout1_0ck1010 FIND v(dout1_0) AT=1020.05n

.meas tran vdout1_1ck1010 FIND v(dout1_1) AT=1020.05n

.meas tran vdout1_2ck1010 FIND v(dout1_2) AT=1020.05n

.meas tran vdout1_3ck1010 FIND v(dout1_3) AT=1020.05n

.meas tran vdout1_4ck1010 FIND v(dout1_4) AT=1020.05n

.meas tran vdout1_5ck1010 FIND v(dout1_5) AT=1020.05n

.meas tran vdout1_6ck1010 FIND v(dout1_6) AT=1020.05n

.meas tran vdout1_0ck1040 FIND v(dout1_0) AT=1050.05n

.meas tran vdout1_1ck1040 FIND v(dout1_1) AT=1050.05n

.meas tran vdout1_2ck1040 FIND v(dout1_2) AT=1050.05n

.meas tran vdout1_3ck1040 FIND v(dout1_3) AT=1050.05n

.meas tran vdout1_4ck1040 FIND v(dout1_4) AT=1050.05n

.meas tran vdout1_5ck1040 FIND v(dout1_5) AT=1050.05n

.meas tran vdout1_6ck1040 FIND v(dout1_6) AT=1050.05n

.meas tran vdout1_0ck1050 FIND v(dout1_0) AT=1060.05n

.meas tran vdout1_1ck1050 FIND v(dout1_1) AT=1060.05n

.meas tran vdout1_2ck1050 FIND v(dout1_2) AT=1060.05n

.meas tran vdout1_3ck1050 FIND v(dout1_3) AT=1060.05n

.meas tran vdout1_4ck1050 FIND v(dout1_4) AT=1060.05n

.meas tran vdout1_5ck1050 FIND v(dout1_5) AT=1060.05n

.meas tran vdout1_6ck1050 FIND v(dout1_6) AT=1060.05n

.meas tran vdout1_0ck1060 FIND v(dout1_0) AT=1070.05n

.meas tran vdout1_1ck1060 FIND v(dout1_1) AT=1070.05n

.meas tran vdout1_2ck1060 FIND v(dout1_2) AT=1070.05n

.meas tran vdout1_3ck1060 FIND v(dout1_3) AT=1070.05n

.meas tran vdout1_4ck1060 FIND v(dout1_4) AT=1070.05n

.meas tran vdout1_5ck1060 FIND v(dout1_5) AT=1070.05n

.meas tran vdout1_6ck1060 FIND v(dout1_6) AT=1070.05n

.meas tran vdout1_0ck1080 FIND v(dout1_0) AT=1090.05n

.meas tran vdout1_1ck1080 FIND v(dout1_1) AT=1090.05n

.meas tran vdout1_2ck1080 FIND v(dout1_2) AT=1090.05n

.meas tran vdout1_3ck1080 FIND v(dout1_3) AT=1090.05n

.meas tran vdout1_4ck1080 FIND v(dout1_4) AT=1090.05n

.meas tran vdout1_5ck1080 FIND v(dout1_5) AT=1090.05n

.meas tran vdout1_6ck1080 FIND v(dout1_6) AT=1090.05n

.meas tran vdout1_0ck1090 FIND v(dout1_0) AT=1100.05n

.meas tran vdout1_1ck1090 FIND v(dout1_1) AT=1100.05n

.meas tran vdout1_2ck1090 FIND v(dout1_2) AT=1100.05n

.meas tran vdout1_3ck1090 FIND v(dout1_3) AT=1100.05n

.meas tran vdout1_4ck1090 FIND v(dout1_4) AT=1100.05n

.meas tran vdout1_5ck1090 FIND v(dout1_5) AT=1100.05n

.meas tran vdout1_6ck1090 FIND v(dout1_6) AT=1100.05n

.meas tran vdout1_0ck1120 FIND v(dout1_0) AT=1130.05n

.meas tran vdout1_1ck1120 FIND v(dout1_1) AT=1130.05n

.meas tran vdout1_2ck1120 FIND v(dout1_2) AT=1130.05n

.meas tran vdout1_3ck1120 FIND v(dout1_3) AT=1130.05n

.meas tran vdout1_4ck1120 FIND v(dout1_4) AT=1130.05n

.meas tran vdout1_5ck1120 FIND v(dout1_5) AT=1130.05n

.meas tran vdout1_6ck1120 FIND v(dout1_6) AT=1130.05n

.meas tran vdout1_0ck1170 FIND v(dout1_0) AT=1180.05n

.meas tran vdout1_1ck1170 FIND v(dout1_1) AT=1180.05n

.meas tran vdout1_2ck1170 FIND v(dout1_2) AT=1180.05n

.meas tran vdout1_3ck1170 FIND v(dout1_3) AT=1180.05n

.meas tran vdout1_4ck1170 FIND v(dout1_4) AT=1180.05n

.meas tran vdout1_5ck1170 FIND v(dout1_5) AT=1180.05n

.meas tran vdout1_6ck1170 FIND v(dout1_6) AT=1180.05n

.meas tran vdout1_0ck1180 FIND v(dout1_0) AT=1190.05n

.meas tran vdout1_1ck1180 FIND v(dout1_1) AT=1190.05n

.meas tran vdout1_2ck1180 FIND v(dout1_2) AT=1190.05n

.meas tran vdout1_3ck1180 FIND v(dout1_3) AT=1190.05n

.meas tran vdout1_4ck1180 FIND v(dout1_4) AT=1190.05n

.meas tran vdout1_5ck1180 FIND v(dout1_5) AT=1190.05n

.meas tran vdout1_6ck1180 FIND v(dout1_6) AT=1190.05n

.meas tran vdout1_0ck1190 FIND v(dout1_0) AT=1200.05n

.meas tran vdout1_1ck1190 FIND v(dout1_1) AT=1200.05n

.meas tran vdout1_2ck1190 FIND v(dout1_2) AT=1200.05n

.meas tran vdout1_3ck1190 FIND v(dout1_3) AT=1200.05n

.meas tran vdout1_4ck1190 FIND v(dout1_4) AT=1200.05n

.meas tran vdout1_5ck1190 FIND v(dout1_5) AT=1200.05n

.meas tran vdout1_6ck1190 FIND v(dout1_6) AT=1200.05n

.meas tran vdout1_0ck1210 FIND v(dout1_0) AT=1220.05n

.meas tran vdout1_1ck1210 FIND v(dout1_1) AT=1220.05n

.meas tran vdout1_2ck1210 FIND v(dout1_2) AT=1220.05n

.meas tran vdout1_3ck1210 FIND v(dout1_3) AT=1220.05n

.meas tran vdout1_4ck1210 FIND v(dout1_4) AT=1220.05n

.meas tran vdout1_5ck1210 FIND v(dout1_5) AT=1220.05n

.meas tran vdout1_6ck1210 FIND v(dout1_6) AT=1220.05n

.meas tran vdout1_0ck1250 FIND v(dout1_0) AT=1260.05n

.meas tran vdout1_1ck1250 FIND v(dout1_1) AT=1260.05n

.meas tran vdout1_2ck1250 FIND v(dout1_2) AT=1260.05n

.meas tran vdout1_3ck1250 FIND v(dout1_3) AT=1260.05n

.meas tran vdout1_4ck1250 FIND v(dout1_4) AT=1260.05n

.meas tran vdout1_5ck1250 FIND v(dout1_5) AT=1260.05n

.meas tran vdout1_6ck1250 FIND v(dout1_6) AT=1260.05n

.meas tran vdout1_0ck1280 FIND v(dout1_0) AT=1290.05n

.meas tran vdout1_1ck1280 FIND v(dout1_1) AT=1290.05n

.meas tran vdout1_2ck1280 FIND v(dout1_2) AT=1290.05n

.meas tran vdout1_3ck1280 FIND v(dout1_3) AT=1290.05n

.meas tran vdout1_4ck1280 FIND v(dout1_4) AT=1290.05n

.meas tran vdout1_5ck1280 FIND v(dout1_5) AT=1290.05n

.meas tran vdout1_6ck1280 FIND v(dout1_6) AT=1290.05n

.meas tran vdout1_0ck1300 FIND v(dout1_0) AT=1310.05n

.meas tran vdout1_1ck1300 FIND v(dout1_1) AT=1310.05n

.meas tran vdout1_2ck1300 FIND v(dout1_2) AT=1310.05n

.meas tran vdout1_3ck1300 FIND v(dout1_3) AT=1310.05n

.meas tran vdout1_4ck1300 FIND v(dout1_4) AT=1310.05n

.meas tran vdout1_5ck1300 FIND v(dout1_5) AT=1310.05n

.meas tran vdout1_6ck1300 FIND v(dout1_6) AT=1310.05n

.meas tran vdout1_0ck1310 FIND v(dout1_0) AT=1320.05n

.meas tran vdout1_1ck1310 FIND v(dout1_1) AT=1320.05n

.meas tran vdout1_2ck1310 FIND v(dout1_2) AT=1320.05n

.meas tran vdout1_3ck1310 FIND v(dout1_3) AT=1320.05n

.meas tran vdout1_4ck1310 FIND v(dout1_4) AT=1320.05n

.meas tran vdout1_5ck1310 FIND v(dout1_5) AT=1320.05n

.meas tran vdout1_6ck1310 FIND v(dout1_6) AT=1320.05n

.meas tran vdout1_0ck1320 FIND v(dout1_0) AT=1330.05n

.meas tran vdout1_1ck1320 FIND v(dout1_1) AT=1330.05n

.meas tran vdout1_2ck1320 FIND v(dout1_2) AT=1330.05n

.meas tran vdout1_3ck1320 FIND v(dout1_3) AT=1330.05n

.meas tran vdout1_4ck1320 FIND v(dout1_4) AT=1330.05n

.meas tran vdout1_5ck1320 FIND v(dout1_5) AT=1330.05n

.meas tran vdout1_6ck1320 FIND v(dout1_6) AT=1330.05n

.meas tran vdout1_0ck1330 FIND v(dout1_0) AT=1340.05n

.meas tran vdout1_1ck1330 FIND v(dout1_1) AT=1340.05n

.meas tran vdout1_2ck1330 FIND v(dout1_2) AT=1340.05n

.meas tran vdout1_3ck1330 FIND v(dout1_3) AT=1340.05n

.meas tran vdout1_4ck1330 FIND v(dout1_4) AT=1340.05n

.meas tran vdout1_5ck1330 FIND v(dout1_5) AT=1340.05n

.meas tran vdout1_6ck1330 FIND v(dout1_6) AT=1340.05n

.meas tran vdout1_0ck1360 FIND v(dout1_0) AT=1370.05n

.meas tran vdout1_1ck1360 FIND v(dout1_1) AT=1370.05n

.meas tran vdout1_2ck1360 FIND v(dout1_2) AT=1370.05n

.meas tran vdout1_3ck1360 FIND v(dout1_3) AT=1370.05n

.meas tran vdout1_4ck1360 FIND v(dout1_4) AT=1370.05n

.meas tran vdout1_5ck1360 FIND v(dout1_5) AT=1370.05n

.meas tran vdout1_6ck1360 FIND v(dout1_6) AT=1370.05n

.meas tran vdout1_0ck1400 FIND v(dout1_0) AT=1410.05n

.meas tran vdout1_1ck1400 FIND v(dout1_1) AT=1410.05n

.meas tran vdout1_2ck1400 FIND v(dout1_2) AT=1410.05n

.meas tran vdout1_3ck1400 FIND v(dout1_3) AT=1410.05n

.meas tran vdout1_4ck1400 FIND v(dout1_4) AT=1410.05n

.meas tran vdout1_5ck1400 FIND v(dout1_5) AT=1410.05n

.meas tran vdout1_6ck1400 FIND v(dout1_6) AT=1410.05n

.meas tran vdout1_0ck1420 FIND v(dout1_0) AT=1430.05n

.meas tran vdout1_1ck1420 FIND v(dout1_1) AT=1430.05n

.meas tran vdout1_2ck1420 FIND v(dout1_2) AT=1430.05n

.meas tran vdout1_3ck1420 FIND v(dout1_3) AT=1430.05n

.meas tran vdout1_4ck1420 FIND v(dout1_4) AT=1430.05n

.meas tran vdout1_5ck1420 FIND v(dout1_5) AT=1430.05n

.meas tran vdout1_6ck1420 FIND v(dout1_6) AT=1430.05n

.meas tran vdout1_0ck1430 FIND v(dout1_0) AT=1440.05n

.meas tran vdout1_1ck1430 FIND v(dout1_1) AT=1440.05n

.meas tran vdout1_2ck1430 FIND v(dout1_2) AT=1440.05n

.meas tran vdout1_3ck1430 FIND v(dout1_3) AT=1440.05n

.meas tran vdout1_4ck1430 FIND v(dout1_4) AT=1440.05n

.meas tran vdout1_5ck1430 FIND v(dout1_5) AT=1440.05n

.meas tran vdout1_6ck1430 FIND v(dout1_6) AT=1440.05n

.meas tran vdout1_0ck1440 FIND v(dout1_0) AT=1450.05n

.meas tran vdout1_1ck1440 FIND v(dout1_1) AT=1450.05n

.meas tran vdout1_2ck1440 FIND v(dout1_2) AT=1450.05n

.meas tran vdout1_3ck1440 FIND v(dout1_3) AT=1450.05n

.meas tran vdout1_4ck1440 FIND v(dout1_4) AT=1450.05n

.meas tran vdout1_5ck1440 FIND v(dout1_5) AT=1450.05n

.meas tran vdout1_6ck1440 FIND v(dout1_6) AT=1450.05n

.meas tran vdout1_0ck1450 FIND v(dout1_0) AT=1460.05n

.meas tran vdout1_1ck1450 FIND v(dout1_1) AT=1460.05n

.meas tran vdout1_2ck1450 FIND v(dout1_2) AT=1460.05n

.meas tran vdout1_3ck1450 FIND v(dout1_3) AT=1460.05n

.meas tran vdout1_4ck1450 FIND v(dout1_4) AT=1460.05n

.meas tran vdout1_5ck1450 FIND v(dout1_5) AT=1460.05n

.meas tran vdout1_6ck1450 FIND v(dout1_6) AT=1460.05n

.meas tran vdout1_0ck1480 FIND v(dout1_0) AT=1490.05n

.meas tran vdout1_1ck1480 FIND v(dout1_1) AT=1490.05n

.meas tran vdout1_2ck1480 FIND v(dout1_2) AT=1490.05n

.meas tran vdout1_3ck1480 FIND v(dout1_3) AT=1490.05n

.meas tran vdout1_4ck1480 FIND v(dout1_4) AT=1490.05n

.meas tran vdout1_5ck1480 FIND v(dout1_5) AT=1490.05n

.meas tran vdout1_6ck1480 FIND v(dout1_6) AT=1490.05n

.meas tran vdout1_0ck1490 FIND v(dout1_0) AT=1500.05n

.meas tran vdout1_1ck1490 FIND v(dout1_1) AT=1500.05n

.meas tran vdout1_2ck1490 FIND v(dout1_2) AT=1500.05n

.meas tran vdout1_3ck1490 FIND v(dout1_3) AT=1500.05n

.meas tran vdout1_4ck1490 FIND v(dout1_4) AT=1500.05n

.meas tran vdout1_5ck1490 FIND v(dout1_5) AT=1500.05n

.meas tran vdout1_6ck1490 FIND v(dout1_6) AT=1500.05n

.meas tran vdout1_0ck1580 FIND v(dout1_0) AT=1590.05n

.meas tran vdout1_1ck1580 FIND v(dout1_1) AT=1590.05n

.meas tran vdout1_2ck1580 FIND v(dout1_2) AT=1590.05n

.meas tran vdout1_3ck1580 FIND v(dout1_3) AT=1590.05n

.meas tran vdout1_4ck1580 FIND v(dout1_4) AT=1590.05n

.meas tran vdout1_5ck1580 FIND v(dout1_5) AT=1590.05n

.meas tran vdout1_6ck1580 FIND v(dout1_6) AT=1590.05n

.meas tran vdout1_0ck1590 FIND v(dout1_0) AT=1600.05n

.meas tran vdout1_1ck1590 FIND v(dout1_1) AT=1600.05n

.meas tran vdout1_2ck1590 FIND v(dout1_2) AT=1600.05n

.meas tran vdout1_3ck1590 FIND v(dout1_3) AT=1600.05n

.meas tran vdout1_4ck1590 FIND v(dout1_4) AT=1600.05n

.meas tran vdout1_5ck1590 FIND v(dout1_5) AT=1600.05n

.meas tran vdout1_6ck1590 FIND v(dout1_6) AT=1600.05n

.meas tran vdout1_0ck1600 FIND v(dout1_0) AT=1610.05n

.meas tran vdout1_1ck1600 FIND v(dout1_1) AT=1610.05n

.meas tran vdout1_2ck1600 FIND v(dout1_2) AT=1610.05n

.meas tran vdout1_3ck1600 FIND v(dout1_3) AT=1610.05n

.meas tran vdout1_4ck1600 FIND v(dout1_4) AT=1610.05n

.meas tran vdout1_5ck1600 FIND v(dout1_5) AT=1610.05n

.meas tran vdout1_6ck1600 FIND v(dout1_6) AT=1610.05n

.meas tran vdout1_0ck1610 FIND v(dout1_0) AT=1620.05n

.meas tran vdout1_1ck1610 FIND v(dout1_1) AT=1620.05n

.meas tran vdout1_2ck1610 FIND v(dout1_2) AT=1620.05n

.meas tran vdout1_3ck1610 FIND v(dout1_3) AT=1620.05n

.meas tran vdout1_4ck1610 FIND v(dout1_4) AT=1620.05n

.meas tran vdout1_5ck1610 FIND v(dout1_5) AT=1620.05n

.meas tran vdout1_6ck1610 FIND v(dout1_6) AT=1620.05n

.meas tran vdout1_0ck1630 FIND v(dout1_0) AT=1640.05n

.meas tran vdout1_1ck1630 FIND v(dout1_1) AT=1640.05n

.meas tran vdout1_2ck1630 FIND v(dout1_2) AT=1640.05n

.meas tran vdout1_3ck1630 FIND v(dout1_3) AT=1640.05n

.meas tran vdout1_4ck1630 FIND v(dout1_4) AT=1640.05n

.meas tran vdout1_5ck1630 FIND v(dout1_5) AT=1640.05n

.meas tran vdout1_6ck1630 FIND v(dout1_6) AT=1640.05n

.meas tran vdout1_0ck1640 FIND v(dout1_0) AT=1650.05n

.meas tran vdout1_1ck1640 FIND v(dout1_1) AT=1650.05n

.meas tran vdout1_2ck1640 FIND v(dout1_2) AT=1650.05n

.meas tran vdout1_3ck1640 FIND v(dout1_3) AT=1650.05n

.meas tran vdout1_4ck1640 FIND v(dout1_4) AT=1650.05n

.meas tran vdout1_5ck1640 FIND v(dout1_5) AT=1650.05n

.meas tran vdout1_6ck1640 FIND v(dout1_6) AT=1650.05n

.meas tran vdout1_0ck1690 FIND v(dout1_0) AT=1700.05n

.meas tran vdout1_1ck1690 FIND v(dout1_1) AT=1700.05n

.meas tran vdout1_2ck1690 FIND v(dout1_2) AT=1700.05n

.meas tran vdout1_3ck1690 FIND v(dout1_3) AT=1700.05n

.meas tran vdout1_4ck1690 FIND v(dout1_4) AT=1700.05n

.meas tran vdout1_5ck1690 FIND v(dout1_5) AT=1700.05n

.meas tran vdout1_6ck1690 FIND v(dout1_6) AT=1700.05n

.meas tran vdout1_0ck1700 FIND v(dout1_0) AT=1710.05n

.meas tran vdout1_1ck1700 FIND v(dout1_1) AT=1710.05n

.meas tran vdout1_2ck1700 FIND v(dout1_2) AT=1710.05n

.meas tran vdout1_3ck1700 FIND v(dout1_3) AT=1710.05n

.meas tran vdout1_4ck1700 FIND v(dout1_4) AT=1710.05n

.meas tran vdout1_5ck1700 FIND v(dout1_5) AT=1710.05n

.meas tran vdout1_6ck1700 FIND v(dout1_6) AT=1710.05n

.meas tran vdout1_0ck1740 FIND v(dout1_0) AT=1750.05n

.meas tran vdout1_1ck1740 FIND v(dout1_1) AT=1750.05n

.meas tran vdout1_2ck1740 FIND v(dout1_2) AT=1750.05n

.meas tran vdout1_3ck1740 FIND v(dout1_3) AT=1750.05n

.meas tran vdout1_4ck1740 FIND v(dout1_4) AT=1750.05n

.meas tran vdout1_5ck1740 FIND v(dout1_5) AT=1750.05n

.meas tran vdout1_6ck1740 FIND v(dout1_6) AT=1750.05n

.meas tran vdout1_0ck1750 FIND v(dout1_0) AT=1760.05n

.meas tran vdout1_1ck1750 FIND v(dout1_1) AT=1760.05n

.meas tran vdout1_2ck1750 FIND v(dout1_2) AT=1760.05n

.meas tran vdout1_3ck1750 FIND v(dout1_3) AT=1760.05n

.meas tran vdout1_4ck1750 FIND v(dout1_4) AT=1760.05n

.meas tran vdout1_5ck1750 FIND v(dout1_5) AT=1760.05n

.meas tran vdout1_6ck1750 FIND v(dout1_6) AT=1760.05n

.meas tran vdout1_0ck1760 FIND v(dout1_0) AT=1770.05n

.meas tran vdout1_1ck1760 FIND v(dout1_1) AT=1770.05n

.meas tran vdout1_2ck1760 FIND v(dout1_2) AT=1770.05n

.meas tran vdout1_3ck1760 FIND v(dout1_3) AT=1770.05n

.meas tran vdout1_4ck1760 FIND v(dout1_4) AT=1770.05n

.meas tran vdout1_5ck1760 FIND v(dout1_5) AT=1770.05n

.meas tran vdout1_6ck1760 FIND v(dout1_6) AT=1770.05n

.meas tran vdout1_0ck1770 FIND v(dout1_0) AT=1780.05n

.meas tran vdout1_1ck1770 FIND v(dout1_1) AT=1780.05n

.meas tran vdout1_2ck1770 FIND v(dout1_2) AT=1780.05n

.meas tran vdout1_3ck1770 FIND v(dout1_3) AT=1780.05n

.meas tran vdout1_4ck1770 FIND v(dout1_4) AT=1780.05n

.meas tran vdout1_5ck1770 FIND v(dout1_5) AT=1780.05n

.meas tran vdout1_6ck1770 FIND v(dout1_6) AT=1780.05n

.meas tran vdout1_0ck1790 FIND v(dout1_0) AT=1800.05n

.meas tran vdout1_1ck1790 FIND v(dout1_1) AT=1800.05n

.meas tran vdout1_2ck1790 FIND v(dout1_2) AT=1800.05n

.meas tran vdout1_3ck1790 FIND v(dout1_3) AT=1800.05n

.meas tran vdout1_4ck1790 FIND v(dout1_4) AT=1800.05n

.meas tran vdout1_5ck1790 FIND v(dout1_5) AT=1800.05n

.meas tran vdout1_6ck1790 FIND v(dout1_6) AT=1800.05n

.meas tran vdout1_0ck1820 FIND v(dout1_0) AT=1830.05n

.meas tran vdout1_1ck1820 FIND v(dout1_1) AT=1830.05n

.meas tran vdout1_2ck1820 FIND v(dout1_2) AT=1830.05n

.meas tran vdout1_3ck1820 FIND v(dout1_3) AT=1830.05n

.meas tran vdout1_4ck1820 FIND v(dout1_4) AT=1830.05n

.meas tran vdout1_5ck1820 FIND v(dout1_5) AT=1830.05n

.meas tran vdout1_6ck1820 FIND v(dout1_6) AT=1830.05n

.meas tran vdout1_0ck1830 FIND v(dout1_0) AT=1840.05n

.meas tran vdout1_1ck1830 FIND v(dout1_1) AT=1840.05n

.meas tran vdout1_2ck1830 FIND v(dout1_2) AT=1840.05n

.meas tran vdout1_3ck1830 FIND v(dout1_3) AT=1840.05n

.meas tran vdout1_4ck1830 FIND v(dout1_4) AT=1840.05n

.meas tran vdout1_5ck1830 FIND v(dout1_5) AT=1840.05n

.meas tran vdout1_6ck1830 FIND v(dout1_6) AT=1840.05n

.meas tran vdout1_0ck1840 FIND v(dout1_0) AT=1850.05n

.meas tran vdout1_1ck1840 FIND v(dout1_1) AT=1850.05n

.meas tran vdout1_2ck1840 FIND v(dout1_2) AT=1850.05n

.meas tran vdout1_3ck1840 FIND v(dout1_3) AT=1850.05n

.meas tran vdout1_4ck1840 FIND v(dout1_4) AT=1850.05n

.meas tran vdout1_5ck1840 FIND v(dout1_5) AT=1850.05n

.meas tran vdout1_6ck1840 FIND v(dout1_6) AT=1850.05n

.meas tran vdout1_0ck1870 FIND v(dout1_0) AT=1880.05n

.meas tran vdout1_1ck1870 FIND v(dout1_1) AT=1880.05n

.meas tran vdout1_2ck1870 FIND v(dout1_2) AT=1880.05n

.meas tran vdout1_3ck1870 FIND v(dout1_3) AT=1880.05n

.meas tran vdout1_4ck1870 FIND v(dout1_4) AT=1880.05n

.meas tran vdout1_5ck1870 FIND v(dout1_5) AT=1880.05n

.meas tran vdout1_6ck1870 FIND v(dout1_6) AT=1880.05n

.meas tran vdout1_0ck1890 FIND v(dout1_0) AT=1900.05n

.meas tran vdout1_1ck1890 FIND v(dout1_1) AT=1900.05n

.meas tran vdout1_2ck1890 FIND v(dout1_2) AT=1900.05n

.meas tran vdout1_3ck1890 FIND v(dout1_3) AT=1900.05n

.meas tran vdout1_4ck1890 FIND v(dout1_4) AT=1900.05n

.meas tran vdout1_5ck1890 FIND v(dout1_5) AT=1900.05n

.meas tran vdout1_6ck1890 FIND v(dout1_6) AT=1900.05n

.meas tran vdout1_0ck1920 FIND v(dout1_0) AT=1930.05n

.meas tran vdout1_1ck1920 FIND v(dout1_1) AT=1930.05n

.meas tran vdout1_2ck1920 FIND v(dout1_2) AT=1930.05n

.meas tran vdout1_3ck1920 FIND v(dout1_3) AT=1930.05n

.meas tran vdout1_4ck1920 FIND v(dout1_4) AT=1930.05n

.meas tran vdout1_5ck1920 FIND v(dout1_5) AT=1930.05n

.meas tran vdout1_6ck1920 FIND v(dout1_6) AT=1930.05n

.meas tran vdout1_0ck1930 FIND v(dout1_0) AT=1940.05n

.meas tran vdout1_1ck1930 FIND v(dout1_1) AT=1940.05n

.meas tran vdout1_2ck1930 FIND v(dout1_2) AT=1940.05n

.meas tran vdout1_3ck1930 FIND v(dout1_3) AT=1940.05n

.meas tran vdout1_4ck1930 FIND v(dout1_4) AT=1940.05n

.meas tran vdout1_5ck1930 FIND v(dout1_5) AT=1940.05n

.meas tran vdout1_6ck1930 FIND v(dout1_6) AT=1940.05n

.meas tran vdout1_0ck1950 FIND v(dout1_0) AT=1960.05n

.meas tran vdout1_1ck1950 FIND v(dout1_1) AT=1960.05n

.meas tran vdout1_2ck1950 FIND v(dout1_2) AT=1960.05n

.meas tran vdout1_3ck1950 FIND v(dout1_3) AT=1960.05n

.meas tran vdout1_4ck1950 FIND v(dout1_4) AT=1960.05n

.meas tran vdout1_5ck1950 FIND v(dout1_5) AT=1960.05n

.meas tran vdout1_6ck1950 FIND v(dout1_6) AT=1960.05n

.meas tran vdout1_0ck1970 FIND v(dout1_0) AT=1980.05n

.meas tran vdout1_1ck1970 FIND v(dout1_1) AT=1980.05n

.meas tran vdout1_2ck1970 FIND v(dout1_2) AT=1980.05n

.meas tran vdout1_3ck1970 FIND v(dout1_3) AT=1980.05n

.meas tran vdout1_4ck1970 FIND v(dout1_4) AT=1980.05n

.meas tran vdout1_5ck1970 FIND v(dout1_5) AT=1980.05n

.meas tran vdout1_6ck1970 FIND v(dout1_6) AT=1980.05n

.meas tran vdout1_0ck2010 FIND v(dout1_0) AT=2020.05n

.meas tran vdout1_1ck2010 FIND v(dout1_1) AT=2020.05n

.meas tran vdout1_2ck2010 FIND v(dout1_2) AT=2020.05n

.meas tran vdout1_3ck2010 FIND v(dout1_3) AT=2020.05n

.meas tran vdout1_4ck2010 FIND v(dout1_4) AT=2020.05n

.meas tran vdout1_5ck2010 FIND v(dout1_5) AT=2020.05n

.meas tran vdout1_6ck2010 FIND v(dout1_6) AT=2020.05n

.meas tran vdout1_0ck2020 FIND v(dout1_0) AT=2030.05n

.meas tran vdout1_1ck2020 FIND v(dout1_1) AT=2030.05n

.meas tran vdout1_2ck2020 FIND v(dout1_2) AT=2030.05n

.meas tran vdout1_3ck2020 FIND v(dout1_3) AT=2030.05n

.meas tran vdout1_4ck2020 FIND v(dout1_4) AT=2030.05n

.meas tran vdout1_5ck2020 FIND v(dout1_5) AT=2030.05n

.meas tran vdout1_6ck2020 FIND v(dout1_6) AT=2030.05n
