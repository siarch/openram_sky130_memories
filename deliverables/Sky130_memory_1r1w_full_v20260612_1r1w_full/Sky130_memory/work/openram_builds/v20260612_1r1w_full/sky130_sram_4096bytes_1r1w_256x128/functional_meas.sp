.meas tran vdout1_0ck40 FIND v(dout1_0) AT=50.05n

.meas tran vdout1_1ck40 FIND v(dout1_1) AT=50.05n

.meas tran vdout1_2ck40 FIND v(dout1_2) AT=50.05n

.meas tran vdout1_3ck40 FIND v(dout1_3) AT=50.05n

.meas tran vdout1_4ck40 FIND v(dout1_4) AT=50.05n

.meas tran vdout1_5ck40 FIND v(dout1_5) AT=50.05n

.meas tran vdout1_6ck40 FIND v(dout1_6) AT=50.05n

.meas tran vdout1_7ck40 FIND v(dout1_7) AT=50.05n

.meas tran vdout1_8ck40 FIND v(dout1_8) AT=50.05n

.meas tran vdout1_9ck40 FIND v(dout1_9) AT=50.05n

.meas tran vdout1_10ck40 FIND v(dout1_10) AT=50.05n

.meas tran vdout1_11ck40 FIND v(dout1_11) AT=50.05n

.meas tran vdout1_12ck40 FIND v(dout1_12) AT=50.05n

.meas tran vdout1_13ck40 FIND v(dout1_13) AT=50.05n

.meas tran vdout1_14ck40 FIND v(dout1_14) AT=50.05n

.meas tran vdout1_15ck40 FIND v(dout1_15) AT=50.05n

.meas tran vdout1_16ck40 FIND v(dout1_16) AT=50.05n

.meas tran vdout1_17ck40 FIND v(dout1_17) AT=50.05n

.meas tran vdout1_18ck40 FIND v(dout1_18) AT=50.05n

.meas tran vdout1_19ck40 FIND v(dout1_19) AT=50.05n

.meas tran vdout1_20ck40 FIND v(dout1_20) AT=50.05n

.meas tran vdout1_21ck40 FIND v(dout1_21) AT=50.05n

.meas tran vdout1_22ck40 FIND v(dout1_22) AT=50.05n

.meas tran vdout1_23ck40 FIND v(dout1_23) AT=50.05n

.meas tran vdout1_24ck40 FIND v(dout1_24) AT=50.05n

.meas tran vdout1_25ck40 FIND v(dout1_25) AT=50.05n

.meas tran vdout1_26ck40 FIND v(dout1_26) AT=50.05n

.meas tran vdout1_27ck40 FIND v(dout1_27) AT=50.05n

.meas tran vdout1_28ck40 FIND v(dout1_28) AT=50.05n

.meas tran vdout1_29ck40 FIND v(dout1_29) AT=50.05n

.meas tran vdout1_30ck40 FIND v(dout1_30) AT=50.05n

.meas tran vdout1_31ck40 FIND v(dout1_31) AT=50.05n

.meas tran vdout1_32ck40 FIND v(dout1_32) AT=50.05n

.meas tran vdout1_33ck40 FIND v(dout1_33) AT=50.05n

.meas tran vdout1_34ck40 FIND v(dout1_34) AT=50.05n

.meas tran vdout1_35ck40 FIND v(dout1_35) AT=50.05n

.meas tran vdout1_36ck40 FIND v(dout1_36) AT=50.05n

.meas tran vdout1_37ck40 FIND v(dout1_37) AT=50.05n

.meas tran vdout1_38ck40 FIND v(dout1_38) AT=50.05n

.meas tran vdout1_39ck40 FIND v(dout1_39) AT=50.05n

.meas tran vdout1_40ck40 FIND v(dout1_40) AT=50.05n

.meas tran vdout1_41ck40 FIND v(dout1_41) AT=50.05n

.meas tran vdout1_42ck40 FIND v(dout1_42) AT=50.05n

.meas tran vdout1_43ck40 FIND v(dout1_43) AT=50.05n

.meas tran vdout1_44ck40 FIND v(dout1_44) AT=50.05n

.meas tran vdout1_45ck40 FIND v(dout1_45) AT=50.05n

.meas tran vdout1_46ck40 FIND v(dout1_46) AT=50.05n

.meas tran vdout1_47ck40 FIND v(dout1_47) AT=50.05n

.meas tran vdout1_48ck40 FIND v(dout1_48) AT=50.05n

.meas tran vdout1_49ck40 FIND v(dout1_49) AT=50.05n

.meas tran vdout1_50ck40 FIND v(dout1_50) AT=50.05n

.meas tran vdout1_51ck40 FIND v(dout1_51) AT=50.05n

.meas tran vdout1_52ck40 FIND v(dout1_52) AT=50.05n

.meas tran vdout1_53ck40 FIND v(dout1_53) AT=50.05n

.meas tran vdout1_54ck40 FIND v(dout1_54) AT=50.05n

.meas tran vdout1_55ck40 FIND v(dout1_55) AT=50.05n

.meas tran vdout1_56ck40 FIND v(dout1_56) AT=50.05n

.meas tran vdout1_57ck40 FIND v(dout1_57) AT=50.05n

.meas tran vdout1_58ck40 FIND v(dout1_58) AT=50.05n

.meas tran vdout1_59ck40 FIND v(dout1_59) AT=50.05n

.meas tran vdout1_60ck40 FIND v(dout1_60) AT=50.05n

.meas tran vdout1_61ck40 FIND v(dout1_61) AT=50.05n

.meas tran vdout1_62ck40 FIND v(dout1_62) AT=50.05n

.meas tran vdout1_63ck40 FIND v(dout1_63) AT=50.05n

.meas tran vdout1_64ck40 FIND v(dout1_64) AT=50.05n

.meas tran vdout1_65ck40 FIND v(dout1_65) AT=50.05n

.meas tran vdout1_66ck40 FIND v(dout1_66) AT=50.05n

.meas tran vdout1_67ck40 FIND v(dout1_67) AT=50.05n

.meas tran vdout1_68ck40 FIND v(dout1_68) AT=50.05n

.meas tran vdout1_69ck40 FIND v(dout1_69) AT=50.05n

.meas tran vdout1_70ck40 FIND v(dout1_70) AT=50.05n

.meas tran vdout1_71ck40 FIND v(dout1_71) AT=50.05n

.meas tran vdout1_72ck40 FIND v(dout1_72) AT=50.05n

.meas tran vdout1_73ck40 FIND v(dout1_73) AT=50.05n

.meas tran vdout1_74ck40 FIND v(dout1_74) AT=50.05n

.meas tran vdout1_75ck40 FIND v(dout1_75) AT=50.05n

.meas tran vdout1_76ck40 FIND v(dout1_76) AT=50.05n

.meas tran vdout1_77ck40 FIND v(dout1_77) AT=50.05n

.meas tran vdout1_78ck40 FIND v(dout1_78) AT=50.05n

.meas tran vdout1_79ck40 FIND v(dout1_79) AT=50.05n

.meas tran vdout1_80ck40 FIND v(dout1_80) AT=50.05n

.meas tran vdout1_81ck40 FIND v(dout1_81) AT=50.05n

.meas tran vdout1_82ck40 FIND v(dout1_82) AT=50.05n

.meas tran vdout1_83ck40 FIND v(dout1_83) AT=50.05n

.meas tran vdout1_84ck40 FIND v(dout1_84) AT=50.05n

.meas tran vdout1_85ck40 FIND v(dout1_85) AT=50.05n

.meas tran vdout1_86ck40 FIND v(dout1_86) AT=50.05n

.meas tran vdout1_87ck40 FIND v(dout1_87) AT=50.05n

.meas tran vdout1_88ck40 FIND v(dout1_88) AT=50.05n

.meas tran vdout1_89ck40 FIND v(dout1_89) AT=50.05n

.meas tran vdout1_90ck40 FIND v(dout1_90) AT=50.05n

.meas tran vdout1_91ck40 FIND v(dout1_91) AT=50.05n

.meas tran vdout1_92ck40 FIND v(dout1_92) AT=50.05n

.meas tran vdout1_93ck40 FIND v(dout1_93) AT=50.05n

.meas tran vdout1_94ck40 FIND v(dout1_94) AT=50.05n

.meas tran vdout1_95ck40 FIND v(dout1_95) AT=50.05n

.meas tran vdout1_96ck40 FIND v(dout1_96) AT=50.05n

.meas tran vdout1_97ck40 FIND v(dout1_97) AT=50.05n

.meas tran vdout1_98ck40 FIND v(dout1_98) AT=50.05n

.meas tran vdout1_99ck40 FIND v(dout1_99) AT=50.05n

.meas tran vdout1_100ck40 FIND v(dout1_100) AT=50.05n

.meas tran vdout1_101ck40 FIND v(dout1_101) AT=50.05n

.meas tran vdout1_102ck40 FIND v(dout1_102) AT=50.05n

.meas tran vdout1_103ck40 FIND v(dout1_103) AT=50.05n

.meas tran vdout1_104ck40 FIND v(dout1_104) AT=50.05n

.meas tran vdout1_105ck40 FIND v(dout1_105) AT=50.05n

.meas tran vdout1_106ck40 FIND v(dout1_106) AT=50.05n

.meas tran vdout1_107ck40 FIND v(dout1_107) AT=50.05n

.meas tran vdout1_108ck40 FIND v(dout1_108) AT=50.05n

.meas tran vdout1_109ck40 FIND v(dout1_109) AT=50.05n

.meas tran vdout1_110ck40 FIND v(dout1_110) AT=50.05n

.meas tran vdout1_111ck40 FIND v(dout1_111) AT=50.05n

.meas tran vdout1_112ck40 FIND v(dout1_112) AT=50.05n

.meas tran vdout1_113ck40 FIND v(dout1_113) AT=50.05n

.meas tran vdout1_114ck40 FIND v(dout1_114) AT=50.05n

.meas tran vdout1_115ck40 FIND v(dout1_115) AT=50.05n

.meas tran vdout1_116ck40 FIND v(dout1_116) AT=50.05n

.meas tran vdout1_117ck40 FIND v(dout1_117) AT=50.05n

.meas tran vdout1_118ck40 FIND v(dout1_118) AT=50.05n

.meas tran vdout1_119ck40 FIND v(dout1_119) AT=50.05n

.meas tran vdout1_120ck40 FIND v(dout1_120) AT=50.05n

.meas tran vdout1_121ck40 FIND v(dout1_121) AT=50.05n

.meas tran vdout1_122ck40 FIND v(dout1_122) AT=50.05n

.meas tran vdout1_123ck40 FIND v(dout1_123) AT=50.05n

.meas tran vdout1_124ck40 FIND v(dout1_124) AT=50.05n

.meas tran vdout1_125ck40 FIND v(dout1_125) AT=50.05n

.meas tran vdout1_126ck40 FIND v(dout1_126) AT=50.05n

.meas tran vdout1_127ck40 FIND v(dout1_127) AT=50.05n

.meas tran vdout1_128ck40 FIND v(dout1_128) AT=50.05n

.meas tran vdout1_129ck40 FIND v(dout1_129) AT=50.05n

.meas tran vdout1_130ck40 FIND v(dout1_130) AT=50.05n

.meas tran vdout1_131ck40 FIND v(dout1_131) AT=50.05n

.meas tran vdout1_132ck40 FIND v(dout1_132) AT=50.05n

.meas tran vdout1_133ck40 FIND v(dout1_133) AT=50.05n

.meas tran vdout1_134ck40 FIND v(dout1_134) AT=50.05n

.meas tran vdout1_135ck40 FIND v(dout1_135) AT=50.05n

.meas tran vdout1_136ck40 FIND v(dout1_136) AT=50.05n

.meas tran vdout1_137ck40 FIND v(dout1_137) AT=50.05n

.meas tran vdout1_138ck40 FIND v(dout1_138) AT=50.05n

.meas tran vdout1_139ck40 FIND v(dout1_139) AT=50.05n

.meas tran vdout1_140ck40 FIND v(dout1_140) AT=50.05n

.meas tran vdout1_141ck40 FIND v(dout1_141) AT=50.05n

.meas tran vdout1_142ck40 FIND v(dout1_142) AT=50.05n

.meas tran vdout1_143ck40 FIND v(dout1_143) AT=50.05n

.meas tran vdout1_144ck40 FIND v(dout1_144) AT=50.05n

.meas tran vdout1_145ck40 FIND v(dout1_145) AT=50.05n

.meas tran vdout1_146ck40 FIND v(dout1_146) AT=50.05n

.meas tran vdout1_147ck40 FIND v(dout1_147) AT=50.05n

.meas tran vdout1_148ck40 FIND v(dout1_148) AT=50.05n

.meas tran vdout1_149ck40 FIND v(dout1_149) AT=50.05n

.meas tran vdout1_150ck40 FIND v(dout1_150) AT=50.05n

.meas tran vdout1_151ck40 FIND v(dout1_151) AT=50.05n

.meas tran vdout1_152ck40 FIND v(dout1_152) AT=50.05n

.meas tran vdout1_153ck40 FIND v(dout1_153) AT=50.05n

.meas tran vdout1_154ck40 FIND v(dout1_154) AT=50.05n

.meas tran vdout1_155ck40 FIND v(dout1_155) AT=50.05n

.meas tran vdout1_156ck40 FIND v(dout1_156) AT=50.05n

.meas tran vdout1_157ck40 FIND v(dout1_157) AT=50.05n

.meas tran vdout1_158ck40 FIND v(dout1_158) AT=50.05n

.meas tran vdout1_159ck40 FIND v(dout1_159) AT=50.05n

.meas tran vdout1_160ck40 FIND v(dout1_160) AT=50.05n

.meas tran vdout1_161ck40 FIND v(dout1_161) AT=50.05n

.meas tran vdout1_162ck40 FIND v(dout1_162) AT=50.05n

.meas tran vdout1_163ck40 FIND v(dout1_163) AT=50.05n

.meas tran vdout1_164ck40 FIND v(dout1_164) AT=50.05n

.meas tran vdout1_165ck40 FIND v(dout1_165) AT=50.05n

.meas tran vdout1_166ck40 FIND v(dout1_166) AT=50.05n

.meas tran vdout1_167ck40 FIND v(dout1_167) AT=50.05n

.meas tran vdout1_168ck40 FIND v(dout1_168) AT=50.05n

.meas tran vdout1_169ck40 FIND v(dout1_169) AT=50.05n

.meas tran vdout1_170ck40 FIND v(dout1_170) AT=50.05n

.meas tran vdout1_171ck40 FIND v(dout1_171) AT=50.05n

.meas tran vdout1_172ck40 FIND v(dout1_172) AT=50.05n

.meas tran vdout1_173ck40 FIND v(dout1_173) AT=50.05n

.meas tran vdout1_174ck40 FIND v(dout1_174) AT=50.05n

.meas tran vdout1_175ck40 FIND v(dout1_175) AT=50.05n

.meas tran vdout1_176ck40 FIND v(dout1_176) AT=50.05n

.meas tran vdout1_177ck40 FIND v(dout1_177) AT=50.05n

.meas tran vdout1_178ck40 FIND v(dout1_178) AT=50.05n

.meas tran vdout1_179ck40 FIND v(dout1_179) AT=50.05n

.meas tran vdout1_180ck40 FIND v(dout1_180) AT=50.05n

.meas tran vdout1_181ck40 FIND v(dout1_181) AT=50.05n

.meas tran vdout1_182ck40 FIND v(dout1_182) AT=50.05n

.meas tran vdout1_183ck40 FIND v(dout1_183) AT=50.05n

.meas tran vdout1_184ck40 FIND v(dout1_184) AT=50.05n

.meas tran vdout1_185ck40 FIND v(dout1_185) AT=50.05n

.meas tran vdout1_186ck40 FIND v(dout1_186) AT=50.05n

.meas tran vdout1_187ck40 FIND v(dout1_187) AT=50.05n

.meas tran vdout1_188ck40 FIND v(dout1_188) AT=50.05n

.meas tran vdout1_189ck40 FIND v(dout1_189) AT=50.05n

.meas tran vdout1_190ck40 FIND v(dout1_190) AT=50.05n

.meas tran vdout1_191ck40 FIND v(dout1_191) AT=50.05n

.meas tran vdout1_192ck40 FIND v(dout1_192) AT=50.05n

.meas tran vdout1_193ck40 FIND v(dout1_193) AT=50.05n

.meas tran vdout1_194ck40 FIND v(dout1_194) AT=50.05n

.meas tran vdout1_195ck40 FIND v(dout1_195) AT=50.05n

.meas tran vdout1_196ck40 FIND v(dout1_196) AT=50.05n

.meas tran vdout1_197ck40 FIND v(dout1_197) AT=50.05n

.meas tran vdout1_198ck40 FIND v(dout1_198) AT=50.05n

.meas tran vdout1_199ck40 FIND v(dout1_199) AT=50.05n

.meas tran vdout1_200ck40 FIND v(dout1_200) AT=50.05n

.meas tran vdout1_201ck40 FIND v(dout1_201) AT=50.05n

.meas tran vdout1_202ck40 FIND v(dout1_202) AT=50.05n

.meas tran vdout1_203ck40 FIND v(dout1_203) AT=50.05n

.meas tran vdout1_204ck40 FIND v(dout1_204) AT=50.05n

.meas tran vdout1_205ck40 FIND v(dout1_205) AT=50.05n

.meas tran vdout1_206ck40 FIND v(dout1_206) AT=50.05n

.meas tran vdout1_207ck40 FIND v(dout1_207) AT=50.05n

.meas tran vdout1_208ck40 FIND v(dout1_208) AT=50.05n

.meas tran vdout1_209ck40 FIND v(dout1_209) AT=50.05n

.meas tran vdout1_210ck40 FIND v(dout1_210) AT=50.05n

.meas tran vdout1_211ck40 FIND v(dout1_211) AT=50.05n

.meas tran vdout1_212ck40 FIND v(dout1_212) AT=50.05n

.meas tran vdout1_213ck40 FIND v(dout1_213) AT=50.05n

.meas tran vdout1_214ck40 FIND v(dout1_214) AT=50.05n

.meas tran vdout1_215ck40 FIND v(dout1_215) AT=50.05n

.meas tran vdout1_216ck40 FIND v(dout1_216) AT=50.05n

.meas tran vdout1_217ck40 FIND v(dout1_217) AT=50.05n

.meas tran vdout1_218ck40 FIND v(dout1_218) AT=50.05n

.meas tran vdout1_219ck40 FIND v(dout1_219) AT=50.05n

.meas tran vdout1_220ck40 FIND v(dout1_220) AT=50.05n

.meas tran vdout1_221ck40 FIND v(dout1_221) AT=50.05n

.meas tran vdout1_222ck40 FIND v(dout1_222) AT=50.05n

.meas tran vdout1_223ck40 FIND v(dout1_223) AT=50.05n

.meas tran vdout1_224ck40 FIND v(dout1_224) AT=50.05n

.meas tran vdout1_225ck40 FIND v(dout1_225) AT=50.05n

.meas tran vdout1_226ck40 FIND v(dout1_226) AT=50.05n

.meas tran vdout1_227ck40 FIND v(dout1_227) AT=50.05n

.meas tran vdout1_228ck40 FIND v(dout1_228) AT=50.05n

.meas tran vdout1_229ck40 FIND v(dout1_229) AT=50.05n

.meas tran vdout1_230ck40 FIND v(dout1_230) AT=50.05n

.meas tran vdout1_231ck40 FIND v(dout1_231) AT=50.05n

.meas tran vdout1_232ck40 FIND v(dout1_232) AT=50.05n

.meas tran vdout1_233ck40 FIND v(dout1_233) AT=50.05n

.meas tran vdout1_234ck40 FIND v(dout1_234) AT=50.05n

.meas tran vdout1_235ck40 FIND v(dout1_235) AT=50.05n

.meas tran vdout1_236ck40 FIND v(dout1_236) AT=50.05n

.meas tran vdout1_237ck40 FIND v(dout1_237) AT=50.05n

.meas tran vdout1_238ck40 FIND v(dout1_238) AT=50.05n

.meas tran vdout1_239ck40 FIND v(dout1_239) AT=50.05n

.meas tran vdout1_240ck40 FIND v(dout1_240) AT=50.05n

.meas tran vdout1_241ck40 FIND v(dout1_241) AT=50.05n

.meas tran vdout1_242ck40 FIND v(dout1_242) AT=50.05n

.meas tran vdout1_243ck40 FIND v(dout1_243) AT=50.05n

.meas tran vdout1_244ck40 FIND v(dout1_244) AT=50.05n

.meas tran vdout1_245ck40 FIND v(dout1_245) AT=50.05n

.meas tran vdout1_246ck40 FIND v(dout1_246) AT=50.05n

.meas tran vdout1_247ck40 FIND v(dout1_247) AT=50.05n

.meas tran vdout1_248ck40 FIND v(dout1_248) AT=50.05n

.meas tran vdout1_249ck40 FIND v(dout1_249) AT=50.05n

.meas tran vdout1_250ck40 FIND v(dout1_250) AT=50.05n

.meas tran vdout1_251ck40 FIND v(dout1_251) AT=50.05n

.meas tran vdout1_252ck40 FIND v(dout1_252) AT=50.05n

.meas tran vdout1_253ck40 FIND v(dout1_253) AT=50.05n

.meas tran vdout1_254ck40 FIND v(dout1_254) AT=50.05n

.meas tran vdout1_255ck40 FIND v(dout1_255) AT=50.05n

.meas tran vdout1_256ck40 FIND v(dout1_256) AT=50.05n

.meas tran vdout1_0ck50 FIND v(dout1_0) AT=60.05n

.meas tran vdout1_1ck50 FIND v(dout1_1) AT=60.05n

.meas tran vdout1_2ck50 FIND v(dout1_2) AT=60.05n

.meas tran vdout1_3ck50 FIND v(dout1_3) AT=60.05n

.meas tran vdout1_4ck50 FIND v(dout1_4) AT=60.05n

.meas tran vdout1_5ck50 FIND v(dout1_5) AT=60.05n

.meas tran vdout1_6ck50 FIND v(dout1_6) AT=60.05n

.meas tran vdout1_7ck50 FIND v(dout1_7) AT=60.05n

.meas tran vdout1_8ck50 FIND v(dout1_8) AT=60.05n

.meas tran vdout1_9ck50 FIND v(dout1_9) AT=60.05n

.meas tran vdout1_10ck50 FIND v(dout1_10) AT=60.05n

.meas tran vdout1_11ck50 FIND v(dout1_11) AT=60.05n

.meas tran vdout1_12ck50 FIND v(dout1_12) AT=60.05n

.meas tran vdout1_13ck50 FIND v(dout1_13) AT=60.05n

.meas tran vdout1_14ck50 FIND v(dout1_14) AT=60.05n

.meas tran vdout1_15ck50 FIND v(dout1_15) AT=60.05n

.meas tran vdout1_16ck50 FIND v(dout1_16) AT=60.05n

.meas tran vdout1_17ck50 FIND v(dout1_17) AT=60.05n

.meas tran vdout1_18ck50 FIND v(dout1_18) AT=60.05n

.meas tran vdout1_19ck50 FIND v(dout1_19) AT=60.05n

.meas tran vdout1_20ck50 FIND v(dout1_20) AT=60.05n

.meas tran vdout1_21ck50 FIND v(dout1_21) AT=60.05n

.meas tran vdout1_22ck50 FIND v(dout1_22) AT=60.05n

.meas tran vdout1_23ck50 FIND v(dout1_23) AT=60.05n

.meas tran vdout1_24ck50 FIND v(dout1_24) AT=60.05n

.meas tran vdout1_25ck50 FIND v(dout1_25) AT=60.05n

.meas tran vdout1_26ck50 FIND v(dout1_26) AT=60.05n

.meas tran vdout1_27ck50 FIND v(dout1_27) AT=60.05n

.meas tran vdout1_28ck50 FIND v(dout1_28) AT=60.05n

.meas tran vdout1_29ck50 FIND v(dout1_29) AT=60.05n

.meas tran vdout1_30ck50 FIND v(dout1_30) AT=60.05n

.meas tran vdout1_31ck50 FIND v(dout1_31) AT=60.05n

.meas tran vdout1_32ck50 FIND v(dout1_32) AT=60.05n

.meas tran vdout1_33ck50 FIND v(dout1_33) AT=60.05n

.meas tran vdout1_34ck50 FIND v(dout1_34) AT=60.05n

.meas tran vdout1_35ck50 FIND v(dout1_35) AT=60.05n

.meas tran vdout1_36ck50 FIND v(dout1_36) AT=60.05n

.meas tran vdout1_37ck50 FIND v(dout1_37) AT=60.05n

.meas tran vdout1_38ck50 FIND v(dout1_38) AT=60.05n

.meas tran vdout1_39ck50 FIND v(dout1_39) AT=60.05n

.meas tran vdout1_40ck50 FIND v(dout1_40) AT=60.05n

.meas tran vdout1_41ck50 FIND v(dout1_41) AT=60.05n

.meas tran vdout1_42ck50 FIND v(dout1_42) AT=60.05n

.meas tran vdout1_43ck50 FIND v(dout1_43) AT=60.05n

.meas tran vdout1_44ck50 FIND v(dout1_44) AT=60.05n

.meas tran vdout1_45ck50 FIND v(dout1_45) AT=60.05n

.meas tran vdout1_46ck50 FIND v(dout1_46) AT=60.05n

.meas tran vdout1_47ck50 FIND v(dout1_47) AT=60.05n

.meas tran vdout1_48ck50 FIND v(dout1_48) AT=60.05n

.meas tran vdout1_49ck50 FIND v(dout1_49) AT=60.05n

.meas tran vdout1_50ck50 FIND v(dout1_50) AT=60.05n

.meas tran vdout1_51ck50 FIND v(dout1_51) AT=60.05n

.meas tran vdout1_52ck50 FIND v(dout1_52) AT=60.05n

.meas tran vdout1_53ck50 FIND v(dout1_53) AT=60.05n

.meas tran vdout1_54ck50 FIND v(dout1_54) AT=60.05n

.meas tran vdout1_55ck50 FIND v(dout1_55) AT=60.05n

.meas tran vdout1_56ck50 FIND v(dout1_56) AT=60.05n

.meas tran vdout1_57ck50 FIND v(dout1_57) AT=60.05n

.meas tran vdout1_58ck50 FIND v(dout1_58) AT=60.05n

.meas tran vdout1_59ck50 FIND v(dout1_59) AT=60.05n

.meas tran vdout1_60ck50 FIND v(dout1_60) AT=60.05n

.meas tran vdout1_61ck50 FIND v(dout1_61) AT=60.05n

.meas tran vdout1_62ck50 FIND v(dout1_62) AT=60.05n

.meas tran vdout1_63ck50 FIND v(dout1_63) AT=60.05n

.meas tran vdout1_64ck50 FIND v(dout1_64) AT=60.05n

.meas tran vdout1_65ck50 FIND v(dout1_65) AT=60.05n

.meas tran vdout1_66ck50 FIND v(dout1_66) AT=60.05n

.meas tran vdout1_67ck50 FIND v(dout1_67) AT=60.05n

.meas tran vdout1_68ck50 FIND v(dout1_68) AT=60.05n

.meas tran vdout1_69ck50 FIND v(dout1_69) AT=60.05n

.meas tran vdout1_70ck50 FIND v(dout1_70) AT=60.05n

.meas tran vdout1_71ck50 FIND v(dout1_71) AT=60.05n

.meas tran vdout1_72ck50 FIND v(dout1_72) AT=60.05n

.meas tran vdout1_73ck50 FIND v(dout1_73) AT=60.05n

.meas tran vdout1_74ck50 FIND v(dout1_74) AT=60.05n

.meas tran vdout1_75ck50 FIND v(dout1_75) AT=60.05n

.meas tran vdout1_76ck50 FIND v(dout1_76) AT=60.05n

.meas tran vdout1_77ck50 FIND v(dout1_77) AT=60.05n

.meas tran vdout1_78ck50 FIND v(dout1_78) AT=60.05n

.meas tran vdout1_79ck50 FIND v(dout1_79) AT=60.05n

.meas tran vdout1_80ck50 FIND v(dout1_80) AT=60.05n

.meas tran vdout1_81ck50 FIND v(dout1_81) AT=60.05n

.meas tran vdout1_82ck50 FIND v(dout1_82) AT=60.05n

.meas tran vdout1_83ck50 FIND v(dout1_83) AT=60.05n

.meas tran vdout1_84ck50 FIND v(dout1_84) AT=60.05n

.meas tran vdout1_85ck50 FIND v(dout1_85) AT=60.05n

.meas tran vdout1_86ck50 FIND v(dout1_86) AT=60.05n

.meas tran vdout1_87ck50 FIND v(dout1_87) AT=60.05n

.meas tran vdout1_88ck50 FIND v(dout1_88) AT=60.05n

.meas tran vdout1_89ck50 FIND v(dout1_89) AT=60.05n

.meas tran vdout1_90ck50 FIND v(dout1_90) AT=60.05n

.meas tran vdout1_91ck50 FIND v(dout1_91) AT=60.05n

.meas tran vdout1_92ck50 FIND v(dout1_92) AT=60.05n

.meas tran vdout1_93ck50 FIND v(dout1_93) AT=60.05n

.meas tran vdout1_94ck50 FIND v(dout1_94) AT=60.05n

.meas tran vdout1_95ck50 FIND v(dout1_95) AT=60.05n

.meas tran vdout1_96ck50 FIND v(dout1_96) AT=60.05n

.meas tran vdout1_97ck50 FIND v(dout1_97) AT=60.05n

.meas tran vdout1_98ck50 FIND v(dout1_98) AT=60.05n

.meas tran vdout1_99ck50 FIND v(dout1_99) AT=60.05n

.meas tran vdout1_100ck50 FIND v(dout1_100) AT=60.05n

.meas tran vdout1_101ck50 FIND v(dout1_101) AT=60.05n

.meas tran vdout1_102ck50 FIND v(dout1_102) AT=60.05n

.meas tran vdout1_103ck50 FIND v(dout1_103) AT=60.05n

.meas tran vdout1_104ck50 FIND v(dout1_104) AT=60.05n

.meas tran vdout1_105ck50 FIND v(dout1_105) AT=60.05n

.meas tran vdout1_106ck50 FIND v(dout1_106) AT=60.05n

.meas tran vdout1_107ck50 FIND v(dout1_107) AT=60.05n

.meas tran vdout1_108ck50 FIND v(dout1_108) AT=60.05n

.meas tran vdout1_109ck50 FIND v(dout1_109) AT=60.05n

.meas tran vdout1_110ck50 FIND v(dout1_110) AT=60.05n

.meas tran vdout1_111ck50 FIND v(dout1_111) AT=60.05n

.meas tran vdout1_112ck50 FIND v(dout1_112) AT=60.05n

.meas tran vdout1_113ck50 FIND v(dout1_113) AT=60.05n

.meas tran vdout1_114ck50 FIND v(dout1_114) AT=60.05n

.meas tran vdout1_115ck50 FIND v(dout1_115) AT=60.05n

.meas tran vdout1_116ck50 FIND v(dout1_116) AT=60.05n

.meas tran vdout1_117ck50 FIND v(dout1_117) AT=60.05n

.meas tran vdout1_118ck50 FIND v(dout1_118) AT=60.05n

.meas tran vdout1_119ck50 FIND v(dout1_119) AT=60.05n

.meas tran vdout1_120ck50 FIND v(dout1_120) AT=60.05n

.meas tran vdout1_121ck50 FIND v(dout1_121) AT=60.05n

.meas tran vdout1_122ck50 FIND v(dout1_122) AT=60.05n

.meas tran vdout1_123ck50 FIND v(dout1_123) AT=60.05n

.meas tran vdout1_124ck50 FIND v(dout1_124) AT=60.05n

.meas tran vdout1_125ck50 FIND v(dout1_125) AT=60.05n

.meas tran vdout1_126ck50 FIND v(dout1_126) AT=60.05n

.meas tran vdout1_127ck50 FIND v(dout1_127) AT=60.05n

.meas tran vdout1_128ck50 FIND v(dout1_128) AT=60.05n

.meas tran vdout1_129ck50 FIND v(dout1_129) AT=60.05n

.meas tran vdout1_130ck50 FIND v(dout1_130) AT=60.05n

.meas tran vdout1_131ck50 FIND v(dout1_131) AT=60.05n

.meas tran vdout1_132ck50 FIND v(dout1_132) AT=60.05n

.meas tran vdout1_133ck50 FIND v(dout1_133) AT=60.05n

.meas tran vdout1_134ck50 FIND v(dout1_134) AT=60.05n

.meas tran vdout1_135ck50 FIND v(dout1_135) AT=60.05n

.meas tran vdout1_136ck50 FIND v(dout1_136) AT=60.05n

.meas tran vdout1_137ck50 FIND v(dout1_137) AT=60.05n

.meas tran vdout1_138ck50 FIND v(dout1_138) AT=60.05n

.meas tran vdout1_139ck50 FIND v(dout1_139) AT=60.05n

.meas tran vdout1_140ck50 FIND v(dout1_140) AT=60.05n

.meas tran vdout1_141ck50 FIND v(dout1_141) AT=60.05n

.meas tran vdout1_142ck50 FIND v(dout1_142) AT=60.05n

.meas tran vdout1_143ck50 FIND v(dout1_143) AT=60.05n

.meas tran vdout1_144ck50 FIND v(dout1_144) AT=60.05n

.meas tran vdout1_145ck50 FIND v(dout1_145) AT=60.05n

.meas tran vdout1_146ck50 FIND v(dout1_146) AT=60.05n

.meas tran vdout1_147ck50 FIND v(dout1_147) AT=60.05n

.meas tran vdout1_148ck50 FIND v(dout1_148) AT=60.05n

.meas tran vdout1_149ck50 FIND v(dout1_149) AT=60.05n

.meas tran vdout1_150ck50 FIND v(dout1_150) AT=60.05n

.meas tran vdout1_151ck50 FIND v(dout1_151) AT=60.05n

.meas tran vdout1_152ck50 FIND v(dout1_152) AT=60.05n

.meas tran vdout1_153ck50 FIND v(dout1_153) AT=60.05n

.meas tran vdout1_154ck50 FIND v(dout1_154) AT=60.05n

.meas tran vdout1_155ck50 FIND v(dout1_155) AT=60.05n

.meas tran vdout1_156ck50 FIND v(dout1_156) AT=60.05n

.meas tran vdout1_157ck50 FIND v(dout1_157) AT=60.05n

.meas tran vdout1_158ck50 FIND v(dout1_158) AT=60.05n

.meas tran vdout1_159ck50 FIND v(dout1_159) AT=60.05n

.meas tran vdout1_160ck50 FIND v(dout1_160) AT=60.05n

.meas tran vdout1_161ck50 FIND v(dout1_161) AT=60.05n

.meas tran vdout1_162ck50 FIND v(dout1_162) AT=60.05n

.meas tran vdout1_163ck50 FIND v(dout1_163) AT=60.05n

.meas tran vdout1_164ck50 FIND v(dout1_164) AT=60.05n

.meas tran vdout1_165ck50 FIND v(dout1_165) AT=60.05n

.meas tran vdout1_166ck50 FIND v(dout1_166) AT=60.05n

.meas tran vdout1_167ck50 FIND v(dout1_167) AT=60.05n

.meas tran vdout1_168ck50 FIND v(dout1_168) AT=60.05n

.meas tran vdout1_169ck50 FIND v(dout1_169) AT=60.05n

.meas tran vdout1_170ck50 FIND v(dout1_170) AT=60.05n

.meas tran vdout1_171ck50 FIND v(dout1_171) AT=60.05n

.meas tran vdout1_172ck50 FIND v(dout1_172) AT=60.05n

.meas tran vdout1_173ck50 FIND v(dout1_173) AT=60.05n

.meas tran vdout1_174ck50 FIND v(dout1_174) AT=60.05n

.meas tran vdout1_175ck50 FIND v(dout1_175) AT=60.05n

.meas tran vdout1_176ck50 FIND v(dout1_176) AT=60.05n

.meas tran vdout1_177ck50 FIND v(dout1_177) AT=60.05n

.meas tran vdout1_178ck50 FIND v(dout1_178) AT=60.05n

.meas tran vdout1_179ck50 FIND v(dout1_179) AT=60.05n

.meas tran vdout1_180ck50 FIND v(dout1_180) AT=60.05n

.meas tran vdout1_181ck50 FIND v(dout1_181) AT=60.05n

.meas tran vdout1_182ck50 FIND v(dout1_182) AT=60.05n

.meas tran vdout1_183ck50 FIND v(dout1_183) AT=60.05n

.meas tran vdout1_184ck50 FIND v(dout1_184) AT=60.05n

.meas tran vdout1_185ck50 FIND v(dout1_185) AT=60.05n

.meas tran vdout1_186ck50 FIND v(dout1_186) AT=60.05n

.meas tran vdout1_187ck50 FIND v(dout1_187) AT=60.05n

.meas tran vdout1_188ck50 FIND v(dout1_188) AT=60.05n

.meas tran vdout1_189ck50 FIND v(dout1_189) AT=60.05n

.meas tran vdout1_190ck50 FIND v(dout1_190) AT=60.05n

.meas tran vdout1_191ck50 FIND v(dout1_191) AT=60.05n

.meas tran vdout1_192ck50 FIND v(dout1_192) AT=60.05n

.meas tran vdout1_193ck50 FIND v(dout1_193) AT=60.05n

.meas tran vdout1_194ck50 FIND v(dout1_194) AT=60.05n

.meas tran vdout1_195ck50 FIND v(dout1_195) AT=60.05n

.meas tran vdout1_196ck50 FIND v(dout1_196) AT=60.05n

.meas tran vdout1_197ck50 FIND v(dout1_197) AT=60.05n

.meas tran vdout1_198ck50 FIND v(dout1_198) AT=60.05n

.meas tran vdout1_199ck50 FIND v(dout1_199) AT=60.05n

.meas tran vdout1_200ck50 FIND v(dout1_200) AT=60.05n

.meas tran vdout1_201ck50 FIND v(dout1_201) AT=60.05n

.meas tran vdout1_202ck50 FIND v(dout1_202) AT=60.05n

.meas tran vdout1_203ck50 FIND v(dout1_203) AT=60.05n

.meas tran vdout1_204ck50 FIND v(dout1_204) AT=60.05n

.meas tran vdout1_205ck50 FIND v(dout1_205) AT=60.05n

.meas tran vdout1_206ck50 FIND v(dout1_206) AT=60.05n

.meas tran vdout1_207ck50 FIND v(dout1_207) AT=60.05n

.meas tran vdout1_208ck50 FIND v(dout1_208) AT=60.05n

.meas tran vdout1_209ck50 FIND v(dout1_209) AT=60.05n

.meas tran vdout1_210ck50 FIND v(dout1_210) AT=60.05n

.meas tran vdout1_211ck50 FIND v(dout1_211) AT=60.05n

.meas tran vdout1_212ck50 FIND v(dout1_212) AT=60.05n

.meas tran vdout1_213ck50 FIND v(dout1_213) AT=60.05n

.meas tran vdout1_214ck50 FIND v(dout1_214) AT=60.05n

.meas tran vdout1_215ck50 FIND v(dout1_215) AT=60.05n

.meas tran vdout1_216ck50 FIND v(dout1_216) AT=60.05n

.meas tran vdout1_217ck50 FIND v(dout1_217) AT=60.05n

.meas tran vdout1_218ck50 FIND v(dout1_218) AT=60.05n

.meas tran vdout1_219ck50 FIND v(dout1_219) AT=60.05n

.meas tran vdout1_220ck50 FIND v(dout1_220) AT=60.05n

.meas tran vdout1_221ck50 FIND v(dout1_221) AT=60.05n

.meas tran vdout1_222ck50 FIND v(dout1_222) AT=60.05n

.meas tran vdout1_223ck50 FIND v(dout1_223) AT=60.05n

.meas tran vdout1_224ck50 FIND v(dout1_224) AT=60.05n

.meas tran vdout1_225ck50 FIND v(dout1_225) AT=60.05n

.meas tran vdout1_226ck50 FIND v(dout1_226) AT=60.05n

.meas tran vdout1_227ck50 FIND v(dout1_227) AT=60.05n

.meas tran vdout1_228ck50 FIND v(dout1_228) AT=60.05n

.meas tran vdout1_229ck50 FIND v(dout1_229) AT=60.05n

.meas tran vdout1_230ck50 FIND v(dout1_230) AT=60.05n

.meas tran vdout1_231ck50 FIND v(dout1_231) AT=60.05n

.meas tran vdout1_232ck50 FIND v(dout1_232) AT=60.05n

.meas tran vdout1_233ck50 FIND v(dout1_233) AT=60.05n

.meas tran vdout1_234ck50 FIND v(dout1_234) AT=60.05n

.meas tran vdout1_235ck50 FIND v(dout1_235) AT=60.05n

.meas tran vdout1_236ck50 FIND v(dout1_236) AT=60.05n

.meas tran vdout1_237ck50 FIND v(dout1_237) AT=60.05n

.meas tran vdout1_238ck50 FIND v(dout1_238) AT=60.05n

.meas tran vdout1_239ck50 FIND v(dout1_239) AT=60.05n

.meas tran vdout1_240ck50 FIND v(dout1_240) AT=60.05n

.meas tran vdout1_241ck50 FIND v(dout1_241) AT=60.05n

.meas tran vdout1_242ck50 FIND v(dout1_242) AT=60.05n

.meas tran vdout1_243ck50 FIND v(dout1_243) AT=60.05n

.meas tran vdout1_244ck50 FIND v(dout1_244) AT=60.05n

.meas tran vdout1_245ck50 FIND v(dout1_245) AT=60.05n

.meas tran vdout1_246ck50 FIND v(dout1_246) AT=60.05n

.meas tran vdout1_247ck50 FIND v(dout1_247) AT=60.05n

.meas tran vdout1_248ck50 FIND v(dout1_248) AT=60.05n

.meas tran vdout1_249ck50 FIND v(dout1_249) AT=60.05n

.meas tran vdout1_250ck50 FIND v(dout1_250) AT=60.05n

.meas tran vdout1_251ck50 FIND v(dout1_251) AT=60.05n

.meas tran vdout1_252ck50 FIND v(dout1_252) AT=60.05n

.meas tran vdout1_253ck50 FIND v(dout1_253) AT=60.05n

.meas tran vdout1_254ck50 FIND v(dout1_254) AT=60.05n

.meas tran vdout1_255ck50 FIND v(dout1_255) AT=60.05n

.meas tran vdout1_256ck50 FIND v(dout1_256) AT=60.05n

.meas tran vdout1_0ck80 FIND v(dout1_0) AT=90.05n

.meas tran vdout1_1ck80 FIND v(dout1_1) AT=90.05n

.meas tran vdout1_2ck80 FIND v(dout1_2) AT=90.05n

.meas tran vdout1_3ck80 FIND v(dout1_3) AT=90.05n

.meas tran vdout1_4ck80 FIND v(dout1_4) AT=90.05n

.meas tran vdout1_5ck80 FIND v(dout1_5) AT=90.05n

.meas tran vdout1_6ck80 FIND v(dout1_6) AT=90.05n

.meas tran vdout1_7ck80 FIND v(dout1_7) AT=90.05n

.meas tran vdout1_8ck80 FIND v(dout1_8) AT=90.05n

.meas tran vdout1_9ck80 FIND v(dout1_9) AT=90.05n

.meas tran vdout1_10ck80 FIND v(dout1_10) AT=90.05n

.meas tran vdout1_11ck80 FIND v(dout1_11) AT=90.05n

.meas tran vdout1_12ck80 FIND v(dout1_12) AT=90.05n

.meas tran vdout1_13ck80 FIND v(dout1_13) AT=90.05n

.meas tran vdout1_14ck80 FIND v(dout1_14) AT=90.05n

.meas tran vdout1_15ck80 FIND v(dout1_15) AT=90.05n

.meas tran vdout1_16ck80 FIND v(dout1_16) AT=90.05n

.meas tran vdout1_17ck80 FIND v(dout1_17) AT=90.05n

.meas tran vdout1_18ck80 FIND v(dout1_18) AT=90.05n

.meas tran vdout1_19ck80 FIND v(dout1_19) AT=90.05n

.meas tran vdout1_20ck80 FIND v(dout1_20) AT=90.05n

.meas tran vdout1_21ck80 FIND v(dout1_21) AT=90.05n

.meas tran vdout1_22ck80 FIND v(dout1_22) AT=90.05n

.meas tran vdout1_23ck80 FIND v(dout1_23) AT=90.05n

.meas tran vdout1_24ck80 FIND v(dout1_24) AT=90.05n

.meas tran vdout1_25ck80 FIND v(dout1_25) AT=90.05n

.meas tran vdout1_26ck80 FIND v(dout1_26) AT=90.05n

.meas tran vdout1_27ck80 FIND v(dout1_27) AT=90.05n

.meas tran vdout1_28ck80 FIND v(dout1_28) AT=90.05n

.meas tran vdout1_29ck80 FIND v(dout1_29) AT=90.05n

.meas tran vdout1_30ck80 FIND v(dout1_30) AT=90.05n

.meas tran vdout1_31ck80 FIND v(dout1_31) AT=90.05n

.meas tran vdout1_32ck80 FIND v(dout1_32) AT=90.05n

.meas tran vdout1_33ck80 FIND v(dout1_33) AT=90.05n

.meas tran vdout1_34ck80 FIND v(dout1_34) AT=90.05n

.meas tran vdout1_35ck80 FIND v(dout1_35) AT=90.05n

.meas tran vdout1_36ck80 FIND v(dout1_36) AT=90.05n

.meas tran vdout1_37ck80 FIND v(dout1_37) AT=90.05n

.meas tran vdout1_38ck80 FIND v(dout1_38) AT=90.05n

.meas tran vdout1_39ck80 FIND v(dout1_39) AT=90.05n

.meas tran vdout1_40ck80 FIND v(dout1_40) AT=90.05n

.meas tran vdout1_41ck80 FIND v(dout1_41) AT=90.05n

.meas tran vdout1_42ck80 FIND v(dout1_42) AT=90.05n

.meas tran vdout1_43ck80 FIND v(dout1_43) AT=90.05n

.meas tran vdout1_44ck80 FIND v(dout1_44) AT=90.05n

.meas tran vdout1_45ck80 FIND v(dout1_45) AT=90.05n

.meas tran vdout1_46ck80 FIND v(dout1_46) AT=90.05n

.meas tran vdout1_47ck80 FIND v(dout1_47) AT=90.05n

.meas tran vdout1_48ck80 FIND v(dout1_48) AT=90.05n

.meas tran vdout1_49ck80 FIND v(dout1_49) AT=90.05n

.meas tran vdout1_50ck80 FIND v(dout1_50) AT=90.05n

.meas tran vdout1_51ck80 FIND v(dout1_51) AT=90.05n

.meas tran vdout1_52ck80 FIND v(dout1_52) AT=90.05n

.meas tran vdout1_53ck80 FIND v(dout1_53) AT=90.05n

.meas tran vdout1_54ck80 FIND v(dout1_54) AT=90.05n

.meas tran vdout1_55ck80 FIND v(dout1_55) AT=90.05n

.meas tran vdout1_56ck80 FIND v(dout1_56) AT=90.05n

.meas tran vdout1_57ck80 FIND v(dout1_57) AT=90.05n

.meas tran vdout1_58ck80 FIND v(dout1_58) AT=90.05n

.meas tran vdout1_59ck80 FIND v(dout1_59) AT=90.05n

.meas tran vdout1_60ck80 FIND v(dout1_60) AT=90.05n

.meas tran vdout1_61ck80 FIND v(dout1_61) AT=90.05n

.meas tran vdout1_62ck80 FIND v(dout1_62) AT=90.05n

.meas tran vdout1_63ck80 FIND v(dout1_63) AT=90.05n

.meas tran vdout1_64ck80 FIND v(dout1_64) AT=90.05n

.meas tran vdout1_65ck80 FIND v(dout1_65) AT=90.05n

.meas tran vdout1_66ck80 FIND v(dout1_66) AT=90.05n

.meas tran vdout1_67ck80 FIND v(dout1_67) AT=90.05n

.meas tran vdout1_68ck80 FIND v(dout1_68) AT=90.05n

.meas tran vdout1_69ck80 FIND v(dout1_69) AT=90.05n

.meas tran vdout1_70ck80 FIND v(dout1_70) AT=90.05n

.meas tran vdout1_71ck80 FIND v(dout1_71) AT=90.05n

.meas tran vdout1_72ck80 FIND v(dout1_72) AT=90.05n

.meas tran vdout1_73ck80 FIND v(dout1_73) AT=90.05n

.meas tran vdout1_74ck80 FIND v(dout1_74) AT=90.05n

.meas tran vdout1_75ck80 FIND v(dout1_75) AT=90.05n

.meas tran vdout1_76ck80 FIND v(dout1_76) AT=90.05n

.meas tran vdout1_77ck80 FIND v(dout1_77) AT=90.05n

.meas tran vdout1_78ck80 FIND v(dout1_78) AT=90.05n

.meas tran vdout1_79ck80 FIND v(dout1_79) AT=90.05n

.meas tran vdout1_80ck80 FIND v(dout1_80) AT=90.05n

.meas tran vdout1_81ck80 FIND v(dout1_81) AT=90.05n

.meas tran vdout1_82ck80 FIND v(dout1_82) AT=90.05n

.meas tran vdout1_83ck80 FIND v(dout1_83) AT=90.05n

.meas tran vdout1_84ck80 FIND v(dout1_84) AT=90.05n

.meas tran vdout1_85ck80 FIND v(dout1_85) AT=90.05n

.meas tran vdout1_86ck80 FIND v(dout1_86) AT=90.05n

.meas tran vdout1_87ck80 FIND v(dout1_87) AT=90.05n

.meas tran vdout1_88ck80 FIND v(dout1_88) AT=90.05n

.meas tran vdout1_89ck80 FIND v(dout1_89) AT=90.05n

.meas tran vdout1_90ck80 FIND v(dout1_90) AT=90.05n

.meas tran vdout1_91ck80 FIND v(dout1_91) AT=90.05n

.meas tran vdout1_92ck80 FIND v(dout1_92) AT=90.05n

.meas tran vdout1_93ck80 FIND v(dout1_93) AT=90.05n

.meas tran vdout1_94ck80 FIND v(dout1_94) AT=90.05n

.meas tran vdout1_95ck80 FIND v(dout1_95) AT=90.05n

.meas tran vdout1_96ck80 FIND v(dout1_96) AT=90.05n

.meas tran vdout1_97ck80 FIND v(dout1_97) AT=90.05n

.meas tran vdout1_98ck80 FIND v(dout1_98) AT=90.05n

.meas tran vdout1_99ck80 FIND v(dout1_99) AT=90.05n

.meas tran vdout1_100ck80 FIND v(dout1_100) AT=90.05n

.meas tran vdout1_101ck80 FIND v(dout1_101) AT=90.05n

.meas tran vdout1_102ck80 FIND v(dout1_102) AT=90.05n

.meas tran vdout1_103ck80 FIND v(dout1_103) AT=90.05n

.meas tran vdout1_104ck80 FIND v(dout1_104) AT=90.05n

.meas tran vdout1_105ck80 FIND v(dout1_105) AT=90.05n

.meas tran vdout1_106ck80 FIND v(dout1_106) AT=90.05n

.meas tran vdout1_107ck80 FIND v(dout1_107) AT=90.05n

.meas tran vdout1_108ck80 FIND v(dout1_108) AT=90.05n

.meas tran vdout1_109ck80 FIND v(dout1_109) AT=90.05n

.meas tran vdout1_110ck80 FIND v(dout1_110) AT=90.05n

.meas tran vdout1_111ck80 FIND v(dout1_111) AT=90.05n

.meas tran vdout1_112ck80 FIND v(dout1_112) AT=90.05n

.meas tran vdout1_113ck80 FIND v(dout1_113) AT=90.05n

.meas tran vdout1_114ck80 FIND v(dout1_114) AT=90.05n

.meas tran vdout1_115ck80 FIND v(dout1_115) AT=90.05n

.meas tran vdout1_116ck80 FIND v(dout1_116) AT=90.05n

.meas tran vdout1_117ck80 FIND v(dout1_117) AT=90.05n

.meas tran vdout1_118ck80 FIND v(dout1_118) AT=90.05n

.meas tran vdout1_119ck80 FIND v(dout1_119) AT=90.05n

.meas tran vdout1_120ck80 FIND v(dout1_120) AT=90.05n

.meas tran vdout1_121ck80 FIND v(dout1_121) AT=90.05n

.meas tran vdout1_122ck80 FIND v(dout1_122) AT=90.05n

.meas tran vdout1_123ck80 FIND v(dout1_123) AT=90.05n

.meas tran vdout1_124ck80 FIND v(dout1_124) AT=90.05n

.meas tran vdout1_125ck80 FIND v(dout1_125) AT=90.05n

.meas tran vdout1_126ck80 FIND v(dout1_126) AT=90.05n

.meas tran vdout1_127ck80 FIND v(dout1_127) AT=90.05n

.meas tran vdout1_128ck80 FIND v(dout1_128) AT=90.05n

.meas tran vdout1_129ck80 FIND v(dout1_129) AT=90.05n

.meas tran vdout1_130ck80 FIND v(dout1_130) AT=90.05n

.meas tran vdout1_131ck80 FIND v(dout1_131) AT=90.05n

.meas tran vdout1_132ck80 FIND v(dout1_132) AT=90.05n

.meas tran vdout1_133ck80 FIND v(dout1_133) AT=90.05n

.meas tran vdout1_134ck80 FIND v(dout1_134) AT=90.05n

.meas tran vdout1_135ck80 FIND v(dout1_135) AT=90.05n

.meas tran vdout1_136ck80 FIND v(dout1_136) AT=90.05n

.meas tran vdout1_137ck80 FIND v(dout1_137) AT=90.05n

.meas tran vdout1_138ck80 FIND v(dout1_138) AT=90.05n

.meas tran vdout1_139ck80 FIND v(dout1_139) AT=90.05n

.meas tran vdout1_140ck80 FIND v(dout1_140) AT=90.05n

.meas tran vdout1_141ck80 FIND v(dout1_141) AT=90.05n

.meas tran vdout1_142ck80 FIND v(dout1_142) AT=90.05n

.meas tran vdout1_143ck80 FIND v(dout1_143) AT=90.05n

.meas tran vdout1_144ck80 FIND v(dout1_144) AT=90.05n

.meas tran vdout1_145ck80 FIND v(dout1_145) AT=90.05n

.meas tran vdout1_146ck80 FIND v(dout1_146) AT=90.05n

.meas tran vdout1_147ck80 FIND v(dout1_147) AT=90.05n

.meas tran vdout1_148ck80 FIND v(dout1_148) AT=90.05n

.meas tran vdout1_149ck80 FIND v(dout1_149) AT=90.05n

.meas tran vdout1_150ck80 FIND v(dout1_150) AT=90.05n

.meas tran vdout1_151ck80 FIND v(dout1_151) AT=90.05n

.meas tran vdout1_152ck80 FIND v(dout1_152) AT=90.05n

.meas tran vdout1_153ck80 FIND v(dout1_153) AT=90.05n

.meas tran vdout1_154ck80 FIND v(dout1_154) AT=90.05n

.meas tran vdout1_155ck80 FIND v(dout1_155) AT=90.05n

.meas tran vdout1_156ck80 FIND v(dout1_156) AT=90.05n

.meas tran vdout1_157ck80 FIND v(dout1_157) AT=90.05n

.meas tran vdout1_158ck80 FIND v(dout1_158) AT=90.05n

.meas tran vdout1_159ck80 FIND v(dout1_159) AT=90.05n

.meas tran vdout1_160ck80 FIND v(dout1_160) AT=90.05n

.meas tran vdout1_161ck80 FIND v(dout1_161) AT=90.05n

.meas tran vdout1_162ck80 FIND v(dout1_162) AT=90.05n

.meas tran vdout1_163ck80 FIND v(dout1_163) AT=90.05n

.meas tran vdout1_164ck80 FIND v(dout1_164) AT=90.05n

.meas tran vdout1_165ck80 FIND v(dout1_165) AT=90.05n

.meas tran vdout1_166ck80 FIND v(dout1_166) AT=90.05n

.meas tran vdout1_167ck80 FIND v(dout1_167) AT=90.05n

.meas tran vdout1_168ck80 FIND v(dout1_168) AT=90.05n

.meas tran vdout1_169ck80 FIND v(dout1_169) AT=90.05n

.meas tran vdout1_170ck80 FIND v(dout1_170) AT=90.05n

.meas tran vdout1_171ck80 FIND v(dout1_171) AT=90.05n

.meas tran vdout1_172ck80 FIND v(dout1_172) AT=90.05n

.meas tran vdout1_173ck80 FIND v(dout1_173) AT=90.05n

.meas tran vdout1_174ck80 FIND v(dout1_174) AT=90.05n

.meas tran vdout1_175ck80 FIND v(dout1_175) AT=90.05n

.meas tran vdout1_176ck80 FIND v(dout1_176) AT=90.05n

.meas tran vdout1_177ck80 FIND v(dout1_177) AT=90.05n

.meas tran vdout1_178ck80 FIND v(dout1_178) AT=90.05n

.meas tran vdout1_179ck80 FIND v(dout1_179) AT=90.05n

.meas tran vdout1_180ck80 FIND v(dout1_180) AT=90.05n

.meas tran vdout1_181ck80 FIND v(dout1_181) AT=90.05n

.meas tran vdout1_182ck80 FIND v(dout1_182) AT=90.05n

.meas tran vdout1_183ck80 FIND v(dout1_183) AT=90.05n

.meas tran vdout1_184ck80 FIND v(dout1_184) AT=90.05n

.meas tran vdout1_185ck80 FIND v(dout1_185) AT=90.05n

.meas tran vdout1_186ck80 FIND v(dout1_186) AT=90.05n

.meas tran vdout1_187ck80 FIND v(dout1_187) AT=90.05n

.meas tran vdout1_188ck80 FIND v(dout1_188) AT=90.05n

.meas tran vdout1_189ck80 FIND v(dout1_189) AT=90.05n

.meas tran vdout1_190ck80 FIND v(dout1_190) AT=90.05n

.meas tran vdout1_191ck80 FIND v(dout1_191) AT=90.05n

.meas tran vdout1_192ck80 FIND v(dout1_192) AT=90.05n

.meas tran vdout1_193ck80 FIND v(dout1_193) AT=90.05n

.meas tran vdout1_194ck80 FIND v(dout1_194) AT=90.05n

.meas tran vdout1_195ck80 FIND v(dout1_195) AT=90.05n

.meas tran vdout1_196ck80 FIND v(dout1_196) AT=90.05n

.meas tran vdout1_197ck80 FIND v(dout1_197) AT=90.05n

.meas tran vdout1_198ck80 FIND v(dout1_198) AT=90.05n

.meas tran vdout1_199ck80 FIND v(dout1_199) AT=90.05n

.meas tran vdout1_200ck80 FIND v(dout1_200) AT=90.05n

.meas tran vdout1_201ck80 FIND v(dout1_201) AT=90.05n

.meas tran vdout1_202ck80 FIND v(dout1_202) AT=90.05n

.meas tran vdout1_203ck80 FIND v(dout1_203) AT=90.05n

.meas tran vdout1_204ck80 FIND v(dout1_204) AT=90.05n

.meas tran vdout1_205ck80 FIND v(dout1_205) AT=90.05n

.meas tran vdout1_206ck80 FIND v(dout1_206) AT=90.05n

.meas tran vdout1_207ck80 FIND v(dout1_207) AT=90.05n

.meas tran vdout1_208ck80 FIND v(dout1_208) AT=90.05n

.meas tran vdout1_209ck80 FIND v(dout1_209) AT=90.05n

.meas tran vdout1_210ck80 FIND v(dout1_210) AT=90.05n

.meas tran vdout1_211ck80 FIND v(dout1_211) AT=90.05n

.meas tran vdout1_212ck80 FIND v(dout1_212) AT=90.05n

.meas tran vdout1_213ck80 FIND v(dout1_213) AT=90.05n

.meas tran vdout1_214ck80 FIND v(dout1_214) AT=90.05n

.meas tran vdout1_215ck80 FIND v(dout1_215) AT=90.05n

.meas tran vdout1_216ck80 FIND v(dout1_216) AT=90.05n

.meas tran vdout1_217ck80 FIND v(dout1_217) AT=90.05n

.meas tran vdout1_218ck80 FIND v(dout1_218) AT=90.05n

.meas tran vdout1_219ck80 FIND v(dout1_219) AT=90.05n

.meas tran vdout1_220ck80 FIND v(dout1_220) AT=90.05n

.meas tran vdout1_221ck80 FIND v(dout1_221) AT=90.05n

.meas tran vdout1_222ck80 FIND v(dout1_222) AT=90.05n

.meas tran vdout1_223ck80 FIND v(dout1_223) AT=90.05n

.meas tran vdout1_224ck80 FIND v(dout1_224) AT=90.05n

.meas tran vdout1_225ck80 FIND v(dout1_225) AT=90.05n

.meas tran vdout1_226ck80 FIND v(dout1_226) AT=90.05n

.meas tran vdout1_227ck80 FIND v(dout1_227) AT=90.05n

.meas tran vdout1_228ck80 FIND v(dout1_228) AT=90.05n

.meas tran vdout1_229ck80 FIND v(dout1_229) AT=90.05n

.meas tran vdout1_230ck80 FIND v(dout1_230) AT=90.05n

.meas tran vdout1_231ck80 FIND v(dout1_231) AT=90.05n

.meas tran vdout1_232ck80 FIND v(dout1_232) AT=90.05n

.meas tran vdout1_233ck80 FIND v(dout1_233) AT=90.05n

.meas tran vdout1_234ck80 FIND v(dout1_234) AT=90.05n

.meas tran vdout1_235ck80 FIND v(dout1_235) AT=90.05n

.meas tran vdout1_236ck80 FIND v(dout1_236) AT=90.05n

.meas tran vdout1_237ck80 FIND v(dout1_237) AT=90.05n

.meas tran vdout1_238ck80 FIND v(dout1_238) AT=90.05n

.meas tran vdout1_239ck80 FIND v(dout1_239) AT=90.05n

.meas tran vdout1_240ck80 FIND v(dout1_240) AT=90.05n

.meas tran vdout1_241ck80 FIND v(dout1_241) AT=90.05n

.meas tran vdout1_242ck80 FIND v(dout1_242) AT=90.05n

.meas tran vdout1_243ck80 FIND v(dout1_243) AT=90.05n

.meas tran vdout1_244ck80 FIND v(dout1_244) AT=90.05n

.meas tran vdout1_245ck80 FIND v(dout1_245) AT=90.05n

.meas tran vdout1_246ck80 FIND v(dout1_246) AT=90.05n

.meas tran vdout1_247ck80 FIND v(dout1_247) AT=90.05n

.meas tran vdout1_248ck80 FIND v(dout1_248) AT=90.05n

.meas tran vdout1_249ck80 FIND v(dout1_249) AT=90.05n

.meas tran vdout1_250ck80 FIND v(dout1_250) AT=90.05n

.meas tran vdout1_251ck80 FIND v(dout1_251) AT=90.05n

.meas tran vdout1_252ck80 FIND v(dout1_252) AT=90.05n

.meas tran vdout1_253ck80 FIND v(dout1_253) AT=90.05n

.meas tran vdout1_254ck80 FIND v(dout1_254) AT=90.05n

.meas tran vdout1_255ck80 FIND v(dout1_255) AT=90.05n

.meas tran vdout1_256ck80 FIND v(dout1_256) AT=90.05n

.meas tran vdout1_0ck100 FIND v(dout1_0) AT=110.05n

.meas tran vdout1_1ck100 FIND v(dout1_1) AT=110.05n

.meas tran vdout1_2ck100 FIND v(dout1_2) AT=110.05n

.meas tran vdout1_3ck100 FIND v(dout1_3) AT=110.05n

.meas tran vdout1_4ck100 FIND v(dout1_4) AT=110.05n

.meas tran vdout1_5ck100 FIND v(dout1_5) AT=110.05n

.meas tran vdout1_6ck100 FIND v(dout1_6) AT=110.05n

.meas tran vdout1_7ck100 FIND v(dout1_7) AT=110.05n

.meas tran vdout1_8ck100 FIND v(dout1_8) AT=110.05n

.meas tran vdout1_9ck100 FIND v(dout1_9) AT=110.05n

.meas tran vdout1_10ck100 FIND v(dout1_10) AT=110.05n

.meas tran vdout1_11ck100 FIND v(dout1_11) AT=110.05n

.meas tran vdout1_12ck100 FIND v(dout1_12) AT=110.05n

.meas tran vdout1_13ck100 FIND v(dout1_13) AT=110.05n

.meas tran vdout1_14ck100 FIND v(dout1_14) AT=110.05n

.meas tran vdout1_15ck100 FIND v(dout1_15) AT=110.05n

.meas tran vdout1_16ck100 FIND v(dout1_16) AT=110.05n

.meas tran vdout1_17ck100 FIND v(dout1_17) AT=110.05n

.meas tran vdout1_18ck100 FIND v(dout1_18) AT=110.05n

.meas tran vdout1_19ck100 FIND v(dout1_19) AT=110.05n

.meas tran vdout1_20ck100 FIND v(dout1_20) AT=110.05n

.meas tran vdout1_21ck100 FIND v(dout1_21) AT=110.05n

.meas tran vdout1_22ck100 FIND v(dout1_22) AT=110.05n

.meas tran vdout1_23ck100 FIND v(dout1_23) AT=110.05n

.meas tran vdout1_24ck100 FIND v(dout1_24) AT=110.05n

.meas tran vdout1_25ck100 FIND v(dout1_25) AT=110.05n

.meas tran vdout1_26ck100 FIND v(dout1_26) AT=110.05n

.meas tran vdout1_27ck100 FIND v(dout1_27) AT=110.05n

.meas tran vdout1_28ck100 FIND v(dout1_28) AT=110.05n

.meas tran vdout1_29ck100 FIND v(dout1_29) AT=110.05n

.meas tran vdout1_30ck100 FIND v(dout1_30) AT=110.05n

.meas tran vdout1_31ck100 FIND v(dout1_31) AT=110.05n

.meas tran vdout1_32ck100 FIND v(dout1_32) AT=110.05n

.meas tran vdout1_33ck100 FIND v(dout1_33) AT=110.05n

.meas tran vdout1_34ck100 FIND v(dout1_34) AT=110.05n

.meas tran vdout1_35ck100 FIND v(dout1_35) AT=110.05n

.meas tran vdout1_36ck100 FIND v(dout1_36) AT=110.05n

.meas tran vdout1_37ck100 FIND v(dout1_37) AT=110.05n

.meas tran vdout1_38ck100 FIND v(dout1_38) AT=110.05n

.meas tran vdout1_39ck100 FIND v(dout1_39) AT=110.05n

.meas tran vdout1_40ck100 FIND v(dout1_40) AT=110.05n

.meas tran vdout1_41ck100 FIND v(dout1_41) AT=110.05n

.meas tran vdout1_42ck100 FIND v(dout1_42) AT=110.05n

.meas tran vdout1_43ck100 FIND v(dout1_43) AT=110.05n

.meas tran vdout1_44ck100 FIND v(dout1_44) AT=110.05n

.meas tran vdout1_45ck100 FIND v(dout1_45) AT=110.05n

.meas tran vdout1_46ck100 FIND v(dout1_46) AT=110.05n

.meas tran vdout1_47ck100 FIND v(dout1_47) AT=110.05n

.meas tran vdout1_48ck100 FIND v(dout1_48) AT=110.05n

.meas tran vdout1_49ck100 FIND v(dout1_49) AT=110.05n

.meas tran vdout1_50ck100 FIND v(dout1_50) AT=110.05n

.meas tran vdout1_51ck100 FIND v(dout1_51) AT=110.05n

.meas tran vdout1_52ck100 FIND v(dout1_52) AT=110.05n

.meas tran vdout1_53ck100 FIND v(dout1_53) AT=110.05n

.meas tran vdout1_54ck100 FIND v(dout1_54) AT=110.05n

.meas tran vdout1_55ck100 FIND v(dout1_55) AT=110.05n

.meas tran vdout1_56ck100 FIND v(dout1_56) AT=110.05n

.meas tran vdout1_57ck100 FIND v(dout1_57) AT=110.05n

.meas tran vdout1_58ck100 FIND v(dout1_58) AT=110.05n

.meas tran vdout1_59ck100 FIND v(dout1_59) AT=110.05n

.meas tran vdout1_60ck100 FIND v(dout1_60) AT=110.05n

.meas tran vdout1_61ck100 FIND v(dout1_61) AT=110.05n

.meas tran vdout1_62ck100 FIND v(dout1_62) AT=110.05n

.meas tran vdout1_63ck100 FIND v(dout1_63) AT=110.05n

.meas tran vdout1_64ck100 FIND v(dout1_64) AT=110.05n

.meas tran vdout1_65ck100 FIND v(dout1_65) AT=110.05n

.meas tran vdout1_66ck100 FIND v(dout1_66) AT=110.05n

.meas tran vdout1_67ck100 FIND v(dout1_67) AT=110.05n

.meas tran vdout1_68ck100 FIND v(dout1_68) AT=110.05n

.meas tran vdout1_69ck100 FIND v(dout1_69) AT=110.05n

.meas tran vdout1_70ck100 FIND v(dout1_70) AT=110.05n

.meas tran vdout1_71ck100 FIND v(dout1_71) AT=110.05n

.meas tran vdout1_72ck100 FIND v(dout1_72) AT=110.05n

.meas tran vdout1_73ck100 FIND v(dout1_73) AT=110.05n

.meas tran vdout1_74ck100 FIND v(dout1_74) AT=110.05n

.meas tran vdout1_75ck100 FIND v(dout1_75) AT=110.05n

.meas tran vdout1_76ck100 FIND v(dout1_76) AT=110.05n

.meas tran vdout1_77ck100 FIND v(dout1_77) AT=110.05n

.meas tran vdout1_78ck100 FIND v(dout1_78) AT=110.05n

.meas tran vdout1_79ck100 FIND v(dout1_79) AT=110.05n

.meas tran vdout1_80ck100 FIND v(dout1_80) AT=110.05n

.meas tran vdout1_81ck100 FIND v(dout1_81) AT=110.05n

.meas tran vdout1_82ck100 FIND v(dout1_82) AT=110.05n

.meas tran vdout1_83ck100 FIND v(dout1_83) AT=110.05n

.meas tran vdout1_84ck100 FIND v(dout1_84) AT=110.05n

.meas tran vdout1_85ck100 FIND v(dout1_85) AT=110.05n

.meas tran vdout1_86ck100 FIND v(dout1_86) AT=110.05n

.meas tran vdout1_87ck100 FIND v(dout1_87) AT=110.05n

.meas tran vdout1_88ck100 FIND v(dout1_88) AT=110.05n

.meas tran vdout1_89ck100 FIND v(dout1_89) AT=110.05n

.meas tran vdout1_90ck100 FIND v(dout1_90) AT=110.05n

.meas tran vdout1_91ck100 FIND v(dout1_91) AT=110.05n

.meas tran vdout1_92ck100 FIND v(dout1_92) AT=110.05n

.meas tran vdout1_93ck100 FIND v(dout1_93) AT=110.05n

.meas tran vdout1_94ck100 FIND v(dout1_94) AT=110.05n

.meas tran vdout1_95ck100 FIND v(dout1_95) AT=110.05n

.meas tran vdout1_96ck100 FIND v(dout1_96) AT=110.05n

.meas tran vdout1_97ck100 FIND v(dout1_97) AT=110.05n

.meas tran vdout1_98ck100 FIND v(dout1_98) AT=110.05n

.meas tran vdout1_99ck100 FIND v(dout1_99) AT=110.05n

.meas tran vdout1_100ck100 FIND v(dout1_100) AT=110.05n

.meas tran vdout1_101ck100 FIND v(dout1_101) AT=110.05n

.meas tran vdout1_102ck100 FIND v(dout1_102) AT=110.05n

.meas tran vdout1_103ck100 FIND v(dout1_103) AT=110.05n

.meas tran vdout1_104ck100 FIND v(dout1_104) AT=110.05n

.meas tran vdout1_105ck100 FIND v(dout1_105) AT=110.05n

.meas tran vdout1_106ck100 FIND v(dout1_106) AT=110.05n

.meas tran vdout1_107ck100 FIND v(dout1_107) AT=110.05n

.meas tran vdout1_108ck100 FIND v(dout1_108) AT=110.05n

.meas tran vdout1_109ck100 FIND v(dout1_109) AT=110.05n

.meas tran vdout1_110ck100 FIND v(dout1_110) AT=110.05n

.meas tran vdout1_111ck100 FIND v(dout1_111) AT=110.05n

.meas tran vdout1_112ck100 FIND v(dout1_112) AT=110.05n

.meas tran vdout1_113ck100 FIND v(dout1_113) AT=110.05n

.meas tran vdout1_114ck100 FIND v(dout1_114) AT=110.05n

.meas tran vdout1_115ck100 FIND v(dout1_115) AT=110.05n

.meas tran vdout1_116ck100 FIND v(dout1_116) AT=110.05n

.meas tran vdout1_117ck100 FIND v(dout1_117) AT=110.05n

.meas tran vdout1_118ck100 FIND v(dout1_118) AT=110.05n

.meas tran vdout1_119ck100 FIND v(dout1_119) AT=110.05n

.meas tran vdout1_120ck100 FIND v(dout1_120) AT=110.05n

.meas tran vdout1_121ck100 FIND v(dout1_121) AT=110.05n

.meas tran vdout1_122ck100 FIND v(dout1_122) AT=110.05n

.meas tran vdout1_123ck100 FIND v(dout1_123) AT=110.05n

.meas tran vdout1_124ck100 FIND v(dout1_124) AT=110.05n

.meas tran vdout1_125ck100 FIND v(dout1_125) AT=110.05n

.meas tran vdout1_126ck100 FIND v(dout1_126) AT=110.05n

.meas tran vdout1_127ck100 FIND v(dout1_127) AT=110.05n

.meas tran vdout1_128ck100 FIND v(dout1_128) AT=110.05n

.meas tran vdout1_129ck100 FIND v(dout1_129) AT=110.05n

.meas tran vdout1_130ck100 FIND v(dout1_130) AT=110.05n

.meas tran vdout1_131ck100 FIND v(dout1_131) AT=110.05n

.meas tran vdout1_132ck100 FIND v(dout1_132) AT=110.05n

.meas tran vdout1_133ck100 FIND v(dout1_133) AT=110.05n

.meas tran vdout1_134ck100 FIND v(dout1_134) AT=110.05n

.meas tran vdout1_135ck100 FIND v(dout1_135) AT=110.05n

.meas tran vdout1_136ck100 FIND v(dout1_136) AT=110.05n

.meas tran vdout1_137ck100 FIND v(dout1_137) AT=110.05n

.meas tran vdout1_138ck100 FIND v(dout1_138) AT=110.05n

.meas tran vdout1_139ck100 FIND v(dout1_139) AT=110.05n

.meas tran vdout1_140ck100 FIND v(dout1_140) AT=110.05n

.meas tran vdout1_141ck100 FIND v(dout1_141) AT=110.05n

.meas tran vdout1_142ck100 FIND v(dout1_142) AT=110.05n

.meas tran vdout1_143ck100 FIND v(dout1_143) AT=110.05n

.meas tran vdout1_144ck100 FIND v(dout1_144) AT=110.05n

.meas tran vdout1_145ck100 FIND v(dout1_145) AT=110.05n

.meas tran vdout1_146ck100 FIND v(dout1_146) AT=110.05n

.meas tran vdout1_147ck100 FIND v(dout1_147) AT=110.05n

.meas tran vdout1_148ck100 FIND v(dout1_148) AT=110.05n

.meas tran vdout1_149ck100 FIND v(dout1_149) AT=110.05n

.meas tran vdout1_150ck100 FIND v(dout1_150) AT=110.05n

.meas tran vdout1_151ck100 FIND v(dout1_151) AT=110.05n

.meas tran vdout1_152ck100 FIND v(dout1_152) AT=110.05n

.meas tran vdout1_153ck100 FIND v(dout1_153) AT=110.05n

.meas tran vdout1_154ck100 FIND v(dout1_154) AT=110.05n

.meas tran vdout1_155ck100 FIND v(dout1_155) AT=110.05n

.meas tran vdout1_156ck100 FIND v(dout1_156) AT=110.05n

.meas tran vdout1_157ck100 FIND v(dout1_157) AT=110.05n

.meas tran vdout1_158ck100 FIND v(dout1_158) AT=110.05n

.meas tran vdout1_159ck100 FIND v(dout1_159) AT=110.05n

.meas tran vdout1_160ck100 FIND v(dout1_160) AT=110.05n

.meas tran vdout1_161ck100 FIND v(dout1_161) AT=110.05n

.meas tran vdout1_162ck100 FIND v(dout1_162) AT=110.05n

.meas tran vdout1_163ck100 FIND v(dout1_163) AT=110.05n

.meas tran vdout1_164ck100 FIND v(dout1_164) AT=110.05n

.meas tran vdout1_165ck100 FIND v(dout1_165) AT=110.05n

.meas tran vdout1_166ck100 FIND v(dout1_166) AT=110.05n

.meas tran vdout1_167ck100 FIND v(dout1_167) AT=110.05n

.meas tran vdout1_168ck100 FIND v(dout1_168) AT=110.05n

.meas tran vdout1_169ck100 FIND v(dout1_169) AT=110.05n

.meas tran vdout1_170ck100 FIND v(dout1_170) AT=110.05n

.meas tran vdout1_171ck100 FIND v(dout1_171) AT=110.05n

.meas tran vdout1_172ck100 FIND v(dout1_172) AT=110.05n

.meas tran vdout1_173ck100 FIND v(dout1_173) AT=110.05n

.meas tran vdout1_174ck100 FIND v(dout1_174) AT=110.05n

.meas tran vdout1_175ck100 FIND v(dout1_175) AT=110.05n

.meas tran vdout1_176ck100 FIND v(dout1_176) AT=110.05n

.meas tran vdout1_177ck100 FIND v(dout1_177) AT=110.05n

.meas tran vdout1_178ck100 FIND v(dout1_178) AT=110.05n

.meas tran vdout1_179ck100 FIND v(dout1_179) AT=110.05n

.meas tran vdout1_180ck100 FIND v(dout1_180) AT=110.05n

.meas tran vdout1_181ck100 FIND v(dout1_181) AT=110.05n

.meas tran vdout1_182ck100 FIND v(dout1_182) AT=110.05n

.meas tran vdout1_183ck100 FIND v(dout1_183) AT=110.05n

.meas tran vdout1_184ck100 FIND v(dout1_184) AT=110.05n

.meas tran vdout1_185ck100 FIND v(dout1_185) AT=110.05n

.meas tran vdout1_186ck100 FIND v(dout1_186) AT=110.05n

.meas tran vdout1_187ck100 FIND v(dout1_187) AT=110.05n

.meas tran vdout1_188ck100 FIND v(dout1_188) AT=110.05n

.meas tran vdout1_189ck100 FIND v(dout1_189) AT=110.05n

.meas tran vdout1_190ck100 FIND v(dout1_190) AT=110.05n

.meas tran vdout1_191ck100 FIND v(dout1_191) AT=110.05n

.meas tran vdout1_192ck100 FIND v(dout1_192) AT=110.05n

.meas tran vdout1_193ck100 FIND v(dout1_193) AT=110.05n

.meas tran vdout1_194ck100 FIND v(dout1_194) AT=110.05n

.meas tran vdout1_195ck100 FIND v(dout1_195) AT=110.05n

.meas tran vdout1_196ck100 FIND v(dout1_196) AT=110.05n

.meas tran vdout1_197ck100 FIND v(dout1_197) AT=110.05n

.meas tran vdout1_198ck100 FIND v(dout1_198) AT=110.05n

.meas tran vdout1_199ck100 FIND v(dout1_199) AT=110.05n

.meas tran vdout1_200ck100 FIND v(dout1_200) AT=110.05n

.meas tran vdout1_201ck100 FIND v(dout1_201) AT=110.05n

.meas tran vdout1_202ck100 FIND v(dout1_202) AT=110.05n

.meas tran vdout1_203ck100 FIND v(dout1_203) AT=110.05n

.meas tran vdout1_204ck100 FIND v(dout1_204) AT=110.05n

.meas tran vdout1_205ck100 FIND v(dout1_205) AT=110.05n

.meas tran vdout1_206ck100 FIND v(dout1_206) AT=110.05n

.meas tran vdout1_207ck100 FIND v(dout1_207) AT=110.05n

.meas tran vdout1_208ck100 FIND v(dout1_208) AT=110.05n

.meas tran vdout1_209ck100 FIND v(dout1_209) AT=110.05n

.meas tran vdout1_210ck100 FIND v(dout1_210) AT=110.05n

.meas tran vdout1_211ck100 FIND v(dout1_211) AT=110.05n

.meas tran vdout1_212ck100 FIND v(dout1_212) AT=110.05n

.meas tran vdout1_213ck100 FIND v(dout1_213) AT=110.05n

.meas tran vdout1_214ck100 FIND v(dout1_214) AT=110.05n

.meas tran vdout1_215ck100 FIND v(dout1_215) AT=110.05n

.meas tran vdout1_216ck100 FIND v(dout1_216) AT=110.05n

.meas tran vdout1_217ck100 FIND v(dout1_217) AT=110.05n

.meas tran vdout1_218ck100 FIND v(dout1_218) AT=110.05n

.meas tran vdout1_219ck100 FIND v(dout1_219) AT=110.05n

.meas tran vdout1_220ck100 FIND v(dout1_220) AT=110.05n

.meas tran vdout1_221ck100 FIND v(dout1_221) AT=110.05n

.meas tran vdout1_222ck100 FIND v(dout1_222) AT=110.05n

.meas tran vdout1_223ck100 FIND v(dout1_223) AT=110.05n

.meas tran vdout1_224ck100 FIND v(dout1_224) AT=110.05n

.meas tran vdout1_225ck100 FIND v(dout1_225) AT=110.05n

.meas tran vdout1_226ck100 FIND v(dout1_226) AT=110.05n

.meas tran vdout1_227ck100 FIND v(dout1_227) AT=110.05n

.meas tran vdout1_228ck100 FIND v(dout1_228) AT=110.05n

.meas tran vdout1_229ck100 FIND v(dout1_229) AT=110.05n

.meas tran vdout1_230ck100 FIND v(dout1_230) AT=110.05n

.meas tran vdout1_231ck100 FIND v(dout1_231) AT=110.05n

.meas tran vdout1_232ck100 FIND v(dout1_232) AT=110.05n

.meas tran vdout1_233ck100 FIND v(dout1_233) AT=110.05n

.meas tran vdout1_234ck100 FIND v(dout1_234) AT=110.05n

.meas tran vdout1_235ck100 FIND v(dout1_235) AT=110.05n

.meas tran vdout1_236ck100 FIND v(dout1_236) AT=110.05n

.meas tran vdout1_237ck100 FIND v(dout1_237) AT=110.05n

.meas tran vdout1_238ck100 FIND v(dout1_238) AT=110.05n

.meas tran vdout1_239ck100 FIND v(dout1_239) AT=110.05n

.meas tran vdout1_240ck100 FIND v(dout1_240) AT=110.05n

.meas tran vdout1_241ck100 FIND v(dout1_241) AT=110.05n

.meas tran vdout1_242ck100 FIND v(dout1_242) AT=110.05n

.meas tran vdout1_243ck100 FIND v(dout1_243) AT=110.05n

.meas tran vdout1_244ck100 FIND v(dout1_244) AT=110.05n

.meas tran vdout1_245ck100 FIND v(dout1_245) AT=110.05n

.meas tran vdout1_246ck100 FIND v(dout1_246) AT=110.05n

.meas tran vdout1_247ck100 FIND v(dout1_247) AT=110.05n

.meas tran vdout1_248ck100 FIND v(dout1_248) AT=110.05n

.meas tran vdout1_249ck100 FIND v(dout1_249) AT=110.05n

.meas tran vdout1_250ck100 FIND v(dout1_250) AT=110.05n

.meas tran vdout1_251ck100 FIND v(dout1_251) AT=110.05n

.meas tran vdout1_252ck100 FIND v(dout1_252) AT=110.05n

.meas tran vdout1_253ck100 FIND v(dout1_253) AT=110.05n

.meas tran vdout1_254ck100 FIND v(dout1_254) AT=110.05n

.meas tran vdout1_255ck100 FIND v(dout1_255) AT=110.05n

.meas tran vdout1_256ck100 FIND v(dout1_256) AT=110.05n

.meas tran vdout1_0ck120 FIND v(dout1_0) AT=130.05n

.meas tran vdout1_1ck120 FIND v(dout1_1) AT=130.05n

.meas tran vdout1_2ck120 FIND v(dout1_2) AT=130.05n

.meas tran vdout1_3ck120 FIND v(dout1_3) AT=130.05n

.meas tran vdout1_4ck120 FIND v(dout1_4) AT=130.05n

.meas tran vdout1_5ck120 FIND v(dout1_5) AT=130.05n

.meas tran vdout1_6ck120 FIND v(dout1_6) AT=130.05n

.meas tran vdout1_7ck120 FIND v(dout1_7) AT=130.05n

.meas tran vdout1_8ck120 FIND v(dout1_8) AT=130.05n

.meas tran vdout1_9ck120 FIND v(dout1_9) AT=130.05n

.meas tran vdout1_10ck120 FIND v(dout1_10) AT=130.05n

.meas tran vdout1_11ck120 FIND v(dout1_11) AT=130.05n

.meas tran vdout1_12ck120 FIND v(dout1_12) AT=130.05n

.meas tran vdout1_13ck120 FIND v(dout1_13) AT=130.05n

.meas tran vdout1_14ck120 FIND v(dout1_14) AT=130.05n

.meas tran vdout1_15ck120 FIND v(dout1_15) AT=130.05n

.meas tran vdout1_16ck120 FIND v(dout1_16) AT=130.05n

.meas tran vdout1_17ck120 FIND v(dout1_17) AT=130.05n

.meas tran vdout1_18ck120 FIND v(dout1_18) AT=130.05n

.meas tran vdout1_19ck120 FIND v(dout1_19) AT=130.05n

.meas tran vdout1_20ck120 FIND v(dout1_20) AT=130.05n

.meas tran vdout1_21ck120 FIND v(dout1_21) AT=130.05n

.meas tran vdout1_22ck120 FIND v(dout1_22) AT=130.05n

.meas tran vdout1_23ck120 FIND v(dout1_23) AT=130.05n

.meas tran vdout1_24ck120 FIND v(dout1_24) AT=130.05n

.meas tran vdout1_25ck120 FIND v(dout1_25) AT=130.05n

.meas tran vdout1_26ck120 FIND v(dout1_26) AT=130.05n

.meas tran vdout1_27ck120 FIND v(dout1_27) AT=130.05n

.meas tran vdout1_28ck120 FIND v(dout1_28) AT=130.05n

.meas tran vdout1_29ck120 FIND v(dout1_29) AT=130.05n

.meas tran vdout1_30ck120 FIND v(dout1_30) AT=130.05n

.meas tran vdout1_31ck120 FIND v(dout1_31) AT=130.05n

.meas tran vdout1_32ck120 FIND v(dout1_32) AT=130.05n

.meas tran vdout1_33ck120 FIND v(dout1_33) AT=130.05n

.meas tran vdout1_34ck120 FIND v(dout1_34) AT=130.05n

.meas tran vdout1_35ck120 FIND v(dout1_35) AT=130.05n

.meas tran vdout1_36ck120 FIND v(dout1_36) AT=130.05n

.meas tran vdout1_37ck120 FIND v(dout1_37) AT=130.05n

.meas tran vdout1_38ck120 FIND v(dout1_38) AT=130.05n

.meas tran vdout1_39ck120 FIND v(dout1_39) AT=130.05n

.meas tran vdout1_40ck120 FIND v(dout1_40) AT=130.05n

.meas tran vdout1_41ck120 FIND v(dout1_41) AT=130.05n

.meas tran vdout1_42ck120 FIND v(dout1_42) AT=130.05n

.meas tran vdout1_43ck120 FIND v(dout1_43) AT=130.05n

.meas tran vdout1_44ck120 FIND v(dout1_44) AT=130.05n

.meas tran vdout1_45ck120 FIND v(dout1_45) AT=130.05n

.meas tran vdout1_46ck120 FIND v(dout1_46) AT=130.05n

.meas tran vdout1_47ck120 FIND v(dout1_47) AT=130.05n

.meas tran vdout1_48ck120 FIND v(dout1_48) AT=130.05n

.meas tran vdout1_49ck120 FIND v(dout1_49) AT=130.05n

.meas tran vdout1_50ck120 FIND v(dout1_50) AT=130.05n

.meas tran vdout1_51ck120 FIND v(dout1_51) AT=130.05n

.meas tran vdout1_52ck120 FIND v(dout1_52) AT=130.05n

.meas tran vdout1_53ck120 FIND v(dout1_53) AT=130.05n

.meas tran vdout1_54ck120 FIND v(dout1_54) AT=130.05n

.meas tran vdout1_55ck120 FIND v(dout1_55) AT=130.05n

.meas tran vdout1_56ck120 FIND v(dout1_56) AT=130.05n

.meas tran vdout1_57ck120 FIND v(dout1_57) AT=130.05n

.meas tran vdout1_58ck120 FIND v(dout1_58) AT=130.05n

.meas tran vdout1_59ck120 FIND v(dout1_59) AT=130.05n

.meas tran vdout1_60ck120 FIND v(dout1_60) AT=130.05n

.meas tran vdout1_61ck120 FIND v(dout1_61) AT=130.05n

.meas tran vdout1_62ck120 FIND v(dout1_62) AT=130.05n

.meas tran vdout1_63ck120 FIND v(dout1_63) AT=130.05n

.meas tran vdout1_64ck120 FIND v(dout1_64) AT=130.05n

.meas tran vdout1_65ck120 FIND v(dout1_65) AT=130.05n

.meas tran vdout1_66ck120 FIND v(dout1_66) AT=130.05n

.meas tran vdout1_67ck120 FIND v(dout1_67) AT=130.05n

.meas tran vdout1_68ck120 FIND v(dout1_68) AT=130.05n

.meas tran vdout1_69ck120 FIND v(dout1_69) AT=130.05n

.meas tran vdout1_70ck120 FIND v(dout1_70) AT=130.05n

.meas tran vdout1_71ck120 FIND v(dout1_71) AT=130.05n

.meas tran vdout1_72ck120 FIND v(dout1_72) AT=130.05n

.meas tran vdout1_73ck120 FIND v(dout1_73) AT=130.05n

.meas tran vdout1_74ck120 FIND v(dout1_74) AT=130.05n

.meas tran vdout1_75ck120 FIND v(dout1_75) AT=130.05n

.meas tran vdout1_76ck120 FIND v(dout1_76) AT=130.05n

.meas tran vdout1_77ck120 FIND v(dout1_77) AT=130.05n

.meas tran vdout1_78ck120 FIND v(dout1_78) AT=130.05n

.meas tran vdout1_79ck120 FIND v(dout1_79) AT=130.05n

.meas tran vdout1_80ck120 FIND v(dout1_80) AT=130.05n

.meas tran vdout1_81ck120 FIND v(dout1_81) AT=130.05n

.meas tran vdout1_82ck120 FIND v(dout1_82) AT=130.05n

.meas tran vdout1_83ck120 FIND v(dout1_83) AT=130.05n

.meas tran vdout1_84ck120 FIND v(dout1_84) AT=130.05n

.meas tran vdout1_85ck120 FIND v(dout1_85) AT=130.05n

.meas tran vdout1_86ck120 FIND v(dout1_86) AT=130.05n

.meas tran vdout1_87ck120 FIND v(dout1_87) AT=130.05n

.meas tran vdout1_88ck120 FIND v(dout1_88) AT=130.05n

.meas tran vdout1_89ck120 FIND v(dout1_89) AT=130.05n

.meas tran vdout1_90ck120 FIND v(dout1_90) AT=130.05n

.meas tran vdout1_91ck120 FIND v(dout1_91) AT=130.05n

.meas tran vdout1_92ck120 FIND v(dout1_92) AT=130.05n

.meas tran vdout1_93ck120 FIND v(dout1_93) AT=130.05n

.meas tran vdout1_94ck120 FIND v(dout1_94) AT=130.05n

.meas tran vdout1_95ck120 FIND v(dout1_95) AT=130.05n

.meas tran vdout1_96ck120 FIND v(dout1_96) AT=130.05n

.meas tran vdout1_97ck120 FIND v(dout1_97) AT=130.05n

.meas tran vdout1_98ck120 FIND v(dout1_98) AT=130.05n

.meas tran vdout1_99ck120 FIND v(dout1_99) AT=130.05n

.meas tran vdout1_100ck120 FIND v(dout1_100) AT=130.05n

.meas tran vdout1_101ck120 FIND v(dout1_101) AT=130.05n

.meas tran vdout1_102ck120 FIND v(dout1_102) AT=130.05n

.meas tran vdout1_103ck120 FIND v(dout1_103) AT=130.05n

.meas tran vdout1_104ck120 FIND v(dout1_104) AT=130.05n

.meas tran vdout1_105ck120 FIND v(dout1_105) AT=130.05n

.meas tran vdout1_106ck120 FIND v(dout1_106) AT=130.05n

.meas tran vdout1_107ck120 FIND v(dout1_107) AT=130.05n

.meas tran vdout1_108ck120 FIND v(dout1_108) AT=130.05n

.meas tran vdout1_109ck120 FIND v(dout1_109) AT=130.05n

.meas tran vdout1_110ck120 FIND v(dout1_110) AT=130.05n

.meas tran vdout1_111ck120 FIND v(dout1_111) AT=130.05n

.meas tran vdout1_112ck120 FIND v(dout1_112) AT=130.05n

.meas tran vdout1_113ck120 FIND v(dout1_113) AT=130.05n

.meas tran vdout1_114ck120 FIND v(dout1_114) AT=130.05n

.meas tran vdout1_115ck120 FIND v(dout1_115) AT=130.05n

.meas tran vdout1_116ck120 FIND v(dout1_116) AT=130.05n

.meas tran vdout1_117ck120 FIND v(dout1_117) AT=130.05n

.meas tran vdout1_118ck120 FIND v(dout1_118) AT=130.05n

.meas tran vdout1_119ck120 FIND v(dout1_119) AT=130.05n

.meas tran vdout1_120ck120 FIND v(dout1_120) AT=130.05n

.meas tran vdout1_121ck120 FIND v(dout1_121) AT=130.05n

.meas tran vdout1_122ck120 FIND v(dout1_122) AT=130.05n

.meas tran vdout1_123ck120 FIND v(dout1_123) AT=130.05n

.meas tran vdout1_124ck120 FIND v(dout1_124) AT=130.05n

.meas tran vdout1_125ck120 FIND v(dout1_125) AT=130.05n

.meas tran vdout1_126ck120 FIND v(dout1_126) AT=130.05n

.meas tran vdout1_127ck120 FIND v(dout1_127) AT=130.05n

.meas tran vdout1_128ck120 FIND v(dout1_128) AT=130.05n

.meas tran vdout1_129ck120 FIND v(dout1_129) AT=130.05n

.meas tran vdout1_130ck120 FIND v(dout1_130) AT=130.05n

.meas tran vdout1_131ck120 FIND v(dout1_131) AT=130.05n

.meas tran vdout1_132ck120 FIND v(dout1_132) AT=130.05n

.meas tran vdout1_133ck120 FIND v(dout1_133) AT=130.05n

.meas tran vdout1_134ck120 FIND v(dout1_134) AT=130.05n

.meas tran vdout1_135ck120 FIND v(dout1_135) AT=130.05n

.meas tran vdout1_136ck120 FIND v(dout1_136) AT=130.05n

.meas tran vdout1_137ck120 FIND v(dout1_137) AT=130.05n

.meas tran vdout1_138ck120 FIND v(dout1_138) AT=130.05n

.meas tran vdout1_139ck120 FIND v(dout1_139) AT=130.05n

.meas tran vdout1_140ck120 FIND v(dout1_140) AT=130.05n

.meas tran vdout1_141ck120 FIND v(dout1_141) AT=130.05n

.meas tran vdout1_142ck120 FIND v(dout1_142) AT=130.05n

.meas tran vdout1_143ck120 FIND v(dout1_143) AT=130.05n

.meas tran vdout1_144ck120 FIND v(dout1_144) AT=130.05n

.meas tran vdout1_145ck120 FIND v(dout1_145) AT=130.05n

.meas tran vdout1_146ck120 FIND v(dout1_146) AT=130.05n

.meas tran vdout1_147ck120 FIND v(dout1_147) AT=130.05n

.meas tran vdout1_148ck120 FIND v(dout1_148) AT=130.05n

.meas tran vdout1_149ck120 FIND v(dout1_149) AT=130.05n

.meas tran vdout1_150ck120 FIND v(dout1_150) AT=130.05n

.meas tran vdout1_151ck120 FIND v(dout1_151) AT=130.05n

.meas tran vdout1_152ck120 FIND v(dout1_152) AT=130.05n

.meas tran vdout1_153ck120 FIND v(dout1_153) AT=130.05n

.meas tran vdout1_154ck120 FIND v(dout1_154) AT=130.05n

.meas tran vdout1_155ck120 FIND v(dout1_155) AT=130.05n

.meas tran vdout1_156ck120 FIND v(dout1_156) AT=130.05n

.meas tran vdout1_157ck120 FIND v(dout1_157) AT=130.05n

.meas tran vdout1_158ck120 FIND v(dout1_158) AT=130.05n

.meas tran vdout1_159ck120 FIND v(dout1_159) AT=130.05n

.meas tran vdout1_160ck120 FIND v(dout1_160) AT=130.05n

.meas tran vdout1_161ck120 FIND v(dout1_161) AT=130.05n

.meas tran vdout1_162ck120 FIND v(dout1_162) AT=130.05n

.meas tran vdout1_163ck120 FIND v(dout1_163) AT=130.05n

.meas tran vdout1_164ck120 FIND v(dout1_164) AT=130.05n

.meas tran vdout1_165ck120 FIND v(dout1_165) AT=130.05n

.meas tran vdout1_166ck120 FIND v(dout1_166) AT=130.05n

.meas tran vdout1_167ck120 FIND v(dout1_167) AT=130.05n

.meas tran vdout1_168ck120 FIND v(dout1_168) AT=130.05n

.meas tran vdout1_169ck120 FIND v(dout1_169) AT=130.05n

.meas tran vdout1_170ck120 FIND v(dout1_170) AT=130.05n

.meas tran vdout1_171ck120 FIND v(dout1_171) AT=130.05n

.meas tran vdout1_172ck120 FIND v(dout1_172) AT=130.05n

.meas tran vdout1_173ck120 FIND v(dout1_173) AT=130.05n

.meas tran vdout1_174ck120 FIND v(dout1_174) AT=130.05n

.meas tran vdout1_175ck120 FIND v(dout1_175) AT=130.05n

.meas tran vdout1_176ck120 FIND v(dout1_176) AT=130.05n

.meas tran vdout1_177ck120 FIND v(dout1_177) AT=130.05n

.meas tran vdout1_178ck120 FIND v(dout1_178) AT=130.05n

.meas tran vdout1_179ck120 FIND v(dout1_179) AT=130.05n

.meas tran vdout1_180ck120 FIND v(dout1_180) AT=130.05n

.meas tran vdout1_181ck120 FIND v(dout1_181) AT=130.05n

.meas tran vdout1_182ck120 FIND v(dout1_182) AT=130.05n

.meas tran vdout1_183ck120 FIND v(dout1_183) AT=130.05n

.meas tran vdout1_184ck120 FIND v(dout1_184) AT=130.05n

.meas tran vdout1_185ck120 FIND v(dout1_185) AT=130.05n

.meas tran vdout1_186ck120 FIND v(dout1_186) AT=130.05n

.meas tran vdout1_187ck120 FIND v(dout1_187) AT=130.05n

.meas tran vdout1_188ck120 FIND v(dout1_188) AT=130.05n

.meas tran vdout1_189ck120 FIND v(dout1_189) AT=130.05n

.meas tran vdout1_190ck120 FIND v(dout1_190) AT=130.05n

.meas tran vdout1_191ck120 FIND v(dout1_191) AT=130.05n

.meas tran vdout1_192ck120 FIND v(dout1_192) AT=130.05n

.meas tran vdout1_193ck120 FIND v(dout1_193) AT=130.05n

.meas tran vdout1_194ck120 FIND v(dout1_194) AT=130.05n

.meas tran vdout1_195ck120 FIND v(dout1_195) AT=130.05n

.meas tran vdout1_196ck120 FIND v(dout1_196) AT=130.05n

.meas tran vdout1_197ck120 FIND v(dout1_197) AT=130.05n

.meas tran vdout1_198ck120 FIND v(dout1_198) AT=130.05n

.meas tran vdout1_199ck120 FIND v(dout1_199) AT=130.05n

.meas tran vdout1_200ck120 FIND v(dout1_200) AT=130.05n

.meas tran vdout1_201ck120 FIND v(dout1_201) AT=130.05n

.meas tran vdout1_202ck120 FIND v(dout1_202) AT=130.05n

.meas tran vdout1_203ck120 FIND v(dout1_203) AT=130.05n

.meas tran vdout1_204ck120 FIND v(dout1_204) AT=130.05n

.meas tran vdout1_205ck120 FIND v(dout1_205) AT=130.05n

.meas tran vdout1_206ck120 FIND v(dout1_206) AT=130.05n

.meas tran vdout1_207ck120 FIND v(dout1_207) AT=130.05n

.meas tran vdout1_208ck120 FIND v(dout1_208) AT=130.05n

.meas tran vdout1_209ck120 FIND v(dout1_209) AT=130.05n

.meas tran vdout1_210ck120 FIND v(dout1_210) AT=130.05n

.meas tran vdout1_211ck120 FIND v(dout1_211) AT=130.05n

.meas tran vdout1_212ck120 FIND v(dout1_212) AT=130.05n

.meas tran vdout1_213ck120 FIND v(dout1_213) AT=130.05n

.meas tran vdout1_214ck120 FIND v(dout1_214) AT=130.05n

.meas tran vdout1_215ck120 FIND v(dout1_215) AT=130.05n

.meas tran vdout1_216ck120 FIND v(dout1_216) AT=130.05n

.meas tran vdout1_217ck120 FIND v(dout1_217) AT=130.05n

.meas tran vdout1_218ck120 FIND v(dout1_218) AT=130.05n

.meas tran vdout1_219ck120 FIND v(dout1_219) AT=130.05n

.meas tran vdout1_220ck120 FIND v(dout1_220) AT=130.05n

.meas tran vdout1_221ck120 FIND v(dout1_221) AT=130.05n

.meas tran vdout1_222ck120 FIND v(dout1_222) AT=130.05n

.meas tran vdout1_223ck120 FIND v(dout1_223) AT=130.05n

.meas tran vdout1_224ck120 FIND v(dout1_224) AT=130.05n

.meas tran vdout1_225ck120 FIND v(dout1_225) AT=130.05n

.meas tran vdout1_226ck120 FIND v(dout1_226) AT=130.05n

.meas tran vdout1_227ck120 FIND v(dout1_227) AT=130.05n

.meas tran vdout1_228ck120 FIND v(dout1_228) AT=130.05n

.meas tran vdout1_229ck120 FIND v(dout1_229) AT=130.05n

.meas tran vdout1_230ck120 FIND v(dout1_230) AT=130.05n

.meas tran vdout1_231ck120 FIND v(dout1_231) AT=130.05n

.meas tran vdout1_232ck120 FIND v(dout1_232) AT=130.05n

.meas tran vdout1_233ck120 FIND v(dout1_233) AT=130.05n

.meas tran vdout1_234ck120 FIND v(dout1_234) AT=130.05n

.meas tran vdout1_235ck120 FIND v(dout1_235) AT=130.05n

.meas tran vdout1_236ck120 FIND v(dout1_236) AT=130.05n

.meas tran vdout1_237ck120 FIND v(dout1_237) AT=130.05n

.meas tran vdout1_238ck120 FIND v(dout1_238) AT=130.05n

.meas tran vdout1_239ck120 FIND v(dout1_239) AT=130.05n

.meas tran vdout1_240ck120 FIND v(dout1_240) AT=130.05n

.meas tran vdout1_241ck120 FIND v(dout1_241) AT=130.05n

.meas tran vdout1_242ck120 FIND v(dout1_242) AT=130.05n

.meas tran vdout1_243ck120 FIND v(dout1_243) AT=130.05n

.meas tran vdout1_244ck120 FIND v(dout1_244) AT=130.05n

.meas tran vdout1_245ck120 FIND v(dout1_245) AT=130.05n

.meas tran vdout1_246ck120 FIND v(dout1_246) AT=130.05n

.meas tran vdout1_247ck120 FIND v(dout1_247) AT=130.05n

.meas tran vdout1_248ck120 FIND v(dout1_248) AT=130.05n

.meas tran vdout1_249ck120 FIND v(dout1_249) AT=130.05n

.meas tran vdout1_250ck120 FIND v(dout1_250) AT=130.05n

.meas tran vdout1_251ck120 FIND v(dout1_251) AT=130.05n

.meas tran vdout1_252ck120 FIND v(dout1_252) AT=130.05n

.meas tran vdout1_253ck120 FIND v(dout1_253) AT=130.05n

.meas tran vdout1_254ck120 FIND v(dout1_254) AT=130.05n

.meas tran vdout1_255ck120 FIND v(dout1_255) AT=130.05n

.meas tran vdout1_256ck120 FIND v(dout1_256) AT=130.05n

.meas tran vdout1_0ck160 FIND v(dout1_0) AT=170.05n

.meas tran vdout1_1ck160 FIND v(dout1_1) AT=170.05n

.meas tran vdout1_2ck160 FIND v(dout1_2) AT=170.05n

.meas tran vdout1_3ck160 FIND v(dout1_3) AT=170.05n

.meas tran vdout1_4ck160 FIND v(dout1_4) AT=170.05n

.meas tran vdout1_5ck160 FIND v(dout1_5) AT=170.05n

.meas tran vdout1_6ck160 FIND v(dout1_6) AT=170.05n

.meas tran vdout1_7ck160 FIND v(dout1_7) AT=170.05n

.meas tran vdout1_8ck160 FIND v(dout1_8) AT=170.05n

.meas tran vdout1_9ck160 FIND v(dout1_9) AT=170.05n

.meas tran vdout1_10ck160 FIND v(dout1_10) AT=170.05n

.meas tran vdout1_11ck160 FIND v(dout1_11) AT=170.05n

.meas tran vdout1_12ck160 FIND v(dout1_12) AT=170.05n

.meas tran vdout1_13ck160 FIND v(dout1_13) AT=170.05n

.meas tran vdout1_14ck160 FIND v(dout1_14) AT=170.05n

.meas tran vdout1_15ck160 FIND v(dout1_15) AT=170.05n

.meas tran vdout1_16ck160 FIND v(dout1_16) AT=170.05n

.meas tran vdout1_17ck160 FIND v(dout1_17) AT=170.05n

.meas tran vdout1_18ck160 FIND v(dout1_18) AT=170.05n

.meas tran vdout1_19ck160 FIND v(dout1_19) AT=170.05n

.meas tran vdout1_20ck160 FIND v(dout1_20) AT=170.05n

.meas tran vdout1_21ck160 FIND v(dout1_21) AT=170.05n

.meas tran vdout1_22ck160 FIND v(dout1_22) AT=170.05n

.meas tran vdout1_23ck160 FIND v(dout1_23) AT=170.05n

.meas tran vdout1_24ck160 FIND v(dout1_24) AT=170.05n

.meas tran vdout1_25ck160 FIND v(dout1_25) AT=170.05n

.meas tran vdout1_26ck160 FIND v(dout1_26) AT=170.05n

.meas tran vdout1_27ck160 FIND v(dout1_27) AT=170.05n

.meas tran vdout1_28ck160 FIND v(dout1_28) AT=170.05n

.meas tran vdout1_29ck160 FIND v(dout1_29) AT=170.05n

.meas tran vdout1_30ck160 FIND v(dout1_30) AT=170.05n

.meas tran vdout1_31ck160 FIND v(dout1_31) AT=170.05n

.meas tran vdout1_32ck160 FIND v(dout1_32) AT=170.05n

.meas tran vdout1_33ck160 FIND v(dout1_33) AT=170.05n

.meas tran vdout1_34ck160 FIND v(dout1_34) AT=170.05n

.meas tran vdout1_35ck160 FIND v(dout1_35) AT=170.05n

.meas tran vdout1_36ck160 FIND v(dout1_36) AT=170.05n

.meas tran vdout1_37ck160 FIND v(dout1_37) AT=170.05n

.meas tran vdout1_38ck160 FIND v(dout1_38) AT=170.05n

.meas tran vdout1_39ck160 FIND v(dout1_39) AT=170.05n

.meas tran vdout1_40ck160 FIND v(dout1_40) AT=170.05n

.meas tran vdout1_41ck160 FIND v(dout1_41) AT=170.05n

.meas tran vdout1_42ck160 FIND v(dout1_42) AT=170.05n

.meas tran vdout1_43ck160 FIND v(dout1_43) AT=170.05n

.meas tran vdout1_44ck160 FIND v(dout1_44) AT=170.05n

.meas tran vdout1_45ck160 FIND v(dout1_45) AT=170.05n

.meas tran vdout1_46ck160 FIND v(dout1_46) AT=170.05n

.meas tran vdout1_47ck160 FIND v(dout1_47) AT=170.05n

.meas tran vdout1_48ck160 FIND v(dout1_48) AT=170.05n

.meas tran vdout1_49ck160 FIND v(dout1_49) AT=170.05n

.meas tran vdout1_50ck160 FIND v(dout1_50) AT=170.05n

.meas tran vdout1_51ck160 FIND v(dout1_51) AT=170.05n

.meas tran vdout1_52ck160 FIND v(dout1_52) AT=170.05n

.meas tran vdout1_53ck160 FIND v(dout1_53) AT=170.05n

.meas tran vdout1_54ck160 FIND v(dout1_54) AT=170.05n

.meas tran vdout1_55ck160 FIND v(dout1_55) AT=170.05n

.meas tran vdout1_56ck160 FIND v(dout1_56) AT=170.05n

.meas tran vdout1_57ck160 FIND v(dout1_57) AT=170.05n

.meas tran vdout1_58ck160 FIND v(dout1_58) AT=170.05n

.meas tran vdout1_59ck160 FIND v(dout1_59) AT=170.05n

.meas tran vdout1_60ck160 FIND v(dout1_60) AT=170.05n

.meas tran vdout1_61ck160 FIND v(dout1_61) AT=170.05n

.meas tran vdout1_62ck160 FIND v(dout1_62) AT=170.05n

.meas tran vdout1_63ck160 FIND v(dout1_63) AT=170.05n

.meas tran vdout1_64ck160 FIND v(dout1_64) AT=170.05n

.meas tran vdout1_65ck160 FIND v(dout1_65) AT=170.05n

.meas tran vdout1_66ck160 FIND v(dout1_66) AT=170.05n

.meas tran vdout1_67ck160 FIND v(dout1_67) AT=170.05n

.meas tran vdout1_68ck160 FIND v(dout1_68) AT=170.05n

.meas tran vdout1_69ck160 FIND v(dout1_69) AT=170.05n

.meas tran vdout1_70ck160 FIND v(dout1_70) AT=170.05n

.meas tran vdout1_71ck160 FIND v(dout1_71) AT=170.05n

.meas tran vdout1_72ck160 FIND v(dout1_72) AT=170.05n

.meas tran vdout1_73ck160 FIND v(dout1_73) AT=170.05n

.meas tran vdout1_74ck160 FIND v(dout1_74) AT=170.05n

.meas tran vdout1_75ck160 FIND v(dout1_75) AT=170.05n

.meas tran vdout1_76ck160 FIND v(dout1_76) AT=170.05n

.meas tran vdout1_77ck160 FIND v(dout1_77) AT=170.05n

.meas tran vdout1_78ck160 FIND v(dout1_78) AT=170.05n

.meas tran vdout1_79ck160 FIND v(dout1_79) AT=170.05n

.meas tran vdout1_80ck160 FIND v(dout1_80) AT=170.05n

.meas tran vdout1_81ck160 FIND v(dout1_81) AT=170.05n

.meas tran vdout1_82ck160 FIND v(dout1_82) AT=170.05n

.meas tran vdout1_83ck160 FIND v(dout1_83) AT=170.05n

.meas tran vdout1_84ck160 FIND v(dout1_84) AT=170.05n

.meas tran vdout1_85ck160 FIND v(dout1_85) AT=170.05n

.meas tran vdout1_86ck160 FIND v(dout1_86) AT=170.05n

.meas tran vdout1_87ck160 FIND v(dout1_87) AT=170.05n

.meas tran vdout1_88ck160 FIND v(dout1_88) AT=170.05n

.meas tran vdout1_89ck160 FIND v(dout1_89) AT=170.05n

.meas tran vdout1_90ck160 FIND v(dout1_90) AT=170.05n

.meas tran vdout1_91ck160 FIND v(dout1_91) AT=170.05n

.meas tran vdout1_92ck160 FIND v(dout1_92) AT=170.05n

.meas tran vdout1_93ck160 FIND v(dout1_93) AT=170.05n

.meas tran vdout1_94ck160 FIND v(dout1_94) AT=170.05n

.meas tran vdout1_95ck160 FIND v(dout1_95) AT=170.05n

.meas tran vdout1_96ck160 FIND v(dout1_96) AT=170.05n

.meas tran vdout1_97ck160 FIND v(dout1_97) AT=170.05n

.meas tran vdout1_98ck160 FIND v(dout1_98) AT=170.05n

.meas tran vdout1_99ck160 FIND v(dout1_99) AT=170.05n

.meas tran vdout1_100ck160 FIND v(dout1_100) AT=170.05n

.meas tran vdout1_101ck160 FIND v(dout1_101) AT=170.05n

.meas tran vdout1_102ck160 FIND v(dout1_102) AT=170.05n

.meas tran vdout1_103ck160 FIND v(dout1_103) AT=170.05n

.meas tran vdout1_104ck160 FIND v(dout1_104) AT=170.05n

.meas tran vdout1_105ck160 FIND v(dout1_105) AT=170.05n

.meas tran vdout1_106ck160 FIND v(dout1_106) AT=170.05n

.meas tran vdout1_107ck160 FIND v(dout1_107) AT=170.05n

.meas tran vdout1_108ck160 FIND v(dout1_108) AT=170.05n

.meas tran vdout1_109ck160 FIND v(dout1_109) AT=170.05n

.meas tran vdout1_110ck160 FIND v(dout1_110) AT=170.05n

.meas tran vdout1_111ck160 FIND v(dout1_111) AT=170.05n

.meas tran vdout1_112ck160 FIND v(dout1_112) AT=170.05n

.meas tran vdout1_113ck160 FIND v(dout1_113) AT=170.05n

.meas tran vdout1_114ck160 FIND v(dout1_114) AT=170.05n

.meas tran vdout1_115ck160 FIND v(dout1_115) AT=170.05n

.meas tran vdout1_116ck160 FIND v(dout1_116) AT=170.05n

.meas tran vdout1_117ck160 FIND v(dout1_117) AT=170.05n

.meas tran vdout1_118ck160 FIND v(dout1_118) AT=170.05n

.meas tran vdout1_119ck160 FIND v(dout1_119) AT=170.05n

.meas tran vdout1_120ck160 FIND v(dout1_120) AT=170.05n

.meas tran vdout1_121ck160 FIND v(dout1_121) AT=170.05n

.meas tran vdout1_122ck160 FIND v(dout1_122) AT=170.05n

.meas tran vdout1_123ck160 FIND v(dout1_123) AT=170.05n

.meas tran vdout1_124ck160 FIND v(dout1_124) AT=170.05n

.meas tran vdout1_125ck160 FIND v(dout1_125) AT=170.05n

.meas tran vdout1_126ck160 FIND v(dout1_126) AT=170.05n

.meas tran vdout1_127ck160 FIND v(dout1_127) AT=170.05n

.meas tran vdout1_128ck160 FIND v(dout1_128) AT=170.05n

.meas tran vdout1_129ck160 FIND v(dout1_129) AT=170.05n

.meas tran vdout1_130ck160 FIND v(dout1_130) AT=170.05n

.meas tran vdout1_131ck160 FIND v(dout1_131) AT=170.05n

.meas tran vdout1_132ck160 FIND v(dout1_132) AT=170.05n

.meas tran vdout1_133ck160 FIND v(dout1_133) AT=170.05n

.meas tran vdout1_134ck160 FIND v(dout1_134) AT=170.05n

.meas tran vdout1_135ck160 FIND v(dout1_135) AT=170.05n

.meas tran vdout1_136ck160 FIND v(dout1_136) AT=170.05n

.meas tran vdout1_137ck160 FIND v(dout1_137) AT=170.05n

.meas tran vdout1_138ck160 FIND v(dout1_138) AT=170.05n

.meas tran vdout1_139ck160 FIND v(dout1_139) AT=170.05n

.meas tran vdout1_140ck160 FIND v(dout1_140) AT=170.05n

.meas tran vdout1_141ck160 FIND v(dout1_141) AT=170.05n

.meas tran vdout1_142ck160 FIND v(dout1_142) AT=170.05n

.meas tran vdout1_143ck160 FIND v(dout1_143) AT=170.05n

.meas tran vdout1_144ck160 FIND v(dout1_144) AT=170.05n

.meas tran vdout1_145ck160 FIND v(dout1_145) AT=170.05n

.meas tran vdout1_146ck160 FIND v(dout1_146) AT=170.05n

.meas tran vdout1_147ck160 FIND v(dout1_147) AT=170.05n

.meas tran vdout1_148ck160 FIND v(dout1_148) AT=170.05n

.meas tran vdout1_149ck160 FIND v(dout1_149) AT=170.05n

.meas tran vdout1_150ck160 FIND v(dout1_150) AT=170.05n

.meas tran vdout1_151ck160 FIND v(dout1_151) AT=170.05n

.meas tran vdout1_152ck160 FIND v(dout1_152) AT=170.05n

.meas tran vdout1_153ck160 FIND v(dout1_153) AT=170.05n

.meas tran vdout1_154ck160 FIND v(dout1_154) AT=170.05n

.meas tran vdout1_155ck160 FIND v(dout1_155) AT=170.05n

.meas tran vdout1_156ck160 FIND v(dout1_156) AT=170.05n

.meas tran vdout1_157ck160 FIND v(dout1_157) AT=170.05n

.meas tran vdout1_158ck160 FIND v(dout1_158) AT=170.05n

.meas tran vdout1_159ck160 FIND v(dout1_159) AT=170.05n

.meas tran vdout1_160ck160 FIND v(dout1_160) AT=170.05n

.meas tran vdout1_161ck160 FIND v(dout1_161) AT=170.05n

.meas tran vdout1_162ck160 FIND v(dout1_162) AT=170.05n

.meas tran vdout1_163ck160 FIND v(dout1_163) AT=170.05n

.meas tran vdout1_164ck160 FIND v(dout1_164) AT=170.05n

.meas tran vdout1_165ck160 FIND v(dout1_165) AT=170.05n

.meas tran vdout1_166ck160 FIND v(dout1_166) AT=170.05n

.meas tran vdout1_167ck160 FIND v(dout1_167) AT=170.05n

.meas tran vdout1_168ck160 FIND v(dout1_168) AT=170.05n

.meas tran vdout1_169ck160 FIND v(dout1_169) AT=170.05n

.meas tran vdout1_170ck160 FIND v(dout1_170) AT=170.05n

.meas tran vdout1_171ck160 FIND v(dout1_171) AT=170.05n

.meas tran vdout1_172ck160 FIND v(dout1_172) AT=170.05n

.meas tran vdout1_173ck160 FIND v(dout1_173) AT=170.05n

.meas tran vdout1_174ck160 FIND v(dout1_174) AT=170.05n

.meas tran vdout1_175ck160 FIND v(dout1_175) AT=170.05n

.meas tran vdout1_176ck160 FIND v(dout1_176) AT=170.05n

.meas tran vdout1_177ck160 FIND v(dout1_177) AT=170.05n

.meas tran vdout1_178ck160 FIND v(dout1_178) AT=170.05n

.meas tran vdout1_179ck160 FIND v(dout1_179) AT=170.05n

.meas tran vdout1_180ck160 FIND v(dout1_180) AT=170.05n

.meas tran vdout1_181ck160 FIND v(dout1_181) AT=170.05n

.meas tran vdout1_182ck160 FIND v(dout1_182) AT=170.05n

.meas tran vdout1_183ck160 FIND v(dout1_183) AT=170.05n

.meas tran vdout1_184ck160 FIND v(dout1_184) AT=170.05n

.meas tran vdout1_185ck160 FIND v(dout1_185) AT=170.05n

.meas tran vdout1_186ck160 FIND v(dout1_186) AT=170.05n

.meas tran vdout1_187ck160 FIND v(dout1_187) AT=170.05n

.meas tran vdout1_188ck160 FIND v(dout1_188) AT=170.05n

.meas tran vdout1_189ck160 FIND v(dout1_189) AT=170.05n

.meas tran vdout1_190ck160 FIND v(dout1_190) AT=170.05n

.meas tran vdout1_191ck160 FIND v(dout1_191) AT=170.05n

.meas tran vdout1_192ck160 FIND v(dout1_192) AT=170.05n

.meas tran vdout1_193ck160 FIND v(dout1_193) AT=170.05n

.meas tran vdout1_194ck160 FIND v(dout1_194) AT=170.05n

.meas tran vdout1_195ck160 FIND v(dout1_195) AT=170.05n

.meas tran vdout1_196ck160 FIND v(dout1_196) AT=170.05n

.meas tran vdout1_197ck160 FIND v(dout1_197) AT=170.05n

.meas tran vdout1_198ck160 FIND v(dout1_198) AT=170.05n

.meas tran vdout1_199ck160 FIND v(dout1_199) AT=170.05n

.meas tran vdout1_200ck160 FIND v(dout1_200) AT=170.05n

.meas tran vdout1_201ck160 FIND v(dout1_201) AT=170.05n

.meas tran vdout1_202ck160 FIND v(dout1_202) AT=170.05n

.meas tran vdout1_203ck160 FIND v(dout1_203) AT=170.05n

.meas tran vdout1_204ck160 FIND v(dout1_204) AT=170.05n

.meas tran vdout1_205ck160 FIND v(dout1_205) AT=170.05n

.meas tran vdout1_206ck160 FIND v(dout1_206) AT=170.05n

.meas tran vdout1_207ck160 FIND v(dout1_207) AT=170.05n

.meas tran vdout1_208ck160 FIND v(dout1_208) AT=170.05n

.meas tran vdout1_209ck160 FIND v(dout1_209) AT=170.05n

.meas tran vdout1_210ck160 FIND v(dout1_210) AT=170.05n

.meas tran vdout1_211ck160 FIND v(dout1_211) AT=170.05n

.meas tran vdout1_212ck160 FIND v(dout1_212) AT=170.05n

.meas tran vdout1_213ck160 FIND v(dout1_213) AT=170.05n

.meas tran vdout1_214ck160 FIND v(dout1_214) AT=170.05n

.meas tran vdout1_215ck160 FIND v(dout1_215) AT=170.05n

.meas tran vdout1_216ck160 FIND v(dout1_216) AT=170.05n

.meas tran vdout1_217ck160 FIND v(dout1_217) AT=170.05n

.meas tran vdout1_218ck160 FIND v(dout1_218) AT=170.05n

.meas tran vdout1_219ck160 FIND v(dout1_219) AT=170.05n

.meas tran vdout1_220ck160 FIND v(dout1_220) AT=170.05n

.meas tran vdout1_221ck160 FIND v(dout1_221) AT=170.05n

.meas tran vdout1_222ck160 FIND v(dout1_222) AT=170.05n

.meas tran vdout1_223ck160 FIND v(dout1_223) AT=170.05n

.meas tran vdout1_224ck160 FIND v(dout1_224) AT=170.05n

.meas tran vdout1_225ck160 FIND v(dout1_225) AT=170.05n

.meas tran vdout1_226ck160 FIND v(dout1_226) AT=170.05n

.meas tran vdout1_227ck160 FIND v(dout1_227) AT=170.05n

.meas tran vdout1_228ck160 FIND v(dout1_228) AT=170.05n

.meas tran vdout1_229ck160 FIND v(dout1_229) AT=170.05n

.meas tran vdout1_230ck160 FIND v(dout1_230) AT=170.05n

.meas tran vdout1_231ck160 FIND v(dout1_231) AT=170.05n

.meas tran vdout1_232ck160 FIND v(dout1_232) AT=170.05n

.meas tran vdout1_233ck160 FIND v(dout1_233) AT=170.05n

.meas tran vdout1_234ck160 FIND v(dout1_234) AT=170.05n

.meas tran vdout1_235ck160 FIND v(dout1_235) AT=170.05n

.meas tran vdout1_236ck160 FIND v(dout1_236) AT=170.05n

.meas tran vdout1_237ck160 FIND v(dout1_237) AT=170.05n

.meas tran vdout1_238ck160 FIND v(dout1_238) AT=170.05n

.meas tran vdout1_239ck160 FIND v(dout1_239) AT=170.05n

.meas tran vdout1_240ck160 FIND v(dout1_240) AT=170.05n

.meas tran vdout1_241ck160 FIND v(dout1_241) AT=170.05n

.meas tran vdout1_242ck160 FIND v(dout1_242) AT=170.05n

.meas tran vdout1_243ck160 FIND v(dout1_243) AT=170.05n

.meas tran vdout1_244ck160 FIND v(dout1_244) AT=170.05n

.meas tran vdout1_245ck160 FIND v(dout1_245) AT=170.05n

.meas tran vdout1_246ck160 FIND v(dout1_246) AT=170.05n

.meas tran vdout1_247ck160 FIND v(dout1_247) AT=170.05n

.meas tran vdout1_248ck160 FIND v(dout1_248) AT=170.05n

.meas tran vdout1_249ck160 FIND v(dout1_249) AT=170.05n

.meas tran vdout1_250ck160 FIND v(dout1_250) AT=170.05n

.meas tran vdout1_251ck160 FIND v(dout1_251) AT=170.05n

.meas tran vdout1_252ck160 FIND v(dout1_252) AT=170.05n

.meas tran vdout1_253ck160 FIND v(dout1_253) AT=170.05n

.meas tran vdout1_254ck160 FIND v(dout1_254) AT=170.05n

.meas tran vdout1_255ck160 FIND v(dout1_255) AT=170.05n

.meas tran vdout1_256ck160 FIND v(dout1_256) AT=170.05n

.meas tran vdout1_0ck180 FIND v(dout1_0) AT=190.05n

.meas tran vdout1_1ck180 FIND v(dout1_1) AT=190.05n

.meas tran vdout1_2ck180 FIND v(dout1_2) AT=190.05n

.meas tran vdout1_3ck180 FIND v(dout1_3) AT=190.05n

.meas tran vdout1_4ck180 FIND v(dout1_4) AT=190.05n

.meas tran vdout1_5ck180 FIND v(dout1_5) AT=190.05n

.meas tran vdout1_6ck180 FIND v(dout1_6) AT=190.05n

.meas tran vdout1_7ck180 FIND v(dout1_7) AT=190.05n

.meas tran vdout1_8ck180 FIND v(dout1_8) AT=190.05n

.meas tran vdout1_9ck180 FIND v(dout1_9) AT=190.05n

.meas tran vdout1_10ck180 FIND v(dout1_10) AT=190.05n

.meas tran vdout1_11ck180 FIND v(dout1_11) AT=190.05n

.meas tran vdout1_12ck180 FIND v(dout1_12) AT=190.05n

.meas tran vdout1_13ck180 FIND v(dout1_13) AT=190.05n

.meas tran vdout1_14ck180 FIND v(dout1_14) AT=190.05n

.meas tran vdout1_15ck180 FIND v(dout1_15) AT=190.05n

.meas tran vdout1_16ck180 FIND v(dout1_16) AT=190.05n

.meas tran vdout1_17ck180 FIND v(dout1_17) AT=190.05n

.meas tran vdout1_18ck180 FIND v(dout1_18) AT=190.05n

.meas tran vdout1_19ck180 FIND v(dout1_19) AT=190.05n

.meas tran vdout1_20ck180 FIND v(dout1_20) AT=190.05n

.meas tran vdout1_21ck180 FIND v(dout1_21) AT=190.05n

.meas tran vdout1_22ck180 FIND v(dout1_22) AT=190.05n

.meas tran vdout1_23ck180 FIND v(dout1_23) AT=190.05n

.meas tran vdout1_24ck180 FIND v(dout1_24) AT=190.05n

.meas tran vdout1_25ck180 FIND v(dout1_25) AT=190.05n

.meas tran vdout1_26ck180 FIND v(dout1_26) AT=190.05n

.meas tran vdout1_27ck180 FIND v(dout1_27) AT=190.05n

.meas tran vdout1_28ck180 FIND v(dout1_28) AT=190.05n

.meas tran vdout1_29ck180 FIND v(dout1_29) AT=190.05n

.meas tran vdout1_30ck180 FIND v(dout1_30) AT=190.05n

.meas tran vdout1_31ck180 FIND v(dout1_31) AT=190.05n

.meas tran vdout1_32ck180 FIND v(dout1_32) AT=190.05n

.meas tran vdout1_33ck180 FIND v(dout1_33) AT=190.05n

.meas tran vdout1_34ck180 FIND v(dout1_34) AT=190.05n

.meas tran vdout1_35ck180 FIND v(dout1_35) AT=190.05n

.meas tran vdout1_36ck180 FIND v(dout1_36) AT=190.05n

.meas tran vdout1_37ck180 FIND v(dout1_37) AT=190.05n

.meas tran vdout1_38ck180 FIND v(dout1_38) AT=190.05n

.meas tran vdout1_39ck180 FIND v(dout1_39) AT=190.05n

.meas tran vdout1_40ck180 FIND v(dout1_40) AT=190.05n

.meas tran vdout1_41ck180 FIND v(dout1_41) AT=190.05n

.meas tran vdout1_42ck180 FIND v(dout1_42) AT=190.05n

.meas tran vdout1_43ck180 FIND v(dout1_43) AT=190.05n

.meas tran vdout1_44ck180 FIND v(dout1_44) AT=190.05n

.meas tran vdout1_45ck180 FIND v(dout1_45) AT=190.05n

.meas tran vdout1_46ck180 FIND v(dout1_46) AT=190.05n

.meas tran vdout1_47ck180 FIND v(dout1_47) AT=190.05n

.meas tran vdout1_48ck180 FIND v(dout1_48) AT=190.05n

.meas tran vdout1_49ck180 FIND v(dout1_49) AT=190.05n

.meas tran vdout1_50ck180 FIND v(dout1_50) AT=190.05n

.meas tran vdout1_51ck180 FIND v(dout1_51) AT=190.05n

.meas tran vdout1_52ck180 FIND v(dout1_52) AT=190.05n

.meas tran vdout1_53ck180 FIND v(dout1_53) AT=190.05n

.meas tran vdout1_54ck180 FIND v(dout1_54) AT=190.05n

.meas tran vdout1_55ck180 FIND v(dout1_55) AT=190.05n

.meas tran vdout1_56ck180 FIND v(dout1_56) AT=190.05n

.meas tran vdout1_57ck180 FIND v(dout1_57) AT=190.05n

.meas tran vdout1_58ck180 FIND v(dout1_58) AT=190.05n

.meas tran vdout1_59ck180 FIND v(dout1_59) AT=190.05n

.meas tran vdout1_60ck180 FIND v(dout1_60) AT=190.05n

.meas tran vdout1_61ck180 FIND v(dout1_61) AT=190.05n

.meas tran vdout1_62ck180 FIND v(dout1_62) AT=190.05n

.meas tran vdout1_63ck180 FIND v(dout1_63) AT=190.05n

.meas tran vdout1_64ck180 FIND v(dout1_64) AT=190.05n

.meas tran vdout1_65ck180 FIND v(dout1_65) AT=190.05n

.meas tran vdout1_66ck180 FIND v(dout1_66) AT=190.05n

.meas tran vdout1_67ck180 FIND v(dout1_67) AT=190.05n

.meas tran vdout1_68ck180 FIND v(dout1_68) AT=190.05n

.meas tran vdout1_69ck180 FIND v(dout1_69) AT=190.05n

.meas tran vdout1_70ck180 FIND v(dout1_70) AT=190.05n

.meas tran vdout1_71ck180 FIND v(dout1_71) AT=190.05n

.meas tran vdout1_72ck180 FIND v(dout1_72) AT=190.05n

.meas tran vdout1_73ck180 FIND v(dout1_73) AT=190.05n

.meas tran vdout1_74ck180 FIND v(dout1_74) AT=190.05n

.meas tran vdout1_75ck180 FIND v(dout1_75) AT=190.05n

.meas tran vdout1_76ck180 FIND v(dout1_76) AT=190.05n

.meas tran vdout1_77ck180 FIND v(dout1_77) AT=190.05n

.meas tran vdout1_78ck180 FIND v(dout1_78) AT=190.05n

.meas tran vdout1_79ck180 FIND v(dout1_79) AT=190.05n

.meas tran vdout1_80ck180 FIND v(dout1_80) AT=190.05n

.meas tran vdout1_81ck180 FIND v(dout1_81) AT=190.05n

.meas tran vdout1_82ck180 FIND v(dout1_82) AT=190.05n

.meas tran vdout1_83ck180 FIND v(dout1_83) AT=190.05n

.meas tran vdout1_84ck180 FIND v(dout1_84) AT=190.05n

.meas tran vdout1_85ck180 FIND v(dout1_85) AT=190.05n

.meas tran vdout1_86ck180 FIND v(dout1_86) AT=190.05n

.meas tran vdout1_87ck180 FIND v(dout1_87) AT=190.05n

.meas tran vdout1_88ck180 FIND v(dout1_88) AT=190.05n

.meas tran vdout1_89ck180 FIND v(dout1_89) AT=190.05n

.meas tran vdout1_90ck180 FIND v(dout1_90) AT=190.05n

.meas tran vdout1_91ck180 FIND v(dout1_91) AT=190.05n

.meas tran vdout1_92ck180 FIND v(dout1_92) AT=190.05n

.meas tran vdout1_93ck180 FIND v(dout1_93) AT=190.05n

.meas tran vdout1_94ck180 FIND v(dout1_94) AT=190.05n

.meas tran vdout1_95ck180 FIND v(dout1_95) AT=190.05n

.meas tran vdout1_96ck180 FIND v(dout1_96) AT=190.05n

.meas tran vdout1_97ck180 FIND v(dout1_97) AT=190.05n

.meas tran vdout1_98ck180 FIND v(dout1_98) AT=190.05n

.meas tran vdout1_99ck180 FIND v(dout1_99) AT=190.05n

.meas tran vdout1_100ck180 FIND v(dout1_100) AT=190.05n

.meas tran vdout1_101ck180 FIND v(dout1_101) AT=190.05n

.meas tran vdout1_102ck180 FIND v(dout1_102) AT=190.05n

.meas tran vdout1_103ck180 FIND v(dout1_103) AT=190.05n

.meas tran vdout1_104ck180 FIND v(dout1_104) AT=190.05n

.meas tran vdout1_105ck180 FIND v(dout1_105) AT=190.05n

.meas tran vdout1_106ck180 FIND v(dout1_106) AT=190.05n

.meas tran vdout1_107ck180 FIND v(dout1_107) AT=190.05n

.meas tran vdout1_108ck180 FIND v(dout1_108) AT=190.05n

.meas tran vdout1_109ck180 FIND v(dout1_109) AT=190.05n

.meas tran vdout1_110ck180 FIND v(dout1_110) AT=190.05n

.meas tran vdout1_111ck180 FIND v(dout1_111) AT=190.05n

.meas tran vdout1_112ck180 FIND v(dout1_112) AT=190.05n

.meas tran vdout1_113ck180 FIND v(dout1_113) AT=190.05n

.meas tran vdout1_114ck180 FIND v(dout1_114) AT=190.05n

.meas tran vdout1_115ck180 FIND v(dout1_115) AT=190.05n

.meas tran vdout1_116ck180 FIND v(dout1_116) AT=190.05n

.meas tran vdout1_117ck180 FIND v(dout1_117) AT=190.05n

.meas tran vdout1_118ck180 FIND v(dout1_118) AT=190.05n

.meas tran vdout1_119ck180 FIND v(dout1_119) AT=190.05n

.meas tran vdout1_120ck180 FIND v(dout1_120) AT=190.05n

.meas tran vdout1_121ck180 FIND v(dout1_121) AT=190.05n

.meas tran vdout1_122ck180 FIND v(dout1_122) AT=190.05n

.meas tran vdout1_123ck180 FIND v(dout1_123) AT=190.05n

.meas tran vdout1_124ck180 FIND v(dout1_124) AT=190.05n

.meas tran vdout1_125ck180 FIND v(dout1_125) AT=190.05n

.meas tran vdout1_126ck180 FIND v(dout1_126) AT=190.05n

.meas tran vdout1_127ck180 FIND v(dout1_127) AT=190.05n

.meas tran vdout1_128ck180 FIND v(dout1_128) AT=190.05n

.meas tran vdout1_129ck180 FIND v(dout1_129) AT=190.05n

.meas tran vdout1_130ck180 FIND v(dout1_130) AT=190.05n

.meas tran vdout1_131ck180 FIND v(dout1_131) AT=190.05n

.meas tran vdout1_132ck180 FIND v(dout1_132) AT=190.05n

.meas tran vdout1_133ck180 FIND v(dout1_133) AT=190.05n

.meas tran vdout1_134ck180 FIND v(dout1_134) AT=190.05n

.meas tran vdout1_135ck180 FIND v(dout1_135) AT=190.05n

.meas tran vdout1_136ck180 FIND v(dout1_136) AT=190.05n

.meas tran vdout1_137ck180 FIND v(dout1_137) AT=190.05n

.meas tran vdout1_138ck180 FIND v(dout1_138) AT=190.05n

.meas tran vdout1_139ck180 FIND v(dout1_139) AT=190.05n

.meas tran vdout1_140ck180 FIND v(dout1_140) AT=190.05n

.meas tran vdout1_141ck180 FIND v(dout1_141) AT=190.05n

.meas tran vdout1_142ck180 FIND v(dout1_142) AT=190.05n

.meas tran vdout1_143ck180 FIND v(dout1_143) AT=190.05n

.meas tran vdout1_144ck180 FIND v(dout1_144) AT=190.05n

.meas tran vdout1_145ck180 FIND v(dout1_145) AT=190.05n

.meas tran vdout1_146ck180 FIND v(dout1_146) AT=190.05n

.meas tran vdout1_147ck180 FIND v(dout1_147) AT=190.05n

.meas tran vdout1_148ck180 FIND v(dout1_148) AT=190.05n

.meas tran vdout1_149ck180 FIND v(dout1_149) AT=190.05n

.meas tran vdout1_150ck180 FIND v(dout1_150) AT=190.05n

.meas tran vdout1_151ck180 FIND v(dout1_151) AT=190.05n

.meas tran vdout1_152ck180 FIND v(dout1_152) AT=190.05n

.meas tran vdout1_153ck180 FIND v(dout1_153) AT=190.05n

.meas tran vdout1_154ck180 FIND v(dout1_154) AT=190.05n

.meas tran vdout1_155ck180 FIND v(dout1_155) AT=190.05n

.meas tran vdout1_156ck180 FIND v(dout1_156) AT=190.05n

.meas tran vdout1_157ck180 FIND v(dout1_157) AT=190.05n

.meas tran vdout1_158ck180 FIND v(dout1_158) AT=190.05n

.meas tran vdout1_159ck180 FIND v(dout1_159) AT=190.05n

.meas tran vdout1_160ck180 FIND v(dout1_160) AT=190.05n

.meas tran vdout1_161ck180 FIND v(dout1_161) AT=190.05n

.meas tran vdout1_162ck180 FIND v(dout1_162) AT=190.05n

.meas tran vdout1_163ck180 FIND v(dout1_163) AT=190.05n

.meas tran vdout1_164ck180 FIND v(dout1_164) AT=190.05n

.meas tran vdout1_165ck180 FIND v(dout1_165) AT=190.05n

.meas tran vdout1_166ck180 FIND v(dout1_166) AT=190.05n

.meas tran vdout1_167ck180 FIND v(dout1_167) AT=190.05n

.meas tran vdout1_168ck180 FIND v(dout1_168) AT=190.05n

.meas tran vdout1_169ck180 FIND v(dout1_169) AT=190.05n

.meas tran vdout1_170ck180 FIND v(dout1_170) AT=190.05n

.meas tran vdout1_171ck180 FIND v(dout1_171) AT=190.05n

.meas tran vdout1_172ck180 FIND v(dout1_172) AT=190.05n

.meas tran vdout1_173ck180 FIND v(dout1_173) AT=190.05n

.meas tran vdout1_174ck180 FIND v(dout1_174) AT=190.05n

.meas tran vdout1_175ck180 FIND v(dout1_175) AT=190.05n

.meas tran vdout1_176ck180 FIND v(dout1_176) AT=190.05n

.meas tran vdout1_177ck180 FIND v(dout1_177) AT=190.05n

.meas tran vdout1_178ck180 FIND v(dout1_178) AT=190.05n

.meas tran vdout1_179ck180 FIND v(dout1_179) AT=190.05n

.meas tran vdout1_180ck180 FIND v(dout1_180) AT=190.05n

.meas tran vdout1_181ck180 FIND v(dout1_181) AT=190.05n

.meas tran vdout1_182ck180 FIND v(dout1_182) AT=190.05n

.meas tran vdout1_183ck180 FIND v(dout1_183) AT=190.05n

.meas tran vdout1_184ck180 FIND v(dout1_184) AT=190.05n

.meas tran vdout1_185ck180 FIND v(dout1_185) AT=190.05n

.meas tran vdout1_186ck180 FIND v(dout1_186) AT=190.05n

.meas tran vdout1_187ck180 FIND v(dout1_187) AT=190.05n

.meas tran vdout1_188ck180 FIND v(dout1_188) AT=190.05n

.meas tran vdout1_189ck180 FIND v(dout1_189) AT=190.05n

.meas tran vdout1_190ck180 FIND v(dout1_190) AT=190.05n

.meas tran vdout1_191ck180 FIND v(dout1_191) AT=190.05n

.meas tran vdout1_192ck180 FIND v(dout1_192) AT=190.05n

.meas tran vdout1_193ck180 FIND v(dout1_193) AT=190.05n

.meas tran vdout1_194ck180 FIND v(dout1_194) AT=190.05n

.meas tran vdout1_195ck180 FIND v(dout1_195) AT=190.05n

.meas tran vdout1_196ck180 FIND v(dout1_196) AT=190.05n

.meas tran vdout1_197ck180 FIND v(dout1_197) AT=190.05n

.meas tran vdout1_198ck180 FIND v(dout1_198) AT=190.05n

.meas tran vdout1_199ck180 FIND v(dout1_199) AT=190.05n

.meas tran vdout1_200ck180 FIND v(dout1_200) AT=190.05n

.meas tran vdout1_201ck180 FIND v(dout1_201) AT=190.05n

.meas tran vdout1_202ck180 FIND v(dout1_202) AT=190.05n

.meas tran vdout1_203ck180 FIND v(dout1_203) AT=190.05n

.meas tran vdout1_204ck180 FIND v(dout1_204) AT=190.05n

.meas tran vdout1_205ck180 FIND v(dout1_205) AT=190.05n

.meas tran vdout1_206ck180 FIND v(dout1_206) AT=190.05n

.meas tran vdout1_207ck180 FIND v(dout1_207) AT=190.05n

.meas tran vdout1_208ck180 FIND v(dout1_208) AT=190.05n

.meas tran vdout1_209ck180 FIND v(dout1_209) AT=190.05n

.meas tran vdout1_210ck180 FIND v(dout1_210) AT=190.05n

.meas tran vdout1_211ck180 FIND v(dout1_211) AT=190.05n

.meas tran vdout1_212ck180 FIND v(dout1_212) AT=190.05n

.meas tran vdout1_213ck180 FIND v(dout1_213) AT=190.05n

.meas tran vdout1_214ck180 FIND v(dout1_214) AT=190.05n

.meas tran vdout1_215ck180 FIND v(dout1_215) AT=190.05n

.meas tran vdout1_216ck180 FIND v(dout1_216) AT=190.05n

.meas tran vdout1_217ck180 FIND v(dout1_217) AT=190.05n

.meas tran vdout1_218ck180 FIND v(dout1_218) AT=190.05n

.meas tran vdout1_219ck180 FIND v(dout1_219) AT=190.05n

.meas tran vdout1_220ck180 FIND v(dout1_220) AT=190.05n

.meas tran vdout1_221ck180 FIND v(dout1_221) AT=190.05n

.meas tran vdout1_222ck180 FIND v(dout1_222) AT=190.05n

.meas tran vdout1_223ck180 FIND v(dout1_223) AT=190.05n

.meas tran vdout1_224ck180 FIND v(dout1_224) AT=190.05n

.meas tran vdout1_225ck180 FIND v(dout1_225) AT=190.05n

.meas tran vdout1_226ck180 FIND v(dout1_226) AT=190.05n

.meas tran vdout1_227ck180 FIND v(dout1_227) AT=190.05n

.meas tran vdout1_228ck180 FIND v(dout1_228) AT=190.05n

.meas tran vdout1_229ck180 FIND v(dout1_229) AT=190.05n

.meas tran vdout1_230ck180 FIND v(dout1_230) AT=190.05n

.meas tran vdout1_231ck180 FIND v(dout1_231) AT=190.05n

.meas tran vdout1_232ck180 FIND v(dout1_232) AT=190.05n

.meas tran vdout1_233ck180 FIND v(dout1_233) AT=190.05n

.meas tran vdout1_234ck180 FIND v(dout1_234) AT=190.05n

.meas tran vdout1_235ck180 FIND v(dout1_235) AT=190.05n

.meas tran vdout1_236ck180 FIND v(dout1_236) AT=190.05n

.meas tran vdout1_237ck180 FIND v(dout1_237) AT=190.05n

.meas tran vdout1_238ck180 FIND v(dout1_238) AT=190.05n

.meas tran vdout1_239ck180 FIND v(dout1_239) AT=190.05n

.meas tran vdout1_240ck180 FIND v(dout1_240) AT=190.05n

.meas tran vdout1_241ck180 FIND v(dout1_241) AT=190.05n

.meas tran vdout1_242ck180 FIND v(dout1_242) AT=190.05n

.meas tran vdout1_243ck180 FIND v(dout1_243) AT=190.05n

.meas tran vdout1_244ck180 FIND v(dout1_244) AT=190.05n

.meas tran vdout1_245ck180 FIND v(dout1_245) AT=190.05n

.meas tran vdout1_246ck180 FIND v(dout1_246) AT=190.05n

.meas tran vdout1_247ck180 FIND v(dout1_247) AT=190.05n

.meas tran vdout1_248ck180 FIND v(dout1_248) AT=190.05n

.meas tran vdout1_249ck180 FIND v(dout1_249) AT=190.05n

.meas tran vdout1_250ck180 FIND v(dout1_250) AT=190.05n

.meas tran vdout1_251ck180 FIND v(dout1_251) AT=190.05n

.meas tran vdout1_252ck180 FIND v(dout1_252) AT=190.05n

.meas tran vdout1_253ck180 FIND v(dout1_253) AT=190.05n

.meas tran vdout1_254ck180 FIND v(dout1_254) AT=190.05n

.meas tran vdout1_255ck180 FIND v(dout1_255) AT=190.05n

.meas tran vdout1_256ck180 FIND v(dout1_256) AT=190.05n

.meas tran vdout1_0ck190 FIND v(dout1_0) AT=200.05n

.meas tran vdout1_1ck190 FIND v(dout1_1) AT=200.05n

.meas tran vdout1_2ck190 FIND v(dout1_2) AT=200.05n

.meas tran vdout1_3ck190 FIND v(dout1_3) AT=200.05n

.meas tran vdout1_4ck190 FIND v(dout1_4) AT=200.05n

.meas tran vdout1_5ck190 FIND v(dout1_5) AT=200.05n

.meas tran vdout1_6ck190 FIND v(dout1_6) AT=200.05n

.meas tran vdout1_7ck190 FIND v(dout1_7) AT=200.05n

.meas tran vdout1_8ck190 FIND v(dout1_8) AT=200.05n

.meas tran vdout1_9ck190 FIND v(dout1_9) AT=200.05n

.meas tran vdout1_10ck190 FIND v(dout1_10) AT=200.05n

.meas tran vdout1_11ck190 FIND v(dout1_11) AT=200.05n

.meas tran vdout1_12ck190 FIND v(dout1_12) AT=200.05n

.meas tran vdout1_13ck190 FIND v(dout1_13) AT=200.05n

.meas tran vdout1_14ck190 FIND v(dout1_14) AT=200.05n

.meas tran vdout1_15ck190 FIND v(dout1_15) AT=200.05n

.meas tran vdout1_16ck190 FIND v(dout1_16) AT=200.05n

.meas tran vdout1_17ck190 FIND v(dout1_17) AT=200.05n

.meas tran vdout1_18ck190 FIND v(dout1_18) AT=200.05n

.meas tran vdout1_19ck190 FIND v(dout1_19) AT=200.05n

.meas tran vdout1_20ck190 FIND v(dout1_20) AT=200.05n

.meas tran vdout1_21ck190 FIND v(dout1_21) AT=200.05n

.meas tran vdout1_22ck190 FIND v(dout1_22) AT=200.05n

.meas tran vdout1_23ck190 FIND v(dout1_23) AT=200.05n

.meas tran vdout1_24ck190 FIND v(dout1_24) AT=200.05n

.meas tran vdout1_25ck190 FIND v(dout1_25) AT=200.05n

.meas tran vdout1_26ck190 FIND v(dout1_26) AT=200.05n

.meas tran vdout1_27ck190 FIND v(dout1_27) AT=200.05n

.meas tran vdout1_28ck190 FIND v(dout1_28) AT=200.05n

.meas tran vdout1_29ck190 FIND v(dout1_29) AT=200.05n

.meas tran vdout1_30ck190 FIND v(dout1_30) AT=200.05n

.meas tran vdout1_31ck190 FIND v(dout1_31) AT=200.05n

.meas tran vdout1_32ck190 FIND v(dout1_32) AT=200.05n

.meas tran vdout1_33ck190 FIND v(dout1_33) AT=200.05n

.meas tran vdout1_34ck190 FIND v(dout1_34) AT=200.05n

.meas tran vdout1_35ck190 FIND v(dout1_35) AT=200.05n

.meas tran vdout1_36ck190 FIND v(dout1_36) AT=200.05n

.meas tran vdout1_37ck190 FIND v(dout1_37) AT=200.05n

.meas tran vdout1_38ck190 FIND v(dout1_38) AT=200.05n

.meas tran vdout1_39ck190 FIND v(dout1_39) AT=200.05n

.meas tran vdout1_40ck190 FIND v(dout1_40) AT=200.05n

.meas tran vdout1_41ck190 FIND v(dout1_41) AT=200.05n

.meas tran vdout1_42ck190 FIND v(dout1_42) AT=200.05n

.meas tran vdout1_43ck190 FIND v(dout1_43) AT=200.05n

.meas tran vdout1_44ck190 FIND v(dout1_44) AT=200.05n

.meas tran vdout1_45ck190 FIND v(dout1_45) AT=200.05n

.meas tran vdout1_46ck190 FIND v(dout1_46) AT=200.05n

.meas tran vdout1_47ck190 FIND v(dout1_47) AT=200.05n

.meas tran vdout1_48ck190 FIND v(dout1_48) AT=200.05n

.meas tran vdout1_49ck190 FIND v(dout1_49) AT=200.05n

.meas tran vdout1_50ck190 FIND v(dout1_50) AT=200.05n

.meas tran vdout1_51ck190 FIND v(dout1_51) AT=200.05n

.meas tran vdout1_52ck190 FIND v(dout1_52) AT=200.05n

.meas tran vdout1_53ck190 FIND v(dout1_53) AT=200.05n

.meas tran vdout1_54ck190 FIND v(dout1_54) AT=200.05n

.meas tran vdout1_55ck190 FIND v(dout1_55) AT=200.05n

.meas tran vdout1_56ck190 FIND v(dout1_56) AT=200.05n

.meas tran vdout1_57ck190 FIND v(dout1_57) AT=200.05n

.meas tran vdout1_58ck190 FIND v(dout1_58) AT=200.05n

.meas tran vdout1_59ck190 FIND v(dout1_59) AT=200.05n

.meas tran vdout1_60ck190 FIND v(dout1_60) AT=200.05n

.meas tran vdout1_61ck190 FIND v(dout1_61) AT=200.05n

.meas tran vdout1_62ck190 FIND v(dout1_62) AT=200.05n

.meas tran vdout1_63ck190 FIND v(dout1_63) AT=200.05n

.meas tran vdout1_64ck190 FIND v(dout1_64) AT=200.05n

.meas tran vdout1_65ck190 FIND v(dout1_65) AT=200.05n

.meas tran vdout1_66ck190 FIND v(dout1_66) AT=200.05n

.meas tran vdout1_67ck190 FIND v(dout1_67) AT=200.05n

.meas tran vdout1_68ck190 FIND v(dout1_68) AT=200.05n

.meas tran vdout1_69ck190 FIND v(dout1_69) AT=200.05n

.meas tran vdout1_70ck190 FIND v(dout1_70) AT=200.05n

.meas tran vdout1_71ck190 FIND v(dout1_71) AT=200.05n

.meas tran vdout1_72ck190 FIND v(dout1_72) AT=200.05n

.meas tran vdout1_73ck190 FIND v(dout1_73) AT=200.05n

.meas tran vdout1_74ck190 FIND v(dout1_74) AT=200.05n

.meas tran vdout1_75ck190 FIND v(dout1_75) AT=200.05n

.meas tran vdout1_76ck190 FIND v(dout1_76) AT=200.05n

.meas tran vdout1_77ck190 FIND v(dout1_77) AT=200.05n

.meas tran vdout1_78ck190 FIND v(dout1_78) AT=200.05n

.meas tran vdout1_79ck190 FIND v(dout1_79) AT=200.05n

.meas tran vdout1_80ck190 FIND v(dout1_80) AT=200.05n

.meas tran vdout1_81ck190 FIND v(dout1_81) AT=200.05n

.meas tran vdout1_82ck190 FIND v(dout1_82) AT=200.05n

.meas tran vdout1_83ck190 FIND v(dout1_83) AT=200.05n

.meas tran vdout1_84ck190 FIND v(dout1_84) AT=200.05n

.meas tran vdout1_85ck190 FIND v(dout1_85) AT=200.05n

.meas tran vdout1_86ck190 FIND v(dout1_86) AT=200.05n

.meas tran vdout1_87ck190 FIND v(dout1_87) AT=200.05n

.meas tran vdout1_88ck190 FIND v(dout1_88) AT=200.05n

.meas tran vdout1_89ck190 FIND v(dout1_89) AT=200.05n

.meas tran vdout1_90ck190 FIND v(dout1_90) AT=200.05n

.meas tran vdout1_91ck190 FIND v(dout1_91) AT=200.05n

.meas tran vdout1_92ck190 FIND v(dout1_92) AT=200.05n

.meas tran vdout1_93ck190 FIND v(dout1_93) AT=200.05n

.meas tran vdout1_94ck190 FIND v(dout1_94) AT=200.05n

.meas tran vdout1_95ck190 FIND v(dout1_95) AT=200.05n

.meas tran vdout1_96ck190 FIND v(dout1_96) AT=200.05n

.meas tran vdout1_97ck190 FIND v(dout1_97) AT=200.05n

.meas tran vdout1_98ck190 FIND v(dout1_98) AT=200.05n

.meas tran vdout1_99ck190 FIND v(dout1_99) AT=200.05n

.meas tran vdout1_100ck190 FIND v(dout1_100) AT=200.05n

.meas tran vdout1_101ck190 FIND v(dout1_101) AT=200.05n

.meas tran vdout1_102ck190 FIND v(dout1_102) AT=200.05n

.meas tran vdout1_103ck190 FIND v(dout1_103) AT=200.05n

.meas tran vdout1_104ck190 FIND v(dout1_104) AT=200.05n

.meas tran vdout1_105ck190 FIND v(dout1_105) AT=200.05n

.meas tran vdout1_106ck190 FIND v(dout1_106) AT=200.05n

.meas tran vdout1_107ck190 FIND v(dout1_107) AT=200.05n

.meas tran vdout1_108ck190 FIND v(dout1_108) AT=200.05n

.meas tran vdout1_109ck190 FIND v(dout1_109) AT=200.05n

.meas tran vdout1_110ck190 FIND v(dout1_110) AT=200.05n

.meas tran vdout1_111ck190 FIND v(dout1_111) AT=200.05n

.meas tran vdout1_112ck190 FIND v(dout1_112) AT=200.05n

.meas tran vdout1_113ck190 FIND v(dout1_113) AT=200.05n

.meas tran vdout1_114ck190 FIND v(dout1_114) AT=200.05n

.meas tran vdout1_115ck190 FIND v(dout1_115) AT=200.05n

.meas tran vdout1_116ck190 FIND v(dout1_116) AT=200.05n

.meas tran vdout1_117ck190 FIND v(dout1_117) AT=200.05n

.meas tran vdout1_118ck190 FIND v(dout1_118) AT=200.05n

.meas tran vdout1_119ck190 FIND v(dout1_119) AT=200.05n

.meas tran vdout1_120ck190 FIND v(dout1_120) AT=200.05n

.meas tran vdout1_121ck190 FIND v(dout1_121) AT=200.05n

.meas tran vdout1_122ck190 FIND v(dout1_122) AT=200.05n

.meas tran vdout1_123ck190 FIND v(dout1_123) AT=200.05n

.meas tran vdout1_124ck190 FIND v(dout1_124) AT=200.05n

.meas tran vdout1_125ck190 FIND v(dout1_125) AT=200.05n

.meas tran vdout1_126ck190 FIND v(dout1_126) AT=200.05n

.meas tran vdout1_127ck190 FIND v(dout1_127) AT=200.05n

.meas tran vdout1_128ck190 FIND v(dout1_128) AT=200.05n

.meas tran vdout1_129ck190 FIND v(dout1_129) AT=200.05n

.meas tran vdout1_130ck190 FIND v(dout1_130) AT=200.05n

.meas tran vdout1_131ck190 FIND v(dout1_131) AT=200.05n

.meas tran vdout1_132ck190 FIND v(dout1_132) AT=200.05n

.meas tran vdout1_133ck190 FIND v(dout1_133) AT=200.05n

.meas tran vdout1_134ck190 FIND v(dout1_134) AT=200.05n

.meas tran vdout1_135ck190 FIND v(dout1_135) AT=200.05n

.meas tran vdout1_136ck190 FIND v(dout1_136) AT=200.05n

.meas tran vdout1_137ck190 FIND v(dout1_137) AT=200.05n

.meas tran vdout1_138ck190 FIND v(dout1_138) AT=200.05n

.meas tran vdout1_139ck190 FIND v(dout1_139) AT=200.05n

.meas tran vdout1_140ck190 FIND v(dout1_140) AT=200.05n

.meas tran vdout1_141ck190 FIND v(dout1_141) AT=200.05n

.meas tran vdout1_142ck190 FIND v(dout1_142) AT=200.05n

.meas tran vdout1_143ck190 FIND v(dout1_143) AT=200.05n

.meas tran vdout1_144ck190 FIND v(dout1_144) AT=200.05n

.meas tran vdout1_145ck190 FIND v(dout1_145) AT=200.05n

.meas tran vdout1_146ck190 FIND v(dout1_146) AT=200.05n

.meas tran vdout1_147ck190 FIND v(dout1_147) AT=200.05n

.meas tran vdout1_148ck190 FIND v(dout1_148) AT=200.05n

.meas tran vdout1_149ck190 FIND v(dout1_149) AT=200.05n

.meas tran vdout1_150ck190 FIND v(dout1_150) AT=200.05n

.meas tran vdout1_151ck190 FIND v(dout1_151) AT=200.05n

.meas tran vdout1_152ck190 FIND v(dout1_152) AT=200.05n

.meas tran vdout1_153ck190 FIND v(dout1_153) AT=200.05n

.meas tran vdout1_154ck190 FIND v(dout1_154) AT=200.05n

.meas tran vdout1_155ck190 FIND v(dout1_155) AT=200.05n

.meas tran vdout1_156ck190 FIND v(dout1_156) AT=200.05n

.meas tran vdout1_157ck190 FIND v(dout1_157) AT=200.05n

.meas tran vdout1_158ck190 FIND v(dout1_158) AT=200.05n

.meas tran vdout1_159ck190 FIND v(dout1_159) AT=200.05n

.meas tran vdout1_160ck190 FIND v(dout1_160) AT=200.05n

.meas tran vdout1_161ck190 FIND v(dout1_161) AT=200.05n

.meas tran vdout1_162ck190 FIND v(dout1_162) AT=200.05n

.meas tran vdout1_163ck190 FIND v(dout1_163) AT=200.05n

.meas tran vdout1_164ck190 FIND v(dout1_164) AT=200.05n

.meas tran vdout1_165ck190 FIND v(dout1_165) AT=200.05n

.meas tran vdout1_166ck190 FIND v(dout1_166) AT=200.05n

.meas tran vdout1_167ck190 FIND v(dout1_167) AT=200.05n

.meas tran vdout1_168ck190 FIND v(dout1_168) AT=200.05n

.meas tran vdout1_169ck190 FIND v(dout1_169) AT=200.05n

.meas tran vdout1_170ck190 FIND v(dout1_170) AT=200.05n

.meas tran vdout1_171ck190 FIND v(dout1_171) AT=200.05n

.meas tran vdout1_172ck190 FIND v(dout1_172) AT=200.05n

.meas tran vdout1_173ck190 FIND v(dout1_173) AT=200.05n

.meas tran vdout1_174ck190 FIND v(dout1_174) AT=200.05n

.meas tran vdout1_175ck190 FIND v(dout1_175) AT=200.05n

.meas tran vdout1_176ck190 FIND v(dout1_176) AT=200.05n

.meas tran vdout1_177ck190 FIND v(dout1_177) AT=200.05n

.meas tran vdout1_178ck190 FIND v(dout1_178) AT=200.05n

.meas tran vdout1_179ck190 FIND v(dout1_179) AT=200.05n

.meas tran vdout1_180ck190 FIND v(dout1_180) AT=200.05n

.meas tran vdout1_181ck190 FIND v(dout1_181) AT=200.05n

.meas tran vdout1_182ck190 FIND v(dout1_182) AT=200.05n

.meas tran vdout1_183ck190 FIND v(dout1_183) AT=200.05n

.meas tran vdout1_184ck190 FIND v(dout1_184) AT=200.05n

.meas tran vdout1_185ck190 FIND v(dout1_185) AT=200.05n

.meas tran vdout1_186ck190 FIND v(dout1_186) AT=200.05n

.meas tran vdout1_187ck190 FIND v(dout1_187) AT=200.05n

.meas tran vdout1_188ck190 FIND v(dout1_188) AT=200.05n

.meas tran vdout1_189ck190 FIND v(dout1_189) AT=200.05n

.meas tran vdout1_190ck190 FIND v(dout1_190) AT=200.05n

.meas tran vdout1_191ck190 FIND v(dout1_191) AT=200.05n

.meas tran vdout1_192ck190 FIND v(dout1_192) AT=200.05n

.meas tran vdout1_193ck190 FIND v(dout1_193) AT=200.05n

.meas tran vdout1_194ck190 FIND v(dout1_194) AT=200.05n

.meas tran vdout1_195ck190 FIND v(dout1_195) AT=200.05n

.meas tran vdout1_196ck190 FIND v(dout1_196) AT=200.05n

.meas tran vdout1_197ck190 FIND v(dout1_197) AT=200.05n

.meas tran vdout1_198ck190 FIND v(dout1_198) AT=200.05n

.meas tran vdout1_199ck190 FIND v(dout1_199) AT=200.05n

.meas tran vdout1_200ck190 FIND v(dout1_200) AT=200.05n

.meas tran vdout1_201ck190 FIND v(dout1_201) AT=200.05n

.meas tran vdout1_202ck190 FIND v(dout1_202) AT=200.05n

.meas tran vdout1_203ck190 FIND v(dout1_203) AT=200.05n

.meas tran vdout1_204ck190 FIND v(dout1_204) AT=200.05n

.meas tran vdout1_205ck190 FIND v(dout1_205) AT=200.05n

.meas tran vdout1_206ck190 FIND v(dout1_206) AT=200.05n

.meas tran vdout1_207ck190 FIND v(dout1_207) AT=200.05n

.meas tran vdout1_208ck190 FIND v(dout1_208) AT=200.05n

.meas tran vdout1_209ck190 FIND v(dout1_209) AT=200.05n

.meas tran vdout1_210ck190 FIND v(dout1_210) AT=200.05n

.meas tran vdout1_211ck190 FIND v(dout1_211) AT=200.05n

.meas tran vdout1_212ck190 FIND v(dout1_212) AT=200.05n

.meas tran vdout1_213ck190 FIND v(dout1_213) AT=200.05n

.meas tran vdout1_214ck190 FIND v(dout1_214) AT=200.05n

.meas tran vdout1_215ck190 FIND v(dout1_215) AT=200.05n

.meas tran vdout1_216ck190 FIND v(dout1_216) AT=200.05n

.meas tran vdout1_217ck190 FIND v(dout1_217) AT=200.05n

.meas tran vdout1_218ck190 FIND v(dout1_218) AT=200.05n

.meas tran vdout1_219ck190 FIND v(dout1_219) AT=200.05n

.meas tran vdout1_220ck190 FIND v(dout1_220) AT=200.05n

.meas tran vdout1_221ck190 FIND v(dout1_221) AT=200.05n

.meas tran vdout1_222ck190 FIND v(dout1_222) AT=200.05n

.meas tran vdout1_223ck190 FIND v(dout1_223) AT=200.05n

.meas tran vdout1_224ck190 FIND v(dout1_224) AT=200.05n

.meas tran vdout1_225ck190 FIND v(dout1_225) AT=200.05n

.meas tran vdout1_226ck190 FIND v(dout1_226) AT=200.05n

.meas tran vdout1_227ck190 FIND v(dout1_227) AT=200.05n

.meas tran vdout1_228ck190 FIND v(dout1_228) AT=200.05n

.meas tran vdout1_229ck190 FIND v(dout1_229) AT=200.05n

.meas tran vdout1_230ck190 FIND v(dout1_230) AT=200.05n

.meas tran vdout1_231ck190 FIND v(dout1_231) AT=200.05n

.meas tran vdout1_232ck190 FIND v(dout1_232) AT=200.05n

.meas tran vdout1_233ck190 FIND v(dout1_233) AT=200.05n

.meas tran vdout1_234ck190 FIND v(dout1_234) AT=200.05n

.meas tran vdout1_235ck190 FIND v(dout1_235) AT=200.05n

.meas tran vdout1_236ck190 FIND v(dout1_236) AT=200.05n

.meas tran vdout1_237ck190 FIND v(dout1_237) AT=200.05n

.meas tran vdout1_238ck190 FIND v(dout1_238) AT=200.05n

.meas tran vdout1_239ck190 FIND v(dout1_239) AT=200.05n

.meas tran vdout1_240ck190 FIND v(dout1_240) AT=200.05n

.meas tran vdout1_241ck190 FIND v(dout1_241) AT=200.05n

.meas tran vdout1_242ck190 FIND v(dout1_242) AT=200.05n

.meas tran vdout1_243ck190 FIND v(dout1_243) AT=200.05n

.meas tran vdout1_244ck190 FIND v(dout1_244) AT=200.05n

.meas tran vdout1_245ck190 FIND v(dout1_245) AT=200.05n

.meas tran vdout1_246ck190 FIND v(dout1_246) AT=200.05n

.meas tran vdout1_247ck190 FIND v(dout1_247) AT=200.05n

.meas tran vdout1_248ck190 FIND v(dout1_248) AT=200.05n

.meas tran vdout1_249ck190 FIND v(dout1_249) AT=200.05n

.meas tran vdout1_250ck190 FIND v(dout1_250) AT=200.05n

.meas tran vdout1_251ck190 FIND v(dout1_251) AT=200.05n

.meas tran vdout1_252ck190 FIND v(dout1_252) AT=200.05n

.meas tran vdout1_253ck190 FIND v(dout1_253) AT=200.05n

.meas tran vdout1_254ck190 FIND v(dout1_254) AT=200.05n

.meas tran vdout1_255ck190 FIND v(dout1_255) AT=200.05n

.meas tran vdout1_256ck190 FIND v(dout1_256) AT=200.05n

.meas tran vdout1_0ck210 FIND v(dout1_0) AT=220.05n

.meas tran vdout1_1ck210 FIND v(dout1_1) AT=220.05n

.meas tran vdout1_2ck210 FIND v(dout1_2) AT=220.05n

.meas tran vdout1_3ck210 FIND v(dout1_3) AT=220.05n

.meas tran vdout1_4ck210 FIND v(dout1_4) AT=220.05n

.meas tran vdout1_5ck210 FIND v(dout1_5) AT=220.05n

.meas tran vdout1_6ck210 FIND v(dout1_6) AT=220.05n

.meas tran vdout1_7ck210 FIND v(dout1_7) AT=220.05n

.meas tran vdout1_8ck210 FIND v(dout1_8) AT=220.05n

.meas tran vdout1_9ck210 FIND v(dout1_9) AT=220.05n

.meas tran vdout1_10ck210 FIND v(dout1_10) AT=220.05n

.meas tran vdout1_11ck210 FIND v(dout1_11) AT=220.05n

.meas tran vdout1_12ck210 FIND v(dout1_12) AT=220.05n

.meas tran vdout1_13ck210 FIND v(dout1_13) AT=220.05n

.meas tran vdout1_14ck210 FIND v(dout1_14) AT=220.05n

.meas tran vdout1_15ck210 FIND v(dout1_15) AT=220.05n

.meas tran vdout1_16ck210 FIND v(dout1_16) AT=220.05n

.meas tran vdout1_17ck210 FIND v(dout1_17) AT=220.05n

.meas tran vdout1_18ck210 FIND v(dout1_18) AT=220.05n

.meas tran vdout1_19ck210 FIND v(dout1_19) AT=220.05n

.meas tran vdout1_20ck210 FIND v(dout1_20) AT=220.05n

.meas tran vdout1_21ck210 FIND v(dout1_21) AT=220.05n

.meas tran vdout1_22ck210 FIND v(dout1_22) AT=220.05n

.meas tran vdout1_23ck210 FIND v(dout1_23) AT=220.05n

.meas tran vdout1_24ck210 FIND v(dout1_24) AT=220.05n

.meas tran vdout1_25ck210 FIND v(dout1_25) AT=220.05n

.meas tran vdout1_26ck210 FIND v(dout1_26) AT=220.05n

.meas tran vdout1_27ck210 FIND v(dout1_27) AT=220.05n

.meas tran vdout1_28ck210 FIND v(dout1_28) AT=220.05n

.meas tran vdout1_29ck210 FIND v(dout1_29) AT=220.05n

.meas tran vdout1_30ck210 FIND v(dout1_30) AT=220.05n

.meas tran vdout1_31ck210 FIND v(dout1_31) AT=220.05n

.meas tran vdout1_32ck210 FIND v(dout1_32) AT=220.05n

.meas tran vdout1_33ck210 FIND v(dout1_33) AT=220.05n

.meas tran vdout1_34ck210 FIND v(dout1_34) AT=220.05n

.meas tran vdout1_35ck210 FIND v(dout1_35) AT=220.05n

.meas tran vdout1_36ck210 FIND v(dout1_36) AT=220.05n

.meas tran vdout1_37ck210 FIND v(dout1_37) AT=220.05n

.meas tran vdout1_38ck210 FIND v(dout1_38) AT=220.05n

.meas tran vdout1_39ck210 FIND v(dout1_39) AT=220.05n

.meas tran vdout1_40ck210 FIND v(dout1_40) AT=220.05n

.meas tran vdout1_41ck210 FIND v(dout1_41) AT=220.05n

.meas tran vdout1_42ck210 FIND v(dout1_42) AT=220.05n

.meas tran vdout1_43ck210 FIND v(dout1_43) AT=220.05n

.meas tran vdout1_44ck210 FIND v(dout1_44) AT=220.05n

.meas tran vdout1_45ck210 FIND v(dout1_45) AT=220.05n

.meas tran vdout1_46ck210 FIND v(dout1_46) AT=220.05n

.meas tran vdout1_47ck210 FIND v(dout1_47) AT=220.05n

.meas tran vdout1_48ck210 FIND v(dout1_48) AT=220.05n

.meas tran vdout1_49ck210 FIND v(dout1_49) AT=220.05n

.meas tran vdout1_50ck210 FIND v(dout1_50) AT=220.05n

.meas tran vdout1_51ck210 FIND v(dout1_51) AT=220.05n

.meas tran vdout1_52ck210 FIND v(dout1_52) AT=220.05n

.meas tran vdout1_53ck210 FIND v(dout1_53) AT=220.05n

.meas tran vdout1_54ck210 FIND v(dout1_54) AT=220.05n

.meas tran vdout1_55ck210 FIND v(dout1_55) AT=220.05n

.meas tran vdout1_56ck210 FIND v(dout1_56) AT=220.05n

.meas tran vdout1_57ck210 FIND v(dout1_57) AT=220.05n

.meas tran vdout1_58ck210 FIND v(dout1_58) AT=220.05n

.meas tran vdout1_59ck210 FIND v(dout1_59) AT=220.05n

.meas tran vdout1_60ck210 FIND v(dout1_60) AT=220.05n

.meas tran vdout1_61ck210 FIND v(dout1_61) AT=220.05n

.meas tran vdout1_62ck210 FIND v(dout1_62) AT=220.05n

.meas tran vdout1_63ck210 FIND v(dout1_63) AT=220.05n

.meas tran vdout1_64ck210 FIND v(dout1_64) AT=220.05n

.meas tran vdout1_65ck210 FIND v(dout1_65) AT=220.05n

.meas tran vdout1_66ck210 FIND v(dout1_66) AT=220.05n

.meas tran vdout1_67ck210 FIND v(dout1_67) AT=220.05n

.meas tran vdout1_68ck210 FIND v(dout1_68) AT=220.05n

.meas tran vdout1_69ck210 FIND v(dout1_69) AT=220.05n

.meas tran vdout1_70ck210 FIND v(dout1_70) AT=220.05n

.meas tran vdout1_71ck210 FIND v(dout1_71) AT=220.05n

.meas tran vdout1_72ck210 FIND v(dout1_72) AT=220.05n

.meas tran vdout1_73ck210 FIND v(dout1_73) AT=220.05n

.meas tran vdout1_74ck210 FIND v(dout1_74) AT=220.05n

.meas tran vdout1_75ck210 FIND v(dout1_75) AT=220.05n

.meas tran vdout1_76ck210 FIND v(dout1_76) AT=220.05n

.meas tran vdout1_77ck210 FIND v(dout1_77) AT=220.05n

.meas tran vdout1_78ck210 FIND v(dout1_78) AT=220.05n

.meas tran vdout1_79ck210 FIND v(dout1_79) AT=220.05n

.meas tran vdout1_80ck210 FIND v(dout1_80) AT=220.05n

.meas tran vdout1_81ck210 FIND v(dout1_81) AT=220.05n

.meas tran vdout1_82ck210 FIND v(dout1_82) AT=220.05n

.meas tran vdout1_83ck210 FIND v(dout1_83) AT=220.05n

.meas tran vdout1_84ck210 FIND v(dout1_84) AT=220.05n

.meas tran vdout1_85ck210 FIND v(dout1_85) AT=220.05n

.meas tran vdout1_86ck210 FIND v(dout1_86) AT=220.05n

.meas tran vdout1_87ck210 FIND v(dout1_87) AT=220.05n

.meas tran vdout1_88ck210 FIND v(dout1_88) AT=220.05n

.meas tran vdout1_89ck210 FIND v(dout1_89) AT=220.05n

.meas tran vdout1_90ck210 FIND v(dout1_90) AT=220.05n

.meas tran vdout1_91ck210 FIND v(dout1_91) AT=220.05n

.meas tran vdout1_92ck210 FIND v(dout1_92) AT=220.05n

.meas tran vdout1_93ck210 FIND v(dout1_93) AT=220.05n

.meas tran vdout1_94ck210 FIND v(dout1_94) AT=220.05n

.meas tran vdout1_95ck210 FIND v(dout1_95) AT=220.05n

.meas tran vdout1_96ck210 FIND v(dout1_96) AT=220.05n

.meas tran vdout1_97ck210 FIND v(dout1_97) AT=220.05n

.meas tran vdout1_98ck210 FIND v(dout1_98) AT=220.05n

.meas tran vdout1_99ck210 FIND v(dout1_99) AT=220.05n

.meas tran vdout1_100ck210 FIND v(dout1_100) AT=220.05n

.meas tran vdout1_101ck210 FIND v(dout1_101) AT=220.05n

.meas tran vdout1_102ck210 FIND v(dout1_102) AT=220.05n

.meas tran vdout1_103ck210 FIND v(dout1_103) AT=220.05n

.meas tran vdout1_104ck210 FIND v(dout1_104) AT=220.05n

.meas tran vdout1_105ck210 FIND v(dout1_105) AT=220.05n

.meas tran vdout1_106ck210 FIND v(dout1_106) AT=220.05n

.meas tran vdout1_107ck210 FIND v(dout1_107) AT=220.05n

.meas tran vdout1_108ck210 FIND v(dout1_108) AT=220.05n

.meas tran vdout1_109ck210 FIND v(dout1_109) AT=220.05n

.meas tran vdout1_110ck210 FIND v(dout1_110) AT=220.05n

.meas tran vdout1_111ck210 FIND v(dout1_111) AT=220.05n

.meas tran vdout1_112ck210 FIND v(dout1_112) AT=220.05n

.meas tran vdout1_113ck210 FIND v(dout1_113) AT=220.05n

.meas tran vdout1_114ck210 FIND v(dout1_114) AT=220.05n

.meas tran vdout1_115ck210 FIND v(dout1_115) AT=220.05n

.meas tran vdout1_116ck210 FIND v(dout1_116) AT=220.05n

.meas tran vdout1_117ck210 FIND v(dout1_117) AT=220.05n

.meas tran vdout1_118ck210 FIND v(dout1_118) AT=220.05n

.meas tran vdout1_119ck210 FIND v(dout1_119) AT=220.05n

.meas tran vdout1_120ck210 FIND v(dout1_120) AT=220.05n

.meas tran vdout1_121ck210 FIND v(dout1_121) AT=220.05n

.meas tran vdout1_122ck210 FIND v(dout1_122) AT=220.05n

.meas tran vdout1_123ck210 FIND v(dout1_123) AT=220.05n

.meas tran vdout1_124ck210 FIND v(dout1_124) AT=220.05n

.meas tran vdout1_125ck210 FIND v(dout1_125) AT=220.05n

.meas tran vdout1_126ck210 FIND v(dout1_126) AT=220.05n

.meas tran vdout1_127ck210 FIND v(dout1_127) AT=220.05n

.meas tran vdout1_128ck210 FIND v(dout1_128) AT=220.05n

.meas tran vdout1_129ck210 FIND v(dout1_129) AT=220.05n

.meas tran vdout1_130ck210 FIND v(dout1_130) AT=220.05n

.meas tran vdout1_131ck210 FIND v(dout1_131) AT=220.05n

.meas tran vdout1_132ck210 FIND v(dout1_132) AT=220.05n

.meas tran vdout1_133ck210 FIND v(dout1_133) AT=220.05n

.meas tran vdout1_134ck210 FIND v(dout1_134) AT=220.05n

.meas tran vdout1_135ck210 FIND v(dout1_135) AT=220.05n

.meas tran vdout1_136ck210 FIND v(dout1_136) AT=220.05n

.meas tran vdout1_137ck210 FIND v(dout1_137) AT=220.05n

.meas tran vdout1_138ck210 FIND v(dout1_138) AT=220.05n

.meas tran vdout1_139ck210 FIND v(dout1_139) AT=220.05n

.meas tran vdout1_140ck210 FIND v(dout1_140) AT=220.05n

.meas tran vdout1_141ck210 FIND v(dout1_141) AT=220.05n

.meas tran vdout1_142ck210 FIND v(dout1_142) AT=220.05n

.meas tran vdout1_143ck210 FIND v(dout1_143) AT=220.05n

.meas tran vdout1_144ck210 FIND v(dout1_144) AT=220.05n

.meas tran vdout1_145ck210 FIND v(dout1_145) AT=220.05n

.meas tran vdout1_146ck210 FIND v(dout1_146) AT=220.05n

.meas tran vdout1_147ck210 FIND v(dout1_147) AT=220.05n

.meas tran vdout1_148ck210 FIND v(dout1_148) AT=220.05n

.meas tran vdout1_149ck210 FIND v(dout1_149) AT=220.05n

.meas tran vdout1_150ck210 FIND v(dout1_150) AT=220.05n

.meas tran vdout1_151ck210 FIND v(dout1_151) AT=220.05n

.meas tran vdout1_152ck210 FIND v(dout1_152) AT=220.05n

.meas tran vdout1_153ck210 FIND v(dout1_153) AT=220.05n

.meas tran vdout1_154ck210 FIND v(dout1_154) AT=220.05n

.meas tran vdout1_155ck210 FIND v(dout1_155) AT=220.05n

.meas tran vdout1_156ck210 FIND v(dout1_156) AT=220.05n

.meas tran vdout1_157ck210 FIND v(dout1_157) AT=220.05n

.meas tran vdout1_158ck210 FIND v(dout1_158) AT=220.05n

.meas tran vdout1_159ck210 FIND v(dout1_159) AT=220.05n

.meas tran vdout1_160ck210 FIND v(dout1_160) AT=220.05n

.meas tran vdout1_161ck210 FIND v(dout1_161) AT=220.05n

.meas tran vdout1_162ck210 FIND v(dout1_162) AT=220.05n

.meas tran vdout1_163ck210 FIND v(dout1_163) AT=220.05n

.meas tran vdout1_164ck210 FIND v(dout1_164) AT=220.05n

.meas tran vdout1_165ck210 FIND v(dout1_165) AT=220.05n

.meas tran vdout1_166ck210 FIND v(dout1_166) AT=220.05n

.meas tran vdout1_167ck210 FIND v(dout1_167) AT=220.05n

.meas tran vdout1_168ck210 FIND v(dout1_168) AT=220.05n

.meas tran vdout1_169ck210 FIND v(dout1_169) AT=220.05n

.meas tran vdout1_170ck210 FIND v(dout1_170) AT=220.05n

.meas tran vdout1_171ck210 FIND v(dout1_171) AT=220.05n

.meas tran vdout1_172ck210 FIND v(dout1_172) AT=220.05n

.meas tran vdout1_173ck210 FIND v(dout1_173) AT=220.05n

.meas tran vdout1_174ck210 FIND v(dout1_174) AT=220.05n

.meas tran vdout1_175ck210 FIND v(dout1_175) AT=220.05n

.meas tran vdout1_176ck210 FIND v(dout1_176) AT=220.05n

.meas tran vdout1_177ck210 FIND v(dout1_177) AT=220.05n

.meas tran vdout1_178ck210 FIND v(dout1_178) AT=220.05n

.meas tran vdout1_179ck210 FIND v(dout1_179) AT=220.05n

.meas tran vdout1_180ck210 FIND v(dout1_180) AT=220.05n

.meas tran vdout1_181ck210 FIND v(dout1_181) AT=220.05n

.meas tran vdout1_182ck210 FIND v(dout1_182) AT=220.05n

.meas tran vdout1_183ck210 FIND v(dout1_183) AT=220.05n

.meas tran vdout1_184ck210 FIND v(dout1_184) AT=220.05n

.meas tran vdout1_185ck210 FIND v(dout1_185) AT=220.05n

.meas tran vdout1_186ck210 FIND v(dout1_186) AT=220.05n

.meas tran vdout1_187ck210 FIND v(dout1_187) AT=220.05n

.meas tran vdout1_188ck210 FIND v(dout1_188) AT=220.05n

.meas tran vdout1_189ck210 FIND v(dout1_189) AT=220.05n

.meas tran vdout1_190ck210 FIND v(dout1_190) AT=220.05n

.meas tran vdout1_191ck210 FIND v(dout1_191) AT=220.05n

.meas tran vdout1_192ck210 FIND v(dout1_192) AT=220.05n

.meas tran vdout1_193ck210 FIND v(dout1_193) AT=220.05n

.meas tran vdout1_194ck210 FIND v(dout1_194) AT=220.05n

.meas tran vdout1_195ck210 FIND v(dout1_195) AT=220.05n

.meas tran vdout1_196ck210 FIND v(dout1_196) AT=220.05n

.meas tran vdout1_197ck210 FIND v(dout1_197) AT=220.05n

.meas tran vdout1_198ck210 FIND v(dout1_198) AT=220.05n

.meas tran vdout1_199ck210 FIND v(dout1_199) AT=220.05n

.meas tran vdout1_200ck210 FIND v(dout1_200) AT=220.05n

.meas tran vdout1_201ck210 FIND v(dout1_201) AT=220.05n

.meas tran vdout1_202ck210 FIND v(dout1_202) AT=220.05n

.meas tran vdout1_203ck210 FIND v(dout1_203) AT=220.05n

.meas tran vdout1_204ck210 FIND v(dout1_204) AT=220.05n

.meas tran vdout1_205ck210 FIND v(dout1_205) AT=220.05n

.meas tran vdout1_206ck210 FIND v(dout1_206) AT=220.05n

.meas tran vdout1_207ck210 FIND v(dout1_207) AT=220.05n

.meas tran vdout1_208ck210 FIND v(dout1_208) AT=220.05n

.meas tran vdout1_209ck210 FIND v(dout1_209) AT=220.05n

.meas tran vdout1_210ck210 FIND v(dout1_210) AT=220.05n

.meas tran vdout1_211ck210 FIND v(dout1_211) AT=220.05n

.meas tran vdout1_212ck210 FIND v(dout1_212) AT=220.05n

.meas tran vdout1_213ck210 FIND v(dout1_213) AT=220.05n

.meas tran vdout1_214ck210 FIND v(dout1_214) AT=220.05n

.meas tran vdout1_215ck210 FIND v(dout1_215) AT=220.05n

.meas tran vdout1_216ck210 FIND v(dout1_216) AT=220.05n

.meas tran vdout1_217ck210 FIND v(dout1_217) AT=220.05n

.meas tran vdout1_218ck210 FIND v(dout1_218) AT=220.05n

.meas tran vdout1_219ck210 FIND v(dout1_219) AT=220.05n

.meas tran vdout1_220ck210 FIND v(dout1_220) AT=220.05n

.meas tran vdout1_221ck210 FIND v(dout1_221) AT=220.05n

.meas tran vdout1_222ck210 FIND v(dout1_222) AT=220.05n

.meas tran vdout1_223ck210 FIND v(dout1_223) AT=220.05n

.meas tran vdout1_224ck210 FIND v(dout1_224) AT=220.05n

.meas tran vdout1_225ck210 FIND v(dout1_225) AT=220.05n

.meas tran vdout1_226ck210 FIND v(dout1_226) AT=220.05n

.meas tran vdout1_227ck210 FIND v(dout1_227) AT=220.05n

.meas tran vdout1_228ck210 FIND v(dout1_228) AT=220.05n

.meas tran vdout1_229ck210 FIND v(dout1_229) AT=220.05n

.meas tran vdout1_230ck210 FIND v(dout1_230) AT=220.05n

.meas tran vdout1_231ck210 FIND v(dout1_231) AT=220.05n

.meas tran vdout1_232ck210 FIND v(dout1_232) AT=220.05n

.meas tran vdout1_233ck210 FIND v(dout1_233) AT=220.05n

.meas tran vdout1_234ck210 FIND v(dout1_234) AT=220.05n

.meas tran vdout1_235ck210 FIND v(dout1_235) AT=220.05n

.meas tran vdout1_236ck210 FIND v(dout1_236) AT=220.05n

.meas tran vdout1_237ck210 FIND v(dout1_237) AT=220.05n

.meas tran vdout1_238ck210 FIND v(dout1_238) AT=220.05n

.meas tran vdout1_239ck210 FIND v(dout1_239) AT=220.05n

.meas tran vdout1_240ck210 FIND v(dout1_240) AT=220.05n

.meas tran vdout1_241ck210 FIND v(dout1_241) AT=220.05n

.meas tran vdout1_242ck210 FIND v(dout1_242) AT=220.05n

.meas tran vdout1_243ck210 FIND v(dout1_243) AT=220.05n

.meas tran vdout1_244ck210 FIND v(dout1_244) AT=220.05n

.meas tran vdout1_245ck210 FIND v(dout1_245) AT=220.05n

.meas tran vdout1_246ck210 FIND v(dout1_246) AT=220.05n

.meas tran vdout1_247ck210 FIND v(dout1_247) AT=220.05n

.meas tran vdout1_248ck210 FIND v(dout1_248) AT=220.05n

.meas tran vdout1_249ck210 FIND v(dout1_249) AT=220.05n

.meas tran vdout1_250ck210 FIND v(dout1_250) AT=220.05n

.meas tran vdout1_251ck210 FIND v(dout1_251) AT=220.05n

.meas tran vdout1_252ck210 FIND v(dout1_252) AT=220.05n

.meas tran vdout1_253ck210 FIND v(dout1_253) AT=220.05n

.meas tran vdout1_254ck210 FIND v(dout1_254) AT=220.05n

.meas tran vdout1_255ck210 FIND v(dout1_255) AT=220.05n

.meas tran vdout1_256ck210 FIND v(dout1_256) AT=220.05n

.meas tran vdout1_0ck240 FIND v(dout1_0) AT=250.05n

.meas tran vdout1_1ck240 FIND v(dout1_1) AT=250.05n

.meas tran vdout1_2ck240 FIND v(dout1_2) AT=250.05n

.meas tran vdout1_3ck240 FIND v(dout1_3) AT=250.05n

.meas tran vdout1_4ck240 FIND v(dout1_4) AT=250.05n

.meas tran vdout1_5ck240 FIND v(dout1_5) AT=250.05n

.meas tran vdout1_6ck240 FIND v(dout1_6) AT=250.05n

.meas tran vdout1_7ck240 FIND v(dout1_7) AT=250.05n

.meas tran vdout1_8ck240 FIND v(dout1_8) AT=250.05n

.meas tran vdout1_9ck240 FIND v(dout1_9) AT=250.05n

.meas tran vdout1_10ck240 FIND v(dout1_10) AT=250.05n

.meas tran vdout1_11ck240 FIND v(dout1_11) AT=250.05n

.meas tran vdout1_12ck240 FIND v(dout1_12) AT=250.05n

.meas tran vdout1_13ck240 FIND v(dout1_13) AT=250.05n

.meas tran vdout1_14ck240 FIND v(dout1_14) AT=250.05n

.meas tran vdout1_15ck240 FIND v(dout1_15) AT=250.05n

.meas tran vdout1_16ck240 FIND v(dout1_16) AT=250.05n

.meas tran vdout1_17ck240 FIND v(dout1_17) AT=250.05n

.meas tran vdout1_18ck240 FIND v(dout1_18) AT=250.05n

.meas tran vdout1_19ck240 FIND v(dout1_19) AT=250.05n

.meas tran vdout1_20ck240 FIND v(dout1_20) AT=250.05n

.meas tran vdout1_21ck240 FIND v(dout1_21) AT=250.05n

.meas tran vdout1_22ck240 FIND v(dout1_22) AT=250.05n

.meas tran vdout1_23ck240 FIND v(dout1_23) AT=250.05n

.meas tran vdout1_24ck240 FIND v(dout1_24) AT=250.05n

.meas tran vdout1_25ck240 FIND v(dout1_25) AT=250.05n

.meas tran vdout1_26ck240 FIND v(dout1_26) AT=250.05n

.meas tran vdout1_27ck240 FIND v(dout1_27) AT=250.05n

.meas tran vdout1_28ck240 FIND v(dout1_28) AT=250.05n

.meas tran vdout1_29ck240 FIND v(dout1_29) AT=250.05n

.meas tran vdout1_30ck240 FIND v(dout1_30) AT=250.05n

.meas tran vdout1_31ck240 FIND v(dout1_31) AT=250.05n

.meas tran vdout1_32ck240 FIND v(dout1_32) AT=250.05n

.meas tran vdout1_33ck240 FIND v(dout1_33) AT=250.05n

.meas tran vdout1_34ck240 FIND v(dout1_34) AT=250.05n

.meas tran vdout1_35ck240 FIND v(dout1_35) AT=250.05n

.meas tran vdout1_36ck240 FIND v(dout1_36) AT=250.05n

.meas tran vdout1_37ck240 FIND v(dout1_37) AT=250.05n

.meas tran vdout1_38ck240 FIND v(dout1_38) AT=250.05n

.meas tran vdout1_39ck240 FIND v(dout1_39) AT=250.05n

.meas tran vdout1_40ck240 FIND v(dout1_40) AT=250.05n

.meas tran vdout1_41ck240 FIND v(dout1_41) AT=250.05n

.meas tran vdout1_42ck240 FIND v(dout1_42) AT=250.05n

.meas tran vdout1_43ck240 FIND v(dout1_43) AT=250.05n

.meas tran vdout1_44ck240 FIND v(dout1_44) AT=250.05n

.meas tran vdout1_45ck240 FIND v(dout1_45) AT=250.05n

.meas tran vdout1_46ck240 FIND v(dout1_46) AT=250.05n

.meas tran vdout1_47ck240 FIND v(dout1_47) AT=250.05n

.meas tran vdout1_48ck240 FIND v(dout1_48) AT=250.05n

.meas tran vdout1_49ck240 FIND v(dout1_49) AT=250.05n

.meas tran vdout1_50ck240 FIND v(dout1_50) AT=250.05n

.meas tran vdout1_51ck240 FIND v(dout1_51) AT=250.05n

.meas tran vdout1_52ck240 FIND v(dout1_52) AT=250.05n

.meas tran vdout1_53ck240 FIND v(dout1_53) AT=250.05n

.meas tran vdout1_54ck240 FIND v(dout1_54) AT=250.05n

.meas tran vdout1_55ck240 FIND v(dout1_55) AT=250.05n

.meas tran vdout1_56ck240 FIND v(dout1_56) AT=250.05n

.meas tran vdout1_57ck240 FIND v(dout1_57) AT=250.05n

.meas tran vdout1_58ck240 FIND v(dout1_58) AT=250.05n

.meas tran vdout1_59ck240 FIND v(dout1_59) AT=250.05n

.meas tran vdout1_60ck240 FIND v(dout1_60) AT=250.05n

.meas tran vdout1_61ck240 FIND v(dout1_61) AT=250.05n

.meas tran vdout1_62ck240 FIND v(dout1_62) AT=250.05n

.meas tran vdout1_63ck240 FIND v(dout1_63) AT=250.05n

.meas tran vdout1_64ck240 FIND v(dout1_64) AT=250.05n

.meas tran vdout1_65ck240 FIND v(dout1_65) AT=250.05n

.meas tran vdout1_66ck240 FIND v(dout1_66) AT=250.05n

.meas tran vdout1_67ck240 FIND v(dout1_67) AT=250.05n

.meas tran vdout1_68ck240 FIND v(dout1_68) AT=250.05n

.meas tran vdout1_69ck240 FIND v(dout1_69) AT=250.05n

.meas tran vdout1_70ck240 FIND v(dout1_70) AT=250.05n

.meas tran vdout1_71ck240 FIND v(dout1_71) AT=250.05n

.meas tran vdout1_72ck240 FIND v(dout1_72) AT=250.05n

.meas tran vdout1_73ck240 FIND v(dout1_73) AT=250.05n

.meas tran vdout1_74ck240 FIND v(dout1_74) AT=250.05n

.meas tran vdout1_75ck240 FIND v(dout1_75) AT=250.05n

.meas tran vdout1_76ck240 FIND v(dout1_76) AT=250.05n

.meas tran vdout1_77ck240 FIND v(dout1_77) AT=250.05n

.meas tran vdout1_78ck240 FIND v(dout1_78) AT=250.05n

.meas tran vdout1_79ck240 FIND v(dout1_79) AT=250.05n

.meas tran vdout1_80ck240 FIND v(dout1_80) AT=250.05n

.meas tran vdout1_81ck240 FIND v(dout1_81) AT=250.05n

.meas tran vdout1_82ck240 FIND v(dout1_82) AT=250.05n

.meas tran vdout1_83ck240 FIND v(dout1_83) AT=250.05n

.meas tran vdout1_84ck240 FIND v(dout1_84) AT=250.05n

.meas tran vdout1_85ck240 FIND v(dout1_85) AT=250.05n

.meas tran vdout1_86ck240 FIND v(dout1_86) AT=250.05n

.meas tran vdout1_87ck240 FIND v(dout1_87) AT=250.05n

.meas tran vdout1_88ck240 FIND v(dout1_88) AT=250.05n

.meas tran vdout1_89ck240 FIND v(dout1_89) AT=250.05n

.meas tran vdout1_90ck240 FIND v(dout1_90) AT=250.05n

.meas tran vdout1_91ck240 FIND v(dout1_91) AT=250.05n

.meas tran vdout1_92ck240 FIND v(dout1_92) AT=250.05n

.meas tran vdout1_93ck240 FIND v(dout1_93) AT=250.05n

.meas tran vdout1_94ck240 FIND v(dout1_94) AT=250.05n

.meas tran vdout1_95ck240 FIND v(dout1_95) AT=250.05n

.meas tran vdout1_96ck240 FIND v(dout1_96) AT=250.05n

.meas tran vdout1_97ck240 FIND v(dout1_97) AT=250.05n

.meas tran vdout1_98ck240 FIND v(dout1_98) AT=250.05n

.meas tran vdout1_99ck240 FIND v(dout1_99) AT=250.05n

.meas tran vdout1_100ck240 FIND v(dout1_100) AT=250.05n

.meas tran vdout1_101ck240 FIND v(dout1_101) AT=250.05n

.meas tran vdout1_102ck240 FIND v(dout1_102) AT=250.05n

.meas tran vdout1_103ck240 FIND v(dout1_103) AT=250.05n

.meas tran vdout1_104ck240 FIND v(dout1_104) AT=250.05n

.meas tran vdout1_105ck240 FIND v(dout1_105) AT=250.05n

.meas tran vdout1_106ck240 FIND v(dout1_106) AT=250.05n

.meas tran vdout1_107ck240 FIND v(dout1_107) AT=250.05n

.meas tran vdout1_108ck240 FIND v(dout1_108) AT=250.05n

.meas tran vdout1_109ck240 FIND v(dout1_109) AT=250.05n

.meas tran vdout1_110ck240 FIND v(dout1_110) AT=250.05n

.meas tran vdout1_111ck240 FIND v(dout1_111) AT=250.05n

.meas tran vdout1_112ck240 FIND v(dout1_112) AT=250.05n

.meas tran vdout1_113ck240 FIND v(dout1_113) AT=250.05n

.meas tran vdout1_114ck240 FIND v(dout1_114) AT=250.05n

.meas tran vdout1_115ck240 FIND v(dout1_115) AT=250.05n

.meas tran vdout1_116ck240 FIND v(dout1_116) AT=250.05n

.meas tran vdout1_117ck240 FIND v(dout1_117) AT=250.05n

.meas tran vdout1_118ck240 FIND v(dout1_118) AT=250.05n

.meas tran vdout1_119ck240 FIND v(dout1_119) AT=250.05n

.meas tran vdout1_120ck240 FIND v(dout1_120) AT=250.05n

.meas tran vdout1_121ck240 FIND v(dout1_121) AT=250.05n

.meas tran vdout1_122ck240 FIND v(dout1_122) AT=250.05n

.meas tran vdout1_123ck240 FIND v(dout1_123) AT=250.05n

.meas tran vdout1_124ck240 FIND v(dout1_124) AT=250.05n

.meas tran vdout1_125ck240 FIND v(dout1_125) AT=250.05n

.meas tran vdout1_126ck240 FIND v(dout1_126) AT=250.05n

.meas tran vdout1_127ck240 FIND v(dout1_127) AT=250.05n

.meas tran vdout1_128ck240 FIND v(dout1_128) AT=250.05n

.meas tran vdout1_129ck240 FIND v(dout1_129) AT=250.05n

.meas tran vdout1_130ck240 FIND v(dout1_130) AT=250.05n

.meas tran vdout1_131ck240 FIND v(dout1_131) AT=250.05n

.meas tran vdout1_132ck240 FIND v(dout1_132) AT=250.05n

.meas tran vdout1_133ck240 FIND v(dout1_133) AT=250.05n

.meas tran vdout1_134ck240 FIND v(dout1_134) AT=250.05n

.meas tran vdout1_135ck240 FIND v(dout1_135) AT=250.05n

.meas tran vdout1_136ck240 FIND v(dout1_136) AT=250.05n

.meas tran vdout1_137ck240 FIND v(dout1_137) AT=250.05n

.meas tran vdout1_138ck240 FIND v(dout1_138) AT=250.05n

.meas tran vdout1_139ck240 FIND v(dout1_139) AT=250.05n

.meas tran vdout1_140ck240 FIND v(dout1_140) AT=250.05n

.meas tran vdout1_141ck240 FIND v(dout1_141) AT=250.05n

.meas tran vdout1_142ck240 FIND v(dout1_142) AT=250.05n

.meas tran vdout1_143ck240 FIND v(dout1_143) AT=250.05n

.meas tran vdout1_144ck240 FIND v(dout1_144) AT=250.05n

.meas tran vdout1_145ck240 FIND v(dout1_145) AT=250.05n

.meas tran vdout1_146ck240 FIND v(dout1_146) AT=250.05n

.meas tran vdout1_147ck240 FIND v(dout1_147) AT=250.05n

.meas tran vdout1_148ck240 FIND v(dout1_148) AT=250.05n

.meas tran vdout1_149ck240 FIND v(dout1_149) AT=250.05n

.meas tran vdout1_150ck240 FIND v(dout1_150) AT=250.05n

.meas tran vdout1_151ck240 FIND v(dout1_151) AT=250.05n

.meas tran vdout1_152ck240 FIND v(dout1_152) AT=250.05n

.meas tran vdout1_153ck240 FIND v(dout1_153) AT=250.05n

.meas tran vdout1_154ck240 FIND v(dout1_154) AT=250.05n

.meas tran vdout1_155ck240 FIND v(dout1_155) AT=250.05n

.meas tran vdout1_156ck240 FIND v(dout1_156) AT=250.05n

.meas tran vdout1_157ck240 FIND v(dout1_157) AT=250.05n

.meas tran vdout1_158ck240 FIND v(dout1_158) AT=250.05n

.meas tran vdout1_159ck240 FIND v(dout1_159) AT=250.05n

.meas tran vdout1_160ck240 FIND v(dout1_160) AT=250.05n

.meas tran vdout1_161ck240 FIND v(dout1_161) AT=250.05n

.meas tran vdout1_162ck240 FIND v(dout1_162) AT=250.05n

.meas tran vdout1_163ck240 FIND v(dout1_163) AT=250.05n

.meas tran vdout1_164ck240 FIND v(dout1_164) AT=250.05n

.meas tran vdout1_165ck240 FIND v(dout1_165) AT=250.05n

.meas tran vdout1_166ck240 FIND v(dout1_166) AT=250.05n

.meas tran vdout1_167ck240 FIND v(dout1_167) AT=250.05n

.meas tran vdout1_168ck240 FIND v(dout1_168) AT=250.05n

.meas tran vdout1_169ck240 FIND v(dout1_169) AT=250.05n

.meas tran vdout1_170ck240 FIND v(dout1_170) AT=250.05n

.meas tran vdout1_171ck240 FIND v(dout1_171) AT=250.05n

.meas tran vdout1_172ck240 FIND v(dout1_172) AT=250.05n

.meas tran vdout1_173ck240 FIND v(dout1_173) AT=250.05n

.meas tran vdout1_174ck240 FIND v(dout1_174) AT=250.05n

.meas tran vdout1_175ck240 FIND v(dout1_175) AT=250.05n

.meas tran vdout1_176ck240 FIND v(dout1_176) AT=250.05n

.meas tran vdout1_177ck240 FIND v(dout1_177) AT=250.05n

.meas tran vdout1_178ck240 FIND v(dout1_178) AT=250.05n

.meas tran vdout1_179ck240 FIND v(dout1_179) AT=250.05n

.meas tran vdout1_180ck240 FIND v(dout1_180) AT=250.05n

.meas tran vdout1_181ck240 FIND v(dout1_181) AT=250.05n

.meas tran vdout1_182ck240 FIND v(dout1_182) AT=250.05n

.meas tran vdout1_183ck240 FIND v(dout1_183) AT=250.05n

.meas tran vdout1_184ck240 FIND v(dout1_184) AT=250.05n

.meas tran vdout1_185ck240 FIND v(dout1_185) AT=250.05n

.meas tran vdout1_186ck240 FIND v(dout1_186) AT=250.05n

.meas tran vdout1_187ck240 FIND v(dout1_187) AT=250.05n

.meas tran vdout1_188ck240 FIND v(dout1_188) AT=250.05n

.meas tran vdout1_189ck240 FIND v(dout1_189) AT=250.05n

.meas tran vdout1_190ck240 FIND v(dout1_190) AT=250.05n

.meas tran vdout1_191ck240 FIND v(dout1_191) AT=250.05n

.meas tran vdout1_192ck240 FIND v(dout1_192) AT=250.05n

.meas tran vdout1_193ck240 FIND v(dout1_193) AT=250.05n

.meas tran vdout1_194ck240 FIND v(dout1_194) AT=250.05n

.meas tran vdout1_195ck240 FIND v(dout1_195) AT=250.05n

.meas tran vdout1_196ck240 FIND v(dout1_196) AT=250.05n

.meas tran vdout1_197ck240 FIND v(dout1_197) AT=250.05n

.meas tran vdout1_198ck240 FIND v(dout1_198) AT=250.05n

.meas tran vdout1_199ck240 FIND v(dout1_199) AT=250.05n

.meas tran vdout1_200ck240 FIND v(dout1_200) AT=250.05n

.meas tran vdout1_201ck240 FIND v(dout1_201) AT=250.05n

.meas tran vdout1_202ck240 FIND v(dout1_202) AT=250.05n

.meas tran vdout1_203ck240 FIND v(dout1_203) AT=250.05n

.meas tran vdout1_204ck240 FIND v(dout1_204) AT=250.05n

.meas tran vdout1_205ck240 FIND v(dout1_205) AT=250.05n

.meas tran vdout1_206ck240 FIND v(dout1_206) AT=250.05n

.meas tran vdout1_207ck240 FIND v(dout1_207) AT=250.05n

.meas tran vdout1_208ck240 FIND v(dout1_208) AT=250.05n

.meas tran vdout1_209ck240 FIND v(dout1_209) AT=250.05n

.meas tran vdout1_210ck240 FIND v(dout1_210) AT=250.05n

.meas tran vdout1_211ck240 FIND v(dout1_211) AT=250.05n

.meas tran vdout1_212ck240 FIND v(dout1_212) AT=250.05n

.meas tran vdout1_213ck240 FIND v(dout1_213) AT=250.05n

.meas tran vdout1_214ck240 FIND v(dout1_214) AT=250.05n

.meas tran vdout1_215ck240 FIND v(dout1_215) AT=250.05n

.meas tran vdout1_216ck240 FIND v(dout1_216) AT=250.05n

.meas tran vdout1_217ck240 FIND v(dout1_217) AT=250.05n

.meas tran vdout1_218ck240 FIND v(dout1_218) AT=250.05n

.meas tran vdout1_219ck240 FIND v(dout1_219) AT=250.05n

.meas tran vdout1_220ck240 FIND v(dout1_220) AT=250.05n

.meas tran vdout1_221ck240 FIND v(dout1_221) AT=250.05n

.meas tran vdout1_222ck240 FIND v(dout1_222) AT=250.05n

.meas tran vdout1_223ck240 FIND v(dout1_223) AT=250.05n

.meas tran vdout1_224ck240 FIND v(dout1_224) AT=250.05n

.meas tran vdout1_225ck240 FIND v(dout1_225) AT=250.05n

.meas tran vdout1_226ck240 FIND v(dout1_226) AT=250.05n

.meas tran vdout1_227ck240 FIND v(dout1_227) AT=250.05n

.meas tran vdout1_228ck240 FIND v(dout1_228) AT=250.05n

.meas tran vdout1_229ck240 FIND v(dout1_229) AT=250.05n

.meas tran vdout1_230ck240 FIND v(dout1_230) AT=250.05n

.meas tran vdout1_231ck240 FIND v(dout1_231) AT=250.05n

.meas tran vdout1_232ck240 FIND v(dout1_232) AT=250.05n

.meas tran vdout1_233ck240 FIND v(dout1_233) AT=250.05n

.meas tran vdout1_234ck240 FIND v(dout1_234) AT=250.05n

.meas tran vdout1_235ck240 FIND v(dout1_235) AT=250.05n

.meas tran vdout1_236ck240 FIND v(dout1_236) AT=250.05n

.meas tran vdout1_237ck240 FIND v(dout1_237) AT=250.05n

.meas tran vdout1_238ck240 FIND v(dout1_238) AT=250.05n

.meas tran vdout1_239ck240 FIND v(dout1_239) AT=250.05n

.meas tran vdout1_240ck240 FIND v(dout1_240) AT=250.05n

.meas tran vdout1_241ck240 FIND v(dout1_241) AT=250.05n

.meas tran vdout1_242ck240 FIND v(dout1_242) AT=250.05n

.meas tran vdout1_243ck240 FIND v(dout1_243) AT=250.05n

.meas tran vdout1_244ck240 FIND v(dout1_244) AT=250.05n

.meas tran vdout1_245ck240 FIND v(dout1_245) AT=250.05n

.meas tran vdout1_246ck240 FIND v(dout1_246) AT=250.05n

.meas tran vdout1_247ck240 FIND v(dout1_247) AT=250.05n

.meas tran vdout1_248ck240 FIND v(dout1_248) AT=250.05n

.meas tran vdout1_249ck240 FIND v(dout1_249) AT=250.05n

.meas tran vdout1_250ck240 FIND v(dout1_250) AT=250.05n

.meas tran vdout1_251ck240 FIND v(dout1_251) AT=250.05n

.meas tran vdout1_252ck240 FIND v(dout1_252) AT=250.05n

.meas tran vdout1_253ck240 FIND v(dout1_253) AT=250.05n

.meas tran vdout1_254ck240 FIND v(dout1_254) AT=250.05n

.meas tran vdout1_255ck240 FIND v(dout1_255) AT=250.05n

.meas tran vdout1_256ck240 FIND v(dout1_256) AT=250.05n

.meas tran vdout1_0ck250 FIND v(dout1_0) AT=260.05n

.meas tran vdout1_1ck250 FIND v(dout1_1) AT=260.05n

.meas tran vdout1_2ck250 FIND v(dout1_2) AT=260.05n

.meas tran vdout1_3ck250 FIND v(dout1_3) AT=260.05n

.meas tran vdout1_4ck250 FIND v(dout1_4) AT=260.05n

.meas tran vdout1_5ck250 FIND v(dout1_5) AT=260.05n

.meas tran vdout1_6ck250 FIND v(dout1_6) AT=260.05n

.meas tran vdout1_7ck250 FIND v(dout1_7) AT=260.05n

.meas tran vdout1_8ck250 FIND v(dout1_8) AT=260.05n

.meas tran vdout1_9ck250 FIND v(dout1_9) AT=260.05n

.meas tran vdout1_10ck250 FIND v(dout1_10) AT=260.05n

.meas tran vdout1_11ck250 FIND v(dout1_11) AT=260.05n

.meas tran vdout1_12ck250 FIND v(dout1_12) AT=260.05n

.meas tran vdout1_13ck250 FIND v(dout1_13) AT=260.05n

.meas tran vdout1_14ck250 FIND v(dout1_14) AT=260.05n

.meas tran vdout1_15ck250 FIND v(dout1_15) AT=260.05n

.meas tran vdout1_16ck250 FIND v(dout1_16) AT=260.05n

.meas tran vdout1_17ck250 FIND v(dout1_17) AT=260.05n

.meas tran vdout1_18ck250 FIND v(dout1_18) AT=260.05n

.meas tran vdout1_19ck250 FIND v(dout1_19) AT=260.05n

.meas tran vdout1_20ck250 FIND v(dout1_20) AT=260.05n

.meas tran vdout1_21ck250 FIND v(dout1_21) AT=260.05n

.meas tran vdout1_22ck250 FIND v(dout1_22) AT=260.05n

.meas tran vdout1_23ck250 FIND v(dout1_23) AT=260.05n

.meas tran vdout1_24ck250 FIND v(dout1_24) AT=260.05n

.meas tran vdout1_25ck250 FIND v(dout1_25) AT=260.05n

.meas tran vdout1_26ck250 FIND v(dout1_26) AT=260.05n

.meas tran vdout1_27ck250 FIND v(dout1_27) AT=260.05n

.meas tran vdout1_28ck250 FIND v(dout1_28) AT=260.05n

.meas tran vdout1_29ck250 FIND v(dout1_29) AT=260.05n

.meas tran vdout1_30ck250 FIND v(dout1_30) AT=260.05n

.meas tran vdout1_31ck250 FIND v(dout1_31) AT=260.05n

.meas tran vdout1_32ck250 FIND v(dout1_32) AT=260.05n

.meas tran vdout1_33ck250 FIND v(dout1_33) AT=260.05n

.meas tran vdout1_34ck250 FIND v(dout1_34) AT=260.05n

.meas tran vdout1_35ck250 FIND v(dout1_35) AT=260.05n

.meas tran vdout1_36ck250 FIND v(dout1_36) AT=260.05n

.meas tran vdout1_37ck250 FIND v(dout1_37) AT=260.05n

.meas tran vdout1_38ck250 FIND v(dout1_38) AT=260.05n

.meas tran vdout1_39ck250 FIND v(dout1_39) AT=260.05n

.meas tran vdout1_40ck250 FIND v(dout1_40) AT=260.05n

.meas tran vdout1_41ck250 FIND v(dout1_41) AT=260.05n

.meas tran vdout1_42ck250 FIND v(dout1_42) AT=260.05n

.meas tran vdout1_43ck250 FIND v(dout1_43) AT=260.05n

.meas tran vdout1_44ck250 FIND v(dout1_44) AT=260.05n

.meas tran vdout1_45ck250 FIND v(dout1_45) AT=260.05n

.meas tran vdout1_46ck250 FIND v(dout1_46) AT=260.05n

.meas tran vdout1_47ck250 FIND v(dout1_47) AT=260.05n

.meas tran vdout1_48ck250 FIND v(dout1_48) AT=260.05n

.meas tran vdout1_49ck250 FIND v(dout1_49) AT=260.05n

.meas tran vdout1_50ck250 FIND v(dout1_50) AT=260.05n

.meas tran vdout1_51ck250 FIND v(dout1_51) AT=260.05n

.meas tran vdout1_52ck250 FIND v(dout1_52) AT=260.05n

.meas tran vdout1_53ck250 FIND v(dout1_53) AT=260.05n

.meas tran vdout1_54ck250 FIND v(dout1_54) AT=260.05n

.meas tran vdout1_55ck250 FIND v(dout1_55) AT=260.05n

.meas tran vdout1_56ck250 FIND v(dout1_56) AT=260.05n

.meas tran vdout1_57ck250 FIND v(dout1_57) AT=260.05n

.meas tran vdout1_58ck250 FIND v(dout1_58) AT=260.05n

.meas tran vdout1_59ck250 FIND v(dout1_59) AT=260.05n

.meas tran vdout1_60ck250 FIND v(dout1_60) AT=260.05n

.meas tran vdout1_61ck250 FIND v(dout1_61) AT=260.05n

.meas tran vdout1_62ck250 FIND v(dout1_62) AT=260.05n

.meas tran vdout1_63ck250 FIND v(dout1_63) AT=260.05n

.meas tran vdout1_64ck250 FIND v(dout1_64) AT=260.05n

.meas tran vdout1_65ck250 FIND v(dout1_65) AT=260.05n

.meas tran vdout1_66ck250 FIND v(dout1_66) AT=260.05n

.meas tran vdout1_67ck250 FIND v(dout1_67) AT=260.05n

.meas tran vdout1_68ck250 FIND v(dout1_68) AT=260.05n

.meas tran vdout1_69ck250 FIND v(dout1_69) AT=260.05n

.meas tran vdout1_70ck250 FIND v(dout1_70) AT=260.05n

.meas tran vdout1_71ck250 FIND v(dout1_71) AT=260.05n

.meas tran vdout1_72ck250 FIND v(dout1_72) AT=260.05n

.meas tran vdout1_73ck250 FIND v(dout1_73) AT=260.05n

.meas tran vdout1_74ck250 FIND v(dout1_74) AT=260.05n

.meas tran vdout1_75ck250 FIND v(dout1_75) AT=260.05n

.meas tran vdout1_76ck250 FIND v(dout1_76) AT=260.05n

.meas tran vdout1_77ck250 FIND v(dout1_77) AT=260.05n

.meas tran vdout1_78ck250 FIND v(dout1_78) AT=260.05n

.meas tran vdout1_79ck250 FIND v(dout1_79) AT=260.05n

.meas tran vdout1_80ck250 FIND v(dout1_80) AT=260.05n

.meas tran vdout1_81ck250 FIND v(dout1_81) AT=260.05n

.meas tran vdout1_82ck250 FIND v(dout1_82) AT=260.05n

.meas tran vdout1_83ck250 FIND v(dout1_83) AT=260.05n

.meas tran vdout1_84ck250 FIND v(dout1_84) AT=260.05n

.meas tran vdout1_85ck250 FIND v(dout1_85) AT=260.05n

.meas tran vdout1_86ck250 FIND v(dout1_86) AT=260.05n

.meas tran vdout1_87ck250 FIND v(dout1_87) AT=260.05n

.meas tran vdout1_88ck250 FIND v(dout1_88) AT=260.05n

.meas tran vdout1_89ck250 FIND v(dout1_89) AT=260.05n

.meas tran vdout1_90ck250 FIND v(dout1_90) AT=260.05n

.meas tran vdout1_91ck250 FIND v(dout1_91) AT=260.05n

.meas tran vdout1_92ck250 FIND v(dout1_92) AT=260.05n

.meas tran vdout1_93ck250 FIND v(dout1_93) AT=260.05n

.meas tran vdout1_94ck250 FIND v(dout1_94) AT=260.05n

.meas tran vdout1_95ck250 FIND v(dout1_95) AT=260.05n

.meas tran vdout1_96ck250 FIND v(dout1_96) AT=260.05n

.meas tran vdout1_97ck250 FIND v(dout1_97) AT=260.05n

.meas tran vdout1_98ck250 FIND v(dout1_98) AT=260.05n

.meas tran vdout1_99ck250 FIND v(dout1_99) AT=260.05n

.meas tran vdout1_100ck250 FIND v(dout1_100) AT=260.05n

.meas tran vdout1_101ck250 FIND v(dout1_101) AT=260.05n

.meas tran vdout1_102ck250 FIND v(dout1_102) AT=260.05n

.meas tran vdout1_103ck250 FIND v(dout1_103) AT=260.05n

.meas tran vdout1_104ck250 FIND v(dout1_104) AT=260.05n

.meas tran vdout1_105ck250 FIND v(dout1_105) AT=260.05n

.meas tran vdout1_106ck250 FIND v(dout1_106) AT=260.05n

.meas tran vdout1_107ck250 FIND v(dout1_107) AT=260.05n

.meas tran vdout1_108ck250 FIND v(dout1_108) AT=260.05n

.meas tran vdout1_109ck250 FIND v(dout1_109) AT=260.05n

.meas tran vdout1_110ck250 FIND v(dout1_110) AT=260.05n

.meas tran vdout1_111ck250 FIND v(dout1_111) AT=260.05n

.meas tran vdout1_112ck250 FIND v(dout1_112) AT=260.05n

.meas tran vdout1_113ck250 FIND v(dout1_113) AT=260.05n

.meas tran vdout1_114ck250 FIND v(dout1_114) AT=260.05n

.meas tran vdout1_115ck250 FIND v(dout1_115) AT=260.05n

.meas tran vdout1_116ck250 FIND v(dout1_116) AT=260.05n

.meas tran vdout1_117ck250 FIND v(dout1_117) AT=260.05n

.meas tran vdout1_118ck250 FIND v(dout1_118) AT=260.05n

.meas tran vdout1_119ck250 FIND v(dout1_119) AT=260.05n

.meas tran vdout1_120ck250 FIND v(dout1_120) AT=260.05n

.meas tran vdout1_121ck250 FIND v(dout1_121) AT=260.05n

.meas tran vdout1_122ck250 FIND v(dout1_122) AT=260.05n

.meas tran vdout1_123ck250 FIND v(dout1_123) AT=260.05n

.meas tran vdout1_124ck250 FIND v(dout1_124) AT=260.05n

.meas tran vdout1_125ck250 FIND v(dout1_125) AT=260.05n

.meas tran vdout1_126ck250 FIND v(dout1_126) AT=260.05n

.meas tran vdout1_127ck250 FIND v(dout1_127) AT=260.05n

.meas tran vdout1_128ck250 FIND v(dout1_128) AT=260.05n

.meas tran vdout1_129ck250 FIND v(dout1_129) AT=260.05n

.meas tran vdout1_130ck250 FIND v(dout1_130) AT=260.05n

.meas tran vdout1_131ck250 FIND v(dout1_131) AT=260.05n

.meas tran vdout1_132ck250 FIND v(dout1_132) AT=260.05n

.meas tran vdout1_133ck250 FIND v(dout1_133) AT=260.05n

.meas tran vdout1_134ck250 FIND v(dout1_134) AT=260.05n

.meas tran vdout1_135ck250 FIND v(dout1_135) AT=260.05n

.meas tran vdout1_136ck250 FIND v(dout1_136) AT=260.05n

.meas tran vdout1_137ck250 FIND v(dout1_137) AT=260.05n

.meas tran vdout1_138ck250 FIND v(dout1_138) AT=260.05n

.meas tran vdout1_139ck250 FIND v(dout1_139) AT=260.05n

.meas tran vdout1_140ck250 FIND v(dout1_140) AT=260.05n

.meas tran vdout1_141ck250 FIND v(dout1_141) AT=260.05n

.meas tran vdout1_142ck250 FIND v(dout1_142) AT=260.05n

.meas tran vdout1_143ck250 FIND v(dout1_143) AT=260.05n

.meas tran vdout1_144ck250 FIND v(dout1_144) AT=260.05n

.meas tran vdout1_145ck250 FIND v(dout1_145) AT=260.05n

.meas tran vdout1_146ck250 FIND v(dout1_146) AT=260.05n

.meas tran vdout1_147ck250 FIND v(dout1_147) AT=260.05n

.meas tran vdout1_148ck250 FIND v(dout1_148) AT=260.05n

.meas tran vdout1_149ck250 FIND v(dout1_149) AT=260.05n

.meas tran vdout1_150ck250 FIND v(dout1_150) AT=260.05n

.meas tran vdout1_151ck250 FIND v(dout1_151) AT=260.05n

.meas tran vdout1_152ck250 FIND v(dout1_152) AT=260.05n

.meas tran vdout1_153ck250 FIND v(dout1_153) AT=260.05n

.meas tran vdout1_154ck250 FIND v(dout1_154) AT=260.05n

.meas tran vdout1_155ck250 FIND v(dout1_155) AT=260.05n

.meas tran vdout1_156ck250 FIND v(dout1_156) AT=260.05n

.meas tran vdout1_157ck250 FIND v(dout1_157) AT=260.05n

.meas tran vdout1_158ck250 FIND v(dout1_158) AT=260.05n

.meas tran vdout1_159ck250 FIND v(dout1_159) AT=260.05n

.meas tran vdout1_160ck250 FIND v(dout1_160) AT=260.05n

.meas tran vdout1_161ck250 FIND v(dout1_161) AT=260.05n

.meas tran vdout1_162ck250 FIND v(dout1_162) AT=260.05n

.meas tran vdout1_163ck250 FIND v(dout1_163) AT=260.05n

.meas tran vdout1_164ck250 FIND v(dout1_164) AT=260.05n

.meas tran vdout1_165ck250 FIND v(dout1_165) AT=260.05n

.meas tran vdout1_166ck250 FIND v(dout1_166) AT=260.05n

.meas tran vdout1_167ck250 FIND v(dout1_167) AT=260.05n

.meas tran vdout1_168ck250 FIND v(dout1_168) AT=260.05n

.meas tran vdout1_169ck250 FIND v(dout1_169) AT=260.05n

.meas tran vdout1_170ck250 FIND v(dout1_170) AT=260.05n

.meas tran vdout1_171ck250 FIND v(dout1_171) AT=260.05n

.meas tran vdout1_172ck250 FIND v(dout1_172) AT=260.05n

.meas tran vdout1_173ck250 FIND v(dout1_173) AT=260.05n

.meas tran vdout1_174ck250 FIND v(dout1_174) AT=260.05n

.meas tran vdout1_175ck250 FIND v(dout1_175) AT=260.05n

.meas tran vdout1_176ck250 FIND v(dout1_176) AT=260.05n

.meas tran vdout1_177ck250 FIND v(dout1_177) AT=260.05n

.meas tran vdout1_178ck250 FIND v(dout1_178) AT=260.05n

.meas tran vdout1_179ck250 FIND v(dout1_179) AT=260.05n

.meas tran vdout1_180ck250 FIND v(dout1_180) AT=260.05n

.meas tran vdout1_181ck250 FIND v(dout1_181) AT=260.05n

.meas tran vdout1_182ck250 FIND v(dout1_182) AT=260.05n

.meas tran vdout1_183ck250 FIND v(dout1_183) AT=260.05n

.meas tran vdout1_184ck250 FIND v(dout1_184) AT=260.05n

.meas tran vdout1_185ck250 FIND v(dout1_185) AT=260.05n

.meas tran vdout1_186ck250 FIND v(dout1_186) AT=260.05n

.meas tran vdout1_187ck250 FIND v(dout1_187) AT=260.05n

.meas tran vdout1_188ck250 FIND v(dout1_188) AT=260.05n

.meas tran vdout1_189ck250 FIND v(dout1_189) AT=260.05n

.meas tran vdout1_190ck250 FIND v(dout1_190) AT=260.05n

.meas tran vdout1_191ck250 FIND v(dout1_191) AT=260.05n

.meas tran vdout1_192ck250 FIND v(dout1_192) AT=260.05n

.meas tran vdout1_193ck250 FIND v(dout1_193) AT=260.05n

.meas tran vdout1_194ck250 FIND v(dout1_194) AT=260.05n

.meas tran vdout1_195ck250 FIND v(dout1_195) AT=260.05n

.meas tran vdout1_196ck250 FIND v(dout1_196) AT=260.05n

.meas tran vdout1_197ck250 FIND v(dout1_197) AT=260.05n

.meas tran vdout1_198ck250 FIND v(dout1_198) AT=260.05n

.meas tran vdout1_199ck250 FIND v(dout1_199) AT=260.05n

.meas tran vdout1_200ck250 FIND v(dout1_200) AT=260.05n

.meas tran vdout1_201ck250 FIND v(dout1_201) AT=260.05n

.meas tran vdout1_202ck250 FIND v(dout1_202) AT=260.05n

.meas tran vdout1_203ck250 FIND v(dout1_203) AT=260.05n

.meas tran vdout1_204ck250 FIND v(dout1_204) AT=260.05n

.meas tran vdout1_205ck250 FIND v(dout1_205) AT=260.05n

.meas tran vdout1_206ck250 FIND v(dout1_206) AT=260.05n

.meas tran vdout1_207ck250 FIND v(dout1_207) AT=260.05n

.meas tran vdout1_208ck250 FIND v(dout1_208) AT=260.05n

.meas tran vdout1_209ck250 FIND v(dout1_209) AT=260.05n

.meas tran vdout1_210ck250 FIND v(dout1_210) AT=260.05n

.meas tran vdout1_211ck250 FIND v(dout1_211) AT=260.05n

.meas tran vdout1_212ck250 FIND v(dout1_212) AT=260.05n

.meas tran vdout1_213ck250 FIND v(dout1_213) AT=260.05n

.meas tran vdout1_214ck250 FIND v(dout1_214) AT=260.05n

.meas tran vdout1_215ck250 FIND v(dout1_215) AT=260.05n

.meas tran vdout1_216ck250 FIND v(dout1_216) AT=260.05n

.meas tran vdout1_217ck250 FIND v(dout1_217) AT=260.05n

.meas tran vdout1_218ck250 FIND v(dout1_218) AT=260.05n

.meas tran vdout1_219ck250 FIND v(dout1_219) AT=260.05n

.meas tran vdout1_220ck250 FIND v(dout1_220) AT=260.05n

.meas tran vdout1_221ck250 FIND v(dout1_221) AT=260.05n

.meas tran vdout1_222ck250 FIND v(dout1_222) AT=260.05n

.meas tran vdout1_223ck250 FIND v(dout1_223) AT=260.05n

.meas tran vdout1_224ck250 FIND v(dout1_224) AT=260.05n

.meas tran vdout1_225ck250 FIND v(dout1_225) AT=260.05n

.meas tran vdout1_226ck250 FIND v(dout1_226) AT=260.05n

.meas tran vdout1_227ck250 FIND v(dout1_227) AT=260.05n

.meas tran vdout1_228ck250 FIND v(dout1_228) AT=260.05n

.meas tran vdout1_229ck250 FIND v(dout1_229) AT=260.05n

.meas tran vdout1_230ck250 FIND v(dout1_230) AT=260.05n

.meas tran vdout1_231ck250 FIND v(dout1_231) AT=260.05n

.meas tran vdout1_232ck250 FIND v(dout1_232) AT=260.05n

.meas tran vdout1_233ck250 FIND v(dout1_233) AT=260.05n

.meas tran vdout1_234ck250 FIND v(dout1_234) AT=260.05n

.meas tran vdout1_235ck250 FIND v(dout1_235) AT=260.05n

.meas tran vdout1_236ck250 FIND v(dout1_236) AT=260.05n

.meas tran vdout1_237ck250 FIND v(dout1_237) AT=260.05n

.meas tran vdout1_238ck250 FIND v(dout1_238) AT=260.05n

.meas tran vdout1_239ck250 FIND v(dout1_239) AT=260.05n

.meas tran vdout1_240ck250 FIND v(dout1_240) AT=260.05n

.meas tran vdout1_241ck250 FIND v(dout1_241) AT=260.05n

.meas tran vdout1_242ck250 FIND v(dout1_242) AT=260.05n

.meas tran vdout1_243ck250 FIND v(dout1_243) AT=260.05n

.meas tran vdout1_244ck250 FIND v(dout1_244) AT=260.05n

.meas tran vdout1_245ck250 FIND v(dout1_245) AT=260.05n

.meas tran vdout1_246ck250 FIND v(dout1_246) AT=260.05n

.meas tran vdout1_247ck250 FIND v(dout1_247) AT=260.05n

.meas tran vdout1_248ck250 FIND v(dout1_248) AT=260.05n

.meas tran vdout1_249ck250 FIND v(dout1_249) AT=260.05n

.meas tran vdout1_250ck250 FIND v(dout1_250) AT=260.05n

.meas tran vdout1_251ck250 FIND v(dout1_251) AT=260.05n

.meas tran vdout1_252ck250 FIND v(dout1_252) AT=260.05n

.meas tran vdout1_253ck250 FIND v(dout1_253) AT=260.05n

.meas tran vdout1_254ck250 FIND v(dout1_254) AT=260.05n

.meas tran vdout1_255ck250 FIND v(dout1_255) AT=260.05n

.meas tran vdout1_256ck250 FIND v(dout1_256) AT=260.05n

.meas tran vdout1_0ck260 FIND v(dout1_0) AT=270.05n

.meas tran vdout1_1ck260 FIND v(dout1_1) AT=270.05n

.meas tran vdout1_2ck260 FIND v(dout1_2) AT=270.05n

.meas tran vdout1_3ck260 FIND v(dout1_3) AT=270.05n

.meas tran vdout1_4ck260 FIND v(dout1_4) AT=270.05n

.meas tran vdout1_5ck260 FIND v(dout1_5) AT=270.05n

.meas tran vdout1_6ck260 FIND v(dout1_6) AT=270.05n

.meas tran vdout1_7ck260 FIND v(dout1_7) AT=270.05n

.meas tran vdout1_8ck260 FIND v(dout1_8) AT=270.05n

.meas tran vdout1_9ck260 FIND v(dout1_9) AT=270.05n

.meas tran vdout1_10ck260 FIND v(dout1_10) AT=270.05n

.meas tran vdout1_11ck260 FIND v(dout1_11) AT=270.05n

.meas tran vdout1_12ck260 FIND v(dout1_12) AT=270.05n

.meas tran vdout1_13ck260 FIND v(dout1_13) AT=270.05n

.meas tran vdout1_14ck260 FIND v(dout1_14) AT=270.05n

.meas tran vdout1_15ck260 FIND v(dout1_15) AT=270.05n

.meas tran vdout1_16ck260 FIND v(dout1_16) AT=270.05n

.meas tran vdout1_17ck260 FIND v(dout1_17) AT=270.05n

.meas tran vdout1_18ck260 FIND v(dout1_18) AT=270.05n

.meas tran vdout1_19ck260 FIND v(dout1_19) AT=270.05n

.meas tran vdout1_20ck260 FIND v(dout1_20) AT=270.05n

.meas tran vdout1_21ck260 FIND v(dout1_21) AT=270.05n

.meas tran vdout1_22ck260 FIND v(dout1_22) AT=270.05n

.meas tran vdout1_23ck260 FIND v(dout1_23) AT=270.05n

.meas tran vdout1_24ck260 FIND v(dout1_24) AT=270.05n

.meas tran vdout1_25ck260 FIND v(dout1_25) AT=270.05n

.meas tran vdout1_26ck260 FIND v(dout1_26) AT=270.05n

.meas tran vdout1_27ck260 FIND v(dout1_27) AT=270.05n

.meas tran vdout1_28ck260 FIND v(dout1_28) AT=270.05n

.meas tran vdout1_29ck260 FIND v(dout1_29) AT=270.05n

.meas tran vdout1_30ck260 FIND v(dout1_30) AT=270.05n

.meas tran vdout1_31ck260 FIND v(dout1_31) AT=270.05n

.meas tran vdout1_32ck260 FIND v(dout1_32) AT=270.05n

.meas tran vdout1_33ck260 FIND v(dout1_33) AT=270.05n

.meas tran vdout1_34ck260 FIND v(dout1_34) AT=270.05n

.meas tran vdout1_35ck260 FIND v(dout1_35) AT=270.05n

.meas tran vdout1_36ck260 FIND v(dout1_36) AT=270.05n

.meas tran vdout1_37ck260 FIND v(dout1_37) AT=270.05n

.meas tran vdout1_38ck260 FIND v(dout1_38) AT=270.05n

.meas tran vdout1_39ck260 FIND v(dout1_39) AT=270.05n

.meas tran vdout1_40ck260 FIND v(dout1_40) AT=270.05n

.meas tran vdout1_41ck260 FIND v(dout1_41) AT=270.05n

.meas tran vdout1_42ck260 FIND v(dout1_42) AT=270.05n

.meas tran vdout1_43ck260 FIND v(dout1_43) AT=270.05n

.meas tran vdout1_44ck260 FIND v(dout1_44) AT=270.05n

.meas tran vdout1_45ck260 FIND v(dout1_45) AT=270.05n

.meas tran vdout1_46ck260 FIND v(dout1_46) AT=270.05n

.meas tran vdout1_47ck260 FIND v(dout1_47) AT=270.05n

.meas tran vdout1_48ck260 FIND v(dout1_48) AT=270.05n

.meas tran vdout1_49ck260 FIND v(dout1_49) AT=270.05n

.meas tran vdout1_50ck260 FIND v(dout1_50) AT=270.05n

.meas tran vdout1_51ck260 FIND v(dout1_51) AT=270.05n

.meas tran vdout1_52ck260 FIND v(dout1_52) AT=270.05n

.meas tran vdout1_53ck260 FIND v(dout1_53) AT=270.05n

.meas tran vdout1_54ck260 FIND v(dout1_54) AT=270.05n

.meas tran vdout1_55ck260 FIND v(dout1_55) AT=270.05n

.meas tran vdout1_56ck260 FIND v(dout1_56) AT=270.05n

.meas tran vdout1_57ck260 FIND v(dout1_57) AT=270.05n

.meas tran vdout1_58ck260 FIND v(dout1_58) AT=270.05n

.meas tran vdout1_59ck260 FIND v(dout1_59) AT=270.05n

.meas tran vdout1_60ck260 FIND v(dout1_60) AT=270.05n

.meas tran vdout1_61ck260 FIND v(dout1_61) AT=270.05n

.meas tran vdout1_62ck260 FIND v(dout1_62) AT=270.05n

.meas tran vdout1_63ck260 FIND v(dout1_63) AT=270.05n

.meas tran vdout1_64ck260 FIND v(dout1_64) AT=270.05n

.meas tran vdout1_65ck260 FIND v(dout1_65) AT=270.05n

.meas tran vdout1_66ck260 FIND v(dout1_66) AT=270.05n

.meas tran vdout1_67ck260 FIND v(dout1_67) AT=270.05n

.meas tran vdout1_68ck260 FIND v(dout1_68) AT=270.05n

.meas tran vdout1_69ck260 FIND v(dout1_69) AT=270.05n

.meas tran vdout1_70ck260 FIND v(dout1_70) AT=270.05n

.meas tran vdout1_71ck260 FIND v(dout1_71) AT=270.05n

.meas tran vdout1_72ck260 FIND v(dout1_72) AT=270.05n

.meas tran vdout1_73ck260 FIND v(dout1_73) AT=270.05n

.meas tran vdout1_74ck260 FIND v(dout1_74) AT=270.05n

.meas tran vdout1_75ck260 FIND v(dout1_75) AT=270.05n

.meas tran vdout1_76ck260 FIND v(dout1_76) AT=270.05n

.meas tran vdout1_77ck260 FIND v(dout1_77) AT=270.05n

.meas tran vdout1_78ck260 FIND v(dout1_78) AT=270.05n

.meas tran vdout1_79ck260 FIND v(dout1_79) AT=270.05n

.meas tran vdout1_80ck260 FIND v(dout1_80) AT=270.05n

.meas tran vdout1_81ck260 FIND v(dout1_81) AT=270.05n

.meas tran vdout1_82ck260 FIND v(dout1_82) AT=270.05n

.meas tran vdout1_83ck260 FIND v(dout1_83) AT=270.05n

.meas tran vdout1_84ck260 FIND v(dout1_84) AT=270.05n

.meas tran vdout1_85ck260 FIND v(dout1_85) AT=270.05n

.meas tran vdout1_86ck260 FIND v(dout1_86) AT=270.05n

.meas tran vdout1_87ck260 FIND v(dout1_87) AT=270.05n

.meas tran vdout1_88ck260 FIND v(dout1_88) AT=270.05n

.meas tran vdout1_89ck260 FIND v(dout1_89) AT=270.05n

.meas tran vdout1_90ck260 FIND v(dout1_90) AT=270.05n

.meas tran vdout1_91ck260 FIND v(dout1_91) AT=270.05n

.meas tran vdout1_92ck260 FIND v(dout1_92) AT=270.05n

.meas tran vdout1_93ck260 FIND v(dout1_93) AT=270.05n

.meas tran vdout1_94ck260 FIND v(dout1_94) AT=270.05n

.meas tran vdout1_95ck260 FIND v(dout1_95) AT=270.05n

.meas tran vdout1_96ck260 FIND v(dout1_96) AT=270.05n

.meas tran vdout1_97ck260 FIND v(dout1_97) AT=270.05n

.meas tran vdout1_98ck260 FIND v(dout1_98) AT=270.05n

.meas tran vdout1_99ck260 FIND v(dout1_99) AT=270.05n

.meas tran vdout1_100ck260 FIND v(dout1_100) AT=270.05n

.meas tran vdout1_101ck260 FIND v(dout1_101) AT=270.05n

.meas tran vdout1_102ck260 FIND v(dout1_102) AT=270.05n

.meas tran vdout1_103ck260 FIND v(dout1_103) AT=270.05n

.meas tran vdout1_104ck260 FIND v(dout1_104) AT=270.05n

.meas tran vdout1_105ck260 FIND v(dout1_105) AT=270.05n

.meas tran vdout1_106ck260 FIND v(dout1_106) AT=270.05n

.meas tran vdout1_107ck260 FIND v(dout1_107) AT=270.05n

.meas tran vdout1_108ck260 FIND v(dout1_108) AT=270.05n

.meas tran vdout1_109ck260 FIND v(dout1_109) AT=270.05n

.meas tran vdout1_110ck260 FIND v(dout1_110) AT=270.05n

.meas tran vdout1_111ck260 FIND v(dout1_111) AT=270.05n

.meas tran vdout1_112ck260 FIND v(dout1_112) AT=270.05n

.meas tran vdout1_113ck260 FIND v(dout1_113) AT=270.05n

.meas tran vdout1_114ck260 FIND v(dout1_114) AT=270.05n

.meas tran vdout1_115ck260 FIND v(dout1_115) AT=270.05n

.meas tran vdout1_116ck260 FIND v(dout1_116) AT=270.05n

.meas tran vdout1_117ck260 FIND v(dout1_117) AT=270.05n

.meas tran vdout1_118ck260 FIND v(dout1_118) AT=270.05n

.meas tran vdout1_119ck260 FIND v(dout1_119) AT=270.05n

.meas tran vdout1_120ck260 FIND v(dout1_120) AT=270.05n

.meas tran vdout1_121ck260 FIND v(dout1_121) AT=270.05n

.meas tran vdout1_122ck260 FIND v(dout1_122) AT=270.05n

.meas tran vdout1_123ck260 FIND v(dout1_123) AT=270.05n

.meas tran vdout1_124ck260 FIND v(dout1_124) AT=270.05n

.meas tran vdout1_125ck260 FIND v(dout1_125) AT=270.05n

.meas tran vdout1_126ck260 FIND v(dout1_126) AT=270.05n

.meas tran vdout1_127ck260 FIND v(dout1_127) AT=270.05n

.meas tran vdout1_128ck260 FIND v(dout1_128) AT=270.05n

.meas tran vdout1_129ck260 FIND v(dout1_129) AT=270.05n

.meas tran vdout1_130ck260 FIND v(dout1_130) AT=270.05n

.meas tran vdout1_131ck260 FIND v(dout1_131) AT=270.05n

.meas tran vdout1_132ck260 FIND v(dout1_132) AT=270.05n

.meas tran vdout1_133ck260 FIND v(dout1_133) AT=270.05n

.meas tran vdout1_134ck260 FIND v(dout1_134) AT=270.05n

.meas tran vdout1_135ck260 FIND v(dout1_135) AT=270.05n

.meas tran vdout1_136ck260 FIND v(dout1_136) AT=270.05n

.meas tran vdout1_137ck260 FIND v(dout1_137) AT=270.05n

.meas tran vdout1_138ck260 FIND v(dout1_138) AT=270.05n

.meas tran vdout1_139ck260 FIND v(dout1_139) AT=270.05n

.meas tran vdout1_140ck260 FIND v(dout1_140) AT=270.05n

.meas tran vdout1_141ck260 FIND v(dout1_141) AT=270.05n

.meas tran vdout1_142ck260 FIND v(dout1_142) AT=270.05n

.meas tran vdout1_143ck260 FIND v(dout1_143) AT=270.05n

.meas tran vdout1_144ck260 FIND v(dout1_144) AT=270.05n

.meas tran vdout1_145ck260 FIND v(dout1_145) AT=270.05n

.meas tran vdout1_146ck260 FIND v(dout1_146) AT=270.05n

.meas tran vdout1_147ck260 FIND v(dout1_147) AT=270.05n

.meas tran vdout1_148ck260 FIND v(dout1_148) AT=270.05n

.meas tran vdout1_149ck260 FIND v(dout1_149) AT=270.05n

.meas tran vdout1_150ck260 FIND v(dout1_150) AT=270.05n

.meas tran vdout1_151ck260 FIND v(dout1_151) AT=270.05n

.meas tran vdout1_152ck260 FIND v(dout1_152) AT=270.05n

.meas tran vdout1_153ck260 FIND v(dout1_153) AT=270.05n

.meas tran vdout1_154ck260 FIND v(dout1_154) AT=270.05n

.meas tran vdout1_155ck260 FIND v(dout1_155) AT=270.05n

.meas tran vdout1_156ck260 FIND v(dout1_156) AT=270.05n

.meas tran vdout1_157ck260 FIND v(dout1_157) AT=270.05n

.meas tran vdout1_158ck260 FIND v(dout1_158) AT=270.05n

.meas tran vdout1_159ck260 FIND v(dout1_159) AT=270.05n

.meas tran vdout1_160ck260 FIND v(dout1_160) AT=270.05n

.meas tran vdout1_161ck260 FIND v(dout1_161) AT=270.05n

.meas tran vdout1_162ck260 FIND v(dout1_162) AT=270.05n

.meas tran vdout1_163ck260 FIND v(dout1_163) AT=270.05n

.meas tran vdout1_164ck260 FIND v(dout1_164) AT=270.05n

.meas tran vdout1_165ck260 FIND v(dout1_165) AT=270.05n

.meas tran vdout1_166ck260 FIND v(dout1_166) AT=270.05n

.meas tran vdout1_167ck260 FIND v(dout1_167) AT=270.05n

.meas tran vdout1_168ck260 FIND v(dout1_168) AT=270.05n

.meas tran vdout1_169ck260 FIND v(dout1_169) AT=270.05n

.meas tran vdout1_170ck260 FIND v(dout1_170) AT=270.05n

.meas tran vdout1_171ck260 FIND v(dout1_171) AT=270.05n

.meas tran vdout1_172ck260 FIND v(dout1_172) AT=270.05n

.meas tran vdout1_173ck260 FIND v(dout1_173) AT=270.05n

.meas tran vdout1_174ck260 FIND v(dout1_174) AT=270.05n

.meas tran vdout1_175ck260 FIND v(dout1_175) AT=270.05n

.meas tran vdout1_176ck260 FIND v(dout1_176) AT=270.05n

.meas tran vdout1_177ck260 FIND v(dout1_177) AT=270.05n

.meas tran vdout1_178ck260 FIND v(dout1_178) AT=270.05n

.meas tran vdout1_179ck260 FIND v(dout1_179) AT=270.05n

.meas tran vdout1_180ck260 FIND v(dout1_180) AT=270.05n

.meas tran vdout1_181ck260 FIND v(dout1_181) AT=270.05n

.meas tran vdout1_182ck260 FIND v(dout1_182) AT=270.05n

.meas tran vdout1_183ck260 FIND v(dout1_183) AT=270.05n

.meas tran vdout1_184ck260 FIND v(dout1_184) AT=270.05n

.meas tran vdout1_185ck260 FIND v(dout1_185) AT=270.05n

.meas tran vdout1_186ck260 FIND v(dout1_186) AT=270.05n

.meas tran vdout1_187ck260 FIND v(dout1_187) AT=270.05n

.meas tran vdout1_188ck260 FIND v(dout1_188) AT=270.05n

.meas tran vdout1_189ck260 FIND v(dout1_189) AT=270.05n

.meas tran vdout1_190ck260 FIND v(dout1_190) AT=270.05n

.meas tran vdout1_191ck260 FIND v(dout1_191) AT=270.05n

.meas tran vdout1_192ck260 FIND v(dout1_192) AT=270.05n

.meas tran vdout1_193ck260 FIND v(dout1_193) AT=270.05n

.meas tran vdout1_194ck260 FIND v(dout1_194) AT=270.05n

.meas tran vdout1_195ck260 FIND v(dout1_195) AT=270.05n

.meas tran vdout1_196ck260 FIND v(dout1_196) AT=270.05n

.meas tran vdout1_197ck260 FIND v(dout1_197) AT=270.05n

.meas tran vdout1_198ck260 FIND v(dout1_198) AT=270.05n

.meas tran vdout1_199ck260 FIND v(dout1_199) AT=270.05n

.meas tran vdout1_200ck260 FIND v(dout1_200) AT=270.05n

.meas tran vdout1_201ck260 FIND v(dout1_201) AT=270.05n

.meas tran vdout1_202ck260 FIND v(dout1_202) AT=270.05n

.meas tran vdout1_203ck260 FIND v(dout1_203) AT=270.05n

.meas tran vdout1_204ck260 FIND v(dout1_204) AT=270.05n

.meas tran vdout1_205ck260 FIND v(dout1_205) AT=270.05n

.meas tran vdout1_206ck260 FIND v(dout1_206) AT=270.05n

.meas tran vdout1_207ck260 FIND v(dout1_207) AT=270.05n

.meas tran vdout1_208ck260 FIND v(dout1_208) AT=270.05n

.meas tran vdout1_209ck260 FIND v(dout1_209) AT=270.05n

.meas tran vdout1_210ck260 FIND v(dout1_210) AT=270.05n

.meas tran vdout1_211ck260 FIND v(dout1_211) AT=270.05n

.meas tran vdout1_212ck260 FIND v(dout1_212) AT=270.05n

.meas tran vdout1_213ck260 FIND v(dout1_213) AT=270.05n

.meas tran vdout1_214ck260 FIND v(dout1_214) AT=270.05n

.meas tran vdout1_215ck260 FIND v(dout1_215) AT=270.05n

.meas tran vdout1_216ck260 FIND v(dout1_216) AT=270.05n

.meas tran vdout1_217ck260 FIND v(dout1_217) AT=270.05n

.meas tran vdout1_218ck260 FIND v(dout1_218) AT=270.05n

.meas tran vdout1_219ck260 FIND v(dout1_219) AT=270.05n

.meas tran vdout1_220ck260 FIND v(dout1_220) AT=270.05n

.meas tran vdout1_221ck260 FIND v(dout1_221) AT=270.05n

.meas tran vdout1_222ck260 FIND v(dout1_222) AT=270.05n

.meas tran vdout1_223ck260 FIND v(dout1_223) AT=270.05n

.meas tran vdout1_224ck260 FIND v(dout1_224) AT=270.05n

.meas tran vdout1_225ck260 FIND v(dout1_225) AT=270.05n

.meas tran vdout1_226ck260 FIND v(dout1_226) AT=270.05n

.meas tran vdout1_227ck260 FIND v(dout1_227) AT=270.05n

.meas tran vdout1_228ck260 FIND v(dout1_228) AT=270.05n

.meas tran vdout1_229ck260 FIND v(dout1_229) AT=270.05n

.meas tran vdout1_230ck260 FIND v(dout1_230) AT=270.05n

.meas tran vdout1_231ck260 FIND v(dout1_231) AT=270.05n

.meas tran vdout1_232ck260 FIND v(dout1_232) AT=270.05n

.meas tran vdout1_233ck260 FIND v(dout1_233) AT=270.05n

.meas tran vdout1_234ck260 FIND v(dout1_234) AT=270.05n

.meas tran vdout1_235ck260 FIND v(dout1_235) AT=270.05n

.meas tran vdout1_236ck260 FIND v(dout1_236) AT=270.05n

.meas tran vdout1_237ck260 FIND v(dout1_237) AT=270.05n

.meas tran vdout1_238ck260 FIND v(dout1_238) AT=270.05n

.meas tran vdout1_239ck260 FIND v(dout1_239) AT=270.05n

.meas tran vdout1_240ck260 FIND v(dout1_240) AT=270.05n

.meas tran vdout1_241ck260 FIND v(dout1_241) AT=270.05n

.meas tran vdout1_242ck260 FIND v(dout1_242) AT=270.05n

.meas tran vdout1_243ck260 FIND v(dout1_243) AT=270.05n

.meas tran vdout1_244ck260 FIND v(dout1_244) AT=270.05n

.meas tran vdout1_245ck260 FIND v(dout1_245) AT=270.05n

.meas tran vdout1_246ck260 FIND v(dout1_246) AT=270.05n

.meas tran vdout1_247ck260 FIND v(dout1_247) AT=270.05n

.meas tran vdout1_248ck260 FIND v(dout1_248) AT=270.05n

.meas tran vdout1_249ck260 FIND v(dout1_249) AT=270.05n

.meas tran vdout1_250ck260 FIND v(dout1_250) AT=270.05n

.meas tran vdout1_251ck260 FIND v(dout1_251) AT=270.05n

.meas tran vdout1_252ck260 FIND v(dout1_252) AT=270.05n

.meas tran vdout1_253ck260 FIND v(dout1_253) AT=270.05n

.meas tran vdout1_254ck260 FIND v(dout1_254) AT=270.05n

.meas tran vdout1_255ck260 FIND v(dout1_255) AT=270.05n

.meas tran vdout1_256ck260 FIND v(dout1_256) AT=270.05n

.meas tran vdout1_0ck280 FIND v(dout1_0) AT=290.05n

.meas tran vdout1_1ck280 FIND v(dout1_1) AT=290.05n

.meas tran vdout1_2ck280 FIND v(dout1_2) AT=290.05n

.meas tran vdout1_3ck280 FIND v(dout1_3) AT=290.05n

.meas tran vdout1_4ck280 FIND v(dout1_4) AT=290.05n

.meas tran vdout1_5ck280 FIND v(dout1_5) AT=290.05n

.meas tran vdout1_6ck280 FIND v(dout1_6) AT=290.05n

.meas tran vdout1_7ck280 FIND v(dout1_7) AT=290.05n

.meas tran vdout1_8ck280 FIND v(dout1_8) AT=290.05n

.meas tran vdout1_9ck280 FIND v(dout1_9) AT=290.05n

.meas tran vdout1_10ck280 FIND v(dout1_10) AT=290.05n

.meas tran vdout1_11ck280 FIND v(dout1_11) AT=290.05n

.meas tran vdout1_12ck280 FIND v(dout1_12) AT=290.05n

.meas tran vdout1_13ck280 FIND v(dout1_13) AT=290.05n

.meas tran vdout1_14ck280 FIND v(dout1_14) AT=290.05n

.meas tran vdout1_15ck280 FIND v(dout1_15) AT=290.05n

.meas tran vdout1_16ck280 FIND v(dout1_16) AT=290.05n

.meas tran vdout1_17ck280 FIND v(dout1_17) AT=290.05n

.meas tran vdout1_18ck280 FIND v(dout1_18) AT=290.05n

.meas tran vdout1_19ck280 FIND v(dout1_19) AT=290.05n

.meas tran vdout1_20ck280 FIND v(dout1_20) AT=290.05n

.meas tran vdout1_21ck280 FIND v(dout1_21) AT=290.05n

.meas tran vdout1_22ck280 FIND v(dout1_22) AT=290.05n

.meas tran vdout1_23ck280 FIND v(dout1_23) AT=290.05n

.meas tran vdout1_24ck280 FIND v(dout1_24) AT=290.05n

.meas tran vdout1_25ck280 FIND v(dout1_25) AT=290.05n

.meas tran vdout1_26ck280 FIND v(dout1_26) AT=290.05n

.meas tran vdout1_27ck280 FIND v(dout1_27) AT=290.05n

.meas tran vdout1_28ck280 FIND v(dout1_28) AT=290.05n

.meas tran vdout1_29ck280 FIND v(dout1_29) AT=290.05n

.meas tran vdout1_30ck280 FIND v(dout1_30) AT=290.05n

.meas tran vdout1_31ck280 FIND v(dout1_31) AT=290.05n

.meas tran vdout1_32ck280 FIND v(dout1_32) AT=290.05n

.meas tran vdout1_33ck280 FIND v(dout1_33) AT=290.05n

.meas tran vdout1_34ck280 FIND v(dout1_34) AT=290.05n

.meas tran vdout1_35ck280 FIND v(dout1_35) AT=290.05n

.meas tran vdout1_36ck280 FIND v(dout1_36) AT=290.05n

.meas tran vdout1_37ck280 FIND v(dout1_37) AT=290.05n

.meas tran vdout1_38ck280 FIND v(dout1_38) AT=290.05n

.meas tran vdout1_39ck280 FIND v(dout1_39) AT=290.05n

.meas tran vdout1_40ck280 FIND v(dout1_40) AT=290.05n

.meas tran vdout1_41ck280 FIND v(dout1_41) AT=290.05n

.meas tran vdout1_42ck280 FIND v(dout1_42) AT=290.05n

.meas tran vdout1_43ck280 FIND v(dout1_43) AT=290.05n

.meas tran vdout1_44ck280 FIND v(dout1_44) AT=290.05n

.meas tran vdout1_45ck280 FIND v(dout1_45) AT=290.05n

.meas tran vdout1_46ck280 FIND v(dout1_46) AT=290.05n

.meas tran vdout1_47ck280 FIND v(dout1_47) AT=290.05n

.meas tran vdout1_48ck280 FIND v(dout1_48) AT=290.05n

.meas tran vdout1_49ck280 FIND v(dout1_49) AT=290.05n

.meas tran vdout1_50ck280 FIND v(dout1_50) AT=290.05n

.meas tran vdout1_51ck280 FIND v(dout1_51) AT=290.05n

.meas tran vdout1_52ck280 FIND v(dout1_52) AT=290.05n

.meas tran vdout1_53ck280 FIND v(dout1_53) AT=290.05n

.meas tran vdout1_54ck280 FIND v(dout1_54) AT=290.05n

.meas tran vdout1_55ck280 FIND v(dout1_55) AT=290.05n

.meas tran vdout1_56ck280 FIND v(dout1_56) AT=290.05n

.meas tran vdout1_57ck280 FIND v(dout1_57) AT=290.05n

.meas tran vdout1_58ck280 FIND v(dout1_58) AT=290.05n

.meas tran vdout1_59ck280 FIND v(dout1_59) AT=290.05n

.meas tran vdout1_60ck280 FIND v(dout1_60) AT=290.05n

.meas tran vdout1_61ck280 FIND v(dout1_61) AT=290.05n

.meas tran vdout1_62ck280 FIND v(dout1_62) AT=290.05n

.meas tran vdout1_63ck280 FIND v(dout1_63) AT=290.05n

.meas tran vdout1_64ck280 FIND v(dout1_64) AT=290.05n

.meas tran vdout1_65ck280 FIND v(dout1_65) AT=290.05n

.meas tran vdout1_66ck280 FIND v(dout1_66) AT=290.05n

.meas tran vdout1_67ck280 FIND v(dout1_67) AT=290.05n

.meas tran vdout1_68ck280 FIND v(dout1_68) AT=290.05n

.meas tran vdout1_69ck280 FIND v(dout1_69) AT=290.05n

.meas tran vdout1_70ck280 FIND v(dout1_70) AT=290.05n

.meas tran vdout1_71ck280 FIND v(dout1_71) AT=290.05n

.meas tran vdout1_72ck280 FIND v(dout1_72) AT=290.05n

.meas tran vdout1_73ck280 FIND v(dout1_73) AT=290.05n

.meas tran vdout1_74ck280 FIND v(dout1_74) AT=290.05n

.meas tran vdout1_75ck280 FIND v(dout1_75) AT=290.05n

.meas tran vdout1_76ck280 FIND v(dout1_76) AT=290.05n

.meas tran vdout1_77ck280 FIND v(dout1_77) AT=290.05n

.meas tran vdout1_78ck280 FIND v(dout1_78) AT=290.05n

.meas tran vdout1_79ck280 FIND v(dout1_79) AT=290.05n

.meas tran vdout1_80ck280 FIND v(dout1_80) AT=290.05n

.meas tran vdout1_81ck280 FIND v(dout1_81) AT=290.05n

.meas tran vdout1_82ck280 FIND v(dout1_82) AT=290.05n

.meas tran vdout1_83ck280 FIND v(dout1_83) AT=290.05n

.meas tran vdout1_84ck280 FIND v(dout1_84) AT=290.05n

.meas tran vdout1_85ck280 FIND v(dout1_85) AT=290.05n

.meas tran vdout1_86ck280 FIND v(dout1_86) AT=290.05n

.meas tran vdout1_87ck280 FIND v(dout1_87) AT=290.05n

.meas tran vdout1_88ck280 FIND v(dout1_88) AT=290.05n

.meas tran vdout1_89ck280 FIND v(dout1_89) AT=290.05n

.meas tran vdout1_90ck280 FIND v(dout1_90) AT=290.05n

.meas tran vdout1_91ck280 FIND v(dout1_91) AT=290.05n

.meas tran vdout1_92ck280 FIND v(dout1_92) AT=290.05n

.meas tran vdout1_93ck280 FIND v(dout1_93) AT=290.05n

.meas tran vdout1_94ck280 FIND v(dout1_94) AT=290.05n

.meas tran vdout1_95ck280 FIND v(dout1_95) AT=290.05n

.meas tran vdout1_96ck280 FIND v(dout1_96) AT=290.05n

.meas tran vdout1_97ck280 FIND v(dout1_97) AT=290.05n

.meas tran vdout1_98ck280 FIND v(dout1_98) AT=290.05n

.meas tran vdout1_99ck280 FIND v(dout1_99) AT=290.05n

.meas tran vdout1_100ck280 FIND v(dout1_100) AT=290.05n

.meas tran vdout1_101ck280 FIND v(dout1_101) AT=290.05n

.meas tran vdout1_102ck280 FIND v(dout1_102) AT=290.05n

.meas tran vdout1_103ck280 FIND v(dout1_103) AT=290.05n

.meas tran vdout1_104ck280 FIND v(dout1_104) AT=290.05n

.meas tran vdout1_105ck280 FIND v(dout1_105) AT=290.05n

.meas tran vdout1_106ck280 FIND v(dout1_106) AT=290.05n

.meas tran vdout1_107ck280 FIND v(dout1_107) AT=290.05n

.meas tran vdout1_108ck280 FIND v(dout1_108) AT=290.05n

.meas tran vdout1_109ck280 FIND v(dout1_109) AT=290.05n

.meas tran vdout1_110ck280 FIND v(dout1_110) AT=290.05n

.meas tran vdout1_111ck280 FIND v(dout1_111) AT=290.05n

.meas tran vdout1_112ck280 FIND v(dout1_112) AT=290.05n

.meas tran vdout1_113ck280 FIND v(dout1_113) AT=290.05n

.meas tran vdout1_114ck280 FIND v(dout1_114) AT=290.05n

.meas tran vdout1_115ck280 FIND v(dout1_115) AT=290.05n

.meas tran vdout1_116ck280 FIND v(dout1_116) AT=290.05n

.meas tran vdout1_117ck280 FIND v(dout1_117) AT=290.05n

.meas tran vdout1_118ck280 FIND v(dout1_118) AT=290.05n

.meas tran vdout1_119ck280 FIND v(dout1_119) AT=290.05n

.meas tran vdout1_120ck280 FIND v(dout1_120) AT=290.05n

.meas tran vdout1_121ck280 FIND v(dout1_121) AT=290.05n

.meas tran vdout1_122ck280 FIND v(dout1_122) AT=290.05n

.meas tran vdout1_123ck280 FIND v(dout1_123) AT=290.05n

.meas tran vdout1_124ck280 FIND v(dout1_124) AT=290.05n

.meas tran vdout1_125ck280 FIND v(dout1_125) AT=290.05n

.meas tran vdout1_126ck280 FIND v(dout1_126) AT=290.05n

.meas tran vdout1_127ck280 FIND v(dout1_127) AT=290.05n

.meas tran vdout1_128ck280 FIND v(dout1_128) AT=290.05n

.meas tran vdout1_129ck280 FIND v(dout1_129) AT=290.05n

.meas tran vdout1_130ck280 FIND v(dout1_130) AT=290.05n

.meas tran vdout1_131ck280 FIND v(dout1_131) AT=290.05n

.meas tran vdout1_132ck280 FIND v(dout1_132) AT=290.05n

.meas tran vdout1_133ck280 FIND v(dout1_133) AT=290.05n

.meas tran vdout1_134ck280 FIND v(dout1_134) AT=290.05n

.meas tran vdout1_135ck280 FIND v(dout1_135) AT=290.05n

.meas tran vdout1_136ck280 FIND v(dout1_136) AT=290.05n

.meas tran vdout1_137ck280 FIND v(dout1_137) AT=290.05n

.meas tran vdout1_138ck280 FIND v(dout1_138) AT=290.05n

.meas tran vdout1_139ck280 FIND v(dout1_139) AT=290.05n

.meas tran vdout1_140ck280 FIND v(dout1_140) AT=290.05n

.meas tran vdout1_141ck280 FIND v(dout1_141) AT=290.05n

.meas tran vdout1_142ck280 FIND v(dout1_142) AT=290.05n

.meas tran vdout1_143ck280 FIND v(dout1_143) AT=290.05n

.meas tran vdout1_144ck280 FIND v(dout1_144) AT=290.05n

.meas tran vdout1_145ck280 FIND v(dout1_145) AT=290.05n

.meas tran vdout1_146ck280 FIND v(dout1_146) AT=290.05n

.meas tran vdout1_147ck280 FIND v(dout1_147) AT=290.05n

.meas tran vdout1_148ck280 FIND v(dout1_148) AT=290.05n

.meas tran vdout1_149ck280 FIND v(dout1_149) AT=290.05n

.meas tran vdout1_150ck280 FIND v(dout1_150) AT=290.05n

.meas tran vdout1_151ck280 FIND v(dout1_151) AT=290.05n

.meas tran vdout1_152ck280 FIND v(dout1_152) AT=290.05n

.meas tran vdout1_153ck280 FIND v(dout1_153) AT=290.05n

.meas tran vdout1_154ck280 FIND v(dout1_154) AT=290.05n

.meas tran vdout1_155ck280 FIND v(dout1_155) AT=290.05n

.meas tran vdout1_156ck280 FIND v(dout1_156) AT=290.05n

.meas tran vdout1_157ck280 FIND v(dout1_157) AT=290.05n

.meas tran vdout1_158ck280 FIND v(dout1_158) AT=290.05n

.meas tran vdout1_159ck280 FIND v(dout1_159) AT=290.05n

.meas tran vdout1_160ck280 FIND v(dout1_160) AT=290.05n

.meas tran vdout1_161ck280 FIND v(dout1_161) AT=290.05n

.meas tran vdout1_162ck280 FIND v(dout1_162) AT=290.05n

.meas tran vdout1_163ck280 FIND v(dout1_163) AT=290.05n

.meas tran vdout1_164ck280 FIND v(dout1_164) AT=290.05n

.meas tran vdout1_165ck280 FIND v(dout1_165) AT=290.05n

.meas tran vdout1_166ck280 FIND v(dout1_166) AT=290.05n

.meas tran vdout1_167ck280 FIND v(dout1_167) AT=290.05n

.meas tran vdout1_168ck280 FIND v(dout1_168) AT=290.05n

.meas tran vdout1_169ck280 FIND v(dout1_169) AT=290.05n

.meas tran vdout1_170ck280 FIND v(dout1_170) AT=290.05n

.meas tran vdout1_171ck280 FIND v(dout1_171) AT=290.05n

.meas tran vdout1_172ck280 FIND v(dout1_172) AT=290.05n

.meas tran vdout1_173ck280 FIND v(dout1_173) AT=290.05n

.meas tran vdout1_174ck280 FIND v(dout1_174) AT=290.05n

.meas tran vdout1_175ck280 FIND v(dout1_175) AT=290.05n

.meas tran vdout1_176ck280 FIND v(dout1_176) AT=290.05n

.meas tran vdout1_177ck280 FIND v(dout1_177) AT=290.05n

.meas tran vdout1_178ck280 FIND v(dout1_178) AT=290.05n

.meas tran vdout1_179ck280 FIND v(dout1_179) AT=290.05n

.meas tran vdout1_180ck280 FIND v(dout1_180) AT=290.05n

.meas tran vdout1_181ck280 FIND v(dout1_181) AT=290.05n

.meas tran vdout1_182ck280 FIND v(dout1_182) AT=290.05n

.meas tran vdout1_183ck280 FIND v(dout1_183) AT=290.05n

.meas tran vdout1_184ck280 FIND v(dout1_184) AT=290.05n

.meas tran vdout1_185ck280 FIND v(dout1_185) AT=290.05n

.meas tran vdout1_186ck280 FIND v(dout1_186) AT=290.05n

.meas tran vdout1_187ck280 FIND v(dout1_187) AT=290.05n

.meas tran vdout1_188ck280 FIND v(dout1_188) AT=290.05n

.meas tran vdout1_189ck280 FIND v(dout1_189) AT=290.05n

.meas tran vdout1_190ck280 FIND v(dout1_190) AT=290.05n

.meas tran vdout1_191ck280 FIND v(dout1_191) AT=290.05n

.meas tran vdout1_192ck280 FIND v(dout1_192) AT=290.05n

.meas tran vdout1_193ck280 FIND v(dout1_193) AT=290.05n

.meas tran vdout1_194ck280 FIND v(dout1_194) AT=290.05n

.meas tran vdout1_195ck280 FIND v(dout1_195) AT=290.05n

.meas tran vdout1_196ck280 FIND v(dout1_196) AT=290.05n

.meas tran vdout1_197ck280 FIND v(dout1_197) AT=290.05n

.meas tran vdout1_198ck280 FIND v(dout1_198) AT=290.05n

.meas tran vdout1_199ck280 FIND v(dout1_199) AT=290.05n

.meas tran vdout1_200ck280 FIND v(dout1_200) AT=290.05n

.meas tran vdout1_201ck280 FIND v(dout1_201) AT=290.05n

.meas tran vdout1_202ck280 FIND v(dout1_202) AT=290.05n

.meas tran vdout1_203ck280 FIND v(dout1_203) AT=290.05n

.meas tran vdout1_204ck280 FIND v(dout1_204) AT=290.05n

.meas tran vdout1_205ck280 FIND v(dout1_205) AT=290.05n

.meas tran vdout1_206ck280 FIND v(dout1_206) AT=290.05n

.meas tran vdout1_207ck280 FIND v(dout1_207) AT=290.05n

.meas tran vdout1_208ck280 FIND v(dout1_208) AT=290.05n

.meas tran vdout1_209ck280 FIND v(dout1_209) AT=290.05n

.meas tran vdout1_210ck280 FIND v(dout1_210) AT=290.05n

.meas tran vdout1_211ck280 FIND v(dout1_211) AT=290.05n

.meas tran vdout1_212ck280 FIND v(dout1_212) AT=290.05n

.meas tran vdout1_213ck280 FIND v(dout1_213) AT=290.05n

.meas tran vdout1_214ck280 FIND v(dout1_214) AT=290.05n

.meas tran vdout1_215ck280 FIND v(dout1_215) AT=290.05n

.meas tran vdout1_216ck280 FIND v(dout1_216) AT=290.05n

.meas tran vdout1_217ck280 FIND v(dout1_217) AT=290.05n

.meas tran vdout1_218ck280 FIND v(dout1_218) AT=290.05n

.meas tran vdout1_219ck280 FIND v(dout1_219) AT=290.05n

.meas tran vdout1_220ck280 FIND v(dout1_220) AT=290.05n

.meas tran vdout1_221ck280 FIND v(dout1_221) AT=290.05n

.meas tran vdout1_222ck280 FIND v(dout1_222) AT=290.05n

.meas tran vdout1_223ck280 FIND v(dout1_223) AT=290.05n

.meas tran vdout1_224ck280 FIND v(dout1_224) AT=290.05n

.meas tran vdout1_225ck280 FIND v(dout1_225) AT=290.05n

.meas tran vdout1_226ck280 FIND v(dout1_226) AT=290.05n

.meas tran vdout1_227ck280 FIND v(dout1_227) AT=290.05n

.meas tran vdout1_228ck280 FIND v(dout1_228) AT=290.05n

.meas tran vdout1_229ck280 FIND v(dout1_229) AT=290.05n

.meas tran vdout1_230ck280 FIND v(dout1_230) AT=290.05n

.meas tran vdout1_231ck280 FIND v(dout1_231) AT=290.05n

.meas tran vdout1_232ck280 FIND v(dout1_232) AT=290.05n

.meas tran vdout1_233ck280 FIND v(dout1_233) AT=290.05n

.meas tran vdout1_234ck280 FIND v(dout1_234) AT=290.05n

.meas tran vdout1_235ck280 FIND v(dout1_235) AT=290.05n

.meas tran vdout1_236ck280 FIND v(dout1_236) AT=290.05n

.meas tran vdout1_237ck280 FIND v(dout1_237) AT=290.05n

.meas tran vdout1_238ck280 FIND v(dout1_238) AT=290.05n

.meas tran vdout1_239ck280 FIND v(dout1_239) AT=290.05n

.meas tran vdout1_240ck280 FIND v(dout1_240) AT=290.05n

.meas tran vdout1_241ck280 FIND v(dout1_241) AT=290.05n

.meas tran vdout1_242ck280 FIND v(dout1_242) AT=290.05n

.meas tran vdout1_243ck280 FIND v(dout1_243) AT=290.05n

.meas tran vdout1_244ck280 FIND v(dout1_244) AT=290.05n

.meas tran vdout1_245ck280 FIND v(dout1_245) AT=290.05n

.meas tran vdout1_246ck280 FIND v(dout1_246) AT=290.05n

.meas tran vdout1_247ck280 FIND v(dout1_247) AT=290.05n

.meas tran vdout1_248ck280 FIND v(dout1_248) AT=290.05n

.meas tran vdout1_249ck280 FIND v(dout1_249) AT=290.05n

.meas tran vdout1_250ck280 FIND v(dout1_250) AT=290.05n

.meas tran vdout1_251ck280 FIND v(dout1_251) AT=290.05n

.meas tran vdout1_252ck280 FIND v(dout1_252) AT=290.05n

.meas tran vdout1_253ck280 FIND v(dout1_253) AT=290.05n

.meas tran vdout1_254ck280 FIND v(dout1_254) AT=290.05n

.meas tran vdout1_255ck280 FIND v(dout1_255) AT=290.05n

.meas tran vdout1_256ck280 FIND v(dout1_256) AT=290.05n

.meas tran vdout1_0ck300 FIND v(dout1_0) AT=310.05n

.meas tran vdout1_1ck300 FIND v(dout1_1) AT=310.05n

.meas tran vdout1_2ck300 FIND v(dout1_2) AT=310.05n

.meas tran vdout1_3ck300 FIND v(dout1_3) AT=310.05n

.meas tran vdout1_4ck300 FIND v(dout1_4) AT=310.05n

.meas tran vdout1_5ck300 FIND v(dout1_5) AT=310.05n

.meas tran vdout1_6ck300 FIND v(dout1_6) AT=310.05n

.meas tran vdout1_7ck300 FIND v(dout1_7) AT=310.05n

.meas tran vdout1_8ck300 FIND v(dout1_8) AT=310.05n

.meas tran vdout1_9ck300 FIND v(dout1_9) AT=310.05n

.meas tran vdout1_10ck300 FIND v(dout1_10) AT=310.05n

.meas tran vdout1_11ck300 FIND v(dout1_11) AT=310.05n

.meas tran vdout1_12ck300 FIND v(dout1_12) AT=310.05n

.meas tran vdout1_13ck300 FIND v(dout1_13) AT=310.05n

.meas tran vdout1_14ck300 FIND v(dout1_14) AT=310.05n

.meas tran vdout1_15ck300 FIND v(dout1_15) AT=310.05n

.meas tran vdout1_16ck300 FIND v(dout1_16) AT=310.05n

.meas tran vdout1_17ck300 FIND v(dout1_17) AT=310.05n

.meas tran vdout1_18ck300 FIND v(dout1_18) AT=310.05n

.meas tran vdout1_19ck300 FIND v(dout1_19) AT=310.05n

.meas tran vdout1_20ck300 FIND v(dout1_20) AT=310.05n

.meas tran vdout1_21ck300 FIND v(dout1_21) AT=310.05n

.meas tran vdout1_22ck300 FIND v(dout1_22) AT=310.05n

.meas tran vdout1_23ck300 FIND v(dout1_23) AT=310.05n

.meas tran vdout1_24ck300 FIND v(dout1_24) AT=310.05n

.meas tran vdout1_25ck300 FIND v(dout1_25) AT=310.05n

.meas tran vdout1_26ck300 FIND v(dout1_26) AT=310.05n

.meas tran vdout1_27ck300 FIND v(dout1_27) AT=310.05n

.meas tran vdout1_28ck300 FIND v(dout1_28) AT=310.05n

.meas tran vdout1_29ck300 FIND v(dout1_29) AT=310.05n

.meas tran vdout1_30ck300 FIND v(dout1_30) AT=310.05n

.meas tran vdout1_31ck300 FIND v(dout1_31) AT=310.05n

.meas tran vdout1_32ck300 FIND v(dout1_32) AT=310.05n

.meas tran vdout1_33ck300 FIND v(dout1_33) AT=310.05n

.meas tran vdout1_34ck300 FIND v(dout1_34) AT=310.05n

.meas tran vdout1_35ck300 FIND v(dout1_35) AT=310.05n

.meas tran vdout1_36ck300 FIND v(dout1_36) AT=310.05n

.meas tran vdout1_37ck300 FIND v(dout1_37) AT=310.05n

.meas tran vdout1_38ck300 FIND v(dout1_38) AT=310.05n

.meas tran vdout1_39ck300 FIND v(dout1_39) AT=310.05n

.meas tran vdout1_40ck300 FIND v(dout1_40) AT=310.05n

.meas tran vdout1_41ck300 FIND v(dout1_41) AT=310.05n

.meas tran vdout1_42ck300 FIND v(dout1_42) AT=310.05n

.meas tran vdout1_43ck300 FIND v(dout1_43) AT=310.05n

.meas tran vdout1_44ck300 FIND v(dout1_44) AT=310.05n

.meas tran vdout1_45ck300 FIND v(dout1_45) AT=310.05n

.meas tran vdout1_46ck300 FIND v(dout1_46) AT=310.05n

.meas tran vdout1_47ck300 FIND v(dout1_47) AT=310.05n

.meas tran vdout1_48ck300 FIND v(dout1_48) AT=310.05n

.meas tran vdout1_49ck300 FIND v(dout1_49) AT=310.05n

.meas tran vdout1_50ck300 FIND v(dout1_50) AT=310.05n

.meas tran vdout1_51ck300 FIND v(dout1_51) AT=310.05n

.meas tran vdout1_52ck300 FIND v(dout1_52) AT=310.05n

.meas tran vdout1_53ck300 FIND v(dout1_53) AT=310.05n

.meas tran vdout1_54ck300 FIND v(dout1_54) AT=310.05n

.meas tran vdout1_55ck300 FIND v(dout1_55) AT=310.05n

.meas tran vdout1_56ck300 FIND v(dout1_56) AT=310.05n

.meas tran vdout1_57ck300 FIND v(dout1_57) AT=310.05n

.meas tran vdout1_58ck300 FIND v(dout1_58) AT=310.05n

.meas tran vdout1_59ck300 FIND v(dout1_59) AT=310.05n

.meas tran vdout1_60ck300 FIND v(dout1_60) AT=310.05n

.meas tran vdout1_61ck300 FIND v(dout1_61) AT=310.05n

.meas tran vdout1_62ck300 FIND v(dout1_62) AT=310.05n

.meas tran vdout1_63ck300 FIND v(dout1_63) AT=310.05n

.meas tran vdout1_64ck300 FIND v(dout1_64) AT=310.05n

.meas tran vdout1_65ck300 FIND v(dout1_65) AT=310.05n

.meas tran vdout1_66ck300 FIND v(dout1_66) AT=310.05n

.meas tran vdout1_67ck300 FIND v(dout1_67) AT=310.05n

.meas tran vdout1_68ck300 FIND v(dout1_68) AT=310.05n

.meas tran vdout1_69ck300 FIND v(dout1_69) AT=310.05n

.meas tran vdout1_70ck300 FIND v(dout1_70) AT=310.05n

.meas tran vdout1_71ck300 FIND v(dout1_71) AT=310.05n

.meas tran vdout1_72ck300 FIND v(dout1_72) AT=310.05n

.meas tran vdout1_73ck300 FIND v(dout1_73) AT=310.05n

.meas tran vdout1_74ck300 FIND v(dout1_74) AT=310.05n

.meas tran vdout1_75ck300 FIND v(dout1_75) AT=310.05n

.meas tran vdout1_76ck300 FIND v(dout1_76) AT=310.05n

.meas tran vdout1_77ck300 FIND v(dout1_77) AT=310.05n

.meas tran vdout1_78ck300 FIND v(dout1_78) AT=310.05n

.meas tran vdout1_79ck300 FIND v(dout1_79) AT=310.05n

.meas tran vdout1_80ck300 FIND v(dout1_80) AT=310.05n

.meas tran vdout1_81ck300 FIND v(dout1_81) AT=310.05n

.meas tran vdout1_82ck300 FIND v(dout1_82) AT=310.05n

.meas tran vdout1_83ck300 FIND v(dout1_83) AT=310.05n

.meas tran vdout1_84ck300 FIND v(dout1_84) AT=310.05n

.meas tran vdout1_85ck300 FIND v(dout1_85) AT=310.05n

.meas tran vdout1_86ck300 FIND v(dout1_86) AT=310.05n

.meas tran vdout1_87ck300 FIND v(dout1_87) AT=310.05n

.meas tran vdout1_88ck300 FIND v(dout1_88) AT=310.05n

.meas tran vdout1_89ck300 FIND v(dout1_89) AT=310.05n

.meas tran vdout1_90ck300 FIND v(dout1_90) AT=310.05n

.meas tran vdout1_91ck300 FIND v(dout1_91) AT=310.05n

.meas tran vdout1_92ck300 FIND v(dout1_92) AT=310.05n

.meas tran vdout1_93ck300 FIND v(dout1_93) AT=310.05n

.meas tran vdout1_94ck300 FIND v(dout1_94) AT=310.05n

.meas tran vdout1_95ck300 FIND v(dout1_95) AT=310.05n

.meas tran vdout1_96ck300 FIND v(dout1_96) AT=310.05n

.meas tran vdout1_97ck300 FIND v(dout1_97) AT=310.05n

.meas tran vdout1_98ck300 FIND v(dout1_98) AT=310.05n

.meas tran vdout1_99ck300 FIND v(dout1_99) AT=310.05n

.meas tran vdout1_100ck300 FIND v(dout1_100) AT=310.05n

.meas tran vdout1_101ck300 FIND v(dout1_101) AT=310.05n

.meas tran vdout1_102ck300 FIND v(dout1_102) AT=310.05n

.meas tran vdout1_103ck300 FIND v(dout1_103) AT=310.05n

.meas tran vdout1_104ck300 FIND v(dout1_104) AT=310.05n

.meas tran vdout1_105ck300 FIND v(dout1_105) AT=310.05n

.meas tran vdout1_106ck300 FIND v(dout1_106) AT=310.05n

.meas tran vdout1_107ck300 FIND v(dout1_107) AT=310.05n

.meas tran vdout1_108ck300 FIND v(dout1_108) AT=310.05n

.meas tran vdout1_109ck300 FIND v(dout1_109) AT=310.05n

.meas tran vdout1_110ck300 FIND v(dout1_110) AT=310.05n

.meas tran vdout1_111ck300 FIND v(dout1_111) AT=310.05n

.meas tran vdout1_112ck300 FIND v(dout1_112) AT=310.05n

.meas tran vdout1_113ck300 FIND v(dout1_113) AT=310.05n

.meas tran vdout1_114ck300 FIND v(dout1_114) AT=310.05n

.meas tran vdout1_115ck300 FIND v(dout1_115) AT=310.05n

.meas tran vdout1_116ck300 FIND v(dout1_116) AT=310.05n

.meas tran vdout1_117ck300 FIND v(dout1_117) AT=310.05n

.meas tran vdout1_118ck300 FIND v(dout1_118) AT=310.05n

.meas tran vdout1_119ck300 FIND v(dout1_119) AT=310.05n

.meas tran vdout1_120ck300 FIND v(dout1_120) AT=310.05n

.meas tran vdout1_121ck300 FIND v(dout1_121) AT=310.05n

.meas tran vdout1_122ck300 FIND v(dout1_122) AT=310.05n

.meas tran vdout1_123ck300 FIND v(dout1_123) AT=310.05n

.meas tran vdout1_124ck300 FIND v(dout1_124) AT=310.05n

.meas tran vdout1_125ck300 FIND v(dout1_125) AT=310.05n

.meas tran vdout1_126ck300 FIND v(dout1_126) AT=310.05n

.meas tran vdout1_127ck300 FIND v(dout1_127) AT=310.05n

.meas tran vdout1_128ck300 FIND v(dout1_128) AT=310.05n

.meas tran vdout1_129ck300 FIND v(dout1_129) AT=310.05n

.meas tran vdout1_130ck300 FIND v(dout1_130) AT=310.05n

.meas tran vdout1_131ck300 FIND v(dout1_131) AT=310.05n

.meas tran vdout1_132ck300 FIND v(dout1_132) AT=310.05n

.meas tran vdout1_133ck300 FIND v(dout1_133) AT=310.05n

.meas tran vdout1_134ck300 FIND v(dout1_134) AT=310.05n

.meas tran vdout1_135ck300 FIND v(dout1_135) AT=310.05n

.meas tran vdout1_136ck300 FIND v(dout1_136) AT=310.05n

.meas tran vdout1_137ck300 FIND v(dout1_137) AT=310.05n

.meas tran vdout1_138ck300 FIND v(dout1_138) AT=310.05n

.meas tran vdout1_139ck300 FIND v(dout1_139) AT=310.05n

.meas tran vdout1_140ck300 FIND v(dout1_140) AT=310.05n

.meas tran vdout1_141ck300 FIND v(dout1_141) AT=310.05n

.meas tran vdout1_142ck300 FIND v(dout1_142) AT=310.05n

.meas tran vdout1_143ck300 FIND v(dout1_143) AT=310.05n

.meas tran vdout1_144ck300 FIND v(dout1_144) AT=310.05n

.meas tran vdout1_145ck300 FIND v(dout1_145) AT=310.05n

.meas tran vdout1_146ck300 FIND v(dout1_146) AT=310.05n

.meas tran vdout1_147ck300 FIND v(dout1_147) AT=310.05n

.meas tran vdout1_148ck300 FIND v(dout1_148) AT=310.05n

.meas tran vdout1_149ck300 FIND v(dout1_149) AT=310.05n

.meas tran vdout1_150ck300 FIND v(dout1_150) AT=310.05n

.meas tran vdout1_151ck300 FIND v(dout1_151) AT=310.05n

.meas tran vdout1_152ck300 FIND v(dout1_152) AT=310.05n

.meas tran vdout1_153ck300 FIND v(dout1_153) AT=310.05n

.meas tran vdout1_154ck300 FIND v(dout1_154) AT=310.05n

.meas tran vdout1_155ck300 FIND v(dout1_155) AT=310.05n

.meas tran vdout1_156ck300 FIND v(dout1_156) AT=310.05n

.meas tran vdout1_157ck300 FIND v(dout1_157) AT=310.05n

.meas tran vdout1_158ck300 FIND v(dout1_158) AT=310.05n

.meas tran vdout1_159ck300 FIND v(dout1_159) AT=310.05n

.meas tran vdout1_160ck300 FIND v(dout1_160) AT=310.05n

.meas tran vdout1_161ck300 FIND v(dout1_161) AT=310.05n

.meas tran vdout1_162ck300 FIND v(dout1_162) AT=310.05n

.meas tran vdout1_163ck300 FIND v(dout1_163) AT=310.05n

.meas tran vdout1_164ck300 FIND v(dout1_164) AT=310.05n

.meas tran vdout1_165ck300 FIND v(dout1_165) AT=310.05n

.meas tran vdout1_166ck300 FIND v(dout1_166) AT=310.05n

.meas tran vdout1_167ck300 FIND v(dout1_167) AT=310.05n

.meas tran vdout1_168ck300 FIND v(dout1_168) AT=310.05n

.meas tran vdout1_169ck300 FIND v(dout1_169) AT=310.05n

.meas tran vdout1_170ck300 FIND v(dout1_170) AT=310.05n

.meas tran vdout1_171ck300 FIND v(dout1_171) AT=310.05n

.meas tran vdout1_172ck300 FIND v(dout1_172) AT=310.05n

.meas tran vdout1_173ck300 FIND v(dout1_173) AT=310.05n

.meas tran vdout1_174ck300 FIND v(dout1_174) AT=310.05n

.meas tran vdout1_175ck300 FIND v(dout1_175) AT=310.05n

.meas tran vdout1_176ck300 FIND v(dout1_176) AT=310.05n

.meas tran vdout1_177ck300 FIND v(dout1_177) AT=310.05n

.meas tran vdout1_178ck300 FIND v(dout1_178) AT=310.05n

.meas tran vdout1_179ck300 FIND v(dout1_179) AT=310.05n

.meas tran vdout1_180ck300 FIND v(dout1_180) AT=310.05n

.meas tran vdout1_181ck300 FIND v(dout1_181) AT=310.05n

.meas tran vdout1_182ck300 FIND v(dout1_182) AT=310.05n

.meas tran vdout1_183ck300 FIND v(dout1_183) AT=310.05n

.meas tran vdout1_184ck300 FIND v(dout1_184) AT=310.05n

.meas tran vdout1_185ck300 FIND v(dout1_185) AT=310.05n

.meas tran vdout1_186ck300 FIND v(dout1_186) AT=310.05n

.meas tran vdout1_187ck300 FIND v(dout1_187) AT=310.05n

.meas tran vdout1_188ck300 FIND v(dout1_188) AT=310.05n

.meas tran vdout1_189ck300 FIND v(dout1_189) AT=310.05n

.meas tran vdout1_190ck300 FIND v(dout1_190) AT=310.05n

.meas tran vdout1_191ck300 FIND v(dout1_191) AT=310.05n

.meas tran vdout1_192ck300 FIND v(dout1_192) AT=310.05n

.meas tran vdout1_193ck300 FIND v(dout1_193) AT=310.05n

.meas tran vdout1_194ck300 FIND v(dout1_194) AT=310.05n

.meas tran vdout1_195ck300 FIND v(dout1_195) AT=310.05n

.meas tran vdout1_196ck300 FIND v(dout1_196) AT=310.05n

.meas tran vdout1_197ck300 FIND v(dout1_197) AT=310.05n

.meas tran vdout1_198ck300 FIND v(dout1_198) AT=310.05n

.meas tran vdout1_199ck300 FIND v(dout1_199) AT=310.05n

.meas tran vdout1_200ck300 FIND v(dout1_200) AT=310.05n

.meas tran vdout1_201ck300 FIND v(dout1_201) AT=310.05n

.meas tran vdout1_202ck300 FIND v(dout1_202) AT=310.05n

.meas tran vdout1_203ck300 FIND v(dout1_203) AT=310.05n

.meas tran vdout1_204ck300 FIND v(dout1_204) AT=310.05n

.meas tran vdout1_205ck300 FIND v(dout1_205) AT=310.05n

.meas tran vdout1_206ck300 FIND v(dout1_206) AT=310.05n

.meas tran vdout1_207ck300 FIND v(dout1_207) AT=310.05n

.meas tran vdout1_208ck300 FIND v(dout1_208) AT=310.05n

.meas tran vdout1_209ck300 FIND v(dout1_209) AT=310.05n

.meas tran vdout1_210ck300 FIND v(dout1_210) AT=310.05n

.meas tran vdout1_211ck300 FIND v(dout1_211) AT=310.05n

.meas tran vdout1_212ck300 FIND v(dout1_212) AT=310.05n

.meas tran vdout1_213ck300 FIND v(dout1_213) AT=310.05n

.meas tran vdout1_214ck300 FIND v(dout1_214) AT=310.05n

.meas tran vdout1_215ck300 FIND v(dout1_215) AT=310.05n

.meas tran vdout1_216ck300 FIND v(dout1_216) AT=310.05n

.meas tran vdout1_217ck300 FIND v(dout1_217) AT=310.05n

.meas tran vdout1_218ck300 FIND v(dout1_218) AT=310.05n

.meas tran vdout1_219ck300 FIND v(dout1_219) AT=310.05n

.meas tran vdout1_220ck300 FIND v(dout1_220) AT=310.05n

.meas tran vdout1_221ck300 FIND v(dout1_221) AT=310.05n

.meas tran vdout1_222ck300 FIND v(dout1_222) AT=310.05n

.meas tran vdout1_223ck300 FIND v(dout1_223) AT=310.05n

.meas tran vdout1_224ck300 FIND v(dout1_224) AT=310.05n

.meas tran vdout1_225ck300 FIND v(dout1_225) AT=310.05n

.meas tran vdout1_226ck300 FIND v(dout1_226) AT=310.05n

.meas tran vdout1_227ck300 FIND v(dout1_227) AT=310.05n

.meas tran vdout1_228ck300 FIND v(dout1_228) AT=310.05n

.meas tran vdout1_229ck300 FIND v(dout1_229) AT=310.05n

.meas tran vdout1_230ck300 FIND v(dout1_230) AT=310.05n

.meas tran vdout1_231ck300 FIND v(dout1_231) AT=310.05n

.meas tran vdout1_232ck300 FIND v(dout1_232) AT=310.05n

.meas tran vdout1_233ck300 FIND v(dout1_233) AT=310.05n

.meas tran vdout1_234ck300 FIND v(dout1_234) AT=310.05n

.meas tran vdout1_235ck300 FIND v(dout1_235) AT=310.05n

.meas tran vdout1_236ck300 FIND v(dout1_236) AT=310.05n

.meas tran vdout1_237ck300 FIND v(dout1_237) AT=310.05n

.meas tran vdout1_238ck300 FIND v(dout1_238) AT=310.05n

.meas tran vdout1_239ck300 FIND v(dout1_239) AT=310.05n

.meas tran vdout1_240ck300 FIND v(dout1_240) AT=310.05n

.meas tran vdout1_241ck300 FIND v(dout1_241) AT=310.05n

.meas tran vdout1_242ck300 FIND v(dout1_242) AT=310.05n

.meas tran vdout1_243ck300 FIND v(dout1_243) AT=310.05n

.meas tran vdout1_244ck300 FIND v(dout1_244) AT=310.05n

.meas tran vdout1_245ck300 FIND v(dout1_245) AT=310.05n

.meas tran vdout1_246ck300 FIND v(dout1_246) AT=310.05n

.meas tran vdout1_247ck300 FIND v(dout1_247) AT=310.05n

.meas tran vdout1_248ck300 FIND v(dout1_248) AT=310.05n

.meas tran vdout1_249ck300 FIND v(dout1_249) AT=310.05n

.meas tran vdout1_250ck300 FIND v(dout1_250) AT=310.05n

.meas tran vdout1_251ck300 FIND v(dout1_251) AT=310.05n

.meas tran vdout1_252ck300 FIND v(dout1_252) AT=310.05n

.meas tran vdout1_253ck300 FIND v(dout1_253) AT=310.05n

.meas tran vdout1_254ck300 FIND v(dout1_254) AT=310.05n

.meas tran vdout1_255ck300 FIND v(dout1_255) AT=310.05n

.meas tran vdout1_256ck300 FIND v(dout1_256) AT=310.05n

.meas tran vdout1_0ck310 FIND v(dout1_0) AT=320.05n

.meas tran vdout1_1ck310 FIND v(dout1_1) AT=320.05n

.meas tran vdout1_2ck310 FIND v(dout1_2) AT=320.05n

.meas tran vdout1_3ck310 FIND v(dout1_3) AT=320.05n

.meas tran vdout1_4ck310 FIND v(dout1_4) AT=320.05n

.meas tran vdout1_5ck310 FIND v(dout1_5) AT=320.05n

.meas tran vdout1_6ck310 FIND v(dout1_6) AT=320.05n

.meas tran vdout1_7ck310 FIND v(dout1_7) AT=320.05n

.meas tran vdout1_8ck310 FIND v(dout1_8) AT=320.05n

.meas tran vdout1_9ck310 FIND v(dout1_9) AT=320.05n

.meas tran vdout1_10ck310 FIND v(dout1_10) AT=320.05n

.meas tran vdout1_11ck310 FIND v(dout1_11) AT=320.05n

.meas tran vdout1_12ck310 FIND v(dout1_12) AT=320.05n

.meas tran vdout1_13ck310 FIND v(dout1_13) AT=320.05n

.meas tran vdout1_14ck310 FIND v(dout1_14) AT=320.05n

.meas tran vdout1_15ck310 FIND v(dout1_15) AT=320.05n

.meas tran vdout1_16ck310 FIND v(dout1_16) AT=320.05n

.meas tran vdout1_17ck310 FIND v(dout1_17) AT=320.05n

.meas tran vdout1_18ck310 FIND v(dout1_18) AT=320.05n

.meas tran vdout1_19ck310 FIND v(dout1_19) AT=320.05n

.meas tran vdout1_20ck310 FIND v(dout1_20) AT=320.05n

.meas tran vdout1_21ck310 FIND v(dout1_21) AT=320.05n

.meas tran vdout1_22ck310 FIND v(dout1_22) AT=320.05n

.meas tran vdout1_23ck310 FIND v(dout1_23) AT=320.05n

.meas tran vdout1_24ck310 FIND v(dout1_24) AT=320.05n

.meas tran vdout1_25ck310 FIND v(dout1_25) AT=320.05n

.meas tran vdout1_26ck310 FIND v(dout1_26) AT=320.05n

.meas tran vdout1_27ck310 FIND v(dout1_27) AT=320.05n

.meas tran vdout1_28ck310 FIND v(dout1_28) AT=320.05n

.meas tran vdout1_29ck310 FIND v(dout1_29) AT=320.05n

.meas tran vdout1_30ck310 FIND v(dout1_30) AT=320.05n

.meas tran vdout1_31ck310 FIND v(dout1_31) AT=320.05n

.meas tran vdout1_32ck310 FIND v(dout1_32) AT=320.05n

.meas tran vdout1_33ck310 FIND v(dout1_33) AT=320.05n

.meas tran vdout1_34ck310 FIND v(dout1_34) AT=320.05n

.meas tran vdout1_35ck310 FIND v(dout1_35) AT=320.05n

.meas tran vdout1_36ck310 FIND v(dout1_36) AT=320.05n

.meas tran vdout1_37ck310 FIND v(dout1_37) AT=320.05n

.meas tran vdout1_38ck310 FIND v(dout1_38) AT=320.05n

.meas tran vdout1_39ck310 FIND v(dout1_39) AT=320.05n

.meas tran vdout1_40ck310 FIND v(dout1_40) AT=320.05n

.meas tran vdout1_41ck310 FIND v(dout1_41) AT=320.05n

.meas tran vdout1_42ck310 FIND v(dout1_42) AT=320.05n

.meas tran vdout1_43ck310 FIND v(dout1_43) AT=320.05n

.meas tran vdout1_44ck310 FIND v(dout1_44) AT=320.05n

.meas tran vdout1_45ck310 FIND v(dout1_45) AT=320.05n

.meas tran vdout1_46ck310 FIND v(dout1_46) AT=320.05n

.meas tran vdout1_47ck310 FIND v(dout1_47) AT=320.05n

.meas tran vdout1_48ck310 FIND v(dout1_48) AT=320.05n

.meas tran vdout1_49ck310 FIND v(dout1_49) AT=320.05n

.meas tran vdout1_50ck310 FIND v(dout1_50) AT=320.05n

.meas tran vdout1_51ck310 FIND v(dout1_51) AT=320.05n

.meas tran vdout1_52ck310 FIND v(dout1_52) AT=320.05n

.meas tran vdout1_53ck310 FIND v(dout1_53) AT=320.05n

.meas tran vdout1_54ck310 FIND v(dout1_54) AT=320.05n

.meas tran vdout1_55ck310 FIND v(dout1_55) AT=320.05n

.meas tran vdout1_56ck310 FIND v(dout1_56) AT=320.05n

.meas tran vdout1_57ck310 FIND v(dout1_57) AT=320.05n

.meas tran vdout1_58ck310 FIND v(dout1_58) AT=320.05n

.meas tran vdout1_59ck310 FIND v(dout1_59) AT=320.05n

.meas tran vdout1_60ck310 FIND v(dout1_60) AT=320.05n

.meas tran vdout1_61ck310 FIND v(dout1_61) AT=320.05n

.meas tran vdout1_62ck310 FIND v(dout1_62) AT=320.05n

.meas tran vdout1_63ck310 FIND v(dout1_63) AT=320.05n

.meas tran vdout1_64ck310 FIND v(dout1_64) AT=320.05n

.meas tran vdout1_65ck310 FIND v(dout1_65) AT=320.05n

.meas tran vdout1_66ck310 FIND v(dout1_66) AT=320.05n

.meas tran vdout1_67ck310 FIND v(dout1_67) AT=320.05n

.meas tran vdout1_68ck310 FIND v(dout1_68) AT=320.05n

.meas tran vdout1_69ck310 FIND v(dout1_69) AT=320.05n

.meas tran vdout1_70ck310 FIND v(dout1_70) AT=320.05n

.meas tran vdout1_71ck310 FIND v(dout1_71) AT=320.05n

.meas tran vdout1_72ck310 FIND v(dout1_72) AT=320.05n

.meas tran vdout1_73ck310 FIND v(dout1_73) AT=320.05n

.meas tran vdout1_74ck310 FIND v(dout1_74) AT=320.05n

.meas tran vdout1_75ck310 FIND v(dout1_75) AT=320.05n

.meas tran vdout1_76ck310 FIND v(dout1_76) AT=320.05n

.meas tran vdout1_77ck310 FIND v(dout1_77) AT=320.05n

.meas tran vdout1_78ck310 FIND v(dout1_78) AT=320.05n

.meas tran vdout1_79ck310 FIND v(dout1_79) AT=320.05n

.meas tran vdout1_80ck310 FIND v(dout1_80) AT=320.05n

.meas tran vdout1_81ck310 FIND v(dout1_81) AT=320.05n

.meas tran vdout1_82ck310 FIND v(dout1_82) AT=320.05n

.meas tran vdout1_83ck310 FIND v(dout1_83) AT=320.05n

.meas tran vdout1_84ck310 FIND v(dout1_84) AT=320.05n

.meas tran vdout1_85ck310 FIND v(dout1_85) AT=320.05n

.meas tran vdout1_86ck310 FIND v(dout1_86) AT=320.05n

.meas tran vdout1_87ck310 FIND v(dout1_87) AT=320.05n

.meas tran vdout1_88ck310 FIND v(dout1_88) AT=320.05n

.meas tran vdout1_89ck310 FIND v(dout1_89) AT=320.05n

.meas tran vdout1_90ck310 FIND v(dout1_90) AT=320.05n

.meas tran vdout1_91ck310 FIND v(dout1_91) AT=320.05n

.meas tran vdout1_92ck310 FIND v(dout1_92) AT=320.05n

.meas tran vdout1_93ck310 FIND v(dout1_93) AT=320.05n

.meas tran vdout1_94ck310 FIND v(dout1_94) AT=320.05n

.meas tran vdout1_95ck310 FIND v(dout1_95) AT=320.05n

.meas tran vdout1_96ck310 FIND v(dout1_96) AT=320.05n

.meas tran vdout1_97ck310 FIND v(dout1_97) AT=320.05n

.meas tran vdout1_98ck310 FIND v(dout1_98) AT=320.05n

.meas tran vdout1_99ck310 FIND v(dout1_99) AT=320.05n

.meas tran vdout1_100ck310 FIND v(dout1_100) AT=320.05n

.meas tran vdout1_101ck310 FIND v(dout1_101) AT=320.05n

.meas tran vdout1_102ck310 FIND v(dout1_102) AT=320.05n

.meas tran vdout1_103ck310 FIND v(dout1_103) AT=320.05n

.meas tran vdout1_104ck310 FIND v(dout1_104) AT=320.05n

.meas tran vdout1_105ck310 FIND v(dout1_105) AT=320.05n

.meas tran vdout1_106ck310 FIND v(dout1_106) AT=320.05n

.meas tran vdout1_107ck310 FIND v(dout1_107) AT=320.05n

.meas tran vdout1_108ck310 FIND v(dout1_108) AT=320.05n

.meas tran vdout1_109ck310 FIND v(dout1_109) AT=320.05n

.meas tran vdout1_110ck310 FIND v(dout1_110) AT=320.05n

.meas tran vdout1_111ck310 FIND v(dout1_111) AT=320.05n

.meas tran vdout1_112ck310 FIND v(dout1_112) AT=320.05n

.meas tran vdout1_113ck310 FIND v(dout1_113) AT=320.05n

.meas tran vdout1_114ck310 FIND v(dout1_114) AT=320.05n

.meas tran vdout1_115ck310 FIND v(dout1_115) AT=320.05n

.meas tran vdout1_116ck310 FIND v(dout1_116) AT=320.05n

.meas tran vdout1_117ck310 FIND v(dout1_117) AT=320.05n

.meas tran vdout1_118ck310 FIND v(dout1_118) AT=320.05n

.meas tran vdout1_119ck310 FIND v(dout1_119) AT=320.05n

.meas tran vdout1_120ck310 FIND v(dout1_120) AT=320.05n

.meas tran vdout1_121ck310 FIND v(dout1_121) AT=320.05n

.meas tran vdout1_122ck310 FIND v(dout1_122) AT=320.05n

.meas tran vdout1_123ck310 FIND v(dout1_123) AT=320.05n

.meas tran vdout1_124ck310 FIND v(dout1_124) AT=320.05n

.meas tran vdout1_125ck310 FIND v(dout1_125) AT=320.05n

.meas tran vdout1_126ck310 FIND v(dout1_126) AT=320.05n

.meas tran vdout1_127ck310 FIND v(dout1_127) AT=320.05n

.meas tran vdout1_128ck310 FIND v(dout1_128) AT=320.05n

.meas tran vdout1_129ck310 FIND v(dout1_129) AT=320.05n

.meas tran vdout1_130ck310 FIND v(dout1_130) AT=320.05n

.meas tran vdout1_131ck310 FIND v(dout1_131) AT=320.05n

.meas tran vdout1_132ck310 FIND v(dout1_132) AT=320.05n

.meas tran vdout1_133ck310 FIND v(dout1_133) AT=320.05n

.meas tran vdout1_134ck310 FIND v(dout1_134) AT=320.05n

.meas tran vdout1_135ck310 FIND v(dout1_135) AT=320.05n

.meas tran vdout1_136ck310 FIND v(dout1_136) AT=320.05n

.meas tran vdout1_137ck310 FIND v(dout1_137) AT=320.05n

.meas tran vdout1_138ck310 FIND v(dout1_138) AT=320.05n

.meas tran vdout1_139ck310 FIND v(dout1_139) AT=320.05n

.meas tran vdout1_140ck310 FIND v(dout1_140) AT=320.05n

.meas tran vdout1_141ck310 FIND v(dout1_141) AT=320.05n

.meas tran vdout1_142ck310 FIND v(dout1_142) AT=320.05n

.meas tran vdout1_143ck310 FIND v(dout1_143) AT=320.05n

.meas tran vdout1_144ck310 FIND v(dout1_144) AT=320.05n

.meas tran vdout1_145ck310 FIND v(dout1_145) AT=320.05n

.meas tran vdout1_146ck310 FIND v(dout1_146) AT=320.05n

.meas tran vdout1_147ck310 FIND v(dout1_147) AT=320.05n

.meas tran vdout1_148ck310 FIND v(dout1_148) AT=320.05n

.meas tran vdout1_149ck310 FIND v(dout1_149) AT=320.05n

.meas tran vdout1_150ck310 FIND v(dout1_150) AT=320.05n

.meas tran vdout1_151ck310 FIND v(dout1_151) AT=320.05n

.meas tran vdout1_152ck310 FIND v(dout1_152) AT=320.05n

.meas tran vdout1_153ck310 FIND v(dout1_153) AT=320.05n

.meas tran vdout1_154ck310 FIND v(dout1_154) AT=320.05n

.meas tran vdout1_155ck310 FIND v(dout1_155) AT=320.05n

.meas tran vdout1_156ck310 FIND v(dout1_156) AT=320.05n

.meas tran vdout1_157ck310 FIND v(dout1_157) AT=320.05n

.meas tran vdout1_158ck310 FIND v(dout1_158) AT=320.05n

.meas tran vdout1_159ck310 FIND v(dout1_159) AT=320.05n

.meas tran vdout1_160ck310 FIND v(dout1_160) AT=320.05n

.meas tran vdout1_161ck310 FIND v(dout1_161) AT=320.05n

.meas tran vdout1_162ck310 FIND v(dout1_162) AT=320.05n

.meas tran vdout1_163ck310 FIND v(dout1_163) AT=320.05n

.meas tran vdout1_164ck310 FIND v(dout1_164) AT=320.05n

.meas tran vdout1_165ck310 FIND v(dout1_165) AT=320.05n

.meas tran vdout1_166ck310 FIND v(dout1_166) AT=320.05n

.meas tran vdout1_167ck310 FIND v(dout1_167) AT=320.05n

.meas tran vdout1_168ck310 FIND v(dout1_168) AT=320.05n

.meas tran vdout1_169ck310 FIND v(dout1_169) AT=320.05n

.meas tran vdout1_170ck310 FIND v(dout1_170) AT=320.05n

.meas tran vdout1_171ck310 FIND v(dout1_171) AT=320.05n

.meas tran vdout1_172ck310 FIND v(dout1_172) AT=320.05n

.meas tran vdout1_173ck310 FIND v(dout1_173) AT=320.05n

.meas tran vdout1_174ck310 FIND v(dout1_174) AT=320.05n

.meas tran vdout1_175ck310 FIND v(dout1_175) AT=320.05n

.meas tran vdout1_176ck310 FIND v(dout1_176) AT=320.05n

.meas tran vdout1_177ck310 FIND v(dout1_177) AT=320.05n

.meas tran vdout1_178ck310 FIND v(dout1_178) AT=320.05n

.meas tran vdout1_179ck310 FIND v(dout1_179) AT=320.05n

.meas tran vdout1_180ck310 FIND v(dout1_180) AT=320.05n

.meas tran vdout1_181ck310 FIND v(dout1_181) AT=320.05n

.meas tran vdout1_182ck310 FIND v(dout1_182) AT=320.05n

.meas tran vdout1_183ck310 FIND v(dout1_183) AT=320.05n

.meas tran vdout1_184ck310 FIND v(dout1_184) AT=320.05n

.meas tran vdout1_185ck310 FIND v(dout1_185) AT=320.05n

.meas tran vdout1_186ck310 FIND v(dout1_186) AT=320.05n

.meas tran vdout1_187ck310 FIND v(dout1_187) AT=320.05n

.meas tran vdout1_188ck310 FIND v(dout1_188) AT=320.05n

.meas tran vdout1_189ck310 FIND v(dout1_189) AT=320.05n

.meas tran vdout1_190ck310 FIND v(dout1_190) AT=320.05n

.meas tran vdout1_191ck310 FIND v(dout1_191) AT=320.05n

.meas tran vdout1_192ck310 FIND v(dout1_192) AT=320.05n

.meas tran vdout1_193ck310 FIND v(dout1_193) AT=320.05n

.meas tran vdout1_194ck310 FIND v(dout1_194) AT=320.05n

.meas tran vdout1_195ck310 FIND v(dout1_195) AT=320.05n

.meas tran vdout1_196ck310 FIND v(dout1_196) AT=320.05n

.meas tran vdout1_197ck310 FIND v(dout1_197) AT=320.05n

.meas tran vdout1_198ck310 FIND v(dout1_198) AT=320.05n

.meas tran vdout1_199ck310 FIND v(dout1_199) AT=320.05n

.meas tran vdout1_200ck310 FIND v(dout1_200) AT=320.05n

.meas tran vdout1_201ck310 FIND v(dout1_201) AT=320.05n

.meas tran vdout1_202ck310 FIND v(dout1_202) AT=320.05n

.meas tran vdout1_203ck310 FIND v(dout1_203) AT=320.05n

.meas tran vdout1_204ck310 FIND v(dout1_204) AT=320.05n

.meas tran vdout1_205ck310 FIND v(dout1_205) AT=320.05n

.meas tran vdout1_206ck310 FIND v(dout1_206) AT=320.05n

.meas tran vdout1_207ck310 FIND v(dout1_207) AT=320.05n

.meas tran vdout1_208ck310 FIND v(dout1_208) AT=320.05n

.meas tran vdout1_209ck310 FIND v(dout1_209) AT=320.05n

.meas tran vdout1_210ck310 FIND v(dout1_210) AT=320.05n

.meas tran vdout1_211ck310 FIND v(dout1_211) AT=320.05n

.meas tran vdout1_212ck310 FIND v(dout1_212) AT=320.05n

.meas tran vdout1_213ck310 FIND v(dout1_213) AT=320.05n

.meas tran vdout1_214ck310 FIND v(dout1_214) AT=320.05n

.meas tran vdout1_215ck310 FIND v(dout1_215) AT=320.05n

.meas tran vdout1_216ck310 FIND v(dout1_216) AT=320.05n

.meas tran vdout1_217ck310 FIND v(dout1_217) AT=320.05n

.meas tran vdout1_218ck310 FIND v(dout1_218) AT=320.05n

.meas tran vdout1_219ck310 FIND v(dout1_219) AT=320.05n

.meas tran vdout1_220ck310 FIND v(dout1_220) AT=320.05n

.meas tran vdout1_221ck310 FIND v(dout1_221) AT=320.05n

.meas tran vdout1_222ck310 FIND v(dout1_222) AT=320.05n

.meas tran vdout1_223ck310 FIND v(dout1_223) AT=320.05n

.meas tran vdout1_224ck310 FIND v(dout1_224) AT=320.05n

.meas tran vdout1_225ck310 FIND v(dout1_225) AT=320.05n

.meas tran vdout1_226ck310 FIND v(dout1_226) AT=320.05n

.meas tran vdout1_227ck310 FIND v(dout1_227) AT=320.05n

.meas tran vdout1_228ck310 FIND v(dout1_228) AT=320.05n

.meas tran vdout1_229ck310 FIND v(dout1_229) AT=320.05n

.meas tran vdout1_230ck310 FIND v(dout1_230) AT=320.05n

.meas tran vdout1_231ck310 FIND v(dout1_231) AT=320.05n

.meas tran vdout1_232ck310 FIND v(dout1_232) AT=320.05n

.meas tran vdout1_233ck310 FIND v(dout1_233) AT=320.05n

.meas tran vdout1_234ck310 FIND v(dout1_234) AT=320.05n

.meas tran vdout1_235ck310 FIND v(dout1_235) AT=320.05n

.meas tran vdout1_236ck310 FIND v(dout1_236) AT=320.05n

.meas tran vdout1_237ck310 FIND v(dout1_237) AT=320.05n

.meas tran vdout1_238ck310 FIND v(dout1_238) AT=320.05n

.meas tran vdout1_239ck310 FIND v(dout1_239) AT=320.05n

.meas tran vdout1_240ck310 FIND v(dout1_240) AT=320.05n

.meas tran vdout1_241ck310 FIND v(dout1_241) AT=320.05n

.meas tran vdout1_242ck310 FIND v(dout1_242) AT=320.05n

.meas tran vdout1_243ck310 FIND v(dout1_243) AT=320.05n

.meas tran vdout1_244ck310 FIND v(dout1_244) AT=320.05n

.meas tran vdout1_245ck310 FIND v(dout1_245) AT=320.05n

.meas tran vdout1_246ck310 FIND v(dout1_246) AT=320.05n

.meas tran vdout1_247ck310 FIND v(dout1_247) AT=320.05n

.meas tran vdout1_248ck310 FIND v(dout1_248) AT=320.05n

.meas tran vdout1_249ck310 FIND v(dout1_249) AT=320.05n

.meas tran vdout1_250ck310 FIND v(dout1_250) AT=320.05n

.meas tran vdout1_251ck310 FIND v(dout1_251) AT=320.05n

.meas tran vdout1_252ck310 FIND v(dout1_252) AT=320.05n

.meas tran vdout1_253ck310 FIND v(dout1_253) AT=320.05n

.meas tran vdout1_254ck310 FIND v(dout1_254) AT=320.05n

.meas tran vdout1_255ck310 FIND v(dout1_255) AT=320.05n

.meas tran vdout1_256ck310 FIND v(dout1_256) AT=320.05n

.meas tran vdout1_0ck320 FIND v(dout1_0) AT=330.05n

.meas tran vdout1_1ck320 FIND v(dout1_1) AT=330.05n

.meas tran vdout1_2ck320 FIND v(dout1_2) AT=330.05n

.meas tran vdout1_3ck320 FIND v(dout1_3) AT=330.05n

.meas tran vdout1_4ck320 FIND v(dout1_4) AT=330.05n

.meas tran vdout1_5ck320 FIND v(dout1_5) AT=330.05n

.meas tran vdout1_6ck320 FIND v(dout1_6) AT=330.05n

.meas tran vdout1_7ck320 FIND v(dout1_7) AT=330.05n

.meas tran vdout1_8ck320 FIND v(dout1_8) AT=330.05n

.meas tran vdout1_9ck320 FIND v(dout1_9) AT=330.05n

.meas tran vdout1_10ck320 FIND v(dout1_10) AT=330.05n

.meas tran vdout1_11ck320 FIND v(dout1_11) AT=330.05n

.meas tran vdout1_12ck320 FIND v(dout1_12) AT=330.05n

.meas tran vdout1_13ck320 FIND v(dout1_13) AT=330.05n

.meas tran vdout1_14ck320 FIND v(dout1_14) AT=330.05n

.meas tran vdout1_15ck320 FIND v(dout1_15) AT=330.05n

.meas tran vdout1_16ck320 FIND v(dout1_16) AT=330.05n

.meas tran vdout1_17ck320 FIND v(dout1_17) AT=330.05n

.meas tran vdout1_18ck320 FIND v(dout1_18) AT=330.05n

.meas tran vdout1_19ck320 FIND v(dout1_19) AT=330.05n

.meas tran vdout1_20ck320 FIND v(dout1_20) AT=330.05n

.meas tran vdout1_21ck320 FIND v(dout1_21) AT=330.05n

.meas tran vdout1_22ck320 FIND v(dout1_22) AT=330.05n

.meas tran vdout1_23ck320 FIND v(dout1_23) AT=330.05n

.meas tran vdout1_24ck320 FIND v(dout1_24) AT=330.05n

.meas tran vdout1_25ck320 FIND v(dout1_25) AT=330.05n

.meas tran vdout1_26ck320 FIND v(dout1_26) AT=330.05n

.meas tran vdout1_27ck320 FIND v(dout1_27) AT=330.05n

.meas tran vdout1_28ck320 FIND v(dout1_28) AT=330.05n

.meas tran vdout1_29ck320 FIND v(dout1_29) AT=330.05n

.meas tran vdout1_30ck320 FIND v(dout1_30) AT=330.05n

.meas tran vdout1_31ck320 FIND v(dout1_31) AT=330.05n

.meas tran vdout1_32ck320 FIND v(dout1_32) AT=330.05n

.meas tran vdout1_33ck320 FIND v(dout1_33) AT=330.05n

.meas tran vdout1_34ck320 FIND v(dout1_34) AT=330.05n

.meas tran vdout1_35ck320 FIND v(dout1_35) AT=330.05n

.meas tran vdout1_36ck320 FIND v(dout1_36) AT=330.05n

.meas tran vdout1_37ck320 FIND v(dout1_37) AT=330.05n

.meas tran vdout1_38ck320 FIND v(dout1_38) AT=330.05n

.meas tran vdout1_39ck320 FIND v(dout1_39) AT=330.05n

.meas tran vdout1_40ck320 FIND v(dout1_40) AT=330.05n

.meas tran vdout1_41ck320 FIND v(dout1_41) AT=330.05n

.meas tran vdout1_42ck320 FIND v(dout1_42) AT=330.05n

.meas tran vdout1_43ck320 FIND v(dout1_43) AT=330.05n

.meas tran vdout1_44ck320 FIND v(dout1_44) AT=330.05n

.meas tran vdout1_45ck320 FIND v(dout1_45) AT=330.05n

.meas tran vdout1_46ck320 FIND v(dout1_46) AT=330.05n

.meas tran vdout1_47ck320 FIND v(dout1_47) AT=330.05n

.meas tran vdout1_48ck320 FIND v(dout1_48) AT=330.05n

.meas tran vdout1_49ck320 FIND v(dout1_49) AT=330.05n

.meas tran vdout1_50ck320 FIND v(dout1_50) AT=330.05n

.meas tran vdout1_51ck320 FIND v(dout1_51) AT=330.05n

.meas tran vdout1_52ck320 FIND v(dout1_52) AT=330.05n

.meas tran vdout1_53ck320 FIND v(dout1_53) AT=330.05n

.meas tran vdout1_54ck320 FIND v(dout1_54) AT=330.05n

.meas tran vdout1_55ck320 FIND v(dout1_55) AT=330.05n

.meas tran vdout1_56ck320 FIND v(dout1_56) AT=330.05n

.meas tran vdout1_57ck320 FIND v(dout1_57) AT=330.05n

.meas tran vdout1_58ck320 FIND v(dout1_58) AT=330.05n

.meas tran vdout1_59ck320 FIND v(dout1_59) AT=330.05n

.meas tran vdout1_60ck320 FIND v(dout1_60) AT=330.05n

.meas tran vdout1_61ck320 FIND v(dout1_61) AT=330.05n

.meas tran vdout1_62ck320 FIND v(dout1_62) AT=330.05n

.meas tran vdout1_63ck320 FIND v(dout1_63) AT=330.05n

.meas tran vdout1_64ck320 FIND v(dout1_64) AT=330.05n

.meas tran vdout1_65ck320 FIND v(dout1_65) AT=330.05n

.meas tran vdout1_66ck320 FIND v(dout1_66) AT=330.05n

.meas tran vdout1_67ck320 FIND v(dout1_67) AT=330.05n

.meas tran vdout1_68ck320 FIND v(dout1_68) AT=330.05n

.meas tran vdout1_69ck320 FIND v(dout1_69) AT=330.05n

.meas tran vdout1_70ck320 FIND v(dout1_70) AT=330.05n

.meas tran vdout1_71ck320 FIND v(dout1_71) AT=330.05n

.meas tran vdout1_72ck320 FIND v(dout1_72) AT=330.05n

.meas tran vdout1_73ck320 FIND v(dout1_73) AT=330.05n

.meas tran vdout1_74ck320 FIND v(dout1_74) AT=330.05n

.meas tran vdout1_75ck320 FIND v(dout1_75) AT=330.05n

.meas tran vdout1_76ck320 FIND v(dout1_76) AT=330.05n

.meas tran vdout1_77ck320 FIND v(dout1_77) AT=330.05n

.meas tran vdout1_78ck320 FIND v(dout1_78) AT=330.05n

.meas tran vdout1_79ck320 FIND v(dout1_79) AT=330.05n

.meas tran vdout1_80ck320 FIND v(dout1_80) AT=330.05n

.meas tran vdout1_81ck320 FIND v(dout1_81) AT=330.05n

.meas tran vdout1_82ck320 FIND v(dout1_82) AT=330.05n

.meas tran vdout1_83ck320 FIND v(dout1_83) AT=330.05n

.meas tran vdout1_84ck320 FIND v(dout1_84) AT=330.05n

.meas tran vdout1_85ck320 FIND v(dout1_85) AT=330.05n

.meas tran vdout1_86ck320 FIND v(dout1_86) AT=330.05n

.meas tran vdout1_87ck320 FIND v(dout1_87) AT=330.05n

.meas tran vdout1_88ck320 FIND v(dout1_88) AT=330.05n

.meas tran vdout1_89ck320 FIND v(dout1_89) AT=330.05n

.meas tran vdout1_90ck320 FIND v(dout1_90) AT=330.05n

.meas tran vdout1_91ck320 FIND v(dout1_91) AT=330.05n

.meas tran vdout1_92ck320 FIND v(dout1_92) AT=330.05n

.meas tran vdout1_93ck320 FIND v(dout1_93) AT=330.05n

.meas tran vdout1_94ck320 FIND v(dout1_94) AT=330.05n

.meas tran vdout1_95ck320 FIND v(dout1_95) AT=330.05n

.meas tran vdout1_96ck320 FIND v(dout1_96) AT=330.05n

.meas tran vdout1_97ck320 FIND v(dout1_97) AT=330.05n

.meas tran vdout1_98ck320 FIND v(dout1_98) AT=330.05n

.meas tran vdout1_99ck320 FIND v(dout1_99) AT=330.05n

.meas tran vdout1_100ck320 FIND v(dout1_100) AT=330.05n

.meas tran vdout1_101ck320 FIND v(dout1_101) AT=330.05n

.meas tran vdout1_102ck320 FIND v(dout1_102) AT=330.05n

.meas tran vdout1_103ck320 FIND v(dout1_103) AT=330.05n

.meas tran vdout1_104ck320 FIND v(dout1_104) AT=330.05n

.meas tran vdout1_105ck320 FIND v(dout1_105) AT=330.05n

.meas tran vdout1_106ck320 FIND v(dout1_106) AT=330.05n

.meas tran vdout1_107ck320 FIND v(dout1_107) AT=330.05n

.meas tran vdout1_108ck320 FIND v(dout1_108) AT=330.05n

.meas tran vdout1_109ck320 FIND v(dout1_109) AT=330.05n

.meas tran vdout1_110ck320 FIND v(dout1_110) AT=330.05n

.meas tran vdout1_111ck320 FIND v(dout1_111) AT=330.05n

.meas tran vdout1_112ck320 FIND v(dout1_112) AT=330.05n

.meas tran vdout1_113ck320 FIND v(dout1_113) AT=330.05n

.meas tran vdout1_114ck320 FIND v(dout1_114) AT=330.05n

.meas tran vdout1_115ck320 FIND v(dout1_115) AT=330.05n

.meas tran vdout1_116ck320 FIND v(dout1_116) AT=330.05n

.meas tran vdout1_117ck320 FIND v(dout1_117) AT=330.05n

.meas tran vdout1_118ck320 FIND v(dout1_118) AT=330.05n

.meas tran vdout1_119ck320 FIND v(dout1_119) AT=330.05n

.meas tran vdout1_120ck320 FIND v(dout1_120) AT=330.05n

.meas tran vdout1_121ck320 FIND v(dout1_121) AT=330.05n

.meas tran vdout1_122ck320 FIND v(dout1_122) AT=330.05n

.meas tran vdout1_123ck320 FIND v(dout1_123) AT=330.05n

.meas tran vdout1_124ck320 FIND v(dout1_124) AT=330.05n

.meas tran vdout1_125ck320 FIND v(dout1_125) AT=330.05n

.meas tran vdout1_126ck320 FIND v(dout1_126) AT=330.05n

.meas tran vdout1_127ck320 FIND v(dout1_127) AT=330.05n

.meas tran vdout1_128ck320 FIND v(dout1_128) AT=330.05n

.meas tran vdout1_129ck320 FIND v(dout1_129) AT=330.05n

.meas tran vdout1_130ck320 FIND v(dout1_130) AT=330.05n

.meas tran vdout1_131ck320 FIND v(dout1_131) AT=330.05n

.meas tran vdout1_132ck320 FIND v(dout1_132) AT=330.05n

.meas tran vdout1_133ck320 FIND v(dout1_133) AT=330.05n

.meas tran vdout1_134ck320 FIND v(dout1_134) AT=330.05n

.meas tran vdout1_135ck320 FIND v(dout1_135) AT=330.05n

.meas tran vdout1_136ck320 FIND v(dout1_136) AT=330.05n

.meas tran vdout1_137ck320 FIND v(dout1_137) AT=330.05n

.meas tran vdout1_138ck320 FIND v(dout1_138) AT=330.05n

.meas tran vdout1_139ck320 FIND v(dout1_139) AT=330.05n

.meas tran vdout1_140ck320 FIND v(dout1_140) AT=330.05n

.meas tran vdout1_141ck320 FIND v(dout1_141) AT=330.05n

.meas tran vdout1_142ck320 FIND v(dout1_142) AT=330.05n

.meas tran vdout1_143ck320 FIND v(dout1_143) AT=330.05n

.meas tran vdout1_144ck320 FIND v(dout1_144) AT=330.05n

.meas tran vdout1_145ck320 FIND v(dout1_145) AT=330.05n

.meas tran vdout1_146ck320 FIND v(dout1_146) AT=330.05n

.meas tran vdout1_147ck320 FIND v(dout1_147) AT=330.05n

.meas tran vdout1_148ck320 FIND v(dout1_148) AT=330.05n

.meas tran vdout1_149ck320 FIND v(dout1_149) AT=330.05n

.meas tran vdout1_150ck320 FIND v(dout1_150) AT=330.05n

.meas tran vdout1_151ck320 FIND v(dout1_151) AT=330.05n

.meas tran vdout1_152ck320 FIND v(dout1_152) AT=330.05n

.meas tran vdout1_153ck320 FIND v(dout1_153) AT=330.05n

.meas tran vdout1_154ck320 FIND v(dout1_154) AT=330.05n

.meas tran vdout1_155ck320 FIND v(dout1_155) AT=330.05n

.meas tran vdout1_156ck320 FIND v(dout1_156) AT=330.05n

.meas tran vdout1_157ck320 FIND v(dout1_157) AT=330.05n

.meas tran vdout1_158ck320 FIND v(dout1_158) AT=330.05n

.meas tran vdout1_159ck320 FIND v(dout1_159) AT=330.05n

.meas tran vdout1_160ck320 FIND v(dout1_160) AT=330.05n

.meas tran vdout1_161ck320 FIND v(dout1_161) AT=330.05n

.meas tran vdout1_162ck320 FIND v(dout1_162) AT=330.05n

.meas tran vdout1_163ck320 FIND v(dout1_163) AT=330.05n

.meas tran vdout1_164ck320 FIND v(dout1_164) AT=330.05n

.meas tran vdout1_165ck320 FIND v(dout1_165) AT=330.05n

.meas tran vdout1_166ck320 FIND v(dout1_166) AT=330.05n

.meas tran vdout1_167ck320 FIND v(dout1_167) AT=330.05n

.meas tran vdout1_168ck320 FIND v(dout1_168) AT=330.05n

.meas tran vdout1_169ck320 FIND v(dout1_169) AT=330.05n

.meas tran vdout1_170ck320 FIND v(dout1_170) AT=330.05n

.meas tran vdout1_171ck320 FIND v(dout1_171) AT=330.05n

.meas tran vdout1_172ck320 FIND v(dout1_172) AT=330.05n

.meas tran vdout1_173ck320 FIND v(dout1_173) AT=330.05n

.meas tran vdout1_174ck320 FIND v(dout1_174) AT=330.05n

.meas tran vdout1_175ck320 FIND v(dout1_175) AT=330.05n

.meas tran vdout1_176ck320 FIND v(dout1_176) AT=330.05n

.meas tran vdout1_177ck320 FIND v(dout1_177) AT=330.05n

.meas tran vdout1_178ck320 FIND v(dout1_178) AT=330.05n

.meas tran vdout1_179ck320 FIND v(dout1_179) AT=330.05n

.meas tran vdout1_180ck320 FIND v(dout1_180) AT=330.05n

.meas tran vdout1_181ck320 FIND v(dout1_181) AT=330.05n

.meas tran vdout1_182ck320 FIND v(dout1_182) AT=330.05n

.meas tran vdout1_183ck320 FIND v(dout1_183) AT=330.05n

.meas tran vdout1_184ck320 FIND v(dout1_184) AT=330.05n

.meas tran vdout1_185ck320 FIND v(dout1_185) AT=330.05n

.meas tran vdout1_186ck320 FIND v(dout1_186) AT=330.05n

.meas tran vdout1_187ck320 FIND v(dout1_187) AT=330.05n

.meas tran vdout1_188ck320 FIND v(dout1_188) AT=330.05n

.meas tran vdout1_189ck320 FIND v(dout1_189) AT=330.05n

.meas tran vdout1_190ck320 FIND v(dout1_190) AT=330.05n

.meas tran vdout1_191ck320 FIND v(dout1_191) AT=330.05n

.meas tran vdout1_192ck320 FIND v(dout1_192) AT=330.05n

.meas tran vdout1_193ck320 FIND v(dout1_193) AT=330.05n

.meas tran vdout1_194ck320 FIND v(dout1_194) AT=330.05n

.meas tran vdout1_195ck320 FIND v(dout1_195) AT=330.05n

.meas tran vdout1_196ck320 FIND v(dout1_196) AT=330.05n

.meas tran vdout1_197ck320 FIND v(dout1_197) AT=330.05n

.meas tran vdout1_198ck320 FIND v(dout1_198) AT=330.05n

.meas tran vdout1_199ck320 FIND v(dout1_199) AT=330.05n

.meas tran vdout1_200ck320 FIND v(dout1_200) AT=330.05n

.meas tran vdout1_201ck320 FIND v(dout1_201) AT=330.05n

.meas tran vdout1_202ck320 FIND v(dout1_202) AT=330.05n

.meas tran vdout1_203ck320 FIND v(dout1_203) AT=330.05n

.meas tran vdout1_204ck320 FIND v(dout1_204) AT=330.05n

.meas tran vdout1_205ck320 FIND v(dout1_205) AT=330.05n

.meas tran vdout1_206ck320 FIND v(dout1_206) AT=330.05n

.meas tran vdout1_207ck320 FIND v(dout1_207) AT=330.05n

.meas tran vdout1_208ck320 FIND v(dout1_208) AT=330.05n

.meas tran vdout1_209ck320 FIND v(dout1_209) AT=330.05n

.meas tran vdout1_210ck320 FIND v(dout1_210) AT=330.05n

.meas tran vdout1_211ck320 FIND v(dout1_211) AT=330.05n

.meas tran vdout1_212ck320 FIND v(dout1_212) AT=330.05n

.meas tran vdout1_213ck320 FIND v(dout1_213) AT=330.05n

.meas tran vdout1_214ck320 FIND v(dout1_214) AT=330.05n

.meas tran vdout1_215ck320 FIND v(dout1_215) AT=330.05n

.meas tran vdout1_216ck320 FIND v(dout1_216) AT=330.05n

.meas tran vdout1_217ck320 FIND v(dout1_217) AT=330.05n

.meas tran vdout1_218ck320 FIND v(dout1_218) AT=330.05n

.meas tran vdout1_219ck320 FIND v(dout1_219) AT=330.05n

.meas tran vdout1_220ck320 FIND v(dout1_220) AT=330.05n

.meas tran vdout1_221ck320 FIND v(dout1_221) AT=330.05n

.meas tran vdout1_222ck320 FIND v(dout1_222) AT=330.05n

.meas tran vdout1_223ck320 FIND v(dout1_223) AT=330.05n

.meas tran vdout1_224ck320 FIND v(dout1_224) AT=330.05n

.meas tran vdout1_225ck320 FIND v(dout1_225) AT=330.05n

.meas tran vdout1_226ck320 FIND v(dout1_226) AT=330.05n

.meas tran vdout1_227ck320 FIND v(dout1_227) AT=330.05n

.meas tran vdout1_228ck320 FIND v(dout1_228) AT=330.05n

.meas tran vdout1_229ck320 FIND v(dout1_229) AT=330.05n

.meas tran vdout1_230ck320 FIND v(dout1_230) AT=330.05n

.meas tran vdout1_231ck320 FIND v(dout1_231) AT=330.05n

.meas tran vdout1_232ck320 FIND v(dout1_232) AT=330.05n

.meas tran vdout1_233ck320 FIND v(dout1_233) AT=330.05n

.meas tran vdout1_234ck320 FIND v(dout1_234) AT=330.05n

.meas tran vdout1_235ck320 FIND v(dout1_235) AT=330.05n

.meas tran vdout1_236ck320 FIND v(dout1_236) AT=330.05n

.meas tran vdout1_237ck320 FIND v(dout1_237) AT=330.05n

.meas tran vdout1_238ck320 FIND v(dout1_238) AT=330.05n

.meas tran vdout1_239ck320 FIND v(dout1_239) AT=330.05n

.meas tran vdout1_240ck320 FIND v(dout1_240) AT=330.05n

.meas tran vdout1_241ck320 FIND v(dout1_241) AT=330.05n

.meas tran vdout1_242ck320 FIND v(dout1_242) AT=330.05n

.meas tran vdout1_243ck320 FIND v(dout1_243) AT=330.05n

.meas tran vdout1_244ck320 FIND v(dout1_244) AT=330.05n

.meas tran vdout1_245ck320 FIND v(dout1_245) AT=330.05n

.meas tran vdout1_246ck320 FIND v(dout1_246) AT=330.05n

.meas tran vdout1_247ck320 FIND v(dout1_247) AT=330.05n

.meas tran vdout1_248ck320 FIND v(dout1_248) AT=330.05n

.meas tran vdout1_249ck320 FIND v(dout1_249) AT=330.05n

.meas tran vdout1_250ck320 FIND v(dout1_250) AT=330.05n

.meas tran vdout1_251ck320 FIND v(dout1_251) AT=330.05n

.meas tran vdout1_252ck320 FIND v(dout1_252) AT=330.05n

.meas tran vdout1_253ck320 FIND v(dout1_253) AT=330.05n

.meas tran vdout1_254ck320 FIND v(dout1_254) AT=330.05n

.meas tran vdout1_255ck320 FIND v(dout1_255) AT=330.05n

.meas tran vdout1_256ck320 FIND v(dout1_256) AT=330.05n

.meas tran vdout1_0ck410 FIND v(dout1_0) AT=420.05n

.meas tran vdout1_1ck410 FIND v(dout1_1) AT=420.05n

.meas tran vdout1_2ck410 FIND v(dout1_2) AT=420.05n

.meas tran vdout1_3ck410 FIND v(dout1_3) AT=420.05n

.meas tran vdout1_4ck410 FIND v(dout1_4) AT=420.05n

.meas tran vdout1_5ck410 FIND v(dout1_5) AT=420.05n

.meas tran vdout1_6ck410 FIND v(dout1_6) AT=420.05n

.meas tran vdout1_7ck410 FIND v(dout1_7) AT=420.05n

.meas tran vdout1_8ck410 FIND v(dout1_8) AT=420.05n

.meas tran vdout1_9ck410 FIND v(dout1_9) AT=420.05n

.meas tran vdout1_10ck410 FIND v(dout1_10) AT=420.05n

.meas tran vdout1_11ck410 FIND v(dout1_11) AT=420.05n

.meas tran vdout1_12ck410 FIND v(dout1_12) AT=420.05n

.meas tran vdout1_13ck410 FIND v(dout1_13) AT=420.05n

.meas tran vdout1_14ck410 FIND v(dout1_14) AT=420.05n

.meas tran vdout1_15ck410 FIND v(dout1_15) AT=420.05n

.meas tran vdout1_16ck410 FIND v(dout1_16) AT=420.05n

.meas tran vdout1_17ck410 FIND v(dout1_17) AT=420.05n

.meas tran vdout1_18ck410 FIND v(dout1_18) AT=420.05n

.meas tran vdout1_19ck410 FIND v(dout1_19) AT=420.05n

.meas tran vdout1_20ck410 FIND v(dout1_20) AT=420.05n

.meas tran vdout1_21ck410 FIND v(dout1_21) AT=420.05n

.meas tran vdout1_22ck410 FIND v(dout1_22) AT=420.05n

.meas tran vdout1_23ck410 FIND v(dout1_23) AT=420.05n

.meas tran vdout1_24ck410 FIND v(dout1_24) AT=420.05n

.meas tran vdout1_25ck410 FIND v(dout1_25) AT=420.05n

.meas tran vdout1_26ck410 FIND v(dout1_26) AT=420.05n

.meas tran vdout1_27ck410 FIND v(dout1_27) AT=420.05n

.meas tran vdout1_28ck410 FIND v(dout1_28) AT=420.05n

.meas tran vdout1_29ck410 FIND v(dout1_29) AT=420.05n

.meas tran vdout1_30ck410 FIND v(dout1_30) AT=420.05n

.meas tran vdout1_31ck410 FIND v(dout1_31) AT=420.05n

.meas tran vdout1_32ck410 FIND v(dout1_32) AT=420.05n

.meas tran vdout1_33ck410 FIND v(dout1_33) AT=420.05n

.meas tran vdout1_34ck410 FIND v(dout1_34) AT=420.05n

.meas tran vdout1_35ck410 FIND v(dout1_35) AT=420.05n

.meas tran vdout1_36ck410 FIND v(dout1_36) AT=420.05n

.meas tran vdout1_37ck410 FIND v(dout1_37) AT=420.05n

.meas tran vdout1_38ck410 FIND v(dout1_38) AT=420.05n

.meas tran vdout1_39ck410 FIND v(dout1_39) AT=420.05n

.meas tran vdout1_40ck410 FIND v(dout1_40) AT=420.05n

.meas tran vdout1_41ck410 FIND v(dout1_41) AT=420.05n

.meas tran vdout1_42ck410 FIND v(dout1_42) AT=420.05n

.meas tran vdout1_43ck410 FIND v(dout1_43) AT=420.05n

.meas tran vdout1_44ck410 FIND v(dout1_44) AT=420.05n

.meas tran vdout1_45ck410 FIND v(dout1_45) AT=420.05n

.meas tran vdout1_46ck410 FIND v(dout1_46) AT=420.05n

.meas tran vdout1_47ck410 FIND v(dout1_47) AT=420.05n

.meas tran vdout1_48ck410 FIND v(dout1_48) AT=420.05n

.meas tran vdout1_49ck410 FIND v(dout1_49) AT=420.05n

.meas tran vdout1_50ck410 FIND v(dout1_50) AT=420.05n

.meas tran vdout1_51ck410 FIND v(dout1_51) AT=420.05n

.meas tran vdout1_52ck410 FIND v(dout1_52) AT=420.05n

.meas tran vdout1_53ck410 FIND v(dout1_53) AT=420.05n

.meas tran vdout1_54ck410 FIND v(dout1_54) AT=420.05n

.meas tran vdout1_55ck410 FIND v(dout1_55) AT=420.05n

.meas tran vdout1_56ck410 FIND v(dout1_56) AT=420.05n

.meas tran vdout1_57ck410 FIND v(dout1_57) AT=420.05n

.meas tran vdout1_58ck410 FIND v(dout1_58) AT=420.05n

.meas tran vdout1_59ck410 FIND v(dout1_59) AT=420.05n

.meas tran vdout1_60ck410 FIND v(dout1_60) AT=420.05n

.meas tran vdout1_61ck410 FIND v(dout1_61) AT=420.05n

.meas tran vdout1_62ck410 FIND v(dout1_62) AT=420.05n

.meas tran vdout1_63ck410 FIND v(dout1_63) AT=420.05n

.meas tran vdout1_64ck410 FIND v(dout1_64) AT=420.05n

.meas tran vdout1_65ck410 FIND v(dout1_65) AT=420.05n

.meas tran vdout1_66ck410 FIND v(dout1_66) AT=420.05n

.meas tran vdout1_67ck410 FIND v(dout1_67) AT=420.05n

.meas tran vdout1_68ck410 FIND v(dout1_68) AT=420.05n

.meas tran vdout1_69ck410 FIND v(dout1_69) AT=420.05n

.meas tran vdout1_70ck410 FIND v(dout1_70) AT=420.05n

.meas tran vdout1_71ck410 FIND v(dout1_71) AT=420.05n

.meas tran vdout1_72ck410 FIND v(dout1_72) AT=420.05n

.meas tran vdout1_73ck410 FIND v(dout1_73) AT=420.05n

.meas tran vdout1_74ck410 FIND v(dout1_74) AT=420.05n

.meas tran vdout1_75ck410 FIND v(dout1_75) AT=420.05n

.meas tran vdout1_76ck410 FIND v(dout1_76) AT=420.05n

.meas tran vdout1_77ck410 FIND v(dout1_77) AT=420.05n

.meas tran vdout1_78ck410 FIND v(dout1_78) AT=420.05n

.meas tran vdout1_79ck410 FIND v(dout1_79) AT=420.05n

.meas tran vdout1_80ck410 FIND v(dout1_80) AT=420.05n

.meas tran vdout1_81ck410 FIND v(dout1_81) AT=420.05n

.meas tran vdout1_82ck410 FIND v(dout1_82) AT=420.05n

.meas tran vdout1_83ck410 FIND v(dout1_83) AT=420.05n

.meas tran vdout1_84ck410 FIND v(dout1_84) AT=420.05n

.meas tran vdout1_85ck410 FIND v(dout1_85) AT=420.05n

.meas tran vdout1_86ck410 FIND v(dout1_86) AT=420.05n

.meas tran vdout1_87ck410 FIND v(dout1_87) AT=420.05n

.meas tran vdout1_88ck410 FIND v(dout1_88) AT=420.05n

.meas tran vdout1_89ck410 FIND v(dout1_89) AT=420.05n

.meas tran vdout1_90ck410 FIND v(dout1_90) AT=420.05n

.meas tran vdout1_91ck410 FIND v(dout1_91) AT=420.05n

.meas tran vdout1_92ck410 FIND v(dout1_92) AT=420.05n

.meas tran vdout1_93ck410 FIND v(dout1_93) AT=420.05n

.meas tran vdout1_94ck410 FIND v(dout1_94) AT=420.05n

.meas tran vdout1_95ck410 FIND v(dout1_95) AT=420.05n

.meas tran vdout1_96ck410 FIND v(dout1_96) AT=420.05n

.meas tran vdout1_97ck410 FIND v(dout1_97) AT=420.05n

.meas tran vdout1_98ck410 FIND v(dout1_98) AT=420.05n

.meas tran vdout1_99ck410 FIND v(dout1_99) AT=420.05n

.meas tran vdout1_100ck410 FIND v(dout1_100) AT=420.05n

.meas tran vdout1_101ck410 FIND v(dout1_101) AT=420.05n

.meas tran vdout1_102ck410 FIND v(dout1_102) AT=420.05n

.meas tran vdout1_103ck410 FIND v(dout1_103) AT=420.05n

.meas tran vdout1_104ck410 FIND v(dout1_104) AT=420.05n

.meas tran vdout1_105ck410 FIND v(dout1_105) AT=420.05n

.meas tran vdout1_106ck410 FIND v(dout1_106) AT=420.05n

.meas tran vdout1_107ck410 FIND v(dout1_107) AT=420.05n

.meas tran vdout1_108ck410 FIND v(dout1_108) AT=420.05n

.meas tran vdout1_109ck410 FIND v(dout1_109) AT=420.05n

.meas tran vdout1_110ck410 FIND v(dout1_110) AT=420.05n

.meas tran vdout1_111ck410 FIND v(dout1_111) AT=420.05n

.meas tran vdout1_112ck410 FIND v(dout1_112) AT=420.05n

.meas tran vdout1_113ck410 FIND v(dout1_113) AT=420.05n

.meas tran vdout1_114ck410 FIND v(dout1_114) AT=420.05n

.meas tran vdout1_115ck410 FIND v(dout1_115) AT=420.05n

.meas tran vdout1_116ck410 FIND v(dout1_116) AT=420.05n

.meas tran vdout1_117ck410 FIND v(dout1_117) AT=420.05n

.meas tran vdout1_118ck410 FIND v(dout1_118) AT=420.05n

.meas tran vdout1_119ck410 FIND v(dout1_119) AT=420.05n

.meas tran vdout1_120ck410 FIND v(dout1_120) AT=420.05n

.meas tran vdout1_121ck410 FIND v(dout1_121) AT=420.05n

.meas tran vdout1_122ck410 FIND v(dout1_122) AT=420.05n

.meas tran vdout1_123ck410 FIND v(dout1_123) AT=420.05n

.meas tran vdout1_124ck410 FIND v(dout1_124) AT=420.05n

.meas tran vdout1_125ck410 FIND v(dout1_125) AT=420.05n

.meas tran vdout1_126ck410 FIND v(dout1_126) AT=420.05n

.meas tran vdout1_127ck410 FIND v(dout1_127) AT=420.05n

.meas tran vdout1_128ck410 FIND v(dout1_128) AT=420.05n

.meas tran vdout1_129ck410 FIND v(dout1_129) AT=420.05n

.meas tran vdout1_130ck410 FIND v(dout1_130) AT=420.05n

.meas tran vdout1_131ck410 FIND v(dout1_131) AT=420.05n

.meas tran vdout1_132ck410 FIND v(dout1_132) AT=420.05n

.meas tran vdout1_133ck410 FIND v(dout1_133) AT=420.05n

.meas tran vdout1_134ck410 FIND v(dout1_134) AT=420.05n

.meas tran vdout1_135ck410 FIND v(dout1_135) AT=420.05n

.meas tran vdout1_136ck410 FIND v(dout1_136) AT=420.05n

.meas tran vdout1_137ck410 FIND v(dout1_137) AT=420.05n

.meas tran vdout1_138ck410 FIND v(dout1_138) AT=420.05n

.meas tran vdout1_139ck410 FIND v(dout1_139) AT=420.05n

.meas tran vdout1_140ck410 FIND v(dout1_140) AT=420.05n

.meas tran vdout1_141ck410 FIND v(dout1_141) AT=420.05n

.meas tran vdout1_142ck410 FIND v(dout1_142) AT=420.05n

.meas tran vdout1_143ck410 FIND v(dout1_143) AT=420.05n

.meas tran vdout1_144ck410 FIND v(dout1_144) AT=420.05n

.meas tran vdout1_145ck410 FIND v(dout1_145) AT=420.05n

.meas tran vdout1_146ck410 FIND v(dout1_146) AT=420.05n

.meas tran vdout1_147ck410 FIND v(dout1_147) AT=420.05n

.meas tran vdout1_148ck410 FIND v(dout1_148) AT=420.05n

.meas tran vdout1_149ck410 FIND v(dout1_149) AT=420.05n

.meas tran vdout1_150ck410 FIND v(dout1_150) AT=420.05n

.meas tran vdout1_151ck410 FIND v(dout1_151) AT=420.05n

.meas tran vdout1_152ck410 FIND v(dout1_152) AT=420.05n

.meas tran vdout1_153ck410 FIND v(dout1_153) AT=420.05n

.meas tran vdout1_154ck410 FIND v(dout1_154) AT=420.05n

.meas tran vdout1_155ck410 FIND v(dout1_155) AT=420.05n

.meas tran vdout1_156ck410 FIND v(dout1_156) AT=420.05n

.meas tran vdout1_157ck410 FIND v(dout1_157) AT=420.05n

.meas tran vdout1_158ck410 FIND v(dout1_158) AT=420.05n

.meas tran vdout1_159ck410 FIND v(dout1_159) AT=420.05n

.meas tran vdout1_160ck410 FIND v(dout1_160) AT=420.05n

.meas tran vdout1_161ck410 FIND v(dout1_161) AT=420.05n

.meas tran vdout1_162ck410 FIND v(dout1_162) AT=420.05n

.meas tran vdout1_163ck410 FIND v(dout1_163) AT=420.05n

.meas tran vdout1_164ck410 FIND v(dout1_164) AT=420.05n

.meas tran vdout1_165ck410 FIND v(dout1_165) AT=420.05n

.meas tran vdout1_166ck410 FIND v(dout1_166) AT=420.05n

.meas tran vdout1_167ck410 FIND v(dout1_167) AT=420.05n

.meas tran vdout1_168ck410 FIND v(dout1_168) AT=420.05n

.meas tran vdout1_169ck410 FIND v(dout1_169) AT=420.05n

.meas tran vdout1_170ck410 FIND v(dout1_170) AT=420.05n

.meas tran vdout1_171ck410 FIND v(dout1_171) AT=420.05n

.meas tran vdout1_172ck410 FIND v(dout1_172) AT=420.05n

.meas tran vdout1_173ck410 FIND v(dout1_173) AT=420.05n

.meas tran vdout1_174ck410 FIND v(dout1_174) AT=420.05n

.meas tran vdout1_175ck410 FIND v(dout1_175) AT=420.05n

.meas tran vdout1_176ck410 FIND v(dout1_176) AT=420.05n

.meas tran vdout1_177ck410 FIND v(dout1_177) AT=420.05n

.meas tran vdout1_178ck410 FIND v(dout1_178) AT=420.05n

.meas tran vdout1_179ck410 FIND v(dout1_179) AT=420.05n

.meas tran vdout1_180ck410 FIND v(dout1_180) AT=420.05n

.meas tran vdout1_181ck410 FIND v(dout1_181) AT=420.05n

.meas tran vdout1_182ck410 FIND v(dout1_182) AT=420.05n

.meas tran vdout1_183ck410 FIND v(dout1_183) AT=420.05n

.meas tran vdout1_184ck410 FIND v(dout1_184) AT=420.05n

.meas tran vdout1_185ck410 FIND v(dout1_185) AT=420.05n

.meas tran vdout1_186ck410 FIND v(dout1_186) AT=420.05n

.meas tran vdout1_187ck410 FIND v(dout1_187) AT=420.05n

.meas tran vdout1_188ck410 FIND v(dout1_188) AT=420.05n

.meas tran vdout1_189ck410 FIND v(dout1_189) AT=420.05n

.meas tran vdout1_190ck410 FIND v(dout1_190) AT=420.05n

.meas tran vdout1_191ck410 FIND v(dout1_191) AT=420.05n

.meas tran vdout1_192ck410 FIND v(dout1_192) AT=420.05n

.meas tran vdout1_193ck410 FIND v(dout1_193) AT=420.05n

.meas tran vdout1_194ck410 FIND v(dout1_194) AT=420.05n

.meas tran vdout1_195ck410 FIND v(dout1_195) AT=420.05n

.meas tran vdout1_196ck410 FIND v(dout1_196) AT=420.05n

.meas tran vdout1_197ck410 FIND v(dout1_197) AT=420.05n

.meas tran vdout1_198ck410 FIND v(dout1_198) AT=420.05n

.meas tran vdout1_199ck410 FIND v(dout1_199) AT=420.05n

.meas tran vdout1_200ck410 FIND v(dout1_200) AT=420.05n

.meas tran vdout1_201ck410 FIND v(dout1_201) AT=420.05n

.meas tran vdout1_202ck410 FIND v(dout1_202) AT=420.05n

.meas tran vdout1_203ck410 FIND v(dout1_203) AT=420.05n

.meas tran vdout1_204ck410 FIND v(dout1_204) AT=420.05n

.meas tran vdout1_205ck410 FIND v(dout1_205) AT=420.05n

.meas tran vdout1_206ck410 FIND v(dout1_206) AT=420.05n

.meas tran vdout1_207ck410 FIND v(dout1_207) AT=420.05n

.meas tran vdout1_208ck410 FIND v(dout1_208) AT=420.05n

.meas tran vdout1_209ck410 FIND v(dout1_209) AT=420.05n

.meas tran vdout1_210ck410 FIND v(dout1_210) AT=420.05n

.meas tran vdout1_211ck410 FIND v(dout1_211) AT=420.05n

.meas tran vdout1_212ck410 FIND v(dout1_212) AT=420.05n

.meas tran vdout1_213ck410 FIND v(dout1_213) AT=420.05n

.meas tran vdout1_214ck410 FIND v(dout1_214) AT=420.05n

.meas tran vdout1_215ck410 FIND v(dout1_215) AT=420.05n

.meas tran vdout1_216ck410 FIND v(dout1_216) AT=420.05n

.meas tran vdout1_217ck410 FIND v(dout1_217) AT=420.05n

.meas tran vdout1_218ck410 FIND v(dout1_218) AT=420.05n

.meas tran vdout1_219ck410 FIND v(dout1_219) AT=420.05n

.meas tran vdout1_220ck410 FIND v(dout1_220) AT=420.05n

.meas tran vdout1_221ck410 FIND v(dout1_221) AT=420.05n

.meas tran vdout1_222ck410 FIND v(dout1_222) AT=420.05n

.meas tran vdout1_223ck410 FIND v(dout1_223) AT=420.05n

.meas tran vdout1_224ck410 FIND v(dout1_224) AT=420.05n

.meas tran vdout1_225ck410 FIND v(dout1_225) AT=420.05n

.meas tran vdout1_226ck410 FIND v(dout1_226) AT=420.05n

.meas tran vdout1_227ck410 FIND v(dout1_227) AT=420.05n

.meas tran vdout1_228ck410 FIND v(dout1_228) AT=420.05n

.meas tran vdout1_229ck410 FIND v(dout1_229) AT=420.05n

.meas tran vdout1_230ck410 FIND v(dout1_230) AT=420.05n

.meas tran vdout1_231ck410 FIND v(dout1_231) AT=420.05n

.meas tran vdout1_232ck410 FIND v(dout1_232) AT=420.05n

.meas tran vdout1_233ck410 FIND v(dout1_233) AT=420.05n

.meas tran vdout1_234ck410 FIND v(dout1_234) AT=420.05n

.meas tran vdout1_235ck410 FIND v(dout1_235) AT=420.05n

.meas tran vdout1_236ck410 FIND v(dout1_236) AT=420.05n

.meas tran vdout1_237ck410 FIND v(dout1_237) AT=420.05n

.meas tran vdout1_238ck410 FIND v(dout1_238) AT=420.05n

.meas tran vdout1_239ck410 FIND v(dout1_239) AT=420.05n

.meas tran vdout1_240ck410 FIND v(dout1_240) AT=420.05n

.meas tran vdout1_241ck410 FIND v(dout1_241) AT=420.05n

.meas tran vdout1_242ck410 FIND v(dout1_242) AT=420.05n

.meas tran vdout1_243ck410 FIND v(dout1_243) AT=420.05n

.meas tran vdout1_244ck410 FIND v(dout1_244) AT=420.05n

.meas tran vdout1_245ck410 FIND v(dout1_245) AT=420.05n

.meas tran vdout1_246ck410 FIND v(dout1_246) AT=420.05n

.meas tran vdout1_247ck410 FIND v(dout1_247) AT=420.05n

.meas tran vdout1_248ck410 FIND v(dout1_248) AT=420.05n

.meas tran vdout1_249ck410 FIND v(dout1_249) AT=420.05n

.meas tran vdout1_250ck410 FIND v(dout1_250) AT=420.05n

.meas tran vdout1_251ck410 FIND v(dout1_251) AT=420.05n

.meas tran vdout1_252ck410 FIND v(dout1_252) AT=420.05n

.meas tran vdout1_253ck410 FIND v(dout1_253) AT=420.05n

.meas tran vdout1_254ck410 FIND v(dout1_254) AT=420.05n

.meas tran vdout1_255ck410 FIND v(dout1_255) AT=420.05n

.meas tran vdout1_256ck410 FIND v(dout1_256) AT=420.05n

.meas tran vdout1_0ck420 FIND v(dout1_0) AT=430.05n

.meas tran vdout1_1ck420 FIND v(dout1_1) AT=430.05n

.meas tran vdout1_2ck420 FIND v(dout1_2) AT=430.05n

.meas tran vdout1_3ck420 FIND v(dout1_3) AT=430.05n

.meas tran vdout1_4ck420 FIND v(dout1_4) AT=430.05n

.meas tran vdout1_5ck420 FIND v(dout1_5) AT=430.05n

.meas tran vdout1_6ck420 FIND v(dout1_6) AT=430.05n

.meas tran vdout1_7ck420 FIND v(dout1_7) AT=430.05n

.meas tran vdout1_8ck420 FIND v(dout1_8) AT=430.05n

.meas tran vdout1_9ck420 FIND v(dout1_9) AT=430.05n

.meas tran vdout1_10ck420 FIND v(dout1_10) AT=430.05n

.meas tran vdout1_11ck420 FIND v(dout1_11) AT=430.05n

.meas tran vdout1_12ck420 FIND v(dout1_12) AT=430.05n

.meas tran vdout1_13ck420 FIND v(dout1_13) AT=430.05n

.meas tran vdout1_14ck420 FIND v(dout1_14) AT=430.05n

.meas tran vdout1_15ck420 FIND v(dout1_15) AT=430.05n

.meas tran vdout1_16ck420 FIND v(dout1_16) AT=430.05n

.meas tran vdout1_17ck420 FIND v(dout1_17) AT=430.05n

.meas tran vdout1_18ck420 FIND v(dout1_18) AT=430.05n

.meas tran vdout1_19ck420 FIND v(dout1_19) AT=430.05n

.meas tran vdout1_20ck420 FIND v(dout1_20) AT=430.05n

.meas tran vdout1_21ck420 FIND v(dout1_21) AT=430.05n

.meas tran vdout1_22ck420 FIND v(dout1_22) AT=430.05n

.meas tran vdout1_23ck420 FIND v(dout1_23) AT=430.05n

.meas tran vdout1_24ck420 FIND v(dout1_24) AT=430.05n

.meas tran vdout1_25ck420 FIND v(dout1_25) AT=430.05n

.meas tran vdout1_26ck420 FIND v(dout1_26) AT=430.05n

.meas tran vdout1_27ck420 FIND v(dout1_27) AT=430.05n

.meas tran vdout1_28ck420 FIND v(dout1_28) AT=430.05n

.meas tran vdout1_29ck420 FIND v(dout1_29) AT=430.05n

.meas tran vdout1_30ck420 FIND v(dout1_30) AT=430.05n

.meas tran vdout1_31ck420 FIND v(dout1_31) AT=430.05n

.meas tran vdout1_32ck420 FIND v(dout1_32) AT=430.05n

.meas tran vdout1_33ck420 FIND v(dout1_33) AT=430.05n

.meas tran vdout1_34ck420 FIND v(dout1_34) AT=430.05n

.meas tran vdout1_35ck420 FIND v(dout1_35) AT=430.05n

.meas tran vdout1_36ck420 FIND v(dout1_36) AT=430.05n

.meas tran vdout1_37ck420 FIND v(dout1_37) AT=430.05n

.meas tran vdout1_38ck420 FIND v(dout1_38) AT=430.05n

.meas tran vdout1_39ck420 FIND v(dout1_39) AT=430.05n

.meas tran vdout1_40ck420 FIND v(dout1_40) AT=430.05n

.meas tran vdout1_41ck420 FIND v(dout1_41) AT=430.05n

.meas tran vdout1_42ck420 FIND v(dout1_42) AT=430.05n

.meas tran vdout1_43ck420 FIND v(dout1_43) AT=430.05n

.meas tran vdout1_44ck420 FIND v(dout1_44) AT=430.05n

.meas tran vdout1_45ck420 FIND v(dout1_45) AT=430.05n

.meas tran vdout1_46ck420 FIND v(dout1_46) AT=430.05n

.meas tran vdout1_47ck420 FIND v(dout1_47) AT=430.05n

.meas tran vdout1_48ck420 FIND v(dout1_48) AT=430.05n

.meas tran vdout1_49ck420 FIND v(dout1_49) AT=430.05n

.meas tran vdout1_50ck420 FIND v(dout1_50) AT=430.05n

.meas tran vdout1_51ck420 FIND v(dout1_51) AT=430.05n

.meas tran vdout1_52ck420 FIND v(dout1_52) AT=430.05n

.meas tran vdout1_53ck420 FIND v(dout1_53) AT=430.05n

.meas tran vdout1_54ck420 FIND v(dout1_54) AT=430.05n

.meas tran vdout1_55ck420 FIND v(dout1_55) AT=430.05n

.meas tran vdout1_56ck420 FIND v(dout1_56) AT=430.05n

.meas tran vdout1_57ck420 FIND v(dout1_57) AT=430.05n

.meas tran vdout1_58ck420 FIND v(dout1_58) AT=430.05n

.meas tran vdout1_59ck420 FIND v(dout1_59) AT=430.05n

.meas tran vdout1_60ck420 FIND v(dout1_60) AT=430.05n

.meas tran vdout1_61ck420 FIND v(dout1_61) AT=430.05n

.meas tran vdout1_62ck420 FIND v(dout1_62) AT=430.05n

.meas tran vdout1_63ck420 FIND v(dout1_63) AT=430.05n

.meas tran vdout1_64ck420 FIND v(dout1_64) AT=430.05n

.meas tran vdout1_65ck420 FIND v(dout1_65) AT=430.05n

.meas tran vdout1_66ck420 FIND v(dout1_66) AT=430.05n

.meas tran vdout1_67ck420 FIND v(dout1_67) AT=430.05n

.meas tran vdout1_68ck420 FIND v(dout1_68) AT=430.05n

.meas tran vdout1_69ck420 FIND v(dout1_69) AT=430.05n

.meas tran vdout1_70ck420 FIND v(dout1_70) AT=430.05n

.meas tran vdout1_71ck420 FIND v(dout1_71) AT=430.05n

.meas tran vdout1_72ck420 FIND v(dout1_72) AT=430.05n

.meas tran vdout1_73ck420 FIND v(dout1_73) AT=430.05n

.meas tran vdout1_74ck420 FIND v(dout1_74) AT=430.05n

.meas tran vdout1_75ck420 FIND v(dout1_75) AT=430.05n

.meas tran vdout1_76ck420 FIND v(dout1_76) AT=430.05n

.meas tran vdout1_77ck420 FIND v(dout1_77) AT=430.05n

.meas tran vdout1_78ck420 FIND v(dout1_78) AT=430.05n

.meas tran vdout1_79ck420 FIND v(dout1_79) AT=430.05n

.meas tran vdout1_80ck420 FIND v(dout1_80) AT=430.05n

.meas tran vdout1_81ck420 FIND v(dout1_81) AT=430.05n

.meas tran vdout1_82ck420 FIND v(dout1_82) AT=430.05n

.meas tran vdout1_83ck420 FIND v(dout1_83) AT=430.05n

.meas tran vdout1_84ck420 FIND v(dout1_84) AT=430.05n

.meas tran vdout1_85ck420 FIND v(dout1_85) AT=430.05n

.meas tran vdout1_86ck420 FIND v(dout1_86) AT=430.05n

.meas tran vdout1_87ck420 FIND v(dout1_87) AT=430.05n

.meas tran vdout1_88ck420 FIND v(dout1_88) AT=430.05n

.meas tran vdout1_89ck420 FIND v(dout1_89) AT=430.05n

.meas tran vdout1_90ck420 FIND v(dout1_90) AT=430.05n

.meas tran vdout1_91ck420 FIND v(dout1_91) AT=430.05n

.meas tran vdout1_92ck420 FIND v(dout1_92) AT=430.05n

.meas tran vdout1_93ck420 FIND v(dout1_93) AT=430.05n

.meas tran vdout1_94ck420 FIND v(dout1_94) AT=430.05n

.meas tran vdout1_95ck420 FIND v(dout1_95) AT=430.05n

.meas tran vdout1_96ck420 FIND v(dout1_96) AT=430.05n

.meas tran vdout1_97ck420 FIND v(dout1_97) AT=430.05n

.meas tran vdout1_98ck420 FIND v(dout1_98) AT=430.05n

.meas tran vdout1_99ck420 FIND v(dout1_99) AT=430.05n

.meas tran vdout1_100ck420 FIND v(dout1_100) AT=430.05n

.meas tran vdout1_101ck420 FIND v(dout1_101) AT=430.05n

.meas tran vdout1_102ck420 FIND v(dout1_102) AT=430.05n

.meas tran vdout1_103ck420 FIND v(dout1_103) AT=430.05n

.meas tran vdout1_104ck420 FIND v(dout1_104) AT=430.05n

.meas tran vdout1_105ck420 FIND v(dout1_105) AT=430.05n

.meas tran vdout1_106ck420 FIND v(dout1_106) AT=430.05n

.meas tran vdout1_107ck420 FIND v(dout1_107) AT=430.05n

.meas tran vdout1_108ck420 FIND v(dout1_108) AT=430.05n

.meas tran vdout1_109ck420 FIND v(dout1_109) AT=430.05n

.meas tran vdout1_110ck420 FIND v(dout1_110) AT=430.05n

.meas tran vdout1_111ck420 FIND v(dout1_111) AT=430.05n

.meas tran vdout1_112ck420 FIND v(dout1_112) AT=430.05n

.meas tran vdout1_113ck420 FIND v(dout1_113) AT=430.05n

.meas tran vdout1_114ck420 FIND v(dout1_114) AT=430.05n

.meas tran vdout1_115ck420 FIND v(dout1_115) AT=430.05n

.meas tran vdout1_116ck420 FIND v(dout1_116) AT=430.05n

.meas tran vdout1_117ck420 FIND v(dout1_117) AT=430.05n

.meas tran vdout1_118ck420 FIND v(dout1_118) AT=430.05n

.meas tran vdout1_119ck420 FIND v(dout1_119) AT=430.05n

.meas tran vdout1_120ck420 FIND v(dout1_120) AT=430.05n

.meas tran vdout1_121ck420 FIND v(dout1_121) AT=430.05n

.meas tran vdout1_122ck420 FIND v(dout1_122) AT=430.05n

.meas tran vdout1_123ck420 FIND v(dout1_123) AT=430.05n

.meas tran vdout1_124ck420 FIND v(dout1_124) AT=430.05n

.meas tran vdout1_125ck420 FIND v(dout1_125) AT=430.05n

.meas tran vdout1_126ck420 FIND v(dout1_126) AT=430.05n

.meas tran vdout1_127ck420 FIND v(dout1_127) AT=430.05n

.meas tran vdout1_128ck420 FIND v(dout1_128) AT=430.05n

.meas tran vdout1_129ck420 FIND v(dout1_129) AT=430.05n

.meas tran vdout1_130ck420 FIND v(dout1_130) AT=430.05n

.meas tran vdout1_131ck420 FIND v(dout1_131) AT=430.05n

.meas tran vdout1_132ck420 FIND v(dout1_132) AT=430.05n

.meas tran vdout1_133ck420 FIND v(dout1_133) AT=430.05n

.meas tran vdout1_134ck420 FIND v(dout1_134) AT=430.05n

.meas tran vdout1_135ck420 FIND v(dout1_135) AT=430.05n

.meas tran vdout1_136ck420 FIND v(dout1_136) AT=430.05n

.meas tran vdout1_137ck420 FIND v(dout1_137) AT=430.05n

.meas tran vdout1_138ck420 FIND v(dout1_138) AT=430.05n

.meas tran vdout1_139ck420 FIND v(dout1_139) AT=430.05n

.meas tran vdout1_140ck420 FIND v(dout1_140) AT=430.05n

.meas tran vdout1_141ck420 FIND v(dout1_141) AT=430.05n

.meas tran vdout1_142ck420 FIND v(dout1_142) AT=430.05n

.meas tran vdout1_143ck420 FIND v(dout1_143) AT=430.05n

.meas tran vdout1_144ck420 FIND v(dout1_144) AT=430.05n

.meas tran vdout1_145ck420 FIND v(dout1_145) AT=430.05n

.meas tran vdout1_146ck420 FIND v(dout1_146) AT=430.05n

.meas tran vdout1_147ck420 FIND v(dout1_147) AT=430.05n

.meas tran vdout1_148ck420 FIND v(dout1_148) AT=430.05n

.meas tran vdout1_149ck420 FIND v(dout1_149) AT=430.05n

.meas tran vdout1_150ck420 FIND v(dout1_150) AT=430.05n

.meas tran vdout1_151ck420 FIND v(dout1_151) AT=430.05n

.meas tran vdout1_152ck420 FIND v(dout1_152) AT=430.05n

.meas tran vdout1_153ck420 FIND v(dout1_153) AT=430.05n

.meas tran vdout1_154ck420 FIND v(dout1_154) AT=430.05n

.meas tran vdout1_155ck420 FIND v(dout1_155) AT=430.05n

.meas tran vdout1_156ck420 FIND v(dout1_156) AT=430.05n

.meas tran vdout1_157ck420 FIND v(dout1_157) AT=430.05n

.meas tran vdout1_158ck420 FIND v(dout1_158) AT=430.05n

.meas tran vdout1_159ck420 FIND v(dout1_159) AT=430.05n

.meas tran vdout1_160ck420 FIND v(dout1_160) AT=430.05n

.meas tran vdout1_161ck420 FIND v(dout1_161) AT=430.05n

.meas tran vdout1_162ck420 FIND v(dout1_162) AT=430.05n

.meas tran vdout1_163ck420 FIND v(dout1_163) AT=430.05n

.meas tran vdout1_164ck420 FIND v(dout1_164) AT=430.05n

.meas tran vdout1_165ck420 FIND v(dout1_165) AT=430.05n

.meas tran vdout1_166ck420 FIND v(dout1_166) AT=430.05n

.meas tran vdout1_167ck420 FIND v(dout1_167) AT=430.05n

.meas tran vdout1_168ck420 FIND v(dout1_168) AT=430.05n

.meas tran vdout1_169ck420 FIND v(dout1_169) AT=430.05n

.meas tran vdout1_170ck420 FIND v(dout1_170) AT=430.05n

.meas tran vdout1_171ck420 FIND v(dout1_171) AT=430.05n

.meas tran vdout1_172ck420 FIND v(dout1_172) AT=430.05n

.meas tran vdout1_173ck420 FIND v(dout1_173) AT=430.05n

.meas tran vdout1_174ck420 FIND v(dout1_174) AT=430.05n

.meas tran vdout1_175ck420 FIND v(dout1_175) AT=430.05n

.meas tran vdout1_176ck420 FIND v(dout1_176) AT=430.05n

.meas tran vdout1_177ck420 FIND v(dout1_177) AT=430.05n

.meas tran vdout1_178ck420 FIND v(dout1_178) AT=430.05n

.meas tran vdout1_179ck420 FIND v(dout1_179) AT=430.05n

.meas tran vdout1_180ck420 FIND v(dout1_180) AT=430.05n

.meas tran vdout1_181ck420 FIND v(dout1_181) AT=430.05n

.meas tran vdout1_182ck420 FIND v(dout1_182) AT=430.05n

.meas tran vdout1_183ck420 FIND v(dout1_183) AT=430.05n

.meas tran vdout1_184ck420 FIND v(dout1_184) AT=430.05n

.meas tran vdout1_185ck420 FIND v(dout1_185) AT=430.05n

.meas tran vdout1_186ck420 FIND v(dout1_186) AT=430.05n

.meas tran vdout1_187ck420 FIND v(dout1_187) AT=430.05n

.meas tran vdout1_188ck420 FIND v(dout1_188) AT=430.05n

.meas tran vdout1_189ck420 FIND v(dout1_189) AT=430.05n

.meas tran vdout1_190ck420 FIND v(dout1_190) AT=430.05n

.meas tran vdout1_191ck420 FIND v(dout1_191) AT=430.05n

.meas tran vdout1_192ck420 FIND v(dout1_192) AT=430.05n

.meas tran vdout1_193ck420 FIND v(dout1_193) AT=430.05n

.meas tran vdout1_194ck420 FIND v(dout1_194) AT=430.05n

.meas tran vdout1_195ck420 FIND v(dout1_195) AT=430.05n

.meas tran vdout1_196ck420 FIND v(dout1_196) AT=430.05n

.meas tran vdout1_197ck420 FIND v(dout1_197) AT=430.05n

.meas tran vdout1_198ck420 FIND v(dout1_198) AT=430.05n

.meas tran vdout1_199ck420 FIND v(dout1_199) AT=430.05n

.meas tran vdout1_200ck420 FIND v(dout1_200) AT=430.05n

.meas tran vdout1_201ck420 FIND v(dout1_201) AT=430.05n

.meas tran vdout1_202ck420 FIND v(dout1_202) AT=430.05n

.meas tran vdout1_203ck420 FIND v(dout1_203) AT=430.05n

.meas tran vdout1_204ck420 FIND v(dout1_204) AT=430.05n

.meas tran vdout1_205ck420 FIND v(dout1_205) AT=430.05n

.meas tran vdout1_206ck420 FIND v(dout1_206) AT=430.05n

.meas tran vdout1_207ck420 FIND v(dout1_207) AT=430.05n

.meas tran vdout1_208ck420 FIND v(dout1_208) AT=430.05n

.meas tran vdout1_209ck420 FIND v(dout1_209) AT=430.05n

.meas tran vdout1_210ck420 FIND v(dout1_210) AT=430.05n

.meas tran vdout1_211ck420 FIND v(dout1_211) AT=430.05n

.meas tran vdout1_212ck420 FIND v(dout1_212) AT=430.05n

.meas tran vdout1_213ck420 FIND v(dout1_213) AT=430.05n

.meas tran vdout1_214ck420 FIND v(dout1_214) AT=430.05n

.meas tran vdout1_215ck420 FIND v(dout1_215) AT=430.05n

.meas tran vdout1_216ck420 FIND v(dout1_216) AT=430.05n

.meas tran vdout1_217ck420 FIND v(dout1_217) AT=430.05n

.meas tran vdout1_218ck420 FIND v(dout1_218) AT=430.05n

.meas tran vdout1_219ck420 FIND v(dout1_219) AT=430.05n

.meas tran vdout1_220ck420 FIND v(dout1_220) AT=430.05n

.meas tran vdout1_221ck420 FIND v(dout1_221) AT=430.05n

.meas tran vdout1_222ck420 FIND v(dout1_222) AT=430.05n

.meas tran vdout1_223ck420 FIND v(dout1_223) AT=430.05n

.meas tran vdout1_224ck420 FIND v(dout1_224) AT=430.05n

.meas tran vdout1_225ck420 FIND v(dout1_225) AT=430.05n

.meas tran vdout1_226ck420 FIND v(dout1_226) AT=430.05n

.meas tran vdout1_227ck420 FIND v(dout1_227) AT=430.05n

.meas tran vdout1_228ck420 FIND v(dout1_228) AT=430.05n

.meas tran vdout1_229ck420 FIND v(dout1_229) AT=430.05n

.meas tran vdout1_230ck420 FIND v(dout1_230) AT=430.05n

.meas tran vdout1_231ck420 FIND v(dout1_231) AT=430.05n

.meas tran vdout1_232ck420 FIND v(dout1_232) AT=430.05n

.meas tran vdout1_233ck420 FIND v(dout1_233) AT=430.05n

.meas tran vdout1_234ck420 FIND v(dout1_234) AT=430.05n

.meas tran vdout1_235ck420 FIND v(dout1_235) AT=430.05n

.meas tran vdout1_236ck420 FIND v(dout1_236) AT=430.05n

.meas tran vdout1_237ck420 FIND v(dout1_237) AT=430.05n

.meas tran vdout1_238ck420 FIND v(dout1_238) AT=430.05n

.meas tran vdout1_239ck420 FIND v(dout1_239) AT=430.05n

.meas tran vdout1_240ck420 FIND v(dout1_240) AT=430.05n

.meas tran vdout1_241ck420 FIND v(dout1_241) AT=430.05n

.meas tran vdout1_242ck420 FIND v(dout1_242) AT=430.05n

.meas tran vdout1_243ck420 FIND v(dout1_243) AT=430.05n

.meas tran vdout1_244ck420 FIND v(dout1_244) AT=430.05n

.meas tran vdout1_245ck420 FIND v(dout1_245) AT=430.05n

.meas tran vdout1_246ck420 FIND v(dout1_246) AT=430.05n

.meas tran vdout1_247ck420 FIND v(dout1_247) AT=430.05n

.meas tran vdout1_248ck420 FIND v(dout1_248) AT=430.05n

.meas tran vdout1_249ck420 FIND v(dout1_249) AT=430.05n

.meas tran vdout1_250ck420 FIND v(dout1_250) AT=430.05n

.meas tran vdout1_251ck420 FIND v(dout1_251) AT=430.05n

.meas tran vdout1_252ck420 FIND v(dout1_252) AT=430.05n

.meas tran vdout1_253ck420 FIND v(dout1_253) AT=430.05n

.meas tran vdout1_254ck420 FIND v(dout1_254) AT=430.05n

.meas tran vdout1_255ck420 FIND v(dout1_255) AT=430.05n

.meas tran vdout1_256ck420 FIND v(dout1_256) AT=430.05n

.meas tran vdout1_0ck440 FIND v(dout1_0) AT=450.05n

.meas tran vdout1_1ck440 FIND v(dout1_1) AT=450.05n

.meas tran vdout1_2ck440 FIND v(dout1_2) AT=450.05n

.meas tran vdout1_3ck440 FIND v(dout1_3) AT=450.05n

.meas tran vdout1_4ck440 FIND v(dout1_4) AT=450.05n

.meas tran vdout1_5ck440 FIND v(dout1_5) AT=450.05n

.meas tran vdout1_6ck440 FIND v(dout1_6) AT=450.05n

.meas tran vdout1_7ck440 FIND v(dout1_7) AT=450.05n

.meas tran vdout1_8ck440 FIND v(dout1_8) AT=450.05n

.meas tran vdout1_9ck440 FIND v(dout1_9) AT=450.05n

.meas tran vdout1_10ck440 FIND v(dout1_10) AT=450.05n

.meas tran vdout1_11ck440 FIND v(dout1_11) AT=450.05n

.meas tran vdout1_12ck440 FIND v(dout1_12) AT=450.05n

.meas tran vdout1_13ck440 FIND v(dout1_13) AT=450.05n

.meas tran vdout1_14ck440 FIND v(dout1_14) AT=450.05n

.meas tran vdout1_15ck440 FIND v(dout1_15) AT=450.05n

.meas tran vdout1_16ck440 FIND v(dout1_16) AT=450.05n

.meas tran vdout1_17ck440 FIND v(dout1_17) AT=450.05n

.meas tran vdout1_18ck440 FIND v(dout1_18) AT=450.05n

.meas tran vdout1_19ck440 FIND v(dout1_19) AT=450.05n

.meas tran vdout1_20ck440 FIND v(dout1_20) AT=450.05n

.meas tran vdout1_21ck440 FIND v(dout1_21) AT=450.05n

.meas tran vdout1_22ck440 FIND v(dout1_22) AT=450.05n

.meas tran vdout1_23ck440 FIND v(dout1_23) AT=450.05n

.meas tran vdout1_24ck440 FIND v(dout1_24) AT=450.05n

.meas tran vdout1_25ck440 FIND v(dout1_25) AT=450.05n

.meas tran vdout1_26ck440 FIND v(dout1_26) AT=450.05n

.meas tran vdout1_27ck440 FIND v(dout1_27) AT=450.05n

.meas tran vdout1_28ck440 FIND v(dout1_28) AT=450.05n

.meas tran vdout1_29ck440 FIND v(dout1_29) AT=450.05n

.meas tran vdout1_30ck440 FIND v(dout1_30) AT=450.05n

.meas tran vdout1_31ck440 FIND v(dout1_31) AT=450.05n

.meas tran vdout1_32ck440 FIND v(dout1_32) AT=450.05n

.meas tran vdout1_33ck440 FIND v(dout1_33) AT=450.05n

.meas tran vdout1_34ck440 FIND v(dout1_34) AT=450.05n

.meas tran vdout1_35ck440 FIND v(dout1_35) AT=450.05n

.meas tran vdout1_36ck440 FIND v(dout1_36) AT=450.05n

.meas tran vdout1_37ck440 FIND v(dout1_37) AT=450.05n

.meas tran vdout1_38ck440 FIND v(dout1_38) AT=450.05n

.meas tran vdout1_39ck440 FIND v(dout1_39) AT=450.05n

.meas tran vdout1_40ck440 FIND v(dout1_40) AT=450.05n

.meas tran vdout1_41ck440 FIND v(dout1_41) AT=450.05n

.meas tran vdout1_42ck440 FIND v(dout1_42) AT=450.05n

.meas tran vdout1_43ck440 FIND v(dout1_43) AT=450.05n

.meas tran vdout1_44ck440 FIND v(dout1_44) AT=450.05n

.meas tran vdout1_45ck440 FIND v(dout1_45) AT=450.05n

.meas tran vdout1_46ck440 FIND v(dout1_46) AT=450.05n

.meas tran vdout1_47ck440 FIND v(dout1_47) AT=450.05n

.meas tran vdout1_48ck440 FIND v(dout1_48) AT=450.05n

.meas tran vdout1_49ck440 FIND v(dout1_49) AT=450.05n

.meas tran vdout1_50ck440 FIND v(dout1_50) AT=450.05n

.meas tran vdout1_51ck440 FIND v(dout1_51) AT=450.05n

.meas tran vdout1_52ck440 FIND v(dout1_52) AT=450.05n

.meas tran vdout1_53ck440 FIND v(dout1_53) AT=450.05n

.meas tran vdout1_54ck440 FIND v(dout1_54) AT=450.05n

.meas tran vdout1_55ck440 FIND v(dout1_55) AT=450.05n

.meas tran vdout1_56ck440 FIND v(dout1_56) AT=450.05n

.meas tran vdout1_57ck440 FIND v(dout1_57) AT=450.05n

.meas tran vdout1_58ck440 FIND v(dout1_58) AT=450.05n

.meas tran vdout1_59ck440 FIND v(dout1_59) AT=450.05n

.meas tran vdout1_60ck440 FIND v(dout1_60) AT=450.05n

.meas tran vdout1_61ck440 FIND v(dout1_61) AT=450.05n

.meas tran vdout1_62ck440 FIND v(dout1_62) AT=450.05n

.meas tran vdout1_63ck440 FIND v(dout1_63) AT=450.05n

.meas tran vdout1_64ck440 FIND v(dout1_64) AT=450.05n

.meas tran vdout1_65ck440 FIND v(dout1_65) AT=450.05n

.meas tran vdout1_66ck440 FIND v(dout1_66) AT=450.05n

.meas tran vdout1_67ck440 FIND v(dout1_67) AT=450.05n

.meas tran vdout1_68ck440 FIND v(dout1_68) AT=450.05n

.meas tran vdout1_69ck440 FIND v(dout1_69) AT=450.05n

.meas tran vdout1_70ck440 FIND v(dout1_70) AT=450.05n

.meas tran vdout1_71ck440 FIND v(dout1_71) AT=450.05n

.meas tran vdout1_72ck440 FIND v(dout1_72) AT=450.05n

.meas tran vdout1_73ck440 FIND v(dout1_73) AT=450.05n

.meas tran vdout1_74ck440 FIND v(dout1_74) AT=450.05n

.meas tran vdout1_75ck440 FIND v(dout1_75) AT=450.05n

.meas tran vdout1_76ck440 FIND v(dout1_76) AT=450.05n

.meas tran vdout1_77ck440 FIND v(dout1_77) AT=450.05n

.meas tran vdout1_78ck440 FIND v(dout1_78) AT=450.05n

.meas tran vdout1_79ck440 FIND v(dout1_79) AT=450.05n

.meas tran vdout1_80ck440 FIND v(dout1_80) AT=450.05n

.meas tran vdout1_81ck440 FIND v(dout1_81) AT=450.05n

.meas tran vdout1_82ck440 FIND v(dout1_82) AT=450.05n

.meas tran vdout1_83ck440 FIND v(dout1_83) AT=450.05n

.meas tran vdout1_84ck440 FIND v(dout1_84) AT=450.05n

.meas tran vdout1_85ck440 FIND v(dout1_85) AT=450.05n

.meas tran vdout1_86ck440 FIND v(dout1_86) AT=450.05n

.meas tran vdout1_87ck440 FIND v(dout1_87) AT=450.05n

.meas tran vdout1_88ck440 FIND v(dout1_88) AT=450.05n

.meas tran vdout1_89ck440 FIND v(dout1_89) AT=450.05n

.meas tran vdout1_90ck440 FIND v(dout1_90) AT=450.05n

.meas tran vdout1_91ck440 FIND v(dout1_91) AT=450.05n

.meas tran vdout1_92ck440 FIND v(dout1_92) AT=450.05n

.meas tran vdout1_93ck440 FIND v(dout1_93) AT=450.05n

.meas tran vdout1_94ck440 FIND v(dout1_94) AT=450.05n

.meas tran vdout1_95ck440 FIND v(dout1_95) AT=450.05n

.meas tran vdout1_96ck440 FIND v(dout1_96) AT=450.05n

.meas tran vdout1_97ck440 FIND v(dout1_97) AT=450.05n

.meas tran vdout1_98ck440 FIND v(dout1_98) AT=450.05n

.meas tran vdout1_99ck440 FIND v(dout1_99) AT=450.05n

.meas tran vdout1_100ck440 FIND v(dout1_100) AT=450.05n

.meas tran vdout1_101ck440 FIND v(dout1_101) AT=450.05n

.meas tran vdout1_102ck440 FIND v(dout1_102) AT=450.05n

.meas tran vdout1_103ck440 FIND v(dout1_103) AT=450.05n

.meas tran vdout1_104ck440 FIND v(dout1_104) AT=450.05n

.meas tran vdout1_105ck440 FIND v(dout1_105) AT=450.05n

.meas tran vdout1_106ck440 FIND v(dout1_106) AT=450.05n

.meas tran vdout1_107ck440 FIND v(dout1_107) AT=450.05n

.meas tran vdout1_108ck440 FIND v(dout1_108) AT=450.05n

.meas tran vdout1_109ck440 FIND v(dout1_109) AT=450.05n

.meas tran vdout1_110ck440 FIND v(dout1_110) AT=450.05n

.meas tran vdout1_111ck440 FIND v(dout1_111) AT=450.05n

.meas tran vdout1_112ck440 FIND v(dout1_112) AT=450.05n

.meas tran vdout1_113ck440 FIND v(dout1_113) AT=450.05n

.meas tran vdout1_114ck440 FIND v(dout1_114) AT=450.05n

.meas tran vdout1_115ck440 FIND v(dout1_115) AT=450.05n

.meas tran vdout1_116ck440 FIND v(dout1_116) AT=450.05n

.meas tran vdout1_117ck440 FIND v(dout1_117) AT=450.05n

.meas tran vdout1_118ck440 FIND v(dout1_118) AT=450.05n

.meas tran vdout1_119ck440 FIND v(dout1_119) AT=450.05n

.meas tran vdout1_120ck440 FIND v(dout1_120) AT=450.05n

.meas tran vdout1_121ck440 FIND v(dout1_121) AT=450.05n

.meas tran vdout1_122ck440 FIND v(dout1_122) AT=450.05n

.meas tran vdout1_123ck440 FIND v(dout1_123) AT=450.05n

.meas tran vdout1_124ck440 FIND v(dout1_124) AT=450.05n

.meas tran vdout1_125ck440 FIND v(dout1_125) AT=450.05n

.meas tran vdout1_126ck440 FIND v(dout1_126) AT=450.05n

.meas tran vdout1_127ck440 FIND v(dout1_127) AT=450.05n

.meas tran vdout1_128ck440 FIND v(dout1_128) AT=450.05n

.meas tran vdout1_129ck440 FIND v(dout1_129) AT=450.05n

.meas tran vdout1_130ck440 FIND v(dout1_130) AT=450.05n

.meas tran vdout1_131ck440 FIND v(dout1_131) AT=450.05n

.meas tran vdout1_132ck440 FIND v(dout1_132) AT=450.05n

.meas tran vdout1_133ck440 FIND v(dout1_133) AT=450.05n

.meas tran vdout1_134ck440 FIND v(dout1_134) AT=450.05n

.meas tran vdout1_135ck440 FIND v(dout1_135) AT=450.05n

.meas tran vdout1_136ck440 FIND v(dout1_136) AT=450.05n

.meas tran vdout1_137ck440 FIND v(dout1_137) AT=450.05n

.meas tran vdout1_138ck440 FIND v(dout1_138) AT=450.05n

.meas tran vdout1_139ck440 FIND v(dout1_139) AT=450.05n

.meas tran vdout1_140ck440 FIND v(dout1_140) AT=450.05n

.meas tran vdout1_141ck440 FIND v(dout1_141) AT=450.05n

.meas tran vdout1_142ck440 FIND v(dout1_142) AT=450.05n

.meas tran vdout1_143ck440 FIND v(dout1_143) AT=450.05n

.meas tran vdout1_144ck440 FIND v(dout1_144) AT=450.05n

.meas tran vdout1_145ck440 FIND v(dout1_145) AT=450.05n

.meas tran vdout1_146ck440 FIND v(dout1_146) AT=450.05n

.meas tran vdout1_147ck440 FIND v(dout1_147) AT=450.05n

.meas tran vdout1_148ck440 FIND v(dout1_148) AT=450.05n

.meas tran vdout1_149ck440 FIND v(dout1_149) AT=450.05n

.meas tran vdout1_150ck440 FIND v(dout1_150) AT=450.05n

.meas tran vdout1_151ck440 FIND v(dout1_151) AT=450.05n

.meas tran vdout1_152ck440 FIND v(dout1_152) AT=450.05n

.meas tran vdout1_153ck440 FIND v(dout1_153) AT=450.05n

.meas tran vdout1_154ck440 FIND v(dout1_154) AT=450.05n

.meas tran vdout1_155ck440 FIND v(dout1_155) AT=450.05n

.meas tran vdout1_156ck440 FIND v(dout1_156) AT=450.05n

.meas tran vdout1_157ck440 FIND v(dout1_157) AT=450.05n

.meas tran vdout1_158ck440 FIND v(dout1_158) AT=450.05n

.meas tran vdout1_159ck440 FIND v(dout1_159) AT=450.05n

.meas tran vdout1_160ck440 FIND v(dout1_160) AT=450.05n

.meas tran vdout1_161ck440 FIND v(dout1_161) AT=450.05n

.meas tran vdout1_162ck440 FIND v(dout1_162) AT=450.05n

.meas tran vdout1_163ck440 FIND v(dout1_163) AT=450.05n

.meas tran vdout1_164ck440 FIND v(dout1_164) AT=450.05n

.meas tran vdout1_165ck440 FIND v(dout1_165) AT=450.05n

.meas tran vdout1_166ck440 FIND v(dout1_166) AT=450.05n

.meas tran vdout1_167ck440 FIND v(dout1_167) AT=450.05n

.meas tran vdout1_168ck440 FIND v(dout1_168) AT=450.05n

.meas tran vdout1_169ck440 FIND v(dout1_169) AT=450.05n

.meas tran vdout1_170ck440 FIND v(dout1_170) AT=450.05n

.meas tran vdout1_171ck440 FIND v(dout1_171) AT=450.05n

.meas tran vdout1_172ck440 FIND v(dout1_172) AT=450.05n

.meas tran vdout1_173ck440 FIND v(dout1_173) AT=450.05n

.meas tran vdout1_174ck440 FIND v(dout1_174) AT=450.05n

.meas tran vdout1_175ck440 FIND v(dout1_175) AT=450.05n

.meas tran vdout1_176ck440 FIND v(dout1_176) AT=450.05n

.meas tran vdout1_177ck440 FIND v(dout1_177) AT=450.05n

.meas tran vdout1_178ck440 FIND v(dout1_178) AT=450.05n

.meas tran vdout1_179ck440 FIND v(dout1_179) AT=450.05n

.meas tran vdout1_180ck440 FIND v(dout1_180) AT=450.05n

.meas tran vdout1_181ck440 FIND v(dout1_181) AT=450.05n

.meas tran vdout1_182ck440 FIND v(dout1_182) AT=450.05n

.meas tran vdout1_183ck440 FIND v(dout1_183) AT=450.05n

.meas tran vdout1_184ck440 FIND v(dout1_184) AT=450.05n

.meas tran vdout1_185ck440 FIND v(dout1_185) AT=450.05n

.meas tran vdout1_186ck440 FIND v(dout1_186) AT=450.05n

.meas tran vdout1_187ck440 FIND v(dout1_187) AT=450.05n

.meas tran vdout1_188ck440 FIND v(dout1_188) AT=450.05n

.meas tran vdout1_189ck440 FIND v(dout1_189) AT=450.05n

.meas tran vdout1_190ck440 FIND v(dout1_190) AT=450.05n

.meas tran vdout1_191ck440 FIND v(dout1_191) AT=450.05n

.meas tran vdout1_192ck440 FIND v(dout1_192) AT=450.05n

.meas tran vdout1_193ck440 FIND v(dout1_193) AT=450.05n

.meas tran vdout1_194ck440 FIND v(dout1_194) AT=450.05n

.meas tran vdout1_195ck440 FIND v(dout1_195) AT=450.05n

.meas tran vdout1_196ck440 FIND v(dout1_196) AT=450.05n

.meas tran vdout1_197ck440 FIND v(dout1_197) AT=450.05n

.meas tran vdout1_198ck440 FIND v(dout1_198) AT=450.05n

.meas tran vdout1_199ck440 FIND v(dout1_199) AT=450.05n

.meas tran vdout1_200ck440 FIND v(dout1_200) AT=450.05n

.meas tran vdout1_201ck440 FIND v(dout1_201) AT=450.05n

.meas tran vdout1_202ck440 FIND v(dout1_202) AT=450.05n

.meas tran vdout1_203ck440 FIND v(dout1_203) AT=450.05n

.meas tran vdout1_204ck440 FIND v(dout1_204) AT=450.05n

.meas tran vdout1_205ck440 FIND v(dout1_205) AT=450.05n

.meas tran vdout1_206ck440 FIND v(dout1_206) AT=450.05n

.meas tran vdout1_207ck440 FIND v(dout1_207) AT=450.05n

.meas tran vdout1_208ck440 FIND v(dout1_208) AT=450.05n

.meas tran vdout1_209ck440 FIND v(dout1_209) AT=450.05n

.meas tran vdout1_210ck440 FIND v(dout1_210) AT=450.05n

.meas tran vdout1_211ck440 FIND v(dout1_211) AT=450.05n

.meas tran vdout1_212ck440 FIND v(dout1_212) AT=450.05n

.meas tran vdout1_213ck440 FIND v(dout1_213) AT=450.05n

.meas tran vdout1_214ck440 FIND v(dout1_214) AT=450.05n

.meas tran vdout1_215ck440 FIND v(dout1_215) AT=450.05n

.meas tran vdout1_216ck440 FIND v(dout1_216) AT=450.05n

.meas tran vdout1_217ck440 FIND v(dout1_217) AT=450.05n

.meas tran vdout1_218ck440 FIND v(dout1_218) AT=450.05n

.meas tran vdout1_219ck440 FIND v(dout1_219) AT=450.05n

.meas tran vdout1_220ck440 FIND v(dout1_220) AT=450.05n

.meas tran vdout1_221ck440 FIND v(dout1_221) AT=450.05n

.meas tran vdout1_222ck440 FIND v(dout1_222) AT=450.05n

.meas tran vdout1_223ck440 FIND v(dout1_223) AT=450.05n

.meas tran vdout1_224ck440 FIND v(dout1_224) AT=450.05n

.meas tran vdout1_225ck440 FIND v(dout1_225) AT=450.05n

.meas tran vdout1_226ck440 FIND v(dout1_226) AT=450.05n

.meas tran vdout1_227ck440 FIND v(dout1_227) AT=450.05n

.meas tran vdout1_228ck440 FIND v(dout1_228) AT=450.05n

.meas tran vdout1_229ck440 FIND v(dout1_229) AT=450.05n

.meas tran vdout1_230ck440 FIND v(dout1_230) AT=450.05n

.meas tran vdout1_231ck440 FIND v(dout1_231) AT=450.05n

.meas tran vdout1_232ck440 FIND v(dout1_232) AT=450.05n

.meas tran vdout1_233ck440 FIND v(dout1_233) AT=450.05n

.meas tran vdout1_234ck440 FIND v(dout1_234) AT=450.05n

.meas tran vdout1_235ck440 FIND v(dout1_235) AT=450.05n

.meas tran vdout1_236ck440 FIND v(dout1_236) AT=450.05n

.meas tran vdout1_237ck440 FIND v(dout1_237) AT=450.05n

.meas tran vdout1_238ck440 FIND v(dout1_238) AT=450.05n

.meas tran vdout1_239ck440 FIND v(dout1_239) AT=450.05n

.meas tran vdout1_240ck440 FIND v(dout1_240) AT=450.05n

.meas tran vdout1_241ck440 FIND v(dout1_241) AT=450.05n

.meas tran vdout1_242ck440 FIND v(dout1_242) AT=450.05n

.meas tran vdout1_243ck440 FIND v(dout1_243) AT=450.05n

.meas tran vdout1_244ck440 FIND v(dout1_244) AT=450.05n

.meas tran vdout1_245ck440 FIND v(dout1_245) AT=450.05n

.meas tran vdout1_246ck440 FIND v(dout1_246) AT=450.05n

.meas tran vdout1_247ck440 FIND v(dout1_247) AT=450.05n

.meas tran vdout1_248ck440 FIND v(dout1_248) AT=450.05n

.meas tran vdout1_249ck440 FIND v(dout1_249) AT=450.05n

.meas tran vdout1_250ck440 FIND v(dout1_250) AT=450.05n

.meas tran vdout1_251ck440 FIND v(dout1_251) AT=450.05n

.meas tran vdout1_252ck440 FIND v(dout1_252) AT=450.05n

.meas tran vdout1_253ck440 FIND v(dout1_253) AT=450.05n

.meas tran vdout1_254ck440 FIND v(dout1_254) AT=450.05n

.meas tran vdout1_255ck440 FIND v(dout1_255) AT=450.05n

.meas tran vdout1_256ck440 FIND v(dout1_256) AT=450.05n

.meas tran vdout1_0ck460 FIND v(dout1_0) AT=470.05n

.meas tran vdout1_1ck460 FIND v(dout1_1) AT=470.05n

.meas tran vdout1_2ck460 FIND v(dout1_2) AT=470.05n

.meas tran vdout1_3ck460 FIND v(dout1_3) AT=470.05n

.meas tran vdout1_4ck460 FIND v(dout1_4) AT=470.05n

.meas tran vdout1_5ck460 FIND v(dout1_5) AT=470.05n

.meas tran vdout1_6ck460 FIND v(dout1_6) AT=470.05n

.meas tran vdout1_7ck460 FIND v(dout1_7) AT=470.05n

.meas tran vdout1_8ck460 FIND v(dout1_8) AT=470.05n

.meas tran vdout1_9ck460 FIND v(dout1_9) AT=470.05n

.meas tran vdout1_10ck460 FIND v(dout1_10) AT=470.05n

.meas tran vdout1_11ck460 FIND v(dout1_11) AT=470.05n

.meas tran vdout1_12ck460 FIND v(dout1_12) AT=470.05n

.meas tran vdout1_13ck460 FIND v(dout1_13) AT=470.05n

.meas tran vdout1_14ck460 FIND v(dout1_14) AT=470.05n

.meas tran vdout1_15ck460 FIND v(dout1_15) AT=470.05n

.meas tran vdout1_16ck460 FIND v(dout1_16) AT=470.05n

.meas tran vdout1_17ck460 FIND v(dout1_17) AT=470.05n

.meas tran vdout1_18ck460 FIND v(dout1_18) AT=470.05n

.meas tran vdout1_19ck460 FIND v(dout1_19) AT=470.05n

.meas tran vdout1_20ck460 FIND v(dout1_20) AT=470.05n

.meas tran vdout1_21ck460 FIND v(dout1_21) AT=470.05n

.meas tran vdout1_22ck460 FIND v(dout1_22) AT=470.05n

.meas tran vdout1_23ck460 FIND v(dout1_23) AT=470.05n

.meas tran vdout1_24ck460 FIND v(dout1_24) AT=470.05n

.meas tran vdout1_25ck460 FIND v(dout1_25) AT=470.05n

.meas tran vdout1_26ck460 FIND v(dout1_26) AT=470.05n

.meas tran vdout1_27ck460 FIND v(dout1_27) AT=470.05n

.meas tran vdout1_28ck460 FIND v(dout1_28) AT=470.05n

.meas tran vdout1_29ck460 FIND v(dout1_29) AT=470.05n

.meas tran vdout1_30ck460 FIND v(dout1_30) AT=470.05n

.meas tran vdout1_31ck460 FIND v(dout1_31) AT=470.05n

.meas tran vdout1_32ck460 FIND v(dout1_32) AT=470.05n

.meas tran vdout1_33ck460 FIND v(dout1_33) AT=470.05n

.meas tran vdout1_34ck460 FIND v(dout1_34) AT=470.05n

.meas tran vdout1_35ck460 FIND v(dout1_35) AT=470.05n

.meas tran vdout1_36ck460 FIND v(dout1_36) AT=470.05n

.meas tran vdout1_37ck460 FIND v(dout1_37) AT=470.05n

.meas tran vdout1_38ck460 FIND v(dout1_38) AT=470.05n

.meas tran vdout1_39ck460 FIND v(dout1_39) AT=470.05n

.meas tran vdout1_40ck460 FIND v(dout1_40) AT=470.05n

.meas tran vdout1_41ck460 FIND v(dout1_41) AT=470.05n

.meas tran vdout1_42ck460 FIND v(dout1_42) AT=470.05n

.meas tran vdout1_43ck460 FIND v(dout1_43) AT=470.05n

.meas tran vdout1_44ck460 FIND v(dout1_44) AT=470.05n

.meas tran vdout1_45ck460 FIND v(dout1_45) AT=470.05n

.meas tran vdout1_46ck460 FIND v(dout1_46) AT=470.05n

.meas tran vdout1_47ck460 FIND v(dout1_47) AT=470.05n

.meas tran vdout1_48ck460 FIND v(dout1_48) AT=470.05n

.meas tran vdout1_49ck460 FIND v(dout1_49) AT=470.05n

.meas tran vdout1_50ck460 FIND v(dout1_50) AT=470.05n

.meas tran vdout1_51ck460 FIND v(dout1_51) AT=470.05n

.meas tran vdout1_52ck460 FIND v(dout1_52) AT=470.05n

.meas tran vdout1_53ck460 FIND v(dout1_53) AT=470.05n

.meas tran vdout1_54ck460 FIND v(dout1_54) AT=470.05n

.meas tran vdout1_55ck460 FIND v(dout1_55) AT=470.05n

.meas tran vdout1_56ck460 FIND v(dout1_56) AT=470.05n

.meas tran vdout1_57ck460 FIND v(dout1_57) AT=470.05n

.meas tran vdout1_58ck460 FIND v(dout1_58) AT=470.05n

.meas tran vdout1_59ck460 FIND v(dout1_59) AT=470.05n

.meas tran vdout1_60ck460 FIND v(dout1_60) AT=470.05n

.meas tran vdout1_61ck460 FIND v(dout1_61) AT=470.05n

.meas tran vdout1_62ck460 FIND v(dout1_62) AT=470.05n

.meas tran vdout1_63ck460 FIND v(dout1_63) AT=470.05n

.meas tran vdout1_64ck460 FIND v(dout1_64) AT=470.05n

.meas tran vdout1_65ck460 FIND v(dout1_65) AT=470.05n

.meas tran vdout1_66ck460 FIND v(dout1_66) AT=470.05n

.meas tran vdout1_67ck460 FIND v(dout1_67) AT=470.05n

.meas tran vdout1_68ck460 FIND v(dout1_68) AT=470.05n

.meas tran vdout1_69ck460 FIND v(dout1_69) AT=470.05n

.meas tran vdout1_70ck460 FIND v(dout1_70) AT=470.05n

.meas tran vdout1_71ck460 FIND v(dout1_71) AT=470.05n

.meas tran vdout1_72ck460 FIND v(dout1_72) AT=470.05n

.meas tran vdout1_73ck460 FIND v(dout1_73) AT=470.05n

.meas tran vdout1_74ck460 FIND v(dout1_74) AT=470.05n

.meas tran vdout1_75ck460 FIND v(dout1_75) AT=470.05n

.meas tran vdout1_76ck460 FIND v(dout1_76) AT=470.05n

.meas tran vdout1_77ck460 FIND v(dout1_77) AT=470.05n

.meas tran vdout1_78ck460 FIND v(dout1_78) AT=470.05n

.meas tran vdout1_79ck460 FIND v(dout1_79) AT=470.05n

.meas tran vdout1_80ck460 FIND v(dout1_80) AT=470.05n

.meas tran vdout1_81ck460 FIND v(dout1_81) AT=470.05n

.meas tran vdout1_82ck460 FIND v(dout1_82) AT=470.05n

.meas tran vdout1_83ck460 FIND v(dout1_83) AT=470.05n

.meas tran vdout1_84ck460 FIND v(dout1_84) AT=470.05n

.meas tran vdout1_85ck460 FIND v(dout1_85) AT=470.05n

.meas tran vdout1_86ck460 FIND v(dout1_86) AT=470.05n

.meas tran vdout1_87ck460 FIND v(dout1_87) AT=470.05n

.meas tran vdout1_88ck460 FIND v(dout1_88) AT=470.05n

.meas tran vdout1_89ck460 FIND v(dout1_89) AT=470.05n

.meas tran vdout1_90ck460 FIND v(dout1_90) AT=470.05n

.meas tran vdout1_91ck460 FIND v(dout1_91) AT=470.05n

.meas tran vdout1_92ck460 FIND v(dout1_92) AT=470.05n

.meas tran vdout1_93ck460 FIND v(dout1_93) AT=470.05n

.meas tran vdout1_94ck460 FIND v(dout1_94) AT=470.05n

.meas tran vdout1_95ck460 FIND v(dout1_95) AT=470.05n

.meas tran vdout1_96ck460 FIND v(dout1_96) AT=470.05n

.meas tran vdout1_97ck460 FIND v(dout1_97) AT=470.05n

.meas tran vdout1_98ck460 FIND v(dout1_98) AT=470.05n

.meas tran vdout1_99ck460 FIND v(dout1_99) AT=470.05n

.meas tran vdout1_100ck460 FIND v(dout1_100) AT=470.05n

.meas tran vdout1_101ck460 FIND v(dout1_101) AT=470.05n

.meas tran vdout1_102ck460 FIND v(dout1_102) AT=470.05n

.meas tran vdout1_103ck460 FIND v(dout1_103) AT=470.05n

.meas tran vdout1_104ck460 FIND v(dout1_104) AT=470.05n

.meas tran vdout1_105ck460 FIND v(dout1_105) AT=470.05n

.meas tran vdout1_106ck460 FIND v(dout1_106) AT=470.05n

.meas tran vdout1_107ck460 FIND v(dout1_107) AT=470.05n

.meas tran vdout1_108ck460 FIND v(dout1_108) AT=470.05n

.meas tran vdout1_109ck460 FIND v(dout1_109) AT=470.05n

.meas tran vdout1_110ck460 FIND v(dout1_110) AT=470.05n

.meas tran vdout1_111ck460 FIND v(dout1_111) AT=470.05n

.meas tran vdout1_112ck460 FIND v(dout1_112) AT=470.05n

.meas tran vdout1_113ck460 FIND v(dout1_113) AT=470.05n

.meas tran vdout1_114ck460 FIND v(dout1_114) AT=470.05n

.meas tran vdout1_115ck460 FIND v(dout1_115) AT=470.05n

.meas tran vdout1_116ck460 FIND v(dout1_116) AT=470.05n

.meas tran vdout1_117ck460 FIND v(dout1_117) AT=470.05n

.meas tran vdout1_118ck460 FIND v(dout1_118) AT=470.05n

.meas tran vdout1_119ck460 FIND v(dout1_119) AT=470.05n

.meas tran vdout1_120ck460 FIND v(dout1_120) AT=470.05n

.meas tran vdout1_121ck460 FIND v(dout1_121) AT=470.05n

.meas tran vdout1_122ck460 FIND v(dout1_122) AT=470.05n

.meas tran vdout1_123ck460 FIND v(dout1_123) AT=470.05n

.meas tran vdout1_124ck460 FIND v(dout1_124) AT=470.05n

.meas tran vdout1_125ck460 FIND v(dout1_125) AT=470.05n

.meas tran vdout1_126ck460 FIND v(dout1_126) AT=470.05n

.meas tran vdout1_127ck460 FIND v(dout1_127) AT=470.05n

.meas tran vdout1_128ck460 FIND v(dout1_128) AT=470.05n

.meas tran vdout1_129ck460 FIND v(dout1_129) AT=470.05n

.meas tran vdout1_130ck460 FIND v(dout1_130) AT=470.05n

.meas tran vdout1_131ck460 FIND v(dout1_131) AT=470.05n

.meas tran vdout1_132ck460 FIND v(dout1_132) AT=470.05n

.meas tran vdout1_133ck460 FIND v(dout1_133) AT=470.05n

.meas tran vdout1_134ck460 FIND v(dout1_134) AT=470.05n

.meas tran vdout1_135ck460 FIND v(dout1_135) AT=470.05n

.meas tran vdout1_136ck460 FIND v(dout1_136) AT=470.05n

.meas tran vdout1_137ck460 FIND v(dout1_137) AT=470.05n

.meas tran vdout1_138ck460 FIND v(dout1_138) AT=470.05n

.meas tran vdout1_139ck460 FIND v(dout1_139) AT=470.05n

.meas tran vdout1_140ck460 FIND v(dout1_140) AT=470.05n

.meas tran vdout1_141ck460 FIND v(dout1_141) AT=470.05n

.meas tran vdout1_142ck460 FIND v(dout1_142) AT=470.05n

.meas tran vdout1_143ck460 FIND v(dout1_143) AT=470.05n

.meas tran vdout1_144ck460 FIND v(dout1_144) AT=470.05n

.meas tran vdout1_145ck460 FIND v(dout1_145) AT=470.05n

.meas tran vdout1_146ck460 FIND v(dout1_146) AT=470.05n

.meas tran vdout1_147ck460 FIND v(dout1_147) AT=470.05n

.meas tran vdout1_148ck460 FIND v(dout1_148) AT=470.05n

.meas tran vdout1_149ck460 FIND v(dout1_149) AT=470.05n

.meas tran vdout1_150ck460 FIND v(dout1_150) AT=470.05n

.meas tran vdout1_151ck460 FIND v(dout1_151) AT=470.05n

.meas tran vdout1_152ck460 FIND v(dout1_152) AT=470.05n

.meas tran vdout1_153ck460 FIND v(dout1_153) AT=470.05n

.meas tran vdout1_154ck460 FIND v(dout1_154) AT=470.05n

.meas tran vdout1_155ck460 FIND v(dout1_155) AT=470.05n

.meas tran vdout1_156ck460 FIND v(dout1_156) AT=470.05n

.meas tran vdout1_157ck460 FIND v(dout1_157) AT=470.05n

.meas tran vdout1_158ck460 FIND v(dout1_158) AT=470.05n

.meas tran vdout1_159ck460 FIND v(dout1_159) AT=470.05n

.meas tran vdout1_160ck460 FIND v(dout1_160) AT=470.05n

.meas tran vdout1_161ck460 FIND v(dout1_161) AT=470.05n

.meas tran vdout1_162ck460 FIND v(dout1_162) AT=470.05n

.meas tran vdout1_163ck460 FIND v(dout1_163) AT=470.05n

.meas tran vdout1_164ck460 FIND v(dout1_164) AT=470.05n

.meas tran vdout1_165ck460 FIND v(dout1_165) AT=470.05n

.meas tran vdout1_166ck460 FIND v(dout1_166) AT=470.05n

.meas tran vdout1_167ck460 FIND v(dout1_167) AT=470.05n

.meas tran vdout1_168ck460 FIND v(dout1_168) AT=470.05n

.meas tran vdout1_169ck460 FIND v(dout1_169) AT=470.05n

.meas tran vdout1_170ck460 FIND v(dout1_170) AT=470.05n

.meas tran vdout1_171ck460 FIND v(dout1_171) AT=470.05n

.meas tran vdout1_172ck460 FIND v(dout1_172) AT=470.05n

.meas tran vdout1_173ck460 FIND v(dout1_173) AT=470.05n

.meas tran vdout1_174ck460 FIND v(dout1_174) AT=470.05n

.meas tran vdout1_175ck460 FIND v(dout1_175) AT=470.05n

.meas tran vdout1_176ck460 FIND v(dout1_176) AT=470.05n

.meas tran vdout1_177ck460 FIND v(dout1_177) AT=470.05n

.meas tran vdout1_178ck460 FIND v(dout1_178) AT=470.05n

.meas tran vdout1_179ck460 FIND v(dout1_179) AT=470.05n

.meas tran vdout1_180ck460 FIND v(dout1_180) AT=470.05n

.meas tran vdout1_181ck460 FIND v(dout1_181) AT=470.05n

.meas tran vdout1_182ck460 FIND v(dout1_182) AT=470.05n

.meas tran vdout1_183ck460 FIND v(dout1_183) AT=470.05n

.meas tran vdout1_184ck460 FIND v(dout1_184) AT=470.05n

.meas tran vdout1_185ck460 FIND v(dout1_185) AT=470.05n

.meas tran vdout1_186ck460 FIND v(dout1_186) AT=470.05n

.meas tran vdout1_187ck460 FIND v(dout1_187) AT=470.05n

.meas tran vdout1_188ck460 FIND v(dout1_188) AT=470.05n

.meas tran vdout1_189ck460 FIND v(dout1_189) AT=470.05n

.meas tran vdout1_190ck460 FIND v(dout1_190) AT=470.05n

.meas tran vdout1_191ck460 FIND v(dout1_191) AT=470.05n

.meas tran vdout1_192ck460 FIND v(dout1_192) AT=470.05n

.meas tran vdout1_193ck460 FIND v(dout1_193) AT=470.05n

.meas tran vdout1_194ck460 FIND v(dout1_194) AT=470.05n

.meas tran vdout1_195ck460 FIND v(dout1_195) AT=470.05n

.meas tran vdout1_196ck460 FIND v(dout1_196) AT=470.05n

.meas tran vdout1_197ck460 FIND v(dout1_197) AT=470.05n

.meas tran vdout1_198ck460 FIND v(dout1_198) AT=470.05n

.meas tran vdout1_199ck460 FIND v(dout1_199) AT=470.05n

.meas tran vdout1_200ck460 FIND v(dout1_200) AT=470.05n

.meas tran vdout1_201ck460 FIND v(dout1_201) AT=470.05n

.meas tran vdout1_202ck460 FIND v(dout1_202) AT=470.05n

.meas tran vdout1_203ck460 FIND v(dout1_203) AT=470.05n

.meas tran vdout1_204ck460 FIND v(dout1_204) AT=470.05n

.meas tran vdout1_205ck460 FIND v(dout1_205) AT=470.05n

.meas tran vdout1_206ck460 FIND v(dout1_206) AT=470.05n

.meas tran vdout1_207ck460 FIND v(dout1_207) AT=470.05n

.meas tran vdout1_208ck460 FIND v(dout1_208) AT=470.05n

.meas tran vdout1_209ck460 FIND v(dout1_209) AT=470.05n

.meas tran vdout1_210ck460 FIND v(dout1_210) AT=470.05n

.meas tran vdout1_211ck460 FIND v(dout1_211) AT=470.05n

.meas tran vdout1_212ck460 FIND v(dout1_212) AT=470.05n

.meas tran vdout1_213ck460 FIND v(dout1_213) AT=470.05n

.meas tran vdout1_214ck460 FIND v(dout1_214) AT=470.05n

.meas tran vdout1_215ck460 FIND v(dout1_215) AT=470.05n

.meas tran vdout1_216ck460 FIND v(dout1_216) AT=470.05n

.meas tran vdout1_217ck460 FIND v(dout1_217) AT=470.05n

.meas tran vdout1_218ck460 FIND v(dout1_218) AT=470.05n

.meas tran vdout1_219ck460 FIND v(dout1_219) AT=470.05n

.meas tran vdout1_220ck460 FIND v(dout1_220) AT=470.05n

.meas tran vdout1_221ck460 FIND v(dout1_221) AT=470.05n

.meas tran vdout1_222ck460 FIND v(dout1_222) AT=470.05n

.meas tran vdout1_223ck460 FIND v(dout1_223) AT=470.05n

.meas tran vdout1_224ck460 FIND v(dout1_224) AT=470.05n

.meas tran vdout1_225ck460 FIND v(dout1_225) AT=470.05n

.meas tran vdout1_226ck460 FIND v(dout1_226) AT=470.05n

.meas tran vdout1_227ck460 FIND v(dout1_227) AT=470.05n

.meas tran vdout1_228ck460 FIND v(dout1_228) AT=470.05n

.meas tran vdout1_229ck460 FIND v(dout1_229) AT=470.05n

.meas tran vdout1_230ck460 FIND v(dout1_230) AT=470.05n

.meas tran vdout1_231ck460 FIND v(dout1_231) AT=470.05n

.meas tran vdout1_232ck460 FIND v(dout1_232) AT=470.05n

.meas tran vdout1_233ck460 FIND v(dout1_233) AT=470.05n

.meas tran vdout1_234ck460 FIND v(dout1_234) AT=470.05n

.meas tran vdout1_235ck460 FIND v(dout1_235) AT=470.05n

.meas tran vdout1_236ck460 FIND v(dout1_236) AT=470.05n

.meas tran vdout1_237ck460 FIND v(dout1_237) AT=470.05n

.meas tran vdout1_238ck460 FIND v(dout1_238) AT=470.05n

.meas tran vdout1_239ck460 FIND v(dout1_239) AT=470.05n

.meas tran vdout1_240ck460 FIND v(dout1_240) AT=470.05n

.meas tran vdout1_241ck460 FIND v(dout1_241) AT=470.05n

.meas tran vdout1_242ck460 FIND v(dout1_242) AT=470.05n

.meas tran vdout1_243ck460 FIND v(dout1_243) AT=470.05n

.meas tran vdout1_244ck460 FIND v(dout1_244) AT=470.05n

.meas tran vdout1_245ck460 FIND v(dout1_245) AT=470.05n

.meas tran vdout1_246ck460 FIND v(dout1_246) AT=470.05n

.meas tran vdout1_247ck460 FIND v(dout1_247) AT=470.05n

.meas tran vdout1_248ck460 FIND v(dout1_248) AT=470.05n

.meas tran vdout1_249ck460 FIND v(dout1_249) AT=470.05n

.meas tran vdout1_250ck460 FIND v(dout1_250) AT=470.05n

.meas tran vdout1_251ck460 FIND v(dout1_251) AT=470.05n

.meas tran vdout1_252ck460 FIND v(dout1_252) AT=470.05n

.meas tran vdout1_253ck460 FIND v(dout1_253) AT=470.05n

.meas tran vdout1_254ck460 FIND v(dout1_254) AT=470.05n

.meas tran vdout1_255ck460 FIND v(dout1_255) AT=470.05n

.meas tran vdout1_256ck460 FIND v(dout1_256) AT=470.05n

.meas tran vdout1_0ck490 FIND v(dout1_0) AT=500.05n

.meas tran vdout1_1ck490 FIND v(dout1_1) AT=500.05n

.meas tran vdout1_2ck490 FIND v(dout1_2) AT=500.05n

.meas tran vdout1_3ck490 FIND v(dout1_3) AT=500.05n

.meas tran vdout1_4ck490 FIND v(dout1_4) AT=500.05n

.meas tran vdout1_5ck490 FIND v(dout1_5) AT=500.05n

.meas tran vdout1_6ck490 FIND v(dout1_6) AT=500.05n

.meas tran vdout1_7ck490 FIND v(dout1_7) AT=500.05n

.meas tran vdout1_8ck490 FIND v(dout1_8) AT=500.05n

.meas tran vdout1_9ck490 FIND v(dout1_9) AT=500.05n

.meas tran vdout1_10ck490 FIND v(dout1_10) AT=500.05n

.meas tran vdout1_11ck490 FIND v(dout1_11) AT=500.05n

.meas tran vdout1_12ck490 FIND v(dout1_12) AT=500.05n

.meas tran vdout1_13ck490 FIND v(dout1_13) AT=500.05n

.meas tran vdout1_14ck490 FIND v(dout1_14) AT=500.05n

.meas tran vdout1_15ck490 FIND v(dout1_15) AT=500.05n

.meas tran vdout1_16ck490 FIND v(dout1_16) AT=500.05n

.meas tran vdout1_17ck490 FIND v(dout1_17) AT=500.05n

.meas tran vdout1_18ck490 FIND v(dout1_18) AT=500.05n

.meas tran vdout1_19ck490 FIND v(dout1_19) AT=500.05n

.meas tran vdout1_20ck490 FIND v(dout1_20) AT=500.05n

.meas tran vdout1_21ck490 FIND v(dout1_21) AT=500.05n

.meas tran vdout1_22ck490 FIND v(dout1_22) AT=500.05n

.meas tran vdout1_23ck490 FIND v(dout1_23) AT=500.05n

.meas tran vdout1_24ck490 FIND v(dout1_24) AT=500.05n

.meas tran vdout1_25ck490 FIND v(dout1_25) AT=500.05n

.meas tran vdout1_26ck490 FIND v(dout1_26) AT=500.05n

.meas tran vdout1_27ck490 FIND v(dout1_27) AT=500.05n

.meas tran vdout1_28ck490 FIND v(dout1_28) AT=500.05n

.meas tran vdout1_29ck490 FIND v(dout1_29) AT=500.05n

.meas tran vdout1_30ck490 FIND v(dout1_30) AT=500.05n

.meas tran vdout1_31ck490 FIND v(dout1_31) AT=500.05n

.meas tran vdout1_32ck490 FIND v(dout1_32) AT=500.05n

.meas tran vdout1_33ck490 FIND v(dout1_33) AT=500.05n

.meas tran vdout1_34ck490 FIND v(dout1_34) AT=500.05n

.meas tran vdout1_35ck490 FIND v(dout1_35) AT=500.05n

.meas tran vdout1_36ck490 FIND v(dout1_36) AT=500.05n

.meas tran vdout1_37ck490 FIND v(dout1_37) AT=500.05n

.meas tran vdout1_38ck490 FIND v(dout1_38) AT=500.05n

.meas tran vdout1_39ck490 FIND v(dout1_39) AT=500.05n

.meas tran vdout1_40ck490 FIND v(dout1_40) AT=500.05n

.meas tran vdout1_41ck490 FIND v(dout1_41) AT=500.05n

.meas tran vdout1_42ck490 FIND v(dout1_42) AT=500.05n

.meas tran vdout1_43ck490 FIND v(dout1_43) AT=500.05n

.meas tran vdout1_44ck490 FIND v(dout1_44) AT=500.05n

.meas tran vdout1_45ck490 FIND v(dout1_45) AT=500.05n

.meas tran vdout1_46ck490 FIND v(dout1_46) AT=500.05n

.meas tran vdout1_47ck490 FIND v(dout1_47) AT=500.05n

.meas tran vdout1_48ck490 FIND v(dout1_48) AT=500.05n

.meas tran vdout1_49ck490 FIND v(dout1_49) AT=500.05n

.meas tran vdout1_50ck490 FIND v(dout1_50) AT=500.05n

.meas tran vdout1_51ck490 FIND v(dout1_51) AT=500.05n

.meas tran vdout1_52ck490 FIND v(dout1_52) AT=500.05n

.meas tran vdout1_53ck490 FIND v(dout1_53) AT=500.05n

.meas tran vdout1_54ck490 FIND v(dout1_54) AT=500.05n

.meas tran vdout1_55ck490 FIND v(dout1_55) AT=500.05n

.meas tran vdout1_56ck490 FIND v(dout1_56) AT=500.05n

.meas tran vdout1_57ck490 FIND v(dout1_57) AT=500.05n

.meas tran vdout1_58ck490 FIND v(dout1_58) AT=500.05n

.meas tran vdout1_59ck490 FIND v(dout1_59) AT=500.05n

.meas tran vdout1_60ck490 FIND v(dout1_60) AT=500.05n

.meas tran vdout1_61ck490 FIND v(dout1_61) AT=500.05n

.meas tran vdout1_62ck490 FIND v(dout1_62) AT=500.05n

.meas tran vdout1_63ck490 FIND v(dout1_63) AT=500.05n

.meas tran vdout1_64ck490 FIND v(dout1_64) AT=500.05n

.meas tran vdout1_65ck490 FIND v(dout1_65) AT=500.05n

.meas tran vdout1_66ck490 FIND v(dout1_66) AT=500.05n

.meas tran vdout1_67ck490 FIND v(dout1_67) AT=500.05n

.meas tran vdout1_68ck490 FIND v(dout1_68) AT=500.05n

.meas tran vdout1_69ck490 FIND v(dout1_69) AT=500.05n

.meas tran vdout1_70ck490 FIND v(dout1_70) AT=500.05n

.meas tran vdout1_71ck490 FIND v(dout1_71) AT=500.05n

.meas tran vdout1_72ck490 FIND v(dout1_72) AT=500.05n

.meas tran vdout1_73ck490 FIND v(dout1_73) AT=500.05n

.meas tran vdout1_74ck490 FIND v(dout1_74) AT=500.05n

.meas tran vdout1_75ck490 FIND v(dout1_75) AT=500.05n

.meas tran vdout1_76ck490 FIND v(dout1_76) AT=500.05n

.meas tran vdout1_77ck490 FIND v(dout1_77) AT=500.05n

.meas tran vdout1_78ck490 FIND v(dout1_78) AT=500.05n

.meas tran vdout1_79ck490 FIND v(dout1_79) AT=500.05n

.meas tran vdout1_80ck490 FIND v(dout1_80) AT=500.05n

.meas tran vdout1_81ck490 FIND v(dout1_81) AT=500.05n

.meas tran vdout1_82ck490 FIND v(dout1_82) AT=500.05n

.meas tran vdout1_83ck490 FIND v(dout1_83) AT=500.05n

.meas tran vdout1_84ck490 FIND v(dout1_84) AT=500.05n

.meas tran vdout1_85ck490 FIND v(dout1_85) AT=500.05n

.meas tran vdout1_86ck490 FIND v(dout1_86) AT=500.05n

.meas tran vdout1_87ck490 FIND v(dout1_87) AT=500.05n

.meas tran vdout1_88ck490 FIND v(dout1_88) AT=500.05n

.meas tran vdout1_89ck490 FIND v(dout1_89) AT=500.05n

.meas tran vdout1_90ck490 FIND v(dout1_90) AT=500.05n

.meas tran vdout1_91ck490 FIND v(dout1_91) AT=500.05n

.meas tran vdout1_92ck490 FIND v(dout1_92) AT=500.05n

.meas tran vdout1_93ck490 FIND v(dout1_93) AT=500.05n

.meas tran vdout1_94ck490 FIND v(dout1_94) AT=500.05n

.meas tran vdout1_95ck490 FIND v(dout1_95) AT=500.05n

.meas tran vdout1_96ck490 FIND v(dout1_96) AT=500.05n

.meas tran vdout1_97ck490 FIND v(dout1_97) AT=500.05n

.meas tran vdout1_98ck490 FIND v(dout1_98) AT=500.05n

.meas tran vdout1_99ck490 FIND v(dout1_99) AT=500.05n

.meas tran vdout1_100ck490 FIND v(dout1_100) AT=500.05n

.meas tran vdout1_101ck490 FIND v(dout1_101) AT=500.05n

.meas tran vdout1_102ck490 FIND v(dout1_102) AT=500.05n

.meas tran vdout1_103ck490 FIND v(dout1_103) AT=500.05n

.meas tran vdout1_104ck490 FIND v(dout1_104) AT=500.05n

.meas tran vdout1_105ck490 FIND v(dout1_105) AT=500.05n

.meas tran vdout1_106ck490 FIND v(dout1_106) AT=500.05n

.meas tran vdout1_107ck490 FIND v(dout1_107) AT=500.05n

.meas tran vdout1_108ck490 FIND v(dout1_108) AT=500.05n

.meas tran vdout1_109ck490 FIND v(dout1_109) AT=500.05n

.meas tran vdout1_110ck490 FIND v(dout1_110) AT=500.05n

.meas tran vdout1_111ck490 FIND v(dout1_111) AT=500.05n

.meas tran vdout1_112ck490 FIND v(dout1_112) AT=500.05n

.meas tran vdout1_113ck490 FIND v(dout1_113) AT=500.05n

.meas tran vdout1_114ck490 FIND v(dout1_114) AT=500.05n

.meas tran vdout1_115ck490 FIND v(dout1_115) AT=500.05n

.meas tran vdout1_116ck490 FIND v(dout1_116) AT=500.05n

.meas tran vdout1_117ck490 FIND v(dout1_117) AT=500.05n

.meas tran vdout1_118ck490 FIND v(dout1_118) AT=500.05n

.meas tran vdout1_119ck490 FIND v(dout1_119) AT=500.05n

.meas tran vdout1_120ck490 FIND v(dout1_120) AT=500.05n

.meas tran vdout1_121ck490 FIND v(dout1_121) AT=500.05n

.meas tran vdout1_122ck490 FIND v(dout1_122) AT=500.05n

.meas tran vdout1_123ck490 FIND v(dout1_123) AT=500.05n

.meas tran vdout1_124ck490 FIND v(dout1_124) AT=500.05n

.meas tran vdout1_125ck490 FIND v(dout1_125) AT=500.05n

.meas tran vdout1_126ck490 FIND v(dout1_126) AT=500.05n

.meas tran vdout1_127ck490 FIND v(dout1_127) AT=500.05n

.meas tran vdout1_128ck490 FIND v(dout1_128) AT=500.05n

.meas tran vdout1_129ck490 FIND v(dout1_129) AT=500.05n

.meas tran vdout1_130ck490 FIND v(dout1_130) AT=500.05n

.meas tran vdout1_131ck490 FIND v(dout1_131) AT=500.05n

.meas tran vdout1_132ck490 FIND v(dout1_132) AT=500.05n

.meas tran vdout1_133ck490 FIND v(dout1_133) AT=500.05n

.meas tran vdout1_134ck490 FIND v(dout1_134) AT=500.05n

.meas tran vdout1_135ck490 FIND v(dout1_135) AT=500.05n

.meas tran vdout1_136ck490 FIND v(dout1_136) AT=500.05n

.meas tran vdout1_137ck490 FIND v(dout1_137) AT=500.05n

.meas tran vdout1_138ck490 FIND v(dout1_138) AT=500.05n

.meas tran vdout1_139ck490 FIND v(dout1_139) AT=500.05n

.meas tran vdout1_140ck490 FIND v(dout1_140) AT=500.05n

.meas tran vdout1_141ck490 FIND v(dout1_141) AT=500.05n

.meas tran vdout1_142ck490 FIND v(dout1_142) AT=500.05n

.meas tran vdout1_143ck490 FIND v(dout1_143) AT=500.05n

.meas tran vdout1_144ck490 FIND v(dout1_144) AT=500.05n

.meas tran vdout1_145ck490 FIND v(dout1_145) AT=500.05n

.meas tran vdout1_146ck490 FIND v(dout1_146) AT=500.05n

.meas tran vdout1_147ck490 FIND v(dout1_147) AT=500.05n

.meas tran vdout1_148ck490 FIND v(dout1_148) AT=500.05n

.meas tran vdout1_149ck490 FIND v(dout1_149) AT=500.05n

.meas tran vdout1_150ck490 FIND v(dout1_150) AT=500.05n

.meas tran vdout1_151ck490 FIND v(dout1_151) AT=500.05n

.meas tran vdout1_152ck490 FIND v(dout1_152) AT=500.05n

.meas tran vdout1_153ck490 FIND v(dout1_153) AT=500.05n

.meas tran vdout1_154ck490 FIND v(dout1_154) AT=500.05n

.meas tran vdout1_155ck490 FIND v(dout1_155) AT=500.05n

.meas tran vdout1_156ck490 FIND v(dout1_156) AT=500.05n

.meas tran vdout1_157ck490 FIND v(dout1_157) AT=500.05n

.meas tran vdout1_158ck490 FIND v(dout1_158) AT=500.05n

.meas tran vdout1_159ck490 FIND v(dout1_159) AT=500.05n

.meas tran vdout1_160ck490 FIND v(dout1_160) AT=500.05n

.meas tran vdout1_161ck490 FIND v(dout1_161) AT=500.05n

.meas tran vdout1_162ck490 FIND v(dout1_162) AT=500.05n

.meas tran vdout1_163ck490 FIND v(dout1_163) AT=500.05n

.meas tran vdout1_164ck490 FIND v(dout1_164) AT=500.05n

.meas tran vdout1_165ck490 FIND v(dout1_165) AT=500.05n

.meas tran vdout1_166ck490 FIND v(dout1_166) AT=500.05n

.meas tran vdout1_167ck490 FIND v(dout1_167) AT=500.05n

.meas tran vdout1_168ck490 FIND v(dout1_168) AT=500.05n

.meas tran vdout1_169ck490 FIND v(dout1_169) AT=500.05n

.meas tran vdout1_170ck490 FIND v(dout1_170) AT=500.05n

.meas tran vdout1_171ck490 FIND v(dout1_171) AT=500.05n

.meas tran vdout1_172ck490 FIND v(dout1_172) AT=500.05n

.meas tran vdout1_173ck490 FIND v(dout1_173) AT=500.05n

.meas tran vdout1_174ck490 FIND v(dout1_174) AT=500.05n

.meas tran vdout1_175ck490 FIND v(dout1_175) AT=500.05n

.meas tran vdout1_176ck490 FIND v(dout1_176) AT=500.05n

.meas tran vdout1_177ck490 FIND v(dout1_177) AT=500.05n

.meas tran vdout1_178ck490 FIND v(dout1_178) AT=500.05n

.meas tran vdout1_179ck490 FIND v(dout1_179) AT=500.05n

.meas tran vdout1_180ck490 FIND v(dout1_180) AT=500.05n

.meas tran vdout1_181ck490 FIND v(dout1_181) AT=500.05n

.meas tran vdout1_182ck490 FIND v(dout1_182) AT=500.05n

.meas tran vdout1_183ck490 FIND v(dout1_183) AT=500.05n

.meas tran vdout1_184ck490 FIND v(dout1_184) AT=500.05n

.meas tran vdout1_185ck490 FIND v(dout1_185) AT=500.05n

.meas tran vdout1_186ck490 FIND v(dout1_186) AT=500.05n

.meas tran vdout1_187ck490 FIND v(dout1_187) AT=500.05n

.meas tran vdout1_188ck490 FIND v(dout1_188) AT=500.05n

.meas tran vdout1_189ck490 FIND v(dout1_189) AT=500.05n

.meas tran vdout1_190ck490 FIND v(dout1_190) AT=500.05n

.meas tran vdout1_191ck490 FIND v(dout1_191) AT=500.05n

.meas tran vdout1_192ck490 FIND v(dout1_192) AT=500.05n

.meas tran vdout1_193ck490 FIND v(dout1_193) AT=500.05n

.meas tran vdout1_194ck490 FIND v(dout1_194) AT=500.05n

.meas tran vdout1_195ck490 FIND v(dout1_195) AT=500.05n

.meas tran vdout1_196ck490 FIND v(dout1_196) AT=500.05n

.meas tran vdout1_197ck490 FIND v(dout1_197) AT=500.05n

.meas tran vdout1_198ck490 FIND v(dout1_198) AT=500.05n

.meas tran vdout1_199ck490 FIND v(dout1_199) AT=500.05n

.meas tran vdout1_200ck490 FIND v(dout1_200) AT=500.05n

.meas tran vdout1_201ck490 FIND v(dout1_201) AT=500.05n

.meas tran vdout1_202ck490 FIND v(dout1_202) AT=500.05n

.meas tran vdout1_203ck490 FIND v(dout1_203) AT=500.05n

.meas tran vdout1_204ck490 FIND v(dout1_204) AT=500.05n

.meas tran vdout1_205ck490 FIND v(dout1_205) AT=500.05n

.meas tran vdout1_206ck490 FIND v(dout1_206) AT=500.05n

.meas tran vdout1_207ck490 FIND v(dout1_207) AT=500.05n

.meas tran vdout1_208ck490 FIND v(dout1_208) AT=500.05n

.meas tran vdout1_209ck490 FIND v(dout1_209) AT=500.05n

.meas tran vdout1_210ck490 FIND v(dout1_210) AT=500.05n

.meas tran vdout1_211ck490 FIND v(dout1_211) AT=500.05n

.meas tran vdout1_212ck490 FIND v(dout1_212) AT=500.05n

.meas tran vdout1_213ck490 FIND v(dout1_213) AT=500.05n

.meas tran vdout1_214ck490 FIND v(dout1_214) AT=500.05n

.meas tran vdout1_215ck490 FIND v(dout1_215) AT=500.05n

.meas tran vdout1_216ck490 FIND v(dout1_216) AT=500.05n

.meas tran vdout1_217ck490 FIND v(dout1_217) AT=500.05n

.meas tran vdout1_218ck490 FIND v(dout1_218) AT=500.05n

.meas tran vdout1_219ck490 FIND v(dout1_219) AT=500.05n

.meas tran vdout1_220ck490 FIND v(dout1_220) AT=500.05n

.meas tran vdout1_221ck490 FIND v(dout1_221) AT=500.05n

.meas tran vdout1_222ck490 FIND v(dout1_222) AT=500.05n

.meas tran vdout1_223ck490 FIND v(dout1_223) AT=500.05n

.meas tran vdout1_224ck490 FIND v(dout1_224) AT=500.05n

.meas tran vdout1_225ck490 FIND v(dout1_225) AT=500.05n

.meas tran vdout1_226ck490 FIND v(dout1_226) AT=500.05n

.meas tran vdout1_227ck490 FIND v(dout1_227) AT=500.05n

.meas tran vdout1_228ck490 FIND v(dout1_228) AT=500.05n

.meas tran vdout1_229ck490 FIND v(dout1_229) AT=500.05n

.meas tran vdout1_230ck490 FIND v(dout1_230) AT=500.05n

.meas tran vdout1_231ck490 FIND v(dout1_231) AT=500.05n

.meas tran vdout1_232ck490 FIND v(dout1_232) AT=500.05n

.meas tran vdout1_233ck490 FIND v(dout1_233) AT=500.05n

.meas tran vdout1_234ck490 FIND v(dout1_234) AT=500.05n

.meas tran vdout1_235ck490 FIND v(dout1_235) AT=500.05n

.meas tran vdout1_236ck490 FIND v(dout1_236) AT=500.05n

.meas tran vdout1_237ck490 FIND v(dout1_237) AT=500.05n

.meas tran vdout1_238ck490 FIND v(dout1_238) AT=500.05n

.meas tran vdout1_239ck490 FIND v(dout1_239) AT=500.05n

.meas tran vdout1_240ck490 FIND v(dout1_240) AT=500.05n

.meas tran vdout1_241ck490 FIND v(dout1_241) AT=500.05n

.meas tran vdout1_242ck490 FIND v(dout1_242) AT=500.05n

.meas tran vdout1_243ck490 FIND v(dout1_243) AT=500.05n

.meas tran vdout1_244ck490 FIND v(dout1_244) AT=500.05n

.meas tran vdout1_245ck490 FIND v(dout1_245) AT=500.05n

.meas tran vdout1_246ck490 FIND v(dout1_246) AT=500.05n

.meas tran vdout1_247ck490 FIND v(dout1_247) AT=500.05n

.meas tran vdout1_248ck490 FIND v(dout1_248) AT=500.05n

.meas tran vdout1_249ck490 FIND v(dout1_249) AT=500.05n

.meas tran vdout1_250ck490 FIND v(dout1_250) AT=500.05n

.meas tran vdout1_251ck490 FIND v(dout1_251) AT=500.05n

.meas tran vdout1_252ck490 FIND v(dout1_252) AT=500.05n

.meas tran vdout1_253ck490 FIND v(dout1_253) AT=500.05n

.meas tran vdout1_254ck490 FIND v(dout1_254) AT=500.05n

.meas tran vdout1_255ck490 FIND v(dout1_255) AT=500.05n

.meas tran vdout1_256ck490 FIND v(dout1_256) AT=500.05n

.meas tran vdout1_0ck500 FIND v(dout1_0) AT=510.05n

.meas tran vdout1_1ck500 FIND v(dout1_1) AT=510.05n

.meas tran vdout1_2ck500 FIND v(dout1_2) AT=510.05n

.meas tran vdout1_3ck500 FIND v(dout1_3) AT=510.05n

.meas tran vdout1_4ck500 FIND v(dout1_4) AT=510.05n

.meas tran vdout1_5ck500 FIND v(dout1_5) AT=510.05n

.meas tran vdout1_6ck500 FIND v(dout1_6) AT=510.05n

.meas tran vdout1_7ck500 FIND v(dout1_7) AT=510.05n

.meas tran vdout1_8ck500 FIND v(dout1_8) AT=510.05n

.meas tran vdout1_9ck500 FIND v(dout1_9) AT=510.05n

.meas tran vdout1_10ck500 FIND v(dout1_10) AT=510.05n

.meas tran vdout1_11ck500 FIND v(dout1_11) AT=510.05n

.meas tran vdout1_12ck500 FIND v(dout1_12) AT=510.05n

.meas tran vdout1_13ck500 FIND v(dout1_13) AT=510.05n

.meas tran vdout1_14ck500 FIND v(dout1_14) AT=510.05n

.meas tran vdout1_15ck500 FIND v(dout1_15) AT=510.05n

.meas tran vdout1_16ck500 FIND v(dout1_16) AT=510.05n

.meas tran vdout1_17ck500 FIND v(dout1_17) AT=510.05n

.meas tran vdout1_18ck500 FIND v(dout1_18) AT=510.05n

.meas tran vdout1_19ck500 FIND v(dout1_19) AT=510.05n

.meas tran vdout1_20ck500 FIND v(dout1_20) AT=510.05n

.meas tran vdout1_21ck500 FIND v(dout1_21) AT=510.05n

.meas tran vdout1_22ck500 FIND v(dout1_22) AT=510.05n

.meas tran vdout1_23ck500 FIND v(dout1_23) AT=510.05n

.meas tran vdout1_24ck500 FIND v(dout1_24) AT=510.05n

.meas tran vdout1_25ck500 FIND v(dout1_25) AT=510.05n

.meas tran vdout1_26ck500 FIND v(dout1_26) AT=510.05n

.meas tran vdout1_27ck500 FIND v(dout1_27) AT=510.05n

.meas tran vdout1_28ck500 FIND v(dout1_28) AT=510.05n

.meas tran vdout1_29ck500 FIND v(dout1_29) AT=510.05n

.meas tran vdout1_30ck500 FIND v(dout1_30) AT=510.05n

.meas tran vdout1_31ck500 FIND v(dout1_31) AT=510.05n

.meas tran vdout1_32ck500 FIND v(dout1_32) AT=510.05n

.meas tran vdout1_33ck500 FIND v(dout1_33) AT=510.05n

.meas tran vdout1_34ck500 FIND v(dout1_34) AT=510.05n

.meas tran vdout1_35ck500 FIND v(dout1_35) AT=510.05n

.meas tran vdout1_36ck500 FIND v(dout1_36) AT=510.05n

.meas tran vdout1_37ck500 FIND v(dout1_37) AT=510.05n

.meas tran vdout1_38ck500 FIND v(dout1_38) AT=510.05n

.meas tran vdout1_39ck500 FIND v(dout1_39) AT=510.05n

.meas tran vdout1_40ck500 FIND v(dout1_40) AT=510.05n

.meas tran vdout1_41ck500 FIND v(dout1_41) AT=510.05n

.meas tran vdout1_42ck500 FIND v(dout1_42) AT=510.05n

.meas tran vdout1_43ck500 FIND v(dout1_43) AT=510.05n

.meas tran vdout1_44ck500 FIND v(dout1_44) AT=510.05n

.meas tran vdout1_45ck500 FIND v(dout1_45) AT=510.05n

.meas tran vdout1_46ck500 FIND v(dout1_46) AT=510.05n

.meas tran vdout1_47ck500 FIND v(dout1_47) AT=510.05n

.meas tran vdout1_48ck500 FIND v(dout1_48) AT=510.05n

.meas tran vdout1_49ck500 FIND v(dout1_49) AT=510.05n

.meas tran vdout1_50ck500 FIND v(dout1_50) AT=510.05n

.meas tran vdout1_51ck500 FIND v(dout1_51) AT=510.05n

.meas tran vdout1_52ck500 FIND v(dout1_52) AT=510.05n

.meas tran vdout1_53ck500 FIND v(dout1_53) AT=510.05n

.meas tran vdout1_54ck500 FIND v(dout1_54) AT=510.05n

.meas tran vdout1_55ck500 FIND v(dout1_55) AT=510.05n

.meas tran vdout1_56ck500 FIND v(dout1_56) AT=510.05n

.meas tran vdout1_57ck500 FIND v(dout1_57) AT=510.05n

.meas tran vdout1_58ck500 FIND v(dout1_58) AT=510.05n

.meas tran vdout1_59ck500 FIND v(dout1_59) AT=510.05n

.meas tran vdout1_60ck500 FIND v(dout1_60) AT=510.05n

.meas tran vdout1_61ck500 FIND v(dout1_61) AT=510.05n

.meas tran vdout1_62ck500 FIND v(dout1_62) AT=510.05n

.meas tran vdout1_63ck500 FIND v(dout1_63) AT=510.05n

.meas tran vdout1_64ck500 FIND v(dout1_64) AT=510.05n

.meas tran vdout1_65ck500 FIND v(dout1_65) AT=510.05n

.meas tran vdout1_66ck500 FIND v(dout1_66) AT=510.05n

.meas tran vdout1_67ck500 FIND v(dout1_67) AT=510.05n

.meas tran vdout1_68ck500 FIND v(dout1_68) AT=510.05n

.meas tran vdout1_69ck500 FIND v(dout1_69) AT=510.05n

.meas tran vdout1_70ck500 FIND v(dout1_70) AT=510.05n

.meas tran vdout1_71ck500 FIND v(dout1_71) AT=510.05n

.meas tran vdout1_72ck500 FIND v(dout1_72) AT=510.05n

.meas tran vdout1_73ck500 FIND v(dout1_73) AT=510.05n

.meas tran vdout1_74ck500 FIND v(dout1_74) AT=510.05n

.meas tran vdout1_75ck500 FIND v(dout1_75) AT=510.05n

.meas tran vdout1_76ck500 FIND v(dout1_76) AT=510.05n

.meas tran vdout1_77ck500 FIND v(dout1_77) AT=510.05n

.meas tran vdout1_78ck500 FIND v(dout1_78) AT=510.05n

.meas tran vdout1_79ck500 FIND v(dout1_79) AT=510.05n

.meas tran vdout1_80ck500 FIND v(dout1_80) AT=510.05n

.meas tran vdout1_81ck500 FIND v(dout1_81) AT=510.05n

.meas tran vdout1_82ck500 FIND v(dout1_82) AT=510.05n

.meas tran vdout1_83ck500 FIND v(dout1_83) AT=510.05n

.meas tran vdout1_84ck500 FIND v(dout1_84) AT=510.05n

.meas tran vdout1_85ck500 FIND v(dout1_85) AT=510.05n

.meas tran vdout1_86ck500 FIND v(dout1_86) AT=510.05n

.meas tran vdout1_87ck500 FIND v(dout1_87) AT=510.05n

.meas tran vdout1_88ck500 FIND v(dout1_88) AT=510.05n

.meas tran vdout1_89ck500 FIND v(dout1_89) AT=510.05n

.meas tran vdout1_90ck500 FIND v(dout1_90) AT=510.05n

.meas tran vdout1_91ck500 FIND v(dout1_91) AT=510.05n

.meas tran vdout1_92ck500 FIND v(dout1_92) AT=510.05n

.meas tran vdout1_93ck500 FIND v(dout1_93) AT=510.05n

.meas tran vdout1_94ck500 FIND v(dout1_94) AT=510.05n

.meas tran vdout1_95ck500 FIND v(dout1_95) AT=510.05n

.meas tran vdout1_96ck500 FIND v(dout1_96) AT=510.05n

.meas tran vdout1_97ck500 FIND v(dout1_97) AT=510.05n

.meas tran vdout1_98ck500 FIND v(dout1_98) AT=510.05n

.meas tran vdout1_99ck500 FIND v(dout1_99) AT=510.05n

.meas tran vdout1_100ck500 FIND v(dout1_100) AT=510.05n

.meas tran vdout1_101ck500 FIND v(dout1_101) AT=510.05n

.meas tran vdout1_102ck500 FIND v(dout1_102) AT=510.05n

.meas tran vdout1_103ck500 FIND v(dout1_103) AT=510.05n

.meas tran vdout1_104ck500 FIND v(dout1_104) AT=510.05n

.meas tran vdout1_105ck500 FIND v(dout1_105) AT=510.05n

.meas tran vdout1_106ck500 FIND v(dout1_106) AT=510.05n

.meas tran vdout1_107ck500 FIND v(dout1_107) AT=510.05n

.meas tran vdout1_108ck500 FIND v(dout1_108) AT=510.05n

.meas tran vdout1_109ck500 FIND v(dout1_109) AT=510.05n

.meas tran vdout1_110ck500 FIND v(dout1_110) AT=510.05n

.meas tran vdout1_111ck500 FIND v(dout1_111) AT=510.05n

.meas tran vdout1_112ck500 FIND v(dout1_112) AT=510.05n

.meas tran vdout1_113ck500 FIND v(dout1_113) AT=510.05n

.meas tran vdout1_114ck500 FIND v(dout1_114) AT=510.05n

.meas tran vdout1_115ck500 FIND v(dout1_115) AT=510.05n

.meas tran vdout1_116ck500 FIND v(dout1_116) AT=510.05n

.meas tran vdout1_117ck500 FIND v(dout1_117) AT=510.05n

.meas tran vdout1_118ck500 FIND v(dout1_118) AT=510.05n

.meas tran vdout1_119ck500 FIND v(dout1_119) AT=510.05n

.meas tran vdout1_120ck500 FIND v(dout1_120) AT=510.05n

.meas tran vdout1_121ck500 FIND v(dout1_121) AT=510.05n

.meas tran vdout1_122ck500 FIND v(dout1_122) AT=510.05n

.meas tran vdout1_123ck500 FIND v(dout1_123) AT=510.05n

.meas tran vdout1_124ck500 FIND v(dout1_124) AT=510.05n

.meas tran vdout1_125ck500 FIND v(dout1_125) AT=510.05n

.meas tran vdout1_126ck500 FIND v(dout1_126) AT=510.05n

.meas tran vdout1_127ck500 FIND v(dout1_127) AT=510.05n

.meas tran vdout1_128ck500 FIND v(dout1_128) AT=510.05n

.meas tran vdout1_129ck500 FIND v(dout1_129) AT=510.05n

.meas tran vdout1_130ck500 FIND v(dout1_130) AT=510.05n

.meas tran vdout1_131ck500 FIND v(dout1_131) AT=510.05n

.meas tran vdout1_132ck500 FIND v(dout1_132) AT=510.05n

.meas tran vdout1_133ck500 FIND v(dout1_133) AT=510.05n

.meas tran vdout1_134ck500 FIND v(dout1_134) AT=510.05n

.meas tran vdout1_135ck500 FIND v(dout1_135) AT=510.05n

.meas tran vdout1_136ck500 FIND v(dout1_136) AT=510.05n

.meas tran vdout1_137ck500 FIND v(dout1_137) AT=510.05n

.meas tran vdout1_138ck500 FIND v(dout1_138) AT=510.05n

.meas tran vdout1_139ck500 FIND v(dout1_139) AT=510.05n

.meas tran vdout1_140ck500 FIND v(dout1_140) AT=510.05n

.meas tran vdout1_141ck500 FIND v(dout1_141) AT=510.05n

.meas tran vdout1_142ck500 FIND v(dout1_142) AT=510.05n

.meas tran vdout1_143ck500 FIND v(dout1_143) AT=510.05n

.meas tran vdout1_144ck500 FIND v(dout1_144) AT=510.05n

.meas tran vdout1_145ck500 FIND v(dout1_145) AT=510.05n

.meas tran vdout1_146ck500 FIND v(dout1_146) AT=510.05n

.meas tran vdout1_147ck500 FIND v(dout1_147) AT=510.05n

.meas tran vdout1_148ck500 FIND v(dout1_148) AT=510.05n

.meas tran vdout1_149ck500 FIND v(dout1_149) AT=510.05n

.meas tran vdout1_150ck500 FIND v(dout1_150) AT=510.05n

.meas tran vdout1_151ck500 FIND v(dout1_151) AT=510.05n

.meas tran vdout1_152ck500 FIND v(dout1_152) AT=510.05n

.meas tran vdout1_153ck500 FIND v(dout1_153) AT=510.05n

.meas tran vdout1_154ck500 FIND v(dout1_154) AT=510.05n

.meas tran vdout1_155ck500 FIND v(dout1_155) AT=510.05n

.meas tran vdout1_156ck500 FIND v(dout1_156) AT=510.05n

.meas tran vdout1_157ck500 FIND v(dout1_157) AT=510.05n

.meas tran vdout1_158ck500 FIND v(dout1_158) AT=510.05n

.meas tran vdout1_159ck500 FIND v(dout1_159) AT=510.05n

.meas tran vdout1_160ck500 FIND v(dout1_160) AT=510.05n

.meas tran vdout1_161ck500 FIND v(dout1_161) AT=510.05n

.meas tran vdout1_162ck500 FIND v(dout1_162) AT=510.05n

.meas tran vdout1_163ck500 FIND v(dout1_163) AT=510.05n

.meas tran vdout1_164ck500 FIND v(dout1_164) AT=510.05n

.meas tran vdout1_165ck500 FIND v(dout1_165) AT=510.05n

.meas tran vdout1_166ck500 FIND v(dout1_166) AT=510.05n

.meas tran vdout1_167ck500 FIND v(dout1_167) AT=510.05n

.meas tran vdout1_168ck500 FIND v(dout1_168) AT=510.05n

.meas tran vdout1_169ck500 FIND v(dout1_169) AT=510.05n

.meas tran vdout1_170ck500 FIND v(dout1_170) AT=510.05n

.meas tran vdout1_171ck500 FIND v(dout1_171) AT=510.05n

.meas tran vdout1_172ck500 FIND v(dout1_172) AT=510.05n

.meas tran vdout1_173ck500 FIND v(dout1_173) AT=510.05n

.meas tran vdout1_174ck500 FIND v(dout1_174) AT=510.05n

.meas tran vdout1_175ck500 FIND v(dout1_175) AT=510.05n

.meas tran vdout1_176ck500 FIND v(dout1_176) AT=510.05n

.meas tran vdout1_177ck500 FIND v(dout1_177) AT=510.05n

.meas tran vdout1_178ck500 FIND v(dout1_178) AT=510.05n

.meas tran vdout1_179ck500 FIND v(dout1_179) AT=510.05n

.meas tran vdout1_180ck500 FIND v(dout1_180) AT=510.05n

.meas tran vdout1_181ck500 FIND v(dout1_181) AT=510.05n

.meas tran vdout1_182ck500 FIND v(dout1_182) AT=510.05n

.meas tran vdout1_183ck500 FIND v(dout1_183) AT=510.05n

.meas tran vdout1_184ck500 FIND v(dout1_184) AT=510.05n

.meas tran vdout1_185ck500 FIND v(dout1_185) AT=510.05n

.meas tran vdout1_186ck500 FIND v(dout1_186) AT=510.05n

.meas tran vdout1_187ck500 FIND v(dout1_187) AT=510.05n

.meas tran vdout1_188ck500 FIND v(dout1_188) AT=510.05n

.meas tran vdout1_189ck500 FIND v(dout1_189) AT=510.05n

.meas tran vdout1_190ck500 FIND v(dout1_190) AT=510.05n

.meas tran vdout1_191ck500 FIND v(dout1_191) AT=510.05n

.meas tran vdout1_192ck500 FIND v(dout1_192) AT=510.05n

.meas tran vdout1_193ck500 FIND v(dout1_193) AT=510.05n

.meas tran vdout1_194ck500 FIND v(dout1_194) AT=510.05n

.meas tran vdout1_195ck500 FIND v(dout1_195) AT=510.05n

.meas tran vdout1_196ck500 FIND v(dout1_196) AT=510.05n

.meas tran vdout1_197ck500 FIND v(dout1_197) AT=510.05n

.meas tran vdout1_198ck500 FIND v(dout1_198) AT=510.05n

.meas tran vdout1_199ck500 FIND v(dout1_199) AT=510.05n

.meas tran vdout1_200ck500 FIND v(dout1_200) AT=510.05n

.meas tran vdout1_201ck500 FIND v(dout1_201) AT=510.05n

.meas tran vdout1_202ck500 FIND v(dout1_202) AT=510.05n

.meas tran vdout1_203ck500 FIND v(dout1_203) AT=510.05n

.meas tran vdout1_204ck500 FIND v(dout1_204) AT=510.05n

.meas tran vdout1_205ck500 FIND v(dout1_205) AT=510.05n

.meas tran vdout1_206ck500 FIND v(dout1_206) AT=510.05n

.meas tran vdout1_207ck500 FIND v(dout1_207) AT=510.05n

.meas tran vdout1_208ck500 FIND v(dout1_208) AT=510.05n

.meas tran vdout1_209ck500 FIND v(dout1_209) AT=510.05n

.meas tran vdout1_210ck500 FIND v(dout1_210) AT=510.05n

.meas tran vdout1_211ck500 FIND v(dout1_211) AT=510.05n

.meas tran vdout1_212ck500 FIND v(dout1_212) AT=510.05n

.meas tran vdout1_213ck500 FIND v(dout1_213) AT=510.05n

.meas tran vdout1_214ck500 FIND v(dout1_214) AT=510.05n

.meas tran vdout1_215ck500 FIND v(dout1_215) AT=510.05n

.meas tran vdout1_216ck500 FIND v(dout1_216) AT=510.05n

.meas tran vdout1_217ck500 FIND v(dout1_217) AT=510.05n

.meas tran vdout1_218ck500 FIND v(dout1_218) AT=510.05n

.meas tran vdout1_219ck500 FIND v(dout1_219) AT=510.05n

.meas tran vdout1_220ck500 FIND v(dout1_220) AT=510.05n

.meas tran vdout1_221ck500 FIND v(dout1_221) AT=510.05n

.meas tran vdout1_222ck500 FIND v(dout1_222) AT=510.05n

.meas tran vdout1_223ck500 FIND v(dout1_223) AT=510.05n

.meas tran vdout1_224ck500 FIND v(dout1_224) AT=510.05n

.meas tran vdout1_225ck500 FIND v(dout1_225) AT=510.05n

.meas tran vdout1_226ck500 FIND v(dout1_226) AT=510.05n

.meas tran vdout1_227ck500 FIND v(dout1_227) AT=510.05n

.meas tran vdout1_228ck500 FIND v(dout1_228) AT=510.05n

.meas tran vdout1_229ck500 FIND v(dout1_229) AT=510.05n

.meas tran vdout1_230ck500 FIND v(dout1_230) AT=510.05n

.meas tran vdout1_231ck500 FIND v(dout1_231) AT=510.05n

.meas tran vdout1_232ck500 FIND v(dout1_232) AT=510.05n

.meas tran vdout1_233ck500 FIND v(dout1_233) AT=510.05n

.meas tran vdout1_234ck500 FIND v(dout1_234) AT=510.05n

.meas tran vdout1_235ck500 FIND v(dout1_235) AT=510.05n

.meas tran vdout1_236ck500 FIND v(dout1_236) AT=510.05n

.meas tran vdout1_237ck500 FIND v(dout1_237) AT=510.05n

.meas tran vdout1_238ck500 FIND v(dout1_238) AT=510.05n

.meas tran vdout1_239ck500 FIND v(dout1_239) AT=510.05n

.meas tran vdout1_240ck500 FIND v(dout1_240) AT=510.05n

.meas tran vdout1_241ck500 FIND v(dout1_241) AT=510.05n

.meas tran vdout1_242ck500 FIND v(dout1_242) AT=510.05n

.meas tran vdout1_243ck500 FIND v(dout1_243) AT=510.05n

.meas tran vdout1_244ck500 FIND v(dout1_244) AT=510.05n

.meas tran vdout1_245ck500 FIND v(dout1_245) AT=510.05n

.meas tran vdout1_246ck500 FIND v(dout1_246) AT=510.05n

.meas tran vdout1_247ck500 FIND v(dout1_247) AT=510.05n

.meas tran vdout1_248ck500 FIND v(dout1_248) AT=510.05n

.meas tran vdout1_249ck500 FIND v(dout1_249) AT=510.05n

.meas tran vdout1_250ck500 FIND v(dout1_250) AT=510.05n

.meas tran vdout1_251ck500 FIND v(dout1_251) AT=510.05n

.meas tran vdout1_252ck500 FIND v(dout1_252) AT=510.05n

.meas tran vdout1_253ck500 FIND v(dout1_253) AT=510.05n

.meas tran vdout1_254ck500 FIND v(dout1_254) AT=510.05n

.meas tran vdout1_255ck500 FIND v(dout1_255) AT=510.05n

.meas tran vdout1_256ck500 FIND v(dout1_256) AT=510.05n

.meas tran vdout1_0ck510 FIND v(dout1_0) AT=520.05n

.meas tran vdout1_1ck510 FIND v(dout1_1) AT=520.05n

.meas tran vdout1_2ck510 FIND v(dout1_2) AT=520.05n

.meas tran vdout1_3ck510 FIND v(dout1_3) AT=520.05n

.meas tran vdout1_4ck510 FIND v(dout1_4) AT=520.05n

.meas tran vdout1_5ck510 FIND v(dout1_5) AT=520.05n

.meas tran vdout1_6ck510 FIND v(dout1_6) AT=520.05n

.meas tran vdout1_7ck510 FIND v(dout1_7) AT=520.05n

.meas tran vdout1_8ck510 FIND v(dout1_8) AT=520.05n

.meas tran vdout1_9ck510 FIND v(dout1_9) AT=520.05n

.meas tran vdout1_10ck510 FIND v(dout1_10) AT=520.05n

.meas tran vdout1_11ck510 FIND v(dout1_11) AT=520.05n

.meas tran vdout1_12ck510 FIND v(dout1_12) AT=520.05n

.meas tran vdout1_13ck510 FIND v(dout1_13) AT=520.05n

.meas tran vdout1_14ck510 FIND v(dout1_14) AT=520.05n

.meas tran vdout1_15ck510 FIND v(dout1_15) AT=520.05n

.meas tran vdout1_16ck510 FIND v(dout1_16) AT=520.05n

.meas tran vdout1_17ck510 FIND v(dout1_17) AT=520.05n

.meas tran vdout1_18ck510 FIND v(dout1_18) AT=520.05n

.meas tran vdout1_19ck510 FIND v(dout1_19) AT=520.05n

.meas tran vdout1_20ck510 FIND v(dout1_20) AT=520.05n

.meas tran vdout1_21ck510 FIND v(dout1_21) AT=520.05n

.meas tran vdout1_22ck510 FIND v(dout1_22) AT=520.05n

.meas tran vdout1_23ck510 FIND v(dout1_23) AT=520.05n

.meas tran vdout1_24ck510 FIND v(dout1_24) AT=520.05n

.meas tran vdout1_25ck510 FIND v(dout1_25) AT=520.05n

.meas tran vdout1_26ck510 FIND v(dout1_26) AT=520.05n

.meas tran vdout1_27ck510 FIND v(dout1_27) AT=520.05n

.meas tran vdout1_28ck510 FIND v(dout1_28) AT=520.05n

.meas tran vdout1_29ck510 FIND v(dout1_29) AT=520.05n

.meas tran vdout1_30ck510 FIND v(dout1_30) AT=520.05n

.meas tran vdout1_31ck510 FIND v(dout1_31) AT=520.05n

.meas tran vdout1_32ck510 FIND v(dout1_32) AT=520.05n

.meas tran vdout1_33ck510 FIND v(dout1_33) AT=520.05n

.meas tran vdout1_34ck510 FIND v(dout1_34) AT=520.05n

.meas tran vdout1_35ck510 FIND v(dout1_35) AT=520.05n

.meas tran vdout1_36ck510 FIND v(dout1_36) AT=520.05n

.meas tran vdout1_37ck510 FIND v(dout1_37) AT=520.05n

.meas tran vdout1_38ck510 FIND v(dout1_38) AT=520.05n

.meas tran vdout1_39ck510 FIND v(dout1_39) AT=520.05n

.meas tran vdout1_40ck510 FIND v(dout1_40) AT=520.05n

.meas tran vdout1_41ck510 FIND v(dout1_41) AT=520.05n

.meas tran vdout1_42ck510 FIND v(dout1_42) AT=520.05n

.meas tran vdout1_43ck510 FIND v(dout1_43) AT=520.05n

.meas tran vdout1_44ck510 FIND v(dout1_44) AT=520.05n

.meas tran vdout1_45ck510 FIND v(dout1_45) AT=520.05n

.meas tran vdout1_46ck510 FIND v(dout1_46) AT=520.05n

.meas tran vdout1_47ck510 FIND v(dout1_47) AT=520.05n

.meas tran vdout1_48ck510 FIND v(dout1_48) AT=520.05n

.meas tran vdout1_49ck510 FIND v(dout1_49) AT=520.05n

.meas tran vdout1_50ck510 FIND v(dout1_50) AT=520.05n

.meas tran vdout1_51ck510 FIND v(dout1_51) AT=520.05n

.meas tran vdout1_52ck510 FIND v(dout1_52) AT=520.05n

.meas tran vdout1_53ck510 FIND v(dout1_53) AT=520.05n

.meas tran vdout1_54ck510 FIND v(dout1_54) AT=520.05n

.meas tran vdout1_55ck510 FIND v(dout1_55) AT=520.05n

.meas tran vdout1_56ck510 FIND v(dout1_56) AT=520.05n

.meas tran vdout1_57ck510 FIND v(dout1_57) AT=520.05n

.meas tran vdout1_58ck510 FIND v(dout1_58) AT=520.05n

.meas tran vdout1_59ck510 FIND v(dout1_59) AT=520.05n

.meas tran vdout1_60ck510 FIND v(dout1_60) AT=520.05n

.meas tran vdout1_61ck510 FIND v(dout1_61) AT=520.05n

.meas tran vdout1_62ck510 FIND v(dout1_62) AT=520.05n

.meas tran vdout1_63ck510 FIND v(dout1_63) AT=520.05n

.meas tran vdout1_64ck510 FIND v(dout1_64) AT=520.05n

.meas tran vdout1_65ck510 FIND v(dout1_65) AT=520.05n

.meas tran vdout1_66ck510 FIND v(dout1_66) AT=520.05n

.meas tran vdout1_67ck510 FIND v(dout1_67) AT=520.05n

.meas tran vdout1_68ck510 FIND v(dout1_68) AT=520.05n

.meas tran vdout1_69ck510 FIND v(dout1_69) AT=520.05n

.meas tran vdout1_70ck510 FIND v(dout1_70) AT=520.05n

.meas tran vdout1_71ck510 FIND v(dout1_71) AT=520.05n

.meas tran vdout1_72ck510 FIND v(dout1_72) AT=520.05n

.meas tran vdout1_73ck510 FIND v(dout1_73) AT=520.05n

.meas tran vdout1_74ck510 FIND v(dout1_74) AT=520.05n

.meas tran vdout1_75ck510 FIND v(dout1_75) AT=520.05n

.meas tran vdout1_76ck510 FIND v(dout1_76) AT=520.05n

.meas tran vdout1_77ck510 FIND v(dout1_77) AT=520.05n

.meas tran vdout1_78ck510 FIND v(dout1_78) AT=520.05n

.meas tran vdout1_79ck510 FIND v(dout1_79) AT=520.05n

.meas tran vdout1_80ck510 FIND v(dout1_80) AT=520.05n

.meas tran vdout1_81ck510 FIND v(dout1_81) AT=520.05n

.meas tran vdout1_82ck510 FIND v(dout1_82) AT=520.05n

.meas tran vdout1_83ck510 FIND v(dout1_83) AT=520.05n

.meas tran vdout1_84ck510 FIND v(dout1_84) AT=520.05n

.meas tran vdout1_85ck510 FIND v(dout1_85) AT=520.05n

.meas tran vdout1_86ck510 FIND v(dout1_86) AT=520.05n

.meas tran vdout1_87ck510 FIND v(dout1_87) AT=520.05n

.meas tran vdout1_88ck510 FIND v(dout1_88) AT=520.05n

.meas tran vdout1_89ck510 FIND v(dout1_89) AT=520.05n

.meas tran vdout1_90ck510 FIND v(dout1_90) AT=520.05n

.meas tran vdout1_91ck510 FIND v(dout1_91) AT=520.05n

.meas tran vdout1_92ck510 FIND v(dout1_92) AT=520.05n

.meas tran vdout1_93ck510 FIND v(dout1_93) AT=520.05n

.meas tran vdout1_94ck510 FIND v(dout1_94) AT=520.05n

.meas tran vdout1_95ck510 FIND v(dout1_95) AT=520.05n

.meas tran vdout1_96ck510 FIND v(dout1_96) AT=520.05n

.meas tran vdout1_97ck510 FIND v(dout1_97) AT=520.05n

.meas tran vdout1_98ck510 FIND v(dout1_98) AT=520.05n

.meas tran vdout1_99ck510 FIND v(dout1_99) AT=520.05n

.meas tran vdout1_100ck510 FIND v(dout1_100) AT=520.05n

.meas tran vdout1_101ck510 FIND v(dout1_101) AT=520.05n

.meas tran vdout1_102ck510 FIND v(dout1_102) AT=520.05n

.meas tran vdout1_103ck510 FIND v(dout1_103) AT=520.05n

.meas tran vdout1_104ck510 FIND v(dout1_104) AT=520.05n

.meas tran vdout1_105ck510 FIND v(dout1_105) AT=520.05n

.meas tran vdout1_106ck510 FIND v(dout1_106) AT=520.05n

.meas tran vdout1_107ck510 FIND v(dout1_107) AT=520.05n

.meas tran vdout1_108ck510 FIND v(dout1_108) AT=520.05n

.meas tran vdout1_109ck510 FIND v(dout1_109) AT=520.05n

.meas tran vdout1_110ck510 FIND v(dout1_110) AT=520.05n

.meas tran vdout1_111ck510 FIND v(dout1_111) AT=520.05n

.meas tran vdout1_112ck510 FIND v(dout1_112) AT=520.05n

.meas tran vdout1_113ck510 FIND v(dout1_113) AT=520.05n

.meas tran vdout1_114ck510 FIND v(dout1_114) AT=520.05n

.meas tran vdout1_115ck510 FIND v(dout1_115) AT=520.05n

.meas tran vdout1_116ck510 FIND v(dout1_116) AT=520.05n

.meas tran vdout1_117ck510 FIND v(dout1_117) AT=520.05n

.meas tran vdout1_118ck510 FIND v(dout1_118) AT=520.05n

.meas tran vdout1_119ck510 FIND v(dout1_119) AT=520.05n

.meas tran vdout1_120ck510 FIND v(dout1_120) AT=520.05n

.meas tran vdout1_121ck510 FIND v(dout1_121) AT=520.05n

.meas tran vdout1_122ck510 FIND v(dout1_122) AT=520.05n

.meas tran vdout1_123ck510 FIND v(dout1_123) AT=520.05n

.meas tran vdout1_124ck510 FIND v(dout1_124) AT=520.05n

.meas tran vdout1_125ck510 FIND v(dout1_125) AT=520.05n

.meas tran vdout1_126ck510 FIND v(dout1_126) AT=520.05n

.meas tran vdout1_127ck510 FIND v(dout1_127) AT=520.05n

.meas tran vdout1_128ck510 FIND v(dout1_128) AT=520.05n

.meas tran vdout1_129ck510 FIND v(dout1_129) AT=520.05n

.meas tran vdout1_130ck510 FIND v(dout1_130) AT=520.05n

.meas tran vdout1_131ck510 FIND v(dout1_131) AT=520.05n

.meas tran vdout1_132ck510 FIND v(dout1_132) AT=520.05n

.meas tran vdout1_133ck510 FIND v(dout1_133) AT=520.05n

.meas tran vdout1_134ck510 FIND v(dout1_134) AT=520.05n

.meas tran vdout1_135ck510 FIND v(dout1_135) AT=520.05n

.meas tran vdout1_136ck510 FIND v(dout1_136) AT=520.05n

.meas tran vdout1_137ck510 FIND v(dout1_137) AT=520.05n

.meas tran vdout1_138ck510 FIND v(dout1_138) AT=520.05n

.meas tran vdout1_139ck510 FIND v(dout1_139) AT=520.05n

.meas tran vdout1_140ck510 FIND v(dout1_140) AT=520.05n

.meas tran vdout1_141ck510 FIND v(dout1_141) AT=520.05n

.meas tran vdout1_142ck510 FIND v(dout1_142) AT=520.05n

.meas tran vdout1_143ck510 FIND v(dout1_143) AT=520.05n

.meas tran vdout1_144ck510 FIND v(dout1_144) AT=520.05n

.meas tran vdout1_145ck510 FIND v(dout1_145) AT=520.05n

.meas tran vdout1_146ck510 FIND v(dout1_146) AT=520.05n

.meas tran vdout1_147ck510 FIND v(dout1_147) AT=520.05n

.meas tran vdout1_148ck510 FIND v(dout1_148) AT=520.05n

.meas tran vdout1_149ck510 FIND v(dout1_149) AT=520.05n

.meas tran vdout1_150ck510 FIND v(dout1_150) AT=520.05n

.meas tran vdout1_151ck510 FIND v(dout1_151) AT=520.05n

.meas tran vdout1_152ck510 FIND v(dout1_152) AT=520.05n

.meas tran vdout1_153ck510 FIND v(dout1_153) AT=520.05n

.meas tran vdout1_154ck510 FIND v(dout1_154) AT=520.05n

.meas tran vdout1_155ck510 FIND v(dout1_155) AT=520.05n

.meas tran vdout1_156ck510 FIND v(dout1_156) AT=520.05n

.meas tran vdout1_157ck510 FIND v(dout1_157) AT=520.05n

.meas tran vdout1_158ck510 FIND v(dout1_158) AT=520.05n

.meas tran vdout1_159ck510 FIND v(dout1_159) AT=520.05n

.meas tran vdout1_160ck510 FIND v(dout1_160) AT=520.05n

.meas tran vdout1_161ck510 FIND v(dout1_161) AT=520.05n

.meas tran vdout1_162ck510 FIND v(dout1_162) AT=520.05n

.meas tran vdout1_163ck510 FIND v(dout1_163) AT=520.05n

.meas tran vdout1_164ck510 FIND v(dout1_164) AT=520.05n

.meas tran vdout1_165ck510 FIND v(dout1_165) AT=520.05n

.meas tran vdout1_166ck510 FIND v(dout1_166) AT=520.05n

.meas tran vdout1_167ck510 FIND v(dout1_167) AT=520.05n

.meas tran vdout1_168ck510 FIND v(dout1_168) AT=520.05n

.meas tran vdout1_169ck510 FIND v(dout1_169) AT=520.05n

.meas tran vdout1_170ck510 FIND v(dout1_170) AT=520.05n

.meas tran vdout1_171ck510 FIND v(dout1_171) AT=520.05n

.meas tran vdout1_172ck510 FIND v(dout1_172) AT=520.05n

.meas tran vdout1_173ck510 FIND v(dout1_173) AT=520.05n

.meas tran vdout1_174ck510 FIND v(dout1_174) AT=520.05n

.meas tran vdout1_175ck510 FIND v(dout1_175) AT=520.05n

.meas tran vdout1_176ck510 FIND v(dout1_176) AT=520.05n

.meas tran vdout1_177ck510 FIND v(dout1_177) AT=520.05n

.meas tran vdout1_178ck510 FIND v(dout1_178) AT=520.05n

.meas tran vdout1_179ck510 FIND v(dout1_179) AT=520.05n

.meas tran vdout1_180ck510 FIND v(dout1_180) AT=520.05n

.meas tran vdout1_181ck510 FIND v(dout1_181) AT=520.05n

.meas tran vdout1_182ck510 FIND v(dout1_182) AT=520.05n

.meas tran vdout1_183ck510 FIND v(dout1_183) AT=520.05n

.meas tran vdout1_184ck510 FIND v(dout1_184) AT=520.05n

.meas tran vdout1_185ck510 FIND v(dout1_185) AT=520.05n

.meas tran vdout1_186ck510 FIND v(dout1_186) AT=520.05n

.meas tran vdout1_187ck510 FIND v(dout1_187) AT=520.05n

.meas tran vdout1_188ck510 FIND v(dout1_188) AT=520.05n

.meas tran vdout1_189ck510 FIND v(dout1_189) AT=520.05n

.meas tran vdout1_190ck510 FIND v(dout1_190) AT=520.05n

.meas tran vdout1_191ck510 FIND v(dout1_191) AT=520.05n

.meas tran vdout1_192ck510 FIND v(dout1_192) AT=520.05n

.meas tran vdout1_193ck510 FIND v(dout1_193) AT=520.05n

.meas tran vdout1_194ck510 FIND v(dout1_194) AT=520.05n

.meas tran vdout1_195ck510 FIND v(dout1_195) AT=520.05n

.meas tran vdout1_196ck510 FIND v(dout1_196) AT=520.05n

.meas tran vdout1_197ck510 FIND v(dout1_197) AT=520.05n

.meas tran vdout1_198ck510 FIND v(dout1_198) AT=520.05n

.meas tran vdout1_199ck510 FIND v(dout1_199) AT=520.05n

.meas tran vdout1_200ck510 FIND v(dout1_200) AT=520.05n

.meas tran vdout1_201ck510 FIND v(dout1_201) AT=520.05n

.meas tran vdout1_202ck510 FIND v(dout1_202) AT=520.05n

.meas tran vdout1_203ck510 FIND v(dout1_203) AT=520.05n

.meas tran vdout1_204ck510 FIND v(dout1_204) AT=520.05n

.meas tran vdout1_205ck510 FIND v(dout1_205) AT=520.05n

.meas tran vdout1_206ck510 FIND v(dout1_206) AT=520.05n

.meas tran vdout1_207ck510 FIND v(dout1_207) AT=520.05n

.meas tran vdout1_208ck510 FIND v(dout1_208) AT=520.05n

.meas tran vdout1_209ck510 FIND v(dout1_209) AT=520.05n

.meas tran vdout1_210ck510 FIND v(dout1_210) AT=520.05n

.meas tran vdout1_211ck510 FIND v(dout1_211) AT=520.05n

.meas tran vdout1_212ck510 FIND v(dout1_212) AT=520.05n

.meas tran vdout1_213ck510 FIND v(dout1_213) AT=520.05n

.meas tran vdout1_214ck510 FIND v(dout1_214) AT=520.05n

.meas tran vdout1_215ck510 FIND v(dout1_215) AT=520.05n

.meas tran vdout1_216ck510 FIND v(dout1_216) AT=520.05n

.meas tran vdout1_217ck510 FIND v(dout1_217) AT=520.05n

.meas tran vdout1_218ck510 FIND v(dout1_218) AT=520.05n

.meas tran vdout1_219ck510 FIND v(dout1_219) AT=520.05n

.meas tran vdout1_220ck510 FIND v(dout1_220) AT=520.05n

.meas tran vdout1_221ck510 FIND v(dout1_221) AT=520.05n

.meas tran vdout1_222ck510 FIND v(dout1_222) AT=520.05n

.meas tran vdout1_223ck510 FIND v(dout1_223) AT=520.05n

.meas tran vdout1_224ck510 FIND v(dout1_224) AT=520.05n

.meas tran vdout1_225ck510 FIND v(dout1_225) AT=520.05n

.meas tran vdout1_226ck510 FIND v(dout1_226) AT=520.05n

.meas tran vdout1_227ck510 FIND v(dout1_227) AT=520.05n

.meas tran vdout1_228ck510 FIND v(dout1_228) AT=520.05n

.meas tran vdout1_229ck510 FIND v(dout1_229) AT=520.05n

.meas tran vdout1_230ck510 FIND v(dout1_230) AT=520.05n

.meas tran vdout1_231ck510 FIND v(dout1_231) AT=520.05n

.meas tran vdout1_232ck510 FIND v(dout1_232) AT=520.05n

.meas tran vdout1_233ck510 FIND v(dout1_233) AT=520.05n

.meas tran vdout1_234ck510 FIND v(dout1_234) AT=520.05n

.meas tran vdout1_235ck510 FIND v(dout1_235) AT=520.05n

.meas tran vdout1_236ck510 FIND v(dout1_236) AT=520.05n

.meas tran vdout1_237ck510 FIND v(dout1_237) AT=520.05n

.meas tran vdout1_238ck510 FIND v(dout1_238) AT=520.05n

.meas tran vdout1_239ck510 FIND v(dout1_239) AT=520.05n

.meas tran vdout1_240ck510 FIND v(dout1_240) AT=520.05n

.meas tran vdout1_241ck510 FIND v(dout1_241) AT=520.05n

.meas tran vdout1_242ck510 FIND v(dout1_242) AT=520.05n

.meas tran vdout1_243ck510 FIND v(dout1_243) AT=520.05n

.meas tran vdout1_244ck510 FIND v(dout1_244) AT=520.05n

.meas tran vdout1_245ck510 FIND v(dout1_245) AT=520.05n

.meas tran vdout1_246ck510 FIND v(dout1_246) AT=520.05n

.meas tran vdout1_247ck510 FIND v(dout1_247) AT=520.05n

.meas tran vdout1_248ck510 FIND v(dout1_248) AT=520.05n

.meas tran vdout1_249ck510 FIND v(dout1_249) AT=520.05n

.meas tran vdout1_250ck510 FIND v(dout1_250) AT=520.05n

.meas tran vdout1_251ck510 FIND v(dout1_251) AT=520.05n

.meas tran vdout1_252ck510 FIND v(dout1_252) AT=520.05n

.meas tran vdout1_253ck510 FIND v(dout1_253) AT=520.05n

.meas tran vdout1_254ck510 FIND v(dout1_254) AT=520.05n

.meas tran vdout1_255ck510 FIND v(dout1_255) AT=520.05n

.meas tran vdout1_256ck510 FIND v(dout1_256) AT=520.05n

.meas tran vdout1_0ck540 FIND v(dout1_0) AT=550.05n

.meas tran vdout1_1ck540 FIND v(dout1_1) AT=550.05n

.meas tran vdout1_2ck540 FIND v(dout1_2) AT=550.05n

.meas tran vdout1_3ck540 FIND v(dout1_3) AT=550.05n

.meas tran vdout1_4ck540 FIND v(dout1_4) AT=550.05n

.meas tran vdout1_5ck540 FIND v(dout1_5) AT=550.05n

.meas tran vdout1_6ck540 FIND v(dout1_6) AT=550.05n

.meas tran vdout1_7ck540 FIND v(dout1_7) AT=550.05n

.meas tran vdout1_8ck540 FIND v(dout1_8) AT=550.05n

.meas tran vdout1_9ck540 FIND v(dout1_9) AT=550.05n

.meas tran vdout1_10ck540 FIND v(dout1_10) AT=550.05n

.meas tran vdout1_11ck540 FIND v(dout1_11) AT=550.05n

.meas tran vdout1_12ck540 FIND v(dout1_12) AT=550.05n

.meas tran vdout1_13ck540 FIND v(dout1_13) AT=550.05n

.meas tran vdout1_14ck540 FIND v(dout1_14) AT=550.05n

.meas tran vdout1_15ck540 FIND v(dout1_15) AT=550.05n

.meas tran vdout1_16ck540 FIND v(dout1_16) AT=550.05n

.meas tran vdout1_17ck540 FIND v(dout1_17) AT=550.05n

.meas tran vdout1_18ck540 FIND v(dout1_18) AT=550.05n

.meas tran vdout1_19ck540 FIND v(dout1_19) AT=550.05n

.meas tran vdout1_20ck540 FIND v(dout1_20) AT=550.05n

.meas tran vdout1_21ck540 FIND v(dout1_21) AT=550.05n

.meas tran vdout1_22ck540 FIND v(dout1_22) AT=550.05n

.meas tran vdout1_23ck540 FIND v(dout1_23) AT=550.05n

.meas tran vdout1_24ck540 FIND v(dout1_24) AT=550.05n

.meas tran vdout1_25ck540 FIND v(dout1_25) AT=550.05n

.meas tran vdout1_26ck540 FIND v(dout1_26) AT=550.05n

.meas tran vdout1_27ck540 FIND v(dout1_27) AT=550.05n

.meas tran vdout1_28ck540 FIND v(dout1_28) AT=550.05n

.meas tran vdout1_29ck540 FIND v(dout1_29) AT=550.05n

.meas tran vdout1_30ck540 FIND v(dout1_30) AT=550.05n

.meas tran vdout1_31ck540 FIND v(dout1_31) AT=550.05n

.meas tran vdout1_32ck540 FIND v(dout1_32) AT=550.05n

.meas tran vdout1_33ck540 FIND v(dout1_33) AT=550.05n

.meas tran vdout1_34ck540 FIND v(dout1_34) AT=550.05n

.meas tran vdout1_35ck540 FIND v(dout1_35) AT=550.05n

.meas tran vdout1_36ck540 FIND v(dout1_36) AT=550.05n

.meas tran vdout1_37ck540 FIND v(dout1_37) AT=550.05n

.meas tran vdout1_38ck540 FIND v(dout1_38) AT=550.05n

.meas tran vdout1_39ck540 FIND v(dout1_39) AT=550.05n

.meas tran vdout1_40ck540 FIND v(dout1_40) AT=550.05n

.meas tran vdout1_41ck540 FIND v(dout1_41) AT=550.05n

.meas tran vdout1_42ck540 FIND v(dout1_42) AT=550.05n

.meas tran vdout1_43ck540 FIND v(dout1_43) AT=550.05n

.meas tran vdout1_44ck540 FIND v(dout1_44) AT=550.05n

.meas tran vdout1_45ck540 FIND v(dout1_45) AT=550.05n

.meas tran vdout1_46ck540 FIND v(dout1_46) AT=550.05n

.meas tran vdout1_47ck540 FIND v(dout1_47) AT=550.05n

.meas tran vdout1_48ck540 FIND v(dout1_48) AT=550.05n

.meas tran vdout1_49ck540 FIND v(dout1_49) AT=550.05n

.meas tran vdout1_50ck540 FIND v(dout1_50) AT=550.05n

.meas tran vdout1_51ck540 FIND v(dout1_51) AT=550.05n

.meas tran vdout1_52ck540 FIND v(dout1_52) AT=550.05n

.meas tran vdout1_53ck540 FIND v(dout1_53) AT=550.05n

.meas tran vdout1_54ck540 FIND v(dout1_54) AT=550.05n

.meas tran vdout1_55ck540 FIND v(dout1_55) AT=550.05n

.meas tran vdout1_56ck540 FIND v(dout1_56) AT=550.05n

.meas tran vdout1_57ck540 FIND v(dout1_57) AT=550.05n

.meas tran vdout1_58ck540 FIND v(dout1_58) AT=550.05n

.meas tran vdout1_59ck540 FIND v(dout1_59) AT=550.05n

.meas tran vdout1_60ck540 FIND v(dout1_60) AT=550.05n

.meas tran vdout1_61ck540 FIND v(dout1_61) AT=550.05n

.meas tran vdout1_62ck540 FIND v(dout1_62) AT=550.05n

.meas tran vdout1_63ck540 FIND v(dout1_63) AT=550.05n

.meas tran vdout1_64ck540 FIND v(dout1_64) AT=550.05n

.meas tran vdout1_65ck540 FIND v(dout1_65) AT=550.05n

.meas tran vdout1_66ck540 FIND v(dout1_66) AT=550.05n

.meas tran vdout1_67ck540 FIND v(dout1_67) AT=550.05n

.meas tran vdout1_68ck540 FIND v(dout1_68) AT=550.05n

.meas tran vdout1_69ck540 FIND v(dout1_69) AT=550.05n

.meas tran vdout1_70ck540 FIND v(dout1_70) AT=550.05n

.meas tran vdout1_71ck540 FIND v(dout1_71) AT=550.05n

.meas tran vdout1_72ck540 FIND v(dout1_72) AT=550.05n

.meas tran vdout1_73ck540 FIND v(dout1_73) AT=550.05n

.meas tran vdout1_74ck540 FIND v(dout1_74) AT=550.05n

.meas tran vdout1_75ck540 FIND v(dout1_75) AT=550.05n

.meas tran vdout1_76ck540 FIND v(dout1_76) AT=550.05n

.meas tran vdout1_77ck540 FIND v(dout1_77) AT=550.05n

.meas tran vdout1_78ck540 FIND v(dout1_78) AT=550.05n

.meas tran vdout1_79ck540 FIND v(dout1_79) AT=550.05n

.meas tran vdout1_80ck540 FIND v(dout1_80) AT=550.05n

.meas tran vdout1_81ck540 FIND v(dout1_81) AT=550.05n

.meas tran vdout1_82ck540 FIND v(dout1_82) AT=550.05n

.meas tran vdout1_83ck540 FIND v(dout1_83) AT=550.05n

.meas tran vdout1_84ck540 FIND v(dout1_84) AT=550.05n

.meas tran vdout1_85ck540 FIND v(dout1_85) AT=550.05n

.meas tran vdout1_86ck540 FIND v(dout1_86) AT=550.05n

.meas tran vdout1_87ck540 FIND v(dout1_87) AT=550.05n

.meas tran vdout1_88ck540 FIND v(dout1_88) AT=550.05n

.meas tran vdout1_89ck540 FIND v(dout1_89) AT=550.05n

.meas tran vdout1_90ck540 FIND v(dout1_90) AT=550.05n

.meas tran vdout1_91ck540 FIND v(dout1_91) AT=550.05n

.meas tran vdout1_92ck540 FIND v(dout1_92) AT=550.05n

.meas tran vdout1_93ck540 FIND v(dout1_93) AT=550.05n

.meas tran vdout1_94ck540 FIND v(dout1_94) AT=550.05n

.meas tran vdout1_95ck540 FIND v(dout1_95) AT=550.05n

.meas tran vdout1_96ck540 FIND v(dout1_96) AT=550.05n

.meas tran vdout1_97ck540 FIND v(dout1_97) AT=550.05n

.meas tran vdout1_98ck540 FIND v(dout1_98) AT=550.05n

.meas tran vdout1_99ck540 FIND v(dout1_99) AT=550.05n

.meas tran vdout1_100ck540 FIND v(dout1_100) AT=550.05n

.meas tran vdout1_101ck540 FIND v(dout1_101) AT=550.05n

.meas tran vdout1_102ck540 FIND v(dout1_102) AT=550.05n

.meas tran vdout1_103ck540 FIND v(dout1_103) AT=550.05n

.meas tran vdout1_104ck540 FIND v(dout1_104) AT=550.05n

.meas tran vdout1_105ck540 FIND v(dout1_105) AT=550.05n

.meas tran vdout1_106ck540 FIND v(dout1_106) AT=550.05n

.meas tran vdout1_107ck540 FIND v(dout1_107) AT=550.05n

.meas tran vdout1_108ck540 FIND v(dout1_108) AT=550.05n

.meas tran vdout1_109ck540 FIND v(dout1_109) AT=550.05n

.meas tran vdout1_110ck540 FIND v(dout1_110) AT=550.05n

.meas tran vdout1_111ck540 FIND v(dout1_111) AT=550.05n

.meas tran vdout1_112ck540 FIND v(dout1_112) AT=550.05n

.meas tran vdout1_113ck540 FIND v(dout1_113) AT=550.05n

.meas tran vdout1_114ck540 FIND v(dout1_114) AT=550.05n

.meas tran vdout1_115ck540 FIND v(dout1_115) AT=550.05n

.meas tran vdout1_116ck540 FIND v(dout1_116) AT=550.05n

.meas tran vdout1_117ck540 FIND v(dout1_117) AT=550.05n

.meas tran vdout1_118ck540 FIND v(dout1_118) AT=550.05n

.meas tran vdout1_119ck540 FIND v(dout1_119) AT=550.05n

.meas tran vdout1_120ck540 FIND v(dout1_120) AT=550.05n

.meas tran vdout1_121ck540 FIND v(dout1_121) AT=550.05n

.meas tran vdout1_122ck540 FIND v(dout1_122) AT=550.05n

.meas tran vdout1_123ck540 FIND v(dout1_123) AT=550.05n

.meas tran vdout1_124ck540 FIND v(dout1_124) AT=550.05n

.meas tran vdout1_125ck540 FIND v(dout1_125) AT=550.05n

.meas tran vdout1_126ck540 FIND v(dout1_126) AT=550.05n

.meas tran vdout1_127ck540 FIND v(dout1_127) AT=550.05n

.meas tran vdout1_128ck540 FIND v(dout1_128) AT=550.05n

.meas tran vdout1_129ck540 FIND v(dout1_129) AT=550.05n

.meas tran vdout1_130ck540 FIND v(dout1_130) AT=550.05n

.meas tran vdout1_131ck540 FIND v(dout1_131) AT=550.05n

.meas tran vdout1_132ck540 FIND v(dout1_132) AT=550.05n

.meas tran vdout1_133ck540 FIND v(dout1_133) AT=550.05n

.meas tran vdout1_134ck540 FIND v(dout1_134) AT=550.05n

.meas tran vdout1_135ck540 FIND v(dout1_135) AT=550.05n

.meas tran vdout1_136ck540 FIND v(dout1_136) AT=550.05n

.meas tran vdout1_137ck540 FIND v(dout1_137) AT=550.05n

.meas tran vdout1_138ck540 FIND v(dout1_138) AT=550.05n

.meas tran vdout1_139ck540 FIND v(dout1_139) AT=550.05n

.meas tran vdout1_140ck540 FIND v(dout1_140) AT=550.05n

.meas tran vdout1_141ck540 FIND v(dout1_141) AT=550.05n

.meas tran vdout1_142ck540 FIND v(dout1_142) AT=550.05n

.meas tran vdout1_143ck540 FIND v(dout1_143) AT=550.05n

.meas tran vdout1_144ck540 FIND v(dout1_144) AT=550.05n

.meas tran vdout1_145ck540 FIND v(dout1_145) AT=550.05n

.meas tran vdout1_146ck540 FIND v(dout1_146) AT=550.05n

.meas tran vdout1_147ck540 FIND v(dout1_147) AT=550.05n

.meas tran vdout1_148ck540 FIND v(dout1_148) AT=550.05n

.meas tran vdout1_149ck540 FIND v(dout1_149) AT=550.05n

.meas tran vdout1_150ck540 FIND v(dout1_150) AT=550.05n

.meas tran vdout1_151ck540 FIND v(dout1_151) AT=550.05n

.meas tran vdout1_152ck540 FIND v(dout1_152) AT=550.05n

.meas tran vdout1_153ck540 FIND v(dout1_153) AT=550.05n

.meas tran vdout1_154ck540 FIND v(dout1_154) AT=550.05n

.meas tran vdout1_155ck540 FIND v(dout1_155) AT=550.05n

.meas tran vdout1_156ck540 FIND v(dout1_156) AT=550.05n

.meas tran vdout1_157ck540 FIND v(dout1_157) AT=550.05n

.meas tran vdout1_158ck540 FIND v(dout1_158) AT=550.05n

.meas tran vdout1_159ck540 FIND v(dout1_159) AT=550.05n

.meas tran vdout1_160ck540 FIND v(dout1_160) AT=550.05n

.meas tran vdout1_161ck540 FIND v(dout1_161) AT=550.05n

.meas tran vdout1_162ck540 FIND v(dout1_162) AT=550.05n

.meas tran vdout1_163ck540 FIND v(dout1_163) AT=550.05n

.meas tran vdout1_164ck540 FIND v(dout1_164) AT=550.05n

.meas tran vdout1_165ck540 FIND v(dout1_165) AT=550.05n

.meas tran vdout1_166ck540 FIND v(dout1_166) AT=550.05n

.meas tran vdout1_167ck540 FIND v(dout1_167) AT=550.05n

.meas tran vdout1_168ck540 FIND v(dout1_168) AT=550.05n

.meas tran vdout1_169ck540 FIND v(dout1_169) AT=550.05n

.meas tran vdout1_170ck540 FIND v(dout1_170) AT=550.05n

.meas tran vdout1_171ck540 FIND v(dout1_171) AT=550.05n

.meas tran vdout1_172ck540 FIND v(dout1_172) AT=550.05n

.meas tran vdout1_173ck540 FIND v(dout1_173) AT=550.05n

.meas tran vdout1_174ck540 FIND v(dout1_174) AT=550.05n

.meas tran vdout1_175ck540 FIND v(dout1_175) AT=550.05n

.meas tran vdout1_176ck540 FIND v(dout1_176) AT=550.05n

.meas tran vdout1_177ck540 FIND v(dout1_177) AT=550.05n

.meas tran vdout1_178ck540 FIND v(dout1_178) AT=550.05n

.meas tran vdout1_179ck540 FIND v(dout1_179) AT=550.05n

.meas tran vdout1_180ck540 FIND v(dout1_180) AT=550.05n

.meas tran vdout1_181ck540 FIND v(dout1_181) AT=550.05n

.meas tran vdout1_182ck540 FIND v(dout1_182) AT=550.05n

.meas tran vdout1_183ck540 FIND v(dout1_183) AT=550.05n

.meas tran vdout1_184ck540 FIND v(dout1_184) AT=550.05n

.meas tran vdout1_185ck540 FIND v(dout1_185) AT=550.05n

.meas tran vdout1_186ck540 FIND v(dout1_186) AT=550.05n

.meas tran vdout1_187ck540 FIND v(dout1_187) AT=550.05n

.meas tran vdout1_188ck540 FIND v(dout1_188) AT=550.05n

.meas tran vdout1_189ck540 FIND v(dout1_189) AT=550.05n

.meas tran vdout1_190ck540 FIND v(dout1_190) AT=550.05n

.meas tran vdout1_191ck540 FIND v(dout1_191) AT=550.05n

.meas tran vdout1_192ck540 FIND v(dout1_192) AT=550.05n

.meas tran vdout1_193ck540 FIND v(dout1_193) AT=550.05n

.meas tran vdout1_194ck540 FIND v(dout1_194) AT=550.05n

.meas tran vdout1_195ck540 FIND v(dout1_195) AT=550.05n

.meas tran vdout1_196ck540 FIND v(dout1_196) AT=550.05n

.meas tran vdout1_197ck540 FIND v(dout1_197) AT=550.05n

.meas tran vdout1_198ck540 FIND v(dout1_198) AT=550.05n

.meas tran vdout1_199ck540 FIND v(dout1_199) AT=550.05n

.meas tran vdout1_200ck540 FIND v(dout1_200) AT=550.05n

.meas tran vdout1_201ck540 FIND v(dout1_201) AT=550.05n

.meas tran vdout1_202ck540 FIND v(dout1_202) AT=550.05n

.meas tran vdout1_203ck540 FIND v(dout1_203) AT=550.05n

.meas tran vdout1_204ck540 FIND v(dout1_204) AT=550.05n

.meas tran vdout1_205ck540 FIND v(dout1_205) AT=550.05n

.meas tran vdout1_206ck540 FIND v(dout1_206) AT=550.05n

.meas tran vdout1_207ck540 FIND v(dout1_207) AT=550.05n

.meas tran vdout1_208ck540 FIND v(dout1_208) AT=550.05n

.meas tran vdout1_209ck540 FIND v(dout1_209) AT=550.05n

.meas tran vdout1_210ck540 FIND v(dout1_210) AT=550.05n

.meas tran vdout1_211ck540 FIND v(dout1_211) AT=550.05n

.meas tran vdout1_212ck540 FIND v(dout1_212) AT=550.05n

.meas tran vdout1_213ck540 FIND v(dout1_213) AT=550.05n

.meas tran vdout1_214ck540 FIND v(dout1_214) AT=550.05n

.meas tran vdout1_215ck540 FIND v(dout1_215) AT=550.05n

.meas tran vdout1_216ck540 FIND v(dout1_216) AT=550.05n

.meas tran vdout1_217ck540 FIND v(dout1_217) AT=550.05n

.meas tran vdout1_218ck540 FIND v(dout1_218) AT=550.05n

.meas tran vdout1_219ck540 FIND v(dout1_219) AT=550.05n

.meas tran vdout1_220ck540 FIND v(dout1_220) AT=550.05n

.meas tran vdout1_221ck540 FIND v(dout1_221) AT=550.05n

.meas tran vdout1_222ck540 FIND v(dout1_222) AT=550.05n

.meas tran vdout1_223ck540 FIND v(dout1_223) AT=550.05n

.meas tran vdout1_224ck540 FIND v(dout1_224) AT=550.05n

.meas tran vdout1_225ck540 FIND v(dout1_225) AT=550.05n

.meas tran vdout1_226ck540 FIND v(dout1_226) AT=550.05n

.meas tran vdout1_227ck540 FIND v(dout1_227) AT=550.05n

.meas tran vdout1_228ck540 FIND v(dout1_228) AT=550.05n

.meas tran vdout1_229ck540 FIND v(dout1_229) AT=550.05n

.meas tran vdout1_230ck540 FIND v(dout1_230) AT=550.05n

.meas tran vdout1_231ck540 FIND v(dout1_231) AT=550.05n

.meas tran vdout1_232ck540 FIND v(dout1_232) AT=550.05n

.meas tran vdout1_233ck540 FIND v(dout1_233) AT=550.05n

.meas tran vdout1_234ck540 FIND v(dout1_234) AT=550.05n

.meas tran vdout1_235ck540 FIND v(dout1_235) AT=550.05n

.meas tran vdout1_236ck540 FIND v(dout1_236) AT=550.05n

.meas tran vdout1_237ck540 FIND v(dout1_237) AT=550.05n

.meas tran vdout1_238ck540 FIND v(dout1_238) AT=550.05n

.meas tran vdout1_239ck540 FIND v(dout1_239) AT=550.05n

.meas tran vdout1_240ck540 FIND v(dout1_240) AT=550.05n

.meas tran vdout1_241ck540 FIND v(dout1_241) AT=550.05n

.meas tran vdout1_242ck540 FIND v(dout1_242) AT=550.05n

.meas tran vdout1_243ck540 FIND v(dout1_243) AT=550.05n

.meas tran vdout1_244ck540 FIND v(dout1_244) AT=550.05n

.meas tran vdout1_245ck540 FIND v(dout1_245) AT=550.05n

.meas tran vdout1_246ck540 FIND v(dout1_246) AT=550.05n

.meas tran vdout1_247ck540 FIND v(dout1_247) AT=550.05n

.meas tran vdout1_248ck540 FIND v(dout1_248) AT=550.05n

.meas tran vdout1_249ck540 FIND v(dout1_249) AT=550.05n

.meas tran vdout1_250ck540 FIND v(dout1_250) AT=550.05n

.meas tran vdout1_251ck540 FIND v(dout1_251) AT=550.05n

.meas tran vdout1_252ck540 FIND v(dout1_252) AT=550.05n

.meas tran vdout1_253ck540 FIND v(dout1_253) AT=550.05n

.meas tran vdout1_254ck540 FIND v(dout1_254) AT=550.05n

.meas tran vdout1_255ck540 FIND v(dout1_255) AT=550.05n

.meas tran vdout1_256ck540 FIND v(dout1_256) AT=550.05n

.meas tran vdout1_0ck600 FIND v(dout1_0) AT=610.05n

.meas tran vdout1_1ck600 FIND v(dout1_1) AT=610.05n

.meas tran vdout1_2ck600 FIND v(dout1_2) AT=610.05n

.meas tran vdout1_3ck600 FIND v(dout1_3) AT=610.05n

.meas tran vdout1_4ck600 FIND v(dout1_4) AT=610.05n

.meas tran vdout1_5ck600 FIND v(dout1_5) AT=610.05n

.meas tran vdout1_6ck600 FIND v(dout1_6) AT=610.05n

.meas tran vdout1_7ck600 FIND v(dout1_7) AT=610.05n

.meas tran vdout1_8ck600 FIND v(dout1_8) AT=610.05n

.meas tran vdout1_9ck600 FIND v(dout1_9) AT=610.05n

.meas tran vdout1_10ck600 FIND v(dout1_10) AT=610.05n

.meas tran vdout1_11ck600 FIND v(dout1_11) AT=610.05n

.meas tran vdout1_12ck600 FIND v(dout1_12) AT=610.05n

.meas tran vdout1_13ck600 FIND v(dout1_13) AT=610.05n

.meas tran vdout1_14ck600 FIND v(dout1_14) AT=610.05n

.meas tran vdout1_15ck600 FIND v(dout1_15) AT=610.05n

.meas tran vdout1_16ck600 FIND v(dout1_16) AT=610.05n

.meas tran vdout1_17ck600 FIND v(dout1_17) AT=610.05n

.meas tran vdout1_18ck600 FIND v(dout1_18) AT=610.05n

.meas tran vdout1_19ck600 FIND v(dout1_19) AT=610.05n

.meas tran vdout1_20ck600 FIND v(dout1_20) AT=610.05n

.meas tran vdout1_21ck600 FIND v(dout1_21) AT=610.05n

.meas tran vdout1_22ck600 FIND v(dout1_22) AT=610.05n

.meas tran vdout1_23ck600 FIND v(dout1_23) AT=610.05n

.meas tran vdout1_24ck600 FIND v(dout1_24) AT=610.05n

.meas tran vdout1_25ck600 FIND v(dout1_25) AT=610.05n

.meas tran vdout1_26ck600 FIND v(dout1_26) AT=610.05n

.meas tran vdout1_27ck600 FIND v(dout1_27) AT=610.05n

.meas tran vdout1_28ck600 FIND v(dout1_28) AT=610.05n

.meas tran vdout1_29ck600 FIND v(dout1_29) AT=610.05n

.meas tran vdout1_30ck600 FIND v(dout1_30) AT=610.05n

.meas tran vdout1_31ck600 FIND v(dout1_31) AT=610.05n

.meas tran vdout1_32ck600 FIND v(dout1_32) AT=610.05n

.meas tran vdout1_33ck600 FIND v(dout1_33) AT=610.05n

.meas tran vdout1_34ck600 FIND v(dout1_34) AT=610.05n

.meas tran vdout1_35ck600 FIND v(dout1_35) AT=610.05n

.meas tran vdout1_36ck600 FIND v(dout1_36) AT=610.05n

.meas tran vdout1_37ck600 FIND v(dout1_37) AT=610.05n

.meas tran vdout1_38ck600 FIND v(dout1_38) AT=610.05n

.meas tran vdout1_39ck600 FIND v(dout1_39) AT=610.05n

.meas tran vdout1_40ck600 FIND v(dout1_40) AT=610.05n

.meas tran vdout1_41ck600 FIND v(dout1_41) AT=610.05n

.meas tran vdout1_42ck600 FIND v(dout1_42) AT=610.05n

.meas tran vdout1_43ck600 FIND v(dout1_43) AT=610.05n

.meas tran vdout1_44ck600 FIND v(dout1_44) AT=610.05n

.meas tran vdout1_45ck600 FIND v(dout1_45) AT=610.05n

.meas tran vdout1_46ck600 FIND v(dout1_46) AT=610.05n

.meas tran vdout1_47ck600 FIND v(dout1_47) AT=610.05n

.meas tran vdout1_48ck600 FIND v(dout1_48) AT=610.05n

.meas tran vdout1_49ck600 FIND v(dout1_49) AT=610.05n

.meas tran vdout1_50ck600 FIND v(dout1_50) AT=610.05n

.meas tran vdout1_51ck600 FIND v(dout1_51) AT=610.05n

.meas tran vdout1_52ck600 FIND v(dout1_52) AT=610.05n

.meas tran vdout1_53ck600 FIND v(dout1_53) AT=610.05n

.meas tran vdout1_54ck600 FIND v(dout1_54) AT=610.05n

.meas tran vdout1_55ck600 FIND v(dout1_55) AT=610.05n

.meas tran vdout1_56ck600 FIND v(dout1_56) AT=610.05n

.meas tran vdout1_57ck600 FIND v(dout1_57) AT=610.05n

.meas tran vdout1_58ck600 FIND v(dout1_58) AT=610.05n

.meas tran vdout1_59ck600 FIND v(dout1_59) AT=610.05n

.meas tran vdout1_60ck600 FIND v(dout1_60) AT=610.05n

.meas tran vdout1_61ck600 FIND v(dout1_61) AT=610.05n

.meas tran vdout1_62ck600 FIND v(dout1_62) AT=610.05n

.meas tran vdout1_63ck600 FIND v(dout1_63) AT=610.05n

.meas tran vdout1_64ck600 FIND v(dout1_64) AT=610.05n

.meas tran vdout1_65ck600 FIND v(dout1_65) AT=610.05n

.meas tran vdout1_66ck600 FIND v(dout1_66) AT=610.05n

.meas tran vdout1_67ck600 FIND v(dout1_67) AT=610.05n

.meas tran vdout1_68ck600 FIND v(dout1_68) AT=610.05n

.meas tran vdout1_69ck600 FIND v(dout1_69) AT=610.05n

.meas tran vdout1_70ck600 FIND v(dout1_70) AT=610.05n

.meas tran vdout1_71ck600 FIND v(dout1_71) AT=610.05n

.meas tran vdout1_72ck600 FIND v(dout1_72) AT=610.05n

.meas tran vdout1_73ck600 FIND v(dout1_73) AT=610.05n

.meas tran vdout1_74ck600 FIND v(dout1_74) AT=610.05n

.meas tran vdout1_75ck600 FIND v(dout1_75) AT=610.05n

.meas tran vdout1_76ck600 FIND v(dout1_76) AT=610.05n

.meas tran vdout1_77ck600 FIND v(dout1_77) AT=610.05n

.meas tran vdout1_78ck600 FIND v(dout1_78) AT=610.05n

.meas tran vdout1_79ck600 FIND v(dout1_79) AT=610.05n

.meas tran vdout1_80ck600 FIND v(dout1_80) AT=610.05n

.meas tran vdout1_81ck600 FIND v(dout1_81) AT=610.05n

.meas tran vdout1_82ck600 FIND v(dout1_82) AT=610.05n

.meas tran vdout1_83ck600 FIND v(dout1_83) AT=610.05n

.meas tran vdout1_84ck600 FIND v(dout1_84) AT=610.05n

.meas tran vdout1_85ck600 FIND v(dout1_85) AT=610.05n

.meas tran vdout1_86ck600 FIND v(dout1_86) AT=610.05n

.meas tran vdout1_87ck600 FIND v(dout1_87) AT=610.05n

.meas tran vdout1_88ck600 FIND v(dout1_88) AT=610.05n

.meas tran vdout1_89ck600 FIND v(dout1_89) AT=610.05n

.meas tran vdout1_90ck600 FIND v(dout1_90) AT=610.05n

.meas tran vdout1_91ck600 FIND v(dout1_91) AT=610.05n

.meas tran vdout1_92ck600 FIND v(dout1_92) AT=610.05n

.meas tran vdout1_93ck600 FIND v(dout1_93) AT=610.05n

.meas tran vdout1_94ck600 FIND v(dout1_94) AT=610.05n

.meas tran vdout1_95ck600 FIND v(dout1_95) AT=610.05n

.meas tran vdout1_96ck600 FIND v(dout1_96) AT=610.05n

.meas tran vdout1_97ck600 FIND v(dout1_97) AT=610.05n

.meas tran vdout1_98ck600 FIND v(dout1_98) AT=610.05n

.meas tran vdout1_99ck600 FIND v(dout1_99) AT=610.05n

.meas tran vdout1_100ck600 FIND v(dout1_100) AT=610.05n

.meas tran vdout1_101ck600 FIND v(dout1_101) AT=610.05n

.meas tran vdout1_102ck600 FIND v(dout1_102) AT=610.05n

.meas tran vdout1_103ck600 FIND v(dout1_103) AT=610.05n

.meas tran vdout1_104ck600 FIND v(dout1_104) AT=610.05n

.meas tran vdout1_105ck600 FIND v(dout1_105) AT=610.05n

.meas tran vdout1_106ck600 FIND v(dout1_106) AT=610.05n

.meas tran vdout1_107ck600 FIND v(dout1_107) AT=610.05n

.meas tran vdout1_108ck600 FIND v(dout1_108) AT=610.05n

.meas tran vdout1_109ck600 FIND v(dout1_109) AT=610.05n

.meas tran vdout1_110ck600 FIND v(dout1_110) AT=610.05n

.meas tran vdout1_111ck600 FIND v(dout1_111) AT=610.05n

.meas tran vdout1_112ck600 FIND v(dout1_112) AT=610.05n

.meas tran vdout1_113ck600 FIND v(dout1_113) AT=610.05n

.meas tran vdout1_114ck600 FIND v(dout1_114) AT=610.05n

.meas tran vdout1_115ck600 FIND v(dout1_115) AT=610.05n

.meas tran vdout1_116ck600 FIND v(dout1_116) AT=610.05n

.meas tran vdout1_117ck600 FIND v(dout1_117) AT=610.05n

.meas tran vdout1_118ck600 FIND v(dout1_118) AT=610.05n

.meas tran vdout1_119ck600 FIND v(dout1_119) AT=610.05n

.meas tran vdout1_120ck600 FIND v(dout1_120) AT=610.05n

.meas tran vdout1_121ck600 FIND v(dout1_121) AT=610.05n

.meas tran vdout1_122ck600 FIND v(dout1_122) AT=610.05n

.meas tran vdout1_123ck600 FIND v(dout1_123) AT=610.05n

.meas tran vdout1_124ck600 FIND v(dout1_124) AT=610.05n

.meas tran vdout1_125ck600 FIND v(dout1_125) AT=610.05n

.meas tran vdout1_126ck600 FIND v(dout1_126) AT=610.05n

.meas tran vdout1_127ck600 FIND v(dout1_127) AT=610.05n

.meas tran vdout1_128ck600 FIND v(dout1_128) AT=610.05n

.meas tran vdout1_129ck600 FIND v(dout1_129) AT=610.05n

.meas tran vdout1_130ck600 FIND v(dout1_130) AT=610.05n

.meas tran vdout1_131ck600 FIND v(dout1_131) AT=610.05n

.meas tran vdout1_132ck600 FIND v(dout1_132) AT=610.05n

.meas tran vdout1_133ck600 FIND v(dout1_133) AT=610.05n

.meas tran vdout1_134ck600 FIND v(dout1_134) AT=610.05n

.meas tran vdout1_135ck600 FIND v(dout1_135) AT=610.05n

.meas tran vdout1_136ck600 FIND v(dout1_136) AT=610.05n

.meas tran vdout1_137ck600 FIND v(dout1_137) AT=610.05n

.meas tran vdout1_138ck600 FIND v(dout1_138) AT=610.05n

.meas tran vdout1_139ck600 FIND v(dout1_139) AT=610.05n

.meas tran vdout1_140ck600 FIND v(dout1_140) AT=610.05n

.meas tran vdout1_141ck600 FIND v(dout1_141) AT=610.05n

.meas tran vdout1_142ck600 FIND v(dout1_142) AT=610.05n

.meas tran vdout1_143ck600 FIND v(dout1_143) AT=610.05n

.meas tran vdout1_144ck600 FIND v(dout1_144) AT=610.05n

.meas tran vdout1_145ck600 FIND v(dout1_145) AT=610.05n

.meas tran vdout1_146ck600 FIND v(dout1_146) AT=610.05n

.meas tran vdout1_147ck600 FIND v(dout1_147) AT=610.05n

.meas tran vdout1_148ck600 FIND v(dout1_148) AT=610.05n

.meas tran vdout1_149ck600 FIND v(dout1_149) AT=610.05n

.meas tran vdout1_150ck600 FIND v(dout1_150) AT=610.05n

.meas tran vdout1_151ck600 FIND v(dout1_151) AT=610.05n

.meas tran vdout1_152ck600 FIND v(dout1_152) AT=610.05n

.meas tran vdout1_153ck600 FIND v(dout1_153) AT=610.05n

.meas tran vdout1_154ck600 FIND v(dout1_154) AT=610.05n

.meas tran vdout1_155ck600 FIND v(dout1_155) AT=610.05n

.meas tran vdout1_156ck600 FIND v(dout1_156) AT=610.05n

.meas tran vdout1_157ck600 FIND v(dout1_157) AT=610.05n

.meas tran vdout1_158ck600 FIND v(dout1_158) AT=610.05n

.meas tran vdout1_159ck600 FIND v(dout1_159) AT=610.05n

.meas tran vdout1_160ck600 FIND v(dout1_160) AT=610.05n

.meas tran vdout1_161ck600 FIND v(dout1_161) AT=610.05n

.meas tran vdout1_162ck600 FIND v(dout1_162) AT=610.05n

.meas tran vdout1_163ck600 FIND v(dout1_163) AT=610.05n

.meas tran vdout1_164ck600 FIND v(dout1_164) AT=610.05n

.meas tran vdout1_165ck600 FIND v(dout1_165) AT=610.05n

.meas tran vdout1_166ck600 FIND v(dout1_166) AT=610.05n

.meas tran vdout1_167ck600 FIND v(dout1_167) AT=610.05n

.meas tran vdout1_168ck600 FIND v(dout1_168) AT=610.05n

.meas tran vdout1_169ck600 FIND v(dout1_169) AT=610.05n

.meas tran vdout1_170ck600 FIND v(dout1_170) AT=610.05n

.meas tran vdout1_171ck600 FIND v(dout1_171) AT=610.05n

.meas tran vdout1_172ck600 FIND v(dout1_172) AT=610.05n

.meas tran vdout1_173ck600 FIND v(dout1_173) AT=610.05n

.meas tran vdout1_174ck600 FIND v(dout1_174) AT=610.05n

.meas tran vdout1_175ck600 FIND v(dout1_175) AT=610.05n

.meas tran vdout1_176ck600 FIND v(dout1_176) AT=610.05n

.meas tran vdout1_177ck600 FIND v(dout1_177) AT=610.05n

.meas tran vdout1_178ck600 FIND v(dout1_178) AT=610.05n

.meas tran vdout1_179ck600 FIND v(dout1_179) AT=610.05n

.meas tran vdout1_180ck600 FIND v(dout1_180) AT=610.05n

.meas tran vdout1_181ck600 FIND v(dout1_181) AT=610.05n

.meas tran vdout1_182ck600 FIND v(dout1_182) AT=610.05n

.meas tran vdout1_183ck600 FIND v(dout1_183) AT=610.05n

.meas tran vdout1_184ck600 FIND v(dout1_184) AT=610.05n

.meas tran vdout1_185ck600 FIND v(dout1_185) AT=610.05n

.meas tran vdout1_186ck600 FIND v(dout1_186) AT=610.05n

.meas tran vdout1_187ck600 FIND v(dout1_187) AT=610.05n

.meas tran vdout1_188ck600 FIND v(dout1_188) AT=610.05n

.meas tran vdout1_189ck600 FIND v(dout1_189) AT=610.05n

.meas tran vdout1_190ck600 FIND v(dout1_190) AT=610.05n

.meas tran vdout1_191ck600 FIND v(dout1_191) AT=610.05n

.meas tran vdout1_192ck600 FIND v(dout1_192) AT=610.05n

.meas tran vdout1_193ck600 FIND v(dout1_193) AT=610.05n

.meas tran vdout1_194ck600 FIND v(dout1_194) AT=610.05n

.meas tran vdout1_195ck600 FIND v(dout1_195) AT=610.05n

.meas tran vdout1_196ck600 FIND v(dout1_196) AT=610.05n

.meas tran vdout1_197ck600 FIND v(dout1_197) AT=610.05n

.meas tran vdout1_198ck600 FIND v(dout1_198) AT=610.05n

.meas tran vdout1_199ck600 FIND v(dout1_199) AT=610.05n

.meas tran vdout1_200ck600 FIND v(dout1_200) AT=610.05n

.meas tran vdout1_201ck600 FIND v(dout1_201) AT=610.05n

.meas tran vdout1_202ck600 FIND v(dout1_202) AT=610.05n

.meas tran vdout1_203ck600 FIND v(dout1_203) AT=610.05n

.meas tran vdout1_204ck600 FIND v(dout1_204) AT=610.05n

.meas tran vdout1_205ck600 FIND v(dout1_205) AT=610.05n

.meas tran vdout1_206ck600 FIND v(dout1_206) AT=610.05n

.meas tran vdout1_207ck600 FIND v(dout1_207) AT=610.05n

.meas tran vdout1_208ck600 FIND v(dout1_208) AT=610.05n

.meas tran vdout1_209ck600 FIND v(dout1_209) AT=610.05n

.meas tran vdout1_210ck600 FIND v(dout1_210) AT=610.05n

.meas tran vdout1_211ck600 FIND v(dout1_211) AT=610.05n

.meas tran vdout1_212ck600 FIND v(dout1_212) AT=610.05n

.meas tran vdout1_213ck600 FIND v(dout1_213) AT=610.05n

.meas tran vdout1_214ck600 FIND v(dout1_214) AT=610.05n

.meas tran vdout1_215ck600 FIND v(dout1_215) AT=610.05n

.meas tran vdout1_216ck600 FIND v(dout1_216) AT=610.05n

.meas tran vdout1_217ck600 FIND v(dout1_217) AT=610.05n

.meas tran vdout1_218ck600 FIND v(dout1_218) AT=610.05n

.meas tran vdout1_219ck600 FIND v(dout1_219) AT=610.05n

.meas tran vdout1_220ck600 FIND v(dout1_220) AT=610.05n

.meas tran vdout1_221ck600 FIND v(dout1_221) AT=610.05n

.meas tran vdout1_222ck600 FIND v(dout1_222) AT=610.05n

.meas tran vdout1_223ck600 FIND v(dout1_223) AT=610.05n

.meas tran vdout1_224ck600 FIND v(dout1_224) AT=610.05n

.meas tran vdout1_225ck600 FIND v(dout1_225) AT=610.05n

.meas tran vdout1_226ck600 FIND v(dout1_226) AT=610.05n

.meas tran vdout1_227ck600 FIND v(dout1_227) AT=610.05n

.meas tran vdout1_228ck600 FIND v(dout1_228) AT=610.05n

.meas tran vdout1_229ck600 FIND v(dout1_229) AT=610.05n

.meas tran vdout1_230ck600 FIND v(dout1_230) AT=610.05n

.meas tran vdout1_231ck600 FIND v(dout1_231) AT=610.05n

.meas tran vdout1_232ck600 FIND v(dout1_232) AT=610.05n

.meas tran vdout1_233ck600 FIND v(dout1_233) AT=610.05n

.meas tran vdout1_234ck600 FIND v(dout1_234) AT=610.05n

.meas tran vdout1_235ck600 FIND v(dout1_235) AT=610.05n

.meas tran vdout1_236ck600 FIND v(dout1_236) AT=610.05n

.meas tran vdout1_237ck600 FIND v(dout1_237) AT=610.05n

.meas tran vdout1_238ck600 FIND v(dout1_238) AT=610.05n

.meas tran vdout1_239ck600 FIND v(dout1_239) AT=610.05n

.meas tran vdout1_240ck600 FIND v(dout1_240) AT=610.05n

.meas tran vdout1_241ck600 FIND v(dout1_241) AT=610.05n

.meas tran vdout1_242ck600 FIND v(dout1_242) AT=610.05n

.meas tran vdout1_243ck600 FIND v(dout1_243) AT=610.05n

.meas tran vdout1_244ck600 FIND v(dout1_244) AT=610.05n

.meas tran vdout1_245ck600 FIND v(dout1_245) AT=610.05n

.meas tran vdout1_246ck600 FIND v(dout1_246) AT=610.05n

.meas tran vdout1_247ck600 FIND v(dout1_247) AT=610.05n

.meas tran vdout1_248ck600 FIND v(dout1_248) AT=610.05n

.meas tran vdout1_249ck600 FIND v(dout1_249) AT=610.05n

.meas tran vdout1_250ck600 FIND v(dout1_250) AT=610.05n

.meas tran vdout1_251ck600 FIND v(dout1_251) AT=610.05n

.meas tran vdout1_252ck600 FIND v(dout1_252) AT=610.05n

.meas tran vdout1_253ck600 FIND v(dout1_253) AT=610.05n

.meas tran vdout1_254ck600 FIND v(dout1_254) AT=610.05n

.meas tran vdout1_255ck600 FIND v(dout1_255) AT=610.05n

.meas tran vdout1_256ck600 FIND v(dout1_256) AT=610.05n

.meas tran vdout1_0ck610 FIND v(dout1_0) AT=620.05n

.meas tran vdout1_1ck610 FIND v(dout1_1) AT=620.05n

.meas tran vdout1_2ck610 FIND v(dout1_2) AT=620.05n

.meas tran vdout1_3ck610 FIND v(dout1_3) AT=620.05n

.meas tran vdout1_4ck610 FIND v(dout1_4) AT=620.05n

.meas tran vdout1_5ck610 FIND v(dout1_5) AT=620.05n

.meas tran vdout1_6ck610 FIND v(dout1_6) AT=620.05n

.meas tran vdout1_7ck610 FIND v(dout1_7) AT=620.05n

.meas tran vdout1_8ck610 FIND v(dout1_8) AT=620.05n

.meas tran vdout1_9ck610 FIND v(dout1_9) AT=620.05n

.meas tran vdout1_10ck610 FIND v(dout1_10) AT=620.05n

.meas tran vdout1_11ck610 FIND v(dout1_11) AT=620.05n

.meas tran vdout1_12ck610 FIND v(dout1_12) AT=620.05n

.meas tran vdout1_13ck610 FIND v(dout1_13) AT=620.05n

.meas tran vdout1_14ck610 FIND v(dout1_14) AT=620.05n

.meas tran vdout1_15ck610 FIND v(dout1_15) AT=620.05n

.meas tran vdout1_16ck610 FIND v(dout1_16) AT=620.05n

.meas tran vdout1_17ck610 FIND v(dout1_17) AT=620.05n

.meas tran vdout1_18ck610 FIND v(dout1_18) AT=620.05n

.meas tran vdout1_19ck610 FIND v(dout1_19) AT=620.05n

.meas tran vdout1_20ck610 FIND v(dout1_20) AT=620.05n

.meas tran vdout1_21ck610 FIND v(dout1_21) AT=620.05n

.meas tran vdout1_22ck610 FIND v(dout1_22) AT=620.05n

.meas tran vdout1_23ck610 FIND v(dout1_23) AT=620.05n

.meas tran vdout1_24ck610 FIND v(dout1_24) AT=620.05n

.meas tran vdout1_25ck610 FIND v(dout1_25) AT=620.05n

.meas tran vdout1_26ck610 FIND v(dout1_26) AT=620.05n

.meas tran vdout1_27ck610 FIND v(dout1_27) AT=620.05n

.meas tran vdout1_28ck610 FIND v(dout1_28) AT=620.05n

.meas tran vdout1_29ck610 FIND v(dout1_29) AT=620.05n

.meas tran vdout1_30ck610 FIND v(dout1_30) AT=620.05n

.meas tran vdout1_31ck610 FIND v(dout1_31) AT=620.05n

.meas tran vdout1_32ck610 FIND v(dout1_32) AT=620.05n

.meas tran vdout1_33ck610 FIND v(dout1_33) AT=620.05n

.meas tran vdout1_34ck610 FIND v(dout1_34) AT=620.05n

.meas tran vdout1_35ck610 FIND v(dout1_35) AT=620.05n

.meas tran vdout1_36ck610 FIND v(dout1_36) AT=620.05n

.meas tran vdout1_37ck610 FIND v(dout1_37) AT=620.05n

.meas tran vdout1_38ck610 FIND v(dout1_38) AT=620.05n

.meas tran vdout1_39ck610 FIND v(dout1_39) AT=620.05n

.meas tran vdout1_40ck610 FIND v(dout1_40) AT=620.05n

.meas tran vdout1_41ck610 FIND v(dout1_41) AT=620.05n

.meas tran vdout1_42ck610 FIND v(dout1_42) AT=620.05n

.meas tran vdout1_43ck610 FIND v(dout1_43) AT=620.05n

.meas tran vdout1_44ck610 FIND v(dout1_44) AT=620.05n

.meas tran vdout1_45ck610 FIND v(dout1_45) AT=620.05n

.meas tran vdout1_46ck610 FIND v(dout1_46) AT=620.05n

.meas tran vdout1_47ck610 FIND v(dout1_47) AT=620.05n

.meas tran vdout1_48ck610 FIND v(dout1_48) AT=620.05n

.meas tran vdout1_49ck610 FIND v(dout1_49) AT=620.05n

.meas tran vdout1_50ck610 FIND v(dout1_50) AT=620.05n

.meas tran vdout1_51ck610 FIND v(dout1_51) AT=620.05n

.meas tran vdout1_52ck610 FIND v(dout1_52) AT=620.05n

.meas tran vdout1_53ck610 FIND v(dout1_53) AT=620.05n

.meas tran vdout1_54ck610 FIND v(dout1_54) AT=620.05n

.meas tran vdout1_55ck610 FIND v(dout1_55) AT=620.05n

.meas tran vdout1_56ck610 FIND v(dout1_56) AT=620.05n

.meas tran vdout1_57ck610 FIND v(dout1_57) AT=620.05n

.meas tran vdout1_58ck610 FIND v(dout1_58) AT=620.05n

.meas tran vdout1_59ck610 FIND v(dout1_59) AT=620.05n

.meas tran vdout1_60ck610 FIND v(dout1_60) AT=620.05n

.meas tran vdout1_61ck610 FIND v(dout1_61) AT=620.05n

.meas tran vdout1_62ck610 FIND v(dout1_62) AT=620.05n

.meas tran vdout1_63ck610 FIND v(dout1_63) AT=620.05n

.meas tran vdout1_64ck610 FIND v(dout1_64) AT=620.05n

.meas tran vdout1_65ck610 FIND v(dout1_65) AT=620.05n

.meas tran vdout1_66ck610 FIND v(dout1_66) AT=620.05n

.meas tran vdout1_67ck610 FIND v(dout1_67) AT=620.05n

.meas tran vdout1_68ck610 FIND v(dout1_68) AT=620.05n

.meas tran vdout1_69ck610 FIND v(dout1_69) AT=620.05n

.meas tran vdout1_70ck610 FIND v(dout1_70) AT=620.05n

.meas tran vdout1_71ck610 FIND v(dout1_71) AT=620.05n

.meas tran vdout1_72ck610 FIND v(dout1_72) AT=620.05n

.meas tran vdout1_73ck610 FIND v(dout1_73) AT=620.05n

.meas tran vdout1_74ck610 FIND v(dout1_74) AT=620.05n

.meas tran vdout1_75ck610 FIND v(dout1_75) AT=620.05n

.meas tran vdout1_76ck610 FIND v(dout1_76) AT=620.05n

.meas tran vdout1_77ck610 FIND v(dout1_77) AT=620.05n

.meas tran vdout1_78ck610 FIND v(dout1_78) AT=620.05n

.meas tran vdout1_79ck610 FIND v(dout1_79) AT=620.05n

.meas tran vdout1_80ck610 FIND v(dout1_80) AT=620.05n

.meas tran vdout1_81ck610 FIND v(dout1_81) AT=620.05n

.meas tran vdout1_82ck610 FIND v(dout1_82) AT=620.05n

.meas tran vdout1_83ck610 FIND v(dout1_83) AT=620.05n

.meas tran vdout1_84ck610 FIND v(dout1_84) AT=620.05n

.meas tran vdout1_85ck610 FIND v(dout1_85) AT=620.05n

.meas tran vdout1_86ck610 FIND v(dout1_86) AT=620.05n

.meas tran vdout1_87ck610 FIND v(dout1_87) AT=620.05n

.meas tran vdout1_88ck610 FIND v(dout1_88) AT=620.05n

.meas tran vdout1_89ck610 FIND v(dout1_89) AT=620.05n

.meas tran vdout1_90ck610 FIND v(dout1_90) AT=620.05n

.meas tran vdout1_91ck610 FIND v(dout1_91) AT=620.05n

.meas tran vdout1_92ck610 FIND v(dout1_92) AT=620.05n

.meas tran vdout1_93ck610 FIND v(dout1_93) AT=620.05n

.meas tran vdout1_94ck610 FIND v(dout1_94) AT=620.05n

.meas tran vdout1_95ck610 FIND v(dout1_95) AT=620.05n

.meas tran vdout1_96ck610 FIND v(dout1_96) AT=620.05n

.meas tran vdout1_97ck610 FIND v(dout1_97) AT=620.05n

.meas tran vdout1_98ck610 FIND v(dout1_98) AT=620.05n

.meas tran vdout1_99ck610 FIND v(dout1_99) AT=620.05n

.meas tran vdout1_100ck610 FIND v(dout1_100) AT=620.05n

.meas tran vdout1_101ck610 FIND v(dout1_101) AT=620.05n

.meas tran vdout1_102ck610 FIND v(dout1_102) AT=620.05n

.meas tran vdout1_103ck610 FIND v(dout1_103) AT=620.05n

.meas tran vdout1_104ck610 FIND v(dout1_104) AT=620.05n

.meas tran vdout1_105ck610 FIND v(dout1_105) AT=620.05n

.meas tran vdout1_106ck610 FIND v(dout1_106) AT=620.05n

.meas tran vdout1_107ck610 FIND v(dout1_107) AT=620.05n

.meas tran vdout1_108ck610 FIND v(dout1_108) AT=620.05n

.meas tran vdout1_109ck610 FIND v(dout1_109) AT=620.05n

.meas tran vdout1_110ck610 FIND v(dout1_110) AT=620.05n

.meas tran vdout1_111ck610 FIND v(dout1_111) AT=620.05n

.meas tran vdout1_112ck610 FIND v(dout1_112) AT=620.05n

.meas tran vdout1_113ck610 FIND v(dout1_113) AT=620.05n

.meas tran vdout1_114ck610 FIND v(dout1_114) AT=620.05n

.meas tran vdout1_115ck610 FIND v(dout1_115) AT=620.05n

.meas tran vdout1_116ck610 FIND v(dout1_116) AT=620.05n

.meas tran vdout1_117ck610 FIND v(dout1_117) AT=620.05n

.meas tran vdout1_118ck610 FIND v(dout1_118) AT=620.05n

.meas tran vdout1_119ck610 FIND v(dout1_119) AT=620.05n

.meas tran vdout1_120ck610 FIND v(dout1_120) AT=620.05n

.meas tran vdout1_121ck610 FIND v(dout1_121) AT=620.05n

.meas tran vdout1_122ck610 FIND v(dout1_122) AT=620.05n

.meas tran vdout1_123ck610 FIND v(dout1_123) AT=620.05n

.meas tran vdout1_124ck610 FIND v(dout1_124) AT=620.05n

.meas tran vdout1_125ck610 FIND v(dout1_125) AT=620.05n

.meas tran vdout1_126ck610 FIND v(dout1_126) AT=620.05n

.meas tran vdout1_127ck610 FIND v(dout1_127) AT=620.05n

.meas tran vdout1_128ck610 FIND v(dout1_128) AT=620.05n

.meas tran vdout1_129ck610 FIND v(dout1_129) AT=620.05n

.meas tran vdout1_130ck610 FIND v(dout1_130) AT=620.05n

.meas tran vdout1_131ck610 FIND v(dout1_131) AT=620.05n

.meas tran vdout1_132ck610 FIND v(dout1_132) AT=620.05n

.meas tran vdout1_133ck610 FIND v(dout1_133) AT=620.05n

.meas tran vdout1_134ck610 FIND v(dout1_134) AT=620.05n

.meas tran vdout1_135ck610 FIND v(dout1_135) AT=620.05n

.meas tran vdout1_136ck610 FIND v(dout1_136) AT=620.05n

.meas tran vdout1_137ck610 FIND v(dout1_137) AT=620.05n

.meas tran vdout1_138ck610 FIND v(dout1_138) AT=620.05n

.meas tran vdout1_139ck610 FIND v(dout1_139) AT=620.05n

.meas tran vdout1_140ck610 FIND v(dout1_140) AT=620.05n

.meas tran vdout1_141ck610 FIND v(dout1_141) AT=620.05n

.meas tran vdout1_142ck610 FIND v(dout1_142) AT=620.05n

.meas tran vdout1_143ck610 FIND v(dout1_143) AT=620.05n

.meas tran vdout1_144ck610 FIND v(dout1_144) AT=620.05n

.meas tran vdout1_145ck610 FIND v(dout1_145) AT=620.05n

.meas tran vdout1_146ck610 FIND v(dout1_146) AT=620.05n

.meas tran vdout1_147ck610 FIND v(dout1_147) AT=620.05n

.meas tran vdout1_148ck610 FIND v(dout1_148) AT=620.05n

.meas tran vdout1_149ck610 FIND v(dout1_149) AT=620.05n

.meas tran vdout1_150ck610 FIND v(dout1_150) AT=620.05n

.meas tran vdout1_151ck610 FIND v(dout1_151) AT=620.05n

.meas tran vdout1_152ck610 FIND v(dout1_152) AT=620.05n

.meas tran vdout1_153ck610 FIND v(dout1_153) AT=620.05n

.meas tran vdout1_154ck610 FIND v(dout1_154) AT=620.05n

.meas tran vdout1_155ck610 FIND v(dout1_155) AT=620.05n

.meas tran vdout1_156ck610 FIND v(dout1_156) AT=620.05n

.meas tran vdout1_157ck610 FIND v(dout1_157) AT=620.05n

.meas tran vdout1_158ck610 FIND v(dout1_158) AT=620.05n

.meas tran vdout1_159ck610 FIND v(dout1_159) AT=620.05n

.meas tran vdout1_160ck610 FIND v(dout1_160) AT=620.05n

.meas tran vdout1_161ck610 FIND v(dout1_161) AT=620.05n

.meas tran vdout1_162ck610 FIND v(dout1_162) AT=620.05n

.meas tran vdout1_163ck610 FIND v(dout1_163) AT=620.05n

.meas tran vdout1_164ck610 FIND v(dout1_164) AT=620.05n

.meas tran vdout1_165ck610 FIND v(dout1_165) AT=620.05n

.meas tran vdout1_166ck610 FIND v(dout1_166) AT=620.05n

.meas tran vdout1_167ck610 FIND v(dout1_167) AT=620.05n

.meas tran vdout1_168ck610 FIND v(dout1_168) AT=620.05n

.meas tran vdout1_169ck610 FIND v(dout1_169) AT=620.05n

.meas tran vdout1_170ck610 FIND v(dout1_170) AT=620.05n

.meas tran vdout1_171ck610 FIND v(dout1_171) AT=620.05n

.meas tran vdout1_172ck610 FIND v(dout1_172) AT=620.05n

.meas tran vdout1_173ck610 FIND v(dout1_173) AT=620.05n

.meas tran vdout1_174ck610 FIND v(dout1_174) AT=620.05n

.meas tran vdout1_175ck610 FIND v(dout1_175) AT=620.05n

.meas tran vdout1_176ck610 FIND v(dout1_176) AT=620.05n

.meas tran vdout1_177ck610 FIND v(dout1_177) AT=620.05n

.meas tran vdout1_178ck610 FIND v(dout1_178) AT=620.05n

.meas tran vdout1_179ck610 FIND v(dout1_179) AT=620.05n

.meas tran vdout1_180ck610 FIND v(dout1_180) AT=620.05n

.meas tran vdout1_181ck610 FIND v(dout1_181) AT=620.05n

.meas tran vdout1_182ck610 FIND v(dout1_182) AT=620.05n

.meas tran vdout1_183ck610 FIND v(dout1_183) AT=620.05n

.meas tran vdout1_184ck610 FIND v(dout1_184) AT=620.05n

.meas tran vdout1_185ck610 FIND v(dout1_185) AT=620.05n

.meas tran vdout1_186ck610 FIND v(dout1_186) AT=620.05n

.meas tran vdout1_187ck610 FIND v(dout1_187) AT=620.05n

.meas tran vdout1_188ck610 FIND v(dout1_188) AT=620.05n

.meas tran vdout1_189ck610 FIND v(dout1_189) AT=620.05n

.meas tran vdout1_190ck610 FIND v(dout1_190) AT=620.05n

.meas tran vdout1_191ck610 FIND v(dout1_191) AT=620.05n

.meas tran vdout1_192ck610 FIND v(dout1_192) AT=620.05n

.meas tran vdout1_193ck610 FIND v(dout1_193) AT=620.05n

.meas tran vdout1_194ck610 FIND v(dout1_194) AT=620.05n

.meas tran vdout1_195ck610 FIND v(dout1_195) AT=620.05n

.meas tran vdout1_196ck610 FIND v(dout1_196) AT=620.05n

.meas tran vdout1_197ck610 FIND v(dout1_197) AT=620.05n

.meas tran vdout1_198ck610 FIND v(dout1_198) AT=620.05n

.meas tran vdout1_199ck610 FIND v(dout1_199) AT=620.05n

.meas tran vdout1_200ck610 FIND v(dout1_200) AT=620.05n

.meas tran vdout1_201ck610 FIND v(dout1_201) AT=620.05n

.meas tran vdout1_202ck610 FIND v(dout1_202) AT=620.05n

.meas tran vdout1_203ck610 FIND v(dout1_203) AT=620.05n

.meas tran vdout1_204ck610 FIND v(dout1_204) AT=620.05n

.meas tran vdout1_205ck610 FIND v(dout1_205) AT=620.05n

.meas tran vdout1_206ck610 FIND v(dout1_206) AT=620.05n

.meas tran vdout1_207ck610 FIND v(dout1_207) AT=620.05n

.meas tran vdout1_208ck610 FIND v(dout1_208) AT=620.05n

.meas tran vdout1_209ck610 FIND v(dout1_209) AT=620.05n

.meas tran vdout1_210ck610 FIND v(dout1_210) AT=620.05n

.meas tran vdout1_211ck610 FIND v(dout1_211) AT=620.05n

.meas tran vdout1_212ck610 FIND v(dout1_212) AT=620.05n

.meas tran vdout1_213ck610 FIND v(dout1_213) AT=620.05n

.meas tran vdout1_214ck610 FIND v(dout1_214) AT=620.05n

.meas tran vdout1_215ck610 FIND v(dout1_215) AT=620.05n

.meas tran vdout1_216ck610 FIND v(dout1_216) AT=620.05n

.meas tran vdout1_217ck610 FIND v(dout1_217) AT=620.05n

.meas tran vdout1_218ck610 FIND v(dout1_218) AT=620.05n

.meas tran vdout1_219ck610 FIND v(dout1_219) AT=620.05n

.meas tran vdout1_220ck610 FIND v(dout1_220) AT=620.05n

.meas tran vdout1_221ck610 FIND v(dout1_221) AT=620.05n

.meas tran vdout1_222ck610 FIND v(dout1_222) AT=620.05n

.meas tran vdout1_223ck610 FIND v(dout1_223) AT=620.05n

.meas tran vdout1_224ck610 FIND v(dout1_224) AT=620.05n

.meas tran vdout1_225ck610 FIND v(dout1_225) AT=620.05n

.meas tran vdout1_226ck610 FIND v(dout1_226) AT=620.05n

.meas tran vdout1_227ck610 FIND v(dout1_227) AT=620.05n

.meas tran vdout1_228ck610 FIND v(dout1_228) AT=620.05n

.meas tran vdout1_229ck610 FIND v(dout1_229) AT=620.05n

.meas tran vdout1_230ck610 FIND v(dout1_230) AT=620.05n

.meas tran vdout1_231ck610 FIND v(dout1_231) AT=620.05n

.meas tran vdout1_232ck610 FIND v(dout1_232) AT=620.05n

.meas tran vdout1_233ck610 FIND v(dout1_233) AT=620.05n

.meas tran vdout1_234ck610 FIND v(dout1_234) AT=620.05n

.meas tran vdout1_235ck610 FIND v(dout1_235) AT=620.05n

.meas tran vdout1_236ck610 FIND v(dout1_236) AT=620.05n

.meas tran vdout1_237ck610 FIND v(dout1_237) AT=620.05n

.meas tran vdout1_238ck610 FIND v(dout1_238) AT=620.05n

.meas tran vdout1_239ck610 FIND v(dout1_239) AT=620.05n

.meas tran vdout1_240ck610 FIND v(dout1_240) AT=620.05n

.meas tran vdout1_241ck610 FIND v(dout1_241) AT=620.05n

.meas tran vdout1_242ck610 FIND v(dout1_242) AT=620.05n

.meas tran vdout1_243ck610 FIND v(dout1_243) AT=620.05n

.meas tran vdout1_244ck610 FIND v(dout1_244) AT=620.05n

.meas tran vdout1_245ck610 FIND v(dout1_245) AT=620.05n

.meas tran vdout1_246ck610 FIND v(dout1_246) AT=620.05n

.meas tran vdout1_247ck610 FIND v(dout1_247) AT=620.05n

.meas tran vdout1_248ck610 FIND v(dout1_248) AT=620.05n

.meas tran vdout1_249ck610 FIND v(dout1_249) AT=620.05n

.meas tran vdout1_250ck610 FIND v(dout1_250) AT=620.05n

.meas tran vdout1_251ck610 FIND v(dout1_251) AT=620.05n

.meas tran vdout1_252ck610 FIND v(dout1_252) AT=620.05n

.meas tran vdout1_253ck610 FIND v(dout1_253) AT=620.05n

.meas tran vdout1_254ck610 FIND v(dout1_254) AT=620.05n

.meas tran vdout1_255ck610 FIND v(dout1_255) AT=620.05n

.meas tran vdout1_256ck610 FIND v(dout1_256) AT=620.05n

.meas tran vdout1_0ck620 FIND v(dout1_0) AT=630.05n

.meas tran vdout1_1ck620 FIND v(dout1_1) AT=630.05n

.meas tran vdout1_2ck620 FIND v(dout1_2) AT=630.05n

.meas tran vdout1_3ck620 FIND v(dout1_3) AT=630.05n

.meas tran vdout1_4ck620 FIND v(dout1_4) AT=630.05n

.meas tran vdout1_5ck620 FIND v(dout1_5) AT=630.05n

.meas tran vdout1_6ck620 FIND v(dout1_6) AT=630.05n

.meas tran vdout1_7ck620 FIND v(dout1_7) AT=630.05n

.meas tran vdout1_8ck620 FIND v(dout1_8) AT=630.05n

.meas tran vdout1_9ck620 FIND v(dout1_9) AT=630.05n

.meas tran vdout1_10ck620 FIND v(dout1_10) AT=630.05n

.meas tran vdout1_11ck620 FIND v(dout1_11) AT=630.05n

.meas tran vdout1_12ck620 FIND v(dout1_12) AT=630.05n

.meas tran vdout1_13ck620 FIND v(dout1_13) AT=630.05n

.meas tran vdout1_14ck620 FIND v(dout1_14) AT=630.05n

.meas tran vdout1_15ck620 FIND v(dout1_15) AT=630.05n

.meas tran vdout1_16ck620 FIND v(dout1_16) AT=630.05n

.meas tran vdout1_17ck620 FIND v(dout1_17) AT=630.05n

.meas tran vdout1_18ck620 FIND v(dout1_18) AT=630.05n

.meas tran vdout1_19ck620 FIND v(dout1_19) AT=630.05n

.meas tran vdout1_20ck620 FIND v(dout1_20) AT=630.05n

.meas tran vdout1_21ck620 FIND v(dout1_21) AT=630.05n

.meas tran vdout1_22ck620 FIND v(dout1_22) AT=630.05n

.meas tran vdout1_23ck620 FIND v(dout1_23) AT=630.05n

.meas tran vdout1_24ck620 FIND v(dout1_24) AT=630.05n

.meas tran vdout1_25ck620 FIND v(dout1_25) AT=630.05n

.meas tran vdout1_26ck620 FIND v(dout1_26) AT=630.05n

.meas tran vdout1_27ck620 FIND v(dout1_27) AT=630.05n

.meas tran vdout1_28ck620 FIND v(dout1_28) AT=630.05n

.meas tran vdout1_29ck620 FIND v(dout1_29) AT=630.05n

.meas tran vdout1_30ck620 FIND v(dout1_30) AT=630.05n

.meas tran vdout1_31ck620 FIND v(dout1_31) AT=630.05n

.meas tran vdout1_32ck620 FIND v(dout1_32) AT=630.05n

.meas tran vdout1_33ck620 FIND v(dout1_33) AT=630.05n

.meas tran vdout1_34ck620 FIND v(dout1_34) AT=630.05n

.meas tran vdout1_35ck620 FIND v(dout1_35) AT=630.05n

.meas tran vdout1_36ck620 FIND v(dout1_36) AT=630.05n

.meas tran vdout1_37ck620 FIND v(dout1_37) AT=630.05n

.meas tran vdout1_38ck620 FIND v(dout1_38) AT=630.05n

.meas tran vdout1_39ck620 FIND v(dout1_39) AT=630.05n

.meas tran vdout1_40ck620 FIND v(dout1_40) AT=630.05n

.meas tran vdout1_41ck620 FIND v(dout1_41) AT=630.05n

.meas tran vdout1_42ck620 FIND v(dout1_42) AT=630.05n

.meas tran vdout1_43ck620 FIND v(dout1_43) AT=630.05n

.meas tran vdout1_44ck620 FIND v(dout1_44) AT=630.05n

.meas tran vdout1_45ck620 FIND v(dout1_45) AT=630.05n

.meas tran vdout1_46ck620 FIND v(dout1_46) AT=630.05n

.meas tran vdout1_47ck620 FIND v(dout1_47) AT=630.05n

.meas tran vdout1_48ck620 FIND v(dout1_48) AT=630.05n

.meas tran vdout1_49ck620 FIND v(dout1_49) AT=630.05n

.meas tran vdout1_50ck620 FIND v(dout1_50) AT=630.05n

.meas tran vdout1_51ck620 FIND v(dout1_51) AT=630.05n

.meas tran vdout1_52ck620 FIND v(dout1_52) AT=630.05n

.meas tran vdout1_53ck620 FIND v(dout1_53) AT=630.05n

.meas tran vdout1_54ck620 FIND v(dout1_54) AT=630.05n

.meas tran vdout1_55ck620 FIND v(dout1_55) AT=630.05n

.meas tran vdout1_56ck620 FIND v(dout1_56) AT=630.05n

.meas tran vdout1_57ck620 FIND v(dout1_57) AT=630.05n

.meas tran vdout1_58ck620 FIND v(dout1_58) AT=630.05n

.meas tran vdout1_59ck620 FIND v(dout1_59) AT=630.05n

.meas tran vdout1_60ck620 FIND v(dout1_60) AT=630.05n

.meas tran vdout1_61ck620 FIND v(dout1_61) AT=630.05n

.meas tran vdout1_62ck620 FIND v(dout1_62) AT=630.05n

.meas tran vdout1_63ck620 FIND v(dout1_63) AT=630.05n

.meas tran vdout1_64ck620 FIND v(dout1_64) AT=630.05n

.meas tran vdout1_65ck620 FIND v(dout1_65) AT=630.05n

.meas tran vdout1_66ck620 FIND v(dout1_66) AT=630.05n

.meas tran vdout1_67ck620 FIND v(dout1_67) AT=630.05n

.meas tran vdout1_68ck620 FIND v(dout1_68) AT=630.05n

.meas tran vdout1_69ck620 FIND v(dout1_69) AT=630.05n

.meas tran vdout1_70ck620 FIND v(dout1_70) AT=630.05n

.meas tran vdout1_71ck620 FIND v(dout1_71) AT=630.05n

.meas tran vdout1_72ck620 FIND v(dout1_72) AT=630.05n

.meas tran vdout1_73ck620 FIND v(dout1_73) AT=630.05n

.meas tran vdout1_74ck620 FIND v(dout1_74) AT=630.05n

.meas tran vdout1_75ck620 FIND v(dout1_75) AT=630.05n

.meas tran vdout1_76ck620 FIND v(dout1_76) AT=630.05n

.meas tran vdout1_77ck620 FIND v(dout1_77) AT=630.05n

.meas tran vdout1_78ck620 FIND v(dout1_78) AT=630.05n

.meas tran vdout1_79ck620 FIND v(dout1_79) AT=630.05n

.meas tran vdout1_80ck620 FIND v(dout1_80) AT=630.05n

.meas tran vdout1_81ck620 FIND v(dout1_81) AT=630.05n

.meas tran vdout1_82ck620 FIND v(dout1_82) AT=630.05n

.meas tran vdout1_83ck620 FIND v(dout1_83) AT=630.05n

.meas tran vdout1_84ck620 FIND v(dout1_84) AT=630.05n

.meas tran vdout1_85ck620 FIND v(dout1_85) AT=630.05n

.meas tran vdout1_86ck620 FIND v(dout1_86) AT=630.05n

.meas tran vdout1_87ck620 FIND v(dout1_87) AT=630.05n

.meas tran vdout1_88ck620 FIND v(dout1_88) AT=630.05n

.meas tran vdout1_89ck620 FIND v(dout1_89) AT=630.05n

.meas tran vdout1_90ck620 FIND v(dout1_90) AT=630.05n

.meas tran vdout1_91ck620 FIND v(dout1_91) AT=630.05n

.meas tran vdout1_92ck620 FIND v(dout1_92) AT=630.05n

.meas tran vdout1_93ck620 FIND v(dout1_93) AT=630.05n

.meas tran vdout1_94ck620 FIND v(dout1_94) AT=630.05n

.meas tran vdout1_95ck620 FIND v(dout1_95) AT=630.05n

.meas tran vdout1_96ck620 FIND v(dout1_96) AT=630.05n

.meas tran vdout1_97ck620 FIND v(dout1_97) AT=630.05n

.meas tran vdout1_98ck620 FIND v(dout1_98) AT=630.05n

.meas tran vdout1_99ck620 FIND v(dout1_99) AT=630.05n

.meas tran vdout1_100ck620 FIND v(dout1_100) AT=630.05n

.meas tran vdout1_101ck620 FIND v(dout1_101) AT=630.05n

.meas tran vdout1_102ck620 FIND v(dout1_102) AT=630.05n

.meas tran vdout1_103ck620 FIND v(dout1_103) AT=630.05n

.meas tran vdout1_104ck620 FIND v(dout1_104) AT=630.05n

.meas tran vdout1_105ck620 FIND v(dout1_105) AT=630.05n

.meas tran vdout1_106ck620 FIND v(dout1_106) AT=630.05n

.meas tran vdout1_107ck620 FIND v(dout1_107) AT=630.05n

.meas tran vdout1_108ck620 FIND v(dout1_108) AT=630.05n

.meas tran vdout1_109ck620 FIND v(dout1_109) AT=630.05n

.meas tran vdout1_110ck620 FIND v(dout1_110) AT=630.05n

.meas tran vdout1_111ck620 FIND v(dout1_111) AT=630.05n

.meas tran vdout1_112ck620 FIND v(dout1_112) AT=630.05n

.meas tran vdout1_113ck620 FIND v(dout1_113) AT=630.05n

.meas tran vdout1_114ck620 FIND v(dout1_114) AT=630.05n

.meas tran vdout1_115ck620 FIND v(dout1_115) AT=630.05n

.meas tran vdout1_116ck620 FIND v(dout1_116) AT=630.05n

.meas tran vdout1_117ck620 FIND v(dout1_117) AT=630.05n

.meas tran vdout1_118ck620 FIND v(dout1_118) AT=630.05n

.meas tran vdout1_119ck620 FIND v(dout1_119) AT=630.05n

.meas tran vdout1_120ck620 FIND v(dout1_120) AT=630.05n

.meas tran vdout1_121ck620 FIND v(dout1_121) AT=630.05n

.meas tran vdout1_122ck620 FIND v(dout1_122) AT=630.05n

.meas tran vdout1_123ck620 FIND v(dout1_123) AT=630.05n

.meas tran vdout1_124ck620 FIND v(dout1_124) AT=630.05n

.meas tran vdout1_125ck620 FIND v(dout1_125) AT=630.05n

.meas tran vdout1_126ck620 FIND v(dout1_126) AT=630.05n

.meas tran vdout1_127ck620 FIND v(dout1_127) AT=630.05n

.meas tran vdout1_128ck620 FIND v(dout1_128) AT=630.05n

.meas tran vdout1_129ck620 FIND v(dout1_129) AT=630.05n

.meas tran vdout1_130ck620 FIND v(dout1_130) AT=630.05n

.meas tran vdout1_131ck620 FIND v(dout1_131) AT=630.05n

.meas tran vdout1_132ck620 FIND v(dout1_132) AT=630.05n

.meas tran vdout1_133ck620 FIND v(dout1_133) AT=630.05n

.meas tran vdout1_134ck620 FIND v(dout1_134) AT=630.05n

.meas tran vdout1_135ck620 FIND v(dout1_135) AT=630.05n

.meas tran vdout1_136ck620 FIND v(dout1_136) AT=630.05n

.meas tran vdout1_137ck620 FIND v(dout1_137) AT=630.05n

.meas tran vdout1_138ck620 FIND v(dout1_138) AT=630.05n

.meas tran vdout1_139ck620 FIND v(dout1_139) AT=630.05n

.meas tran vdout1_140ck620 FIND v(dout1_140) AT=630.05n

.meas tran vdout1_141ck620 FIND v(dout1_141) AT=630.05n

.meas tran vdout1_142ck620 FIND v(dout1_142) AT=630.05n

.meas tran vdout1_143ck620 FIND v(dout1_143) AT=630.05n

.meas tran vdout1_144ck620 FIND v(dout1_144) AT=630.05n

.meas tran vdout1_145ck620 FIND v(dout1_145) AT=630.05n

.meas tran vdout1_146ck620 FIND v(dout1_146) AT=630.05n

.meas tran vdout1_147ck620 FIND v(dout1_147) AT=630.05n

.meas tran vdout1_148ck620 FIND v(dout1_148) AT=630.05n

.meas tran vdout1_149ck620 FIND v(dout1_149) AT=630.05n

.meas tran vdout1_150ck620 FIND v(dout1_150) AT=630.05n

.meas tran vdout1_151ck620 FIND v(dout1_151) AT=630.05n

.meas tran vdout1_152ck620 FIND v(dout1_152) AT=630.05n

.meas tran vdout1_153ck620 FIND v(dout1_153) AT=630.05n

.meas tran vdout1_154ck620 FIND v(dout1_154) AT=630.05n

.meas tran vdout1_155ck620 FIND v(dout1_155) AT=630.05n

.meas tran vdout1_156ck620 FIND v(dout1_156) AT=630.05n

.meas tran vdout1_157ck620 FIND v(dout1_157) AT=630.05n

.meas tran vdout1_158ck620 FIND v(dout1_158) AT=630.05n

.meas tran vdout1_159ck620 FIND v(dout1_159) AT=630.05n

.meas tran vdout1_160ck620 FIND v(dout1_160) AT=630.05n

.meas tran vdout1_161ck620 FIND v(dout1_161) AT=630.05n

.meas tran vdout1_162ck620 FIND v(dout1_162) AT=630.05n

.meas tran vdout1_163ck620 FIND v(dout1_163) AT=630.05n

.meas tran vdout1_164ck620 FIND v(dout1_164) AT=630.05n

.meas tran vdout1_165ck620 FIND v(dout1_165) AT=630.05n

.meas tran vdout1_166ck620 FIND v(dout1_166) AT=630.05n

.meas tran vdout1_167ck620 FIND v(dout1_167) AT=630.05n

.meas tran vdout1_168ck620 FIND v(dout1_168) AT=630.05n

.meas tran vdout1_169ck620 FIND v(dout1_169) AT=630.05n

.meas tran vdout1_170ck620 FIND v(dout1_170) AT=630.05n

.meas tran vdout1_171ck620 FIND v(dout1_171) AT=630.05n

.meas tran vdout1_172ck620 FIND v(dout1_172) AT=630.05n

.meas tran vdout1_173ck620 FIND v(dout1_173) AT=630.05n

.meas tran vdout1_174ck620 FIND v(dout1_174) AT=630.05n

.meas tran vdout1_175ck620 FIND v(dout1_175) AT=630.05n

.meas tran vdout1_176ck620 FIND v(dout1_176) AT=630.05n

.meas tran vdout1_177ck620 FIND v(dout1_177) AT=630.05n

.meas tran vdout1_178ck620 FIND v(dout1_178) AT=630.05n

.meas tran vdout1_179ck620 FIND v(dout1_179) AT=630.05n

.meas tran vdout1_180ck620 FIND v(dout1_180) AT=630.05n

.meas tran vdout1_181ck620 FIND v(dout1_181) AT=630.05n

.meas tran vdout1_182ck620 FIND v(dout1_182) AT=630.05n

.meas tran vdout1_183ck620 FIND v(dout1_183) AT=630.05n

.meas tran vdout1_184ck620 FIND v(dout1_184) AT=630.05n

.meas tran vdout1_185ck620 FIND v(dout1_185) AT=630.05n

.meas tran vdout1_186ck620 FIND v(dout1_186) AT=630.05n

.meas tran vdout1_187ck620 FIND v(dout1_187) AT=630.05n

.meas tran vdout1_188ck620 FIND v(dout1_188) AT=630.05n

.meas tran vdout1_189ck620 FIND v(dout1_189) AT=630.05n

.meas tran vdout1_190ck620 FIND v(dout1_190) AT=630.05n

.meas tran vdout1_191ck620 FIND v(dout1_191) AT=630.05n

.meas tran vdout1_192ck620 FIND v(dout1_192) AT=630.05n

.meas tran vdout1_193ck620 FIND v(dout1_193) AT=630.05n

.meas tran vdout1_194ck620 FIND v(dout1_194) AT=630.05n

.meas tran vdout1_195ck620 FIND v(dout1_195) AT=630.05n

.meas tran vdout1_196ck620 FIND v(dout1_196) AT=630.05n

.meas tran vdout1_197ck620 FIND v(dout1_197) AT=630.05n

.meas tran vdout1_198ck620 FIND v(dout1_198) AT=630.05n

.meas tran vdout1_199ck620 FIND v(dout1_199) AT=630.05n

.meas tran vdout1_200ck620 FIND v(dout1_200) AT=630.05n

.meas tran vdout1_201ck620 FIND v(dout1_201) AT=630.05n

.meas tran vdout1_202ck620 FIND v(dout1_202) AT=630.05n

.meas tran vdout1_203ck620 FIND v(dout1_203) AT=630.05n

.meas tran vdout1_204ck620 FIND v(dout1_204) AT=630.05n

.meas tran vdout1_205ck620 FIND v(dout1_205) AT=630.05n

.meas tran vdout1_206ck620 FIND v(dout1_206) AT=630.05n

.meas tran vdout1_207ck620 FIND v(dout1_207) AT=630.05n

.meas tran vdout1_208ck620 FIND v(dout1_208) AT=630.05n

.meas tran vdout1_209ck620 FIND v(dout1_209) AT=630.05n

.meas tran vdout1_210ck620 FIND v(dout1_210) AT=630.05n

.meas tran vdout1_211ck620 FIND v(dout1_211) AT=630.05n

.meas tran vdout1_212ck620 FIND v(dout1_212) AT=630.05n

.meas tran vdout1_213ck620 FIND v(dout1_213) AT=630.05n

.meas tran vdout1_214ck620 FIND v(dout1_214) AT=630.05n

.meas tran vdout1_215ck620 FIND v(dout1_215) AT=630.05n

.meas tran vdout1_216ck620 FIND v(dout1_216) AT=630.05n

.meas tran vdout1_217ck620 FIND v(dout1_217) AT=630.05n

.meas tran vdout1_218ck620 FIND v(dout1_218) AT=630.05n

.meas tran vdout1_219ck620 FIND v(dout1_219) AT=630.05n

.meas tran vdout1_220ck620 FIND v(dout1_220) AT=630.05n

.meas tran vdout1_221ck620 FIND v(dout1_221) AT=630.05n

.meas tran vdout1_222ck620 FIND v(dout1_222) AT=630.05n

.meas tran vdout1_223ck620 FIND v(dout1_223) AT=630.05n

.meas tran vdout1_224ck620 FIND v(dout1_224) AT=630.05n

.meas tran vdout1_225ck620 FIND v(dout1_225) AT=630.05n

.meas tran vdout1_226ck620 FIND v(dout1_226) AT=630.05n

.meas tran vdout1_227ck620 FIND v(dout1_227) AT=630.05n

.meas tran vdout1_228ck620 FIND v(dout1_228) AT=630.05n

.meas tran vdout1_229ck620 FIND v(dout1_229) AT=630.05n

.meas tran vdout1_230ck620 FIND v(dout1_230) AT=630.05n

.meas tran vdout1_231ck620 FIND v(dout1_231) AT=630.05n

.meas tran vdout1_232ck620 FIND v(dout1_232) AT=630.05n

.meas tran vdout1_233ck620 FIND v(dout1_233) AT=630.05n

.meas tran vdout1_234ck620 FIND v(dout1_234) AT=630.05n

.meas tran vdout1_235ck620 FIND v(dout1_235) AT=630.05n

.meas tran vdout1_236ck620 FIND v(dout1_236) AT=630.05n

.meas tran vdout1_237ck620 FIND v(dout1_237) AT=630.05n

.meas tran vdout1_238ck620 FIND v(dout1_238) AT=630.05n

.meas tran vdout1_239ck620 FIND v(dout1_239) AT=630.05n

.meas tran vdout1_240ck620 FIND v(dout1_240) AT=630.05n

.meas tran vdout1_241ck620 FIND v(dout1_241) AT=630.05n

.meas tran vdout1_242ck620 FIND v(dout1_242) AT=630.05n

.meas tran vdout1_243ck620 FIND v(dout1_243) AT=630.05n

.meas tran vdout1_244ck620 FIND v(dout1_244) AT=630.05n

.meas tran vdout1_245ck620 FIND v(dout1_245) AT=630.05n

.meas tran vdout1_246ck620 FIND v(dout1_246) AT=630.05n

.meas tran vdout1_247ck620 FIND v(dout1_247) AT=630.05n

.meas tran vdout1_248ck620 FIND v(dout1_248) AT=630.05n

.meas tran vdout1_249ck620 FIND v(dout1_249) AT=630.05n

.meas tran vdout1_250ck620 FIND v(dout1_250) AT=630.05n

.meas tran vdout1_251ck620 FIND v(dout1_251) AT=630.05n

.meas tran vdout1_252ck620 FIND v(dout1_252) AT=630.05n

.meas tran vdout1_253ck620 FIND v(dout1_253) AT=630.05n

.meas tran vdout1_254ck620 FIND v(dout1_254) AT=630.05n

.meas tran vdout1_255ck620 FIND v(dout1_255) AT=630.05n

.meas tran vdout1_256ck620 FIND v(dout1_256) AT=630.05n

.meas tran vdout1_0ck630 FIND v(dout1_0) AT=640.05n

.meas tran vdout1_1ck630 FIND v(dout1_1) AT=640.05n

.meas tran vdout1_2ck630 FIND v(dout1_2) AT=640.05n

.meas tran vdout1_3ck630 FIND v(dout1_3) AT=640.05n

.meas tran vdout1_4ck630 FIND v(dout1_4) AT=640.05n

.meas tran vdout1_5ck630 FIND v(dout1_5) AT=640.05n

.meas tran vdout1_6ck630 FIND v(dout1_6) AT=640.05n

.meas tran vdout1_7ck630 FIND v(dout1_7) AT=640.05n

.meas tran vdout1_8ck630 FIND v(dout1_8) AT=640.05n

.meas tran vdout1_9ck630 FIND v(dout1_9) AT=640.05n

.meas tran vdout1_10ck630 FIND v(dout1_10) AT=640.05n

.meas tran vdout1_11ck630 FIND v(dout1_11) AT=640.05n

.meas tran vdout1_12ck630 FIND v(dout1_12) AT=640.05n

.meas tran vdout1_13ck630 FIND v(dout1_13) AT=640.05n

.meas tran vdout1_14ck630 FIND v(dout1_14) AT=640.05n

.meas tran vdout1_15ck630 FIND v(dout1_15) AT=640.05n

.meas tran vdout1_16ck630 FIND v(dout1_16) AT=640.05n

.meas tran vdout1_17ck630 FIND v(dout1_17) AT=640.05n

.meas tran vdout1_18ck630 FIND v(dout1_18) AT=640.05n

.meas tran vdout1_19ck630 FIND v(dout1_19) AT=640.05n

.meas tran vdout1_20ck630 FIND v(dout1_20) AT=640.05n

.meas tran vdout1_21ck630 FIND v(dout1_21) AT=640.05n

.meas tran vdout1_22ck630 FIND v(dout1_22) AT=640.05n

.meas tran vdout1_23ck630 FIND v(dout1_23) AT=640.05n

.meas tran vdout1_24ck630 FIND v(dout1_24) AT=640.05n

.meas tran vdout1_25ck630 FIND v(dout1_25) AT=640.05n

.meas tran vdout1_26ck630 FIND v(dout1_26) AT=640.05n

.meas tran vdout1_27ck630 FIND v(dout1_27) AT=640.05n

.meas tran vdout1_28ck630 FIND v(dout1_28) AT=640.05n

.meas tran vdout1_29ck630 FIND v(dout1_29) AT=640.05n

.meas tran vdout1_30ck630 FIND v(dout1_30) AT=640.05n

.meas tran vdout1_31ck630 FIND v(dout1_31) AT=640.05n

.meas tran vdout1_32ck630 FIND v(dout1_32) AT=640.05n

.meas tran vdout1_33ck630 FIND v(dout1_33) AT=640.05n

.meas tran vdout1_34ck630 FIND v(dout1_34) AT=640.05n

.meas tran vdout1_35ck630 FIND v(dout1_35) AT=640.05n

.meas tran vdout1_36ck630 FIND v(dout1_36) AT=640.05n

.meas tran vdout1_37ck630 FIND v(dout1_37) AT=640.05n

.meas tran vdout1_38ck630 FIND v(dout1_38) AT=640.05n

.meas tran vdout1_39ck630 FIND v(dout1_39) AT=640.05n

.meas tran vdout1_40ck630 FIND v(dout1_40) AT=640.05n

.meas tran vdout1_41ck630 FIND v(dout1_41) AT=640.05n

.meas tran vdout1_42ck630 FIND v(dout1_42) AT=640.05n

.meas tran vdout1_43ck630 FIND v(dout1_43) AT=640.05n

.meas tran vdout1_44ck630 FIND v(dout1_44) AT=640.05n

.meas tran vdout1_45ck630 FIND v(dout1_45) AT=640.05n

.meas tran vdout1_46ck630 FIND v(dout1_46) AT=640.05n

.meas tran vdout1_47ck630 FIND v(dout1_47) AT=640.05n

.meas tran vdout1_48ck630 FIND v(dout1_48) AT=640.05n

.meas tran vdout1_49ck630 FIND v(dout1_49) AT=640.05n

.meas tran vdout1_50ck630 FIND v(dout1_50) AT=640.05n

.meas tran vdout1_51ck630 FIND v(dout1_51) AT=640.05n

.meas tran vdout1_52ck630 FIND v(dout1_52) AT=640.05n

.meas tran vdout1_53ck630 FIND v(dout1_53) AT=640.05n

.meas tran vdout1_54ck630 FIND v(dout1_54) AT=640.05n

.meas tran vdout1_55ck630 FIND v(dout1_55) AT=640.05n

.meas tran vdout1_56ck630 FIND v(dout1_56) AT=640.05n

.meas tran vdout1_57ck630 FIND v(dout1_57) AT=640.05n

.meas tran vdout1_58ck630 FIND v(dout1_58) AT=640.05n

.meas tran vdout1_59ck630 FIND v(dout1_59) AT=640.05n

.meas tran vdout1_60ck630 FIND v(dout1_60) AT=640.05n

.meas tran vdout1_61ck630 FIND v(dout1_61) AT=640.05n

.meas tran vdout1_62ck630 FIND v(dout1_62) AT=640.05n

.meas tran vdout1_63ck630 FIND v(dout1_63) AT=640.05n

.meas tran vdout1_64ck630 FIND v(dout1_64) AT=640.05n

.meas tran vdout1_65ck630 FIND v(dout1_65) AT=640.05n

.meas tran vdout1_66ck630 FIND v(dout1_66) AT=640.05n

.meas tran vdout1_67ck630 FIND v(dout1_67) AT=640.05n

.meas tran vdout1_68ck630 FIND v(dout1_68) AT=640.05n

.meas tran vdout1_69ck630 FIND v(dout1_69) AT=640.05n

.meas tran vdout1_70ck630 FIND v(dout1_70) AT=640.05n

.meas tran vdout1_71ck630 FIND v(dout1_71) AT=640.05n

.meas tran vdout1_72ck630 FIND v(dout1_72) AT=640.05n

.meas tran vdout1_73ck630 FIND v(dout1_73) AT=640.05n

.meas tran vdout1_74ck630 FIND v(dout1_74) AT=640.05n

.meas tran vdout1_75ck630 FIND v(dout1_75) AT=640.05n

.meas tran vdout1_76ck630 FIND v(dout1_76) AT=640.05n

.meas tran vdout1_77ck630 FIND v(dout1_77) AT=640.05n

.meas tran vdout1_78ck630 FIND v(dout1_78) AT=640.05n

.meas tran vdout1_79ck630 FIND v(dout1_79) AT=640.05n

.meas tran vdout1_80ck630 FIND v(dout1_80) AT=640.05n

.meas tran vdout1_81ck630 FIND v(dout1_81) AT=640.05n

.meas tran vdout1_82ck630 FIND v(dout1_82) AT=640.05n

.meas tran vdout1_83ck630 FIND v(dout1_83) AT=640.05n

.meas tran vdout1_84ck630 FIND v(dout1_84) AT=640.05n

.meas tran vdout1_85ck630 FIND v(dout1_85) AT=640.05n

.meas tran vdout1_86ck630 FIND v(dout1_86) AT=640.05n

.meas tran vdout1_87ck630 FIND v(dout1_87) AT=640.05n

.meas tran vdout1_88ck630 FIND v(dout1_88) AT=640.05n

.meas tran vdout1_89ck630 FIND v(dout1_89) AT=640.05n

.meas tran vdout1_90ck630 FIND v(dout1_90) AT=640.05n

.meas tran vdout1_91ck630 FIND v(dout1_91) AT=640.05n

.meas tran vdout1_92ck630 FIND v(dout1_92) AT=640.05n

.meas tran vdout1_93ck630 FIND v(dout1_93) AT=640.05n

.meas tran vdout1_94ck630 FIND v(dout1_94) AT=640.05n

.meas tran vdout1_95ck630 FIND v(dout1_95) AT=640.05n

.meas tran vdout1_96ck630 FIND v(dout1_96) AT=640.05n

.meas tran vdout1_97ck630 FIND v(dout1_97) AT=640.05n

.meas tran vdout1_98ck630 FIND v(dout1_98) AT=640.05n

.meas tran vdout1_99ck630 FIND v(dout1_99) AT=640.05n

.meas tran vdout1_100ck630 FIND v(dout1_100) AT=640.05n

.meas tran vdout1_101ck630 FIND v(dout1_101) AT=640.05n

.meas tran vdout1_102ck630 FIND v(dout1_102) AT=640.05n

.meas tran vdout1_103ck630 FIND v(dout1_103) AT=640.05n

.meas tran vdout1_104ck630 FIND v(dout1_104) AT=640.05n

.meas tran vdout1_105ck630 FIND v(dout1_105) AT=640.05n

.meas tran vdout1_106ck630 FIND v(dout1_106) AT=640.05n

.meas tran vdout1_107ck630 FIND v(dout1_107) AT=640.05n

.meas tran vdout1_108ck630 FIND v(dout1_108) AT=640.05n

.meas tran vdout1_109ck630 FIND v(dout1_109) AT=640.05n

.meas tran vdout1_110ck630 FIND v(dout1_110) AT=640.05n

.meas tran vdout1_111ck630 FIND v(dout1_111) AT=640.05n

.meas tran vdout1_112ck630 FIND v(dout1_112) AT=640.05n

.meas tran vdout1_113ck630 FIND v(dout1_113) AT=640.05n

.meas tran vdout1_114ck630 FIND v(dout1_114) AT=640.05n

.meas tran vdout1_115ck630 FIND v(dout1_115) AT=640.05n

.meas tran vdout1_116ck630 FIND v(dout1_116) AT=640.05n

.meas tran vdout1_117ck630 FIND v(dout1_117) AT=640.05n

.meas tran vdout1_118ck630 FIND v(dout1_118) AT=640.05n

.meas tran vdout1_119ck630 FIND v(dout1_119) AT=640.05n

.meas tran vdout1_120ck630 FIND v(dout1_120) AT=640.05n

.meas tran vdout1_121ck630 FIND v(dout1_121) AT=640.05n

.meas tran vdout1_122ck630 FIND v(dout1_122) AT=640.05n

.meas tran vdout1_123ck630 FIND v(dout1_123) AT=640.05n

.meas tran vdout1_124ck630 FIND v(dout1_124) AT=640.05n

.meas tran vdout1_125ck630 FIND v(dout1_125) AT=640.05n

.meas tran vdout1_126ck630 FIND v(dout1_126) AT=640.05n

.meas tran vdout1_127ck630 FIND v(dout1_127) AT=640.05n

.meas tran vdout1_128ck630 FIND v(dout1_128) AT=640.05n

.meas tran vdout1_129ck630 FIND v(dout1_129) AT=640.05n

.meas tran vdout1_130ck630 FIND v(dout1_130) AT=640.05n

.meas tran vdout1_131ck630 FIND v(dout1_131) AT=640.05n

.meas tran vdout1_132ck630 FIND v(dout1_132) AT=640.05n

.meas tran vdout1_133ck630 FIND v(dout1_133) AT=640.05n

.meas tran vdout1_134ck630 FIND v(dout1_134) AT=640.05n

.meas tran vdout1_135ck630 FIND v(dout1_135) AT=640.05n

.meas tran vdout1_136ck630 FIND v(dout1_136) AT=640.05n

.meas tran vdout1_137ck630 FIND v(dout1_137) AT=640.05n

.meas tran vdout1_138ck630 FIND v(dout1_138) AT=640.05n

.meas tran vdout1_139ck630 FIND v(dout1_139) AT=640.05n

.meas tran vdout1_140ck630 FIND v(dout1_140) AT=640.05n

.meas tran vdout1_141ck630 FIND v(dout1_141) AT=640.05n

.meas tran vdout1_142ck630 FIND v(dout1_142) AT=640.05n

.meas tran vdout1_143ck630 FIND v(dout1_143) AT=640.05n

.meas tran vdout1_144ck630 FIND v(dout1_144) AT=640.05n

.meas tran vdout1_145ck630 FIND v(dout1_145) AT=640.05n

.meas tran vdout1_146ck630 FIND v(dout1_146) AT=640.05n

.meas tran vdout1_147ck630 FIND v(dout1_147) AT=640.05n

.meas tran vdout1_148ck630 FIND v(dout1_148) AT=640.05n

.meas tran vdout1_149ck630 FIND v(dout1_149) AT=640.05n

.meas tran vdout1_150ck630 FIND v(dout1_150) AT=640.05n

.meas tran vdout1_151ck630 FIND v(dout1_151) AT=640.05n

.meas tran vdout1_152ck630 FIND v(dout1_152) AT=640.05n

.meas tran vdout1_153ck630 FIND v(dout1_153) AT=640.05n

.meas tran vdout1_154ck630 FIND v(dout1_154) AT=640.05n

.meas tran vdout1_155ck630 FIND v(dout1_155) AT=640.05n

.meas tran vdout1_156ck630 FIND v(dout1_156) AT=640.05n

.meas tran vdout1_157ck630 FIND v(dout1_157) AT=640.05n

.meas tran vdout1_158ck630 FIND v(dout1_158) AT=640.05n

.meas tran vdout1_159ck630 FIND v(dout1_159) AT=640.05n

.meas tran vdout1_160ck630 FIND v(dout1_160) AT=640.05n

.meas tran vdout1_161ck630 FIND v(dout1_161) AT=640.05n

.meas tran vdout1_162ck630 FIND v(dout1_162) AT=640.05n

.meas tran vdout1_163ck630 FIND v(dout1_163) AT=640.05n

.meas tran vdout1_164ck630 FIND v(dout1_164) AT=640.05n

.meas tran vdout1_165ck630 FIND v(dout1_165) AT=640.05n

.meas tran vdout1_166ck630 FIND v(dout1_166) AT=640.05n

.meas tran vdout1_167ck630 FIND v(dout1_167) AT=640.05n

.meas tran vdout1_168ck630 FIND v(dout1_168) AT=640.05n

.meas tran vdout1_169ck630 FIND v(dout1_169) AT=640.05n

.meas tran vdout1_170ck630 FIND v(dout1_170) AT=640.05n

.meas tran vdout1_171ck630 FIND v(dout1_171) AT=640.05n

.meas tran vdout1_172ck630 FIND v(dout1_172) AT=640.05n

.meas tran vdout1_173ck630 FIND v(dout1_173) AT=640.05n

.meas tran vdout1_174ck630 FIND v(dout1_174) AT=640.05n

.meas tran vdout1_175ck630 FIND v(dout1_175) AT=640.05n

.meas tran vdout1_176ck630 FIND v(dout1_176) AT=640.05n

.meas tran vdout1_177ck630 FIND v(dout1_177) AT=640.05n

.meas tran vdout1_178ck630 FIND v(dout1_178) AT=640.05n

.meas tran vdout1_179ck630 FIND v(dout1_179) AT=640.05n

.meas tran vdout1_180ck630 FIND v(dout1_180) AT=640.05n

.meas tran vdout1_181ck630 FIND v(dout1_181) AT=640.05n

.meas tran vdout1_182ck630 FIND v(dout1_182) AT=640.05n

.meas tran vdout1_183ck630 FIND v(dout1_183) AT=640.05n

.meas tran vdout1_184ck630 FIND v(dout1_184) AT=640.05n

.meas tran vdout1_185ck630 FIND v(dout1_185) AT=640.05n

.meas tran vdout1_186ck630 FIND v(dout1_186) AT=640.05n

.meas tran vdout1_187ck630 FIND v(dout1_187) AT=640.05n

.meas tran vdout1_188ck630 FIND v(dout1_188) AT=640.05n

.meas tran vdout1_189ck630 FIND v(dout1_189) AT=640.05n

.meas tran vdout1_190ck630 FIND v(dout1_190) AT=640.05n

.meas tran vdout1_191ck630 FIND v(dout1_191) AT=640.05n

.meas tran vdout1_192ck630 FIND v(dout1_192) AT=640.05n

.meas tran vdout1_193ck630 FIND v(dout1_193) AT=640.05n

.meas tran vdout1_194ck630 FIND v(dout1_194) AT=640.05n

.meas tran vdout1_195ck630 FIND v(dout1_195) AT=640.05n

.meas tran vdout1_196ck630 FIND v(dout1_196) AT=640.05n

.meas tran vdout1_197ck630 FIND v(dout1_197) AT=640.05n

.meas tran vdout1_198ck630 FIND v(dout1_198) AT=640.05n

.meas tran vdout1_199ck630 FIND v(dout1_199) AT=640.05n

.meas tran vdout1_200ck630 FIND v(dout1_200) AT=640.05n

.meas tran vdout1_201ck630 FIND v(dout1_201) AT=640.05n

.meas tran vdout1_202ck630 FIND v(dout1_202) AT=640.05n

.meas tran vdout1_203ck630 FIND v(dout1_203) AT=640.05n

.meas tran vdout1_204ck630 FIND v(dout1_204) AT=640.05n

.meas tran vdout1_205ck630 FIND v(dout1_205) AT=640.05n

.meas tran vdout1_206ck630 FIND v(dout1_206) AT=640.05n

.meas tran vdout1_207ck630 FIND v(dout1_207) AT=640.05n

.meas tran vdout1_208ck630 FIND v(dout1_208) AT=640.05n

.meas tran vdout1_209ck630 FIND v(dout1_209) AT=640.05n

.meas tran vdout1_210ck630 FIND v(dout1_210) AT=640.05n

.meas tran vdout1_211ck630 FIND v(dout1_211) AT=640.05n

.meas tran vdout1_212ck630 FIND v(dout1_212) AT=640.05n

.meas tran vdout1_213ck630 FIND v(dout1_213) AT=640.05n

.meas tran vdout1_214ck630 FIND v(dout1_214) AT=640.05n

.meas tran vdout1_215ck630 FIND v(dout1_215) AT=640.05n

.meas tran vdout1_216ck630 FIND v(dout1_216) AT=640.05n

.meas tran vdout1_217ck630 FIND v(dout1_217) AT=640.05n

.meas tran vdout1_218ck630 FIND v(dout1_218) AT=640.05n

.meas tran vdout1_219ck630 FIND v(dout1_219) AT=640.05n

.meas tran vdout1_220ck630 FIND v(dout1_220) AT=640.05n

.meas tran vdout1_221ck630 FIND v(dout1_221) AT=640.05n

.meas tran vdout1_222ck630 FIND v(dout1_222) AT=640.05n

.meas tran vdout1_223ck630 FIND v(dout1_223) AT=640.05n

.meas tran vdout1_224ck630 FIND v(dout1_224) AT=640.05n

.meas tran vdout1_225ck630 FIND v(dout1_225) AT=640.05n

.meas tran vdout1_226ck630 FIND v(dout1_226) AT=640.05n

.meas tran vdout1_227ck630 FIND v(dout1_227) AT=640.05n

.meas tran vdout1_228ck630 FIND v(dout1_228) AT=640.05n

.meas tran vdout1_229ck630 FIND v(dout1_229) AT=640.05n

.meas tran vdout1_230ck630 FIND v(dout1_230) AT=640.05n

.meas tran vdout1_231ck630 FIND v(dout1_231) AT=640.05n

.meas tran vdout1_232ck630 FIND v(dout1_232) AT=640.05n

.meas tran vdout1_233ck630 FIND v(dout1_233) AT=640.05n

.meas tran vdout1_234ck630 FIND v(dout1_234) AT=640.05n

.meas tran vdout1_235ck630 FIND v(dout1_235) AT=640.05n

.meas tran vdout1_236ck630 FIND v(dout1_236) AT=640.05n

.meas tran vdout1_237ck630 FIND v(dout1_237) AT=640.05n

.meas tran vdout1_238ck630 FIND v(dout1_238) AT=640.05n

.meas tran vdout1_239ck630 FIND v(dout1_239) AT=640.05n

.meas tran vdout1_240ck630 FIND v(dout1_240) AT=640.05n

.meas tran vdout1_241ck630 FIND v(dout1_241) AT=640.05n

.meas tran vdout1_242ck630 FIND v(dout1_242) AT=640.05n

.meas tran vdout1_243ck630 FIND v(dout1_243) AT=640.05n

.meas tran vdout1_244ck630 FIND v(dout1_244) AT=640.05n

.meas tran vdout1_245ck630 FIND v(dout1_245) AT=640.05n

.meas tran vdout1_246ck630 FIND v(dout1_246) AT=640.05n

.meas tran vdout1_247ck630 FIND v(dout1_247) AT=640.05n

.meas tran vdout1_248ck630 FIND v(dout1_248) AT=640.05n

.meas tran vdout1_249ck630 FIND v(dout1_249) AT=640.05n

.meas tran vdout1_250ck630 FIND v(dout1_250) AT=640.05n

.meas tran vdout1_251ck630 FIND v(dout1_251) AT=640.05n

.meas tran vdout1_252ck630 FIND v(dout1_252) AT=640.05n

.meas tran vdout1_253ck630 FIND v(dout1_253) AT=640.05n

.meas tran vdout1_254ck630 FIND v(dout1_254) AT=640.05n

.meas tran vdout1_255ck630 FIND v(dout1_255) AT=640.05n

.meas tran vdout1_256ck630 FIND v(dout1_256) AT=640.05n

.meas tran vdout1_0ck670 FIND v(dout1_0) AT=680.05n

.meas tran vdout1_1ck670 FIND v(dout1_1) AT=680.05n

.meas tran vdout1_2ck670 FIND v(dout1_2) AT=680.05n

.meas tran vdout1_3ck670 FIND v(dout1_3) AT=680.05n

.meas tran vdout1_4ck670 FIND v(dout1_4) AT=680.05n

.meas tran vdout1_5ck670 FIND v(dout1_5) AT=680.05n

.meas tran vdout1_6ck670 FIND v(dout1_6) AT=680.05n

.meas tran vdout1_7ck670 FIND v(dout1_7) AT=680.05n

.meas tran vdout1_8ck670 FIND v(dout1_8) AT=680.05n

.meas tran vdout1_9ck670 FIND v(dout1_9) AT=680.05n

.meas tran vdout1_10ck670 FIND v(dout1_10) AT=680.05n

.meas tran vdout1_11ck670 FIND v(dout1_11) AT=680.05n

.meas tran vdout1_12ck670 FIND v(dout1_12) AT=680.05n

.meas tran vdout1_13ck670 FIND v(dout1_13) AT=680.05n

.meas tran vdout1_14ck670 FIND v(dout1_14) AT=680.05n

.meas tran vdout1_15ck670 FIND v(dout1_15) AT=680.05n

.meas tran vdout1_16ck670 FIND v(dout1_16) AT=680.05n

.meas tran vdout1_17ck670 FIND v(dout1_17) AT=680.05n

.meas tran vdout1_18ck670 FIND v(dout1_18) AT=680.05n

.meas tran vdout1_19ck670 FIND v(dout1_19) AT=680.05n

.meas tran vdout1_20ck670 FIND v(dout1_20) AT=680.05n

.meas tran vdout1_21ck670 FIND v(dout1_21) AT=680.05n

.meas tran vdout1_22ck670 FIND v(dout1_22) AT=680.05n

.meas tran vdout1_23ck670 FIND v(dout1_23) AT=680.05n

.meas tran vdout1_24ck670 FIND v(dout1_24) AT=680.05n

.meas tran vdout1_25ck670 FIND v(dout1_25) AT=680.05n

.meas tran vdout1_26ck670 FIND v(dout1_26) AT=680.05n

.meas tran vdout1_27ck670 FIND v(dout1_27) AT=680.05n

.meas tran vdout1_28ck670 FIND v(dout1_28) AT=680.05n

.meas tran vdout1_29ck670 FIND v(dout1_29) AT=680.05n

.meas tran vdout1_30ck670 FIND v(dout1_30) AT=680.05n

.meas tran vdout1_31ck670 FIND v(dout1_31) AT=680.05n

.meas tran vdout1_32ck670 FIND v(dout1_32) AT=680.05n

.meas tran vdout1_33ck670 FIND v(dout1_33) AT=680.05n

.meas tran vdout1_34ck670 FIND v(dout1_34) AT=680.05n

.meas tran vdout1_35ck670 FIND v(dout1_35) AT=680.05n

.meas tran vdout1_36ck670 FIND v(dout1_36) AT=680.05n

.meas tran vdout1_37ck670 FIND v(dout1_37) AT=680.05n

.meas tran vdout1_38ck670 FIND v(dout1_38) AT=680.05n

.meas tran vdout1_39ck670 FIND v(dout1_39) AT=680.05n

.meas tran vdout1_40ck670 FIND v(dout1_40) AT=680.05n

.meas tran vdout1_41ck670 FIND v(dout1_41) AT=680.05n

.meas tran vdout1_42ck670 FIND v(dout1_42) AT=680.05n

.meas tran vdout1_43ck670 FIND v(dout1_43) AT=680.05n

.meas tran vdout1_44ck670 FIND v(dout1_44) AT=680.05n

.meas tran vdout1_45ck670 FIND v(dout1_45) AT=680.05n

.meas tran vdout1_46ck670 FIND v(dout1_46) AT=680.05n

.meas tran vdout1_47ck670 FIND v(dout1_47) AT=680.05n

.meas tran vdout1_48ck670 FIND v(dout1_48) AT=680.05n

.meas tran vdout1_49ck670 FIND v(dout1_49) AT=680.05n

.meas tran vdout1_50ck670 FIND v(dout1_50) AT=680.05n

.meas tran vdout1_51ck670 FIND v(dout1_51) AT=680.05n

.meas tran vdout1_52ck670 FIND v(dout1_52) AT=680.05n

.meas tran vdout1_53ck670 FIND v(dout1_53) AT=680.05n

.meas tran vdout1_54ck670 FIND v(dout1_54) AT=680.05n

.meas tran vdout1_55ck670 FIND v(dout1_55) AT=680.05n

.meas tran vdout1_56ck670 FIND v(dout1_56) AT=680.05n

.meas tran vdout1_57ck670 FIND v(dout1_57) AT=680.05n

.meas tran vdout1_58ck670 FIND v(dout1_58) AT=680.05n

.meas tran vdout1_59ck670 FIND v(dout1_59) AT=680.05n

.meas tran vdout1_60ck670 FIND v(dout1_60) AT=680.05n

.meas tran vdout1_61ck670 FIND v(dout1_61) AT=680.05n

.meas tran vdout1_62ck670 FIND v(dout1_62) AT=680.05n

.meas tran vdout1_63ck670 FIND v(dout1_63) AT=680.05n

.meas tran vdout1_64ck670 FIND v(dout1_64) AT=680.05n

.meas tran vdout1_65ck670 FIND v(dout1_65) AT=680.05n

.meas tran vdout1_66ck670 FIND v(dout1_66) AT=680.05n

.meas tran vdout1_67ck670 FIND v(dout1_67) AT=680.05n

.meas tran vdout1_68ck670 FIND v(dout1_68) AT=680.05n

.meas tran vdout1_69ck670 FIND v(dout1_69) AT=680.05n

.meas tran vdout1_70ck670 FIND v(dout1_70) AT=680.05n

.meas tran vdout1_71ck670 FIND v(dout1_71) AT=680.05n

.meas tran vdout1_72ck670 FIND v(dout1_72) AT=680.05n

.meas tran vdout1_73ck670 FIND v(dout1_73) AT=680.05n

.meas tran vdout1_74ck670 FIND v(dout1_74) AT=680.05n

.meas tran vdout1_75ck670 FIND v(dout1_75) AT=680.05n

.meas tran vdout1_76ck670 FIND v(dout1_76) AT=680.05n

.meas tran vdout1_77ck670 FIND v(dout1_77) AT=680.05n

.meas tran vdout1_78ck670 FIND v(dout1_78) AT=680.05n

.meas tran vdout1_79ck670 FIND v(dout1_79) AT=680.05n

.meas tran vdout1_80ck670 FIND v(dout1_80) AT=680.05n

.meas tran vdout1_81ck670 FIND v(dout1_81) AT=680.05n

.meas tran vdout1_82ck670 FIND v(dout1_82) AT=680.05n

.meas tran vdout1_83ck670 FIND v(dout1_83) AT=680.05n

.meas tran vdout1_84ck670 FIND v(dout1_84) AT=680.05n

.meas tran vdout1_85ck670 FIND v(dout1_85) AT=680.05n

.meas tran vdout1_86ck670 FIND v(dout1_86) AT=680.05n

.meas tran vdout1_87ck670 FIND v(dout1_87) AT=680.05n

.meas tran vdout1_88ck670 FIND v(dout1_88) AT=680.05n

.meas tran vdout1_89ck670 FIND v(dout1_89) AT=680.05n

.meas tran vdout1_90ck670 FIND v(dout1_90) AT=680.05n

.meas tran vdout1_91ck670 FIND v(dout1_91) AT=680.05n

.meas tran vdout1_92ck670 FIND v(dout1_92) AT=680.05n

.meas tran vdout1_93ck670 FIND v(dout1_93) AT=680.05n

.meas tran vdout1_94ck670 FIND v(dout1_94) AT=680.05n

.meas tran vdout1_95ck670 FIND v(dout1_95) AT=680.05n

.meas tran vdout1_96ck670 FIND v(dout1_96) AT=680.05n

.meas tran vdout1_97ck670 FIND v(dout1_97) AT=680.05n

.meas tran vdout1_98ck670 FIND v(dout1_98) AT=680.05n

.meas tran vdout1_99ck670 FIND v(dout1_99) AT=680.05n

.meas tran vdout1_100ck670 FIND v(dout1_100) AT=680.05n

.meas tran vdout1_101ck670 FIND v(dout1_101) AT=680.05n

.meas tran vdout1_102ck670 FIND v(dout1_102) AT=680.05n

.meas tran vdout1_103ck670 FIND v(dout1_103) AT=680.05n

.meas tran vdout1_104ck670 FIND v(dout1_104) AT=680.05n

.meas tran vdout1_105ck670 FIND v(dout1_105) AT=680.05n

.meas tran vdout1_106ck670 FIND v(dout1_106) AT=680.05n

.meas tran vdout1_107ck670 FIND v(dout1_107) AT=680.05n

.meas tran vdout1_108ck670 FIND v(dout1_108) AT=680.05n

.meas tran vdout1_109ck670 FIND v(dout1_109) AT=680.05n

.meas tran vdout1_110ck670 FIND v(dout1_110) AT=680.05n

.meas tran vdout1_111ck670 FIND v(dout1_111) AT=680.05n

.meas tran vdout1_112ck670 FIND v(dout1_112) AT=680.05n

.meas tran vdout1_113ck670 FIND v(dout1_113) AT=680.05n

.meas tran vdout1_114ck670 FIND v(dout1_114) AT=680.05n

.meas tran vdout1_115ck670 FIND v(dout1_115) AT=680.05n

.meas tran vdout1_116ck670 FIND v(dout1_116) AT=680.05n

.meas tran vdout1_117ck670 FIND v(dout1_117) AT=680.05n

.meas tran vdout1_118ck670 FIND v(dout1_118) AT=680.05n

.meas tran vdout1_119ck670 FIND v(dout1_119) AT=680.05n

.meas tran vdout1_120ck670 FIND v(dout1_120) AT=680.05n

.meas tran vdout1_121ck670 FIND v(dout1_121) AT=680.05n

.meas tran vdout1_122ck670 FIND v(dout1_122) AT=680.05n

.meas tran vdout1_123ck670 FIND v(dout1_123) AT=680.05n

.meas tran vdout1_124ck670 FIND v(dout1_124) AT=680.05n

.meas tran vdout1_125ck670 FIND v(dout1_125) AT=680.05n

.meas tran vdout1_126ck670 FIND v(dout1_126) AT=680.05n

.meas tran vdout1_127ck670 FIND v(dout1_127) AT=680.05n

.meas tran vdout1_128ck670 FIND v(dout1_128) AT=680.05n

.meas tran vdout1_129ck670 FIND v(dout1_129) AT=680.05n

.meas tran vdout1_130ck670 FIND v(dout1_130) AT=680.05n

.meas tran vdout1_131ck670 FIND v(dout1_131) AT=680.05n

.meas tran vdout1_132ck670 FIND v(dout1_132) AT=680.05n

.meas tran vdout1_133ck670 FIND v(dout1_133) AT=680.05n

.meas tran vdout1_134ck670 FIND v(dout1_134) AT=680.05n

.meas tran vdout1_135ck670 FIND v(dout1_135) AT=680.05n

.meas tran vdout1_136ck670 FIND v(dout1_136) AT=680.05n

.meas tran vdout1_137ck670 FIND v(dout1_137) AT=680.05n

.meas tran vdout1_138ck670 FIND v(dout1_138) AT=680.05n

.meas tran vdout1_139ck670 FIND v(dout1_139) AT=680.05n

.meas tran vdout1_140ck670 FIND v(dout1_140) AT=680.05n

.meas tran vdout1_141ck670 FIND v(dout1_141) AT=680.05n

.meas tran vdout1_142ck670 FIND v(dout1_142) AT=680.05n

.meas tran vdout1_143ck670 FIND v(dout1_143) AT=680.05n

.meas tran vdout1_144ck670 FIND v(dout1_144) AT=680.05n

.meas tran vdout1_145ck670 FIND v(dout1_145) AT=680.05n

.meas tran vdout1_146ck670 FIND v(dout1_146) AT=680.05n

.meas tran vdout1_147ck670 FIND v(dout1_147) AT=680.05n

.meas tran vdout1_148ck670 FIND v(dout1_148) AT=680.05n

.meas tran vdout1_149ck670 FIND v(dout1_149) AT=680.05n

.meas tran vdout1_150ck670 FIND v(dout1_150) AT=680.05n

.meas tran vdout1_151ck670 FIND v(dout1_151) AT=680.05n

.meas tran vdout1_152ck670 FIND v(dout1_152) AT=680.05n

.meas tran vdout1_153ck670 FIND v(dout1_153) AT=680.05n

.meas tran vdout1_154ck670 FIND v(dout1_154) AT=680.05n

.meas tran vdout1_155ck670 FIND v(dout1_155) AT=680.05n

.meas tran vdout1_156ck670 FIND v(dout1_156) AT=680.05n

.meas tran vdout1_157ck670 FIND v(dout1_157) AT=680.05n

.meas tran vdout1_158ck670 FIND v(dout1_158) AT=680.05n

.meas tran vdout1_159ck670 FIND v(dout1_159) AT=680.05n

.meas tran vdout1_160ck670 FIND v(dout1_160) AT=680.05n

.meas tran vdout1_161ck670 FIND v(dout1_161) AT=680.05n

.meas tran vdout1_162ck670 FIND v(dout1_162) AT=680.05n

.meas tran vdout1_163ck670 FIND v(dout1_163) AT=680.05n

.meas tran vdout1_164ck670 FIND v(dout1_164) AT=680.05n

.meas tran vdout1_165ck670 FIND v(dout1_165) AT=680.05n

.meas tran vdout1_166ck670 FIND v(dout1_166) AT=680.05n

.meas tran vdout1_167ck670 FIND v(dout1_167) AT=680.05n

.meas tran vdout1_168ck670 FIND v(dout1_168) AT=680.05n

.meas tran vdout1_169ck670 FIND v(dout1_169) AT=680.05n

.meas tran vdout1_170ck670 FIND v(dout1_170) AT=680.05n

.meas tran vdout1_171ck670 FIND v(dout1_171) AT=680.05n

.meas tran vdout1_172ck670 FIND v(dout1_172) AT=680.05n

.meas tran vdout1_173ck670 FIND v(dout1_173) AT=680.05n

.meas tran vdout1_174ck670 FIND v(dout1_174) AT=680.05n

.meas tran vdout1_175ck670 FIND v(dout1_175) AT=680.05n

.meas tran vdout1_176ck670 FIND v(dout1_176) AT=680.05n

.meas tran vdout1_177ck670 FIND v(dout1_177) AT=680.05n

.meas tran vdout1_178ck670 FIND v(dout1_178) AT=680.05n

.meas tran vdout1_179ck670 FIND v(dout1_179) AT=680.05n

.meas tran vdout1_180ck670 FIND v(dout1_180) AT=680.05n

.meas tran vdout1_181ck670 FIND v(dout1_181) AT=680.05n

.meas tran vdout1_182ck670 FIND v(dout1_182) AT=680.05n

.meas tran vdout1_183ck670 FIND v(dout1_183) AT=680.05n

.meas tran vdout1_184ck670 FIND v(dout1_184) AT=680.05n

.meas tran vdout1_185ck670 FIND v(dout1_185) AT=680.05n

.meas tran vdout1_186ck670 FIND v(dout1_186) AT=680.05n

.meas tran vdout1_187ck670 FIND v(dout1_187) AT=680.05n

.meas tran vdout1_188ck670 FIND v(dout1_188) AT=680.05n

.meas tran vdout1_189ck670 FIND v(dout1_189) AT=680.05n

.meas tran vdout1_190ck670 FIND v(dout1_190) AT=680.05n

.meas tran vdout1_191ck670 FIND v(dout1_191) AT=680.05n

.meas tran vdout1_192ck670 FIND v(dout1_192) AT=680.05n

.meas tran vdout1_193ck670 FIND v(dout1_193) AT=680.05n

.meas tran vdout1_194ck670 FIND v(dout1_194) AT=680.05n

.meas tran vdout1_195ck670 FIND v(dout1_195) AT=680.05n

.meas tran vdout1_196ck670 FIND v(dout1_196) AT=680.05n

.meas tran vdout1_197ck670 FIND v(dout1_197) AT=680.05n

.meas tran vdout1_198ck670 FIND v(dout1_198) AT=680.05n

.meas tran vdout1_199ck670 FIND v(dout1_199) AT=680.05n

.meas tran vdout1_200ck670 FIND v(dout1_200) AT=680.05n

.meas tran vdout1_201ck670 FIND v(dout1_201) AT=680.05n

.meas tran vdout1_202ck670 FIND v(dout1_202) AT=680.05n

.meas tran vdout1_203ck670 FIND v(dout1_203) AT=680.05n

.meas tran vdout1_204ck670 FIND v(dout1_204) AT=680.05n

.meas tran vdout1_205ck670 FIND v(dout1_205) AT=680.05n

.meas tran vdout1_206ck670 FIND v(dout1_206) AT=680.05n

.meas tran vdout1_207ck670 FIND v(dout1_207) AT=680.05n

.meas tran vdout1_208ck670 FIND v(dout1_208) AT=680.05n

.meas tran vdout1_209ck670 FIND v(dout1_209) AT=680.05n

.meas tran vdout1_210ck670 FIND v(dout1_210) AT=680.05n

.meas tran vdout1_211ck670 FIND v(dout1_211) AT=680.05n

.meas tran vdout1_212ck670 FIND v(dout1_212) AT=680.05n

.meas tran vdout1_213ck670 FIND v(dout1_213) AT=680.05n

.meas tran vdout1_214ck670 FIND v(dout1_214) AT=680.05n

.meas tran vdout1_215ck670 FIND v(dout1_215) AT=680.05n

.meas tran vdout1_216ck670 FIND v(dout1_216) AT=680.05n

.meas tran vdout1_217ck670 FIND v(dout1_217) AT=680.05n

.meas tran vdout1_218ck670 FIND v(dout1_218) AT=680.05n

.meas tran vdout1_219ck670 FIND v(dout1_219) AT=680.05n

.meas tran vdout1_220ck670 FIND v(dout1_220) AT=680.05n

.meas tran vdout1_221ck670 FIND v(dout1_221) AT=680.05n

.meas tran vdout1_222ck670 FIND v(dout1_222) AT=680.05n

.meas tran vdout1_223ck670 FIND v(dout1_223) AT=680.05n

.meas tran vdout1_224ck670 FIND v(dout1_224) AT=680.05n

.meas tran vdout1_225ck670 FIND v(dout1_225) AT=680.05n

.meas tran vdout1_226ck670 FIND v(dout1_226) AT=680.05n

.meas tran vdout1_227ck670 FIND v(dout1_227) AT=680.05n

.meas tran vdout1_228ck670 FIND v(dout1_228) AT=680.05n

.meas tran vdout1_229ck670 FIND v(dout1_229) AT=680.05n

.meas tran vdout1_230ck670 FIND v(dout1_230) AT=680.05n

.meas tran vdout1_231ck670 FIND v(dout1_231) AT=680.05n

.meas tran vdout1_232ck670 FIND v(dout1_232) AT=680.05n

.meas tran vdout1_233ck670 FIND v(dout1_233) AT=680.05n

.meas tran vdout1_234ck670 FIND v(dout1_234) AT=680.05n

.meas tran vdout1_235ck670 FIND v(dout1_235) AT=680.05n

.meas tran vdout1_236ck670 FIND v(dout1_236) AT=680.05n

.meas tran vdout1_237ck670 FIND v(dout1_237) AT=680.05n

.meas tran vdout1_238ck670 FIND v(dout1_238) AT=680.05n

.meas tran vdout1_239ck670 FIND v(dout1_239) AT=680.05n

.meas tran vdout1_240ck670 FIND v(dout1_240) AT=680.05n

.meas tran vdout1_241ck670 FIND v(dout1_241) AT=680.05n

.meas tran vdout1_242ck670 FIND v(dout1_242) AT=680.05n

.meas tran vdout1_243ck670 FIND v(dout1_243) AT=680.05n

.meas tran vdout1_244ck670 FIND v(dout1_244) AT=680.05n

.meas tran vdout1_245ck670 FIND v(dout1_245) AT=680.05n

.meas tran vdout1_246ck670 FIND v(dout1_246) AT=680.05n

.meas tran vdout1_247ck670 FIND v(dout1_247) AT=680.05n

.meas tran vdout1_248ck670 FIND v(dout1_248) AT=680.05n

.meas tran vdout1_249ck670 FIND v(dout1_249) AT=680.05n

.meas tran vdout1_250ck670 FIND v(dout1_250) AT=680.05n

.meas tran vdout1_251ck670 FIND v(dout1_251) AT=680.05n

.meas tran vdout1_252ck670 FIND v(dout1_252) AT=680.05n

.meas tran vdout1_253ck670 FIND v(dout1_253) AT=680.05n

.meas tran vdout1_254ck670 FIND v(dout1_254) AT=680.05n

.meas tran vdout1_255ck670 FIND v(dout1_255) AT=680.05n

.meas tran vdout1_256ck670 FIND v(dout1_256) AT=680.05n

.meas tran vdout1_0ck710 FIND v(dout1_0) AT=720.05n

.meas tran vdout1_1ck710 FIND v(dout1_1) AT=720.05n

.meas tran vdout1_2ck710 FIND v(dout1_2) AT=720.05n

.meas tran vdout1_3ck710 FIND v(dout1_3) AT=720.05n

.meas tran vdout1_4ck710 FIND v(dout1_4) AT=720.05n

.meas tran vdout1_5ck710 FIND v(dout1_5) AT=720.05n

.meas tran vdout1_6ck710 FIND v(dout1_6) AT=720.05n

.meas tran vdout1_7ck710 FIND v(dout1_7) AT=720.05n

.meas tran vdout1_8ck710 FIND v(dout1_8) AT=720.05n

.meas tran vdout1_9ck710 FIND v(dout1_9) AT=720.05n

.meas tran vdout1_10ck710 FIND v(dout1_10) AT=720.05n

.meas tran vdout1_11ck710 FIND v(dout1_11) AT=720.05n

.meas tran vdout1_12ck710 FIND v(dout1_12) AT=720.05n

.meas tran vdout1_13ck710 FIND v(dout1_13) AT=720.05n

.meas tran vdout1_14ck710 FIND v(dout1_14) AT=720.05n

.meas tran vdout1_15ck710 FIND v(dout1_15) AT=720.05n

.meas tran vdout1_16ck710 FIND v(dout1_16) AT=720.05n

.meas tran vdout1_17ck710 FIND v(dout1_17) AT=720.05n

.meas tran vdout1_18ck710 FIND v(dout1_18) AT=720.05n

.meas tran vdout1_19ck710 FIND v(dout1_19) AT=720.05n

.meas tran vdout1_20ck710 FIND v(dout1_20) AT=720.05n

.meas tran vdout1_21ck710 FIND v(dout1_21) AT=720.05n

.meas tran vdout1_22ck710 FIND v(dout1_22) AT=720.05n

.meas tran vdout1_23ck710 FIND v(dout1_23) AT=720.05n

.meas tran vdout1_24ck710 FIND v(dout1_24) AT=720.05n

.meas tran vdout1_25ck710 FIND v(dout1_25) AT=720.05n

.meas tran vdout1_26ck710 FIND v(dout1_26) AT=720.05n

.meas tran vdout1_27ck710 FIND v(dout1_27) AT=720.05n

.meas tran vdout1_28ck710 FIND v(dout1_28) AT=720.05n

.meas tran vdout1_29ck710 FIND v(dout1_29) AT=720.05n

.meas tran vdout1_30ck710 FIND v(dout1_30) AT=720.05n

.meas tran vdout1_31ck710 FIND v(dout1_31) AT=720.05n

.meas tran vdout1_32ck710 FIND v(dout1_32) AT=720.05n

.meas tran vdout1_33ck710 FIND v(dout1_33) AT=720.05n

.meas tran vdout1_34ck710 FIND v(dout1_34) AT=720.05n

.meas tran vdout1_35ck710 FIND v(dout1_35) AT=720.05n

.meas tran vdout1_36ck710 FIND v(dout1_36) AT=720.05n

.meas tran vdout1_37ck710 FIND v(dout1_37) AT=720.05n

.meas tran vdout1_38ck710 FIND v(dout1_38) AT=720.05n

.meas tran vdout1_39ck710 FIND v(dout1_39) AT=720.05n

.meas tran vdout1_40ck710 FIND v(dout1_40) AT=720.05n

.meas tran vdout1_41ck710 FIND v(dout1_41) AT=720.05n

.meas tran vdout1_42ck710 FIND v(dout1_42) AT=720.05n

.meas tran vdout1_43ck710 FIND v(dout1_43) AT=720.05n

.meas tran vdout1_44ck710 FIND v(dout1_44) AT=720.05n

.meas tran vdout1_45ck710 FIND v(dout1_45) AT=720.05n

.meas tran vdout1_46ck710 FIND v(dout1_46) AT=720.05n

.meas tran vdout1_47ck710 FIND v(dout1_47) AT=720.05n

.meas tran vdout1_48ck710 FIND v(dout1_48) AT=720.05n

.meas tran vdout1_49ck710 FIND v(dout1_49) AT=720.05n

.meas tran vdout1_50ck710 FIND v(dout1_50) AT=720.05n

.meas tran vdout1_51ck710 FIND v(dout1_51) AT=720.05n

.meas tran vdout1_52ck710 FIND v(dout1_52) AT=720.05n

.meas tran vdout1_53ck710 FIND v(dout1_53) AT=720.05n

.meas tran vdout1_54ck710 FIND v(dout1_54) AT=720.05n

.meas tran vdout1_55ck710 FIND v(dout1_55) AT=720.05n

.meas tran vdout1_56ck710 FIND v(dout1_56) AT=720.05n

.meas tran vdout1_57ck710 FIND v(dout1_57) AT=720.05n

.meas tran vdout1_58ck710 FIND v(dout1_58) AT=720.05n

.meas tran vdout1_59ck710 FIND v(dout1_59) AT=720.05n

.meas tran vdout1_60ck710 FIND v(dout1_60) AT=720.05n

.meas tran vdout1_61ck710 FIND v(dout1_61) AT=720.05n

.meas tran vdout1_62ck710 FIND v(dout1_62) AT=720.05n

.meas tran vdout1_63ck710 FIND v(dout1_63) AT=720.05n

.meas tran vdout1_64ck710 FIND v(dout1_64) AT=720.05n

.meas tran vdout1_65ck710 FIND v(dout1_65) AT=720.05n

.meas tran vdout1_66ck710 FIND v(dout1_66) AT=720.05n

.meas tran vdout1_67ck710 FIND v(dout1_67) AT=720.05n

.meas tran vdout1_68ck710 FIND v(dout1_68) AT=720.05n

.meas tran vdout1_69ck710 FIND v(dout1_69) AT=720.05n

.meas tran vdout1_70ck710 FIND v(dout1_70) AT=720.05n

.meas tran vdout1_71ck710 FIND v(dout1_71) AT=720.05n

.meas tran vdout1_72ck710 FIND v(dout1_72) AT=720.05n

.meas tran vdout1_73ck710 FIND v(dout1_73) AT=720.05n

.meas tran vdout1_74ck710 FIND v(dout1_74) AT=720.05n

.meas tran vdout1_75ck710 FIND v(dout1_75) AT=720.05n

.meas tran vdout1_76ck710 FIND v(dout1_76) AT=720.05n

.meas tran vdout1_77ck710 FIND v(dout1_77) AT=720.05n

.meas tran vdout1_78ck710 FIND v(dout1_78) AT=720.05n

.meas tran vdout1_79ck710 FIND v(dout1_79) AT=720.05n

.meas tran vdout1_80ck710 FIND v(dout1_80) AT=720.05n

.meas tran vdout1_81ck710 FIND v(dout1_81) AT=720.05n

.meas tran vdout1_82ck710 FIND v(dout1_82) AT=720.05n

.meas tran vdout1_83ck710 FIND v(dout1_83) AT=720.05n

.meas tran vdout1_84ck710 FIND v(dout1_84) AT=720.05n

.meas tran vdout1_85ck710 FIND v(dout1_85) AT=720.05n

.meas tran vdout1_86ck710 FIND v(dout1_86) AT=720.05n

.meas tran vdout1_87ck710 FIND v(dout1_87) AT=720.05n

.meas tran vdout1_88ck710 FIND v(dout1_88) AT=720.05n

.meas tran vdout1_89ck710 FIND v(dout1_89) AT=720.05n

.meas tran vdout1_90ck710 FIND v(dout1_90) AT=720.05n

.meas tran vdout1_91ck710 FIND v(dout1_91) AT=720.05n

.meas tran vdout1_92ck710 FIND v(dout1_92) AT=720.05n

.meas tran vdout1_93ck710 FIND v(dout1_93) AT=720.05n

.meas tran vdout1_94ck710 FIND v(dout1_94) AT=720.05n

.meas tran vdout1_95ck710 FIND v(dout1_95) AT=720.05n

.meas tran vdout1_96ck710 FIND v(dout1_96) AT=720.05n

.meas tran vdout1_97ck710 FIND v(dout1_97) AT=720.05n

.meas tran vdout1_98ck710 FIND v(dout1_98) AT=720.05n

.meas tran vdout1_99ck710 FIND v(dout1_99) AT=720.05n

.meas tran vdout1_100ck710 FIND v(dout1_100) AT=720.05n

.meas tran vdout1_101ck710 FIND v(dout1_101) AT=720.05n

.meas tran vdout1_102ck710 FIND v(dout1_102) AT=720.05n

.meas tran vdout1_103ck710 FIND v(dout1_103) AT=720.05n

.meas tran vdout1_104ck710 FIND v(dout1_104) AT=720.05n

.meas tran vdout1_105ck710 FIND v(dout1_105) AT=720.05n

.meas tran vdout1_106ck710 FIND v(dout1_106) AT=720.05n

.meas tran vdout1_107ck710 FIND v(dout1_107) AT=720.05n

.meas tran vdout1_108ck710 FIND v(dout1_108) AT=720.05n

.meas tran vdout1_109ck710 FIND v(dout1_109) AT=720.05n

.meas tran vdout1_110ck710 FIND v(dout1_110) AT=720.05n

.meas tran vdout1_111ck710 FIND v(dout1_111) AT=720.05n

.meas tran vdout1_112ck710 FIND v(dout1_112) AT=720.05n

.meas tran vdout1_113ck710 FIND v(dout1_113) AT=720.05n

.meas tran vdout1_114ck710 FIND v(dout1_114) AT=720.05n

.meas tran vdout1_115ck710 FIND v(dout1_115) AT=720.05n

.meas tran vdout1_116ck710 FIND v(dout1_116) AT=720.05n

.meas tran vdout1_117ck710 FIND v(dout1_117) AT=720.05n

.meas tran vdout1_118ck710 FIND v(dout1_118) AT=720.05n

.meas tran vdout1_119ck710 FIND v(dout1_119) AT=720.05n

.meas tran vdout1_120ck710 FIND v(dout1_120) AT=720.05n

.meas tran vdout1_121ck710 FIND v(dout1_121) AT=720.05n

.meas tran vdout1_122ck710 FIND v(dout1_122) AT=720.05n

.meas tran vdout1_123ck710 FIND v(dout1_123) AT=720.05n

.meas tran vdout1_124ck710 FIND v(dout1_124) AT=720.05n

.meas tran vdout1_125ck710 FIND v(dout1_125) AT=720.05n

.meas tran vdout1_126ck710 FIND v(dout1_126) AT=720.05n

.meas tran vdout1_127ck710 FIND v(dout1_127) AT=720.05n

.meas tran vdout1_128ck710 FIND v(dout1_128) AT=720.05n

.meas tran vdout1_129ck710 FIND v(dout1_129) AT=720.05n

.meas tran vdout1_130ck710 FIND v(dout1_130) AT=720.05n

.meas tran vdout1_131ck710 FIND v(dout1_131) AT=720.05n

.meas tran vdout1_132ck710 FIND v(dout1_132) AT=720.05n

.meas tran vdout1_133ck710 FIND v(dout1_133) AT=720.05n

.meas tran vdout1_134ck710 FIND v(dout1_134) AT=720.05n

.meas tran vdout1_135ck710 FIND v(dout1_135) AT=720.05n

.meas tran vdout1_136ck710 FIND v(dout1_136) AT=720.05n

.meas tran vdout1_137ck710 FIND v(dout1_137) AT=720.05n

.meas tran vdout1_138ck710 FIND v(dout1_138) AT=720.05n

.meas tran vdout1_139ck710 FIND v(dout1_139) AT=720.05n

.meas tran vdout1_140ck710 FIND v(dout1_140) AT=720.05n

.meas tran vdout1_141ck710 FIND v(dout1_141) AT=720.05n

.meas tran vdout1_142ck710 FIND v(dout1_142) AT=720.05n

.meas tran vdout1_143ck710 FIND v(dout1_143) AT=720.05n

.meas tran vdout1_144ck710 FIND v(dout1_144) AT=720.05n

.meas tran vdout1_145ck710 FIND v(dout1_145) AT=720.05n

.meas tran vdout1_146ck710 FIND v(dout1_146) AT=720.05n

.meas tran vdout1_147ck710 FIND v(dout1_147) AT=720.05n

.meas tran vdout1_148ck710 FIND v(dout1_148) AT=720.05n

.meas tran vdout1_149ck710 FIND v(dout1_149) AT=720.05n

.meas tran vdout1_150ck710 FIND v(dout1_150) AT=720.05n

.meas tran vdout1_151ck710 FIND v(dout1_151) AT=720.05n

.meas tran vdout1_152ck710 FIND v(dout1_152) AT=720.05n

.meas tran vdout1_153ck710 FIND v(dout1_153) AT=720.05n

.meas tran vdout1_154ck710 FIND v(dout1_154) AT=720.05n

.meas tran vdout1_155ck710 FIND v(dout1_155) AT=720.05n

.meas tran vdout1_156ck710 FIND v(dout1_156) AT=720.05n

.meas tran vdout1_157ck710 FIND v(dout1_157) AT=720.05n

.meas tran vdout1_158ck710 FIND v(dout1_158) AT=720.05n

.meas tran vdout1_159ck710 FIND v(dout1_159) AT=720.05n

.meas tran vdout1_160ck710 FIND v(dout1_160) AT=720.05n

.meas tran vdout1_161ck710 FIND v(dout1_161) AT=720.05n

.meas tran vdout1_162ck710 FIND v(dout1_162) AT=720.05n

.meas tran vdout1_163ck710 FIND v(dout1_163) AT=720.05n

.meas tran vdout1_164ck710 FIND v(dout1_164) AT=720.05n

.meas tran vdout1_165ck710 FIND v(dout1_165) AT=720.05n

.meas tran vdout1_166ck710 FIND v(dout1_166) AT=720.05n

.meas tran vdout1_167ck710 FIND v(dout1_167) AT=720.05n

.meas tran vdout1_168ck710 FIND v(dout1_168) AT=720.05n

.meas tran vdout1_169ck710 FIND v(dout1_169) AT=720.05n

.meas tran vdout1_170ck710 FIND v(dout1_170) AT=720.05n

.meas tran vdout1_171ck710 FIND v(dout1_171) AT=720.05n

.meas tran vdout1_172ck710 FIND v(dout1_172) AT=720.05n

.meas tran vdout1_173ck710 FIND v(dout1_173) AT=720.05n

.meas tran vdout1_174ck710 FIND v(dout1_174) AT=720.05n

.meas tran vdout1_175ck710 FIND v(dout1_175) AT=720.05n

.meas tran vdout1_176ck710 FIND v(dout1_176) AT=720.05n

.meas tran vdout1_177ck710 FIND v(dout1_177) AT=720.05n

.meas tran vdout1_178ck710 FIND v(dout1_178) AT=720.05n

.meas tran vdout1_179ck710 FIND v(dout1_179) AT=720.05n

.meas tran vdout1_180ck710 FIND v(dout1_180) AT=720.05n

.meas tran vdout1_181ck710 FIND v(dout1_181) AT=720.05n

.meas tran vdout1_182ck710 FIND v(dout1_182) AT=720.05n

.meas tran vdout1_183ck710 FIND v(dout1_183) AT=720.05n

.meas tran vdout1_184ck710 FIND v(dout1_184) AT=720.05n

.meas tran vdout1_185ck710 FIND v(dout1_185) AT=720.05n

.meas tran vdout1_186ck710 FIND v(dout1_186) AT=720.05n

.meas tran vdout1_187ck710 FIND v(dout1_187) AT=720.05n

.meas tran vdout1_188ck710 FIND v(dout1_188) AT=720.05n

.meas tran vdout1_189ck710 FIND v(dout1_189) AT=720.05n

.meas tran vdout1_190ck710 FIND v(dout1_190) AT=720.05n

.meas tran vdout1_191ck710 FIND v(dout1_191) AT=720.05n

.meas tran vdout1_192ck710 FIND v(dout1_192) AT=720.05n

.meas tran vdout1_193ck710 FIND v(dout1_193) AT=720.05n

.meas tran vdout1_194ck710 FIND v(dout1_194) AT=720.05n

.meas tran vdout1_195ck710 FIND v(dout1_195) AT=720.05n

.meas tran vdout1_196ck710 FIND v(dout1_196) AT=720.05n

.meas tran vdout1_197ck710 FIND v(dout1_197) AT=720.05n

.meas tran vdout1_198ck710 FIND v(dout1_198) AT=720.05n

.meas tran vdout1_199ck710 FIND v(dout1_199) AT=720.05n

.meas tran vdout1_200ck710 FIND v(dout1_200) AT=720.05n

.meas tran vdout1_201ck710 FIND v(dout1_201) AT=720.05n

.meas tran vdout1_202ck710 FIND v(dout1_202) AT=720.05n

.meas tran vdout1_203ck710 FIND v(dout1_203) AT=720.05n

.meas tran vdout1_204ck710 FIND v(dout1_204) AT=720.05n

.meas tran vdout1_205ck710 FIND v(dout1_205) AT=720.05n

.meas tran vdout1_206ck710 FIND v(dout1_206) AT=720.05n

.meas tran vdout1_207ck710 FIND v(dout1_207) AT=720.05n

.meas tran vdout1_208ck710 FIND v(dout1_208) AT=720.05n

.meas tran vdout1_209ck710 FIND v(dout1_209) AT=720.05n

.meas tran vdout1_210ck710 FIND v(dout1_210) AT=720.05n

.meas tran vdout1_211ck710 FIND v(dout1_211) AT=720.05n

.meas tran vdout1_212ck710 FIND v(dout1_212) AT=720.05n

.meas tran vdout1_213ck710 FIND v(dout1_213) AT=720.05n

.meas tran vdout1_214ck710 FIND v(dout1_214) AT=720.05n

.meas tran vdout1_215ck710 FIND v(dout1_215) AT=720.05n

.meas tran vdout1_216ck710 FIND v(dout1_216) AT=720.05n

.meas tran vdout1_217ck710 FIND v(dout1_217) AT=720.05n

.meas tran vdout1_218ck710 FIND v(dout1_218) AT=720.05n

.meas tran vdout1_219ck710 FIND v(dout1_219) AT=720.05n

.meas tran vdout1_220ck710 FIND v(dout1_220) AT=720.05n

.meas tran vdout1_221ck710 FIND v(dout1_221) AT=720.05n

.meas tran vdout1_222ck710 FIND v(dout1_222) AT=720.05n

.meas tran vdout1_223ck710 FIND v(dout1_223) AT=720.05n

.meas tran vdout1_224ck710 FIND v(dout1_224) AT=720.05n

.meas tran vdout1_225ck710 FIND v(dout1_225) AT=720.05n

.meas tran vdout1_226ck710 FIND v(dout1_226) AT=720.05n

.meas tran vdout1_227ck710 FIND v(dout1_227) AT=720.05n

.meas tran vdout1_228ck710 FIND v(dout1_228) AT=720.05n

.meas tran vdout1_229ck710 FIND v(dout1_229) AT=720.05n

.meas tran vdout1_230ck710 FIND v(dout1_230) AT=720.05n

.meas tran vdout1_231ck710 FIND v(dout1_231) AT=720.05n

.meas tran vdout1_232ck710 FIND v(dout1_232) AT=720.05n

.meas tran vdout1_233ck710 FIND v(dout1_233) AT=720.05n

.meas tran vdout1_234ck710 FIND v(dout1_234) AT=720.05n

.meas tran vdout1_235ck710 FIND v(dout1_235) AT=720.05n

.meas tran vdout1_236ck710 FIND v(dout1_236) AT=720.05n

.meas tran vdout1_237ck710 FIND v(dout1_237) AT=720.05n

.meas tran vdout1_238ck710 FIND v(dout1_238) AT=720.05n

.meas tran vdout1_239ck710 FIND v(dout1_239) AT=720.05n

.meas tran vdout1_240ck710 FIND v(dout1_240) AT=720.05n

.meas tran vdout1_241ck710 FIND v(dout1_241) AT=720.05n

.meas tran vdout1_242ck710 FIND v(dout1_242) AT=720.05n

.meas tran vdout1_243ck710 FIND v(dout1_243) AT=720.05n

.meas tran vdout1_244ck710 FIND v(dout1_244) AT=720.05n

.meas tran vdout1_245ck710 FIND v(dout1_245) AT=720.05n

.meas tran vdout1_246ck710 FIND v(dout1_246) AT=720.05n

.meas tran vdout1_247ck710 FIND v(dout1_247) AT=720.05n

.meas tran vdout1_248ck710 FIND v(dout1_248) AT=720.05n

.meas tran vdout1_249ck710 FIND v(dout1_249) AT=720.05n

.meas tran vdout1_250ck710 FIND v(dout1_250) AT=720.05n

.meas tran vdout1_251ck710 FIND v(dout1_251) AT=720.05n

.meas tran vdout1_252ck710 FIND v(dout1_252) AT=720.05n

.meas tran vdout1_253ck710 FIND v(dout1_253) AT=720.05n

.meas tran vdout1_254ck710 FIND v(dout1_254) AT=720.05n

.meas tran vdout1_255ck710 FIND v(dout1_255) AT=720.05n

.meas tran vdout1_256ck710 FIND v(dout1_256) AT=720.05n

.meas tran vdout1_0ck720 FIND v(dout1_0) AT=730.05n

.meas tran vdout1_1ck720 FIND v(dout1_1) AT=730.05n

.meas tran vdout1_2ck720 FIND v(dout1_2) AT=730.05n

.meas tran vdout1_3ck720 FIND v(dout1_3) AT=730.05n

.meas tran vdout1_4ck720 FIND v(dout1_4) AT=730.05n

.meas tran vdout1_5ck720 FIND v(dout1_5) AT=730.05n

.meas tran vdout1_6ck720 FIND v(dout1_6) AT=730.05n

.meas tran vdout1_7ck720 FIND v(dout1_7) AT=730.05n

.meas tran vdout1_8ck720 FIND v(dout1_8) AT=730.05n

.meas tran vdout1_9ck720 FIND v(dout1_9) AT=730.05n

.meas tran vdout1_10ck720 FIND v(dout1_10) AT=730.05n

.meas tran vdout1_11ck720 FIND v(dout1_11) AT=730.05n

.meas tran vdout1_12ck720 FIND v(dout1_12) AT=730.05n

.meas tran vdout1_13ck720 FIND v(dout1_13) AT=730.05n

.meas tran vdout1_14ck720 FIND v(dout1_14) AT=730.05n

.meas tran vdout1_15ck720 FIND v(dout1_15) AT=730.05n

.meas tran vdout1_16ck720 FIND v(dout1_16) AT=730.05n

.meas tran vdout1_17ck720 FIND v(dout1_17) AT=730.05n

.meas tran vdout1_18ck720 FIND v(dout1_18) AT=730.05n

.meas tran vdout1_19ck720 FIND v(dout1_19) AT=730.05n

.meas tran vdout1_20ck720 FIND v(dout1_20) AT=730.05n

.meas tran vdout1_21ck720 FIND v(dout1_21) AT=730.05n

.meas tran vdout1_22ck720 FIND v(dout1_22) AT=730.05n

.meas tran vdout1_23ck720 FIND v(dout1_23) AT=730.05n

.meas tran vdout1_24ck720 FIND v(dout1_24) AT=730.05n

.meas tran vdout1_25ck720 FIND v(dout1_25) AT=730.05n

.meas tran vdout1_26ck720 FIND v(dout1_26) AT=730.05n

.meas tran vdout1_27ck720 FIND v(dout1_27) AT=730.05n

.meas tran vdout1_28ck720 FIND v(dout1_28) AT=730.05n

.meas tran vdout1_29ck720 FIND v(dout1_29) AT=730.05n

.meas tran vdout1_30ck720 FIND v(dout1_30) AT=730.05n

.meas tran vdout1_31ck720 FIND v(dout1_31) AT=730.05n

.meas tran vdout1_32ck720 FIND v(dout1_32) AT=730.05n

.meas tran vdout1_33ck720 FIND v(dout1_33) AT=730.05n

.meas tran vdout1_34ck720 FIND v(dout1_34) AT=730.05n

.meas tran vdout1_35ck720 FIND v(dout1_35) AT=730.05n

.meas tran vdout1_36ck720 FIND v(dout1_36) AT=730.05n

.meas tran vdout1_37ck720 FIND v(dout1_37) AT=730.05n

.meas tran vdout1_38ck720 FIND v(dout1_38) AT=730.05n

.meas tran vdout1_39ck720 FIND v(dout1_39) AT=730.05n

.meas tran vdout1_40ck720 FIND v(dout1_40) AT=730.05n

.meas tran vdout1_41ck720 FIND v(dout1_41) AT=730.05n

.meas tran vdout1_42ck720 FIND v(dout1_42) AT=730.05n

.meas tran vdout1_43ck720 FIND v(dout1_43) AT=730.05n

.meas tran vdout1_44ck720 FIND v(dout1_44) AT=730.05n

.meas tran vdout1_45ck720 FIND v(dout1_45) AT=730.05n

.meas tran vdout1_46ck720 FIND v(dout1_46) AT=730.05n

.meas tran vdout1_47ck720 FIND v(dout1_47) AT=730.05n

.meas tran vdout1_48ck720 FIND v(dout1_48) AT=730.05n

.meas tran vdout1_49ck720 FIND v(dout1_49) AT=730.05n

.meas tran vdout1_50ck720 FIND v(dout1_50) AT=730.05n

.meas tran vdout1_51ck720 FIND v(dout1_51) AT=730.05n

.meas tran vdout1_52ck720 FIND v(dout1_52) AT=730.05n

.meas tran vdout1_53ck720 FIND v(dout1_53) AT=730.05n

.meas tran vdout1_54ck720 FIND v(dout1_54) AT=730.05n

.meas tran vdout1_55ck720 FIND v(dout1_55) AT=730.05n

.meas tran vdout1_56ck720 FIND v(dout1_56) AT=730.05n

.meas tran vdout1_57ck720 FIND v(dout1_57) AT=730.05n

.meas tran vdout1_58ck720 FIND v(dout1_58) AT=730.05n

.meas tran vdout1_59ck720 FIND v(dout1_59) AT=730.05n

.meas tran vdout1_60ck720 FIND v(dout1_60) AT=730.05n

.meas tran vdout1_61ck720 FIND v(dout1_61) AT=730.05n

.meas tran vdout1_62ck720 FIND v(dout1_62) AT=730.05n

.meas tran vdout1_63ck720 FIND v(dout1_63) AT=730.05n

.meas tran vdout1_64ck720 FIND v(dout1_64) AT=730.05n

.meas tran vdout1_65ck720 FIND v(dout1_65) AT=730.05n

.meas tran vdout1_66ck720 FIND v(dout1_66) AT=730.05n

.meas tran vdout1_67ck720 FIND v(dout1_67) AT=730.05n

.meas tran vdout1_68ck720 FIND v(dout1_68) AT=730.05n

.meas tran vdout1_69ck720 FIND v(dout1_69) AT=730.05n

.meas tran vdout1_70ck720 FIND v(dout1_70) AT=730.05n

.meas tran vdout1_71ck720 FIND v(dout1_71) AT=730.05n

.meas tran vdout1_72ck720 FIND v(dout1_72) AT=730.05n

.meas tran vdout1_73ck720 FIND v(dout1_73) AT=730.05n

.meas tran vdout1_74ck720 FIND v(dout1_74) AT=730.05n

.meas tran vdout1_75ck720 FIND v(dout1_75) AT=730.05n

.meas tran vdout1_76ck720 FIND v(dout1_76) AT=730.05n

.meas tran vdout1_77ck720 FIND v(dout1_77) AT=730.05n

.meas tran vdout1_78ck720 FIND v(dout1_78) AT=730.05n

.meas tran vdout1_79ck720 FIND v(dout1_79) AT=730.05n

.meas tran vdout1_80ck720 FIND v(dout1_80) AT=730.05n

.meas tran vdout1_81ck720 FIND v(dout1_81) AT=730.05n

.meas tran vdout1_82ck720 FIND v(dout1_82) AT=730.05n

.meas tran vdout1_83ck720 FIND v(dout1_83) AT=730.05n

.meas tran vdout1_84ck720 FIND v(dout1_84) AT=730.05n

.meas tran vdout1_85ck720 FIND v(dout1_85) AT=730.05n

.meas tran vdout1_86ck720 FIND v(dout1_86) AT=730.05n

.meas tran vdout1_87ck720 FIND v(dout1_87) AT=730.05n

.meas tran vdout1_88ck720 FIND v(dout1_88) AT=730.05n

.meas tran vdout1_89ck720 FIND v(dout1_89) AT=730.05n

.meas tran vdout1_90ck720 FIND v(dout1_90) AT=730.05n

.meas tran vdout1_91ck720 FIND v(dout1_91) AT=730.05n

.meas tran vdout1_92ck720 FIND v(dout1_92) AT=730.05n

.meas tran vdout1_93ck720 FIND v(dout1_93) AT=730.05n

.meas tran vdout1_94ck720 FIND v(dout1_94) AT=730.05n

.meas tran vdout1_95ck720 FIND v(dout1_95) AT=730.05n

.meas tran vdout1_96ck720 FIND v(dout1_96) AT=730.05n

.meas tran vdout1_97ck720 FIND v(dout1_97) AT=730.05n

.meas tran vdout1_98ck720 FIND v(dout1_98) AT=730.05n

.meas tran vdout1_99ck720 FIND v(dout1_99) AT=730.05n

.meas tran vdout1_100ck720 FIND v(dout1_100) AT=730.05n

.meas tran vdout1_101ck720 FIND v(dout1_101) AT=730.05n

.meas tran vdout1_102ck720 FIND v(dout1_102) AT=730.05n

.meas tran vdout1_103ck720 FIND v(dout1_103) AT=730.05n

.meas tran vdout1_104ck720 FIND v(dout1_104) AT=730.05n

.meas tran vdout1_105ck720 FIND v(dout1_105) AT=730.05n

.meas tran vdout1_106ck720 FIND v(dout1_106) AT=730.05n

.meas tran vdout1_107ck720 FIND v(dout1_107) AT=730.05n

.meas tran vdout1_108ck720 FIND v(dout1_108) AT=730.05n

.meas tran vdout1_109ck720 FIND v(dout1_109) AT=730.05n

.meas tran vdout1_110ck720 FIND v(dout1_110) AT=730.05n

.meas tran vdout1_111ck720 FIND v(dout1_111) AT=730.05n

.meas tran vdout1_112ck720 FIND v(dout1_112) AT=730.05n

.meas tran vdout1_113ck720 FIND v(dout1_113) AT=730.05n

.meas tran vdout1_114ck720 FIND v(dout1_114) AT=730.05n

.meas tran vdout1_115ck720 FIND v(dout1_115) AT=730.05n

.meas tran vdout1_116ck720 FIND v(dout1_116) AT=730.05n

.meas tran vdout1_117ck720 FIND v(dout1_117) AT=730.05n

.meas tran vdout1_118ck720 FIND v(dout1_118) AT=730.05n

.meas tran vdout1_119ck720 FIND v(dout1_119) AT=730.05n

.meas tran vdout1_120ck720 FIND v(dout1_120) AT=730.05n

.meas tran vdout1_121ck720 FIND v(dout1_121) AT=730.05n

.meas tran vdout1_122ck720 FIND v(dout1_122) AT=730.05n

.meas tran vdout1_123ck720 FIND v(dout1_123) AT=730.05n

.meas tran vdout1_124ck720 FIND v(dout1_124) AT=730.05n

.meas tran vdout1_125ck720 FIND v(dout1_125) AT=730.05n

.meas tran vdout1_126ck720 FIND v(dout1_126) AT=730.05n

.meas tran vdout1_127ck720 FIND v(dout1_127) AT=730.05n

.meas tran vdout1_128ck720 FIND v(dout1_128) AT=730.05n

.meas tran vdout1_129ck720 FIND v(dout1_129) AT=730.05n

.meas tran vdout1_130ck720 FIND v(dout1_130) AT=730.05n

.meas tran vdout1_131ck720 FIND v(dout1_131) AT=730.05n

.meas tran vdout1_132ck720 FIND v(dout1_132) AT=730.05n

.meas tran vdout1_133ck720 FIND v(dout1_133) AT=730.05n

.meas tran vdout1_134ck720 FIND v(dout1_134) AT=730.05n

.meas tran vdout1_135ck720 FIND v(dout1_135) AT=730.05n

.meas tran vdout1_136ck720 FIND v(dout1_136) AT=730.05n

.meas tran vdout1_137ck720 FIND v(dout1_137) AT=730.05n

.meas tran vdout1_138ck720 FIND v(dout1_138) AT=730.05n

.meas tran vdout1_139ck720 FIND v(dout1_139) AT=730.05n

.meas tran vdout1_140ck720 FIND v(dout1_140) AT=730.05n

.meas tran vdout1_141ck720 FIND v(dout1_141) AT=730.05n

.meas tran vdout1_142ck720 FIND v(dout1_142) AT=730.05n

.meas tran vdout1_143ck720 FIND v(dout1_143) AT=730.05n

.meas tran vdout1_144ck720 FIND v(dout1_144) AT=730.05n

.meas tran vdout1_145ck720 FIND v(dout1_145) AT=730.05n

.meas tran vdout1_146ck720 FIND v(dout1_146) AT=730.05n

.meas tran vdout1_147ck720 FIND v(dout1_147) AT=730.05n

.meas tran vdout1_148ck720 FIND v(dout1_148) AT=730.05n

.meas tran vdout1_149ck720 FIND v(dout1_149) AT=730.05n

.meas tran vdout1_150ck720 FIND v(dout1_150) AT=730.05n

.meas tran vdout1_151ck720 FIND v(dout1_151) AT=730.05n

.meas tran vdout1_152ck720 FIND v(dout1_152) AT=730.05n

.meas tran vdout1_153ck720 FIND v(dout1_153) AT=730.05n

.meas tran vdout1_154ck720 FIND v(dout1_154) AT=730.05n

.meas tran vdout1_155ck720 FIND v(dout1_155) AT=730.05n

.meas tran vdout1_156ck720 FIND v(dout1_156) AT=730.05n

.meas tran vdout1_157ck720 FIND v(dout1_157) AT=730.05n

.meas tran vdout1_158ck720 FIND v(dout1_158) AT=730.05n

.meas tran vdout1_159ck720 FIND v(dout1_159) AT=730.05n

.meas tran vdout1_160ck720 FIND v(dout1_160) AT=730.05n

.meas tran vdout1_161ck720 FIND v(dout1_161) AT=730.05n

.meas tran vdout1_162ck720 FIND v(dout1_162) AT=730.05n

.meas tran vdout1_163ck720 FIND v(dout1_163) AT=730.05n

.meas tran vdout1_164ck720 FIND v(dout1_164) AT=730.05n

.meas tran vdout1_165ck720 FIND v(dout1_165) AT=730.05n

.meas tran vdout1_166ck720 FIND v(dout1_166) AT=730.05n

.meas tran vdout1_167ck720 FIND v(dout1_167) AT=730.05n

.meas tran vdout1_168ck720 FIND v(dout1_168) AT=730.05n

.meas tran vdout1_169ck720 FIND v(dout1_169) AT=730.05n

.meas tran vdout1_170ck720 FIND v(dout1_170) AT=730.05n

.meas tran vdout1_171ck720 FIND v(dout1_171) AT=730.05n

.meas tran vdout1_172ck720 FIND v(dout1_172) AT=730.05n

.meas tran vdout1_173ck720 FIND v(dout1_173) AT=730.05n

.meas tran vdout1_174ck720 FIND v(dout1_174) AT=730.05n

.meas tran vdout1_175ck720 FIND v(dout1_175) AT=730.05n

.meas tran vdout1_176ck720 FIND v(dout1_176) AT=730.05n

.meas tran vdout1_177ck720 FIND v(dout1_177) AT=730.05n

.meas tran vdout1_178ck720 FIND v(dout1_178) AT=730.05n

.meas tran vdout1_179ck720 FIND v(dout1_179) AT=730.05n

.meas tran vdout1_180ck720 FIND v(dout1_180) AT=730.05n

.meas tran vdout1_181ck720 FIND v(dout1_181) AT=730.05n

.meas tran vdout1_182ck720 FIND v(dout1_182) AT=730.05n

.meas tran vdout1_183ck720 FIND v(dout1_183) AT=730.05n

.meas tran vdout1_184ck720 FIND v(dout1_184) AT=730.05n

.meas tran vdout1_185ck720 FIND v(dout1_185) AT=730.05n

.meas tran vdout1_186ck720 FIND v(dout1_186) AT=730.05n

.meas tran vdout1_187ck720 FIND v(dout1_187) AT=730.05n

.meas tran vdout1_188ck720 FIND v(dout1_188) AT=730.05n

.meas tran vdout1_189ck720 FIND v(dout1_189) AT=730.05n

.meas tran vdout1_190ck720 FIND v(dout1_190) AT=730.05n

.meas tran vdout1_191ck720 FIND v(dout1_191) AT=730.05n

.meas tran vdout1_192ck720 FIND v(dout1_192) AT=730.05n

.meas tran vdout1_193ck720 FIND v(dout1_193) AT=730.05n

.meas tran vdout1_194ck720 FIND v(dout1_194) AT=730.05n

.meas tran vdout1_195ck720 FIND v(dout1_195) AT=730.05n

.meas tran vdout1_196ck720 FIND v(dout1_196) AT=730.05n

.meas tran vdout1_197ck720 FIND v(dout1_197) AT=730.05n

.meas tran vdout1_198ck720 FIND v(dout1_198) AT=730.05n

.meas tran vdout1_199ck720 FIND v(dout1_199) AT=730.05n

.meas tran vdout1_200ck720 FIND v(dout1_200) AT=730.05n

.meas tran vdout1_201ck720 FIND v(dout1_201) AT=730.05n

.meas tran vdout1_202ck720 FIND v(dout1_202) AT=730.05n

.meas tran vdout1_203ck720 FIND v(dout1_203) AT=730.05n

.meas tran vdout1_204ck720 FIND v(dout1_204) AT=730.05n

.meas tran vdout1_205ck720 FIND v(dout1_205) AT=730.05n

.meas tran vdout1_206ck720 FIND v(dout1_206) AT=730.05n

.meas tran vdout1_207ck720 FIND v(dout1_207) AT=730.05n

.meas tran vdout1_208ck720 FIND v(dout1_208) AT=730.05n

.meas tran vdout1_209ck720 FIND v(dout1_209) AT=730.05n

.meas tran vdout1_210ck720 FIND v(dout1_210) AT=730.05n

.meas tran vdout1_211ck720 FIND v(dout1_211) AT=730.05n

.meas tran vdout1_212ck720 FIND v(dout1_212) AT=730.05n

.meas tran vdout1_213ck720 FIND v(dout1_213) AT=730.05n

.meas tran vdout1_214ck720 FIND v(dout1_214) AT=730.05n

.meas tran vdout1_215ck720 FIND v(dout1_215) AT=730.05n

.meas tran vdout1_216ck720 FIND v(dout1_216) AT=730.05n

.meas tran vdout1_217ck720 FIND v(dout1_217) AT=730.05n

.meas tran vdout1_218ck720 FIND v(dout1_218) AT=730.05n

.meas tran vdout1_219ck720 FIND v(dout1_219) AT=730.05n

.meas tran vdout1_220ck720 FIND v(dout1_220) AT=730.05n

.meas tran vdout1_221ck720 FIND v(dout1_221) AT=730.05n

.meas tran vdout1_222ck720 FIND v(dout1_222) AT=730.05n

.meas tran vdout1_223ck720 FIND v(dout1_223) AT=730.05n

.meas tran vdout1_224ck720 FIND v(dout1_224) AT=730.05n

.meas tran vdout1_225ck720 FIND v(dout1_225) AT=730.05n

.meas tran vdout1_226ck720 FIND v(dout1_226) AT=730.05n

.meas tran vdout1_227ck720 FIND v(dout1_227) AT=730.05n

.meas tran vdout1_228ck720 FIND v(dout1_228) AT=730.05n

.meas tran vdout1_229ck720 FIND v(dout1_229) AT=730.05n

.meas tran vdout1_230ck720 FIND v(dout1_230) AT=730.05n

.meas tran vdout1_231ck720 FIND v(dout1_231) AT=730.05n

.meas tran vdout1_232ck720 FIND v(dout1_232) AT=730.05n

.meas tran vdout1_233ck720 FIND v(dout1_233) AT=730.05n

.meas tran vdout1_234ck720 FIND v(dout1_234) AT=730.05n

.meas tran vdout1_235ck720 FIND v(dout1_235) AT=730.05n

.meas tran vdout1_236ck720 FIND v(dout1_236) AT=730.05n

.meas tran vdout1_237ck720 FIND v(dout1_237) AT=730.05n

.meas tran vdout1_238ck720 FIND v(dout1_238) AT=730.05n

.meas tran vdout1_239ck720 FIND v(dout1_239) AT=730.05n

.meas tran vdout1_240ck720 FIND v(dout1_240) AT=730.05n

.meas tran vdout1_241ck720 FIND v(dout1_241) AT=730.05n

.meas tran vdout1_242ck720 FIND v(dout1_242) AT=730.05n

.meas tran vdout1_243ck720 FIND v(dout1_243) AT=730.05n

.meas tran vdout1_244ck720 FIND v(dout1_244) AT=730.05n

.meas tran vdout1_245ck720 FIND v(dout1_245) AT=730.05n

.meas tran vdout1_246ck720 FIND v(dout1_246) AT=730.05n

.meas tran vdout1_247ck720 FIND v(dout1_247) AT=730.05n

.meas tran vdout1_248ck720 FIND v(dout1_248) AT=730.05n

.meas tran vdout1_249ck720 FIND v(dout1_249) AT=730.05n

.meas tran vdout1_250ck720 FIND v(dout1_250) AT=730.05n

.meas tran vdout1_251ck720 FIND v(dout1_251) AT=730.05n

.meas tran vdout1_252ck720 FIND v(dout1_252) AT=730.05n

.meas tran vdout1_253ck720 FIND v(dout1_253) AT=730.05n

.meas tran vdout1_254ck720 FIND v(dout1_254) AT=730.05n

.meas tran vdout1_255ck720 FIND v(dout1_255) AT=730.05n

.meas tran vdout1_256ck720 FIND v(dout1_256) AT=730.05n

.meas tran vdout1_0ck760 FIND v(dout1_0) AT=770.05n

.meas tran vdout1_1ck760 FIND v(dout1_1) AT=770.05n

.meas tran vdout1_2ck760 FIND v(dout1_2) AT=770.05n

.meas tran vdout1_3ck760 FIND v(dout1_3) AT=770.05n

.meas tran vdout1_4ck760 FIND v(dout1_4) AT=770.05n

.meas tran vdout1_5ck760 FIND v(dout1_5) AT=770.05n

.meas tran vdout1_6ck760 FIND v(dout1_6) AT=770.05n

.meas tran vdout1_7ck760 FIND v(dout1_7) AT=770.05n

.meas tran vdout1_8ck760 FIND v(dout1_8) AT=770.05n

.meas tran vdout1_9ck760 FIND v(dout1_9) AT=770.05n

.meas tran vdout1_10ck760 FIND v(dout1_10) AT=770.05n

.meas tran vdout1_11ck760 FIND v(dout1_11) AT=770.05n

.meas tran vdout1_12ck760 FIND v(dout1_12) AT=770.05n

.meas tran vdout1_13ck760 FIND v(dout1_13) AT=770.05n

.meas tran vdout1_14ck760 FIND v(dout1_14) AT=770.05n

.meas tran vdout1_15ck760 FIND v(dout1_15) AT=770.05n

.meas tran vdout1_16ck760 FIND v(dout1_16) AT=770.05n

.meas tran vdout1_17ck760 FIND v(dout1_17) AT=770.05n

.meas tran vdout1_18ck760 FIND v(dout1_18) AT=770.05n

.meas tran vdout1_19ck760 FIND v(dout1_19) AT=770.05n

.meas tran vdout1_20ck760 FIND v(dout1_20) AT=770.05n

.meas tran vdout1_21ck760 FIND v(dout1_21) AT=770.05n

.meas tran vdout1_22ck760 FIND v(dout1_22) AT=770.05n

.meas tran vdout1_23ck760 FIND v(dout1_23) AT=770.05n

.meas tran vdout1_24ck760 FIND v(dout1_24) AT=770.05n

.meas tran vdout1_25ck760 FIND v(dout1_25) AT=770.05n

.meas tran vdout1_26ck760 FIND v(dout1_26) AT=770.05n

.meas tran vdout1_27ck760 FIND v(dout1_27) AT=770.05n

.meas tran vdout1_28ck760 FIND v(dout1_28) AT=770.05n

.meas tran vdout1_29ck760 FIND v(dout1_29) AT=770.05n

.meas tran vdout1_30ck760 FIND v(dout1_30) AT=770.05n

.meas tran vdout1_31ck760 FIND v(dout1_31) AT=770.05n

.meas tran vdout1_32ck760 FIND v(dout1_32) AT=770.05n

.meas tran vdout1_33ck760 FIND v(dout1_33) AT=770.05n

.meas tran vdout1_34ck760 FIND v(dout1_34) AT=770.05n

.meas tran vdout1_35ck760 FIND v(dout1_35) AT=770.05n

.meas tran vdout1_36ck760 FIND v(dout1_36) AT=770.05n

.meas tran vdout1_37ck760 FIND v(dout1_37) AT=770.05n

.meas tran vdout1_38ck760 FIND v(dout1_38) AT=770.05n

.meas tran vdout1_39ck760 FIND v(dout1_39) AT=770.05n

.meas tran vdout1_40ck760 FIND v(dout1_40) AT=770.05n

.meas tran vdout1_41ck760 FIND v(dout1_41) AT=770.05n

.meas tran vdout1_42ck760 FIND v(dout1_42) AT=770.05n

.meas tran vdout1_43ck760 FIND v(dout1_43) AT=770.05n

.meas tran vdout1_44ck760 FIND v(dout1_44) AT=770.05n

.meas tran vdout1_45ck760 FIND v(dout1_45) AT=770.05n

.meas tran vdout1_46ck760 FIND v(dout1_46) AT=770.05n

.meas tran vdout1_47ck760 FIND v(dout1_47) AT=770.05n

.meas tran vdout1_48ck760 FIND v(dout1_48) AT=770.05n

.meas tran vdout1_49ck760 FIND v(dout1_49) AT=770.05n

.meas tran vdout1_50ck760 FIND v(dout1_50) AT=770.05n

.meas tran vdout1_51ck760 FIND v(dout1_51) AT=770.05n

.meas tran vdout1_52ck760 FIND v(dout1_52) AT=770.05n

.meas tran vdout1_53ck760 FIND v(dout1_53) AT=770.05n

.meas tran vdout1_54ck760 FIND v(dout1_54) AT=770.05n

.meas tran vdout1_55ck760 FIND v(dout1_55) AT=770.05n

.meas tran vdout1_56ck760 FIND v(dout1_56) AT=770.05n

.meas tran vdout1_57ck760 FIND v(dout1_57) AT=770.05n

.meas tran vdout1_58ck760 FIND v(dout1_58) AT=770.05n

.meas tran vdout1_59ck760 FIND v(dout1_59) AT=770.05n

.meas tran vdout1_60ck760 FIND v(dout1_60) AT=770.05n

.meas tran vdout1_61ck760 FIND v(dout1_61) AT=770.05n

.meas tran vdout1_62ck760 FIND v(dout1_62) AT=770.05n

.meas tran vdout1_63ck760 FIND v(dout1_63) AT=770.05n

.meas tran vdout1_64ck760 FIND v(dout1_64) AT=770.05n

.meas tran vdout1_65ck760 FIND v(dout1_65) AT=770.05n

.meas tran vdout1_66ck760 FIND v(dout1_66) AT=770.05n

.meas tran vdout1_67ck760 FIND v(dout1_67) AT=770.05n

.meas tran vdout1_68ck760 FIND v(dout1_68) AT=770.05n

.meas tran vdout1_69ck760 FIND v(dout1_69) AT=770.05n

.meas tran vdout1_70ck760 FIND v(dout1_70) AT=770.05n

.meas tran vdout1_71ck760 FIND v(dout1_71) AT=770.05n

.meas tran vdout1_72ck760 FIND v(dout1_72) AT=770.05n

.meas tran vdout1_73ck760 FIND v(dout1_73) AT=770.05n

.meas tran vdout1_74ck760 FIND v(dout1_74) AT=770.05n

.meas tran vdout1_75ck760 FIND v(dout1_75) AT=770.05n

.meas tran vdout1_76ck760 FIND v(dout1_76) AT=770.05n

.meas tran vdout1_77ck760 FIND v(dout1_77) AT=770.05n

.meas tran vdout1_78ck760 FIND v(dout1_78) AT=770.05n

.meas tran vdout1_79ck760 FIND v(dout1_79) AT=770.05n

.meas tran vdout1_80ck760 FIND v(dout1_80) AT=770.05n

.meas tran vdout1_81ck760 FIND v(dout1_81) AT=770.05n

.meas tran vdout1_82ck760 FIND v(dout1_82) AT=770.05n

.meas tran vdout1_83ck760 FIND v(dout1_83) AT=770.05n

.meas tran vdout1_84ck760 FIND v(dout1_84) AT=770.05n

.meas tran vdout1_85ck760 FIND v(dout1_85) AT=770.05n

.meas tran vdout1_86ck760 FIND v(dout1_86) AT=770.05n

.meas tran vdout1_87ck760 FIND v(dout1_87) AT=770.05n

.meas tran vdout1_88ck760 FIND v(dout1_88) AT=770.05n

.meas tran vdout1_89ck760 FIND v(dout1_89) AT=770.05n

.meas tran vdout1_90ck760 FIND v(dout1_90) AT=770.05n

.meas tran vdout1_91ck760 FIND v(dout1_91) AT=770.05n

.meas tran vdout1_92ck760 FIND v(dout1_92) AT=770.05n

.meas tran vdout1_93ck760 FIND v(dout1_93) AT=770.05n

.meas tran vdout1_94ck760 FIND v(dout1_94) AT=770.05n

.meas tran vdout1_95ck760 FIND v(dout1_95) AT=770.05n

.meas tran vdout1_96ck760 FIND v(dout1_96) AT=770.05n

.meas tran vdout1_97ck760 FIND v(dout1_97) AT=770.05n

.meas tran vdout1_98ck760 FIND v(dout1_98) AT=770.05n

.meas tran vdout1_99ck760 FIND v(dout1_99) AT=770.05n

.meas tran vdout1_100ck760 FIND v(dout1_100) AT=770.05n

.meas tran vdout1_101ck760 FIND v(dout1_101) AT=770.05n

.meas tran vdout1_102ck760 FIND v(dout1_102) AT=770.05n

.meas tran vdout1_103ck760 FIND v(dout1_103) AT=770.05n

.meas tran vdout1_104ck760 FIND v(dout1_104) AT=770.05n

.meas tran vdout1_105ck760 FIND v(dout1_105) AT=770.05n

.meas tran vdout1_106ck760 FIND v(dout1_106) AT=770.05n

.meas tran vdout1_107ck760 FIND v(dout1_107) AT=770.05n

.meas tran vdout1_108ck760 FIND v(dout1_108) AT=770.05n

.meas tran vdout1_109ck760 FIND v(dout1_109) AT=770.05n

.meas tran vdout1_110ck760 FIND v(dout1_110) AT=770.05n

.meas tran vdout1_111ck760 FIND v(dout1_111) AT=770.05n

.meas tran vdout1_112ck760 FIND v(dout1_112) AT=770.05n

.meas tran vdout1_113ck760 FIND v(dout1_113) AT=770.05n

.meas tran vdout1_114ck760 FIND v(dout1_114) AT=770.05n

.meas tran vdout1_115ck760 FIND v(dout1_115) AT=770.05n

.meas tran vdout1_116ck760 FIND v(dout1_116) AT=770.05n

.meas tran vdout1_117ck760 FIND v(dout1_117) AT=770.05n

.meas tran vdout1_118ck760 FIND v(dout1_118) AT=770.05n

.meas tran vdout1_119ck760 FIND v(dout1_119) AT=770.05n

.meas tran vdout1_120ck760 FIND v(dout1_120) AT=770.05n

.meas tran vdout1_121ck760 FIND v(dout1_121) AT=770.05n

.meas tran vdout1_122ck760 FIND v(dout1_122) AT=770.05n

.meas tran vdout1_123ck760 FIND v(dout1_123) AT=770.05n

.meas tran vdout1_124ck760 FIND v(dout1_124) AT=770.05n

.meas tran vdout1_125ck760 FIND v(dout1_125) AT=770.05n

.meas tran vdout1_126ck760 FIND v(dout1_126) AT=770.05n

.meas tran vdout1_127ck760 FIND v(dout1_127) AT=770.05n

.meas tran vdout1_128ck760 FIND v(dout1_128) AT=770.05n

.meas tran vdout1_129ck760 FIND v(dout1_129) AT=770.05n

.meas tran vdout1_130ck760 FIND v(dout1_130) AT=770.05n

.meas tran vdout1_131ck760 FIND v(dout1_131) AT=770.05n

.meas tran vdout1_132ck760 FIND v(dout1_132) AT=770.05n

.meas tran vdout1_133ck760 FIND v(dout1_133) AT=770.05n

.meas tran vdout1_134ck760 FIND v(dout1_134) AT=770.05n

.meas tran vdout1_135ck760 FIND v(dout1_135) AT=770.05n

.meas tran vdout1_136ck760 FIND v(dout1_136) AT=770.05n

.meas tran vdout1_137ck760 FIND v(dout1_137) AT=770.05n

.meas tran vdout1_138ck760 FIND v(dout1_138) AT=770.05n

.meas tran vdout1_139ck760 FIND v(dout1_139) AT=770.05n

.meas tran vdout1_140ck760 FIND v(dout1_140) AT=770.05n

.meas tran vdout1_141ck760 FIND v(dout1_141) AT=770.05n

.meas tran vdout1_142ck760 FIND v(dout1_142) AT=770.05n

.meas tran vdout1_143ck760 FIND v(dout1_143) AT=770.05n

.meas tran vdout1_144ck760 FIND v(dout1_144) AT=770.05n

.meas tran vdout1_145ck760 FIND v(dout1_145) AT=770.05n

.meas tran vdout1_146ck760 FIND v(dout1_146) AT=770.05n

.meas tran vdout1_147ck760 FIND v(dout1_147) AT=770.05n

.meas tran vdout1_148ck760 FIND v(dout1_148) AT=770.05n

.meas tran vdout1_149ck760 FIND v(dout1_149) AT=770.05n

.meas tran vdout1_150ck760 FIND v(dout1_150) AT=770.05n

.meas tran vdout1_151ck760 FIND v(dout1_151) AT=770.05n

.meas tran vdout1_152ck760 FIND v(dout1_152) AT=770.05n

.meas tran vdout1_153ck760 FIND v(dout1_153) AT=770.05n

.meas tran vdout1_154ck760 FIND v(dout1_154) AT=770.05n

.meas tran vdout1_155ck760 FIND v(dout1_155) AT=770.05n

.meas tran vdout1_156ck760 FIND v(dout1_156) AT=770.05n

.meas tran vdout1_157ck760 FIND v(dout1_157) AT=770.05n

.meas tran vdout1_158ck760 FIND v(dout1_158) AT=770.05n

.meas tran vdout1_159ck760 FIND v(dout1_159) AT=770.05n

.meas tran vdout1_160ck760 FIND v(dout1_160) AT=770.05n

.meas tran vdout1_161ck760 FIND v(dout1_161) AT=770.05n

.meas tran vdout1_162ck760 FIND v(dout1_162) AT=770.05n

.meas tran vdout1_163ck760 FIND v(dout1_163) AT=770.05n

.meas tran vdout1_164ck760 FIND v(dout1_164) AT=770.05n

.meas tran vdout1_165ck760 FIND v(dout1_165) AT=770.05n

.meas tran vdout1_166ck760 FIND v(dout1_166) AT=770.05n

.meas tran vdout1_167ck760 FIND v(dout1_167) AT=770.05n

.meas tran vdout1_168ck760 FIND v(dout1_168) AT=770.05n

.meas tran vdout1_169ck760 FIND v(dout1_169) AT=770.05n

.meas tran vdout1_170ck760 FIND v(dout1_170) AT=770.05n

.meas tran vdout1_171ck760 FIND v(dout1_171) AT=770.05n

.meas tran vdout1_172ck760 FIND v(dout1_172) AT=770.05n

.meas tran vdout1_173ck760 FIND v(dout1_173) AT=770.05n

.meas tran vdout1_174ck760 FIND v(dout1_174) AT=770.05n

.meas tran vdout1_175ck760 FIND v(dout1_175) AT=770.05n

.meas tran vdout1_176ck760 FIND v(dout1_176) AT=770.05n

.meas tran vdout1_177ck760 FIND v(dout1_177) AT=770.05n

.meas tran vdout1_178ck760 FIND v(dout1_178) AT=770.05n

.meas tran vdout1_179ck760 FIND v(dout1_179) AT=770.05n

.meas tran vdout1_180ck760 FIND v(dout1_180) AT=770.05n

.meas tran vdout1_181ck760 FIND v(dout1_181) AT=770.05n

.meas tran vdout1_182ck760 FIND v(dout1_182) AT=770.05n

.meas tran vdout1_183ck760 FIND v(dout1_183) AT=770.05n

.meas tran vdout1_184ck760 FIND v(dout1_184) AT=770.05n

.meas tran vdout1_185ck760 FIND v(dout1_185) AT=770.05n

.meas tran vdout1_186ck760 FIND v(dout1_186) AT=770.05n

.meas tran vdout1_187ck760 FIND v(dout1_187) AT=770.05n

.meas tran vdout1_188ck760 FIND v(dout1_188) AT=770.05n

.meas tran vdout1_189ck760 FIND v(dout1_189) AT=770.05n

.meas tran vdout1_190ck760 FIND v(dout1_190) AT=770.05n

.meas tran vdout1_191ck760 FIND v(dout1_191) AT=770.05n

.meas tran vdout1_192ck760 FIND v(dout1_192) AT=770.05n

.meas tran vdout1_193ck760 FIND v(dout1_193) AT=770.05n

.meas tran vdout1_194ck760 FIND v(dout1_194) AT=770.05n

.meas tran vdout1_195ck760 FIND v(dout1_195) AT=770.05n

.meas tran vdout1_196ck760 FIND v(dout1_196) AT=770.05n

.meas tran vdout1_197ck760 FIND v(dout1_197) AT=770.05n

.meas tran vdout1_198ck760 FIND v(dout1_198) AT=770.05n

.meas tran vdout1_199ck760 FIND v(dout1_199) AT=770.05n

.meas tran vdout1_200ck760 FIND v(dout1_200) AT=770.05n

.meas tran vdout1_201ck760 FIND v(dout1_201) AT=770.05n

.meas tran vdout1_202ck760 FIND v(dout1_202) AT=770.05n

.meas tran vdout1_203ck760 FIND v(dout1_203) AT=770.05n

.meas tran vdout1_204ck760 FIND v(dout1_204) AT=770.05n

.meas tran vdout1_205ck760 FIND v(dout1_205) AT=770.05n

.meas tran vdout1_206ck760 FIND v(dout1_206) AT=770.05n

.meas tran vdout1_207ck760 FIND v(dout1_207) AT=770.05n

.meas tran vdout1_208ck760 FIND v(dout1_208) AT=770.05n

.meas tran vdout1_209ck760 FIND v(dout1_209) AT=770.05n

.meas tran vdout1_210ck760 FIND v(dout1_210) AT=770.05n

.meas tran vdout1_211ck760 FIND v(dout1_211) AT=770.05n

.meas tran vdout1_212ck760 FIND v(dout1_212) AT=770.05n

.meas tran vdout1_213ck760 FIND v(dout1_213) AT=770.05n

.meas tran vdout1_214ck760 FIND v(dout1_214) AT=770.05n

.meas tran vdout1_215ck760 FIND v(dout1_215) AT=770.05n

.meas tran vdout1_216ck760 FIND v(dout1_216) AT=770.05n

.meas tran vdout1_217ck760 FIND v(dout1_217) AT=770.05n

.meas tran vdout1_218ck760 FIND v(dout1_218) AT=770.05n

.meas tran vdout1_219ck760 FIND v(dout1_219) AT=770.05n

.meas tran vdout1_220ck760 FIND v(dout1_220) AT=770.05n

.meas tran vdout1_221ck760 FIND v(dout1_221) AT=770.05n

.meas tran vdout1_222ck760 FIND v(dout1_222) AT=770.05n

.meas tran vdout1_223ck760 FIND v(dout1_223) AT=770.05n

.meas tran vdout1_224ck760 FIND v(dout1_224) AT=770.05n

.meas tran vdout1_225ck760 FIND v(dout1_225) AT=770.05n

.meas tran vdout1_226ck760 FIND v(dout1_226) AT=770.05n

.meas tran vdout1_227ck760 FIND v(dout1_227) AT=770.05n

.meas tran vdout1_228ck760 FIND v(dout1_228) AT=770.05n

.meas tran vdout1_229ck760 FIND v(dout1_229) AT=770.05n

.meas tran vdout1_230ck760 FIND v(dout1_230) AT=770.05n

.meas tran vdout1_231ck760 FIND v(dout1_231) AT=770.05n

.meas tran vdout1_232ck760 FIND v(dout1_232) AT=770.05n

.meas tran vdout1_233ck760 FIND v(dout1_233) AT=770.05n

.meas tran vdout1_234ck760 FIND v(dout1_234) AT=770.05n

.meas tran vdout1_235ck760 FIND v(dout1_235) AT=770.05n

.meas tran vdout1_236ck760 FIND v(dout1_236) AT=770.05n

.meas tran vdout1_237ck760 FIND v(dout1_237) AT=770.05n

.meas tran vdout1_238ck760 FIND v(dout1_238) AT=770.05n

.meas tran vdout1_239ck760 FIND v(dout1_239) AT=770.05n

.meas tran vdout1_240ck760 FIND v(dout1_240) AT=770.05n

.meas tran vdout1_241ck760 FIND v(dout1_241) AT=770.05n

.meas tran vdout1_242ck760 FIND v(dout1_242) AT=770.05n

.meas tran vdout1_243ck760 FIND v(dout1_243) AT=770.05n

.meas tran vdout1_244ck760 FIND v(dout1_244) AT=770.05n

.meas tran vdout1_245ck760 FIND v(dout1_245) AT=770.05n

.meas tran vdout1_246ck760 FIND v(dout1_246) AT=770.05n

.meas tran vdout1_247ck760 FIND v(dout1_247) AT=770.05n

.meas tran vdout1_248ck760 FIND v(dout1_248) AT=770.05n

.meas tran vdout1_249ck760 FIND v(dout1_249) AT=770.05n

.meas tran vdout1_250ck760 FIND v(dout1_250) AT=770.05n

.meas tran vdout1_251ck760 FIND v(dout1_251) AT=770.05n

.meas tran vdout1_252ck760 FIND v(dout1_252) AT=770.05n

.meas tran vdout1_253ck760 FIND v(dout1_253) AT=770.05n

.meas tran vdout1_254ck760 FIND v(dout1_254) AT=770.05n

.meas tran vdout1_255ck760 FIND v(dout1_255) AT=770.05n

.meas tran vdout1_256ck760 FIND v(dout1_256) AT=770.05n

.meas tran vdout1_0ck770 FIND v(dout1_0) AT=780.05n

.meas tran vdout1_1ck770 FIND v(dout1_1) AT=780.05n

.meas tran vdout1_2ck770 FIND v(dout1_2) AT=780.05n

.meas tran vdout1_3ck770 FIND v(dout1_3) AT=780.05n

.meas tran vdout1_4ck770 FIND v(dout1_4) AT=780.05n

.meas tran vdout1_5ck770 FIND v(dout1_5) AT=780.05n

.meas tran vdout1_6ck770 FIND v(dout1_6) AT=780.05n

.meas tran vdout1_7ck770 FIND v(dout1_7) AT=780.05n

.meas tran vdout1_8ck770 FIND v(dout1_8) AT=780.05n

.meas tran vdout1_9ck770 FIND v(dout1_9) AT=780.05n

.meas tran vdout1_10ck770 FIND v(dout1_10) AT=780.05n

.meas tran vdout1_11ck770 FIND v(dout1_11) AT=780.05n

.meas tran vdout1_12ck770 FIND v(dout1_12) AT=780.05n

.meas tran vdout1_13ck770 FIND v(dout1_13) AT=780.05n

.meas tran vdout1_14ck770 FIND v(dout1_14) AT=780.05n

.meas tran vdout1_15ck770 FIND v(dout1_15) AT=780.05n

.meas tran vdout1_16ck770 FIND v(dout1_16) AT=780.05n

.meas tran vdout1_17ck770 FIND v(dout1_17) AT=780.05n

.meas tran vdout1_18ck770 FIND v(dout1_18) AT=780.05n

.meas tran vdout1_19ck770 FIND v(dout1_19) AT=780.05n

.meas tran vdout1_20ck770 FIND v(dout1_20) AT=780.05n

.meas tran vdout1_21ck770 FIND v(dout1_21) AT=780.05n

.meas tran vdout1_22ck770 FIND v(dout1_22) AT=780.05n

.meas tran vdout1_23ck770 FIND v(dout1_23) AT=780.05n

.meas tran vdout1_24ck770 FIND v(dout1_24) AT=780.05n

.meas tran vdout1_25ck770 FIND v(dout1_25) AT=780.05n

.meas tran vdout1_26ck770 FIND v(dout1_26) AT=780.05n

.meas tran vdout1_27ck770 FIND v(dout1_27) AT=780.05n

.meas tran vdout1_28ck770 FIND v(dout1_28) AT=780.05n

.meas tran vdout1_29ck770 FIND v(dout1_29) AT=780.05n

.meas tran vdout1_30ck770 FIND v(dout1_30) AT=780.05n

.meas tran vdout1_31ck770 FIND v(dout1_31) AT=780.05n

.meas tran vdout1_32ck770 FIND v(dout1_32) AT=780.05n

.meas tran vdout1_33ck770 FIND v(dout1_33) AT=780.05n

.meas tran vdout1_34ck770 FIND v(dout1_34) AT=780.05n

.meas tran vdout1_35ck770 FIND v(dout1_35) AT=780.05n

.meas tran vdout1_36ck770 FIND v(dout1_36) AT=780.05n

.meas tran vdout1_37ck770 FIND v(dout1_37) AT=780.05n

.meas tran vdout1_38ck770 FIND v(dout1_38) AT=780.05n

.meas tran vdout1_39ck770 FIND v(dout1_39) AT=780.05n

.meas tran vdout1_40ck770 FIND v(dout1_40) AT=780.05n

.meas tran vdout1_41ck770 FIND v(dout1_41) AT=780.05n

.meas tran vdout1_42ck770 FIND v(dout1_42) AT=780.05n

.meas tran vdout1_43ck770 FIND v(dout1_43) AT=780.05n

.meas tran vdout1_44ck770 FIND v(dout1_44) AT=780.05n

.meas tran vdout1_45ck770 FIND v(dout1_45) AT=780.05n

.meas tran vdout1_46ck770 FIND v(dout1_46) AT=780.05n

.meas tran vdout1_47ck770 FIND v(dout1_47) AT=780.05n

.meas tran vdout1_48ck770 FIND v(dout1_48) AT=780.05n

.meas tran vdout1_49ck770 FIND v(dout1_49) AT=780.05n

.meas tran vdout1_50ck770 FIND v(dout1_50) AT=780.05n

.meas tran vdout1_51ck770 FIND v(dout1_51) AT=780.05n

.meas tran vdout1_52ck770 FIND v(dout1_52) AT=780.05n

.meas tran vdout1_53ck770 FIND v(dout1_53) AT=780.05n

.meas tran vdout1_54ck770 FIND v(dout1_54) AT=780.05n

.meas tran vdout1_55ck770 FIND v(dout1_55) AT=780.05n

.meas tran vdout1_56ck770 FIND v(dout1_56) AT=780.05n

.meas tran vdout1_57ck770 FIND v(dout1_57) AT=780.05n

.meas tran vdout1_58ck770 FIND v(dout1_58) AT=780.05n

.meas tran vdout1_59ck770 FIND v(dout1_59) AT=780.05n

.meas tran vdout1_60ck770 FIND v(dout1_60) AT=780.05n

.meas tran vdout1_61ck770 FIND v(dout1_61) AT=780.05n

.meas tran vdout1_62ck770 FIND v(dout1_62) AT=780.05n

.meas tran vdout1_63ck770 FIND v(dout1_63) AT=780.05n

.meas tran vdout1_64ck770 FIND v(dout1_64) AT=780.05n

.meas tran vdout1_65ck770 FIND v(dout1_65) AT=780.05n

.meas tran vdout1_66ck770 FIND v(dout1_66) AT=780.05n

.meas tran vdout1_67ck770 FIND v(dout1_67) AT=780.05n

.meas tran vdout1_68ck770 FIND v(dout1_68) AT=780.05n

.meas tran vdout1_69ck770 FIND v(dout1_69) AT=780.05n

.meas tran vdout1_70ck770 FIND v(dout1_70) AT=780.05n

.meas tran vdout1_71ck770 FIND v(dout1_71) AT=780.05n

.meas tran vdout1_72ck770 FIND v(dout1_72) AT=780.05n

.meas tran vdout1_73ck770 FIND v(dout1_73) AT=780.05n

.meas tran vdout1_74ck770 FIND v(dout1_74) AT=780.05n

.meas tran vdout1_75ck770 FIND v(dout1_75) AT=780.05n

.meas tran vdout1_76ck770 FIND v(dout1_76) AT=780.05n

.meas tran vdout1_77ck770 FIND v(dout1_77) AT=780.05n

.meas tran vdout1_78ck770 FIND v(dout1_78) AT=780.05n

.meas tran vdout1_79ck770 FIND v(dout1_79) AT=780.05n

.meas tran vdout1_80ck770 FIND v(dout1_80) AT=780.05n

.meas tran vdout1_81ck770 FIND v(dout1_81) AT=780.05n

.meas tran vdout1_82ck770 FIND v(dout1_82) AT=780.05n

.meas tran vdout1_83ck770 FIND v(dout1_83) AT=780.05n

.meas tran vdout1_84ck770 FIND v(dout1_84) AT=780.05n

.meas tran vdout1_85ck770 FIND v(dout1_85) AT=780.05n

.meas tran vdout1_86ck770 FIND v(dout1_86) AT=780.05n

.meas tran vdout1_87ck770 FIND v(dout1_87) AT=780.05n

.meas tran vdout1_88ck770 FIND v(dout1_88) AT=780.05n

.meas tran vdout1_89ck770 FIND v(dout1_89) AT=780.05n

.meas tran vdout1_90ck770 FIND v(dout1_90) AT=780.05n

.meas tran vdout1_91ck770 FIND v(dout1_91) AT=780.05n

.meas tran vdout1_92ck770 FIND v(dout1_92) AT=780.05n

.meas tran vdout1_93ck770 FIND v(dout1_93) AT=780.05n

.meas tran vdout1_94ck770 FIND v(dout1_94) AT=780.05n

.meas tran vdout1_95ck770 FIND v(dout1_95) AT=780.05n

.meas tran vdout1_96ck770 FIND v(dout1_96) AT=780.05n

.meas tran vdout1_97ck770 FIND v(dout1_97) AT=780.05n

.meas tran vdout1_98ck770 FIND v(dout1_98) AT=780.05n

.meas tran vdout1_99ck770 FIND v(dout1_99) AT=780.05n

.meas tran vdout1_100ck770 FIND v(dout1_100) AT=780.05n

.meas tran vdout1_101ck770 FIND v(dout1_101) AT=780.05n

.meas tran vdout1_102ck770 FIND v(dout1_102) AT=780.05n

.meas tran vdout1_103ck770 FIND v(dout1_103) AT=780.05n

.meas tran vdout1_104ck770 FIND v(dout1_104) AT=780.05n

.meas tran vdout1_105ck770 FIND v(dout1_105) AT=780.05n

.meas tran vdout1_106ck770 FIND v(dout1_106) AT=780.05n

.meas tran vdout1_107ck770 FIND v(dout1_107) AT=780.05n

.meas tran vdout1_108ck770 FIND v(dout1_108) AT=780.05n

.meas tran vdout1_109ck770 FIND v(dout1_109) AT=780.05n

.meas tran vdout1_110ck770 FIND v(dout1_110) AT=780.05n

.meas tran vdout1_111ck770 FIND v(dout1_111) AT=780.05n

.meas tran vdout1_112ck770 FIND v(dout1_112) AT=780.05n

.meas tran vdout1_113ck770 FIND v(dout1_113) AT=780.05n

.meas tran vdout1_114ck770 FIND v(dout1_114) AT=780.05n

.meas tran vdout1_115ck770 FIND v(dout1_115) AT=780.05n

.meas tran vdout1_116ck770 FIND v(dout1_116) AT=780.05n

.meas tran vdout1_117ck770 FIND v(dout1_117) AT=780.05n

.meas tran vdout1_118ck770 FIND v(dout1_118) AT=780.05n

.meas tran vdout1_119ck770 FIND v(dout1_119) AT=780.05n

.meas tran vdout1_120ck770 FIND v(dout1_120) AT=780.05n

.meas tran vdout1_121ck770 FIND v(dout1_121) AT=780.05n

.meas tran vdout1_122ck770 FIND v(dout1_122) AT=780.05n

.meas tran vdout1_123ck770 FIND v(dout1_123) AT=780.05n

.meas tran vdout1_124ck770 FIND v(dout1_124) AT=780.05n

.meas tran vdout1_125ck770 FIND v(dout1_125) AT=780.05n

.meas tran vdout1_126ck770 FIND v(dout1_126) AT=780.05n

.meas tran vdout1_127ck770 FIND v(dout1_127) AT=780.05n

.meas tran vdout1_128ck770 FIND v(dout1_128) AT=780.05n

.meas tran vdout1_129ck770 FIND v(dout1_129) AT=780.05n

.meas tran vdout1_130ck770 FIND v(dout1_130) AT=780.05n

.meas tran vdout1_131ck770 FIND v(dout1_131) AT=780.05n

.meas tran vdout1_132ck770 FIND v(dout1_132) AT=780.05n

.meas tran vdout1_133ck770 FIND v(dout1_133) AT=780.05n

.meas tran vdout1_134ck770 FIND v(dout1_134) AT=780.05n

.meas tran vdout1_135ck770 FIND v(dout1_135) AT=780.05n

.meas tran vdout1_136ck770 FIND v(dout1_136) AT=780.05n

.meas tran vdout1_137ck770 FIND v(dout1_137) AT=780.05n

.meas tran vdout1_138ck770 FIND v(dout1_138) AT=780.05n

.meas tran vdout1_139ck770 FIND v(dout1_139) AT=780.05n

.meas tran vdout1_140ck770 FIND v(dout1_140) AT=780.05n

.meas tran vdout1_141ck770 FIND v(dout1_141) AT=780.05n

.meas tran vdout1_142ck770 FIND v(dout1_142) AT=780.05n

.meas tran vdout1_143ck770 FIND v(dout1_143) AT=780.05n

.meas tran vdout1_144ck770 FIND v(dout1_144) AT=780.05n

.meas tran vdout1_145ck770 FIND v(dout1_145) AT=780.05n

.meas tran vdout1_146ck770 FIND v(dout1_146) AT=780.05n

.meas tran vdout1_147ck770 FIND v(dout1_147) AT=780.05n

.meas tran vdout1_148ck770 FIND v(dout1_148) AT=780.05n

.meas tran vdout1_149ck770 FIND v(dout1_149) AT=780.05n

.meas tran vdout1_150ck770 FIND v(dout1_150) AT=780.05n

.meas tran vdout1_151ck770 FIND v(dout1_151) AT=780.05n

.meas tran vdout1_152ck770 FIND v(dout1_152) AT=780.05n

.meas tran vdout1_153ck770 FIND v(dout1_153) AT=780.05n

.meas tran vdout1_154ck770 FIND v(dout1_154) AT=780.05n

.meas tran vdout1_155ck770 FIND v(dout1_155) AT=780.05n

.meas tran vdout1_156ck770 FIND v(dout1_156) AT=780.05n

.meas tran vdout1_157ck770 FIND v(dout1_157) AT=780.05n

.meas tran vdout1_158ck770 FIND v(dout1_158) AT=780.05n

.meas tran vdout1_159ck770 FIND v(dout1_159) AT=780.05n

.meas tran vdout1_160ck770 FIND v(dout1_160) AT=780.05n

.meas tran vdout1_161ck770 FIND v(dout1_161) AT=780.05n

.meas tran vdout1_162ck770 FIND v(dout1_162) AT=780.05n

.meas tran vdout1_163ck770 FIND v(dout1_163) AT=780.05n

.meas tran vdout1_164ck770 FIND v(dout1_164) AT=780.05n

.meas tran vdout1_165ck770 FIND v(dout1_165) AT=780.05n

.meas tran vdout1_166ck770 FIND v(dout1_166) AT=780.05n

.meas tran vdout1_167ck770 FIND v(dout1_167) AT=780.05n

.meas tran vdout1_168ck770 FIND v(dout1_168) AT=780.05n

.meas tran vdout1_169ck770 FIND v(dout1_169) AT=780.05n

.meas tran vdout1_170ck770 FIND v(dout1_170) AT=780.05n

.meas tran vdout1_171ck770 FIND v(dout1_171) AT=780.05n

.meas tran vdout1_172ck770 FIND v(dout1_172) AT=780.05n

.meas tran vdout1_173ck770 FIND v(dout1_173) AT=780.05n

.meas tran vdout1_174ck770 FIND v(dout1_174) AT=780.05n

.meas tran vdout1_175ck770 FIND v(dout1_175) AT=780.05n

.meas tran vdout1_176ck770 FIND v(dout1_176) AT=780.05n

.meas tran vdout1_177ck770 FIND v(dout1_177) AT=780.05n

.meas tran vdout1_178ck770 FIND v(dout1_178) AT=780.05n

.meas tran vdout1_179ck770 FIND v(dout1_179) AT=780.05n

.meas tran vdout1_180ck770 FIND v(dout1_180) AT=780.05n

.meas tran vdout1_181ck770 FIND v(dout1_181) AT=780.05n

.meas tran vdout1_182ck770 FIND v(dout1_182) AT=780.05n

.meas tran vdout1_183ck770 FIND v(dout1_183) AT=780.05n

.meas tran vdout1_184ck770 FIND v(dout1_184) AT=780.05n

.meas tran vdout1_185ck770 FIND v(dout1_185) AT=780.05n

.meas tran vdout1_186ck770 FIND v(dout1_186) AT=780.05n

.meas tran vdout1_187ck770 FIND v(dout1_187) AT=780.05n

.meas tran vdout1_188ck770 FIND v(dout1_188) AT=780.05n

.meas tran vdout1_189ck770 FIND v(dout1_189) AT=780.05n

.meas tran vdout1_190ck770 FIND v(dout1_190) AT=780.05n

.meas tran vdout1_191ck770 FIND v(dout1_191) AT=780.05n

.meas tran vdout1_192ck770 FIND v(dout1_192) AT=780.05n

.meas tran vdout1_193ck770 FIND v(dout1_193) AT=780.05n

.meas tran vdout1_194ck770 FIND v(dout1_194) AT=780.05n

.meas tran vdout1_195ck770 FIND v(dout1_195) AT=780.05n

.meas tran vdout1_196ck770 FIND v(dout1_196) AT=780.05n

.meas tran vdout1_197ck770 FIND v(dout1_197) AT=780.05n

.meas tran vdout1_198ck770 FIND v(dout1_198) AT=780.05n

.meas tran vdout1_199ck770 FIND v(dout1_199) AT=780.05n

.meas tran vdout1_200ck770 FIND v(dout1_200) AT=780.05n

.meas tran vdout1_201ck770 FIND v(dout1_201) AT=780.05n

.meas tran vdout1_202ck770 FIND v(dout1_202) AT=780.05n

.meas tran vdout1_203ck770 FIND v(dout1_203) AT=780.05n

.meas tran vdout1_204ck770 FIND v(dout1_204) AT=780.05n

.meas tran vdout1_205ck770 FIND v(dout1_205) AT=780.05n

.meas tran vdout1_206ck770 FIND v(dout1_206) AT=780.05n

.meas tran vdout1_207ck770 FIND v(dout1_207) AT=780.05n

.meas tran vdout1_208ck770 FIND v(dout1_208) AT=780.05n

.meas tran vdout1_209ck770 FIND v(dout1_209) AT=780.05n

.meas tran vdout1_210ck770 FIND v(dout1_210) AT=780.05n

.meas tran vdout1_211ck770 FIND v(dout1_211) AT=780.05n

.meas tran vdout1_212ck770 FIND v(dout1_212) AT=780.05n

.meas tran vdout1_213ck770 FIND v(dout1_213) AT=780.05n

.meas tran vdout1_214ck770 FIND v(dout1_214) AT=780.05n

.meas tran vdout1_215ck770 FIND v(dout1_215) AT=780.05n

.meas tran vdout1_216ck770 FIND v(dout1_216) AT=780.05n

.meas tran vdout1_217ck770 FIND v(dout1_217) AT=780.05n

.meas tran vdout1_218ck770 FIND v(dout1_218) AT=780.05n

.meas tran vdout1_219ck770 FIND v(dout1_219) AT=780.05n

.meas tran vdout1_220ck770 FIND v(dout1_220) AT=780.05n

.meas tran vdout1_221ck770 FIND v(dout1_221) AT=780.05n

.meas tran vdout1_222ck770 FIND v(dout1_222) AT=780.05n

.meas tran vdout1_223ck770 FIND v(dout1_223) AT=780.05n

.meas tran vdout1_224ck770 FIND v(dout1_224) AT=780.05n

.meas tran vdout1_225ck770 FIND v(dout1_225) AT=780.05n

.meas tran vdout1_226ck770 FIND v(dout1_226) AT=780.05n

.meas tran vdout1_227ck770 FIND v(dout1_227) AT=780.05n

.meas tran vdout1_228ck770 FIND v(dout1_228) AT=780.05n

.meas tran vdout1_229ck770 FIND v(dout1_229) AT=780.05n

.meas tran vdout1_230ck770 FIND v(dout1_230) AT=780.05n

.meas tran vdout1_231ck770 FIND v(dout1_231) AT=780.05n

.meas tran vdout1_232ck770 FIND v(dout1_232) AT=780.05n

.meas tran vdout1_233ck770 FIND v(dout1_233) AT=780.05n

.meas tran vdout1_234ck770 FIND v(dout1_234) AT=780.05n

.meas tran vdout1_235ck770 FIND v(dout1_235) AT=780.05n

.meas tran vdout1_236ck770 FIND v(dout1_236) AT=780.05n

.meas tran vdout1_237ck770 FIND v(dout1_237) AT=780.05n

.meas tran vdout1_238ck770 FIND v(dout1_238) AT=780.05n

.meas tran vdout1_239ck770 FIND v(dout1_239) AT=780.05n

.meas tran vdout1_240ck770 FIND v(dout1_240) AT=780.05n

.meas tran vdout1_241ck770 FIND v(dout1_241) AT=780.05n

.meas tran vdout1_242ck770 FIND v(dout1_242) AT=780.05n

.meas tran vdout1_243ck770 FIND v(dout1_243) AT=780.05n

.meas tran vdout1_244ck770 FIND v(dout1_244) AT=780.05n

.meas tran vdout1_245ck770 FIND v(dout1_245) AT=780.05n

.meas tran vdout1_246ck770 FIND v(dout1_246) AT=780.05n

.meas tran vdout1_247ck770 FIND v(dout1_247) AT=780.05n

.meas tran vdout1_248ck770 FIND v(dout1_248) AT=780.05n

.meas tran vdout1_249ck770 FIND v(dout1_249) AT=780.05n

.meas tran vdout1_250ck770 FIND v(dout1_250) AT=780.05n

.meas tran vdout1_251ck770 FIND v(dout1_251) AT=780.05n

.meas tran vdout1_252ck770 FIND v(dout1_252) AT=780.05n

.meas tran vdout1_253ck770 FIND v(dout1_253) AT=780.05n

.meas tran vdout1_254ck770 FIND v(dout1_254) AT=780.05n

.meas tran vdout1_255ck770 FIND v(dout1_255) AT=780.05n

.meas tran vdout1_256ck770 FIND v(dout1_256) AT=780.05n

.meas tran vdout1_0ck800 FIND v(dout1_0) AT=810.05n

.meas tran vdout1_1ck800 FIND v(dout1_1) AT=810.05n

.meas tran vdout1_2ck800 FIND v(dout1_2) AT=810.05n

.meas tran vdout1_3ck800 FIND v(dout1_3) AT=810.05n

.meas tran vdout1_4ck800 FIND v(dout1_4) AT=810.05n

.meas tran vdout1_5ck800 FIND v(dout1_5) AT=810.05n

.meas tran vdout1_6ck800 FIND v(dout1_6) AT=810.05n

.meas tran vdout1_7ck800 FIND v(dout1_7) AT=810.05n

.meas tran vdout1_8ck800 FIND v(dout1_8) AT=810.05n

.meas tran vdout1_9ck800 FIND v(dout1_9) AT=810.05n

.meas tran vdout1_10ck800 FIND v(dout1_10) AT=810.05n

.meas tran vdout1_11ck800 FIND v(dout1_11) AT=810.05n

.meas tran vdout1_12ck800 FIND v(dout1_12) AT=810.05n

.meas tran vdout1_13ck800 FIND v(dout1_13) AT=810.05n

.meas tran vdout1_14ck800 FIND v(dout1_14) AT=810.05n

.meas tran vdout1_15ck800 FIND v(dout1_15) AT=810.05n

.meas tran vdout1_16ck800 FIND v(dout1_16) AT=810.05n

.meas tran vdout1_17ck800 FIND v(dout1_17) AT=810.05n

.meas tran vdout1_18ck800 FIND v(dout1_18) AT=810.05n

.meas tran vdout1_19ck800 FIND v(dout1_19) AT=810.05n

.meas tran vdout1_20ck800 FIND v(dout1_20) AT=810.05n

.meas tran vdout1_21ck800 FIND v(dout1_21) AT=810.05n

.meas tran vdout1_22ck800 FIND v(dout1_22) AT=810.05n

.meas tran vdout1_23ck800 FIND v(dout1_23) AT=810.05n

.meas tran vdout1_24ck800 FIND v(dout1_24) AT=810.05n

.meas tran vdout1_25ck800 FIND v(dout1_25) AT=810.05n

.meas tran vdout1_26ck800 FIND v(dout1_26) AT=810.05n

.meas tran vdout1_27ck800 FIND v(dout1_27) AT=810.05n

.meas tran vdout1_28ck800 FIND v(dout1_28) AT=810.05n

.meas tran vdout1_29ck800 FIND v(dout1_29) AT=810.05n

.meas tran vdout1_30ck800 FIND v(dout1_30) AT=810.05n

.meas tran vdout1_31ck800 FIND v(dout1_31) AT=810.05n

.meas tran vdout1_32ck800 FIND v(dout1_32) AT=810.05n

.meas tran vdout1_33ck800 FIND v(dout1_33) AT=810.05n

.meas tran vdout1_34ck800 FIND v(dout1_34) AT=810.05n

.meas tran vdout1_35ck800 FIND v(dout1_35) AT=810.05n

.meas tran vdout1_36ck800 FIND v(dout1_36) AT=810.05n

.meas tran vdout1_37ck800 FIND v(dout1_37) AT=810.05n

.meas tran vdout1_38ck800 FIND v(dout1_38) AT=810.05n

.meas tran vdout1_39ck800 FIND v(dout1_39) AT=810.05n

.meas tran vdout1_40ck800 FIND v(dout1_40) AT=810.05n

.meas tran vdout1_41ck800 FIND v(dout1_41) AT=810.05n

.meas tran vdout1_42ck800 FIND v(dout1_42) AT=810.05n

.meas tran vdout1_43ck800 FIND v(dout1_43) AT=810.05n

.meas tran vdout1_44ck800 FIND v(dout1_44) AT=810.05n

.meas tran vdout1_45ck800 FIND v(dout1_45) AT=810.05n

.meas tran vdout1_46ck800 FIND v(dout1_46) AT=810.05n

.meas tran vdout1_47ck800 FIND v(dout1_47) AT=810.05n

.meas tran vdout1_48ck800 FIND v(dout1_48) AT=810.05n

.meas tran vdout1_49ck800 FIND v(dout1_49) AT=810.05n

.meas tran vdout1_50ck800 FIND v(dout1_50) AT=810.05n

.meas tran vdout1_51ck800 FIND v(dout1_51) AT=810.05n

.meas tran vdout1_52ck800 FIND v(dout1_52) AT=810.05n

.meas tran vdout1_53ck800 FIND v(dout1_53) AT=810.05n

.meas tran vdout1_54ck800 FIND v(dout1_54) AT=810.05n

.meas tran vdout1_55ck800 FIND v(dout1_55) AT=810.05n

.meas tran vdout1_56ck800 FIND v(dout1_56) AT=810.05n

.meas tran vdout1_57ck800 FIND v(dout1_57) AT=810.05n

.meas tran vdout1_58ck800 FIND v(dout1_58) AT=810.05n

.meas tran vdout1_59ck800 FIND v(dout1_59) AT=810.05n

.meas tran vdout1_60ck800 FIND v(dout1_60) AT=810.05n

.meas tran vdout1_61ck800 FIND v(dout1_61) AT=810.05n

.meas tran vdout1_62ck800 FIND v(dout1_62) AT=810.05n

.meas tran vdout1_63ck800 FIND v(dout1_63) AT=810.05n

.meas tran vdout1_64ck800 FIND v(dout1_64) AT=810.05n

.meas tran vdout1_65ck800 FIND v(dout1_65) AT=810.05n

.meas tran vdout1_66ck800 FIND v(dout1_66) AT=810.05n

.meas tran vdout1_67ck800 FIND v(dout1_67) AT=810.05n

.meas tran vdout1_68ck800 FIND v(dout1_68) AT=810.05n

.meas tran vdout1_69ck800 FIND v(dout1_69) AT=810.05n

.meas tran vdout1_70ck800 FIND v(dout1_70) AT=810.05n

.meas tran vdout1_71ck800 FIND v(dout1_71) AT=810.05n

.meas tran vdout1_72ck800 FIND v(dout1_72) AT=810.05n

.meas tran vdout1_73ck800 FIND v(dout1_73) AT=810.05n

.meas tran vdout1_74ck800 FIND v(dout1_74) AT=810.05n

.meas tran vdout1_75ck800 FIND v(dout1_75) AT=810.05n

.meas tran vdout1_76ck800 FIND v(dout1_76) AT=810.05n

.meas tran vdout1_77ck800 FIND v(dout1_77) AT=810.05n

.meas tran vdout1_78ck800 FIND v(dout1_78) AT=810.05n

.meas tran vdout1_79ck800 FIND v(dout1_79) AT=810.05n

.meas tran vdout1_80ck800 FIND v(dout1_80) AT=810.05n

.meas tran vdout1_81ck800 FIND v(dout1_81) AT=810.05n

.meas tran vdout1_82ck800 FIND v(dout1_82) AT=810.05n

.meas tran vdout1_83ck800 FIND v(dout1_83) AT=810.05n

.meas tran vdout1_84ck800 FIND v(dout1_84) AT=810.05n

.meas tran vdout1_85ck800 FIND v(dout1_85) AT=810.05n

.meas tran vdout1_86ck800 FIND v(dout1_86) AT=810.05n

.meas tran vdout1_87ck800 FIND v(dout1_87) AT=810.05n

.meas tran vdout1_88ck800 FIND v(dout1_88) AT=810.05n

.meas tran vdout1_89ck800 FIND v(dout1_89) AT=810.05n

.meas tran vdout1_90ck800 FIND v(dout1_90) AT=810.05n

.meas tran vdout1_91ck800 FIND v(dout1_91) AT=810.05n

.meas tran vdout1_92ck800 FIND v(dout1_92) AT=810.05n

.meas tran vdout1_93ck800 FIND v(dout1_93) AT=810.05n

.meas tran vdout1_94ck800 FIND v(dout1_94) AT=810.05n

.meas tran vdout1_95ck800 FIND v(dout1_95) AT=810.05n

.meas tran vdout1_96ck800 FIND v(dout1_96) AT=810.05n

.meas tran vdout1_97ck800 FIND v(dout1_97) AT=810.05n

.meas tran vdout1_98ck800 FIND v(dout1_98) AT=810.05n

.meas tran vdout1_99ck800 FIND v(dout1_99) AT=810.05n

.meas tran vdout1_100ck800 FIND v(dout1_100) AT=810.05n

.meas tran vdout1_101ck800 FIND v(dout1_101) AT=810.05n

.meas tran vdout1_102ck800 FIND v(dout1_102) AT=810.05n

.meas tran vdout1_103ck800 FIND v(dout1_103) AT=810.05n

.meas tran vdout1_104ck800 FIND v(dout1_104) AT=810.05n

.meas tran vdout1_105ck800 FIND v(dout1_105) AT=810.05n

.meas tran vdout1_106ck800 FIND v(dout1_106) AT=810.05n

.meas tran vdout1_107ck800 FIND v(dout1_107) AT=810.05n

.meas tran vdout1_108ck800 FIND v(dout1_108) AT=810.05n

.meas tran vdout1_109ck800 FIND v(dout1_109) AT=810.05n

.meas tran vdout1_110ck800 FIND v(dout1_110) AT=810.05n

.meas tran vdout1_111ck800 FIND v(dout1_111) AT=810.05n

.meas tran vdout1_112ck800 FIND v(dout1_112) AT=810.05n

.meas tran vdout1_113ck800 FIND v(dout1_113) AT=810.05n

.meas tran vdout1_114ck800 FIND v(dout1_114) AT=810.05n

.meas tran vdout1_115ck800 FIND v(dout1_115) AT=810.05n

.meas tran vdout1_116ck800 FIND v(dout1_116) AT=810.05n

.meas tran vdout1_117ck800 FIND v(dout1_117) AT=810.05n

.meas tran vdout1_118ck800 FIND v(dout1_118) AT=810.05n

.meas tran vdout1_119ck800 FIND v(dout1_119) AT=810.05n

.meas tran vdout1_120ck800 FIND v(dout1_120) AT=810.05n

.meas tran vdout1_121ck800 FIND v(dout1_121) AT=810.05n

.meas tran vdout1_122ck800 FIND v(dout1_122) AT=810.05n

.meas tran vdout1_123ck800 FIND v(dout1_123) AT=810.05n

.meas tran vdout1_124ck800 FIND v(dout1_124) AT=810.05n

.meas tran vdout1_125ck800 FIND v(dout1_125) AT=810.05n

.meas tran vdout1_126ck800 FIND v(dout1_126) AT=810.05n

.meas tran vdout1_127ck800 FIND v(dout1_127) AT=810.05n

.meas tran vdout1_128ck800 FIND v(dout1_128) AT=810.05n

.meas tran vdout1_129ck800 FIND v(dout1_129) AT=810.05n

.meas tran vdout1_130ck800 FIND v(dout1_130) AT=810.05n

.meas tran vdout1_131ck800 FIND v(dout1_131) AT=810.05n

.meas tran vdout1_132ck800 FIND v(dout1_132) AT=810.05n

.meas tran vdout1_133ck800 FIND v(dout1_133) AT=810.05n

.meas tran vdout1_134ck800 FIND v(dout1_134) AT=810.05n

.meas tran vdout1_135ck800 FIND v(dout1_135) AT=810.05n

.meas tran vdout1_136ck800 FIND v(dout1_136) AT=810.05n

.meas tran vdout1_137ck800 FIND v(dout1_137) AT=810.05n

.meas tran vdout1_138ck800 FIND v(dout1_138) AT=810.05n

.meas tran vdout1_139ck800 FIND v(dout1_139) AT=810.05n

.meas tran vdout1_140ck800 FIND v(dout1_140) AT=810.05n

.meas tran vdout1_141ck800 FIND v(dout1_141) AT=810.05n

.meas tran vdout1_142ck800 FIND v(dout1_142) AT=810.05n

.meas tran vdout1_143ck800 FIND v(dout1_143) AT=810.05n

.meas tran vdout1_144ck800 FIND v(dout1_144) AT=810.05n

.meas tran vdout1_145ck800 FIND v(dout1_145) AT=810.05n

.meas tran vdout1_146ck800 FIND v(dout1_146) AT=810.05n

.meas tran vdout1_147ck800 FIND v(dout1_147) AT=810.05n

.meas tran vdout1_148ck800 FIND v(dout1_148) AT=810.05n

.meas tran vdout1_149ck800 FIND v(dout1_149) AT=810.05n

.meas tran vdout1_150ck800 FIND v(dout1_150) AT=810.05n

.meas tran vdout1_151ck800 FIND v(dout1_151) AT=810.05n

.meas tran vdout1_152ck800 FIND v(dout1_152) AT=810.05n

.meas tran vdout1_153ck800 FIND v(dout1_153) AT=810.05n

.meas tran vdout1_154ck800 FIND v(dout1_154) AT=810.05n

.meas tran vdout1_155ck800 FIND v(dout1_155) AT=810.05n

.meas tran vdout1_156ck800 FIND v(dout1_156) AT=810.05n

.meas tran vdout1_157ck800 FIND v(dout1_157) AT=810.05n

.meas tran vdout1_158ck800 FIND v(dout1_158) AT=810.05n

.meas tran vdout1_159ck800 FIND v(dout1_159) AT=810.05n

.meas tran vdout1_160ck800 FIND v(dout1_160) AT=810.05n

.meas tran vdout1_161ck800 FIND v(dout1_161) AT=810.05n

.meas tran vdout1_162ck800 FIND v(dout1_162) AT=810.05n

.meas tran vdout1_163ck800 FIND v(dout1_163) AT=810.05n

.meas tran vdout1_164ck800 FIND v(dout1_164) AT=810.05n

.meas tran vdout1_165ck800 FIND v(dout1_165) AT=810.05n

.meas tran vdout1_166ck800 FIND v(dout1_166) AT=810.05n

.meas tran vdout1_167ck800 FIND v(dout1_167) AT=810.05n

.meas tran vdout1_168ck800 FIND v(dout1_168) AT=810.05n

.meas tran vdout1_169ck800 FIND v(dout1_169) AT=810.05n

.meas tran vdout1_170ck800 FIND v(dout1_170) AT=810.05n

.meas tran vdout1_171ck800 FIND v(dout1_171) AT=810.05n

.meas tran vdout1_172ck800 FIND v(dout1_172) AT=810.05n

.meas tran vdout1_173ck800 FIND v(dout1_173) AT=810.05n

.meas tran vdout1_174ck800 FIND v(dout1_174) AT=810.05n

.meas tran vdout1_175ck800 FIND v(dout1_175) AT=810.05n

.meas tran vdout1_176ck800 FIND v(dout1_176) AT=810.05n

.meas tran vdout1_177ck800 FIND v(dout1_177) AT=810.05n

.meas tran vdout1_178ck800 FIND v(dout1_178) AT=810.05n

.meas tran vdout1_179ck800 FIND v(dout1_179) AT=810.05n

.meas tran vdout1_180ck800 FIND v(dout1_180) AT=810.05n

.meas tran vdout1_181ck800 FIND v(dout1_181) AT=810.05n

.meas tran vdout1_182ck800 FIND v(dout1_182) AT=810.05n

.meas tran vdout1_183ck800 FIND v(dout1_183) AT=810.05n

.meas tran vdout1_184ck800 FIND v(dout1_184) AT=810.05n

.meas tran vdout1_185ck800 FIND v(dout1_185) AT=810.05n

.meas tran vdout1_186ck800 FIND v(dout1_186) AT=810.05n

.meas tran vdout1_187ck800 FIND v(dout1_187) AT=810.05n

.meas tran vdout1_188ck800 FIND v(dout1_188) AT=810.05n

.meas tran vdout1_189ck800 FIND v(dout1_189) AT=810.05n

.meas tran vdout1_190ck800 FIND v(dout1_190) AT=810.05n

.meas tran vdout1_191ck800 FIND v(dout1_191) AT=810.05n

.meas tran vdout1_192ck800 FIND v(dout1_192) AT=810.05n

.meas tran vdout1_193ck800 FIND v(dout1_193) AT=810.05n

.meas tran vdout1_194ck800 FIND v(dout1_194) AT=810.05n

.meas tran vdout1_195ck800 FIND v(dout1_195) AT=810.05n

.meas tran vdout1_196ck800 FIND v(dout1_196) AT=810.05n

.meas tran vdout1_197ck800 FIND v(dout1_197) AT=810.05n

.meas tran vdout1_198ck800 FIND v(dout1_198) AT=810.05n

.meas tran vdout1_199ck800 FIND v(dout1_199) AT=810.05n

.meas tran vdout1_200ck800 FIND v(dout1_200) AT=810.05n

.meas tran vdout1_201ck800 FIND v(dout1_201) AT=810.05n

.meas tran vdout1_202ck800 FIND v(dout1_202) AT=810.05n

.meas tran vdout1_203ck800 FIND v(dout1_203) AT=810.05n

.meas tran vdout1_204ck800 FIND v(dout1_204) AT=810.05n

.meas tran vdout1_205ck800 FIND v(dout1_205) AT=810.05n

.meas tran vdout1_206ck800 FIND v(dout1_206) AT=810.05n

.meas tran vdout1_207ck800 FIND v(dout1_207) AT=810.05n

.meas tran vdout1_208ck800 FIND v(dout1_208) AT=810.05n

.meas tran vdout1_209ck800 FIND v(dout1_209) AT=810.05n

.meas tran vdout1_210ck800 FIND v(dout1_210) AT=810.05n

.meas tran vdout1_211ck800 FIND v(dout1_211) AT=810.05n

.meas tran vdout1_212ck800 FIND v(dout1_212) AT=810.05n

.meas tran vdout1_213ck800 FIND v(dout1_213) AT=810.05n

.meas tran vdout1_214ck800 FIND v(dout1_214) AT=810.05n

.meas tran vdout1_215ck800 FIND v(dout1_215) AT=810.05n

.meas tran vdout1_216ck800 FIND v(dout1_216) AT=810.05n

.meas tran vdout1_217ck800 FIND v(dout1_217) AT=810.05n

.meas tran vdout1_218ck800 FIND v(dout1_218) AT=810.05n

.meas tran vdout1_219ck800 FIND v(dout1_219) AT=810.05n

.meas tran vdout1_220ck800 FIND v(dout1_220) AT=810.05n

.meas tran vdout1_221ck800 FIND v(dout1_221) AT=810.05n

.meas tran vdout1_222ck800 FIND v(dout1_222) AT=810.05n

.meas tran vdout1_223ck800 FIND v(dout1_223) AT=810.05n

.meas tran vdout1_224ck800 FIND v(dout1_224) AT=810.05n

.meas tran vdout1_225ck800 FIND v(dout1_225) AT=810.05n

.meas tran vdout1_226ck800 FIND v(dout1_226) AT=810.05n

.meas tran vdout1_227ck800 FIND v(dout1_227) AT=810.05n

.meas tran vdout1_228ck800 FIND v(dout1_228) AT=810.05n

.meas tran vdout1_229ck800 FIND v(dout1_229) AT=810.05n

.meas tran vdout1_230ck800 FIND v(dout1_230) AT=810.05n

.meas tran vdout1_231ck800 FIND v(dout1_231) AT=810.05n

.meas tran vdout1_232ck800 FIND v(dout1_232) AT=810.05n

.meas tran vdout1_233ck800 FIND v(dout1_233) AT=810.05n

.meas tran vdout1_234ck800 FIND v(dout1_234) AT=810.05n

.meas tran vdout1_235ck800 FIND v(dout1_235) AT=810.05n

.meas tran vdout1_236ck800 FIND v(dout1_236) AT=810.05n

.meas tran vdout1_237ck800 FIND v(dout1_237) AT=810.05n

.meas tran vdout1_238ck800 FIND v(dout1_238) AT=810.05n

.meas tran vdout1_239ck800 FIND v(dout1_239) AT=810.05n

.meas tran vdout1_240ck800 FIND v(dout1_240) AT=810.05n

.meas tran vdout1_241ck800 FIND v(dout1_241) AT=810.05n

.meas tran vdout1_242ck800 FIND v(dout1_242) AT=810.05n

.meas tran vdout1_243ck800 FIND v(dout1_243) AT=810.05n

.meas tran vdout1_244ck800 FIND v(dout1_244) AT=810.05n

.meas tran vdout1_245ck800 FIND v(dout1_245) AT=810.05n

.meas tran vdout1_246ck800 FIND v(dout1_246) AT=810.05n

.meas tran vdout1_247ck800 FIND v(dout1_247) AT=810.05n

.meas tran vdout1_248ck800 FIND v(dout1_248) AT=810.05n

.meas tran vdout1_249ck800 FIND v(dout1_249) AT=810.05n

.meas tran vdout1_250ck800 FIND v(dout1_250) AT=810.05n

.meas tran vdout1_251ck800 FIND v(dout1_251) AT=810.05n

.meas tran vdout1_252ck800 FIND v(dout1_252) AT=810.05n

.meas tran vdout1_253ck800 FIND v(dout1_253) AT=810.05n

.meas tran vdout1_254ck800 FIND v(dout1_254) AT=810.05n

.meas tran vdout1_255ck800 FIND v(dout1_255) AT=810.05n

.meas tran vdout1_256ck800 FIND v(dout1_256) AT=810.05n

.meas tran vdout1_0ck820 FIND v(dout1_0) AT=830.05n

.meas tran vdout1_1ck820 FIND v(dout1_1) AT=830.05n

.meas tran vdout1_2ck820 FIND v(dout1_2) AT=830.05n

.meas tran vdout1_3ck820 FIND v(dout1_3) AT=830.05n

.meas tran vdout1_4ck820 FIND v(dout1_4) AT=830.05n

.meas tran vdout1_5ck820 FIND v(dout1_5) AT=830.05n

.meas tran vdout1_6ck820 FIND v(dout1_6) AT=830.05n

.meas tran vdout1_7ck820 FIND v(dout1_7) AT=830.05n

.meas tran vdout1_8ck820 FIND v(dout1_8) AT=830.05n

.meas tran vdout1_9ck820 FIND v(dout1_9) AT=830.05n

.meas tran vdout1_10ck820 FIND v(dout1_10) AT=830.05n

.meas tran vdout1_11ck820 FIND v(dout1_11) AT=830.05n

.meas tran vdout1_12ck820 FIND v(dout1_12) AT=830.05n

.meas tran vdout1_13ck820 FIND v(dout1_13) AT=830.05n

.meas tran vdout1_14ck820 FIND v(dout1_14) AT=830.05n

.meas tran vdout1_15ck820 FIND v(dout1_15) AT=830.05n

.meas tran vdout1_16ck820 FIND v(dout1_16) AT=830.05n

.meas tran vdout1_17ck820 FIND v(dout1_17) AT=830.05n

.meas tran vdout1_18ck820 FIND v(dout1_18) AT=830.05n

.meas tran vdout1_19ck820 FIND v(dout1_19) AT=830.05n

.meas tran vdout1_20ck820 FIND v(dout1_20) AT=830.05n

.meas tran vdout1_21ck820 FIND v(dout1_21) AT=830.05n

.meas tran vdout1_22ck820 FIND v(dout1_22) AT=830.05n

.meas tran vdout1_23ck820 FIND v(dout1_23) AT=830.05n

.meas tran vdout1_24ck820 FIND v(dout1_24) AT=830.05n

.meas tran vdout1_25ck820 FIND v(dout1_25) AT=830.05n

.meas tran vdout1_26ck820 FIND v(dout1_26) AT=830.05n

.meas tran vdout1_27ck820 FIND v(dout1_27) AT=830.05n

.meas tran vdout1_28ck820 FIND v(dout1_28) AT=830.05n

.meas tran vdout1_29ck820 FIND v(dout1_29) AT=830.05n

.meas tran vdout1_30ck820 FIND v(dout1_30) AT=830.05n

.meas tran vdout1_31ck820 FIND v(dout1_31) AT=830.05n

.meas tran vdout1_32ck820 FIND v(dout1_32) AT=830.05n

.meas tran vdout1_33ck820 FIND v(dout1_33) AT=830.05n

.meas tran vdout1_34ck820 FIND v(dout1_34) AT=830.05n

.meas tran vdout1_35ck820 FIND v(dout1_35) AT=830.05n

.meas tran vdout1_36ck820 FIND v(dout1_36) AT=830.05n

.meas tran vdout1_37ck820 FIND v(dout1_37) AT=830.05n

.meas tran vdout1_38ck820 FIND v(dout1_38) AT=830.05n

.meas tran vdout1_39ck820 FIND v(dout1_39) AT=830.05n

.meas tran vdout1_40ck820 FIND v(dout1_40) AT=830.05n

.meas tran vdout1_41ck820 FIND v(dout1_41) AT=830.05n

.meas tran vdout1_42ck820 FIND v(dout1_42) AT=830.05n

.meas tran vdout1_43ck820 FIND v(dout1_43) AT=830.05n

.meas tran vdout1_44ck820 FIND v(dout1_44) AT=830.05n

.meas tran vdout1_45ck820 FIND v(dout1_45) AT=830.05n

.meas tran vdout1_46ck820 FIND v(dout1_46) AT=830.05n

.meas tran vdout1_47ck820 FIND v(dout1_47) AT=830.05n

.meas tran vdout1_48ck820 FIND v(dout1_48) AT=830.05n

.meas tran vdout1_49ck820 FIND v(dout1_49) AT=830.05n

.meas tran vdout1_50ck820 FIND v(dout1_50) AT=830.05n

.meas tran vdout1_51ck820 FIND v(dout1_51) AT=830.05n

.meas tran vdout1_52ck820 FIND v(dout1_52) AT=830.05n

.meas tran vdout1_53ck820 FIND v(dout1_53) AT=830.05n

.meas tran vdout1_54ck820 FIND v(dout1_54) AT=830.05n

.meas tran vdout1_55ck820 FIND v(dout1_55) AT=830.05n

.meas tran vdout1_56ck820 FIND v(dout1_56) AT=830.05n

.meas tran vdout1_57ck820 FIND v(dout1_57) AT=830.05n

.meas tran vdout1_58ck820 FIND v(dout1_58) AT=830.05n

.meas tran vdout1_59ck820 FIND v(dout1_59) AT=830.05n

.meas tran vdout1_60ck820 FIND v(dout1_60) AT=830.05n

.meas tran vdout1_61ck820 FIND v(dout1_61) AT=830.05n

.meas tran vdout1_62ck820 FIND v(dout1_62) AT=830.05n

.meas tran vdout1_63ck820 FIND v(dout1_63) AT=830.05n

.meas tran vdout1_64ck820 FIND v(dout1_64) AT=830.05n

.meas tran vdout1_65ck820 FIND v(dout1_65) AT=830.05n

.meas tran vdout1_66ck820 FIND v(dout1_66) AT=830.05n

.meas tran vdout1_67ck820 FIND v(dout1_67) AT=830.05n

.meas tran vdout1_68ck820 FIND v(dout1_68) AT=830.05n

.meas tran vdout1_69ck820 FIND v(dout1_69) AT=830.05n

.meas tran vdout1_70ck820 FIND v(dout1_70) AT=830.05n

.meas tran vdout1_71ck820 FIND v(dout1_71) AT=830.05n

.meas tran vdout1_72ck820 FIND v(dout1_72) AT=830.05n

.meas tran vdout1_73ck820 FIND v(dout1_73) AT=830.05n

.meas tran vdout1_74ck820 FIND v(dout1_74) AT=830.05n

.meas tran vdout1_75ck820 FIND v(dout1_75) AT=830.05n

.meas tran vdout1_76ck820 FIND v(dout1_76) AT=830.05n

.meas tran vdout1_77ck820 FIND v(dout1_77) AT=830.05n

.meas tran vdout1_78ck820 FIND v(dout1_78) AT=830.05n

.meas tran vdout1_79ck820 FIND v(dout1_79) AT=830.05n

.meas tran vdout1_80ck820 FIND v(dout1_80) AT=830.05n

.meas tran vdout1_81ck820 FIND v(dout1_81) AT=830.05n

.meas tran vdout1_82ck820 FIND v(dout1_82) AT=830.05n

.meas tran vdout1_83ck820 FIND v(dout1_83) AT=830.05n

.meas tran vdout1_84ck820 FIND v(dout1_84) AT=830.05n

.meas tran vdout1_85ck820 FIND v(dout1_85) AT=830.05n

.meas tran vdout1_86ck820 FIND v(dout1_86) AT=830.05n

.meas tran vdout1_87ck820 FIND v(dout1_87) AT=830.05n

.meas tran vdout1_88ck820 FIND v(dout1_88) AT=830.05n

.meas tran vdout1_89ck820 FIND v(dout1_89) AT=830.05n

.meas tran vdout1_90ck820 FIND v(dout1_90) AT=830.05n

.meas tran vdout1_91ck820 FIND v(dout1_91) AT=830.05n

.meas tran vdout1_92ck820 FIND v(dout1_92) AT=830.05n

.meas tran vdout1_93ck820 FIND v(dout1_93) AT=830.05n

.meas tran vdout1_94ck820 FIND v(dout1_94) AT=830.05n

.meas tran vdout1_95ck820 FIND v(dout1_95) AT=830.05n

.meas tran vdout1_96ck820 FIND v(dout1_96) AT=830.05n

.meas tran vdout1_97ck820 FIND v(dout1_97) AT=830.05n

.meas tran vdout1_98ck820 FIND v(dout1_98) AT=830.05n

.meas tran vdout1_99ck820 FIND v(dout1_99) AT=830.05n

.meas tran vdout1_100ck820 FIND v(dout1_100) AT=830.05n

.meas tran vdout1_101ck820 FIND v(dout1_101) AT=830.05n

.meas tran vdout1_102ck820 FIND v(dout1_102) AT=830.05n

.meas tran vdout1_103ck820 FIND v(dout1_103) AT=830.05n

.meas tran vdout1_104ck820 FIND v(dout1_104) AT=830.05n

.meas tran vdout1_105ck820 FIND v(dout1_105) AT=830.05n

.meas tran vdout1_106ck820 FIND v(dout1_106) AT=830.05n

.meas tran vdout1_107ck820 FIND v(dout1_107) AT=830.05n

.meas tran vdout1_108ck820 FIND v(dout1_108) AT=830.05n

.meas tran vdout1_109ck820 FIND v(dout1_109) AT=830.05n

.meas tran vdout1_110ck820 FIND v(dout1_110) AT=830.05n

.meas tran vdout1_111ck820 FIND v(dout1_111) AT=830.05n

.meas tran vdout1_112ck820 FIND v(dout1_112) AT=830.05n

.meas tran vdout1_113ck820 FIND v(dout1_113) AT=830.05n

.meas tran vdout1_114ck820 FIND v(dout1_114) AT=830.05n

.meas tran vdout1_115ck820 FIND v(dout1_115) AT=830.05n

.meas tran vdout1_116ck820 FIND v(dout1_116) AT=830.05n

.meas tran vdout1_117ck820 FIND v(dout1_117) AT=830.05n

.meas tran vdout1_118ck820 FIND v(dout1_118) AT=830.05n

.meas tran vdout1_119ck820 FIND v(dout1_119) AT=830.05n

.meas tran vdout1_120ck820 FIND v(dout1_120) AT=830.05n

.meas tran vdout1_121ck820 FIND v(dout1_121) AT=830.05n

.meas tran vdout1_122ck820 FIND v(dout1_122) AT=830.05n

.meas tran vdout1_123ck820 FIND v(dout1_123) AT=830.05n

.meas tran vdout1_124ck820 FIND v(dout1_124) AT=830.05n

.meas tran vdout1_125ck820 FIND v(dout1_125) AT=830.05n

.meas tran vdout1_126ck820 FIND v(dout1_126) AT=830.05n

.meas tran vdout1_127ck820 FIND v(dout1_127) AT=830.05n

.meas tran vdout1_128ck820 FIND v(dout1_128) AT=830.05n

.meas tran vdout1_129ck820 FIND v(dout1_129) AT=830.05n

.meas tran vdout1_130ck820 FIND v(dout1_130) AT=830.05n

.meas tran vdout1_131ck820 FIND v(dout1_131) AT=830.05n

.meas tran vdout1_132ck820 FIND v(dout1_132) AT=830.05n

.meas tran vdout1_133ck820 FIND v(dout1_133) AT=830.05n

.meas tran vdout1_134ck820 FIND v(dout1_134) AT=830.05n

.meas tran vdout1_135ck820 FIND v(dout1_135) AT=830.05n

.meas tran vdout1_136ck820 FIND v(dout1_136) AT=830.05n

.meas tran vdout1_137ck820 FIND v(dout1_137) AT=830.05n

.meas tran vdout1_138ck820 FIND v(dout1_138) AT=830.05n

.meas tran vdout1_139ck820 FIND v(dout1_139) AT=830.05n

.meas tran vdout1_140ck820 FIND v(dout1_140) AT=830.05n

.meas tran vdout1_141ck820 FIND v(dout1_141) AT=830.05n

.meas tran vdout1_142ck820 FIND v(dout1_142) AT=830.05n

.meas tran vdout1_143ck820 FIND v(dout1_143) AT=830.05n

.meas tran vdout1_144ck820 FIND v(dout1_144) AT=830.05n

.meas tran vdout1_145ck820 FIND v(dout1_145) AT=830.05n

.meas tran vdout1_146ck820 FIND v(dout1_146) AT=830.05n

.meas tran vdout1_147ck820 FIND v(dout1_147) AT=830.05n

.meas tran vdout1_148ck820 FIND v(dout1_148) AT=830.05n

.meas tran vdout1_149ck820 FIND v(dout1_149) AT=830.05n

.meas tran vdout1_150ck820 FIND v(dout1_150) AT=830.05n

.meas tran vdout1_151ck820 FIND v(dout1_151) AT=830.05n

.meas tran vdout1_152ck820 FIND v(dout1_152) AT=830.05n

.meas tran vdout1_153ck820 FIND v(dout1_153) AT=830.05n

.meas tran vdout1_154ck820 FIND v(dout1_154) AT=830.05n

.meas tran vdout1_155ck820 FIND v(dout1_155) AT=830.05n

.meas tran vdout1_156ck820 FIND v(dout1_156) AT=830.05n

.meas tran vdout1_157ck820 FIND v(dout1_157) AT=830.05n

.meas tran vdout1_158ck820 FIND v(dout1_158) AT=830.05n

.meas tran vdout1_159ck820 FIND v(dout1_159) AT=830.05n

.meas tran vdout1_160ck820 FIND v(dout1_160) AT=830.05n

.meas tran vdout1_161ck820 FIND v(dout1_161) AT=830.05n

.meas tran vdout1_162ck820 FIND v(dout1_162) AT=830.05n

.meas tran vdout1_163ck820 FIND v(dout1_163) AT=830.05n

.meas tran vdout1_164ck820 FIND v(dout1_164) AT=830.05n

.meas tran vdout1_165ck820 FIND v(dout1_165) AT=830.05n

.meas tran vdout1_166ck820 FIND v(dout1_166) AT=830.05n

.meas tran vdout1_167ck820 FIND v(dout1_167) AT=830.05n

.meas tran vdout1_168ck820 FIND v(dout1_168) AT=830.05n

.meas tran vdout1_169ck820 FIND v(dout1_169) AT=830.05n

.meas tran vdout1_170ck820 FIND v(dout1_170) AT=830.05n

.meas tran vdout1_171ck820 FIND v(dout1_171) AT=830.05n

.meas tran vdout1_172ck820 FIND v(dout1_172) AT=830.05n

.meas tran vdout1_173ck820 FIND v(dout1_173) AT=830.05n

.meas tran vdout1_174ck820 FIND v(dout1_174) AT=830.05n

.meas tran vdout1_175ck820 FIND v(dout1_175) AT=830.05n

.meas tran vdout1_176ck820 FIND v(dout1_176) AT=830.05n

.meas tran vdout1_177ck820 FIND v(dout1_177) AT=830.05n

.meas tran vdout1_178ck820 FIND v(dout1_178) AT=830.05n

.meas tran vdout1_179ck820 FIND v(dout1_179) AT=830.05n

.meas tran vdout1_180ck820 FIND v(dout1_180) AT=830.05n

.meas tran vdout1_181ck820 FIND v(dout1_181) AT=830.05n

.meas tran vdout1_182ck820 FIND v(dout1_182) AT=830.05n

.meas tran vdout1_183ck820 FIND v(dout1_183) AT=830.05n

.meas tran vdout1_184ck820 FIND v(dout1_184) AT=830.05n

.meas tran vdout1_185ck820 FIND v(dout1_185) AT=830.05n

.meas tran vdout1_186ck820 FIND v(dout1_186) AT=830.05n

.meas tran vdout1_187ck820 FIND v(dout1_187) AT=830.05n

.meas tran vdout1_188ck820 FIND v(dout1_188) AT=830.05n

.meas tran vdout1_189ck820 FIND v(dout1_189) AT=830.05n

.meas tran vdout1_190ck820 FIND v(dout1_190) AT=830.05n

.meas tran vdout1_191ck820 FIND v(dout1_191) AT=830.05n

.meas tran vdout1_192ck820 FIND v(dout1_192) AT=830.05n

.meas tran vdout1_193ck820 FIND v(dout1_193) AT=830.05n

.meas tran vdout1_194ck820 FIND v(dout1_194) AT=830.05n

.meas tran vdout1_195ck820 FIND v(dout1_195) AT=830.05n

.meas tran vdout1_196ck820 FIND v(dout1_196) AT=830.05n

.meas tran vdout1_197ck820 FIND v(dout1_197) AT=830.05n

.meas tran vdout1_198ck820 FIND v(dout1_198) AT=830.05n

.meas tran vdout1_199ck820 FIND v(dout1_199) AT=830.05n

.meas tran vdout1_200ck820 FIND v(dout1_200) AT=830.05n

.meas tran vdout1_201ck820 FIND v(dout1_201) AT=830.05n

.meas tran vdout1_202ck820 FIND v(dout1_202) AT=830.05n

.meas tran vdout1_203ck820 FIND v(dout1_203) AT=830.05n

.meas tran vdout1_204ck820 FIND v(dout1_204) AT=830.05n

.meas tran vdout1_205ck820 FIND v(dout1_205) AT=830.05n

.meas tran vdout1_206ck820 FIND v(dout1_206) AT=830.05n

.meas tran vdout1_207ck820 FIND v(dout1_207) AT=830.05n

.meas tran vdout1_208ck820 FIND v(dout1_208) AT=830.05n

.meas tran vdout1_209ck820 FIND v(dout1_209) AT=830.05n

.meas tran vdout1_210ck820 FIND v(dout1_210) AT=830.05n

.meas tran vdout1_211ck820 FIND v(dout1_211) AT=830.05n

.meas tran vdout1_212ck820 FIND v(dout1_212) AT=830.05n

.meas tran vdout1_213ck820 FIND v(dout1_213) AT=830.05n

.meas tran vdout1_214ck820 FIND v(dout1_214) AT=830.05n

.meas tran vdout1_215ck820 FIND v(dout1_215) AT=830.05n

.meas tran vdout1_216ck820 FIND v(dout1_216) AT=830.05n

.meas tran vdout1_217ck820 FIND v(dout1_217) AT=830.05n

.meas tran vdout1_218ck820 FIND v(dout1_218) AT=830.05n

.meas tran vdout1_219ck820 FIND v(dout1_219) AT=830.05n

.meas tran vdout1_220ck820 FIND v(dout1_220) AT=830.05n

.meas tran vdout1_221ck820 FIND v(dout1_221) AT=830.05n

.meas tran vdout1_222ck820 FIND v(dout1_222) AT=830.05n

.meas tran vdout1_223ck820 FIND v(dout1_223) AT=830.05n

.meas tran vdout1_224ck820 FIND v(dout1_224) AT=830.05n

.meas tran vdout1_225ck820 FIND v(dout1_225) AT=830.05n

.meas tran vdout1_226ck820 FIND v(dout1_226) AT=830.05n

.meas tran vdout1_227ck820 FIND v(dout1_227) AT=830.05n

.meas tran vdout1_228ck820 FIND v(dout1_228) AT=830.05n

.meas tran vdout1_229ck820 FIND v(dout1_229) AT=830.05n

.meas tran vdout1_230ck820 FIND v(dout1_230) AT=830.05n

.meas tran vdout1_231ck820 FIND v(dout1_231) AT=830.05n

.meas tran vdout1_232ck820 FIND v(dout1_232) AT=830.05n

.meas tran vdout1_233ck820 FIND v(dout1_233) AT=830.05n

.meas tran vdout1_234ck820 FIND v(dout1_234) AT=830.05n

.meas tran vdout1_235ck820 FIND v(dout1_235) AT=830.05n

.meas tran vdout1_236ck820 FIND v(dout1_236) AT=830.05n

.meas tran vdout1_237ck820 FIND v(dout1_237) AT=830.05n

.meas tran vdout1_238ck820 FIND v(dout1_238) AT=830.05n

.meas tran vdout1_239ck820 FIND v(dout1_239) AT=830.05n

.meas tran vdout1_240ck820 FIND v(dout1_240) AT=830.05n

.meas tran vdout1_241ck820 FIND v(dout1_241) AT=830.05n

.meas tran vdout1_242ck820 FIND v(dout1_242) AT=830.05n

.meas tran vdout1_243ck820 FIND v(dout1_243) AT=830.05n

.meas tran vdout1_244ck820 FIND v(dout1_244) AT=830.05n

.meas tran vdout1_245ck820 FIND v(dout1_245) AT=830.05n

.meas tran vdout1_246ck820 FIND v(dout1_246) AT=830.05n

.meas tran vdout1_247ck820 FIND v(dout1_247) AT=830.05n

.meas tran vdout1_248ck820 FIND v(dout1_248) AT=830.05n

.meas tran vdout1_249ck820 FIND v(dout1_249) AT=830.05n

.meas tran vdout1_250ck820 FIND v(dout1_250) AT=830.05n

.meas tran vdout1_251ck820 FIND v(dout1_251) AT=830.05n

.meas tran vdout1_252ck820 FIND v(dout1_252) AT=830.05n

.meas tran vdout1_253ck820 FIND v(dout1_253) AT=830.05n

.meas tran vdout1_254ck820 FIND v(dout1_254) AT=830.05n

.meas tran vdout1_255ck820 FIND v(dout1_255) AT=830.05n

.meas tran vdout1_256ck820 FIND v(dout1_256) AT=830.05n

.meas tran vdout1_0ck830 FIND v(dout1_0) AT=840.05n

.meas tran vdout1_1ck830 FIND v(dout1_1) AT=840.05n

.meas tran vdout1_2ck830 FIND v(dout1_2) AT=840.05n

.meas tran vdout1_3ck830 FIND v(dout1_3) AT=840.05n

.meas tran vdout1_4ck830 FIND v(dout1_4) AT=840.05n

.meas tran vdout1_5ck830 FIND v(dout1_5) AT=840.05n

.meas tran vdout1_6ck830 FIND v(dout1_6) AT=840.05n

.meas tran vdout1_7ck830 FIND v(dout1_7) AT=840.05n

.meas tran vdout1_8ck830 FIND v(dout1_8) AT=840.05n

.meas tran vdout1_9ck830 FIND v(dout1_9) AT=840.05n

.meas tran vdout1_10ck830 FIND v(dout1_10) AT=840.05n

.meas tran vdout1_11ck830 FIND v(dout1_11) AT=840.05n

.meas tran vdout1_12ck830 FIND v(dout1_12) AT=840.05n

.meas tran vdout1_13ck830 FIND v(dout1_13) AT=840.05n

.meas tran vdout1_14ck830 FIND v(dout1_14) AT=840.05n

.meas tran vdout1_15ck830 FIND v(dout1_15) AT=840.05n

.meas tran vdout1_16ck830 FIND v(dout1_16) AT=840.05n

.meas tran vdout1_17ck830 FIND v(dout1_17) AT=840.05n

.meas tran vdout1_18ck830 FIND v(dout1_18) AT=840.05n

.meas tran vdout1_19ck830 FIND v(dout1_19) AT=840.05n

.meas tran vdout1_20ck830 FIND v(dout1_20) AT=840.05n

.meas tran vdout1_21ck830 FIND v(dout1_21) AT=840.05n

.meas tran vdout1_22ck830 FIND v(dout1_22) AT=840.05n

.meas tran vdout1_23ck830 FIND v(dout1_23) AT=840.05n

.meas tran vdout1_24ck830 FIND v(dout1_24) AT=840.05n

.meas tran vdout1_25ck830 FIND v(dout1_25) AT=840.05n

.meas tran vdout1_26ck830 FIND v(dout1_26) AT=840.05n

.meas tran vdout1_27ck830 FIND v(dout1_27) AT=840.05n

.meas tran vdout1_28ck830 FIND v(dout1_28) AT=840.05n

.meas tran vdout1_29ck830 FIND v(dout1_29) AT=840.05n

.meas tran vdout1_30ck830 FIND v(dout1_30) AT=840.05n

.meas tran vdout1_31ck830 FIND v(dout1_31) AT=840.05n

.meas tran vdout1_32ck830 FIND v(dout1_32) AT=840.05n

.meas tran vdout1_33ck830 FIND v(dout1_33) AT=840.05n

.meas tran vdout1_34ck830 FIND v(dout1_34) AT=840.05n

.meas tran vdout1_35ck830 FIND v(dout1_35) AT=840.05n

.meas tran vdout1_36ck830 FIND v(dout1_36) AT=840.05n

.meas tran vdout1_37ck830 FIND v(dout1_37) AT=840.05n

.meas tran vdout1_38ck830 FIND v(dout1_38) AT=840.05n

.meas tran vdout1_39ck830 FIND v(dout1_39) AT=840.05n

.meas tran vdout1_40ck830 FIND v(dout1_40) AT=840.05n

.meas tran vdout1_41ck830 FIND v(dout1_41) AT=840.05n

.meas tran vdout1_42ck830 FIND v(dout1_42) AT=840.05n

.meas tran vdout1_43ck830 FIND v(dout1_43) AT=840.05n

.meas tran vdout1_44ck830 FIND v(dout1_44) AT=840.05n

.meas tran vdout1_45ck830 FIND v(dout1_45) AT=840.05n

.meas tran vdout1_46ck830 FIND v(dout1_46) AT=840.05n

.meas tran vdout1_47ck830 FIND v(dout1_47) AT=840.05n

.meas tran vdout1_48ck830 FIND v(dout1_48) AT=840.05n

.meas tran vdout1_49ck830 FIND v(dout1_49) AT=840.05n

.meas tran vdout1_50ck830 FIND v(dout1_50) AT=840.05n

.meas tran vdout1_51ck830 FIND v(dout1_51) AT=840.05n

.meas tran vdout1_52ck830 FIND v(dout1_52) AT=840.05n

.meas tran vdout1_53ck830 FIND v(dout1_53) AT=840.05n

.meas tran vdout1_54ck830 FIND v(dout1_54) AT=840.05n

.meas tran vdout1_55ck830 FIND v(dout1_55) AT=840.05n

.meas tran vdout1_56ck830 FIND v(dout1_56) AT=840.05n

.meas tran vdout1_57ck830 FIND v(dout1_57) AT=840.05n

.meas tran vdout1_58ck830 FIND v(dout1_58) AT=840.05n

.meas tran vdout1_59ck830 FIND v(dout1_59) AT=840.05n

.meas tran vdout1_60ck830 FIND v(dout1_60) AT=840.05n

.meas tran vdout1_61ck830 FIND v(dout1_61) AT=840.05n

.meas tran vdout1_62ck830 FIND v(dout1_62) AT=840.05n

.meas tran vdout1_63ck830 FIND v(dout1_63) AT=840.05n

.meas tran vdout1_64ck830 FIND v(dout1_64) AT=840.05n

.meas tran vdout1_65ck830 FIND v(dout1_65) AT=840.05n

.meas tran vdout1_66ck830 FIND v(dout1_66) AT=840.05n

.meas tran vdout1_67ck830 FIND v(dout1_67) AT=840.05n

.meas tran vdout1_68ck830 FIND v(dout1_68) AT=840.05n

.meas tran vdout1_69ck830 FIND v(dout1_69) AT=840.05n

.meas tran vdout1_70ck830 FIND v(dout1_70) AT=840.05n

.meas tran vdout1_71ck830 FIND v(dout1_71) AT=840.05n

.meas tran vdout1_72ck830 FIND v(dout1_72) AT=840.05n

.meas tran vdout1_73ck830 FIND v(dout1_73) AT=840.05n

.meas tran vdout1_74ck830 FIND v(dout1_74) AT=840.05n

.meas tran vdout1_75ck830 FIND v(dout1_75) AT=840.05n

.meas tran vdout1_76ck830 FIND v(dout1_76) AT=840.05n

.meas tran vdout1_77ck830 FIND v(dout1_77) AT=840.05n

.meas tran vdout1_78ck830 FIND v(dout1_78) AT=840.05n

.meas tran vdout1_79ck830 FIND v(dout1_79) AT=840.05n

.meas tran vdout1_80ck830 FIND v(dout1_80) AT=840.05n

.meas tran vdout1_81ck830 FIND v(dout1_81) AT=840.05n

.meas tran vdout1_82ck830 FIND v(dout1_82) AT=840.05n

.meas tran vdout1_83ck830 FIND v(dout1_83) AT=840.05n

.meas tran vdout1_84ck830 FIND v(dout1_84) AT=840.05n

.meas tran vdout1_85ck830 FIND v(dout1_85) AT=840.05n

.meas tran vdout1_86ck830 FIND v(dout1_86) AT=840.05n

.meas tran vdout1_87ck830 FIND v(dout1_87) AT=840.05n

.meas tran vdout1_88ck830 FIND v(dout1_88) AT=840.05n

.meas tran vdout1_89ck830 FIND v(dout1_89) AT=840.05n

.meas tran vdout1_90ck830 FIND v(dout1_90) AT=840.05n

.meas tran vdout1_91ck830 FIND v(dout1_91) AT=840.05n

.meas tran vdout1_92ck830 FIND v(dout1_92) AT=840.05n

.meas tran vdout1_93ck830 FIND v(dout1_93) AT=840.05n

.meas tran vdout1_94ck830 FIND v(dout1_94) AT=840.05n

.meas tran vdout1_95ck830 FIND v(dout1_95) AT=840.05n

.meas tran vdout1_96ck830 FIND v(dout1_96) AT=840.05n

.meas tran vdout1_97ck830 FIND v(dout1_97) AT=840.05n

.meas tran vdout1_98ck830 FIND v(dout1_98) AT=840.05n

.meas tran vdout1_99ck830 FIND v(dout1_99) AT=840.05n

.meas tran vdout1_100ck830 FIND v(dout1_100) AT=840.05n

.meas tran vdout1_101ck830 FIND v(dout1_101) AT=840.05n

.meas tran vdout1_102ck830 FIND v(dout1_102) AT=840.05n

.meas tran vdout1_103ck830 FIND v(dout1_103) AT=840.05n

.meas tran vdout1_104ck830 FIND v(dout1_104) AT=840.05n

.meas tran vdout1_105ck830 FIND v(dout1_105) AT=840.05n

.meas tran vdout1_106ck830 FIND v(dout1_106) AT=840.05n

.meas tran vdout1_107ck830 FIND v(dout1_107) AT=840.05n

.meas tran vdout1_108ck830 FIND v(dout1_108) AT=840.05n

.meas tran vdout1_109ck830 FIND v(dout1_109) AT=840.05n

.meas tran vdout1_110ck830 FIND v(dout1_110) AT=840.05n

.meas tran vdout1_111ck830 FIND v(dout1_111) AT=840.05n

.meas tran vdout1_112ck830 FIND v(dout1_112) AT=840.05n

.meas tran vdout1_113ck830 FIND v(dout1_113) AT=840.05n

.meas tran vdout1_114ck830 FIND v(dout1_114) AT=840.05n

.meas tran vdout1_115ck830 FIND v(dout1_115) AT=840.05n

.meas tran vdout1_116ck830 FIND v(dout1_116) AT=840.05n

.meas tran vdout1_117ck830 FIND v(dout1_117) AT=840.05n

.meas tran vdout1_118ck830 FIND v(dout1_118) AT=840.05n

.meas tran vdout1_119ck830 FIND v(dout1_119) AT=840.05n

.meas tran vdout1_120ck830 FIND v(dout1_120) AT=840.05n

.meas tran vdout1_121ck830 FIND v(dout1_121) AT=840.05n

.meas tran vdout1_122ck830 FIND v(dout1_122) AT=840.05n

.meas tran vdout1_123ck830 FIND v(dout1_123) AT=840.05n

.meas tran vdout1_124ck830 FIND v(dout1_124) AT=840.05n

.meas tran vdout1_125ck830 FIND v(dout1_125) AT=840.05n

.meas tran vdout1_126ck830 FIND v(dout1_126) AT=840.05n

.meas tran vdout1_127ck830 FIND v(dout1_127) AT=840.05n

.meas tran vdout1_128ck830 FIND v(dout1_128) AT=840.05n

.meas tran vdout1_129ck830 FIND v(dout1_129) AT=840.05n

.meas tran vdout1_130ck830 FIND v(dout1_130) AT=840.05n

.meas tran vdout1_131ck830 FIND v(dout1_131) AT=840.05n

.meas tran vdout1_132ck830 FIND v(dout1_132) AT=840.05n

.meas tran vdout1_133ck830 FIND v(dout1_133) AT=840.05n

.meas tran vdout1_134ck830 FIND v(dout1_134) AT=840.05n

.meas tran vdout1_135ck830 FIND v(dout1_135) AT=840.05n

.meas tran vdout1_136ck830 FIND v(dout1_136) AT=840.05n

.meas tran vdout1_137ck830 FIND v(dout1_137) AT=840.05n

.meas tran vdout1_138ck830 FIND v(dout1_138) AT=840.05n

.meas tran vdout1_139ck830 FIND v(dout1_139) AT=840.05n

.meas tran vdout1_140ck830 FIND v(dout1_140) AT=840.05n

.meas tran vdout1_141ck830 FIND v(dout1_141) AT=840.05n

.meas tran vdout1_142ck830 FIND v(dout1_142) AT=840.05n

.meas tran vdout1_143ck830 FIND v(dout1_143) AT=840.05n

.meas tran vdout1_144ck830 FIND v(dout1_144) AT=840.05n

.meas tran vdout1_145ck830 FIND v(dout1_145) AT=840.05n

.meas tran vdout1_146ck830 FIND v(dout1_146) AT=840.05n

.meas tran vdout1_147ck830 FIND v(dout1_147) AT=840.05n

.meas tran vdout1_148ck830 FIND v(dout1_148) AT=840.05n

.meas tran vdout1_149ck830 FIND v(dout1_149) AT=840.05n

.meas tran vdout1_150ck830 FIND v(dout1_150) AT=840.05n

.meas tran vdout1_151ck830 FIND v(dout1_151) AT=840.05n

.meas tran vdout1_152ck830 FIND v(dout1_152) AT=840.05n

.meas tran vdout1_153ck830 FIND v(dout1_153) AT=840.05n

.meas tran vdout1_154ck830 FIND v(dout1_154) AT=840.05n

.meas tran vdout1_155ck830 FIND v(dout1_155) AT=840.05n

.meas tran vdout1_156ck830 FIND v(dout1_156) AT=840.05n

.meas tran vdout1_157ck830 FIND v(dout1_157) AT=840.05n

.meas tran vdout1_158ck830 FIND v(dout1_158) AT=840.05n

.meas tran vdout1_159ck830 FIND v(dout1_159) AT=840.05n

.meas tran vdout1_160ck830 FIND v(dout1_160) AT=840.05n

.meas tran vdout1_161ck830 FIND v(dout1_161) AT=840.05n

.meas tran vdout1_162ck830 FIND v(dout1_162) AT=840.05n

.meas tran vdout1_163ck830 FIND v(dout1_163) AT=840.05n

.meas tran vdout1_164ck830 FIND v(dout1_164) AT=840.05n

.meas tran vdout1_165ck830 FIND v(dout1_165) AT=840.05n

.meas tran vdout1_166ck830 FIND v(dout1_166) AT=840.05n

.meas tran vdout1_167ck830 FIND v(dout1_167) AT=840.05n

.meas tran vdout1_168ck830 FIND v(dout1_168) AT=840.05n

.meas tran vdout1_169ck830 FIND v(dout1_169) AT=840.05n

.meas tran vdout1_170ck830 FIND v(dout1_170) AT=840.05n

.meas tran vdout1_171ck830 FIND v(dout1_171) AT=840.05n

.meas tran vdout1_172ck830 FIND v(dout1_172) AT=840.05n

.meas tran vdout1_173ck830 FIND v(dout1_173) AT=840.05n

.meas tran vdout1_174ck830 FIND v(dout1_174) AT=840.05n

.meas tran vdout1_175ck830 FIND v(dout1_175) AT=840.05n

.meas tran vdout1_176ck830 FIND v(dout1_176) AT=840.05n

.meas tran vdout1_177ck830 FIND v(dout1_177) AT=840.05n

.meas tran vdout1_178ck830 FIND v(dout1_178) AT=840.05n

.meas tran vdout1_179ck830 FIND v(dout1_179) AT=840.05n

.meas tran vdout1_180ck830 FIND v(dout1_180) AT=840.05n

.meas tran vdout1_181ck830 FIND v(dout1_181) AT=840.05n

.meas tran vdout1_182ck830 FIND v(dout1_182) AT=840.05n

.meas tran vdout1_183ck830 FIND v(dout1_183) AT=840.05n

.meas tran vdout1_184ck830 FIND v(dout1_184) AT=840.05n

.meas tran vdout1_185ck830 FIND v(dout1_185) AT=840.05n

.meas tran vdout1_186ck830 FIND v(dout1_186) AT=840.05n

.meas tran vdout1_187ck830 FIND v(dout1_187) AT=840.05n

.meas tran vdout1_188ck830 FIND v(dout1_188) AT=840.05n

.meas tran vdout1_189ck830 FIND v(dout1_189) AT=840.05n

.meas tran vdout1_190ck830 FIND v(dout1_190) AT=840.05n

.meas tran vdout1_191ck830 FIND v(dout1_191) AT=840.05n

.meas tran vdout1_192ck830 FIND v(dout1_192) AT=840.05n

.meas tran vdout1_193ck830 FIND v(dout1_193) AT=840.05n

.meas tran vdout1_194ck830 FIND v(dout1_194) AT=840.05n

.meas tran vdout1_195ck830 FIND v(dout1_195) AT=840.05n

.meas tran vdout1_196ck830 FIND v(dout1_196) AT=840.05n

.meas tran vdout1_197ck830 FIND v(dout1_197) AT=840.05n

.meas tran vdout1_198ck830 FIND v(dout1_198) AT=840.05n

.meas tran vdout1_199ck830 FIND v(dout1_199) AT=840.05n

.meas tran vdout1_200ck830 FIND v(dout1_200) AT=840.05n

.meas tran vdout1_201ck830 FIND v(dout1_201) AT=840.05n

.meas tran vdout1_202ck830 FIND v(dout1_202) AT=840.05n

.meas tran vdout1_203ck830 FIND v(dout1_203) AT=840.05n

.meas tran vdout1_204ck830 FIND v(dout1_204) AT=840.05n

.meas tran vdout1_205ck830 FIND v(dout1_205) AT=840.05n

.meas tran vdout1_206ck830 FIND v(dout1_206) AT=840.05n

.meas tran vdout1_207ck830 FIND v(dout1_207) AT=840.05n

.meas tran vdout1_208ck830 FIND v(dout1_208) AT=840.05n

.meas tran vdout1_209ck830 FIND v(dout1_209) AT=840.05n

.meas tran vdout1_210ck830 FIND v(dout1_210) AT=840.05n

.meas tran vdout1_211ck830 FIND v(dout1_211) AT=840.05n

.meas tran vdout1_212ck830 FIND v(dout1_212) AT=840.05n

.meas tran vdout1_213ck830 FIND v(dout1_213) AT=840.05n

.meas tran vdout1_214ck830 FIND v(dout1_214) AT=840.05n

.meas tran vdout1_215ck830 FIND v(dout1_215) AT=840.05n

.meas tran vdout1_216ck830 FIND v(dout1_216) AT=840.05n

.meas tran vdout1_217ck830 FIND v(dout1_217) AT=840.05n

.meas tran vdout1_218ck830 FIND v(dout1_218) AT=840.05n

.meas tran vdout1_219ck830 FIND v(dout1_219) AT=840.05n

.meas tran vdout1_220ck830 FIND v(dout1_220) AT=840.05n

.meas tran vdout1_221ck830 FIND v(dout1_221) AT=840.05n

.meas tran vdout1_222ck830 FIND v(dout1_222) AT=840.05n

.meas tran vdout1_223ck830 FIND v(dout1_223) AT=840.05n

.meas tran vdout1_224ck830 FIND v(dout1_224) AT=840.05n

.meas tran vdout1_225ck830 FIND v(dout1_225) AT=840.05n

.meas tran vdout1_226ck830 FIND v(dout1_226) AT=840.05n

.meas tran vdout1_227ck830 FIND v(dout1_227) AT=840.05n

.meas tran vdout1_228ck830 FIND v(dout1_228) AT=840.05n

.meas tran vdout1_229ck830 FIND v(dout1_229) AT=840.05n

.meas tran vdout1_230ck830 FIND v(dout1_230) AT=840.05n

.meas tran vdout1_231ck830 FIND v(dout1_231) AT=840.05n

.meas tran vdout1_232ck830 FIND v(dout1_232) AT=840.05n

.meas tran vdout1_233ck830 FIND v(dout1_233) AT=840.05n

.meas tran vdout1_234ck830 FIND v(dout1_234) AT=840.05n

.meas tran vdout1_235ck830 FIND v(dout1_235) AT=840.05n

.meas tran vdout1_236ck830 FIND v(dout1_236) AT=840.05n

.meas tran vdout1_237ck830 FIND v(dout1_237) AT=840.05n

.meas tran vdout1_238ck830 FIND v(dout1_238) AT=840.05n

.meas tran vdout1_239ck830 FIND v(dout1_239) AT=840.05n

.meas tran vdout1_240ck830 FIND v(dout1_240) AT=840.05n

.meas tran vdout1_241ck830 FIND v(dout1_241) AT=840.05n

.meas tran vdout1_242ck830 FIND v(dout1_242) AT=840.05n

.meas tran vdout1_243ck830 FIND v(dout1_243) AT=840.05n

.meas tran vdout1_244ck830 FIND v(dout1_244) AT=840.05n

.meas tran vdout1_245ck830 FIND v(dout1_245) AT=840.05n

.meas tran vdout1_246ck830 FIND v(dout1_246) AT=840.05n

.meas tran vdout1_247ck830 FIND v(dout1_247) AT=840.05n

.meas tran vdout1_248ck830 FIND v(dout1_248) AT=840.05n

.meas tran vdout1_249ck830 FIND v(dout1_249) AT=840.05n

.meas tran vdout1_250ck830 FIND v(dout1_250) AT=840.05n

.meas tran vdout1_251ck830 FIND v(dout1_251) AT=840.05n

.meas tran vdout1_252ck830 FIND v(dout1_252) AT=840.05n

.meas tran vdout1_253ck830 FIND v(dout1_253) AT=840.05n

.meas tran vdout1_254ck830 FIND v(dout1_254) AT=840.05n

.meas tran vdout1_255ck830 FIND v(dout1_255) AT=840.05n

.meas tran vdout1_256ck830 FIND v(dout1_256) AT=840.05n

.meas tran vdout1_0ck840 FIND v(dout1_0) AT=850.05n

.meas tran vdout1_1ck840 FIND v(dout1_1) AT=850.05n

.meas tran vdout1_2ck840 FIND v(dout1_2) AT=850.05n

.meas tran vdout1_3ck840 FIND v(dout1_3) AT=850.05n

.meas tran vdout1_4ck840 FIND v(dout1_4) AT=850.05n

.meas tran vdout1_5ck840 FIND v(dout1_5) AT=850.05n

.meas tran vdout1_6ck840 FIND v(dout1_6) AT=850.05n

.meas tran vdout1_7ck840 FIND v(dout1_7) AT=850.05n

.meas tran vdout1_8ck840 FIND v(dout1_8) AT=850.05n

.meas tran vdout1_9ck840 FIND v(dout1_9) AT=850.05n

.meas tran vdout1_10ck840 FIND v(dout1_10) AT=850.05n

.meas tran vdout1_11ck840 FIND v(dout1_11) AT=850.05n

.meas tran vdout1_12ck840 FIND v(dout1_12) AT=850.05n

.meas tran vdout1_13ck840 FIND v(dout1_13) AT=850.05n

.meas tran vdout1_14ck840 FIND v(dout1_14) AT=850.05n

.meas tran vdout1_15ck840 FIND v(dout1_15) AT=850.05n

.meas tran vdout1_16ck840 FIND v(dout1_16) AT=850.05n

.meas tran vdout1_17ck840 FIND v(dout1_17) AT=850.05n

.meas tran vdout1_18ck840 FIND v(dout1_18) AT=850.05n

.meas tran vdout1_19ck840 FIND v(dout1_19) AT=850.05n

.meas tran vdout1_20ck840 FIND v(dout1_20) AT=850.05n

.meas tran vdout1_21ck840 FIND v(dout1_21) AT=850.05n

.meas tran vdout1_22ck840 FIND v(dout1_22) AT=850.05n

.meas tran vdout1_23ck840 FIND v(dout1_23) AT=850.05n

.meas tran vdout1_24ck840 FIND v(dout1_24) AT=850.05n

.meas tran vdout1_25ck840 FIND v(dout1_25) AT=850.05n

.meas tran vdout1_26ck840 FIND v(dout1_26) AT=850.05n

.meas tran vdout1_27ck840 FIND v(dout1_27) AT=850.05n

.meas tran vdout1_28ck840 FIND v(dout1_28) AT=850.05n

.meas tran vdout1_29ck840 FIND v(dout1_29) AT=850.05n

.meas tran vdout1_30ck840 FIND v(dout1_30) AT=850.05n

.meas tran vdout1_31ck840 FIND v(dout1_31) AT=850.05n

.meas tran vdout1_32ck840 FIND v(dout1_32) AT=850.05n

.meas tran vdout1_33ck840 FIND v(dout1_33) AT=850.05n

.meas tran vdout1_34ck840 FIND v(dout1_34) AT=850.05n

.meas tran vdout1_35ck840 FIND v(dout1_35) AT=850.05n

.meas tran vdout1_36ck840 FIND v(dout1_36) AT=850.05n

.meas tran vdout1_37ck840 FIND v(dout1_37) AT=850.05n

.meas tran vdout1_38ck840 FIND v(dout1_38) AT=850.05n

.meas tran vdout1_39ck840 FIND v(dout1_39) AT=850.05n

.meas tran vdout1_40ck840 FIND v(dout1_40) AT=850.05n

.meas tran vdout1_41ck840 FIND v(dout1_41) AT=850.05n

.meas tran vdout1_42ck840 FIND v(dout1_42) AT=850.05n

.meas tran vdout1_43ck840 FIND v(dout1_43) AT=850.05n

.meas tran vdout1_44ck840 FIND v(dout1_44) AT=850.05n

.meas tran vdout1_45ck840 FIND v(dout1_45) AT=850.05n

.meas tran vdout1_46ck840 FIND v(dout1_46) AT=850.05n

.meas tran vdout1_47ck840 FIND v(dout1_47) AT=850.05n

.meas tran vdout1_48ck840 FIND v(dout1_48) AT=850.05n

.meas tran vdout1_49ck840 FIND v(dout1_49) AT=850.05n

.meas tran vdout1_50ck840 FIND v(dout1_50) AT=850.05n

.meas tran vdout1_51ck840 FIND v(dout1_51) AT=850.05n

.meas tran vdout1_52ck840 FIND v(dout1_52) AT=850.05n

.meas tran vdout1_53ck840 FIND v(dout1_53) AT=850.05n

.meas tran vdout1_54ck840 FIND v(dout1_54) AT=850.05n

.meas tran vdout1_55ck840 FIND v(dout1_55) AT=850.05n

.meas tran vdout1_56ck840 FIND v(dout1_56) AT=850.05n

.meas tran vdout1_57ck840 FIND v(dout1_57) AT=850.05n

.meas tran vdout1_58ck840 FIND v(dout1_58) AT=850.05n

.meas tran vdout1_59ck840 FIND v(dout1_59) AT=850.05n

.meas tran vdout1_60ck840 FIND v(dout1_60) AT=850.05n

.meas tran vdout1_61ck840 FIND v(dout1_61) AT=850.05n

.meas tran vdout1_62ck840 FIND v(dout1_62) AT=850.05n

.meas tran vdout1_63ck840 FIND v(dout1_63) AT=850.05n

.meas tran vdout1_64ck840 FIND v(dout1_64) AT=850.05n

.meas tran vdout1_65ck840 FIND v(dout1_65) AT=850.05n

.meas tran vdout1_66ck840 FIND v(dout1_66) AT=850.05n

.meas tran vdout1_67ck840 FIND v(dout1_67) AT=850.05n

.meas tran vdout1_68ck840 FIND v(dout1_68) AT=850.05n

.meas tran vdout1_69ck840 FIND v(dout1_69) AT=850.05n

.meas tran vdout1_70ck840 FIND v(dout1_70) AT=850.05n

.meas tran vdout1_71ck840 FIND v(dout1_71) AT=850.05n

.meas tran vdout1_72ck840 FIND v(dout1_72) AT=850.05n

.meas tran vdout1_73ck840 FIND v(dout1_73) AT=850.05n

.meas tran vdout1_74ck840 FIND v(dout1_74) AT=850.05n

.meas tran vdout1_75ck840 FIND v(dout1_75) AT=850.05n

.meas tran vdout1_76ck840 FIND v(dout1_76) AT=850.05n

.meas tran vdout1_77ck840 FIND v(dout1_77) AT=850.05n

.meas tran vdout1_78ck840 FIND v(dout1_78) AT=850.05n

.meas tran vdout1_79ck840 FIND v(dout1_79) AT=850.05n

.meas tran vdout1_80ck840 FIND v(dout1_80) AT=850.05n

.meas tran vdout1_81ck840 FIND v(dout1_81) AT=850.05n

.meas tran vdout1_82ck840 FIND v(dout1_82) AT=850.05n

.meas tran vdout1_83ck840 FIND v(dout1_83) AT=850.05n

.meas tran vdout1_84ck840 FIND v(dout1_84) AT=850.05n

.meas tran vdout1_85ck840 FIND v(dout1_85) AT=850.05n

.meas tran vdout1_86ck840 FIND v(dout1_86) AT=850.05n

.meas tran vdout1_87ck840 FIND v(dout1_87) AT=850.05n

.meas tran vdout1_88ck840 FIND v(dout1_88) AT=850.05n

.meas tran vdout1_89ck840 FIND v(dout1_89) AT=850.05n

.meas tran vdout1_90ck840 FIND v(dout1_90) AT=850.05n

.meas tran vdout1_91ck840 FIND v(dout1_91) AT=850.05n

.meas tran vdout1_92ck840 FIND v(dout1_92) AT=850.05n

.meas tran vdout1_93ck840 FIND v(dout1_93) AT=850.05n

.meas tran vdout1_94ck840 FIND v(dout1_94) AT=850.05n

.meas tran vdout1_95ck840 FIND v(dout1_95) AT=850.05n

.meas tran vdout1_96ck840 FIND v(dout1_96) AT=850.05n

.meas tran vdout1_97ck840 FIND v(dout1_97) AT=850.05n

.meas tran vdout1_98ck840 FIND v(dout1_98) AT=850.05n

.meas tran vdout1_99ck840 FIND v(dout1_99) AT=850.05n

.meas tran vdout1_100ck840 FIND v(dout1_100) AT=850.05n

.meas tran vdout1_101ck840 FIND v(dout1_101) AT=850.05n

.meas tran vdout1_102ck840 FIND v(dout1_102) AT=850.05n

.meas tran vdout1_103ck840 FIND v(dout1_103) AT=850.05n

.meas tran vdout1_104ck840 FIND v(dout1_104) AT=850.05n

.meas tran vdout1_105ck840 FIND v(dout1_105) AT=850.05n

.meas tran vdout1_106ck840 FIND v(dout1_106) AT=850.05n

.meas tran vdout1_107ck840 FIND v(dout1_107) AT=850.05n

.meas tran vdout1_108ck840 FIND v(dout1_108) AT=850.05n

.meas tran vdout1_109ck840 FIND v(dout1_109) AT=850.05n

.meas tran vdout1_110ck840 FIND v(dout1_110) AT=850.05n

.meas tran vdout1_111ck840 FIND v(dout1_111) AT=850.05n

.meas tran vdout1_112ck840 FIND v(dout1_112) AT=850.05n

.meas tran vdout1_113ck840 FIND v(dout1_113) AT=850.05n

.meas tran vdout1_114ck840 FIND v(dout1_114) AT=850.05n

.meas tran vdout1_115ck840 FIND v(dout1_115) AT=850.05n

.meas tran vdout1_116ck840 FIND v(dout1_116) AT=850.05n

.meas tran vdout1_117ck840 FIND v(dout1_117) AT=850.05n

.meas tran vdout1_118ck840 FIND v(dout1_118) AT=850.05n

.meas tran vdout1_119ck840 FIND v(dout1_119) AT=850.05n

.meas tran vdout1_120ck840 FIND v(dout1_120) AT=850.05n

.meas tran vdout1_121ck840 FIND v(dout1_121) AT=850.05n

.meas tran vdout1_122ck840 FIND v(dout1_122) AT=850.05n

.meas tran vdout1_123ck840 FIND v(dout1_123) AT=850.05n

.meas tran vdout1_124ck840 FIND v(dout1_124) AT=850.05n

.meas tran vdout1_125ck840 FIND v(dout1_125) AT=850.05n

.meas tran vdout1_126ck840 FIND v(dout1_126) AT=850.05n

.meas tran vdout1_127ck840 FIND v(dout1_127) AT=850.05n

.meas tran vdout1_128ck840 FIND v(dout1_128) AT=850.05n

.meas tran vdout1_129ck840 FIND v(dout1_129) AT=850.05n

.meas tran vdout1_130ck840 FIND v(dout1_130) AT=850.05n

.meas tran vdout1_131ck840 FIND v(dout1_131) AT=850.05n

.meas tran vdout1_132ck840 FIND v(dout1_132) AT=850.05n

.meas tran vdout1_133ck840 FIND v(dout1_133) AT=850.05n

.meas tran vdout1_134ck840 FIND v(dout1_134) AT=850.05n

.meas tran vdout1_135ck840 FIND v(dout1_135) AT=850.05n

.meas tran vdout1_136ck840 FIND v(dout1_136) AT=850.05n

.meas tran vdout1_137ck840 FIND v(dout1_137) AT=850.05n

.meas tran vdout1_138ck840 FIND v(dout1_138) AT=850.05n

.meas tran vdout1_139ck840 FIND v(dout1_139) AT=850.05n

.meas tran vdout1_140ck840 FIND v(dout1_140) AT=850.05n

.meas tran vdout1_141ck840 FIND v(dout1_141) AT=850.05n

.meas tran vdout1_142ck840 FIND v(dout1_142) AT=850.05n

.meas tran vdout1_143ck840 FIND v(dout1_143) AT=850.05n

.meas tran vdout1_144ck840 FIND v(dout1_144) AT=850.05n

.meas tran vdout1_145ck840 FIND v(dout1_145) AT=850.05n

.meas tran vdout1_146ck840 FIND v(dout1_146) AT=850.05n

.meas tran vdout1_147ck840 FIND v(dout1_147) AT=850.05n

.meas tran vdout1_148ck840 FIND v(dout1_148) AT=850.05n

.meas tran vdout1_149ck840 FIND v(dout1_149) AT=850.05n

.meas tran vdout1_150ck840 FIND v(dout1_150) AT=850.05n

.meas tran vdout1_151ck840 FIND v(dout1_151) AT=850.05n

.meas tran vdout1_152ck840 FIND v(dout1_152) AT=850.05n

.meas tran vdout1_153ck840 FIND v(dout1_153) AT=850.05n

.meas tran vdout1_154ck840 FIND v(dout1_154) AT=850.05n

.meas tran vdout1_155ck840 FIND v(dout1_155) AT=850.05n

.meas tran vdout1_156ck840 FIND v(dout1_156) AT=850.05n

.meas tran vdout1_157ck840 FIND v(dout1_157) AT=850.05n

.meas tran vdout1_158ck840 FIND v(dout1_158) AT=850.05n

.meas tran vdout1_159ck840 FIND v(dout1_159) AT=850.05n

.meas tran vdout1_160ck840 FIND v(dout1_160) AT=850.05n

.meas tran vdout1_161ck840 FIND v(dout1_161) AT=850.05n

.meas tran vdout1_162ck840 FIND v(dout1_162) AT=850.05n

.meas tran vdout1_163ck840 FIND v(dout1_163) AT=850.05n

.meas tran vdout1_164ck840 FIND v(dout1_164) AT=850.05n

.meas tran vdout1_165ck840 FIND v(dout1_165) AT=850.05n

.meas tran vdout1_166ck840 FIND v(dout1_166) AT=850.05n

.meas tran vdout1_167ck840 FIND v(dout1_167) AT=850.05n

.meas tran vdout1_168ck840 FIND v(dout1_168) AT=850.05n

.meas tran vdout1_169ck840 FIND v(dout1_169) AT=850.05n

.meas tran vdout1_170ck840 FIND v(dout1_170) AT=850.05n

.meas tran vdout1_171ck840 FIND v(dout1_171) AT=850.05n

.meas tran vdout1_172ck840 FIND v(dout1_172) AT=850.05n

.meas tran vdout1_173ck840 FIND v(dout1_173) AT=850.05n

.meas tran vdout1_174ck840 FIND v(dout1_174) AT=850.05n

.meas tran vdout1_175ck840 FIND v(dout1_175) AT=850.05n

.meas tran vdout1_176ck840 FIND v(dout1_176) AT=850.05n

.meas tran vdout1_177ck840 FIND v(dout1_177) AT=850.05n

.meas tran vdout1_178ck840 FIND v(dout1_178) AT=850.05n

.meas tran vdout1_179ck840 FIND v(dout1_179) AT=850.05n

.meas tran vdout1_180ck840 FIND v(dout1_180) AT=850.05n

.meas tran vdout1_181ck840 FIND v(dout1_181) AT=850.05n

.meas tran vdout1_182ck840 FIND v(dout1_182) AT=850.05n

.meas tran vdout1_183ck840 FIND v(dout1_183) AT=850.05n

.meas tran vdout1_184ck840 FIND v(dout1_184) AT=850.05n

.meas tran vdout1_185ck840 FIND v(dout1_185) AT=850.05n

.meas tran vdout1_186ck840 FIND v(dout1_186) AT=850.05n

.meas tran vdout1_187ck840 FIND v(dout1_187) AT=850.05n

.meas tran vdout1_188ck840 FIND v(dout1_188) AT=850.05n

.meas tran vdout1_189ck840 FIND v(dout1_189) AT=850.05n

.meas tran vdout1_190ck840 FIND v(dout1_190) AT=850.05n

.meas tran vdout1_191ck840 FIND v(dout1_191) AT=850.05n

.meas tran vdout1_192ck840 FIND v(dout1_192) AT=850.05n

.meas tran vdout1_193ck840 FIND v(dout1_193) AT=850.05n

.meas tran vdout1_194ck840 FIND v(dout1_194) AT=850.05n

.meas tran vdout1_195ck840 FIND v(dout1_195) AT=850.05n

.meas tran vdout1_196ck840 FIND v(dout1_196) AT=850.05n

.meas tran vdout1_197ck840 FIND v(dout1_197) AT=850.05n

.meas tran vdout1_198ck840 FIND v(dout1_198) AT=850.05n

.meas tran vdout1_199ck840 FIND v(dout1_199) AT=850.05n

.meas tran vdout1_200ck840 FIND v(dout1_200) AT=850.05n

.meas tran vdout1_201ck840 FIND v(dout1_201) AT=850.05n

.meas tran vdout1_202ck840 FIND v(dout1_202) AT=850.05n

.meas tran vdout1_203ck840 FIND v(dout1_203) AT=850.05n

.meas tran vdout1_204ck840 FIND v(dout1_204) AT=850.05n

.meas tran vdout1_205ck840 FIND v(dout1_205) AT=850.05n

.meas tran vdout1_206ck840 FIND v(dout1_206) AT=850.05n

.meas tran vdout1_207ck840 FIND v(dout1_207) AT=850.05n

.meas tran vdout1_208ck840 FIND v(dout1_208) AT=850.05n

.meas tran vdout1_209ck840 FIND v(dout1_209) AT=850.05n

.meas tran vdout1_210ck840 FIND v(dout1_210) AT=850.05n

.meas tran vdout1_211ck840 FIND v(dout1_211) AT=850.05n

.meas tran vdout1_212ck840 FIND v(dout1_212) AT=850.05n

.meas tran vdout1_213ck840 FIND v(dout1_213) AT=850.05n

.meas tran vdout1_214ck840 FIND v(dout1_214) AT=850.05n

.meas tran vdout1_215ck840 FIND v(dout1_215) AT=850.05n

.meas tran vdout1_216ck840 FIND v(dout1_216) AT=850.05n

.meas tran vdout1_217ck840 FIND v(dout1_217) AT=850.05n

.meas tran vdout1_218ck840 FIND v(dout1_218) AT=850.05n

.meas tran vdout1_219ck840 FIND v(dout1_219) AT=850.05n

.meas tran vdout1_220ck840 FIND v(dout1_220) AT=850.05n

.meas tran vdout1_221ck840 FIND v(dout1_221) AT=850.05n

.meas tran vdout1_222ck840 FIND v(dout1_222) AT=850.05n

.meas tran vdout1_223ck840 FIND v(dout1_223) AT=850.05n

.meas tran vdout1_224ck840 FIND v(dout1_224) AT=850.05n

.meas tran vdout1_225ck840 FIND v(dout1_225) AT=850.05n

.meas tran vdout1_226ck840 FIND v(dout1_226) AT=850.05n

.meas tran vdout1_227ck840 FIND v(dout1_227) AT=850.05n

.meas tran vdout1_228ck840 FIND v(dout1_228) AT=850.05n

.meas tran vdout1_229ck840 FIND v(dout1_229) AT=850.05n

.meas tran vdout1_230ck840 FIND v(dout1_230) AT=850.05n

.meas tran vdout1_231ck840 FIND v(dout1_231) AT=850.05n

.meas tran vdout1_232ck840 FIND v(dout1_232) AT=850.05n

.meas tran vdout1_233ck840 FIND v(dout1_233) AT=850.05n

.meas tran vdout1_234ck840 FIND v(dout1_234) AT=850.05n

.meas tran vdout1_235ck840 FIND v(dout1_235) AT=850.05n

.meas tran vdout1_236ck840 FIND v(dout1_236) AT=850.05n

.meas tran vdout1_237ck840 FIND v(dout1_237) AT=850.05n

.meas tran vdout1_238ck840 FIND v(dout1_238) AT=850.05n

.meas tran vdout1_239ck840 FIND v(dout1_239) AT=850.05n

.meas tran vdout1_240ck840 FIND v(dout1_240) AT=850.05n

.meas tran vdout1_241ck840 FIND v(dout1_241) AT=850.05n

.meas tran vdout1_242ck840 FIND v(dout1_242) AT=850.05n

.meas tran vdout1_243ck840 FIND v(dout1_243) AT=850.05n

.meas tran vdout1_244ck840 FIND v(dout1_244) AT=850.05n

.meas tran vdout1_245ck840 FIND v(dout1_245) AT=850.05n

.meas tran vdout1_246ck840 FIND v(dout1_246) AT=850.05n

.meas tran vdout1_247ck840 FIND v(dout1_247) AT=850.05n

.meas tran vdout1_248ck840 FIND v(dout1_248) AT=850.05n

.meas tran vdout1_249ck840 FIND v(dout1_249) AT=850.05n

.meas tran vdout1_250ck840 FIND v(dout1_250) AT=850.05n

.meas tran vdout1_251ck840 FIND v(dout1_251) AT=850.05n

.meas tran vdout1_252ck840 FIND v(dout1_252) AT=850.05n

.meas tran vdout1_253ck840 FIND v(dout1_253) AT=850.05n

.meas tran vdout1_254ck840 FIND v(dout1_254) AT=850.05n

.meas tran vdout1_255ck840 FIND v(dout1_255) AT=850.05n

.meas tran vdout1_256ck840 FIND v(dout1_256) AT=850.05n

.meas tran vdout1_0ck850 FIND v(dout1_0) AT=860.05n

.meas tran vdout1_1ck850 FIND v(dout1_1) AT=860.05n

.meas tran vdout1_2ck850 FIND v(dout1_2) AT=860.05n

.meas tran vdout1_3ck850 FIND v(dout1_3) AT=860.05n

.meas tran vdout1_4ck850 FIND v(dout1_4) AT=860.05n

.meas tran vdout1_5ck850 FIND v(dout1_5) AT=860.05n

.meas tran vdout1_6ck850 FIND v(dout1_6) AT=860.05n

.meas tran vdout1_7ck850 FIND v(dout1_7) AT=860.05n

.meas tran vdout1_8ck850 FIND v(dout1_8) AT=860.05n

.meas tran vdout1_9ck850 FIND v(dout1_9) AT=860.05n

.meas tran vdout1_10ck850 FIND v(dout1_10) AT=860.05n

.meas tran vdout1_11ck850 FIND v(dout1_11) AT=860.05n

.meas tran vdout1_12ck850 FIND v(dout1_12) AT=860.05n

.meas tran vdout1_13ck850 FIND v(dout1_13) AT=860.05n

.meas tran vdout1_14ck850 FIND v(dout1_14) AT=860.05n

.meas tran vdout1_15ck850 FIND v(dout1_15) AT=860.05n

.meas tran vdout1_16ck850 FIND v(dout1_16) AT=860.05n

.meas tran vdout1_17ck850 FIND v(dout1_17) AT=860.05n

.meas tran vdout1_18ck850 FIND v(dout1_18) AT=860.05n

.meas tran vdout1_19ck850 FIND v(dout1_19) AT=860.05n

.meas tran vdout1_20ck850 FIND v(dout1_20) AT=860.05n

.meas tran vdout1_21ck850 FIND v(dout1_21) AT=860.05n

.meas tran vdout1_22ck850 FIND v(dout1_22) AT=860.05n

.meas tran vdout1_23ck850 FIND v(dout1_23) AT=860.05n

.meas tran vdout1_24ck850 FIND v(dout1_24) AT=860.05n

.meas tran vdout1_25ck850 FIND v(dout1_25) AT=860.05n

.meas tran vdout1_26ck850 FIND v(dout1_26) AT=860.05n

.meas tran vdout1_27ck850 FIND v(dout1_27) AT=860.05n

.meas tran vdout1_28ck850 FIND v(dout1_28) AT=860.05n

.meas tran vdout1_29ck850 FIND v(dout1_29) AT=860.05n

.meas tran vdout1_30ck850 FIND v(dout1_30) AT=860.05n

.meas tran vdout1_31ck850 FIND v(dout1_31) AT=860.05n

.meas tran vdout1_32ck850 FIND v(dout1_32) AT=860.05n

.meas tran vdout1_33ck850 FIND v(dout1_33) AT=860.05n

.meas tran vdout1_34ck850 FIND v(dout1_34) AT=860.05n

.meas tran vdout1_35ck850 FIND v(dout1_35) AT=860.05n

.meas tran vdout1_36ck850 FIND v(dout1_36) AT=860.05n

.meas tran vdout1_37ck850 FIND v(dout1_37) AT=860.05n

.meas tran vdout1_38ck850 FIND v(dout1_38) AT=860.05n

.meas tran vdout1_39ck850 FIND v(dout1_39) AT=860.05n

.meas tran vdout1_40ck850 FIND v(dout1_40) AT=860.05n

.meas tran vdout1_41ck850 FIND v(dout1_41) AT=860.05n

.meas tran vdout1_42ck850 FIND v(dout1_42) AT=860.05n

.meas tran vdout1_43ck850 FIND v(dout1_43) AT=860.05n

.meas tran vdout1_44ck850 FIND v(dout1_44) AT=860.05n

.meas tran vdout1_45ck850 FIND v(dout1_45) AT=860.05n

.meas tran vdout1_46ck850 FIND v(dout1_46) AT=860.05n

.meas tran vdout1_47ck850 FIND v(dout1_47) AT=860.05n

.meas tran vdout1_48ck850 FIND v(dout1_48) AT=860.05n

.meas tran vdout1_49ck850 FIND v(dout1_49) AT=860.05n

.meas tran vdout1_50ck850 FIND v(dout1_50) AT=860.05n

.meas tran vdout1_51ck850 FIND v(dout1_51) AT=860.05n

.meas tran vdout1_52ck850 FIND v(dout1_52) AT=860.05n

.meas tran vdout1_53ck850 FIND v(dout1_53) AT=860.05n

.meas tran vdout1_54ck850 FIND v(dout1_54) AT=860.05n

.meas tran vdout1_55ck850 FIND v(dout1_55) AT=860.05n

.meas tran vdout1_56ck850 FIND v(dout1_56) AT=860.05n

.meas tran vdout1_57ck850 FIND v(dout1_57) AT=860.05n

.meas tran vdout1_58ck850 FIND v(dout1_58) AT=860.05n

.meas tran vdout1_59ck850 FIND v(dout1_59) AT=860.05n

.meas tran vdout1_60ck850 FIND v(dout1_60) AT=860.05n

.meas tran vdout1_61ck850 FIND v(dout1_61) AT=860.05n

.meas tran vdout1_62ck850 FIND v(dout1_62) AT=860.05n

.meas tran vdout1_63ck850 FIND v(dout1_63) AT=860.05n

.meas tran vdout1_64ck850 FIND v(dout1_64) AT=860.05n

.meas tran vdout1_65ck850 FIND v(dout1_65) AT=860.05n

.meas tran vdout1_66ck850 FIND v(dout1_66) AT=860.05n

.meas tran vdout1_67ck850 FIND v(dout1_67) AT=860.05n

.meas tran vdout1_68ck850 FIND v(dout1_68) AT=860.05n

.meas tran vdout1_69ck850 FIND v(dout1_69) AT=860.05n

.meas tran vdout1_70ck850 FIND v(dout1_70) AT=860.05n

.meas tran vdout1_71ck850 FIND v(dout1_71) AT=860.05n

.meas tran vdout1_72ck850 FIND v(dout1_72) AT=860.05n

.meas tran vdout1_73ck850 FIND v(dout1_73) AT=860.05n

.meas tran vdout1_74ck850 FIND v(dout1_74) AT=860.05n

.meas tran vdout1_75ck850 FIND v(dout1_75) AT=860.05n

.meas tran vdout1_76ck850 FIND v(dout1_76) AT=860.05n

.meas tran vdout1_77ck850 FIND v(dout1_77) AT=860.05n

.meas tran vdout1_78ck850 FIND v(dout1_78) AT=860.05n

.meas tran vdout1_79ck850 FIND v(dout1_79) AT=860.05n

.meas tran vdout1_80ck850 FIND v(dout1_80) AT=860.05n

.meas tran vdout1_81ck850 FIND v(dout1_81) AT=860.05n

.meas tran vdout1_82ck850 FIND v(dout1_82) AT=860.05n

.meas tran vdout1_83ck850 FIND v(dout1_83) AT=860.05n

.meas tran vdout1_84ck850 FIND v(dout1_84) AT=860.05n

.meas tran vdout1_85ck850 FIND v(dout1_85) AT=860.05n

.meas tran vdout1_86ck850 FIND v(dout1_86) AT=860.05n

.meas tran vdout1_87ck850 FIND v(dout1_87) AT=860.05n

.meas tran vdout1_88ck850 FIND v(dout1_88) AT=860.05n

.meas tran vdout1_89ck850 FIND v(dout1_89) AT=860.05n

.meas tran vdout1_90ck850 FIND v(dout1_90) AT=860.05n

.meas tran vdout1_91ck850 FIND v(dout1_91) AT=860.05n

.meas tran vdout1_92ck850 FIND v(dout1_92) AT=860.05n

.meas tran vdout1_93ck850 FIND v(dout1_93) AT=860.05n

.meas tran vdout1_94ck850 FIND v(dout1_94) AT=860.05n

.meas tran vdout1_95ck850 FIND v(dout1_95) AT=860.05n

.meas tran vdout1_96ck850 FIND v(dout1_96) AT=860.05n

.meas tran vdout1_97ck850 FIND v(dout1_97) AT=860.05n

.meas tran vdout1_98ck850 FIND v(dout1_98) AT=860.05n

.meas tran vdout1_99ck850 FIND v(dout1_99) AT=860.05n

.meas tran vdout1_100ck850 FIND v(dout1_100) AT=860.05n

.meas tran vdout1_101ck850 FIND v(dout1_101) AT=860.05n

.meas tran vdout1_102ck850 FIND v(dout1_102) AT=860.05n

.meas tran vdout1_103ck850 FIND v(dout1_103) AT=860.05n

.meas tran vdout1_104ck850 FIND v(dout1_104) AT=860.05n

.meas tran vdout1_105ck850 FIND v(dout1_105) AT=860.05n

.meas tran vdout1_106ck850 FIND v(dout1_106) AT=860.05n

.meas tran vdout1_107ck850 FIND v(dout1_107) AT=860.05n

.meas tran vdout1_108ck850 FIND v(dout1_108) AT=860.05n

.meas tran vdout1_109ck850 FIND v(dout1_109) AT=860.05n

.meas tran vdout1_110ck850 FIND v(dout1_110) AT=860.05n

.meas tran vdout1_111ck850 FIND v(dout1_111) AT=860.05n

.meas tran vdout1_112ck850 FIND v(dout1_112) AT=860.05n

.meas tran vdout1_113ck850 FIND v(dout1_113) AT=860.05n

.meas tran vdout1_114ck850 FIND v(dout1_114) AT=860.05n

.meas tran vdout1_115ck850 FIND v(dout1_115) AT=860.05n

.meas tran vdout1_116ck850 FIND v(dout1_116) AT=860.05n

.meas tran vdout1_117ck850 FIND v(dout1_117) AT=860.05n

.meas tran vdout1_118ck850 FIND v(dout1_118) AT=860.05n

.meas tran vdout1_119ck850 FIND v(dout1_119) AT=860.05n

.meas tran vdout1_120ck850 FIND v(dout1_120) AT=860.05n

.meas tran vdout1_121ck850 FIND v(dout1_121) AT=860.05n

.meas tran vdout1_122ck850 FIND v(dout1_122) AT=860.05n

.meas tran vdout1_123ck850 FIND v(dout1_123) AT=860.05n

.meas tran vdout1_124ck850 FIND v(dout1_124) AT=860.05n

.meas tran vdout1_125ck850 FIND v(dout1_125) AT=860.05n

.meas tran vdout1_126ck850 FIND v(dout1_126) AT=860.05n

.meas tran vdout1_127ck850 FIND v(dout1_127) AT=860.05n

.meas tran vdout1_128ck850 FIND v(dout1_128) AT=860.05n

.meas tran vdout1_129ck850 FIND v(dout1_129) AT=860.05n

.meas tran vdout1_130ck850 FIND v(dout1_130) AT=860.05n

.meas tran vdout1_131ck850 FIND v(dout1_131) AT=860.05n

.meas tran vdout1_132ck850 FIND v(dout1_132) AT=860.05n

.meas tran vdout1_133ck850 FIND v(dout1_133) AT=860.05n

.meas tran vdout1_134ck850 FIND v(dout1_134) AT=860.05n

.meas tran vdout1_135ck850 FIND v(dout1_135) AT=860.05n

.meas tran vdout1_136ck850 FIND v(dout1_136) AT=860.05n

.meas tran vdout1_137ck850 FIND v(dout1_137) AT=860.05n

.meas tran vdout1_138ck850 FIND v(dout1_138) AT=860.05n

.meas tran vdout1_139ck850 FIND v(dout1_139) AT=860.05n

.meas tran vdout1_140ck850 FIND v(dout1_140) AT=860.05n

.meas tran vdout1_141ck850 FIND v(dout1_141) AT=860.05n

.meas tran vdout1_142ck850 FIND v(dout1_142) AT=860.05n

.meas tran vdout1_143ck850 FIND v(dout1_143) AT=860.05n

.meas tran vdout1_144ck850 FIND v(dout1_144) AT=860.05n

.meas tran vdout1_145ck850 FIND v(dout1_145) AT=860.05n

.meas tran vdout1_146ck850 FIND v(dout1_146) AT=860.05n

.meas tran vdout1_147ck850 FIND v(dout1_147) AT=860.05n

.meas tran vdout1_148ck850 FIND v(dout1_148) AT=860.05n

.meas tran vdout1_149ck850 FIND v(dout1_149) AT=860.05n

.meas tran vdout1_150ck850 FIND v(dout1_150) AT=860.05n

.meas tran vdout1_151ck850 FIND v(dout1_151) AT=860.05n

.meas tran vdout1_152ck850 FIND v(dout1_152) AT=860.05n

.meas tran vdout1_153ck850 FIND v(dout1_153) AT=860.05n

.meas tran vdout1_154ck850 FIND v(dout1_154) AT=860.05n

.meas tran vdout1_155ck850 FIND v(dout1_155) AT=860.05n

.meas tran vdout1_156ck850 FIND v(dout1_156) AT=860.05n

.meas tran vdout1_157ck850 FIND v(dout1_157) AT=860.05n

.meas tran vdout1_158ck850 FIND v(dout1_158) AT=860.05n

.meas tran vdout1_159ck850 FIND v(dout1_159) AT=860.05n

.meas tran vdout1_160ck850 FIND v(dout1_160) AT=860.05n

.meas tran vdout1_161ck850 FIND v(dout1_161) AT=860.05n

.meas tran vdout1_162ck850 FIND v(dout1_162) AT=860.05n

.meas tran vdout1_163ck850 FIND v(dout1_163) AT=860.05n

.meas tran vdout1_164ck850 FIND v(dout1_164) AT=860.05n

.meas tran vdout1_165ck850 FIND v(dout1_165) AT=860.05n

.meas tran vdout1_166ck850 FIND v(dout1_166) AT=860.05n

.meas tran vdout1_167ck850 FIND v(dout1_167) AT=860.05n

.meas tran vdout1_168ck850 FIND v(dout1_168) AT=860.05n

.meas tran vdout1_169ck850 FIND v(dout1_169) AT=860.05n

.meas tran vdout1_170ck850 FIND v(dout1_170) AT=860.05n

.meas tran vdout1_171ck850 FIND v(dout1_171) AT=860.05n

.meas tran vdout1_172ck850 FIND v(dout1_172) AT=860.05n

.meas tran vdout1_173ck850 FIND v(dout1_173) AT=860.05n

.meas tran vdout1_174ck850 FIND v(dout1_174) AT=860.05n

.meas tran vdout1_175ck850 FIND v(dout1_175) AT=860.05n

.meas tran vdout1_176ck850 FIND v(dout1_176) AT=860.05n

.meas tran vdout1_177ck850 FIND v(dout1_177) AT=860.05n

.meas tran vdout1_178ck850 FIND v(dout1_178) AT=860.05n

.meas tran vdout1_179ck850 FIND v(dout1_179) AT=860.05n

.meas tran vdout1_180ck850 FIND v(dout1_180) AT=860.05n

.meas tran vdout1_181ck850 FIND v(dout1_181) AT=860.05n

.meas tran vdout1_182ck850 FIND v(dout1_182) AT=860.05n

.meas tran vdout1_183ck850 FIND v(dout1_183) AT=860.05n

.meas tran vdout1_184ck850 FIND v(dout1_184) AT=860.05n

.meas tran vdout1_185ck850 FIND v(dout1_185) AT=860.05n

.meas tran vdout1_186ck850 FIND v(dout1_186) AT=860.05n

.meas tran vdout1_187ck850 FIND v(dout1_187) AT=860.05n

.meas tran vdout1_188ck850 FIND v(dout1_188) AT=860.05n

.meas tran vdout1_189ck850 FIND v(dout1_189) AT=860.05n

.meas tran vdout1_190ck850 FIND v(dout1_190) AT=860.05n

.meas tran vdout1_191ck850 FIND v(dout1_191) AT=860.05n

.meas tran vdout1_192ck850 FIND v(dout1_192) AT=860.05n

.meas tran vdout1_193ck850 FIND v(dout1_193) AT=860.05n

.meas tran vdout1_194ck850 FIND v(dout1_194) AT=860.05n

.meas tran vdout1_195ck850 FIND v(dout1_195) AT=860.05n

.meas tran vdout1_196ck850 FIND v(dout1_196) AT=860.05n

.meas tran vdout1_197ck850 FIND v(dout1_197) AT=860.05n

.meas tran vdout1_198ck850 FIND v(dout1_198) AT=860.05n

.meas tran vdout1_199ck850 FIND v(dout1_199) AT=860.05n

.meas tran vdout1_200ck850 FIND v(dout1_200) AT=860.05n

.meas tran vdout1_201ck850 FIND v(dout1_201) AT=860.05n

.meas tran vdout1_202ck850 FIND v(dout1_202) AT=860.05n

.meas tran vdout1_203ck850 FIND v(dout1_203) AT=860.05n

.meas tran vdout1_204ck850 FIND v(dout1_204) AT=860.05n

.meas tran vdout1_205ck850 FIND v(dout1_205) AT=860.05n

.meas tran vdout1_206ck850 FIND v(dout1_206) AT=860.05n

.meas tran vdout1_207ck850 FIND v(dout1_207) AT=860.05n

.meas tran vdout1_208ck850 FIND v(dout1_208) AT=860.05n

.meas tran vdout1_209ck850 FIND v(dout1_209) AT=860.05n

.meas tran vdout1_210ck850 FIND v(dout1_210) AT=860.05n

.meas tran vdout1_211ck850 FIND v(dout1_211) AT=860.05n

.meas tran vdout1_212ck850 FIND v(dout1_212) AT=860.05n

.meas tran vdout1_213ck850 FIND v(dout1_213) AT=860.05n

.meas tran vdout1_214ck850 FIND v(dout1_214) AT=860.05n

.meas tran vdout1_215ck850 FIND v(dout1_215) AT=860.05n

.meas tran vdout1_216ck850 FIND v(dout1_216) AT=860.05n

.meas tran vdout1_217ck850 FIND v(dout1_217) AT=860.05n

.meas tran vdout1_218ck850 FIND v(dout1_218) AT=860.05n

.meas tran vdout1_219ck850 FIND v(dout1_219) AT=860.05n

.meas tran vdout1_220ck850 FIND v(dout1_220) AT=860.05n

.meas tran vdout1_221ck850 FIND v(dout1_221) AT=860.05n

.meas tran vdout1_222ck850 FIND v(dout1_222) AT=860.05n

.meas tran vdout1_223ck850 FIND v(dout1_223) AT=860.05n

.meas tran vdout1_224ck850 FIND v(dout1_224) AT=860.05n

.meas tran vdout1_225ck850 FIND v(dout1_225) AT=860.05n

.meas tran vdout1_226ck850 FIND v(dout1_226) AT=860.05n

.meas tran vdout1_227ck850 FIND v(dout1_227) AT=860.05n

.meas tran vdout1_228ck850 FIND v(dout1_228) AT=860.05n

.meas tran vdout1_229ck850 FIND v(dout1_229) AT=860.05n

.meas tran vdout1_230ck850 FIND v(dout1_230) AT=860.05n

.meas tran vdout1_231ck850 FIND v(dout1_231) AT=860.05n

.meas tran vdout1_232ck850 FIND v(dout1_232) AT=860.05n

.meas tran vdout1_233ck850 FIND v(dout1_233) AT=860.05n

.meas tran vdout1_234ck850 FIND v(dout1_234) AT=860.05n

.meas tran vdout1_235ck850 FIND v(dout1_235) AT=860.05n

.meas tran vdout1_236ck850 FIND v(dout1_236) AT=860.05n

.meas tran vdout1_237ck850 FIND v(dout1_237) AT=860.05n

.meas tran vdout1_238ck850 FIND v(dout1_238) AT=860.05n

.meas tran vdout1_239ck850 FIND v(dout1_239) AT=860.05n

.meas tran vdout1_240ck850 FIND v(dout1_240) AT=860.05n

.meas tran vdout1_241ck850 FIND v(dout1_241) AT=860.05n

.meas tran vdout1_242ck850 FIND v(dout1_242) AT=860.05n

.meas tran vdout1_243ck850 FIND v(dout1_243) AT=860.05n

.meas tran vdout1_244ck850 FIND v(dout1_244) AT=860.05n

.meas tran vdout1_245ck850 FIND v(dout1_245) AT=860.05n

.meas tran vdout1_246ck850 FIND v(dout1_246) AT=860.05n

.meas tran vdout1_247ck850 FIND v(dout1_247) AT=860.05n

.meas tran vdout1_248ck850 FIND v(dout1_248) AT=860.05n

.meas tran vdout1_249ck850 FIND v(dout1_249) AT=860.05n

.meas tran vdout1_250ck850 FIND v(dout1_250) AT=860.05n

.meas tran vdout1_251ck850 FIND v(dout1_251) AT=860.05n

.meas tran vdout1_252ck850 FIND v(dout1_252) AT=860.05n

.meas tran vdout1_253ck850 FIND v(dout1_253) AT=860.05n

.meas tran vdout1_254ck850 FIND v(dout1_254) AT=860.05n

.meas tran vdout1_255ck850 FIND v(dout1_255) AT=860.05n

.meas tran vdout1_256ck850 FIND v(dout1_256) AT=860.05n

.meas tran vdout1_0ck860 FIND v(dout1_0) AT=870.05n

.meas tran vdout1_1ck860 FIND v(dout1_1) AT=870.05n

.meas tran vdout1_2ck860 FIND v(dout1_2) AT=870.05n

.meas tran vdout1_3ck860 FIND v(dout1_3) AT=870.05n

.meas tran vdout1_4ck860 FIND v(dout1_4) AT=870.05n

.meas tran vdout1_5ck860 FIND v(dout1_5) AT=870.05n

.meas tran vdout1_6ck860 FIND v(dout1_6) AT=870.05n

.meas tran vdout1_7ck860 FIND v(dout1_7) AT=870.05n

.meas tran vdout1_8ck860 FIND v(dout1_8) AT=870.05n

.meas tran vdout1_9ck860 FIND v(dout1_9) AT=870.05n

.meas tran vdout1_10ck860 FIND v(dout1_10) AT=870.05n

.meas tran vdout1_11ck860 FIND v(dout1_11) AT=870.05n

.meas tran vdout1_12ck860 FIND v(dout1_12) AT=870.05n

.meas tran vdout1_13ck860 FIND v(dout1_13) AT=870.05n

.meas tran vdout1_14ck860 FIND v(dout1_14) AT=870.05n

.meas tran vdout1_15ck860 FIND v(dout1_15) AT=870.05n

.meas tran vdout1_16ck860 FIND v(dout1_16) AT=870.05n

.meas tran vdout1_17ck860 FIND v(dout1_17) AT=870.05n

.meas tran vdout1_18ck860 FIND v(dout1_18) AT=870.05n

.meas tran vdout1_19ck860 FIND v(dout1_19) AT=870.05n

.meas tran vdout1_20ck860 FIND v(dout1_20) AT=870.05n

.meas tran vdout1_21ck860 FIND v(dout1_21) AT=870.05n

.meas tran vdout1_22ck860 FIND v(dout1_22) AT=870.05n

.meas tran vdout1_23ck860 FIND v(dout1_23) AT=870.05n

.meas tran vdout1_24ck860 FIND v(dout1_24) AT=870.05n

.meas tran vdout1_25ck860 FIND v(dout1_25) AT=870.05n

.meas tran vdout1_26ck860 FIND v(dout1_26) AT=870.05n

.meas tran vdout1_27ck860 FIND v(dout1_27) AT=870.05n

.meas tran vdout1_28ck860 FIND v(dout1_28) AT=870.05n

.meas tran vdout1_29ck860 FIND v(dout1_29) AT=870.05n

.meas tran vdout1_30ck860 FIND v(dout1_30) AT=870.05n

.meas tran vdout1_31ck860 FIND v(dout1_31) AT=870.05n

.meas tran vdout1_32ck860 FIND v(dout1_32) AT=870.05n

.meas tran vdout1_33ck860 FIND v(dout1_33) AT=870.05n

.meas tran vdout1_34ck860 FIND v(dout1_34) AT=870.05n

.meas tran vdout1_35ck860 FIND v(dout1_35) AT=870.05n

.meas tran vdout1_36ck860 FIND v(dout1_36) AT=870.05n

.meas tran vdout1_37ck860 FIND v(dout1_37) AT=870.05n

.meas tran vdout1_38ck860 FIND v(dout1_38) AT=870.05n

.meas tran vdout1_39ck860 FIND v(dout1_39) AT=870.05n

.meas tran vdout1_40ck860 FIND v(dout1_40) AT=870.05n

.meas tran vdout1_41ck860 FIND v(dout1_41) AT=870.05n

.meas tran vdout1_42ck860 FIND v(dout1_42) AT=870.05n

.meas tran vdout1_43ck860 FIND v(dout1_43) AT=870.05n

.meas tran vdout1_44ck860 FIND v(dout1_44) AT=870.05n

.meas tran vdout1_45ck860 FIND v(dout1_45) AT=870.05n

.meas tran vdout1_46ck860 FIND v(dout1_46) AT=870.05n

.meas tran vdout1_47ck860 FIND v(dout1_47) AT=870.05n

.meas tran vdout1_48ck860 FIND v(dout1_48) AT=870.05n

.meas tran vdout1_49ck860 FIND v(dout1_49) AT=870.05n

.meas tran vdout1_50ck860 FIND v(dout1_50) AT=870.05n

.meas tran vdout1_51ck860 FIND v(dout1_51) AT=870.05n

.meas tran vdout1_52ck860 FIND v(dout1_52) AT=870.05n

.meas tran vdout1_53ck860 FIND v(dout1_53) AT=870.05n

.meas tran vdout1_54ck860 FIND v(dout1_54) AT=870.05n

.meas tran vdout1_55ck860 FIND v(dout1_55) AT=870.05n

.meas tran vdout1_56ck860 FIND v(dout1_56) AT=870.05n

.meas tran vdout1_57ck860 FIND v(dout1_57) AT=870.05n

.meas tran vdout1_58ck860 FIND v(dout1_58) AT=870.05n

.meas tran vdout1_59ck860 FIND v(dout1_59) AT=870.05n

.meas tran vdout1_60ck860 FIND v(dout1_60) AT=870.05n

.meas tran vdout1_61ck860 FIND v(dout1_61) AT=870.05n

.meas tran vdout1_62ck860 FIND v(dout1_62) AT=870.05n

.meas tran vdout1_63ck860 FIND v(dout1_63) AT=870.05n

.meas tran vdout1_64ck860 FIND v(dout1_64) AT=870.05n

.meas tran vdout1_65ck860 FIND v(dout1_65) AT=870.05n

.meas tran vdout1_66ck860 FIND v(dout1_66) AT=870.05n

.meas tran vdout1_67ck860 FIND v(dout1_67) AT=870.05n

.meas tran vdout1_68ck860 FIND v(dout1_68) AT=870.05n

.meas tran vdout1_69ck860 FIND v(dout1_69) AT=870.05n

.meas tran vdout1_70ck860 FIND v(dout1_70) AT=870.05n

.meas tran vdout1_71ck860 FIND v(dout1_71) AT=870.05n

.meas tran vdout1_72ck860 FIND v(dout1_72) AT=870.05n

.meas tran vdout1_73ck860 FIND v(dout1_73) AT=870.05n

.meas tran vdout1_74ck860 FIND v(dout1_74) AT=870.05n

.meas tran vdout1_75ck860 FIND v(dout1_75) AT=870.05n

.meas tran vdout1_76ck860 FIND v(dout1_76) AT=870.05n

.meas tran vdout1_77ck860 FIND v(dout1_77) AT=870.05n

.meas tran vdout1_78ck860 FIND v(dout1_78) AT=870.05n

.meas tran vdout1_79ck860 FIND v(dout1_79) AT=870.05n

.meas tran vdout1_80ck860 FIND v(dout1_80) AT=870.05n

.meas tran vdout1_81ck860 FIND v(dout1_81) AT=870.05n

.meas tran vdout1_82ck860 FIND v(dout1_82) AT=870.05n

.meas tran vdout1_83ck860 FIND v(dout1_83) AT=870.05n

.meas tran vdout1_84ck860 FIND v(dout1_84) AT=870.05n

.meas tran vdout1_85ck860 FIND v(dout1_85) AT=870.05n

.meas tran vdout1_86ck860 FIND v(dout1_86) AT=870.05n

.meas tran vdout1_87ck860 FIND v(dout1_87) AT=870.05n

.meas tran vdout1_88ck860 FIND v(dout1_88) AT=870.05n

.meas tran vdout1_89ck860 FIND v(dout1_89) AT=870.05n

.meas tran vdout1_90ck860 FIND v(dout1_90) AT=870.05n

.meas tran vdout1_91ck860 FIND v(dout1_91) AT=870.05n

.meas tran vdout1_92ck860 FIND v(dout1_92) AT=870.05n

.meas tran vdout1_93ck860 FIND v(dout1_93) AT=870.05n

.meas tran vdout1_94ck860 FIND v(dout1_94) AT=870.05n

.meas tran vdout1_95ck860 FIND v(dout1_95) AT=870.05n

.meas tran vdout1_96ck860 FIND v(dout1_96) AT=870.05n

.meas tran vdout1_97ck860 FIND v(dout1_97) AT=870.05n

.meas tran vdout1_98ck860 FIND v(dout1_98) AT=870.05n

.meas tran vdout1_99ck860 FIND v(dout1_99) AT=870.05n

.meas tran vdout1_100ck860 FIND v(dout1_100) AT=870.05n

.meas tran vdout1_101ck860 FIND v(dout1_101) AT=870.05n

.meas tran vdout1_102ck860 FIND v(dout1_102) AT=870.05n

.meas tran vdout1_103ck860 FIND v(dout1_103) AT=870.05n

.meas tran vdout1_104ck860 FIND v(dout1_104) AT=870.05n

.meas tran vdout1_105ck860 FIND v(dout1_105) AT=870.05n

.meas tran vdout1_106ck860 FIND v(dout1_106) AT=870.05n

.meas tran vdout1_107ck860 FIND v(dout1_107) AT=870.05n

.meas tran vdout1_108ck860 FIND v(dout1_108) AT=870.05n

.meas tran vdout1_109ck860 FIND v(dout1_109) AT=870.05n

.meas tran vdout1_110ck860 FIND v(dout1_110) AT=870.05n

.meas tran vdout1_111ck860 FIND v(dout1_111) AT=870.05n

.meas tran vdout1_112ck860 FIND v(dout1_112) AT=870.05n

.meas tran vdout1_113ck860 FIND v(dout1_113) AT=870.05n

.meas tran vdout1_114ck860 FIND v(dout1_114) AT=870.05n

.meas tran vdout1_115ck860 FIND v(dout1_115) AT=870.05n

.meas tran vdout1_116ck860 FIND v(dout1_116) AT=870.05n

.meas tran vdout1_117ck860 FIND v(dout1_117) AT=870.05n

.meas tran vdout1_118ck860 FIND v(dout1_118) AT=870.05n

.meas tran vdout1_119ck860 FIND v(dout1_119) AT=870.05n

.meas tran vdout1_120ck860 FIND v(dout1_120) AT=870.05n

.meas tran vdout1_121ck860 FIND v(dout1_121) AT=870.05n

.meas tran vdout1_122ck860 FIND v(dout1_122) AT=870.05n

.meas tran vdout1_123ck860 FIND v(dout1_123) AT=870.05n

.meas tran vdout1_124ck860 FIND v(dout1_124) AT=870.05n

.meas tran vdout1_125ck860 FIND v(dout1_125) AT=870.05n

.meas tran vdout1_126ck860 FIND v(dout1_126) AT=870.05n

.meas tran vdout1_127ck860 FIND v(dout1_127) AT=870.05n

.meas tran vdout1_128ck860 FIND v(dout1_128) AT=870.05n

.meas tran vdout1_129ck860 FIND v(dout1_129) AT=870.05n

.meas tran vdout1_130ck860 FIND v(dout1_130) AT=870.05n

.meas tran vdout1_131ck860 FIND v(dout1_131) AT=870.05n

.meas tran vdout1_132ck860 FIND v(dout1_132) AT=870.05n

.meas tran vdout1_133ck860 FIND v(dout1_133) AT=870.05n

.meas tran vdout1_134ck860 FIND v(dout1_134) AT=870.05n

.meas tran vdout1_135ck860 FIND v(dout1_135) AT=870.05n

.meas tran vdout1_136ck860 FIND v(dout1_136) AT=870.05n

.meas tran vdout1_137ck860 FIND v(dout1_137) AT=870.05n

.meas tran vdout1_138ck860 FIND v(dout1_138) AT=870.05n

.meas tran vdout1_139ck860 FIND v(dout1_139) AT=870.05n

.meas tran vdout1_140ck860 FIND v(dout1_140) AT=870.05n

.meas tran vdout1_141ck860 FIND v(dout1_141) AT=870.05n

.meas tran vdout1_142ck860 FIND v(dout1_142) AT=870.05n

.meas tran vdout1_143ck860 FIND v(dout1_143) AT=870.05n

.meas tran vdout1_144ck860 FIND v(dout1_144) AT=870.05n

.meas tran vdout1_145ck860 FIND v(dout1_145) AT=870.05n

.meas tran vdout1_146ck860 FIND v(dout1_146) AT=870.05n

.meas tran vdout1_147ck860 FIND v(dout1_147) AT=870.05n

.meas tran vdout1_148ck860 FIND v(dout1_148) AT=870.05n

.meas tran vdout1_149ck860 FIND v(dout1_149) AT=870.05n

.meas tran vdout1_150ck860 FIND v(dout1_150) AT=870.05n

.meas tran vdout1_151ck860 FIND v(dout1_151) AT=870.05n

.meas tran vdout1_152ck860 FIND v(dout1_152) AT=870.05n

.meas tran vdout1_153ck860 FIND v(dout1_153) AT=870.05n

.meas tran vdout1_154ck860 FIND v(dout1_154) AT=870.05n

.meas tran vdout1_155ck860 FIND v(dout1_155) AT=870.05n

.meas tran vdout1_156ck860 FIND v(dout1_156) AT=870.05n

.meas tran vdout1_157ck860 FIND v(dout1_157) AT=870.05n

.meas tran vdout1_158ck860 FIND v(dout1_158) AT=870.05n

.meas tran vdout1_159ck860 FIND v(dout1_159) AT=870.05n

.meas tran vdout1_160ck860 FIND v(dout1_160) AT=870.05n

.meas tran vdout1_161ck860 FIND v(dout1_161) AT=870.05n

.meas tran vdout1_162ck860 FIND v(dout1_162) AT=870.05n

.meas tran vdout1_163ck860 FIND v(dout1_163) AT=870.05n

.meas tran vdout1_164ck860 FIND v(dout1_164) AT=870.05n

.meas tran vdout1_165ck860 FIND v(dout1_165) AT=870.05n

.meas tran vdout1_166ck860 FIND v(dout1_166) AT=870.05n

.meas tran vdout1_167ck860 FIND v(dout1_167) AT=870.05n

.meas tran vdout1_168ck860 FIND v(dout1_168) AT=870.05n

.meas tran vdout1_169ck860 FIND v(dout1_169) AT=870.05n

.meas tran vdout1_170ck860 FIND v(dout1_170) AT=870.05n

.meas tran vdout1_171ck860 FIND v(dout1_171) AT=870.05n

.meas tran vdout1_172ck860 FIND v(dout1_172) AT=870.05n

.meas tran vdout1_173ck860 FIND v(dout1_173) AT=870.05n

.meas tran vdout1_174ck860 FIND v(dout1_174) AT=870.05n

.meas tran vdout1_175ck860 FIND v(dout1_175) AT=870.05n

.meas tran vdout1_176ck860 FIND v(dout1_176) AT=870.05n

.meas tran vdout1_177ck860 FIND v(dout1_177) AT=870.05n

.meas tran vdout1_178ck860 FIND v(dout1_178) AT=870.05n

.meas tran vdout1_179ck860 FIND v(dout1_179) AT=870.05n

.meas tran vdout1_180ck860 FIND v(dout1_180) AT=870.05n

.meas tran vdout1_181ck860 FIND v(dout1_181) AT=870.05n

.meas tran vdout1_182ck860 FIND v(dout1_182) AT=870.05n

.meas tran vdout1_183ck860 FIND v(dout1_183) AT=870.05n

.meas tran vdout1_184ck860 FIND v(dout1_184) AT=870.05n

.meas tran vdout1_185ck860 FIND v(dout1_185) AT=870.05n

.meas tran vdout1_186ck860 FIND v(dout1_186) AT=870.05n

.meas tran vdout1_187ck860 FIND v(dout1_187) AT=870.05n

.meas tran vdout1_188ck860 FIND v(dout1_188) AT=870.05n

.meas tran vdout1_189ck860 FIND v(dout1_189) AT=870.05n

.meas tran vdout1_190ck860 FIND v(dout1_190) AT=870.05n

.meas tran vdout1_191ck860 FIND v(dout1_191) AT=870.05n

.meas tran vdout1_192ck860 FIND v(dout1_192) AT=870.05n

.meas tran vdout1_193ck860 FIND v(dout1_193) AT=870.05n

.meas tran vdout1_194ck860 FIND v(dout1_194) AT=870.05n

.meas tran vdout1_195ck860 FIND v(dout1_195) AT=870.05n

.meas tran vdout1_196ck860 FIND v(dout1_196) AT=870.05n

.meas tran vdout1_197ck860 FIND v(dout1_197) AT=870.05n

.meas tran vdout1_198ck860 FIND v(dout1_198) AT=870.05n

.meas tran vdout1_199ck860 FIND v(dout1_199) AT=870.05n

.meas tran vdout1_200ck860 FIND v(dout1_200) AT=870.05n

.meas tran vdout1_201ck860 FIND v(dout1_201) AT=870.05n

.meas tran vdout1_202ck860 FIND v(dout1_202) AT=870.05n

.meas tran vdout1_203ck860 FIND v(dout1_203) AT=870.05n

.meas tran vdout1_204ck860 FIND v(dout1_204) AT=870.05n

.meas tran vdout1_205ck860 FIND v(dout1_205) AT=870.05n

.meas tran vdout1_206ck860 FIND v(dout1_206) AT=870.05n

.meas tran vdout1_207ck860 FIND v(dout1_207) AT=870.05n

.meas tran vdout1_208ck860 FIND v(dout1_208) AT=870.05n

.meas tran vdout1_209ck860 FIND v(dout1_209) AT=870.05n

.meas tran vdout1_210ck860 FIND v(dout1_210) AT=870.05n

.meas tran vdout1_211ck860 FIND v(dout1_211) AT=870.05n

.meas tran vdout1_212ck860 FIND v(dout1_212) AT=870.05n

.meas tran vdout1_213ck860 FIND v(dout1_213) AT=870.05n

.meas tran vdout1_214ck860 FIND v(dout1_214) AT=870.05n

.meas tran vdout1_215ck860 FIND v(dout1_215) AT=870.05n

.meas tran vdout1_216ck860 FIND v(dout1_216) AT=870.05n

.meas tran vdout1_217ck860 FIND v(dout1_217) AT=870.05n

.meas tran vdout1_218ck860 FIND v(dout1_218) AT=870.05n

.meas tran vdout1_219ck860 FIND v(dout1_219) AT=870.05n

.meas tran vdout1_220ck860 FIND v(dout1_220) AT=870.05n

.meas tran vdout1_221ck860 FIND v(dout1_221) AT=870.05n

.meas tran vdout1_222ck860 FIND v(dout1_222) AT=870.05n

.meas tran vdout1_223ck860 FIND v(dout1_223) AT=870.05n

.meas tran vdout1_224ck860 FIND v(dout1_224) AT=870.05n

.meas tran vdout1_225ck860 FIND v(dout1_225) AT=870.05n

.meas tran vdout1_226ck860 FIND v(dout1_226) AT=870.05n

.meas tran vdout1_227ck860 FIND v(dout1_227) AT=870.05n

.meas tran vdout1_228ck860 FIND v(dout1_228) AT=870.05n

.meas tran vdout1_229ck860 FIND v(dout1_229) AT=870.05n

.meas tran vdout1_230ck860 FIND v(dout1_230) AT=870.05n

.meas tran vdout1_231ck860 FIND v(dout1_231) AT=870.05n

.meas tran vdout1_232ck860 FIND v(dout1_232) AT=870.05n

.meas tran vdout1_233ck860 FIND v(dout1_233) AT=870.05n

.meas tran vdout1_234ck860 FIND v(dout1_234) AT=870.05n

.meas tran vdout1_235ck860 FIND v(dout1_235) AT=870.05n

.meas tran vdout1_236ck860 FIND v(dout1_236) AT=870.05n

.meas tran vdout1_237ck860 FIND v(dout1_237) AT=870.05n

.meas tran vdout1_238ck860 FIND v(dout1_238) AT=870.05n

.meas tran vdout1_239ck860 FIND v(dout1_239) AT=870.05n

.meas tran vdout1_240ck860 FIND v(dout1_240) AT=870.05n

.meas tran vdout1_241ck860 FIND v(dout1_241) AT=870.05n

.meas tran vdout1_242ck860 FIND v(dout1_242) AT=870.05n

.meas tran vdout1_243ck860 FIND v(dout1_243) AT=870.05n

.meas tran vdout1_244ck860 FIND v(dout1_244) AT=870.05n

.meas tran vdout1_245ck860 FIND v(dout1_245) AT=870.05n

.meas tran vdout1_246ck860 FIND v(dout1_246) AT=870.05n

.meas tran vdout1_247ck860 FIND v(dout1_247) AT=870.05n

.meas tran vdout1_248ck860 FIND v(dout1_248) AT=870.05n

.meas tran vdout1_249ck860 FIND v(dout1_249) AT=870.05n

.meas tran vdout1_250ck860 FIND v(dout1_250) AT=870.05n

.meas tran vdout1_251ck860 FIND v(dout1_251) AT=870.05n

.meas tran vdout1_252ck860 FIND v(dout1_252) AT=870.05n

.meas tran vdout1_253ck860 FIND v(dout1_253) AT=870.05n

.meas tran vdout1_254ck860 FIND v(dout1_254) AT=870.05n

.meas tran vdout1_255ck860 FIND v(dout1_255) AT=870.05n

.meas tran vdout1_256ck860 FIND v(dout1_256) AT=870.05n

.meas tran vdout1_0ck900 FIND v(dout1_0) AT=910.05n

.meas tran vdout1_1ck900 FIND v(dout1_1) AT=910.05n

.meas tran vdout1_2ck900 FIND v(dout1_2) AT=910.05n

.meas tran vdout1_3ck900 FIND v(dout1_3) AT=910.05n

.meas tran vdout1_4ck900 FIND v(dout1_4) AT=910.05n

.meas tran vdout1_5ck900 FIND v(dout1_5) AT=910.05n

.meas tran vdout1_6ck900 FIND v(dout1_6) AT=910.05n

.meas tran vdout1_7ck900 FIND v(dout1_7) AT=910.05n

.meas tran vdout1_8ck900 FIND v(dout1_8) AT=910.05n

.meas tran vdout1_9ck900 FIND v(dout1_9) AT=910.05n

.meas tran vdout1_10ck900 FIND v(dout1_10) AT=910.05n

.meas tran vdout1_11ck900 FIND v(dout1_11) AT=910.05n

.meas tran vdout1_12ck900 FIND v(dout1_12) AT=910.05n

.meas tran vdout1_13ck900 FIND v(dout1_13) AT=910.05n

.meas tran vdout1_14ck900 FIND v(dout1_14) AT=910.05n

.meas tran vdout1_15ck900 FIND v(dout1_15) AT=910.05n

.meas tran vdout1_16ck900 FIND v(dout1_16) AT=910.05n

.meas tran vdout1_17ck900 FIND v(dout1_17) AT=910.05n

.meas tran vdout1_18ck900 FIND v(dout1_18) AT=910.05n

.meas tran vdout1_19ck900 FIND v(dout1_19) AT=910.05n

.meas tran vdout1_20ck900 FIND v(dout1_20) AT=910.05n

.meas tran vdout1_21ck900 FIND v(dout1_21) AT=910.05n

.meas tran vdout1_22ck900 FIND v(dout1_22) AT=910.05n

.meas tran vdout1_23ck900 FIND v(dout1_23) AT=910.05n

.meas tran vdout1_24ck900 FIND v(dout1_24) AT=910.05n

.meas tran vdout1_25ck900 FIND v(dout1_25) AT=910.05n

.meas tran vdout1_26ck900 FIND v(dout1_26) AT=910.05n

.meas tran vdout1_27ck900 FIND v(dout1_27) AT=910.05n

.meas tran vdout1_28ck900 FIND v(dout1_28) AT=910.05n

.meas tran vdout1_29ck900 FIND v(dout1_29) AT=910.05n

.meas tran vdout1_30ck900 FIND v(dout1_30) AT=910.05n

.meas tran vdout1_31ck900 FIND v(dout1_31) AT=910.05n

.meas tran vdout1_32ck900 FIND v(dout1_32) AT=910.05n

.meas tran vdout1_33ck900 FIND v(dout1_33) AT=910.05n

.meas tran vdout1_34ck900 FIND v(dout1_34) AT=910.05n

.meas tran vdout1_35ck900 FIND v(dout1_35) AT=910.05n

.meas tran vdout1_36ck900 FIND v(dout1_36) AT=910.05n

.meas tran vdout1_37ck900 FIND v(dout1_37) AT=910.05n

.meas tran vdout1_38ck900 FIND v(dout1_38) AT=910.05n

.meas tran vdout1_39ck900 FIND v(dout1_39) AT=910.05n

.meas tran vdout1_40ck900 FIND v(dout1_40) AT=910.05n

.meas tran vdout1_41ck900 FIND v(dout1_41) AT=910.05n

.meas tran vdout1_42ck900 FIND v(dout1_42) AT=910.05n

.meas tran vdout1_43ck900 FIND v(dout1_43) AT=910.05n

.meas tran vdout1_44ck900 FIND v(dout1_44) AT=910.05n

.meas tran vdout1_45ck900 FIND v(dout1_45) AT=910.05n

.meas tran vdout1_46ck900 FIND v(dout1_46) AT=910.05n

.meas tran vdout1_47ck900 FIND v(dout1_47) AT=910.05n

.meas tran vdout1_48ck900 FIND v(dout1_48) AT=910.05n

.meas tran vdout1_49ck900 FIND v(dout1_49) AT=910.05n

.meas tran vdout1_50ck900 FIND v(dout1_50) AT=910.05n

.meas tran vdout1_51ck900 FIND v(dout1_51) AT=910.05n

.meas tran vdout1_52ck900 FIND v(dout1_52) AT=910.05n

.meas tran vdout1_53ck900 FIND v(dout1_53) AT=910.05n

.meas tran vdout1_54ck900 FIND v(dout1_54) AT=910.05n

.meas tran vdout1_55ck900 FIND v(dout1_55) AT=910.05n

.meas tran vdout1_56ck900 FIND v(dout1_56) AT=910.05n

.meas tran vdout1_57ck900 FIND v(dout1_57) AT=910.05n

.meas tran vdout1_58ck900 FIND v(dout1_58) AT=910.05n

.meas tran vdout1_59ck900 FIND v(dout1_59) AT=910.05n

.meas tran vdout1_60ck900 FIND v(dout1_60) AT=910.05n

.meas tran vdout1_61ck900 FIND v(dout1_61) AT=910.05n

.meas tran vdout1_62ck900 FIND v(dout1_62) AT=910.05n

.meas tran vdout1_63ck900 FIND v(dout1_63) AT=910.05n

.meas tran vdout1_64ck900 FIND v(dout1_64) AT=910.05n

.meas tran vdout1_65ck900 FIND v(dout1_65) AT=910.05n

.meas tran vdout1_66ck900 FIND v(dout1_66) AT=910.05n

.meas tran vdout1_67ck900 FIND v(dout1_67) AT=910.05n

.meas tran vdout1_68ck900 FIND v(dout1_68) AT=910.05n

.meas tran vdout1_69ck900 FIND v(dout1_69) AT=910.05n

.meas tran vdout1_70ck900 FIND v(dout1_70) AT=910.05n

.meas tran vdout1_71ck900 FIND v(dout1_71) AT=910.05n

.meas tran vdout1_72ck900 FIND v(dout1_72) AT=910.05n

.meas tran vdout1_73ck900 FIND v(dout1_73) AT=910.05n

.meas tran vdout1_74ck900 FIND v(dout1_74) AT=910.05n

.meas tran vdout1_75ck900 FIND v(dout1_75) AT=910.05n

.meas tran vdout1_76ck900 FIND v(dout1_76) AT=910.05n

.meas tran vdout1_77ck900 FIND v(dout1_77) AT=910.05n

.meas tran vdout1_78ck900 FIND v(dout1_78) AT=910.05n

.meas tran vdout1_79ck900 FIND v(dout1_79) AT=910.05n

.meas tran vdout1_80ck900 FIND v(dout1_80) AT=910.05n

.meas tran vdout1_81ck900 FIND v(dout1_81) AT=910.05n

.meas tran vdout1_82ck900 FIND v(dout1_82) AT=910.05n

.meas tran vdout1_83ck900 FIND v(dout1_83) AT=910.05n

.meas tran vdout1_84ck900 FIND v(dout1_84) AT=910.05n

.meas tran vdout1_85ck900 FIND v(dout1_85) AT=910.05n

.meas tran vdout1_86ck900 FIND v(dout1_86) AT=910.05n

.meas tran vdout1_87ck900 FIND v(dout1_87) AT=910.05n

.meas tran vdout1_88ck900 FIND v(dout1_88) AT=910.05n

.meas tran vdout1_89ck900 FIND v(dout1_89) AT=910.05n

.meas tran vdout1_90ck900 FIND v(dout1_90) AT=910.05n

.meas tran vdout1_91ck900 FIND v(dout1_91) AT=910.05n

.meas tran vdout1_92ck900 FIND v(dout1_92) AT=910.05n

.meas tran vdout1_93ck900 FIND v(dout1_93) AT=910.05n

.meas tran vdout1_94ck900 FIND v(dout1_94) AT=910.05n

.meas tran vdout1_95ck900 FIND v(dout1_95) AT=910.05n

.meas tran vdout1_96ck900 FIND v(dout1_96) AT=910.05n

.meas tran vdout1_97ck900 FIND v(dout1_97) AT=910.05n

.meas tran vdout1_98ck900 FIND v(dout1_98) AT=910.05n

.meas tran vdout1_99ck900 FIND v(dout1_99) AT=910.05n

.meas tran vdout1_100ck900 FIND v(dout1_100) AT=910.05n

.meas tran vdout1_101ck900 FIND v(dout1_101) AT=910.05n

.meas tran vdout1_102ck900 FIND v(dout1_102) AT=910.05n

.meas tran vdout1_103ck900 FIND v(dout1_103) AT=910.05n

.meas tran vdout1_104ck900 FIND v(dout1_104) AT=910.05n

.meas tran vdout1_105ck900 FIND v(dout1_105) AT=910.05n

.meas tran vdout1_106ck900 FIND v(dout1_106) AT=910.05n

.meas tran vdout1_107ck900 FIND v(dout1_107) AT=910.05n

.meas tran vdout1_108ck900 FIND v(dout1_108) AT=910.05n

.meas tran vdout1_109ck900 FIND v(dout1_109) AT=910.05n

.meas tran vdout1_110ck900 FIND v(dout1_110) AT=910.05n

.meas tran vdout1_111ck900 FIND v(dout1_111) AT=910.05n

.meas tran vdout1_112ck900 FIND v(dout1_112) AT=910.05n

.meas tran vdout1_113ck900 FIND v(dout1_113) AT=910.05n

.meas tran vdout1_114ck900 FIND v(dout1_114) AT=910.05n

.meas tran vdout1_115ck900 FIND v(dout1_115) AT=910.05n

.meas tran vdout1_116ck900 FIND v(dout1_116) AT=910.05n

.meas tran vdout1_117ck900 FIND v(dout1_117) AT=910.05n

.meas tran vdout1_118ck900 FIND v(dout1_118) AT=910.05n

.meas tran vdout1_119ck900 FIND v(dout1_119) AT=910.05n

.meas tran vdout1_120ck900 FIND v(dout1_120) AT=910.05n

.meas tran vdout1_121ck900 FIND v(dout1_121) AT=910.05n

.meas tran vdout1_122ck900 FIND v(dout1_122) AT=910.05n

.meas tran vdout1_123ck900 FIND v(dout1_123) AT=910.05n

.meas tran vdout1_124ck900 FIND v(dout1_124) AT=910.05n

.meas tran vdout1_125ck900 FIND v(dout1_125) AT=910.05n

.meas tran vdout1_126ck900 FIND v(dout1_126) AT=910.05n

.meas tran vdout1_127ck900 FIND v(dout1_127) AT=910.05n

.meas tran vdout1_128ck900 FIND v(dout1_128) AT=910.05n

.meas tran vdout1_129ck900 FIND v(dout1_129) AT=910.05n

.meas tran vdout1_130ck900 FIND v(dout1_130) AT=910.05n

.meas tran vdout1_131ck900 FIND v(dout1_131) AT=910.05n

.meas tran vdout1_132ck900 FIND v(dout1_132) AT=910.05n

.meas tran vdout1_133ck900 FIND v(dout1_133) AT=910.05n

.meas tran vdout1_134ck900 FIND v(dout1_134) AT=910.05n

.meas tran vdout1_135ck900 FIND v(dout1_135) AT=910.05n

.meas tran vdout1_136ck900 FIND v(dout1_136) AT=910.05n

.meas tran vdout1_137ck900 FIND v(dout1_137) AT=910.05n

.meas tran vdout1_138ck900 FIND v(dout1_138) AT=910.05n

.meas tran vdout1_139ck900 FIND v(dout1_139) AT=910.05n

.meas tran vdout1_140ck900 FIND v(dout1_140) AT=910.05n

.meas tran vdout1_141ck900 FIND v(dout1_141) AT=910.05n

.meas tran vdout1_142ck900 FIND v(dout1_142) AT=910.05n

.meas tran vdout1_143ck900 FIND v(dout1_143) AT=910.05n

.meas tran vdout1_144ck900 FIND v(dout1_144) AT=910.05n

.meas tran vdout1_145ck900 FIND v(dout1_145) AT=910.05n

.meas tran vdout1_146ck900 FIND v(dout1_146) AT=910.05n

.meas tran vdout1_147ck900 FIND v(dout1_147) AT=910.05n

.meas tran vdout1_148ck900 FIND v(dout1_148) AT=910.05n

.meas tran vdout1_149ck900 FIND v(dout1_149) AT=910.05n

.meas tran vdout1_150ck900 FIND v(dout1_150) AT=910.05n

.meas tran vdout1_151ck900 FIND v(dout1_151) AT=910.05n

.meas tran vdout1_152ck900 FIND v(dout1_152) AT=910.05n

.meas tran vdout1_153ck900 FIND v(dout1_153) AT=910.05n

.meas tran vdout1_154ck900 FIND v(dout1_154) AT=910.05n

.meas tran vdout1_155ck900 FIND v(dout1_155) AT=910.05n

.meas tran vdout1_156ck900 FIND v(dout1_156) AT=910.05n

.meas tran vdout1_157ck900 FIND v(dout1_157) AT=910.05n

.meas tran vdout1_158ck900 FIND v(dout1_158) AT=910.05n

.meas tran vdout1_159ck900 FIND v(dout1_159) AT=910.05n

.meas tran vdout1_160ck900 FIND v(dout1_160) AT=910.05n

.meas tran vdout1_161ck900 FIND v(dout1_161) AT=910.05n

.meas tran vdout1_162ck900 FIND v(dout1_162) AT=910.05n

.meas tran vdout1_163ck900 FIND v(dout1_163) AT=910.05n

.meas tran vdout1_164ck900 FIND v(dout1_164) AT=910.05n

.meas tran vdout1_165ck900 FIND v(dout1_165) AT=910.05n

.meas tran vdout1_166ck900 FIND v(dout1_166) AT=910.05n

.meas tran vdout1_167ck900 FIND v(dout1_167) AT=910.05n

.meas tran vdout1_168ck900 FIND v(dout1_168) AT=910.05n

.meas tran vdout1_169ck900 FIND v(dout1_169) AT=910.05n

.meas tran vdout1_170ck900 FIND v(dout1_170) AT=910.05n

.meas tran vdout1_171ck900 FIND v(dout1_171) AT=910.05n

.meas tran vdout1_172ck900 FIND v(dout1_172) AT=910.05n

.meas tran vdout1_173ck900 FIND v(dout1_173) AT=910.05n

.meas tran vdout1_174ck900 FIND v(dout1_174) AT=910.05n

.meas tran vdout1_175ck900 FIND v(dout1_175) AT=910.05n

.meas tran vdout1_176ck900 FIND v(dout1_176) AT=910.05n

.meas tran vdout1_177ck900 FIND v(dout1_177) AT=910.05n

.meas tran vdout1_178ck900 FIND v(dout1_178) AT=910.05n

.meas tran vdout1_179ck900 FIND v(dout1_179) AT=910.05n

.meas tran vdout1_180ck900 FIND v(dout1_180) AT=910.05n

.meas tran vdout1_181ck900 FIND v(dout1_181) AT=910.05n

.meas tran vdout1_182ck900 FIND v(dout1_182) AT=910.05n

.meas tran vdout1_183ck900 FIND v(dout1_183) AT=910.05n

.meas tran vdout1_184ck900 FIND v(dout1_184) AT=910.05n

.meas tran vdout1_185ck900 FIND v(dout1_185) AT=910.05n

.meas tran vdout1_186ck900 FIND v(dout1_186) AT=910.05n

.meas tran vdout1_187ck900 FIND v(dout1_187) AT=910.05n

.meas tran vdout1_188ck900 FIND v(dout1_188) AT=910.05n

.meas tran vdout1_189ck900 FIND v(dout1_189) AT=910.05n

.meas tran vdout1_190ck900 FIND v(dout1_190) AT=910.05n

.meas tran vdout1_191ck900 FIND v(dout1_191) AT=910.05n

.meas tran vdout1_192ck900 FIND v(dout1_192) AT=910.05n

.meas tran vdout1_193ck900 FIND v(dout1_193) AT=910.05n

.meas tran vdout1_194ck900 FIND v(dout1_194) AT=910.05n

.meas tran vdout1_195ck900 FIND v(dout1_195) AT=910.05n

.meas tran vdout1_196ck900 FIND v(dout1_196) AT=910.05n

.meas tran vdout1_197ck900 FIND v(dout1_197) AT=910.05n

.meas tran vdout1_198ck900 FIND v(dout1_198) AT=910.05n

.meas tran vdout1_199ck900 FIND v(dout1_199) AT=910.05n

.meas tran vdout1_200ck900 FIND v(dout1_200) AT=910.05n

.meas tran vdout1_201ck900 FIND v(dout1_201) AT=910.05n

.meas tran vdout1_202ck900 FIND v(dout1_202) AT=910.05n

.meas tran vdout1_203ck900 FIND v(dout1_203) AT=910.05n

.meas tran vdout1_204ck900 FIND v(dout1_204) AT=910.05n

.meas tran vdout1_205ck900 FIND v(dout1_205) AT=910.05n

.meas tran vdout1_206ck900 FIND v(dout1_206) AT=910.05n

.meas tran vdout1_207ck900 FIND v(dout1_207) AT=910.05n

.meas tran vdout1_208ck900 FIND v(dout1_208) AT=910.05n

.meas tran vdout1_209ck900 FIND v(dout1_209) AT=910.05n

.meas tran vdout1_210ck900 FIND v(dout1_210) AT=910.05n

.meas tran vdout1_211ck900 FIND v(dout1_211) AT=910.05n

.meas tran vdout1_212ck900 FIND v(dout1_212) AT=910.05n

.meas tran vdout1_213ck900 FIND v(dout1_213) AT=910.05n

.meas tran vdout1_214ck900 FIND v(dout1_214) AT=910.05n

.meas tran vdout1_215ck900 FIND v(dout1_215) AT=910.05n

.meas tran vdout1_216ck900 FIND v(dout1_216) AT=910.05n

.meas tran vdout1_217ck900 FIND v(dout1_217) AT=910.05n

.meas tran vdout1_218ck900 FIND v(dout1_218) AT=910.05n

.meas tran vdout1_219ck900 FIND v(dout1_219) AT=910.05n

.meas tran vdout1_220ck900 FIND v(dout1_220) AT=910.05n

.meas tran vdout1_221ck900 FIND v(dout1_221) AT=910.05n

.meas tran vdout1_222ck900 FIND v(dout1_222) AT=910.05n

.meas tran vdout1_223ck900 FIND v(dout1_223) AT=910.05n

.meas tran vdout1_224ck900 FIND v(dout1_224) AT=910.05n

.meas tran vdout1_225ck900 FIND v(dout1_225) AT=910.05n

.meas tran vdout1_226ck900 FIND v(dout1_226) AT=910.05n

.meas tran vdout1_227ck900 FIND v(dout1_227) AT=910.05n

.meas tran vdout1_228ck900 FIND v(dout1_228) AT=910.05n

.meas tran vdout1_229ck900 FIND v(dout1_229) AT=910.05n

.meas tran vdout1_230ck900 FIND v(dout1_230) AT=910.05n

.meas tran vdout1_231ck900 FIND v(dout1_231) AT=910.05n

.meas tran vdout1_232ck900 FIND v(dout1_232) AT=910.05n

.meas tran vdout1_233ck900 FIND v(dout1_233) AT=910.05n

.meas tran vdout1_234ck900 FIND v(dout1_234) AT=910.05n

.meas tran vdout1_235ck900 FIND v(dout1_235) AT=910.05n

.meas tran vdout1_236ck900 FIND v(dout1_236) AT=910.05n

.meas tran vdout1_237ck900 FIND v(dout1_237) AT=910.05n

.meas tran vdout1_238ck900 FIND v(dout1_238) AT=910.05n

.meas tran vdout1_239ck900 FIND v(dout1_239) AT=910.05n

.meas tran vdout1_240ck900 FIND v(dout1_240) AT=910.05n

.meas tran vdout1_241ck900 FIND v(dout1_241) AT=910.05n

.meas tran vdout1_242ck900 FIND v(dout1_242) AT=910.05n

.meas tran vdout1_243ck900 FIND v(dout1_243) AT=910.05n

.meas tran vdout1_244ck900 FIND v(dout1_244) AT=910.05n

.meas tran vdout1_245ck900 FIND v(dout1_245) AT=910.05n

.meas tran vdout1_246ck900 FIND v(dout1_246) AT=910.05n

.meas tran vdout1_247ck900 FIND v(dout1_247) AT=910.05n

.meas tran vdout1_248ck900 FIND v(dout1_248) AT=910.05n

.meas tran vdout1_249ck900 FIND v(dout1_249) AT=910.05n

.meas tran vdout1_250ck900 FIND v(dout1_250) AT=910.05n

.meas tran vdout1_251ck900 FIND v(dout1_251) AT=910.05n

.meas tran vdout1_252ck900 FIND v(dout1_252) AT=910.05n

.meas tran vdout1_253ck900 FIND v(dout1_253) AT=910.05n

.meas tran vdout1_254ck900 FIND v(dout1_254) AT=910.05n

.meas tran vdout1_255ck900 FIND v(dout1_255) AT=910.05n

.meas tran vdout1_256ck900 FIND v(dout1_256) AT=910.05n

.meas tran vdout1_0ck910 FIND v(dout1_0) AT=920.05n

.meas tran vdout1_1ck910 FIND v(dout1_1) AT=920.05n

.meas tran vdout1_2ck910 FIND v(dout1_2) AT=920.05n

.meas tran vdout1_3ck910 FIND v(dout1_3) AT=920.05n

.meas tran vdout1_4ck910 FIND v(dout1_4) AT=920.05n

.meas tran vdout1_5ck910 FIND v(dout1_5) AT=920.05n

.meas tran vdout1_6ck910 FIND v(dout1_6) AT=920.05n

.meas tran vdout1_7ck910 FIND v(dout1_7) AT=920.05n

.meas tran vdout1_8ck910 FIND v(dout1_8) AT=920.05n

.meas tran vdout1_9ck910 FIND v(dout1_9) AT=920.05n

.meas tran vdout1_10ck910 FIND v(dout1_10) AT=920.05n

.meas tran vdout1_11ck910 FIND v(dout1_11) AT=920.05n

.meas tran vdout1_12ck910 FIND v(dout1_12) AT=920.05n

.meas tran vdout1_13ck910 FIND v(dout1_13) AT=920.05n

.meas tran vdout1_14ck910 FIND v(dout1_14) AT=920.05n

.meas tran vdout1_15ck910 FIND v(dout1_15) AT=920.05n

.meas tran vdout1_16ck910 FIND v(dout1_16) AT=920.05n

.meas tran vdout1_17ck910 FIND v(dout1_17) AT=920.05n

.meas tran vdout1_18ck910 FIND v(dout1_18) AT=920.05n

.meas tran vdout1_19ck910 FIND v(dout1_19) AT=920.05n

.meas tran vdout1_20ck910 FIND v(dout1_20) AT=920.05n

.meas tran vdout1_21ck910 FIND v(dout1_21) AT=920.05n

.meas tran vdout1_22ck910 FIND v(dout1_22) AT=920.05n

.meas tran vdout1_23ck910 FIND v(dout1_23) AT=920.05n

.meas tran vdout1_24ck910 FIND v(dout1_24) AT=920.05n

.meas tran vdout1_25ck910 FIND v(dout1_25) AT=920.05n

.meas tran vdout1_26ck910 FIND v(dout1_26) AT=920.05n

.meas tran vdout1_27ck910 FIND v(dout1_27) AT=920.05n

.meas tran vdout1_28ck910 FIND v(dout1_28) AT=920.05n

.meas tran vdout1_29ck910 FIND v(dout1_29) AT=920.05n

.meas tran vdout1_30ck910 FIND v(dout1_30) AT=920.05n

.meas tran vdout1_31ck910 FIND v(dout1_31) AT=920.05n

.meas tran vdout1_32ck910 FIND v(dout1_32) AT=920.05n

.meas tran vdout1_33ck910 FIND v(dout1_33) AT=920.05n

.meas tran vdout1_34ck910 FIND v(dout1_34) AT=920.05n

.meas tran vdout1_35ck910 FIND v(dout1_35) AT=920.05n

.meas tran vdout1_36ck910 FIND v(dout1_36) AT=920.05n

.meas tran vdout1_37ck910 FIND v(dout1_37) AT=920.05n

.meas tran vdout1_38ck910 FIND v(dout1_38) AT=920.05n

.meas tran vdout1_39ck910 FIND v(dout1_39) AT=920.05n

.meas tran vdout1_40ck910 FIND v(dout1_40) AT=920.05n

.meas tran vdout1_41ck910 FIND v(dout1_41) AT=920.05n

.meas tran vdout1_42ck910 FIND v(dout1_42) AT=920.05n

.meas tran vdout1_43ck910 FIND v(dout1_43) AT=920.05n

.meas tran vdout1_44ck910 FIND v(dout1_44) AT=920.05n

.meas tran vdout1_45ck910 FIND v(dout1_45) AT=920.05n

.meas tran vdout1_46ck910 FIND v(dout1_46) AT=920.05n

.meas tran vdout1_47ck910 FIND v(dout1_47) AT=920.05n

.meas tran vdout1_48ck910 FIND v(dout1_48) AT=920.05n

.meas tran vdout1_49ck910 FIND v(dout1_49) AT=920.05n

.meas tran vdout1_50ck910 FIND v(dout1_50) AT=920.05n

.meas tran vdout1_51ck910 FIND v(dout1_51) AT=920.05n

.meas tran vdout1_52ck910 FIND v(dout1_52) AT=920.05n

.meas tran vdout1_53ck910 FIND v(dout1_53) AT=920.05n

.meas tran vdout1_54ck910 FIND v(dout1_54) AT=920.05n

.meas tran vdout1_55ck910 FIND v(dout1_55) AT=920.05n

.meas tran vdout1_56ck910 FIND v(dout1_56) AT=920.05n

.meas tran vdout1_57ck910 FIND v(dout1_57) AT=920.05n

.meas tran vdout1_58ck910 FIND v(dout1_58) AT=920.05n

.meas tran vdout1_59ck910 FIND v(dout1_59) AT=920.05n

.meas tran vdout1_60ck910 FIND v(dout1_60) AT=920.05n

.meas tran vdout1_61ck910 FIND v(dout1_61) AT=920.05n

.meas tran vdout1_62ck910 FIND v(dout1_62) AT=920.05n

.meas tran vdout1_63ck910 FIND v(dout1_63) AT=920.05n

.meas tran vdout1_64ck910 FIND v(dout1_64) AT=920.05n

.meas tran vdout1_65ck910 FIND v(dout1_65) AT=920.05n

.meas tran vdout1_66ck910 FIND v(dout1_66) AT=920.05n

.meas tran vdout1_67ck910 FIND v(dout1_67) AT=920.05n

.meas tran vdout1_68ck910 FIND v(dout1_68) AT=920.05n

.meas tran vdout1_69ck910 FIND v(dout1_69) AT=920.05n

.meas tran vdout1_70ck910 FIND v(dout1_70) AT=920.05n

.meas tran vdout1_71ck910 FIND v(dout1_71) AT=920.05n

.meas tran vdout1_72ck910 FIND v(dout1_72) AT=920.05n

.meas tran vdout1_73ck910 FIND v(dout1_73) AT=920.05n

.meas tran vdout1_74ck910 FIND v(dout1_74) AT=920.05n

.meas tran vdout1_75ck910 FIND v(dout1_75) AT=920.05n

.meas tran vdout1_76ck910 FIND v(dout1_76) AT=920.05n

.meas tran vdout1_77ck910 FIND v(dout1_77) AT=920.05n

.meas tran vdout1_78ck910 FIND v(dout1_78) AT=920.05n

.meas tran vdout1_79ck910 FIND v(dout1_79) AT=920.05n

.meas tran vdout1_80ck910 FIND v(dout1_80) AT=920.05n

.meas tran vdout1_81ck910 FIND v(dout1_81) AT=920.05n

.meas tran vdout1_82ck910 FIND v(dout1_82) AT=920.05n

.meas tran vdout1_83ck910 FIND v(dout1_83) AT=920.05n

.meas tran vdout1_84ck910 FIND v(dout1_84) AT=920.05n

.meas tran vdout1_85ck910 FIND v(dout1_85) AT=920.05n

.meas tran vdout1_86ck910 FIND v(dout1_86) AT=920.05n

.meas tran vdout1_87ck910 FIND v(dout1_87) AT=920.05n

.meas tran vdout1_88ck910 FIND v(dout1_88) AT=920.05n

.meas tran vdout1_89ck910 FIND v(dout1_89) AT=920.05n

.meas tran vdout1_90ck910 FIND v(dout1_90) AT=920.05n

.meas tran vdout1_91ck910 FIND v(dout1_91) AT=920.05n

.meas tran vdout1_92ck910 FIND v(dout1_92) AT=920.05n

.meas tran vdout1_93ck910 FIND v(dout1_93) AT=920.05n

.meas tran vdout1_94ck910 FIND v(dout1_94) AT=920.05n

.meas tran vdout1_95ck910 FIND v(dout1_95) AT=920.05n

.meas tran vdout1_96ck910 FIND v(dout1_96) AT=920.05n

.meas tran vdout1_97ck910 FIND v(dout1_97) AT=920.05n

.meas tran vdout1_98ck910 FIND v(dout1_98) AT=920.05n

.meas tran vdout1_99ck910 FIND v(dout1_99) AT=920.05n

.meas tran vdout1_100ck910 FIND v(dout1_100) AT=920.05n

.meas tran vdout1_101ck910 FIND v(dout1_101) AT=920.05n

.meas tran vdout1_102ck910 FIND v(dout1_102) AT=920.05n

.meas tran vdout1_103ck910 FIND v(dout1_103) AT=920.05n

.meas tran vdout1_104ck910 FIND v(dout1_104) AT=920.05n

.meas tran vdout1_105ck910 FIND v(dout1_105) AT=920.05n

.meas tran vdout1_106ck910 FIND v(dout1_106) AT=920.05n

.meas tran vdout1_107ck910 FIND v(dout1_107) AT=920.05n

.meas tran vdout1_108ck910 FIND v(dout1_108) AT=920.05n

.meas tran vdout1_109ck910 FIND v(dout1_109) AT=920.05n

.meas tran vdout1_110ck910 FIND v(dout1_110) AT=920.05n

.meas tran vdout1_111ck910 FIND v(dout1_111) AT=920.05n

.meas tran vdout1_112ck910 FIND v(dout1_112) AT=920.05n

.meas tran vdout1_113ck910 FIND v(dout1_113) AT=920.05n

.meas tran vdout1_114ck910 FIND v(dout1_114) AT=920.05n

.meas tran vdout1_115ck910 FIND v(dout1_115) AT=920.05n

.meas tran vdout1_116ck910 FIND v(dout1_116) AT=920.05n

.meas tran vdout1_117ck910 FIND v(dout1_117) AT=920.05n

.meas tran vdout1_118ck910 FIND v(dout1_118) AT=920.05n

.meas tran vdout1_119ck910 FIND v(dout1_119) AT=920.05n

.meas tran vdout1_120ck910 FIND v(dout1_120) AT=920.05n

.meas tran vdout1_121ck910 FIND v(dout1_121) AT=920.05n

.meas tran vdout1_122ck910 FIND v(dout1_122) AT=920.05n

.meas tran vdout1_123ck910 FIND v(dout1_123) AT=920.05n

.meas tran vdout1_124ck910 FIND v(dout1_124) AT=920.05n

.meas tran vdout1_125ck910 FIND v(dout1_125) AT=920.05n

.meas tran vdout1_126ck910 FIND v(dout1_126) AT=920.05n

.meas tran vdout1_127ck910 FIND v(dout1_127) AT=920.05n

.meas tran vdout1_128ck910 FIND v(dout1_128) AT=920.05n

.meas tran vdout1_129ck910 FIND v(dout1_129) AT=920.05n

.meas tran vdout1_130ck910 FIND v(dout1_130) AT=920.05n

.meas tran vdout1_131ck910 FIND v(dout1_131) AT=920.05n

.meas tran vdout1_132ck910 FIND v(dout1_132) AT=920.05n

.meas tran vdout1_133ck910 FIND v(dout1_133) AT=920.05n

.meas tran vdout1_134ck910 FIND v(dout1_134) AT=920.05n

.meas tran vdout1_135ck910 FIND v(dout1_135) AT=920.05n

.meas tran vdout1_136ck910 FIND v(dout1_136) AT=920.05n

.meas tran vdout1_137ck910 FIND v(dout1_137) AT=920.05n

.meas tran vdout1_138ck910 FIND v(dout1_138) AT=920.05n

.meas tran vdout1_139ck910 FIND v(dout1_139) AT=920.05n

.meas tran vdout1_140ck910 FIND v(dout1_140) AT=920.05n

.meas tran vdout1_141ck910 FIND v(dout1_141) AT=920.05n

.meas tran vdout1_142ck910 FIND v(dout1_142) AT=920.05n

.meas tran vdout1_143ck910 FIND v(dout1_143) AT=920.05n

.meas tran vdout1_144ck910 FIND v(dout1_144) AT=920.05n

.meas tran vdout1_145ck910 FIND v(dout1_145) AT=920.05n

.meas tran vdout1_146ck910 FIND v(dout1_146) AT=920.05n

.meas tran vdout1_147ck910 FIND v(dout1_147) AT=920.05n

.meas tran vdout1_148ck910 FIND v(dout1_148) AT=920.05n

.meas tran vdout1_149ck910 FIND v(dout1_149) AT=920.05n

.meas tran vdout1_150ck910 FIND v(dout1_150) AT=920.05n

.meas tran vdout1_151ck910 FIND v(dout1_151) AT=920.05n

.meas tran vdout1_152ck910 FIND v(dout1_152) AT=920.05n

.meas tran vdout1_153ck910 FIND v(dout1_153) AT=920.05n

.meas tran vdout1_154ck910 FIND v(dout1_154) AT=920.05n

.meas tran vdout1_155ck910 FIND v(dout1_155) AT=920.05n

.meas tran vdout1_156ck910 FIND v(dout1_156) AT=920.05n

.meas tran vdout1_157ck910 FIND v(dout1_157) AT=920.05n

.meas tran vdout1_158ck910 FIND v(dout1_158) AT=920.05n

.meas tran vdout1_159ck910 FIND v(dout1_159) AT=920.05n

.meas tran vdout1_160ck910 FIND v(dout1_160) AT=920.05n

.meas tran vdout1_161ck910 FIND v(dout1_161) AT=920.05n

.meas tran vdout1_162ck910 FIND v(dout1_162) AT=920.05n

.meas tran vdout1_163ck910 FIND v(dout1_163) AT=920.05n

.meas tran vdout1_164ck910 FIND v(dout1_164) AT=920.05n

.meas tran vdout1_165ck910 FIND v(dout1_165) AT=920.05n

.meas tran vdout1_166ck910 FIND v(dout1_166) AT=920.05n

.meas tran vdout1_167ck910 FIND v(dout1_167) AT=920.05n

.meas tran vdout1_168ck910 FIND v(dout1_168) AT=920.05n

.meas tran vdout1_169ck910 FIND v(dout1_169) AT=920.05n

.meas tran vdout1_170ck910 FIND v(dout1_170) AT=920.05n

.meas tran vdout1_171ck910 FIND v(dout1_171) AT=920.05n

.meas tran vdout1_172ck910 FIND v(dout1_172) AT=920.05n

.meas tran vdout1_173ck910 FIND v(dout1_173) AT=920.05n

.meas tran vdout1_174ck910 FIND v(dout1_174) AT=920.05n

.meas tran vdout1_175ck910 FIND v(dout1_175) AT=920.05n

.meas tran vdout1_176ck910 FIND v(dout1_176) AT=920.05n

.meas tran vdout1_177ck910 FIND v(dout1_177) AT=920.05n

.meas tran vdout1_178ck910 FIND v(dout1_178) AT=920.05n

.meas tran vdout1_179ck910 FIND v(dout1_179) AT=920.05n

.meas tran vdout1_180ck910 FIND v(dout1_180) AT=920.05n

.meas tran vdout1_181ck910 FIND v(dout1_181) AT=920.05n

.meas tran vdout1_182ck910 FIND v(dout1_182) AT=920.05n

.meas tran vdout1_183ck910 FIND v(dout1_183) AT=920.05n

.meas tran vdout1_184ck910 FIND v(dout1_184) AT=920.05n

.meas tran vdout1_185ck910 FIND v(dout1_185) AT=920.05n

.meas tran vdout1_186ck910 FIND v(dout1_186) AT=920.05n

.meas tran vdout1_187ck910 FIND v(dout1_187) AT=920.05n

.meas tran vdout1_188ck910 FIND v(dout1_188) AT=920.05n

.meas tran vdout1_189ck910 FIND v(dout1_189) AT=920.05n

.meas tran vdout1_190ck910 FIND v(dout1_190) AT=920.05n

.meas tran vdout1_191ck910 FIND v(dout1_191) AT=920.05n

.meas tran vdout1_192ck910 FIND v(dout1_192) AT=920.05n

.meas tran vdout1_193ck910 FIND v(dout1_193) AT=920.05n

.meas tran vdout1_194ck910 FIND v(dout1_194) AT=920.05n

.meas tran vdout1_195ck910 FIND v(dout1_195) AT=920.05n

.meas tran vdout1_196ck910 FIND v(dout1_196) AT=920.05n

.meas tran vdout1_197ck910 FIND v(dout1_197) AT=920.05n

.meas tran vdout1_198ck910 FIND v(dout1_198) AT=920.05n

.meas tran vdout1_199ck910 FIND v(dout1_199) AT=920.05n

.meas tran vdout1_200ck910 FIND v(dout1_200) AT=920.05n

.meas tran vdout1_201ck910 FIND v(dout1_201) AT=920.05n

.meas tran vdout1_202ck910 FIND v(dout1_202) AT=920.05n

.meas tran vdout1_203ck910 FIND v(dout1_203) AT=920.05n

.meas tran vdout1_204ck910 FIND v(dout1_204) AT=920.05n

.meas tran vdout1_205ck910 FIND v(dout1_205) AT=920.05n

.meas tran vdout1_206ck910 FIND v(dout1_206) AT=920.05n

.meas tran vdout1_207ck910 FIND v(dout1_207) AT=920.05n

.meas tran vdout1_208ck910 FIND v(dout1_208) AT=920.05n

.meas tran vdout1_209ck910 FIND v(dout1_209) AT=920.05n

.meas tran vdout1_210ck910 FIND v(dout1_210) AT=920.05n

.meas tran vdout1_211ck910 FIND v(dout1_211) AT=920.05n

.meas tran vdout1_212ck910 FIND v(dout1_212) AT=920.05n

.meas tran vdout1_213ck910 FIND v(dout1_213) AT=920.05n

.meas tran vdout1_214ck910 FIND v(dout1_214) AT=920.05n

.meas tran vdout1_215ck910 FIND v(dout1_215) AT=920.05n

.meas tran vdout1_216ck910 FIND v(dout1_216) AT=920.05n

.meas tran vdout1_217ck910 FIND v(dout1_217) AT=920.05n

.meas tran vdout1_218ck910 FIND v(dout1_218) AT=920.05n

.meas tran vdout1_219ck910 FIND v(dout1_219) AT=920.05n

.meas tran vdout1_220ck910 FIND v(dout1_220) AT=920.05n

.meas tran vdout1_221ck910 FIND v(dout1_221) AT=920.05n

.meas tran vdout1_222ck910 FIND v(dout1_222) AT=920.05n

.meas tran vdout1_223ck910 FIND v(dout1_223) AT=920.05n

.meas tran vdout1_224ck910 FIND v(dout1_224) AT=920.05n

.meas tran vdout1_225ck910 FIND v(dout1_225) AT=920.05n

.meas tran vdout1_226ck910 FIND v(dout1_226) AT=920.05n

.meas tran vdout1_227ck910 FIND v(dout1_227) AT=920.05n

.meas tran vdout1_228ck910 FIND v(dout1_228) AT=920.05n

.meas tran vdout1_229ck910 FIND v(dout1_229) AT=920.05n

.meas tran vdout1_230ck910 FIND v(dout1_230) AT=920.05n

.meas tran vdout1_231ck910 FIND v(dout1_231) AT=920.05n

.meas tran vdout1_232ck910 FIND v(dout1_232) AT=920.05n

.meas tran vdout1_233ck910 FIND v(dout1_233) AT=920.05n

.meas tran vdout1_234ck910 FIND v(dout1_234) AT=920.05n

.meas tran vdout1_235ck910 FIND v(dout1_235) AT=920.05n

.meas tran vdout1_236ck910 FIND v(dout1_236) AT=920.05n

.meas tran vdout1_237ck910 FIND v(dout1_237) AT=920.05n

.meas tran vdout1_238ck910 FIND v(dout1_238) AT=920.05n

.meas tran vdout1_239ck910 FIND v(dout1_239) AT=920.05n

.meas tran vdout1_240ck910 FIND v(dout1_240) AT=920.05n

.meas tran vdout1_241ck910 FIND v(dout1_241) AT=920.05n

.meas tran vdout1_242ck910 FIND v(dout1_242) AT=920.05n

.meas tran vdout1_243ck910 FIND v(dout1_243) AT=920.05n

.meas tran vdout1_244ck910 FIND v(dout1_244) AT=920.05n

.meas tran vdout1_245ck910 FIND v(dout1_245) AT=920.05n

.meas tran vdout1_246ck910 FIND v(dout1_246) AT=920.05n

.meas tran vdout1_247ck910 FIND v(dout1_247) AT=920.05n

.meas tran vdout1_248ck910 FIND v(dout1_248) AT=920.05n

.meas tran vdout1_249ck910 FIND v(dout1_249) AT=920.05n

.meas tran vdout1_250ck910 FIND v(dout1_250) AT=920.05n

.meas tran vdout1_251ck910 FIND v(dout1_251) AT=920.05n

.meas tran vdout1_252ck910 FIND v(dout1_252) AT=920.05n

.meas tran vdout1_253ck910 FIND v(dout1_253) AT=920.05n

.meas tran vdout1_254ck910 FIND v(dout1_254) AT=920.05n

.meas tran vdout1_255ck910 FIND v(dout1_255) AT=920.05n

.meas tran vdout1_256ck910 FIND v(dout1_256) AT=920.05n

.meas tran vdout1_0ck920 FIND v(dout1_0) AT=930.05n

.meas tran vdout1_1ck920 FIND v(dout1_1) AT=930.05n

.meas tran vdout1_2ck920 FIND v(dout1_2) AT=930.05n

.meas tran vdout1_3ck920 FIND v(dout1_3) AT=930.05n

.meas tran vdout1_4ck920 FIND v(dout1_4) AT=930.05n

.meas tran vdout1_5ck920 FIND v(dout1_5) AT=930.05n

.meas tran vdout1_6ck920 FIND v(dout1_6) AT=930.05n

.meas tran vdout1_7ck920 FIND v(dout1_7) AT=930.05n

.meas tran vdout1_8ck920 FIND v(dout1_8) AT=930.05n

.meas tran vdout1_9ck920 FIND v(dout1_9) AT=930.05n

.meas tran vdout1_10ck920 FIND v(dout1_10) AT=930.05n

.meas tran vdout1_11ck920 FIND v(dout1_11) AT=930.05n

.meas tran vdout1_12ck920 FIND v(dout1_12) AT=930.05n

.meas tran vdout1_13ck920 FIND v(dout1_13) AT=930.05n

.meas tran vdout1_14ck920 FIND v(dout1_14) AT=930.05n

.meas tran vdout1_15ck920 FIND v(dout1_15) AT=930.05n

.meas tran vdout1_16ck920 FIND v(dout1_16) AT=930.05n

.meas tran vdout1_17ck920 FIND v(dout1_17) AT=930.05n

.meas tran vdout1_18ck920 FIND v(dout1_18) AT=930.05n

.meas tran vdout1_19ck920 FIND v(dout1_19) AT=930.05n

.meas tran vdout1_20ck920 FIND v(dout1_20) AT=930.05n

.meas tran vdout1_21ck920 FIND v(dout1_21) AT=930.05n

.meas tran vdout1_22ck920 FIND v(dout1_22) AT=930.05n

.meas tran vdout1_23ck920 FIND v(dout1_23) AT=930.05n

.meas tran vdout1_24ck920 FIND v(dout1_24) AT=930.05n

.meas tran vdout1_25ck920 FIND v(dout1_25) AT=930.05n

.meas tran vdout1_26ck920 FIND v(dout1_26) AT=930.05n

.meas tran vdout1_27ck920 FIND v(dout1_27) AT=930.05n

.meas tran vdout1_28ck920 FIND v(dout1_28) AT=930.05n

.meas tran vdout1_29ck920 FIND v(dout1_29) AT=930.05n

.meas tran vdout1_30ck920 FIND v(dout1_30) AT=930.05n

.meas tran vdout1_31ck920 FIND v(dout1_31) AT=930.05n

.meas tran vdout1_32ck920 FIND v(dout1_32) AT=930.05n

.meas tran vdout1_33ck920 FIND v(dout1_33) AT=930.05n

.meas tran vdout1_34ck920 FIND v(dout1_34) AT=930.05n

.meas tran vdout1_35ck920 FIND v(dout1_35) AT=930.05n

.meas tran vdout1_36ck920 FIND v(dout1_36) AT=930.05n

.meas tran vdout1_37ck920 FIND v(dout1_37) AT=930.05n

.meas tran vdout1_38ck920 FIND v(dout1_38) AT=930.05n

.meas tran vdout1_39ck920 FIND v(dout1_39) AT=930.05n

.meas tran vdout1_40ck920 FIND v(dout1_40) AT=930.05n

.meas tran vdout1_41ck920 FIND v(dout1_41) AT=930.05n

.meas tran vdout1_42ck920 FIND v(dout1_42) AT=930.05n

.meas tran vdout1_43ck920 FIND v(dout1_43) AT=930.05n

.meas tran vdout1_44ck920 FIND v(dout1_44) AT=930.05n

.meas tran vdout1_45ck920 FIND v(dout1_45) AT=930.05n

.meas tran vdout1_46ck920 FIND v(dout1_46) AT=930.05n

.meas tran vdout1_47ck920 FIND v(dout1_47) AT=930.05n

.meas tran vdout1_48ck920 FIND v(dout1_48) AT=930.05n

.meas tran vdout1_49ck920 FIND v(dout1_49) AT=930.05n

.meas tran vdout1_50ck920 FIND v(dout1_50) AT=930.05n

.meas tran vdout1_51ck920 FIND v(dout1_51) AT=930.05n

.meas tran vdout1_52ck920 FIND v(dout1_52) AT=930.05n

.meas tran vdout1_53ck920 FIND v(dout1_53) AT=930.05n

.meas tran vdout1_54ck920 FIND v(dout1_54) AT=930.05n

.meas tran vdout1_55ck920 FIND v(dout1_55) AT=930.05n

.meas tran vdout1_56ck920 FIND v(dout1_56) AT=930.05n

.meas tran vdout1_57ck920 FIND v(dout1_57) AT=930.05n

.meas tran vdout1_58ck920 FIND v(dout1_58) AT=930.05n

.meas tran vdout1_59ck920 FIND v(dout1_59) AT=930.05n

.meas tran vdout1_60ck920 FIND v(dout1_60) AT=930.05n

.meas tran vdout1_61ck920 FIND v(dout1_61) AT=930.05n

.meas tran vdout1_62ck920 FIND v(dout1_62) AT=930.05n

.meas tran vdout1_63ck920 FIND v(dout1_63) AT=930.05n

.meas tran vdout1_64ck920 FIND v(dout1_64) AT=930.05n

.meas tran vdout1_65ck920 FIND v(dout1_65) AT=930.05n

.meas tran vdout1_66ck920 FIND v(dout1_66) AT=930.05n

.meas tran vdout1_67ck920 FIND v(dout1_67) AT=930.05n

.meas tran vdout1_68ck920 FIND v(dout1_68) AT=930.05n

.meas tran vdout1_69ck920 FIND v(dout1_69) AT=930.05n

.meas tran vdout1_70ck920 FIND v(dout1_70) AT=930.05n

.meas tran vdout1_71ck920 FIND v(dout1_71) AT=930.05n

.meas tran vdout1_72ck920 FIND v(dout1_72) AT=930.05n

.meas tran vdout1_73ck920 FIND v(dout1_73) AT=930.05n

.meas tran vdout1_74ck920 FIND v(dout1_74) AT=930.05n

.meas tran vdout1_75ck920 FIND v(dout1_75) AT=930.05n

.meas tran vdout1_76ck920 FIND v(dout1_76) AT=930.05n

.meas tran vdout1_77ck920 FIND v(dout1_77) AT=930.05n

.meas tran vdout1_78ck920 FIND v(dout1_78) AT=930.05n

.meas tran vdout1_79ck920 FIND v(dout1_79) AT=930.05n

.meas tran vdout1_80ck920 FIND v(dout1_80) AT=930.05n

.meas tran vdout1_81ck920 FIND v(dout1_81) AT=930.05n

.meas tran vdout1_82ck920 FIND v(dout1_82) AT=930.05n

.meas tran vdout1_83ck920 FIND v(dout1_83) AT=930.05n

.meas tran vdout1_84ck920 FIND v(dout1_84) AT=930.05n

.meas tran vdout1_85ck920 FIND v(dout1_85) AT=930.05n

.meas tran vdout1_86ck920 FIND v(dout1_86) AT=930.05n

.meas tran vdout1_87ck920 FIND v(dout1_87) AT=930.05n

.meas tran vdout1_88ck920 FIND v(dout1_88) AT=930.05n

.meas tran vdout1_89ck920 FIND v(dout1_89) AT=930.05n

.meas tran vdout1_90ck920 FIND v(dout1_90) AT=930.05n

.meas tran vdout1_91ck920 FIND v(dout1_91) AT=930.05n

.meas tran vdout1_92ck920 FIND v(dout1_92) AT=930.05n

.meas tran vdout1_93ck920 FIND v(dout1_93) AT=930.05n

.meas tran vdout1_94ck920 FIND v(dout1_94) AT=930.05n

.meas tran vdout1_95ck920 FIND v(dout1_95) AT=930.05n

.meas tran vdout1_96ck920 FIND v(dout1_96) AT=930.05n

.meas tran vdout1_97ck920 FIND v(dout1_97) AT=930.05n

.meas tran vdout1_98ck920 FIND v(dout1_98) AT=930.05n

.meas tran vdout1_99ck920 FIND v(dout1_99) AT=930.05n

.meas tran vdout1_100ck920 FIND v(dout1_100) AT=930.05n

.meas tran vdout1_101ck920 FIND v(dout1_101) AT=930.05n

.meas tran vdout1_102ck920 FIND v(dout1_102) AT=930.05n

.meas tran vdout1_103ck920 FIND v(dout1_103) AT=930.05n

.meas tran vdout1_104ck920 FIND v(dout1_104) AT=930.05n

.meas tran vdout1_105ck920 FIND v(dout1_105) AT=930.05n

.meas tran vdout1_106ck920 FIND v(dout1_106) AT=930.05n

.meas tran vdout1_107ck920 FIND v(dout1_107) AT=930.05n

.meas tran vdout1_108ck920 FIND v(dout1_108) AT=930.05n

.meas tran vdout1_109ck920 FIND v(dout1_109) AT=930.05n

.meas tran vdout1_110ck920 FIND v(dout1_110) AT=930.05n

.meas tran vdout1_111ck920 FIND v(dout1_111) AT=930.05n

.meas tran vdout1_112ck920 FIND v(dout1_112) AT=930.05n

.meas tran vdout1_113ck920 FIND v(dout1_113) AT=930.05n

.meas tran vdout1_114ck920 FIND v(dout1_114) AT=930.05n

.meas tran vdout1_115ck920 FIND v(dout1_115) AT=930.05n

.meas tran vdout1_116ck920 FIND v(dout1_116) AT=930.05n

.meas tran vdout1_117ck920 FIND v(dout1_117) AT=930.05n

.meas tran vdout1_118ck920 FIND v(dout1_118) AT=930.05n

.meas tran vdout1_119ck920 FIND v(dout1_119) AT=930.05n

.meas tran vdout1_120ck920 FIND v(dout1_120) AT=930.05n

.meas tran vdout1_121ck920 FIND v(dout1_121) AT=930.05n

.meas tran vdout1_122ck920 FIND v(dout1_122) AT=930.05n

.meas tran vdout1_123ck920 FIND v(dout1_123) AT=930.05n

.meas tran vdout1_124ck920 FIND v(dout1_124) AT=930.05n

.meas tran vdout1_125ck920 FIND v(dout1_125) AT=930.05n

.meas tran vdout1_126ck920 FIND v(dout1_126) AT=930.05n

.meas tran vdout1_127ck920 FIND v(dout1_127) AT=930.05n

.meas tran vdout1_128ck920 FIND v(dout1_128) AT=930.05n

.meas tran vdout1_129ck920 FIND v(dout1_129) AT=930.05n

.meas tran vdout1_130ck920 FIND v(dout1_130) AT=930.05n

.meas tran vdout1_131ck920 FIND v(dout1_131) AT=930.05n

.meas tran vdout1_132ck920 FIND v(dout1_132) AT=930.05n

.meas tran vdout1_133ck920 FIND v(dout1_133) AT=930.05n

.meas tran vdout1_134ck920 FIND v(dout1_134) AT=930.05n

.meas tran vdout1_135ck920 FIND v(dout1_135) AT=930.05n

.meas tran vdout1_136ck920 FIND v(dout1_136) AT=930.05n

.meas tran vdout1_137ck920 FIND v(dout1_137) AT=930.05n

.meas tran vdout1_138ck920 FIND v(dout1_138) AT=930.05n

.meas tran vdout1_139ck920 FIND v(dout1_139) AT=930.05n

.meas tran vdout1_140ck920 FIND v(dout1_140) AT=930.05n

.meas tran vdout1_141ck920 FIND v(dout1_141) AT=930.05n

.meas tran vdout1_142ck920 FIND v(dout1_142) AT=930.05n

.meas tran vdout1_143ck920 FIND v(dout1_143) AT=930.05n

.meas tran vdout1_144ck920 FIND v(dout1_144) AT=930.05n

.meas tran vdout1_145ck920 FIND v(dout1_145) AT=930.05n

.meas tran vdout1_146ck920 FIND v(dout1_146) AT=930.05n

.meas tran vdout1_147ck920 FIND v(dout1_147) AT=930.05n

.meas tran vdout1_148ck920 FIND v(dout1_148) AT=930.05n

.meas tran vdout1_149ck920 FIND v(dout1_149) AT=930.05n

.meas tran vdout1_150ck920 FIND v(dout1_150) AT=930.05n

.meas tran vdout1_151ck920 FIND v(dout1_151) AT=930.05n

.meas tran vdout1_152ck920 FIND v(dout1_152) AT=930.05n

.meas tran vdout1_153ck920 FIND v(dout1_153) AT=930.05n

.meas tran vdout1_154ck920 FIND v(dout1_154) AT=930.05n

.meas tran vdout1_155ck920 FIND v(dout1_155) AT=930.05n

.meas tran vdout1_156ck920 FIND v(dout1_156) AT=930.05n

.meas tran vdout1_157ck920 FIND v(dout1_157) AT=930.05n

.meas tran vdout1_158ck920 FIND v(dout1_158) AT=930.05n

.meas tran vdout1_159ck920 FIND v(dout1_159) AT=930.05n

.meas tran vdout1_160ck920 FIND v(dout1_160) AT=930.05n

.meas tran vdout1_161ck920 FIND v(dout1_161) AT=930.05n

.meas tran vdout1_162ck920 FIND v(dout1_162) AT=930.05n

.meas tran vdout1_163ck920 FIND v(dout1_163) AT=930.05n

.meas tran vdout1_164ck920 FIND v(dout1_164) AT=930.05n

.meas tran vdout1_165ck920 FIND v(dout1_165) AT=930.05n

.meas tran vdout1_166ck920 FIND v(dout1_166) AT=930.05n

.meas tran vdout1_167ck920 FIND v(dout1_167) AT=930.05n

.meas tran vdout1_168ck920 FIND v(dout1_168) AT=930.05n

.meas tran vdout1_169ck920 FIND v(dout1_169) AT=930.05n

.meas tran vdout1_170ck920 FIND v(dout1_170) AT=930.05n

.meas tran vdout1_171ck920 FIND v(dout1_171) AT=930.05n

.meas tran vdout1_172ck920 FIND v(dout1_172) AT=930.05n

.meas tran vdout1_173ck920 FIND v(dout1_173) AT=930.05n

.meas tran vdout1_174ck920 FIND v(dout1_174) AT=930.05n

.meas tran vdout1_175ck920 FIND v(dout1_175) AT=930.05n

.meas tran vdout1_176ck920 FIND v(dout1_176) AT=930.05n

.meas tran vdout1_177ck920 FIND v(dout1_177) AT=930.05n

.meas tran vdout1_178ck920 FIND v(dout1_178) AT=930.05n

.meas tran vdout1_179ck920 FIND v(dout1_179) AT=930.05n

.meas tran vdout1_180ck920 FIND v(dout1_180) AT=930.05n

.meas tran vdout1_181ck920 FIND v(dout1_181) AT=930.05n

.meas tran vdout1_182ck920 FIND v(dout1_182) AT=930.05n

.meas tran vdout1_183ck920 FIND v(dout1_183) AT=930.05n

.meas tran vdout1_184ck920 FIND v(dout1_184) AT=930.05n

.meas tran vdout1_185ck920 FIND v(dout1_185) AT=930.05n

.meas tran vdout1_186ck920 FIND v(dout1_186) AT=930.05n

.meas tran vdout1_187ck920 FIND v(dout1_187) AT=930.05n

.meas tran vdout1_188ck920 FIND v(dout1_188) AT=930.05n

.meas tran vdout1_189ck920 FIND v(dout1_189) AT=930.05n

.meas tran vdout1_190ck920 FIND v(dout1_190) AT=930.05n

.meas tran vdout1_191ck920 FIND v(dout1_191) AT=930.05n

.meas tran vdout1_192ck920 FIND v(dout1_192) AT=930.05n

.meas tran vdout1_193ck920 FIND v(dout1_193) AT=930.05n

.meas tran vdout1_194ck920 FIND v(dout1_194) AT=930.05n

.meas tran vdout1_195ck920 FIND v(dout1_195) AT=930.05n

.meas tran vdout1_196ck920 FIND v(dout1_196) AT=930.05n

.meas tran vdout1_197ck920 FIND v(dout1_197) AT=930.05n

.meas tran vdout1_198ck920 FIND v(dout1_198) AT=930.05n

.meas tran vdout1_199ck920 FIND v(dout1_199) AT=930.05n

.meas tran vdout1_200ck920 FIND v(dout1_200) AT=930.05n

.meas tran vdout1_201ck920 FIND v(dout1_201) AT=930.05n

.meas tran vdout1_202ck920 FIND v(dout1_202) AT=930.05n

.meas tran vdout1_203ck920 FIND v(dout1_203) AT=930.05n

.meas tran vdout1_204ck920 FIND v(dout1_204) AT=930.05n

.meas tran vdout1_205ck920 FIND v(dout1_205) AT=930.05n

.meas tran vdout1_206ck920 FIND v(dout1_206) AT=930.05n

.meas tran vdout1_207ck920 FIND v(dout1_207) AT=930.05n

.meas tran vdout1_208ck920 FIND v(dout1_208) AT=930.05n

.meas tran vdout1_209ck920 FIND v(dout1_209) AT=930.05n

.meas tran vdout1_210ck920 FIND v(dout1_210) AT=930.05n

.meas tran vdout1_211ck920 FIND v(dout1_211) AT=930.05n

.meas tran vdout1_212ck920 FIND v(dout1_212) AT=930.05n

.meas tran vdout1_213ck920 FIND v(dout1_213) AT=930.05n

.meas tran vdout1_214ck920 FIND v(dout1_214) AT=930.05n

.meas tran vdout1_215ck920 FIND v(dout1_215) AT=930.05n

.meas tran vdout1_216ck920 FIND v(dout1_216) AT=930.05n

.meas tran vdout1_217ck920 FIND v(dout1_217) AT=930.05n

.meas tran vdout1_218ck920 FIND v(dout1_218) AT=930.05n

.meas tran vdout1_219ck920 FIND v(dout1_219) AT=930.05n

.meas tran vdout1_220ck920 FIND v(dout1_220) AT=930.05n

.meas tran vdout1_221ck920 FIND v(dout1_221) AT=930.05n

.meas tran vdout1_222ck920 FIND v(dout1_222) AT=930.05n

.meas tran vdout1_223ck920 FIND v(dout1_223) AT=930.05n

.meas tran vdout1_224ck920 FIND v(dout1_224) AT=930.05n

.meas tran vdout1_225ck920 FIND v(dout1_225) AT=930.05n

.meas tran vdout1_226ck920 FIND v(dout1_226) AT=930.05n

.meas tran vdout1_227ck920 FIND v(dout1_227) AT=930.05n

.meas tran vdout1_228ck920 FIND v(dout1_228) AT=930.05n

.meas tran vdout1_229ck920 FIND v(dout1_229) AT=930.05n

.meas tran vdout1_230ck920 FIND v(dout1_230) AT=930.05n

.meas tran vdout1_231ck920 FIND v(dout1_231) AT=930.05n

.meas tran vdout1_232ck920 FIND v(dout1_232) AT=930.05n

.meas tran vdout1_233ck920 FIND v(dout1_233) AT=930.05n

.meas tran vdout1_234ck920 FIND v(dout1_234) AT=930.05n

.meas tran vdout1_235ck920 FIND v(dout1_235) AT=930.05n

.meas tran vdout1_236ck920 FIND v(dout1_236) AT=930.05n

.meas tran vdout1_237ck920 FIND v(dout1_237) AT=930.05n

.meas tran vdout1_238ck920 FIND v(dout1_238) AT=930.05n

.meas tran vdout1_239ck920 FIND v(dout1_239) AT=930.05n

.meas tran vdout1_240ck920 FIND v(dout1_240) AT=930.05n

.meas tran vdout1_241ck920 FIND v(dout1_241) AT=930.05n

.meas tran vdout1_242ck920 FIND v(dout1_242) AT=930.05n

.meas tran vdout1_243ck920 FIND v(dout1_243) AT=930.05n

.meas tran vdout1_244ck920 FIND v(dout1_244) AT=930.05n

.meas tran vdout1_245ck920 FIND v(dout1_245) AT=930.05n

.meas tran vdout1_246ck920 FIND v(dout1_246) AT=930.05n

.meas tran vdout1_247ck920 FIND v(dout1_247) AT=930.05n

.meas tran vdout1_248ck920 FIND v(dout1_248) AT=930.05n

.meas tran vdout1_249ck920 FIND v(dout1_249) AT=930.05n

.meas tran vdout1_250ck920 FIND v(dout1_250) AT=930.05n

.meas tran vdout1_251ck920 FIND v(dout1_251) AT=930.05n

.meas tran vdout1_252ck920 FIND v(dout1_252) AT=930.05n

.meas tran vdout1_253ck920 FIND v(dout1_253) AT=930.05n

.meas tran vdout1_254ck920 FIND v(dout1_254) AT=930.05n

.meas tran vdout1_255ck920 FIND v(dout1_255) AT=930.05n

.meas tran vdout1_256ck920 FIND v(dout1_256) AT=930.05n

.meas tran vdout1_0ck950 FIND v(dout1_0) AT=960.05n

.meas tran vdout1_1ck950 FIND v(dout1_1) AT=960.05n

.meas tran vdout1_2ck950 FIND v(dout1_2) AT=960.05n

.meas tran vdout1_3ck950 FIND v(dout1_3) AT=960.05n

.meas tran vdout1_4ck950 FIND v(dout1_4) AT=960.05n

.meas tran vdout1_5ck950 FIND v(dout1_5) AT=960.05n

.meas tran vdout1_6ck950 FIND v(dout1_6) AT=960.05n

.meas tran vdout1_7ck950 FIND v(dout1_7) AT=960.05n

.meas tran vdout1_8ck950 FIND v(dout1_8) AT=960.05n

.meas tran vdout1_9ck950 FIND v(dout1_9) AT=960.05n

.meas tran vdout1_10ck950 FIND v(dout1_10) AT=960.05n

.meas tran vdout1_11ck950 FIND v(dout1_11) AT=960.05n

.meas tran vdout1_12ck950 FIND v(dout1_12) AT=960.05n

.meas tran vdout1_13ck950 FIND v(dout1_13) AT=960.05n

.meas tran vdout1_14ck950 FIND v(dout1_14) AT=960.05n

.meas tran vdout1_15ck950 FIND v(dout1_15) AT=960.05n

.meas tran vdout1_16ck950 FIND v(dout1_16) AT=960.05n

.meas tran vdout1_17ck950 FIND v(dout1_17) AT=960.05n

.meas tran vdout1_18ck950 FIND v(dout1_18) AT=960.05n

.meas tran vdout1_19ck950 FIND v(dout1_19) AT=960.05n

.meas tran vdout1_20ck950 FIND v(dout1_20) AT=960.05n

.meas tran vdout1_21ck950 FIND v(dout1_21) AT=960.05n

.meas tran vdout1_22ck950 FIND v(dout1_22) AT=960.05n

.meas tran vdout1_23ck950 FIND v(dout1_23) AT=960.05n

.meas tran vdout1_24ck950 FIND v(dout1_24) AT=960.05n

.meas tran vdout1_25ck950 FIND v(dout1_25) AT=960.05n

.meas tran vdout1_26ck950 FIND v(dout1_26) AT=960.05n

.meas tran vdout1_27ck950 FIND v(dout1_27) AT=960.05n

.meas tran vdout1_28ck950 FIND v(dout1_28) AT=960.05n

.meas tran vdout1_29ck950 FIND v(dout1_29) AT=960.05n

.meas tran vdout1_30ck950 FIND v(dout1_30) AT=960.05n

.meas tran vdout1_31ck950 FIND v(dout1_31) AT=960.05n

.meas tran vdout1_32ck950 FIND v(dout1_32) AT=960.05n

.meas tran vdout1_33ck950 FIND v(dout1_33) AT=960.05n

.meas tran vdout1_34ck950 FIND v(dout1_34) AT=960.05n

.meas tran vdout1_35ck950 FIND v(dout1_35) AT=960.05n

.meas tran vdout1_36ck950 FIND v(dout1_36) AT=960.05n

.meas tran vdout1_37ck950 FIND v(dout1_37) AT=960.05n

.meas tran vdout1_38ck950 FIND v(dout1_38) AT=960.05n

.meas tran vdout1_39ck950 FIND v(dout1_39) AT=960.05n

.meas tran vdout1_40ck950 FIND v(dout1_40) AT=960.05n

.meas tran vdout1_41ck950 FIND v(dout1_41) AT=960.05n

.meas tran vdout1_42ck950 FIND v(dout1_42) AT=960.05n

.meas tran vdout1_43ck950 FIND v(dout1_43) AT=960.05n

.meas tran vdout1_44ck950 FIND v(dout1_44) AT=960.05n

.meas tran vdout1_45ck950 FIND v(dout1_45) AT=960.05n

.meas tran vdout1_46ck950 FIND v(dout1_46) AT=960.05n

.meas tran vdout1_47ck950 FIND v(dout1_47) AT=960.05n

.meas tran vdout1_48ck950 FIND v(dout1_48) AT=960.05n

.meas tran vdout1_49ck950 FIND v(dout1_49) AT=960.05n

.meas tran vdout1_50ck950 FIND v(dout1_50) AT=960.05n

.meas tran vdout1_51ck950 FIND v(dout1_51) AT=960.05n

.meas tran vdout1_52ck950 FIND v(dout1_52) AT=960.05n

.meas tran vdout1_53ck950 FIND v(dout1_53) AT=960.05n

.meas tran vdout1_54ck950 FIND v(dout1_54) AT=960.05n

.meas tran vdout1_55ck950 FIND v(dout1_55) AT=960.05n

.meas tran vdout1_56ck950 FIND v(dout1_56) AT=960.05n

.meas tran vdout1_57ck950 FIND v(dout1_57) AT=960.05n

.meas tran vdout1_58ck950 FIND v(dout1_58) AT=960.05n

.meas tran vdout1_59ck950 FIND v(dout1_59) AT=960.05n

.meas tran vdout1_60ck950 FIND v(dout1_60) AT=960.05n

.meas tran vdout1_61ck950 FIND v(dout1_61) AT=960.05n

.meas tran vdout1_62ck950 FIND v(dout1_62) AT=960.05n

.meas tran vdout1_63ck950 FIND v(dout1_63) AT=960.05n

.meas tran vdout1_64ck950 FIND v(dout1_64) AT=960.05n

.meas tran vdout1_65ck950 FIND v(dout1_65) AT=960.05n

.meas tran vdout1_66ck950 FIND v(dout1_66) AT=960.05n

.meas tran vdout1_67ck950 FIND v(dout1_67) AT=960.05n

.meas tran vdout1_68ck950 FIND v(dout1_68) AT=960.05n

.meas tran vdout1_69ck950 FIND v(dout1_69) AT=960.05n

.meas tran vdout1_70ck950 FIND v(dout1_70) AT=960.05n

.meas tran vdout1_71ck950 FIND v(dout1_71) AT=960.05n

.meas tran vdout1_72ck950 FIND v(dout1_72) AT=960.05n

.meas tran vdout1_73ck950 FIND v(dout1_73) AT=960.05n

.meas tran vdout1_74ck950 FIND v(dout1_74) AT=960.05n

.meas tran vdout1_75ck950 FIND v(dout1_75) AT=960.05n

.meas tran vdout1_76ck950 FIND v(dout1_76) AT=960.05n

.meas tran vdout1_77ck950 FIND v(dout1_77) AT=960.05n

.meas tran vdout1_78ck950 FIND v(dout1_78) AT=960.05n

.meas tran vdout1_79ck950 FIND v(dout1_79) AT=960.05n

.meas tran vdout1_80ck950 FIND v(dout1_80) AT=960.05n

.meas tran vdout1_81ck950 FIND v(dout1_81) AT=960.05n

.meas tran vdout1_82ck950 FIND v(dout1_82) AT=960.05n

.meas tran vdout1_83ck950 FIND v(dout1_83) AT=960.05n

.meas tran vdout1_84ck950 FIND v(dout1_84) AT=960.05n

.meas tran vdout1_85ck950 FIND v(dout1_85) AT=960.05n

.meas tran vdout1_86ck950 FIND v(dout1_86) AT=960.05n

.meas tran vdout1_87ck950 FIND v(dout1_87) AT=960.05n

.meas tran vdout1_88ck950 FIND v(dout1_88) AT=960.05n

.meas tran vdout1_89ck950 FIND v(dout1_89) AT=960.05n

.meas tran vdout1_90ck950 FIND v(dout1_90) AT=960.05n

.meas tran vdout1_91ck950 FIND v(dout1_91) AT=960.05n

.meas tran vdout1_92ck950 FIND v(dout1_92) AT=960.05n

.meas tran vdout1_93ck950 FIND v(dout1_93) AT=960.05n

.meas tran vdout1_94ck950 FIND v(dout1_94) AT=960.05n

.meas tran vdout1_95ck950 FIND v(dout1_95) AT=960.05n

.meas tran vdout1_96ck950 FIND v(dout1_96) AT=960.05n

.meas tran vdout1_97ck950 FIND v(dout1_97) AT=960.05n

.meas tran vdout1_98ck950 FIND v(dout1_98) AT=960.05n

.meas tran vdout1_99ck950 FIND v(dout1_99) AT=960.05n

.meas tran vdout1_100ck950 FIND v(dout1_100) AT=960.05n

.meas tran vdout1_101ck950 FIND v(dout1_101) AT=960.05n

.meas tran vdout1_102ck950 FIND v(dout1_102) AT=960.05n

.meas tran vdout1_103ck950 FIND v(dout1_103) AT=960.05n

.meas tran vdout1_104ck950 FIND v(dout1_104) AT=960.05n

.meas tran vdout1_105ck950 FIND v(dout1_105) AT=960.05n

.meas tran vdout1_106ck950 FIND v(dout1_106) AT=960.05n

.meas tran vdout1_107ck950 FIND v(dout1_107) AT=960.05n

.meas tran vdout1_108ck950 FIND v(dout1_108) AT=960.05n

.meas tran vdout1_109ck950 FIND v(dout1_109) AT=960.05n

.meas tran vdout1_110ck950 FIND v(dout1_110) AT=960.05n

.meas tran vdout1_111ck950 FIND v(dout1_111) AT=960.05n

.meas tran vdout1_112ck950 FIND v(dout1_112) AT=960.05n

.meas tran vdout1_113ck950 FIND v(dout1_113) AT=960.05n

.meas tran vdout1_114ck950 FIND v(dout1_114) AT=960.05n

.meas tran vdout1_115ck950 FIND v(dout1_115) AT=960.05n

.meas tran vdout1_116ck950 FIND v(dout1_116) AT=960.05n

.meas tran vdout1_117ck950 FIND v(dout1_117) AT=960.05n

.meas tran vdout1_118ck950 FIND v(dout1_118) AT=960.05n

.meas tran vdout1_119ck950 FIND v(dout1_119) AT=960.05n

.meas tran vdout1_120ck950 FIND v(dout1_120) AT=960.05n

.meas tran vdout1_121ck950 FIND v(dout1_121) AT=960.05n

.meas tran vdout1_122ck950 FIND v(dout1_122) AT=960.05n

.meas tran vdout1_123ck950 FIND v(dout1_123) AT=960.05n

.meas tran vdout1_124ck950 FIND v(dout1_124) AT=960.05n

.meas tran vdout1_125ck950 FIND v(dout1_125) AT=960.05n

.meas tran vdout1_126ck950 FIND v(dout1_126) AT=960.05n

.meas tran vdout1_127ck950 FIND v(dout1_127) AT=960.05n

.meas tran vdout1_128ck950 FIND v(dout1_128) AT=960.05n

.meas tran vdout1_129ck950 FIND v(dout1_129) AT=960.05n

.meas tran vdout1_130ck950 FIND v(dout1_130) AT=960.05n

.meas tran vdout1_131ck950 FIND v(dout1_131) AT=960.05n

.meas tran vdout1_132ck950 FIND v(dout1_132) AT=960.05n

.meas tran vdout1_133ck950 FIND v(dout1_133) AT=960.05n

.meas tran vdout1_134ck950 FIND v(dout1_134) AT=960.05n

.meas tran vdout1_135ck950 FIND v(dout1_135) AT=960.05n

.meas tran vdout1_136ck950 FIND v(dout1_136) AT=960.05n

.meas tran vdout1_137ck950 FIND v(dout1_137) AT=960.05n

.meas tran vdout1_138ck950 FIND v(dout1_138) AT=960.05n

.meas tran vdout1_139ck950 FIND v(dout1_139) AT=960.05n

.meas tran vdout1_140ck950 FIND v(dout1_140) AT=960.05n

.meas tran vdout1_141ck950 FIND v(dout1_141) AT=960.05n

.meas tran vdout1_142ck950 FIND v(dout1_142) AT=960.05n

.meas tran vdout1_143ck950 FIND v(dout1_143) AT=960.05n

.meas tran vdout1_144ck950 FIND v(dout1_144) AT=960.05n

.meas tran vdout1_145ck950 FIND v(dout1_145) AT=960.05n

.meas tran vdout1_146ck950 FIND v(dout1_146) AT=960.05n

.meas tran vdout1_147ck950 FIND v(dout1_147) AT=960.05n

.meas tran vdout1_148ck950 FIND v(dout1_148) AT=960.05n

.meas tran vdout1_149ck950 FIND v(dout1_149) AT=960.05n

.meas tran vdout1_150ck950 FIND v(dout1_150) AT=960.05n

.meas tran vdout1_151ck950 FIND v(dout1_151) AT=960.05n

.meas tran vdout1_152ck950 FIND v(dout1_152) AT=960.05n

.meas tran vdout1_153ck950 FIND v(dout1_153) AT=960.05n

.meas tran vdout1_154ck950 FIND v(dout1_154) AT=960.05n

.meas tran vdout1_155ck950 FIND v(dout1_155) AT=960.05n

.meas tran vdout1_156ck950 FIND v(dout1_156) AT=960.05n

.meas tran vdout1_157ck950 FIND v(dout1_157) AT=960.05n

.meas tran vdout1_158ck950 FIND v(dout1_158) AT=960.05n

.meas tran vdout1_159ck950 FIND v(dout1_159) AT=960.05n

.meas tran vdout1_160ck950 FIND v(dout1_160) AT=960.05n

.meas tran vdout1_161ck950 FIND v(dout1_161) AT=960.05n

.meas tran vdout1_162ck950 FIND v(dout1_162) AT=960.05n

.meas tran vdout1_163ck950 FIND v(dout1_163) AT=960.05n

.meas tran vdout1_164ck950 FIND v(dout1_164) AT=960.05n

.meas tran vdout1_165ck950 FIND v(dout1_165) AT=960.05n

.meas tran vdout1_166ck950 FIND v(dout1_166) AT=960.05n

.meas tran vdout1_167ck950 FIND v(dout1_167) AT=960.05n

.meas tran vdout1_168ck950 FIND v(dout1_168) AT=960.05n

.meas tran vdout1_169ck950 FIND v(dout1_169) AT=960.05n

.meas tran vdout1_170ck950 FIND v(dout1_170) AT=960.05n

.meas tran vdout1_171ck950 FIND v(dout1_171) AT=960.05n

.meas tran vdout1_172ck950 FIND v(dout1_172) AT=960.05n

.meas tran vdout1_173ck950 FIND v(dout1_173) AT=960.05n

.meas tran vdout1_174ck950 FIND v(dout1_174) AT=960.05n

.meas tran vdout1_175ck950 FIND v(dout1_175) AT=960.05n

.meas tran vdout1_176ck950 FIND v(dout1_176) AT=960.05n

.meas tran vdout1_177ck950 FIND v(dout1_177) AT=960.05n

.meas tran vdout1_178ck950 FIND v(dout1_178) AT=960.05n

.meas tran vdout1_179ck950 FIND v(dout1_179) AT=960.05n

.meas tran vdout1_180ck950 FIND v(dout1_180) AT=960.05n

.meas tran vdout1_181ck950 FIND v(dout1_181) AT=960.05n

.meas tran vdout1_182ck950 FIND v(dout1_182) AT=960.05n

.meas tran vdout1_183ck950 FIND v(dout1_183) AT=960.05n

.meas tran vdout1_184ck950 FIND v(dout1_184) AT=960.05n

.meas tran vdout1_185ck950 FIND v(dout1_185) AT=960.05n

.meas tran vdout1_186ck950 FIND v(dout1_186) AT=960.05n

.meas tran vdout1_187ck950 FIND v(dout1_187) AT=960.05n

.meas tran vdout1_188ck950 FIND v(dout1_188) AT=960.05n

.meas tran vdout1_189ck950 FIND v(dout1_189) AT=960.05n

.meas tran vdout1_190ck950 FIND v(dout1_190) AT=960.05n

.meas tran vdout1_191ck950 FIND v(dout1_191) AT=960.05n

.meas tran vdout1_192ck950 FIND v(dout1_192) AT=960.05n

.meas tran vdout1_193ck950 FIND v(dout1_193) AT=960.05n

.meas tran vdout1_194ck950 FIND v(dout1_194) AT=960.05n

.meas tran vdout1_195ck950 FIND v(dout1_195) AT=960.05n

.meas tran vdout1_196ck950 FIND v(dout1_196) AT=960.05n

.meas tran vdout1_197ck950 FIND v(dout1_197) AT=960.05n

.meas tran vdout1_198ck950 FIND v(dout1_198) AT=960.05n

.meas tran vdout1_199ck950 FIND v(dout1_199) AT=960.05n

.meas tran vdout1_200ck950 FIND v(dout1_200) AT=960.05n

.meas tran vdout1_201ck950 FIND v(dout1_201) AT=960.05n

.meas tran vdout1_202ck950 FIND v(dout1_202) AT=960.05n

.meas tran vdout1_203ck950 FIND v(dout1_203) AT=960.05n

.meas tran vdout1_204ck950 FIND v(dout1_204) AT=960.05n

.meas tran vdout1_205ck950 FIND v(dout1_205) AT=960.05n

.meas tran vdout1_206ck950 FIND v(dout1_206) AT=960.05n

.meas tran vdout1_207ck950 FIND v(dout1_207) AT=960.05n

.meas tran vdout1_208ck950 FIND v(dout1_208) AT=960.05n

.meas tran vdout1_209ck950 FIND v(dout1_209) AT=960.05n

.meas tran vdout1_210ck950 FIND v(dout1_210) AT=960.05n

.meas tran vdout1_211ck950 FIND v(dout1_211) AT=960.05n

.meas tran vdout1_212ck950 FIND v(dout1_212) AT=960.05n

.meas tran vdout1_213ck950 FIND v(dout1_213) AT=960.05n

.meas tran vdout1_214ck950 FIND v(dout1_214) AT=960.05n

.meas tran vdout1_215ck950 FIND v(dout1_215) AT=960.05n

.meas tran vdout1_216ck950 FIND v(dout1_216) AT=960.05n

.meas tran vdout1_217ck950 FIND v(dout1_217) AT=960.05n

.meas tran vdout1_218ck950 FIND v(dout1_218) AT=960.05n

.meas tran vdout1_219ck950 FIND v(dout1_219) AT=960.05n

.meas tran vdout1_220ck950 FIND v(dout1_220) AT=960.05n

.meas tran vdout1_221ck950 FIND v(dout1_221) AT=960.05n

.meas tran vdout1_222ck950 FIND v(dout1_222) AT=960.05n

.meas tran vdout1_223ck950 FIND v(dout1_223) AT=960.05n

.meas tran vdout1_224ck950 FIND v(dout1_224) AT=960.05n

.meas tran vdout1_225ck950 FIND v(dout1_225) AT=960.05n

.meas tran vdout1_226ck950 FIND v(dout1_226) AT=960.05n

.meas tran vdout1_227ck950 FIND v(dout1_227) AT=960.05n

.meas tran vdout1_228ck950 FIND v(dout1_228) AT=960.05n

.meas tran vdout1_229ck950 FIND v(dout1_229) AT=960.05n

.meas tran vdout1_230ck950 FIND v(dout1_230) AT=960.05n

.meas tran vdout1_231ck950 FIND v(dout1_231) AT=960.05n

.meas tran vdout1_232ck950 FIND v(dout1_232) AT=960.05n

.meas tran vdout1_233ck950 FIND v(dout1_233) AT=960.05n

.meas tran vdout1_234ck950 FIND v(dout1_234) AT=960.05n

.meas tran vdout1_235ck950 FIND v(dout1_235) AT=960.05n

.meas tran vdout1_236ck950 FIND v(dout1_236) AT=960.05n

.meas tran vdout1_237ck950 FIND v(dout1_237) AT=960.05n

.meas tran vdout1_238ck950 FIND v(dout1_238) AT=960.05n

.meas tran vdout1_239ck950 FIND v(dout1_239) AT=960.05n

.meas tran vdout1_240ck950 FIND v(dout1_240) AT=960.05n

.meas tran vdout1_241ck950 FIND v(dout1_241) AT=960.05n

.meas tran vdout1_242ck950 FIND v(dout1_242) AT=960.05n

.meas tran vdout1_243ck950 FIND v(dout1_243) AT=960.05n

.meas tran vdout1_244ck950 FIND v(dout1_244) AT=960.05n

.meas tran vdout1_245ck950 FIND v(dout1_245) AT=960.05n

.meas tran vdout1_246ck950 FIND v(dout1_246) AT=960.05n

.meas tran vdout1_247ck950 FIND v(dout1_247) AT=960.05n

.meas tran vdout1_248ck950 FIND v(dout1_248) AT=960.05n

.meas tran vdout1_249ck950 FIND v(dout1_249) AT=960.05n

.meas tran vdout1_250ck950 FIND v(dout1_250) AT=960.05n

.meas tran vdout1_251ck950 FIND v(dout1_251) AT=960.05n

.meas tran vdout1_252ck950 FIND v(dout1_252) AT=960.05n

.meas tran vdout1_253ck950 FIND v(dout1_253) AT=960.05n

.meas tran vdout1_254ck950 FIND v(dout1_254) AT=960.05n

.meas tran vdout1_255ck950 FIND v(dout1_255) AT=960.05n

.meas tran vdout1_256ck950 FIND v(dout1_256) AT=960.05n

.meas tran vdout1_0ck970 FIND v(dout1_0) AT=980.05n

.meas tran vdout1_1ck970 FIND v(dout1_1) AT=980.05n

.meas tran vdout1_2ck970 FIND v(dout1_2) AT=980.05n

.meas tran vdout1_3ck970 FIND v(dout1_3) AT=980.05n

.meas tran vdout1_4ck970 FIND v(dout1_4) AT=980.05n

.meas tran vdout1_5ck970 FIND v(dout1_5) AT=980.05n

.meas tran vdout1_6ck970 FIND v(dout1_6) AT=980.05n

.meas tran vdout1_7ck970 FIND v(dout1_7) AT=980.05n

.meas tran vdout1_8ck970 FIND v(dout1_8) AT=980.05n

.meas tran vdout1_9ck970 FIND v(dout1_9) AT=980.05n

.meas tran vdout1_10ck970 FIND v(dout1_10) AT=980.05n

.meas tran vdout1_11ck970 FIND v(dout1_11) AT=980.05n

.meas tran vdout1_12ck970 FIND v(dout1_12) AT=980.05n

.meas tran vdout1_13ck970 FIND v(dout1_13) AT=980.05n

.meas tran vdout1_14ck970 FIND v(dout1_14) AT=980.05n

.meas tran vdout1_15ck970 FIND v(dout1_15) AT=980.05n

.meas tran vdout1_16ck970 FIND v(dout1_16) AT=980.05n

.meas tran vdout1_17ck970 FIND v(dout1_17) AT=980.05n

.meas tran vdout1_18ck970 FIND v(dout1_18) AT=980.05n

.meas tran vdout1_19ck970 FIND v(dout1_19) AT=980.05n

.meas tran vdout1_20ck970 FIND v(dout1_20) AT=980.05n

.meas tran vdout1_21ck970 FIND v(dout1_21) AT=980.05n

.meas tran vdout1_22ck970 FIND v(dout1_22) AT=980.05n

.meas tran vdout1_23ck970 FIND v(dout1_23) AT=980.05n

.meas tran vdout1_24ck970 FIND v(dout1_24) AT=980.05n

.meas tran vdout1_25ck970 FIND v(dout1_25) AT=980.05n

.meas tran vdout1_26ck970 FIND v(dout1_26) AT=980.05n

.meas tran vdout1_27ck970 FIND v(dout1_27) AT=980.05n

.meas tran vdout1_28ck970 FIND v(dout1_28) AT=980.05n

.meas tran vdout1_29ck970 FIND v(dout1_29) AT=980.05n

.meas tran vdout1_30ck970 FIND v(dout1_30) AT=980.05n

.meas tran vdout1_31ck970 FIND v(dout1_31) AT=980.05n

.meas tran vdout1_32ck970 FIND v(dout1_32) AT=980.05n

.meas tran vdout1_33ck970 FIND v(dout1_33) AT=980.05n

.meas tran vdout1_34ck970 FIND v(dout1_34) AT=980.05n

.meas tran vdout1_35ck970 FIND v(dout1_35) AT=980.05n

.meas tran vdout1_36ck970 FIND v(dout1_36) AT=980.05n

.meas tran vdout1_37ck970 FIND v(dout1_37) AT=980.05n

.meas tran vdout1_38ck970 FIND v(dout1_38) AT=980.05n

.meas tran vdout1_39ck970 FIND v(dout1_39) AT=980.05n

.meas tran vdout1_40ck970 FIND v(dout1_40) AT=980.05n

.meas tran vdout1_41ck970 FIND v(dout1_41) AT=980.05n

.meas tran vdout1_42ck970 FIND v(dout1_42) AT=980.05n

.meas tran vdout1_43ck970 FIND v(dout1_43) AT=980.05n

.meas tran vdout1_44ck970 FIND v(dout1_44) AT=980.05n

.meas tran vdout1_45ck970 FIND v(dout1_45) AT=980.05n

.meas tran vdout1_46ck970 FIND v(dout1_46) AT=980.05n

.meas tran vdout1_47ck970 FIND v(dout1_47) AT=980.05n

.meas tran vdout1_48ck970 FIND v(dout1_48) AT=980.05n

.meas tran vdout1_49ck970 FIND v(dout1_49) AT=980.05n

.meas tran vdout1_50ck970 FIND v(dout1_50) AT=980.05n

.meas tran vdout1_51ck970 FIND v(dout1_51) AT=980.05n

.meas tran vdout1_52ck970 FIND v(dout1_52) AT=980.05n

.meas tran vdout1_53ck970 FIND v(dout1_53) AT=980.05n

.meas tran vdout1_54ck970 FIND v(dout1_54) AT=980.05n

.meas tran vdout1_55ck970 FIND v(dout1_55) AT=980.05n

.meas tran vdout1_56ck970 FIND v(dout1_56) AT=980.05n

.meas tran vdout1_57ck970 FIND v(dout1_57) AT=980.05n

.meas tran vdout1_58ck970 FIND v(dout1_58) AT=980.05n

.meas tran vdout1_59ck970 FIND v(dout1_59) AT=980.05n

.meas tran vdout1_60ck970 FIND v(dout1_60) AT=980.05n

.meas tran vdout1_61ck970 FIND v(dout1_61) AT=980.05n

.meas tran vdout1_62ck970 FIND v(dout1_62) AT=980.05n

.meas tran vdout1_63ck970 FIND v(dout1_63) AT=980.05n

.meas tran vdout1_64ck970 FIND v(dout1_64) AT=980.05n

.meas tran vdout1_65ck970 FIND v(dout1_65) AT=980.05n

.meas tran vdout1_66ck970 FIND v(dout1_66) AT=980.05n

.meas tran vdout1_67ck970 FIND v(dout1_67) AT=980.05n

.meas tran vdout1_68ck970 FIND v(dout1_68) AT=980.05n

.meas tran vdout1_69ck970 FIND v(dout1_69) AT=980.05n

.meas tran vdout1_70ck970 FIND v(dout1_70) AT=980.05n

.meas tran vdout1_71ck970 FIND v(dout1_71) AT=980.05n

.meas tran vdout1_72ck970 FIND v(dout1_72) AT=980.05n

.meas tran vdout1_73ck970 FIND v(dout1_73) AT=980.05n

.meas tran vdout1_74ck970 FIND v(dout1_74) AT=980.05n

.meas tran vdout1_75ck970 FIND v(dout1_75) AT=980.05n

.meas tran vdout1_76ck970 FIND v(dout1_76) AT=980.05n

.meas tran vdout1_77ck970 FIND v(dout1_77) AT=980.05n

.meas tran vdout1_78ck970 FIND v(dout1_78) AT=980.05n

.meas tran vdout1_79ck970 FIND v(dout1_79) AT=980.05n

.meas tran vdout1_80ck970 FIND v(dout1_80) AT=980.05n

.meas tran vdout1_81ck970 FIND v(dout1_81) AT=980.05n

.meas tran vdout1_82ck970 FIND v(dout1_82) AT=980.05n

.meas tran vdout1_83ck970 FIND v(dout1_83) AT=980.05n

.meas tran vdout1_84ck970 FIND v(dout1_84) AT=980.05n

.meas tran vdout1_85ck970 FIND v(dout1_85) AT=980.05n

.meas tran vdout1_86ck970 FIND v(dout1_86) AT=980.05n

.meas tran vdout1_87ck970 FIND v(dout1_87) AT=980.05n

.meas tran vdout1_88ck970 FIND v(dout1_88) AT=980.05n

.meas tran vdout1_89ck970 FIND v(dout1_89) AT=980.05n

.meas tran vdout1_90ck970 FIND v(dout1_90) AT=980.05n

.meas tran vdout1_91ck970 FIND v(dout1_91) AT=980.05n

.meas tran vdout1_92ck970 FIND v(dout1_92) AT=980.05n

.meas tran vdout1_93ck970 FIND v(dout1_93) AT=980.05n

.meas tran vdout1_94ck970 FIND v(dout1_94) AT=980.05n

.meas tran vdout1_95ck970 FIND v(dout1_95) AT=980.05n

.meas tran vdout1_96ck970 FIND v(dout1_96) AT=980.05n

.meas tran vdout1_97ck970 FIND v(dout1_97) AT=980.05n

.meas tran vdout1_98ck970 FIND v(dout1_98) AT=980.05n

.meas tran vdout1_99ck970 FIND v(dout1_99) AT=980.05n

.meas tran vdout1_100ck970 FIND v(dout1_100) AT=980.05n

.meas tran vdout1_101ck970 FIND v(dout1_101) AT=980.05n

.meas tran vdout1_102ck970 FIND v(dout1_102) AT=980.05n

.meas tran vdout1_103ck970 FIND v(dout1_103) AT=980.05n

.meas tran vdout1_104ck970 FIND v(dout1_104) AT=980.05n

.meas tran vdout1_105ck970 FIND v(dout1_105) AT=980.05n

.meas tran vdout1_106ck970 FIND v(dout1_106) AT=980.05n

.meas tran vdout1_107ck970 FIND v(dout1_107) AT=980.05n

.meas tran vdout1_108ck970 FIND v(dout1_108) AT=980.05n

.meas tran vdout1_109ck970 FIND v(dout1_109) AT=980.05n

.meas tran vdout1_110ck970 FIND v(dout1_110) AT=980.05n

.meas tran vdout1_111ck970 FIND v(dout1_111) AT=980.05n

.meas tran vdout1_112ck970 FIND v(dout1_112) AT=980.05n

.meas tran vdout1_113ck970 FIND v(dout1_113) AT=980.05n

.meas tran vdout1_114ck970 FIND v(dout1_114) AT=980.05n

.meas tran vdout1_115ck970 FIND v(dout1_115) AT=980.05n

.meas tran vdout1_116ck970 FIND v(dout1_116) AT=980.05n

.meas tran vdout1_117ck970 FIND v(dout1_117) AT=980.05n

.meas tran vdout1_118ck970 FIND v(dout1_118) AT=980.05n

.meas tran vdout1_119ck970 FIND v(dout1_119) AT=980.05n

.meas tran vdout1_120ck970 FIND v(dout1_120) AT=980.05n

.meas tran vdout1_121ck970 FIND v(dout1_121) AT=980.05n

.meas tran vdout1_122ck970 FIND v(dout1_122) AT=980.05n

.meas tran vdout1_123ck970 FIND v(dout1_123) AT=980.05n

.meas tran vdout1_124ck970 FIND v(dout1_124) AT=980.05n

.meas tran vdout1_125ck970 FIND v(dout1_125) AT=980.05n

.meas tran vdout1_126ck970 FIND v(dout1_126) AT=980.05n

.meas tran vdout1_127ck970 FIND v(dout1_127) AT=980.05n

.meas tran vdout1_128ck970 FIND v(dout1_128) AT=980.05n

.meas tran vdout1_129ck970 FIND v(dout1_129) AT=980.05n

.meas tran vdout1_130ck970 FIND v(dout1_130) AT=980.05n

.meas tran vdout1_131ck970 FIND v(dout1_131) AT=980.05n

.meas tran vdout1_132ck970 FIND v(dout1_132) AT=980.05n

.meas tran vdout1_133ck970 FIND v(dout1_133) AT=980.05n

.meas tran vdout1_134ck970 FIND v(dout1_134) AT=980.05n

.meas tran vdout1_135ck970 FIND v(dout1_135) AT=980.05n

.meas tran vdout1_136ck970 FIND v(dout1_136) AT=980.05n

.meas tran vdout1_137ck970 FIND v(dout1_137) AT=980.05n

.meas tran vdout1_138ck970 FIND v(dout1_138) AT=980.05n

.meas tran vdout1_139ck970 FIND v(dout1_139) AT=980.05n

.meas tran vdout1_140ck970 FIND v(dout1_140) AT=980.05n

.meas tran vdout1_141ck970 FIND v(dout1_141) AT=980.05n

.meas tran vdout1_142ck970 FIND v(dout1_142) AT=980.05n

.meas tran vdout1_143ck970 FIND v(dout1_143) AT=980.05n

.meas tran vdout1_144ck970 FIND v(dout1_144) AT=980.05n

.meas tran vdout1_145ck970 FIND v(dout1_145) AT=980.05n

.meas tran vdout1_146ck970 FIND v(dout1_146) AT=980.05n

.meas tran vdout1_147ck970 FIND v(dout1_147) AT=980.05n

.meas tran vdout1_148ck970 FIND v(dout1_148) AT=980.05n

.meas tran vdout1_149ck970 FIND v(dout1_149) AT=980.05n

.meas tran vdout1_150ck970 FIND v(dout1_150) AT=980.05n

.meas tran vdout1_151ck970 FIND v(dout1_151) AT=980.05n

.meas tran vdout1_152ck970 FIND v(dout1_152) AT=980.05n

.meas tran vdout1_153ck970 FIND v(dout1_153) AT=980.05n

.meas tran vdout1_154ck970 FIND v(dout1_154) AT=980.05n

.meas tran vdout1_155ck970 FIND v(dout1_155) AT=980.05n

.meas tran vdout1_156ck970 FIND v(dout1_156) AT=980.05n

.meas tran vdout1_157ck970 FIND v(dout1_157) AT=980.05n

.meas tran vdout1_158ck970 FIND v(dout1_158) AT=980.05n

.meas tran vdout1_159ck970 FIND v(dout1_159) AT=980.05n

.meas tran vdout1_160ck970 FIND v(dout1_160) AT=980.05n

.meas tran vdout1_161ck970 FIND v(dout1_161) AT=980.05n

.meas tran vdout1_162ck970 FIND v(dout1_162) AT=980.05n

.meas tran vdout1_163ck970 FIND v(dout1_163) AT=980.05n

.meas tran vdout1_164ck970 FIND v(dout1_164) AT=980.05n

.meas tran vdout1_165ck970 FIND v(dout1_165) AT=980.05n

.meas tran vdout1_166ck970 FIND v(dout1_166) AT=980.05n

.meas tran vdout1_167ck970 FIND v(dout1_167) AT=980.05n

.meas tran vdout1_168ck970 FIND v(dout1_168) AT=980.05n

.meas tran vdout1_169ck970 FIND v(dout1_169) AT=980.05n

.meas tran vdout1_170ck970 FIND v(dout1_170) AT=980.05n

.meas tran vdout1_171ck970 FIND v(dout1_171) AT=980.05n

.meas tran vdout1_172ck970 FIND v(dout1_172) AT=980.05n

.meas tran vdout1_173ck970 FIND v(dout1_173) AT=980.05n

.meas tran vdout1_174ck970 FIND v(dout1_174) AT=980.05n

.meas tran vdout1_175ck970 FIND v(dout1_175) AT=980.05n

.meas tran vdout1_176ck970 FIND v(dout1_176) AT=980.05n

.meas tran vdout1_177ck970 FIND v(dout1_177) AT=980.05n

.meas tran vdout1_178ck970 FIND v(dout1_178) AT=980.05n

.meas tran vdout1_179ck970 FIND v(dout1_179) AT=980.05n

.meas tran vdout1_180ck970 FIND v(dout1_180) AT=980.05n

.meas tran vdout1_181ck970 FIND v(dout1_181) AT=980.05n

.meas tran vdout1_182ck970 FIND v(dout1_182) AT=980.05n

.meas tran vdout1_183ck970 FIND v(dout1_183) AT=980.05n

.meas tran vdout1_184ck970 FIND v(dout1_184) AT=980.05n

.meas tran vdout1_185ck970 FIND v(dout1_185) AT=980.05n

.meas tran vdout1_186ck970 FIND v(dout1_186) AT=980.05n

.meas tran vdout1_187ck970 FIND v(dout1_187) AT=980.05n

.meas tran vdout1_188ck970 FIND v(dout1_188) AT=980.05n

.meas tran vdout1_189ck970 FIND v(dout1_189) AT=980.05n

.meas tran vdout1_190ck970 FIND v(dout1_190) AT=980.05n

.meas tran vdout1_191ck970 FIND v(dout1_191) AT=980.05n

.meas tran vdout1_192ck970 FIND v(dout1_192) AT=980.05n

.meas tran vdout1_193ck970 FIND v(dout1_193) AT=980.05n

.meas tran vdout1_194ck970 FIND v(dout1_194) AT=980.05n

.meas tran vdout1_195ck970 FIND v(dout1_195) AT=980.05n

.meas tran vdout1_196ck970 FIND v(dout1_196) AT=980.05n

.meas tran vdout1_197ck970 FIND v(dout1_197) AT=980.05n

.meas tran vdout1_198ck970 FIND v(dout1_198) AT=980.05n

.meas tran vdout1_199ck970 FIND v(dout1_199) AT=980.05n

.meas tran vdout1_200ck970 FIND v(dout1_200) AT=980.05n

.meas tran vdout1_201ck970 FIND v(dout1_201) AT=980.05n

.meas tran vdout1_202ck970 FIND v(dout1_202) AT=980.05n

.meas tran vdout1_203ck970 FIND v(dout1_203) AT=980.05n

.meas tran vdout1_204ck970 FIND v(dout1_204) AT=980.05n

.meas tran vdout1_205ck970 FIND v(dout1_205) AT=980.05n

.meas tran vdout1_206ck970 FIND v(dout1_206) AT=980.05n

.meas tran vdout1_207ck970 FIND v(dout1_207) AT=980.05n

.meas tran vdout1_208ck970 FIND v(dout1_208) AT=980.05n

.meas tran vdout1_209ck970 FIND v(dout1_209) AT=980.05n

.meas tran vdout1_210ck970 FIND v(dout1_210) AT=980.05n

.meas tran vdout1_211ck970 FIND v(dout1_211) AT=980.05n

.meas tran vdout1_212ck970 FIND v(dout1_212) AT=980.05n

.meas tran vdout1_213ck970 FIND v(dout1_213) AT=980.05n

.meas tran vdout1_214ck970 FIND v(dout1_214) AT=980.05n

.meas tran vdout1_215ck970 FIND v(dout1_215) AT=980.05n

.meas tran vdout1_216ck970 FIND v(dout1_216) AT=980.05n

.meas tran vdout1_217ck970 FIND v(dout1_217) AT=980.05n

.meas tran vdout1_218ck970 FIND v(dout1_218) AT=980.05n

.meas tran vdout1_219ck970 FIND v(dout1_219) AT=980.05n

.meas tran vdout1_220ck970 FIND v(dout1_220) AT=980.05n

.meas tran vdout1_221ck970 FIND v(dout1_221) AT=980.05n

.meas tran vdout1_222ck970 FIND v(dout1_222) AT=980.05n

.meas tran vdout1_223ck970 FIND v(dout1_223) AT=980.05n

.meas tran vdout1_224ck970 FIND v(dout1_224) AT=980.05n

.meas tran vdout1_225ck970 FIND v(dout1_225) AT=980.05n

.meas tran vdout1_226ck970 FIND v(dout1_226) AT=980.05n

.meas tran vdout1_227ck970 FIND v(dout1_227) AT=980.05n

.meas tran vdout1_228ck970 FIND v(dout1_228) AT=980.05n

.meas tran vdout1_229ck970 FIND v(dout1_229) AT=980.05n

.meas tran vdout1_230ck970 FIND v(dout1_230) AT=980.05n

.meas tran vdout1_231ck970 FIND v(dout1_231) AT=980.05n

.meas tran vdout1_232ck970 FIND v(dout1_232) AT=980.05n

.meas tran vdout1_233ck970 FIND v(dout1_233) AT=980.05n

.meas tran vdout1_234ck970 FIND v(dout1_234) AT=980.05n

.meas tran vdout1_235ck970 FIND v(dout1_235) AT=980.05n

.meas tran vdout1_236ck970 FIND v(dout1_236) AT=980.05n

.meas tran vdout1_237ck970 FIND v(dout1_237) AT=980.05n

.meas tran vdout1_238ck970 FIND v(dout1_238) AT=980.05n

.meas tran vdout1_239ck970 FIND v(dout1_239) AT=980.05n

.meas tran vdout1_240ck970 FIND v(dout1_240) AT=980.05n

.meas tran vdout1_241ck970 FIND v(dout1_241) AT=980.05n

.meas tran vdout1_242ck970 FIND v(dout1_242) AT=980.05n

.meas tran vdout1_243ck970 FIND v(dout1_243) AT=980.05n

.meas tran vdout1_244ck970 FIND v(dout1_244) AT=980.05n

.meas tran vdout1_245ck970 FIND v(dout1_245) AT=980.05n

.meas tran vdout1_246ck970 FIND v(dout1_246) AT=980.05n

.meas tran vdout1_247ck970 FIND v(dout1_247) AT=980.05n

.meas tran vdout1_248ck970 FIND v(dout1_248) AT=980.05n

.meas tran vdout1_249ck970 FIND v(dout1_249) AT=980.05n

.meas tran vdout1_250ck970 FIND v(dout1_250) AT=980.05n

.meas tran vdout1_251ck970 FIND v(dout1_251) AT=980.05n

.meas tran vdout1_252ck970 FIND v(dout1_252) AT=980.05n

.meas tran vdout1_253ck970 FIND v(dout1_253) AT=980.05n

.meas tran vdout1_254ck970 FIND v(dout1_254) AT=980.05n

.meas tran vdout1_255ck970 FIND v(dout1_255) AT=980.05n

.meas tran vdout1_256ck970 FIND v(dout1_256) AT=980.05n

.meas tran vdout1_0ck980 FIND v(dout1_0) AT=990.05n

.meas tran vdout1_1ck980 FIND v(dout1_1) AT=990.05n

.meas tran vdout1_2ck980 FIND v(dout1_2) AT=990.05n

.meas tran vdout1_3ck980 FIND v(dout1_3) AT=990.05n

.meas tran vdout1_4ck980 FIND v(dout1_4) AT=990.05n

.meas tran vdout1_5ck980 FIND v(dout1_5) AT=990.05n

.meas tran vdout1_6ck980 FIND v(dout1_6) AT=990.05n

.meas tran vdout1_7ck980 FIND v(dout1_7) AT=990.05n

.meas tran vdout1_8ck980 FIND v(dout1_8) AT=990.05n

.meas tran vdout1_9ck980 FIND v(dout1_9) AT=990.05n

.meas tran vdout1_10ck980 FIND v(dout1_10) AT=990.05n

.meas tran vdout1_11ck980 FIND v(dout1_11) AT=990.05n

.meas tran vdout1_12ck980 FIND v(dout1_12) AT=990.05n

.meas tran vdout1_13ck980 FIND v(dout1_13) AT=990.05n

.meas tran vdout1_14ck980 FIND v(dout1_14) AT=990.05n

.meas tran vdout1_15ck980 FIND v(dout1_15) AT=990.05n

.meas tran vdout1_16ck980 FIND v(dout1_16) AT=990.05n

.meas tran vdout1_17ck980 FIND v(dout1_17) AT=990.05n

.meas tran vdout1_18ck980 FIND v(dout1_18) AT=990.05n

.meas tran vdout1_19ck980 FIND v(dout1_19) AT=990.05n

.meas tran vdout1_20ck980 FIND v(dout1_20) AT=990.05n

.meas tran vdout1_21ck980 FIND v(dout1_21) AT=990.05n

.meas tran vdout1_22ck980 FIND v(dout1_22) AT=990.05n

.meas tran vdout1_23ck980 FIND v(dout1_23) AT=990.05n

.meas tran vdout1_24ck980 FIND v(dout1_24) AT=990.05n

.meas tran vdout1_25ck980 FIND v(dout1_25) AT=990.05n

.meas tran vdout1_26ck980 FIND v(dout1_26) AT=990.05n

.meas tran vdout1_27ck980 FIND v(dout1_27) AT=990.05n

.meas tran vdout1_28ck980 FIND v(dout1_28) AT=990.05n

.meas tran vdout1_29ck980 FIND v(dout1_29) AT=990.05n

.meas tran vdout1_30ck980 FIND v(dout1_30) AT=990.05n

.meas tran vdout1_31ck980 FIND v(dout1_31) AT=990.05n

.meas tran vdout1_32ck980 FIND v(dout1_32) AT=990.05n

.meas tran vdout1_33ck980 FIND v(dout1_33) AT=990.05n

.meas tran vdout1_34ck980 FIND v(dout1_34) AT=990.05n

.meas tran vdout1_35ck980 FIND v(dout1_35) AT=990.05n

.meas tran vdout1_36ck980 FIND v(dout1_36) AT=990.05n

.meas tran vdout1_37ck980 FIND v(dout1_37) AT=990.05n

.meas tran vdout1_38ck980 FIND v(dout1_38) AT=990.05n

.meas tran vdout1_39ck980 FIND v(dout1_39) AT=990.05n

.meas tran vdout1_40ck980 FIND v(dout1_40) AT=990.05n

.meas tran vdout1_41ck980 FIND v(dout1_41) AT=990.05n

.meas tran vdout1_42ck980 FIND v(dout1_42) AT=990.05n

.meas tran vdout1_43ck980 FIND v(dout1_43) AT=990.05n

.meas tran vdout1_44ck980 FIND v(dout1_44) AT=990.05n

.meas tran vdout1_45ck980 FIND v(dout1_45) AT=990.05n

.meas tran vdout1_46ck980 FIND v(dout1_46) AT=990.05n

.meas tran vdout1_47ck980 FIND v(dout1_47) AT=990.05n

.meas tran vdout1_48ck980 FIND v(dout1_48) AT=990.05n

.meas tran vdout1_49ck980 FIND v(dout1_49) AT=990.05n

.meas tran vdout1_50ck980 FIND v(dout1_50) AT=990.05n

.meas tran vdout1_51ck980 FIND v(dout1_51) AT=990.05n

.meas tran vdout1_52ck980 FIND v(dout1_52) AT=990.05n

.meas tran vdout1_53ck980 FIND v(dout1_53) AT=990.05n

.meas tran vdout1_54ck980 FIND v(dout1_54) AT=990.05n

.meas tran vdout1_55ck980 FIND v(dout1_55) AT=990.05n

.meas tran vdout1_56ck980 FIND v(dout1_56) AT=990.05n

.meas tran vdout1_57ck980 FIND v(dout1_57) AT=990.05n

.meas tran vdout1_58ck980 FIND v(dout1_58) AT=990.05n

.meas tran vdout1_59ck980 FIND v(dout1_59) AT=990.05n

.meas tran vdout1_60ck980 FIND v(dout1_60) AT=990.05n

.meas tran vdout1_61ck980 FIND v(dout1_61) AT=990.05n

.meas tran vdout1_62ck980 FIND v(dout1_62) AT=990.05n

.meas tran vdout1_63ck980 FIND v(dout1_63) AT=990.05n

.meas tran vdout1_64ck980 FIND v(dout1_64) AT=990.05n

.meas tran vdout1_65ck980 FIND v(dout1_65) AT=990.05n

.meas tran vdout1_66ck980 FIND v(dout1_66) AT=990.05n

.meas tran vdout1_67ck980 FIND v(dout1_67) AT=990.05n

.meas tran vdout1_68ck980 FIND v(dout1_68) AT=990.05n

.meas tran vdout1_69ck980 FIND v(dout1_69) AT=990.05n

.meas tran vdout1_70ck980 FIND v(dout1_70) AT=990.05n

.meas tran vdout1_71ck980 FIND v(dout1_71) AT=990.05n

.meas tran vdout1_72ck980 FIND v(dout1_72) AT=990.05n

.meas tran vdout1_73ck980 FIND v(dout1_73) AT=990.05n

.meas tran vdout1_74ck980 FIND v(dout1_74) AT=990.05n

.meas tran vdout1_75ck980 FIND v(dout1_75) AT=990.05n

.meas tran vdout1_76ck980 FIND v(dout1_76) AT=990.05n

.meas tran vdout1_77ck980 FIND v(dout1_77) AT=990.05n

.meas tran vdout1_78ck980 FIND v(dout1_78) AT=990.05n

.meas tran vdout1_79ck980 FIND v(dout1_79) AT=990.05n

.meas tran vdout1_80ck980 FIND v(dout1_80) AT=990.05n

.meas tran vdout1_81ck980 FIND v(dout1_81) AT=990.05n

.meas tran vdout1_82ck980 FIND v(dout1_82) AT=990.05n

.meas tran vdout1_83ck980 FIND v(dout1_83) AT=990.05n

.meas tran vdout1_84ck980 FIND v(dout1_84) AT=990.05n

.meas tran vdout1_85ck980 FIND v(dout1_85) AT=990.05n

.meas tran vdout1_86ck980 FIND v(dout1_86) AT=990.05n

.meas tran vdout1_87ck980 FIND v(dout1_87) AT=990.05n

.meas tran vdout1_88ck980 FIND v(dout1_88) AT=990.05n

.meas tran vdout1_89ck980 FIND v(dout1_89) AT=990.05n

.meas tran vdout1_90ck980 FIND v(dout1_90) AT=990.05n

.meas tran vdout1_91ck980 FIND v(dout1_91) AT=990.05n

.meas tran vdout1_92ck980 FIND v(dout1_92) AT=990.05n

.meas tran vdout1_93ck980 FIND v(dout1_93) AT=990.05n

.meas tran vdout1_94ck980 FIND v(dout1_94) AT=990.05n

.meas tran vdout1_95ck980 FIND v(dout1_95) AT=990.05n

.meas tran vdout1_96ck980 FIND v(dout1_96) AT=990.05n

.meas tran vdout1_97ck980 FIND v(dout1_97) AT=990.05n

.meas tran vdout1_98ck980 FIND v(dout1_98) AT=990.05n

.meas tran vdout1_99ck980 FIND v(dout1_99) AT=990.05n

.meas tran vdout1_100ck980 FIND v(dout1_100) AT=990.05n

.meas tran vdout1_101ck980 FIND v(dout1_101) AT=990.05n

.meas tran vdout1_102ck980 FIND v(dout1_102) AT=990.05n

.meas tran vdout1_103ck980 FIND v(dout1_103) AT=990.05n

.meas tran vdout1_104ck980 FIND v(dout1_104) AT=990.05n

.meas tran vdout1_105ck980 FIND v(dout1_105) AT=990.05n

.meas tran vdout1_106ck980 FIND v(dout1_106) AT=990.05n

.meas tran vdout1_107ck980 FIND v(dout1_107) AT=990.05n

.meas tran vdout1_108ck980 FIND v(dout1_108) AT=990.05n

.meas tran vdout1_109ck980 FIND v(dout1_109) AT=990.05n

.meas tran vdout1_110ck980 FIND v(dout1_110) AT=990.05n

.meas tran vdout1_111ck980 FIND v(dout1_111) AT=990.05n

.meas tran vdout1_112ck980 FIND v(dout1_112) AT=990.05n

.meas tran vdout1_113ck980 FIND v(dout1_113) AT=990.05n

.meas tran vdout1_114ck980 FIND v(dout1_114) AT=990.05n

.meas tran vdout1_115ck980 FIND v(dout1_115) AT=990.05n

.meas tran vdout1_116ck980 FIND v(dout1_116) AT=990.05n

.meas tran vdout1_117ck980 FIND v(dout1_117) AT=990.05n

.meas tran vdout1_118ck980 FIND v(dout1_118) AT=990.05n

.meas tran vdout1_119ck980 FIND v(dout1_119) AT=990.05n

.meas tran vdout1_120ck980 FIND v(dout1_120) AT=990.05n

.meas tran vdout1_121ck980 FIND v(dout1_121) AT=990.05n

.meas tran vdout1_122ck980 FIND v(dout1_122) AT=990.05n

.meas tran vdout1_123ck980 FIND v(dout1_123) AT=990.05n

.meas tran vdout1_124ck980 FIND v(dout1_124) AT=990.05n

.meas tran vdout1_125ck980 FIND v(dout1_125) AT=990.05n

.meas tran vdout1_126ck980 FIND v(dout1_126) AT=990.05n

.meas tran vdout1_127ck980 FIND v(dout1_127) AT=990.05n

.meas tran vdout1_128ck980 FIND v(dout1_128) AT=990.05n

.meas tran vdout1_129ck980 FIND v(dout1_129) AT=990.05n

.meas tran vdout1_130ck980 FIND v(dout1_130) AT=990.05n

.meas tran vdout1_131ck980 FIND v(dout1_131) AT=990.05n

.meas tran vdout1_132ck980 FIND v(dout1_132) AT=990.05n

.meas tran vdout1_133ck980 FIND v(dout1_133) AT=990.05n

.meas tran vdout1_134ck980 FIND v(dout1_134) AT=990.05n

.meas tran vdout1_135ck980 FIND v(dout1_135) AT=990.05n

.meas tran vdout1_136ck980 FIND v(dout1_136) AT=990.05n

.meas tran vdout1_137ck980 FIND v(dout1_137) AT=990.05n

.meas tran vdout1_138ck980 FIND v(dout1_138) AT=990.05n

.meas tran vdout1_139ck980 FIND v(dout1_139) AT=990.05n

.meas tran vdout1_140ck980 FIND v(dout1_140) AT=990.05n

.meas tran vdout1_141ck980 FIND v(dout1_141) AT=990.05n

.meas tran vdout1_142ck980 FIND v(dout1_142) AT=990.05n

.meas tran vdout1_143ck980 FIND v(dout1_143) AT=990.05n

.meas tran vdout1_144ck980 FIND v(dout1_144) AT=990.05n

.meas tran vdout1_145ck980 FIND v(dout1_145) AT=990.05n

.meas tran vdout1_146ck980 FIND v(dout1_146) AT=990.05n

.meas tran vdout1_147ck980 FIND v(dout1_147) AT=990.05n

.meas tran vdout1_148ck980 FIND v(dout1_148) AT=990.05n

.meas tran vdout1_149ck980 FIND v(dout1_149) AT=990.05n

.meas tran vdout1_150ck980 FIND v(dout1_150) AT=990.05n

.meas tran vdout1_151ck980 FIND v(dout1_151) AT=990.05n

.meas tran vdout1_152ck980 FIND v(dout1_152) AT=990.05n

.meas tran vdout1_153ck980 FIND v(dout1_153) AT=990.05n

.meas tran vdout1_154ck980 FIND v(dout1_154) AT=990.05n

.meas tran vdout1_155ck980 FIND v(dout1_155) AT=990.05n

.meas tran vdout1_156ck980 FIND v(dout1_156) AT=990.05n

.meas tran vdout1_157ck980 FIND v(dout1_157) AT=990.05n

.meas tran vdout1_158ck980 FIND v(dout1_158) AT=990.05n

.meas tran vdout1_159ck980 FIND v(dout1_159) AT=990.05n

.meas tran vdout1_160ck980 FIND v(dout1_160) AT=990.05n

.meas tran vdout1_161ck980 FIND v(dout1_161) AT=990.05n

.meas tran vdout1_162ck980 FIND v(dout1_162) AT=990.05n

.meas tran vdout1_163ck980 FIND v(dout1_163) AT=990.05n

.meas tran vdout1_164ck980 FIND v(dout1_164) AT=990.05n

.meas tran vdout1_165ck980 FIND v(dout1_165) AT=990.05n

.meas tran vdout1_166ck980 FIND v(dout1_166) AT=990.05n

.meas tran vdout1_167ck980 FIND v(dout1_167) AT=990.05n

.meas tran vdout1_168ck980 FIND v(dout1_168) AT=990.05n

.meas tran vdout1_169ck980 FIND v(dout1_169) AT=990.05n

.meas tran vdout1_170ck980 FIND v(dout1_170) AT=990.05n

.meas tran vdout1_171ck980 FIND v(dout1_171) AT=990.05n

.meas tran vdout1_172ck980 FIND v(dout1_172) AT=990.05n

.meas tran vdout1_173ck980 FIND v(dout1_173) AT=990.05n

.meas tran vdout1_174ck980 FIND v(dout1_174) AT=990.05n

.meas tran vdout1_175ck980 FIND v(dout1_175) AT=990.05n

.meas tran vdout1_176ck980 FIND v(dout1_176) AT=990.05n

.meas tran vdout1_177ck980 FIND v(dout1_177) AT=990.05n

.meas tran vdout1_178ck980 FIND v(dout1_178) AT=990.05n

.meas tran vdout1_179ck980 FIND v(dout1_179) AT=990.05n

.meas tran vdout1_180ck980 FIND v(dout1_180) AT=990.05n

.meas tran vdout1_181ck980 FIND v(dout1_181) AT=990.05n

.meas tran vdout1_182ck980 FIND v(dout1_182) AT=990.05n

.meas tran vdout1_183ck980 FIND v(dout1_183) AT=990.05n

.meas tran vdout1_184ck980 FIND v(dout1_184) AT=990.05n

.meas tran vdout1_185ck980 FIND v(dout1_185) AT=990.05n

.meas tran vdout1_186ck980 FIND v(dout1_186) AT=990.05n

.meas tran vdout1_187ck980 FIND v(dout1_187) AT=990.05n

.meas tran vdout1_188ck980 FIND v(dout1_188) AT=990.05n

.meas tran vdout1_189ck980 FIND v(dout1_189) AT=990.05n

.meas tran vdout1_190ck980 FIND v(dout1_190) AT=990.05n

.meas tran vdout1_191ck980 FIND v(dout1_191) AT=990.05n

.meas tran vdout1_192ck980 FIND v(dout1_192) AT=990.05n

.meas tran vdout1_193ck980 FIND v(dout1_193) AT=990.05n

.meas tran vdout1_194ck980 FIND v(dout1_194) AT=990.05n

.meas tran vdout1_195ck980 FIND v(dout1_195) AT=990.05n

.meas tran vdout1_196ck980 FIND v(dout1_196) AT=990.05n

.meas tran vdout1_197ck980 FIND v(dout1_197) AT=990.05n

.meas tran vdout1_198ck980 FIND v(dout1_198) AT=990.05n

.meas tran vdout1_199ck980 FIND v(dout1_199) AT=990.05n

.meas tran vdout1_200ck980 FIND v(dout1_200) AT=990.05n

.meas tran vdout1_201ck980 FIND v(dout1_201) AT=990.05n

.meas tran vdout1_202ck980 FIND v(dout1_202) AT=990.05n

.meas tran vdout1_203ck980 FIND v(dout1_203) AT=990.05n

.meas tran vdout1_204ck980 FIND v(dout1_204) AT=990.05n

.meas tran vdout1_205ck980 FIND v(dout1_205) AT=990.05n

.meas tran vdout1_206ck980 FIND v(dout1_206) AT=990.05n

.meas tran vdout1_207ck980 FIND v(dout1_207) AT=990.05n

.meas tran vdout1_208ck980 FIND v(dout1_208) AT=990.05n

.meas tran vdout1_209ck980 FIND v(dout1_209) AT=990.05n

.meas tran vdout1_210ck980 FIND v(dout1_210) AT=990.05n

.meas tran vdout1_211ck980 FIND v(dout1_211) AT=990.05n

.meas tran vdout1_212ck980 FIND v(dout1_212) AT=990.05n

.meas tran vdout1_213ck980 FIND v(dout1_213) AT=990.05n

.meas tran vdout1_214ck980 FIND v(dout1_214) AT=990.05n

.meas tran vdout1_215ck980 FIND v(dout1_215) AT=990.05n

.meas tran vdout1_216ck980 FIND v(dout1_216) AT=990.05n

.meas tran vdout1_217ck980 FIND v(dout1_217) AT=990.05n

.meas tran vdout1_218ck980 FIND v(dout1_218) AT=990.05n

.meas tran vdout1_219ck980 FIND v(dout1_219) AT=990.05n

.meas tran vdout1_220ck980 FIND v(dout1_220) AT=990.05n

.meas tran vdout1_221ck980 FIND v(dout1_221) AT=990.05n

.meas tran vdout1_222ck980 FIND v(dout1_222) AT=990.05n

.meas tran vdout1_223ck980 FIND v(dout1_223) AT=990.05n

.meas tran vdout1_224ck980 FIND v(dout1_224) AT=990.05n

.meas tran vdout1_225ck980 FIND v(dout1_225) AT=990.05n

.meas tran vdout1_226ck980 FIND v(dout1_226) AT=990.05n

.meas tran vdout1_227ck980 FIND v(dout1_227) AT=990.05n

.meas tran vdout1_228ck980 FIND v(dout1_228) AT=990.05n

.meas tran vdout1_229ck980 FIND v(dout1_229) AT=990.05n

.meas tran vdout1_230ck980 FIND v(dout1_230) AT=990.05n

.meas tran vdout1_231ck980 FIND v(dout1_231) AT=990.05n

.meas tran vdout1_232ck980 FIND v(dout1_232) AT=990.05n

.meas tran vdout1_233ck980 FIND v(dout1_233) AT=990.05n

.meas tran vdout1_234ck980 FIND v(dout1_234) AT=990.05n

.meas tran vdout1_235ck980 FIND v(dout1_235) AT=990.05n

.meas tran vdout1_236ck980 FIND v(dout1_236) AT=990.05n

.meas tran vdout1_237ck980 FIND v(dout1_237) AT=990.05n

.meas tran vdout1_238ck980 FIND v(dout1_238) AT=990.05n

.meas tran vdout1_239ck980 FIND v(dout1_239) AT=990.05n

.meas tran vdout1_240ck980 FIND v(dout1_240) AT=990.05n

.meas tran vdout1_241ck980 FIND v(dout1_241) AT=990.05n

.meas tran vdout1_242ck980 FIND v(dout1_242) AT=990.05n

.meas tran vdout1_243ck980 FIND v(dout1_243) AT=990.05n

.meas tran vdout1_244ck980 FIND v(dout1_244) AT=990.05n

.meas tran vdout1_245ck980 FIND v(dout1_245) AT=990.05n

.meas tran vdout1_246ck980 FIND v(dout1_246) AT=990.05n

.meas tran vdout1_247ck980 FIND v(dout1_247) AT=990.05n

.meas tran vdout1_248ck980 FIND v(dout1_248) AT=990.05n

.meas tran vdout1_249ck980 FIND v(dout1_249) AT=990.05n

.meas tran vdout1_250ck980 FIND v(dout1_250) AT=990.05n

.meas tran vdout1_251ck980 FIND v(dout1_251) AT=990.05n

.meas tran vdout1_252ck980 FIND v(dout1_252) AT=990.05n

.meas tran vdout1_253ck980 FIND v(dout1_253) AT=990.05n

.meas tran vdout1_254ck980 FIND v(dout1_254) AT=990.05n

.meas tran vdout1_255ck980 FIND v(dout1_255) AT=990.05n

.meas tran vdout1_256ck980 FIND v(dout1_256) AT=990.05n

.meas tran vdout1_0ck1000 FIND v(dout1_0) AT=1010.05n

.meas tran vdout1_1ck1000 FIND v(dout1_1) AT=1010.05n

.meas tran vdout1_2ck1000 FIND v(dout1_2) AT=1010.05n

.meas tran vdout1_3ck1000 FIND v(dout1_3) AT=1010.05n

.meas tran vdout1_4ck1000 FIND v(dout1_4) AT=1010.05n

.meas tran vdout1_5ck1000 FIND v(dout1_5) AT=1010.05n

.meas tran vdout1_6ck1000 FIND v(dout1_6) AT=1010.05n

.meas tran vdout1_7ck1000 FIND v(dout1_7) AT=1010.05n

.meas tran vdout1_8ck1000 FIND v(dout1_8) AT=1010.05n

.meas tran vdout1_9ck1000 FIND v(dout1_9) AT=1010.05n

.meas tran vdout1_10ck1000 FIND v(dout1_10) AT=1010.05n

.meas tran vdout1_11ck1000 FIND v(dout1_11) AT=1010.05n

.meas tran vdout1_12ck1000 FIND v(dout1_12) AT=1010.05n

.meas tran vdout1_13ck1000 FIND v(dout1_13) AT=1010.05n

.meas tran vdout1_14ck1000 FIND v(dout1_14) AT=1010.05n

.meas tran vdout1_15ck1000 FIND v(dout1_15) AT=1010.05n

.meas tran vdout1_16ck1000 FIND v(dout1_16) AT=1010.05n

.meas tran vdout1_17ck1000 FIND v(dout1_17) AT=1010.05n

.meas tran vdout1_18ck1000 FIND v(dout1_18) AT=1010.05n

.meas tran vdout1_19ck1000 FIND v(dout1_19) AT=1010.05n

.meas tran vdout1_20ck1000 FIND v(dout1_20) AT=1010.05n

.meas tran vdout1_21ck1000 FIND v(dout1_21) AT=1010.05n

.meas tran vdout1_22ck1000 FIND v(dout1_22) AT=1010.05n

.meas tran vdout1_23ck1000 FIND v(dout1_23) AT=1010.05n

.meas tran vdout1_24ck1000 FIND v(dout1_24) AT=1010.05n

.meas tran vdout1_25ck1000 FIND v(dout1_25) AT=1010.05n

.meas tran vdout1_26ck1000 FIND v(dout1_26) AT=1010.05n

.meas tran vdout1_27ck1000 FIND v(dout1_27) AT=1010.05n

.meas tran vdout1_28ck1000 FIND v(dout1_28) AT=1010.05n

.meas tran vdout1_29ck1000 FIND v(dout1_29) AT=1010.05n

.meas tran vdout1_30ck1000 FIND v(dout1_30) AT=1010.05n

.meas tran vdout1_31ck1000 FIND v(dout1_31) AT=1010.05n

.meas tran vdout1_32ck1000 FIND v(dout1_32) AT=1010.05n

.meas tran vdout1_33ck1000 FIND v(dout1_33) AT=1010.05n

.meas tran vdout1_34ck1000 FIND v(dout1_34) AT=1010.05n

.meas tran vdout1_35ck1000 FIND v(dout1_35) AT=1010.05n

.meas tran vdout1_36ck1000 FIND v(dout1_36) AT=1010.05n

.meas tran vdout1_37ck1000 FIND v(dout1_37) AT=1010.05n

.meas tran vdout1_38ck1000 FIND v(dout1_38) AT=1010.05n

.meas tran vdout1_39ck1000 FIND v(dout1_39) AT=1010.05n

.meas tran vdout1_40ck1000 FIND v(dout1_40) AT=1010.05n

.meas tran vdout1_41ck1000 FIND v(dout1_41) AT=1010.05n

.meas tran vdout1_42ck1000 FIND v(dout1_42) AT=1010.05n

.meas tran vdout1_43ck1000 FIND v(dout1_43) AT=1010.05n

.meas tran vdout1_44ck1000 FIND v(dout1_44) AT=1010.05n

.meas tran vdout1_45ck1000 FIND v(dout1_45) AT=1010.05n

.meas tran vdout1_46ck1000 FIND v(dout1_46) AT=1010.05n

.meas tran vdout1_47ck1000 FIND v(dout1_47) AT=1010.05n

.meas tran vdout1_48ck1000 FIND v(dout1_48) AT=1010.05n

.meas tran vdout1_49ck1000 FIND v(dout1_49) AT=1010.05n

.meas tran vdout1_50ck1000 FIND v(dout1_50) AT=1010.05n

.meas tran vdout1_51ck1000 FIND v(dout1_51) AT=1010.05n

.meas tran vdout1_52ck1000 FIND v(dout1_52) AT=1010.05n

.meas tran vdout1_53ck1000 FIND v(dout1_53) AT=1010.05n

.meas tran vdout1_54ck1000 FIND v(dout1_54) AT=1010.05n

.meas tran vdout1_55ck1000 FIND v(dout1_55) AT=1010.05n

.meas tran vdout1_56ck1000 FIND v(dout1_56) AT=1010.05n

.meas tran vdout1_57ck1000 FIND v(dout1_57) AT=1010.05n

.meas tran vdout1_58ck1000 FIND v(dout1_58) AT=1010.05n

.meas tran vdout1_59ck1000 FIND v(dout1_59) AT=1010.05n

.meas tran vdout1_60ck1000 FIND v(dout1_60) AT=1010.05n

.meas tran vdout1_61ck1000 FIND v(dout1_61) AT=1010.05n

.meas tran vdout1_62ck1000 FIND v(dout1_62) AT=1010.05n

.meas tran vdout1_63ck1000 FIND v(dout1_63) AT=1010.05n

.meas tran vdout1_64ck1000 FIND v(dout1_64) AT=1010.05n

.meas tran vdout1_65ck1000 FIND v(dout1_65) AT=1010.05n

.meas tran vdout1_66ck1000 FIND v(dout1_66) AT=1010.05n

.meas tran vdout1_67ck1000 FIND v(dout1_67) AT=1010.05n

.meas tran vdout1_68ck1000 FIND v(dout1_68) AT=1010.05n

.meas tran vdout1_69ck1000 FIND v(dout1_69) AT=1010.05n

.meas tran vdout1_70ck1000 FIND v(dout1_70) AT=1010.05n

.meas tran vdout1_71ck1000 FIND v(dout1_71) AT=1010.05n

.meas tran vdout1_72ck1000 FIND v(dout1_72) AT=1010.05n

.meas tran vdout1_73ck1000 FIND v(dout1_73) AT=1010.05n

.meas tran vdout1_74ck1000 FIND v(dout1_74) AT=1010.05n

.meas tran vdout1_75ck1000 FIND v(dout1_75) AT=1010.05n

.meas tran vdout1_76ck1000 FIND v(dout1_76) AT=1010.05n

.meas tran vdout1_77ck1000 FIND v(dout1_77) AT=1010.05n

.meas tran vdout1_78ck1000 FIND v(dout1_78) AT=1010.05n

.meas tran vdout1_79ck1000 FIND v(dout1_79) AT=1010.05n

.meas tran vdout1_80ck1000 FIND v(dout1_80) AT=1010.05n

.meas tran vdout1_81ck1000 FIND v(dout1_81) AT=1010.05n

.meas tran vdout1_82ck1000 FIND v(dout1_82) AT=1010.05n

.meas tran vdout1_83ck1000 FIND v(dout1_83) AT=1010.05n

.meas tran vdout1_84ck1000 FIND v(dout1_84) AT=1010.05n

.meas tran vdout1_85ck1000 FIND v(dout1_85) AT=1010.05n

.meas tran vdout1_86ck1000 FIND v(dout1_86) AT=1010.05n

.meas tran vdout1_87ck1000 FIND v(dout1_87) AT=1010.05n

.meas tran vdout1_88ck1000 FIND v(dout1_88) AT=1010.05n

.meas tran vdout1_89ck1000 FIND v(dout1_89) AT=1010.05n

.meas tran vdout1_90ck1000 FIND v(dout1_90) AT=1010.05n

.meas tran vdout1_91ck1000 FIND v(dout1_91) AT=1010.05n

.meas tran vdout1_92ck1000 FIND v(dout1_92) AT=1010.05n

.meas tran vdout1_93ck1000 FIND v(dout1_93) AT=1010.05n

.meas tran vdout1_94ck1000 FIND v(dout1_94) AT=1010.05n

.meas tran vdout1_95ck1000 FIND v(dout1_95) AT=1010.05n

.meas tran vdout1_96ck1000 FIND v(dout1_96) AT=1010.05n

.meas tran vdout1_97ck1000 FIND v(dout1_97) AT=1010.05n

.meas tran vdout1_98ck1000 FIND v(dout1_98) AT=1010.05n

.meas tran vdout1_99ck1000 FIND v(dout1_99) AT=1010.05n

.meas tran vdout1_100ck1000 FIND v(dout1_100) AT=1010.05n

.meas tran vdout1_101ck1000 FIND v(dout1_101) AT=1010.05n

.meas tran vdout1_102ck1000 FIND v(dout1_102) AT=1010.05n

.meas tran vdout1_103ck1000 FIND v(dout1_103) AT=1010.05n

.meas tran vdout1_104ck1000 FIND v(dout1_104) AT=1010.05n

.meas tran vdout1_105ck1000 FIND v(dout1_105) AT=1010.05n

.meas tran vdout1_106ck1000 FIND v(dout1_106) AT=1010.05n

.meas tran vdout1_107ck1000 FIND v(dout1_107) AT=1010.05n

.meas tran vdout1_108ck1000 FIND v(dout1_108) AT=1010.05n

.meas tran vdout1_109ck1000 FIND v(dout1_109) AT=1010.05n

.meas tran vdout1_110ck1000 FIND v(dout1_110) AT=1010.05n

.meas tran vdout1_111ck1000 FIND v(dout1_111) AT=1010.05n

.meas tran vdout1_112ck1000 FIND v(dout1_112) AT=1010.05n

.meas tran vdout1_113ck1000 FIND v(dout1_113) AT=1010.05n

.meas tran vdout1_114ck1000 FIND v(dout1_114) AT=1010.05n

.meas tran vdout1_115ck1000 FIND v(dout1_115) AT=1010.05n

.meas tran vdout1_116ck1000 FIND v(dout1_116) AT=1010.05n

.meas tran vdout1_117ck1000 FIND v(dout1_117) AT=1010.05n

.meas tran vdout1_118ck1000 FIND v(dout1_118) AT=1010.05n

.meas tran vdout1_119ck1000 FIND v(dout1_119) AT=1010.05n

.meas tran vdout1_120ck1000 FIND v(dout1_120) AT=1010.05n

.meas tran vdout1_121ck1000 FIND v(dout1_121) AT=1010.05n

.meas tran vdout1_122ck1000 FIND v(dout1_122) AT=1010.05n

.meas tran vdout1_123ck1000 FIND v(dout1_123) AT=1010.05n

.meas tran vdout1_124ck1000 FIND v(dout1_124) AT=1010.05n

.meas tran vdout1_125ck1000 FIND v(dout1_125) AT=1010.05n

.meas tran vdout1_126ck1000 FIND v(dout1_126) AT=1010.05n

.meas tran vdout1_127ck1000 FIND v(dout1_127) AT=1010.05n

.meas tran vdout1_128ck1000 FIND v(dout1_128) AT=1010.05n

.meas tran vdout1_129ck1000 FIND v(dout1_129) AT=1010.05n

.meas tran vdout1_130ck1000 FIND v(dout1_130) AT=1010.05n

.meas tran vdout1_131ck1000 FIND v(dout1_131) AT=1010.05n

.meas tran vdout1_132ck1000 FIND v(dout1_132) AT=1010.05n

.meas tran vdout1_133ck1000 FIND v(dout1_133) AT=1010.05n

.meas tran vdout1_134ck1000 FIND v(dout1_134) AT=1010.05n

.meas tran vdout1_135ck1000 FIND v(dout1_135) AT=1010.05n

.meas tran vdout1_136ck1000 FIND v(dout1_136) AT=1010.05n

.meas tran vdout1_137ck1000 FIND v(dout1_137) AT=1010.05n

.meas tran vdout1_138ck1000 FIND v(dout1_138) AT=1010.05n

.meas tran vdout1_139ck1000 FIND v(dout1_139) AT=1010.05n

.meas tran vdout1_140ck1000 FIND v(dout1_140) AT=1010.05n

.meas tran vdout1_141ck1000 FIND v(dout1_141) AT=1010.05n

.meas tran vdout1_142ck1000 FIND v(dout1_142) AT=1010.05n

.meas tran vdout1_143ck1000 FIND v(dout1_143) AT=1010.05n

.meas tran vdout1_144ck1000 FIND v(dout1_144) AT=1010.05n

.meas tran vdout1_145ck1000 FIND v(dout1_145) AT=1010.05n

.meas tran vdout1_146ck1000 FIND v(dout1_146) AT=1010.05n

.meas tran vdout1_147ck1000 FIND v(dout1_147) AT=1010.05n

.meas tran vdout1_148ck1000 FIND v(dout1_148) AT=1010.05n

.meas tran vdout1_149ck1000 FIND v(dout1_149) AT=1010.05n

.meas tran vdout1_150ck1000 FIND v(dout1_150) AT=1010.05n

.meas tran vdout1_151ck1000 FIND v(dout1_151) AT=1010.05n

.meas tran vdout1_152ck1000 FIND v(dout1_152) AT=1010.05n

.meas tran vdout1_153ck1000 FIND v(dout1_153) AT=1010.05n

.meas tran vdout1_154ck1000 FIND v(dout1_154) AT=1010.05n

.meas tran vdout1_155ck1000 FIND v(dout1_155) AT=1010.05n

.meas tran vdout1_156ck1000 FIND v(dout1_156) AT=1010.05n

.meas tran vdout1_157ck1000 FIND v(dout1_157) AT=1010.05n

.meas tran vdout1_158ck1000 FIND v(dout1_158) AT=1010.05n

.meas tran vdout1_159ck1000 FIND v(dout1_159) AT=1010.05n

.meas tran vdout1_160ck1000 FIND v(dout1_160) AT=1010.05n

.meas tran vdout1_161ck1000 FIND v(dout1_161) AT=1010.05n

.meas tran vdout1_162ck1000 FIND v(dout1_162) AT=1010.05n

.meas tran vdout1_163ck1000 FIND v(dout1_163) AT=1010.05n

.meas tran vdout1_164ck1000 FIND v(dout1_164) AT=1010.05n

.meas tran vdout1_165ck1000 FIND v(dout1_165) AT=1010.05n

.meas tran vdout1_166ck1000 FIND v(dout1_166) AT=1010.05n

.meas tran vdout1_167ck1000 FIND v(dout1_167) AT=1010.05n

.meas tran vdout1_168ck1000 FIND v(dout1_168) AT=1010.05n

.meas tran vdout1_169ck1000 FIND v(dout1_169) AT=1010.05n

.meas tran vdout1_170ck1000 FIND v(dout1_170) AT=1010.05n

.meas tran vdout1_171ck1000 FIND v(dout1_171) AT=1010.05n

.meas tran vdout1_172ck1000 FIND v(dout1_172) AT=1010.05n

.meas tran vdout1_173ck1000 FIND v(dout1_173) AT=1010.05n

.meas tran vdout1_174ck1000 FIND v(dout1_174) AT=1010.05n

.meas tran vdout1_175ck1000 FIND v(dout1_175) AT=1010.05n

.meas tran vdout1_176ck1000 FIND v(dout1_176) AT=1010.05n

.meas tran vdout1_177ck1000 FIND v(dout1_177) AT=1010.05n

.meas tran vdout1_178ck1000 FIND v(dout1_178) AT=1010.05n

.meas tran vdout1_179ck1000 FIND v(dout1_179) AT=1010.05n

.meas tran vdout1_180ck1000 FIND v(dout1_180) AT=1010.05n

.meas tran vdout1_181ck1000 FIND v(dout1_181) AT=1010.05n

.meas tran vdout1_182ck1000 FIND v(dout1_182) AT=1010.05n

.meas tran vdout1_183ck1000 FIND v(dout1_183) AT=1010.05n

.meas tran vdout1_184ck1000 FIND v(dout1_184) AT=1010.05n

.meas tran vdout1_185ck1000 FIND v(dout1_185) AT=1010.05n

.meas tran vdout1_186ck1000 FIND v(dout1_186) AT=1010.05n

.meas tran vdout1_187ck1000 FIND v(dout1_187) AT=1010.05n

.meas tran vdout1_188ck1000 FIND v(dout1_188) AT=1010.05n

.meas tran vdout1_189ck1000 FIND v(dout1_189) AT=1010.05n

.meas tran vdout1_190ck1000 FIND v(dout1_190) AT=1010.05n

.meas tran vdout1_191ck1000 FIND v(dout1_191) AT=1010.05n

.meas tran vdout1_192ck1000 FIND v(dout1_192) AT=1010.05n

.meas tran vdout1_193ck1000 FIND v(dout1_193) AT=1010.05n

.meas tran vdout1_194ck1000 FIND v(dout1_194) AT=1010.05n

.meas tran vdout1_195ck1000 FIND v(dout1_195) AT=1010.05n

.meas tran vdout1_196ck1000 FIND v(dout1_196) AT=1010.05n

.meas tran vdout1_197ck1000 FIND v(dout1_197) AT=1010.05n

.meas tran vdout1_198ck1000 FIND v(dout1_198) AT=1010.05n

.meas tran vdout1_199ck1000 FIND v(dout1_199) AT=1010.05n

.meas tran vdout1_200ck1000 FIND v(dout1_200) AT=1010.05n

.meas tran vdout1_201ck1000 FIND v(dout1_201) AT=1010.05n

.meas tran vdout1_202ck1000 FIND v(dout1_202) AT=1010.05n

.meas tran vdout1_203ck1000 FIND v(dout1_203) AT=1010.05n

.meas tran vdout1_204ck1000 FIND v(dout1_204) AT=1010.05n

.meas tran vdout1_205ck1000 FIND v(dout1_205) AT=1010.05n

.meas tran vdout1_206ck1000 FIND v(dout1_206) AT=1010.05n

.meas tran vdout1_207ck1000 FIND v(dout1_207) AT=1010.05n

.meas tran vdout1_208ck1000 FIND v(dout1_208) AT=1010.05n

.meas tran vdout1_209ck1000 FIND v(dout1_209) AT=1010.05n

.meas tran vdout1_210ck1000 FIND v(dout1_210) AT=1010.05n

.meas tran vdout1_211ck1000 FIND v(dout1_211) AT=1010.05n

.meas tran vdout1_212ck1000 FIND v(dout1_212) AT=1010.05n

.meas tran vdout1_213ck1000 FIND v(dout1_213) AT=1010.05n

.meas tran vdout1_214ck1000 FIND v(dout1_214) AT=1010.05n

.meas tran vdout1_215ck1000 FIND v(dout1_215) AT=1010.05n

.meas tran vdout1_216ck1000 FIND v(dout1_216) AT=1010.05n

.meas tran vdout1_217ck1000 FIND v(dout1_217) AT=1010.05n

.meas tran vdout1_218ck1000 FIND v(dout1_218) AT=1010.05n

.meas tran vdout1_219ck1000 FIND v(dout1_219) AT=1010.05n

.meas tran vdout1_220ck1000 FIND v(dout1_220) AT=1010.05n

.meas tran vdout1_221ck1000 FIND v(dout1_221) AT=1010.05n

.meas tran vdout1_222ck1000 FIND v(dout1_222) AT=1010.05n

.meas tran vdout1_223ck1000 FIND v(dout1_223) AT=1010.05n

.meas tran vdout1_224ck1000 FIND v(dout1_224) AT=1010.05n

.meas tran vdout1_225ck1000 FIND v(dout1_225) AT=1010.05n

.meas tran vdout1_226ck1000 FIND v(dout1_226) AT=1010.05n

.meas tran vdout1_227ck1000 FIND v(dout1_227) AT=1010.05n

.meas tran vdout1_228ck1000 FIND v(dout1_228) AT=1010.05n

.meas tran vdout1_229ck1000 FIND v(dout1_229) AT=1010.05n

.meas tran vdout1_230ck1000 FIND v(dout1_230) AT=1010.05n

.meas tran vdout1_231ck1000 FIND v(dout1_231) AT=1010.05n

.meas tran vdout1_232ck1000 FIND v(dout1_232) AT=1010.05n

.meas tran vdout1_233ck1000 FIND v(dout1_233) AT=1010.05n

.meas tran vdout1_234ck1000 FIND v(dout1_234) AT=1010.05n

.meas tran vdout1_235ck1000 FIND v(dout1_235) AT=1010.05n

.meas tran vdout1_236ck1000 FIND v(dout1_236) AT=1010.05n

.meas tran vdout1_237ck1000 FIND v(dout1_237) AT=1010.05n

.meas tran vdout1_238ck1000 FIND v(dout1_238) AT=1010.05n

.meas tran vdout1_239ck1000 FIND v(dout1_239) AT=1010.05n

.meas tran vdout1_240ck1000 FIND v(dout1_240) AT=1010.05n

.meas tran vdout1_241ck1000 FIND v(dout1_241) AT=1010.05n

.meas tran vdout1_242ck1000 FIND v(dout1_242) AT=1010.05n

.meas tran vdout1_243ck1000 FIND v(dout1_243) AT=1010.05n

.meas tran vdout1_244ck1000 FIND v(dout1_244) AT=1010.05n

.meas tran vdout1_245ck1000 FIND v(dout1_245) AT=1010.05n

.meas tran vdout1_246ck1000 FIND v(dout1_246) AT=1010.05n

.meas tran vdout1_247ck1000 FIND v(dout1_247) AT=1010.05n

.meas tran vdout1_248ck1000 FIND v(dout1_248) AT=1010.05n

.meas tran vdout1_249ck1000 FIND v(dout1_249) AT=1010.05n

.meas tran vdout1_250ck1000 FIND v(dout1_250) AT=1010.05n

.meas tran vdout1_251ck1000 FIND v(dout1_251) AT=1010.05n

.meas tran vdout1_252ck1000 FIND v(dout1_252) AT=1010.05n

.meas tran vdout1_253ck1000 FIND v(dout1_253) AT=1010.05n

.meas tran vdout1_254ck1000 FIND v(dout1_254) AT=1010.05n

.meas tran vdout1_255ck1000 FIND v(dout1_255) AT=1010.05n

.meas tran vdout1_256ck1000 FIND v(dout1_256) AT=1010.05n

.meas tran vdout1_0ck1060 FIND v(dout1_0) AT=1070.05n

.meas tran vdout1_1ck1060 FIND v(dout1_1) AT=1070.05n

.meas tran vdout1_2ck1060 FIND v(dout1_2) AT=1070.05n

.meas tran vdout1_3ck1060 FIND v(dout1_3) AT=1070.05n

.meas tran vdout1_4ck1060 FIND v(dout1_4) AT=1070.05n

.meas tran vdout1_5ck1060 FIND v(dout1_5) AT=1070.05n

.meas tran vdout1_6ck1060 FIND v(dout1_6) AT=1070.05n

.meas tran vdout1_7ck1060 FIND v(dout1_7) AT=1070.05n

.meas tran vdout1_8ck1060 FIND v(dout1_8) AT=1070.05n

.meas tran vdout1_9ck1060 FIND v(dout1_9) AT=1070.05n

.meas tran vdout1_10ck1060 FIND v(dout1_10) AT=1070.05n

.meas tran vdout1_11ck1060 FIND v(dout1_11) AT=1070.05n

.meas tran vdout1_12ck1060 FIND v(dout1_12) AT=1070.05n

.meas tran vdout1_13ck1060 FIND v(dout1_13) AT=1070.05n

.meas tran vdout1_14ck1060 FIND v(dout1_14) AT=1070.05n

.meas tran vdout1_15ck1060 FIND v(dout1_15) AT=1070.05n

.meas tran vdout1_16ck1060 FIND v(dout1_16) AT=1070.05n

.meas tran vdout1_17ck1060 FIND v(dout1_17) AT=1070.05n

.meas tran vdout1_18ck1060 FIND v(dout1_18) AT=1070.05n

.meas tran vdout1_19ck1060 FIND v(dout1_19) AT=1070.05n

.meas tran vdout1_20ck1060 FIND v(dout1_20) AT=1070.05n

.meas tran vdout1_21ck1060 FIND v(dout1_21) AT=1070.05n

.meas tran vdout1_22ck1060 FIND v(dout1_22) AT=1070.05n

.meas tran vdout1_23ck1060 FIND v(dout1_23) AT=1070.05n

.meas tran vdout1_24ck1060 FIND v(dout1_24) AT=1070.05n

.meas tran vdout1_25ck1060 FIND v(dout1_25) AT=1070.05n

.meas tran vdout1_26ck1060 FIND v(dout1_26) AT=1070.05n

.meas tran vdout1_27ck1060 FIND v(dout1_27) AT=1070.05n

.meas tran vdout1_28ck1060 FIND v(dout1_28) AT=1070.05n

.meas tran vdout1_29ck1060 FIND v(dout1_29) AT=1070.05n

.meas tran vdout1_30ck1060 FIND v(dout1_30) AT=1070.05n

.meas tran vdout1_31ck1060 FIND v(dout1_31) AT=1070.05n

.meas tran vdout1_32ck1060 FIND v(dout1_32) AT=1070.05n

.meas tran vdout1_33ck1060 FIND v(dout1_33) AT=1070.05n

.meas tran vdout1_34ck1060 FIND v(dout1_34) AT=1070.05n

.meas tran vdout1_35ck1060 FIND v(dout1_35) AT=1070.05n

.meas tran vdout1_36ck1060 FIND v(dout1_36) AT=1070.05n

.meas tran vdout1_37ck1060 FIND v(dout1_37) AT=1070.05n

.meas tran vdout1_38ck1060 FIND v(dout1_38) AT=1070.05n

.meas tran vdout1_39ck1060 FIND v(dout1_39) AT=1070.05n

.meas tran vdout1_40ck1060 FIND v(dout1_40) AT=1070.05n

.meas tran vdout1_41ck1060 FIND v(dout1_41) AT=1070.05n

.meas tran vdout1_42ck1060 FIND v(dout1_42) AT=1070.05n

.meas tran vdout1_43ck1060 FIND v(dout1_43) AT=1070.05n

.meas tran vdout1_44ck1060 FIND v(dout1_44) AT=1070.05n

.meas tran vdout1_45ck1060 FIND v(dout1_45) AT=1070.05n

.meas tran vdout1_46ck1060 FIND v(dout1_46) AT=1070.05n

.meas tran vdout1_47ck1060 FIND v(dout1_47) AT=1070.05n

.meas tran vdout1_48ck1060 FIND v(dout1_48) AT=1070.05n

.meas tran vdout1_49ck1060 FIND v(dout1_49) AT=1070.05n

.meas tran vdout1_50ck1060 FIND v(dout1_50) AT=1070.05n

.meas tran vdout1_51ck1060 FIND v(dout1_51) AT=1070.05n

.meas tran vdout1_52ck1060 FIND v(dout1_52) AT=1070.05n

.meas tran vdout1_53ck1060 FIND v(dout1_53) AT=1070.05n

.meas tran vdout1_54ck1060 FIND v(dout1_54) AT=1070.05n

.meas tran vdout1_55ck1060 FIND v(dout1_55) AT=1070.05n

.meas tran vdout1_56ck1060 FIND v(dout1_56) AT=1070.05n

.meas tran vdout1_57ck1060 FIND v(dout1_57) AT=1070.05n

.meas tran vdout1_58ck1060 FIND v(dout1_58) AT=1070.05n

.meas tran vdout1_59ck1060 FIND v(dout1_59) AT=1070.05n

.meas tran vdout1_60ck1060 FIND v(dout1_60) AT=1070.05n

.meas tran vdout1_61ck1060 FIND v(dout1_61) AT=1070.05n

.meas tran vdout1_62ck1060 FIND v(dout1_62) AT=1070.05n

.meas tran vdout1_63ck1060 FIND v(dout1_63) AT=1070.05n

.meas tran vdout1_64ck1060 FIND v(dout1_64) AT=1070.05n

.meas tran vdout1_65ck1060 FIND v(dout1_65) AT=1070.05n

.meas tran vdout1_66ck1060 FIND v(dout1_66) AT=1070.05n

.meas tran vdout1_67ck1060 FIND v(dout1_67) AT=1070.05n

.meas tran vdout1_68ck1060 FIND v(dout1_68) AT=1070.05n

.meas tran vdout1_69ck1060 FIND v(dout1_69) AT=1070.05n

.meas tran vdout1_70ck1060 FIND v(dout1_70) AT=1070.05n

.meas tran vdout1_71ck1060 FIND v(dout1_71) AT=1070.05n

.meas tran vdout1_72ck1060 FIND v(dout1_72) AT=1070.05n

.meas tran vdout1_73ck1060 FIND v(dout1_73) AT=1070.05n

.meas tran vdout1_74ck1060 FIND v(dout1_74) AT=1070.05n

.meas tran vdout1_75ck1060 FIND v(dout1_75) AT=1070.05n

.meas tran vdout1_76ck1060 FIND v(dout1_76) AT=1070.05n

.meas tran vdout1_77ck1060 FIND v(dout1_77) AT=1070.05n

.meas tran vdout1_78ck1060 FIND v(dout1_78) AT=1070.05n

.meas tran vdout1_79ck1060 FIND v(dout1_79) AT=1070.05n

.meas tran vdout1_80ck1060 FIND v(dout1_80) AT=1070.05n

.meas tran vdout1_81ck1060 FIND v(dout1_81) AT=1070.05n

.meas tran vdout1_82ck1060 FIND v(dout1_82) AT=1070.05n

.meas tran vdout1_83ck1060 FIND v(dout1_83) AT=1070.05n

.meas tran vdout1_84ck1060 FIND v(dout1_84) AT=1070.05n

.meas tran vdout1_85ck1060 FIND v(dout1_85) AT=1070.05n

.meas tran vdout1_86ck1060 FIND v(dout1_86) AT=1070.05n

.meas tran vdout1_87ck1060 FIND v(dout1_87) AT=1070.05n

.meas tran vdout1_88ck1060 FIND v(dout1_88) AT=1070.05n

.meas tran vdout1_89ck1060 FIND v(dout1_89) AT=1070.05n

.meas tran vdout1_90ck1060 FIND v(dout1_90) AT=1070.05n

.meas tran vdout1_91ck1060 FIND v(dout1_91) AT=1070.05n

.meas tran vdout1_92ck1060 FIND v(dout1_92) AT=1070.05n

.meas tran vdout1_93ck1060 FIND v(dout1_93) AT=1070.05n

.meas tran vdout1_94ck1060 FIND v(dout1_94) AT=1070.05n

.meas tran vdout1_95ck1060 FIND v(dout1_95) AT=1070.05n

.meas tran vdout1_96ck1060 FIND v(dout1_96) AT=1070.05n

.meas tran vdout1_97ck1060 FIND v(dout1_97) AT=1070.05n

.meas tran vdout1_98ck1060 FIND v(dout1_98) AT=1070.05n

.meas tran vdout1_99ck1060 FIND v(dout1_99) AT=1070.05n

.meas tran vdout1_100ck1060 FIND v(dout1_100) AT=1070.05n

.meas tran vdout1_101ck1060 FIND v(dout1_101) AT=1070.05n

.meas tran vdout1_102ck1060 FIND v(dout1_102) AT=1070.05n

.meas tran vdout1_103ck1060 FIND v(dout1_103) AT=1070.05n

.meas tran vdout1_104ck1060 FIND v(dout1_104) AT=1070.05n

.meas tran vdout1_105ck1060 FIND v(dout1_105) AT=1070.05n

.meas tran vdout1_106ck1060 FIND v(dout1_106) AT=1070.05n

.meas tran vdout1_107ck1060 FIND v(dout1_107) AT=1070.05n

.meas tran vdout1_108ck1060 FIND v(dout1_108) AT=1070.05n

.meas tran vdout1_109ck1060 FIND v(dout1_109) AT=1070.05n

.meas tran vdout1_110ck1060 FIND v(dout1_110) AT=1070.05n

.meas tran vdout1_111ck1060 FIND v(dout1_111) AT=1070.05n

.meas tran vdout1_112ck1060 FIND v(dout1_112) AT=1070.05n

.meas tran vdout1_113ck1060 FIND v(dout1_113) AT=1070.05n

.meas tran vdout1_114ck1060 FIND v(dout1_114) AT=1070.05n

.meas tran vdout1_115ck1060 FIND v(dout1_115) AT=1070.05n

.meas tran vdout1_116ck1060 FIND v(dout1_116) AT=1070.05n

.meas tran vdout1_117ck1060 FIND v(dout1_117) AT=1070.05n

.meas tran vdout1_118ck1060 FIND v(dout1_118) AT=1070.05n

.meas tran vdout1_119ck1060 FIND v(dout1_119) AT=1070.05n

.meas tran vdout1_120ck1060 FIND v(dout1_120) AT=1070.05n

.meas tran vdout1_121ck1060 FIND v(dout1_121) AT=1070.05n

.meas tran vdout1_122ck1060 FIND v(dout1_122) AT=1070.05n

.meas tran vdout1_123ck1060 FIND v(dout1_123) AT=1070.05n

.meas tran vdout1_124ck1060 FIND v(dout1_124) AT=1070.05n

.meas tran vdout1_125ck1060 FIND v(dout1_125) AT=1070.05n

.meas tran vdout1_126ck1060 FIND v(dout1_126) AT=1070.05n

.meas tran vdout1_127ck1060 FIND v(dout1_127) AT=1070.05n

.meas tran vdout1_128ck1060 FIND v(dout1_128) AT=1070.05n

.meas tran vdout1_129ck1060 FIND v(dout1_129) AT=1070.05n

.meas tran vdout1_130ck1060 FIND v(dout1_130) AT=1070.05n

.meas tran vdout1_131ck1060 FIND v(dout1_131) AT=1070.05n

.meas tran vdout1_132ck1060 FIND v(dout1_132) AT=1070.05n

.meas tran vdout1_133ck1060 FIND v(dout1_133) AT=1070.05n

.meas tran vdout1_134ck1060 FIND v(dout1_134) AT=1070.05n

.meas tran vdout1_135ck1060 FIND v(dout1_135) AT=1070.05n

.meas tran vdout1_136ck1060 FIND v(dout1_136) AT=1070.05n

.meas tran vdout1_137ck1060 FIND v(dout1_137) AT=1070.05n

.meas tran vdout1_138ck1060 FIND v(dout1_138) AT=1070.05n

.meas tran vdout1_139ck1060 FIND v(dout1_139) AT=1070.05n

.meas tran vdout1_140ck1060 FIND v(dout1_140) AT=1070.05n

.meas tran vdout1_141ck1060 FIND v(dout1_141) AT=1070.05n

.meas tran vdout1_142ck1060 FIND v(dout1_142) AT=1070.05n

.meas tran vdout1_143ck1060 FIND v(dout1_143) AT=1070.05n

.meas tran vdout1_144ck1060 FIND v(dout1_144) AT=1070.05n

.meas tran vdout1_145ck1060 FIND v(dout1_145) AT=1070.05n

.meas tran vdout1_146ck1060 FIND v(dout1_146) AT=1070.05n

.meas tran vdout1_147ck1060 FIND v(dout1_147) AT=1070.05n

.meas tran vdout1_148ck1060 FIND v(dout1_148) AT=1070.05n

.meas tran vdout1_149ck1060 FIND v(dout1_149) AT=1070.05n

.meas tran vdout1_150ck1060 FIND v(dout1_150) AT=1070.05n

.meas tran vdout1_151ck1060 FIND v(dout1_151) AT=1070.05n

.meas tran vdout1_152ck1060 FIND v(dout1_152) AT=1070.05n

.meas tran vdout1_153ck1060 FIND v(dout1_153) AT=1070.05n

.meas tran vdout1_154ck1060 FIND v(dout1_154) AT=1070.05n

.meas tran vdout1_155ck1060 FIND v(dout1_155) AT=1070.05n

.meas tran vdout1_156ck1060 FIND v(dout1_156) AT=1070.05n

.meas tran vdout1_157ck1060 FIND v(dout1_157) AT=1070.05n

.meas tran vdout1_158ck1060 FIND v(dout1_158) AT=1070.05n

.meas tran vdout1_159ck1060 FIND v(dout1_159) AT=1070.05n

.meas tran vdout1_160ck1060 FIND v(dout1_160) AT=1070.05n

.meas tran vdout1_161ck1060 FIND v(dout1_161) AT=1070.05n

.meas tran vdout1_162ck1060 FIND v(dout1_162) AT=1070.05n

.meas tran vdout1_163ck1060 FIND v(dout1_163) AT=1070.05n

.meas tran vdout1_164ck1060 FIND v(dout1_164) AT=1070.05n

.meas tran vdout1_165ck1060 FIND v(dout1_165) AT=1070.05n

.meas tran vdout1_166ck1060 FIND v(dout1_166) AT=1070.05n

.meas tran vdout1_167ck1060 FIND v(dout1_167) AT=1070.05n

.meas tran vdout1_168ck1060 FIND v(dout1_168) AT=1070.05n

.meas tran vdout1_169ck1060 FIND v(dout1_169) AT=1070.05n

.meas tran vdout1_170ck1060 FIND v(dout1_170) AT=1070.05n

.meas tran vdout1_171ck1060 FIND v(dout1_171) AT=1070.05n

.meas tran vdout1_172ck1060 FIND v(dout1_172) AT=1070.05n

.meas tran vdout1_173ck1060 FIND v(dout1_173) AT=1070.05n

.meas tran vdout1_174ck1060 FIND v(dout1_174) AT=1070.05n

.meas tran vdout1_175ck1060 FIND v(dout1_175) AT=1070.05n

.meas tran vdout1_176ck1060 FIND v(dout1_176) AT=1070.05n

.meas tran vdout1_177ck1060 FIND v(dout1_177) AT=1070.05n

.meas tran vdout1_178ck1060 FIND v(dout1_178) AT=1070.05n

.meas tran vdout1_179ck1060 FIND v(dout1_179) AT=1070.05n

.meas tran vdout1_180ck1060 FIND v(dout1_180) AT=1070.05n

.meas tran vdout1_181ck1060 FIND v(dout1_181) AT=1070.05n

.meas tran vdout1_182ck1060 FIND v(dout1_182) AT=1070.05n

.meas tran vdout1_183ck1060 FIND v(dout1_183) AT=1070.05n

.meas tran vdout1_184ck1060 FIND v(dout1_184) AT=1070.05n

.meas tran vdout1_185ck1060 FIND v(dout1_185) AT=1070.05n

.meas tran vdout1_186ck1060 FIND v(dout1_186) AT=1070.05n

.meas tran vdout1_187ck1060 FIND v(dout1_187) AT=1070.05n

.meas tran vdout1_188ck1060 FIND v(dout1_188) AT=1070.05n

.meas tran vdout1_189ck1060 FIND v(dout1_189) AT=1070.05n

.meas tran vdout1_190ck1060 FIND v(dout1_190) AT=1070.05n

.meas tran vdout1_191ck1060 FIND v(dout1_191) AT=1070.05n

.meas tran vdout1_192ck1060 FIND v(dout1_192) AT=1070.05n

.meas tran vdout1_193ck1060 FIND v(dout1_193) AT=1070.05n

.meas tran vdout1_194ck1060 FIND v(dout1_194) AT=1070.05n

.meas tran vdout1_195ck1060 FIND v(dout1_195) AT=1070.05n

.meas tran vdout1_196ck1060 FIND v(dout1_196) AT=1070.05n

.meas tran vdout1_197ck1060 FIND v(dout1_197) AT=1070.05n

.meas tran vdout1_198ck1060 FIND v(dout1_198) AT=1070.05n

.meas tran vdout1_199ck1060 FIND v(dout1_199) AT=1070.05n

.meas tran vdout1_200ck1060 FIND v(dout1_200) AT=1070.05n

.meas tran vdout1_201ck1060 FIND v(dout1_201) AT=1070.05n

.meas tran vdout1_202ck1060 FIND v(dout1_202) AT=1070.05n

.meas tran vdout1_203ck1060 FIND v(dout1_203) AT=1070.05n

.meas tran vdout1_204ck1060 FIND v(dout1_204) AT=1070.05n

.meas tran vdout1_205ck1060 FIND v(dout1_205) AT=1070.05n

.meas tran vdout1_206ck1060 FIND v(dout1_206) AT=1070.05n

.meas tran vdout1_207ck1060 FIND v(dout1_207) AT=1070.05n

.meas tran vdout1_208ck1060 FIND v(dout1_208) AT=1070.05n

.meas tran vdout1_209ck1060 FIND v(dout1_209) AT=1070.05n

.meas tran vdout1_210ck1060 FIND v(dout1_210) AT=1070.05n

.meas tran vdout1_211ck1060 FIND v(dout1_211) AT=1070.05n

.meas tran vdout1_212ck1060 FIND v(dout1_212) AT=1070.05n

.meas tran vdout1_213ck1060 FIND v(dout1_213) AT=1070.05n

.meas tran vdout1_214ck1060 FIND v(dout1_214) AT=1070.05n

.meas tran vdout1_215ck1060 FIND v(dout1_215) AT=1070.05n

.meas tran vdout1_216ck1060 FIND v(dout1_216) AT=1070.05n

.meas tran vdout1_217ck1060 FIND v(dout1_217) AT=1070.05n

.meas tran vdout1_218ck1060 FIND v(dout1_218) AT=1070.05n

.meas tran vdout1_219ck1060 FIND v(dout1_219) AT=1070.05n

.meas tran vdout1_220ck1060 FIND v(dout1_220) AT=1070.05n

.meas tran vdout1_221ck1060 FIND v(dout1_221) AT=1070.05n

.meas tran vdout1_222ck1060 FIND v(dout1_222) AT=1070.05n

.meas tran vdout1_223ck1060 FIND v(dout1_223) AT=1070.05n

.meas tran vdout1_224ck1060 FIND v(dout1_224) AT=1070.05n

.meas tran vdout1_225ck1060 FIND v(dout1_225) AT=1070.05n

.meas tran vdout1_226ck1060 FIND v(dout1_226) AT=1070.05n

.meas tran vdout1_227ck1060 FIND v(dout1_227) AT=1070.05n

.meas tran vdout1_228ck1060 FIND v(dout1_228) AT=1070.05n

.meas tran vdout1_229ck1060 FIND v(dout1_229) AT=1070.05n

.meas tran vdout1_230ck1060 FIND v(dout1_230) AT=1070.05n

.meas tran vdout1_231ck1060 FIND v(dout1_231) AT=1070.05n

.meas tran vdout1_232ck1060 FIND v(dout1_232) AT=1070.05n

.meas tran vdout1_233ck1060 FIND v(dout1_233) AT=1070.05n

.meas tran vdout1_234ck1060 FIND v(dout1_234) AT=1070.05n

.meas tran vdout1_235ck1060 FIND v(dout1_235) AT=1070.05n

.meas tran vdout1_236ck1060 FIND v(dout1_236) AT=1070.05n

.meas tran vdout1_237ck1060 FIND v(dout1_237) AT=1070.05n

.meas tran vdout1_238ck1060 FIND v(dout1_238) AT=1070.05n

.meas tran vdout1_239ck1060 FIND v(dout1_239) AT=1070.05n

.meas tran vdout1_240ck1060 FIND v(dout1_240) AT=1070.05n

.meas tran vdout1_241ck1060 FIND v(dout1_241) AT=1070.05n

.meas tran vdout1_242ck1060 FIND v(dout1_242) AT=1070.05n

.meas tran vdout1_243ck1060 FIND v(dout1_243) AT=1070.05n

.meas tran vdout1_244ck1060 FIND v(dout1_244) AT=1070.05n

.meas tran vdout1_245ck1060 FIND v(dout1_245) AT=1070.05n

.meas tran vdout1_246ck1060 FIND v(dout1_246) AT=1070.05n

.meas tran vdout1_247ck1060 FIND v(dout1_247) AT=1070.05n

.meas tran vdout1_248ck1060 FIND v(dout1_248) AT=1070.05n

.meas tran vdout1_249ck1060 FIND v(dout1_249) AT=1070.05n

.meas tran vdout1_250ck1060 FIND v(dout1_250) AT=1070.05n

.meas tran vdout1_251ck1060 FIND v(dout1_251) AT=1070.05n

.meas tran vdout1_252ck1060 FIND v(dout1_252) AT=1070.05n

.meas tran vdout1_253ck1060 FIND v(dout1_253) AT=1070.05n

.meas tran vdout1_254ck1060 FIND v(dout1_254) AT=1070.05n

.meas tran vdout1_255ck1060 FIND v(dout1_255) AT=1070.05n

.meas tran vdout1_256ck1060 FIND v(dout1_256) AT=1070.05n

.meas tran vdout1_0ck1170 FIND v(dout1_0) AT=1180.05n

.meas tran vdout1_1ck1170 FIND v(dout1_1) AT=1180.05n

.meas tran vdout1_2ck1170 FIND v(dout1_2) AT=1180.05n

.meas tran vdout1_3ck1170 FIND v(dout1_3) AT=1180.05n

.meas tran vdout1_4ck1170 FIND v(dout1_4) AT=1180.05n

.meas tran vdout1_5ck1170 FIND v(dout1_5) AT=1180.05n

.meas tran vdout1_6ck1170 FIND v(dout1_6) AT=1180.05n

.meas tran vdout1_7ck1170 FIND v(dout1_7) AT=1180.05n

.meas tran vdout1_8ck1170 FIND v(dout1_8) AT=1180.05n

.meas tran vdout1_9ck1170 FIND v(dout1_9) AT=1180.05n

.meas tran vdout1_10ck1170 FIND v(dout1_10) AT=1180.05n

.meas tran vdout1_11ck1170 FIND v(dout1_11) AT=1180.05n

.meas tran vdout1_12ck1170 FIND v(dout1_12) AT=1180.05n

.meas tran vdout1_13ck1170 FIND v(dout1_13) AT=1180.05n

.meas tran vdout1_14ck1170 FIND v(dout1_14) AT=1180.05n

.meas tran vdout1_15ck1170 FIND v(dout1_15) AT=1180.05n

.meas tran vdout1_16ck1170 FIND v(dout1_16) AT=1180.05n

.meas tran vdout1_17ck1170 FIND v(dout1_17) AT=1180.05n

.meas tran vdout1_18ck1170 FIND v(dout1_18) AT=1180.05n

.meas tran vdout1_19ck1170 FIND v(dout1_19) AT=1180.05n

.meas tran vdout1_20ck1170 FIND v(dout1_20) AT=1180.05n

.meas tran vdout1_21ck1170 FIND v(dout1_21) AT=1180.05n

.meas tran vdout1_22ck1170 FIND v(dout1_22) AT=1180.05n

.meas tran vdout1_23ck1170 FIND v(dout1_23) AT=1180.05n

.meas tran vdout1_24ck1170 FIND v(dout1_24) AT=1180.05n

.meas tran vdout1_25ck1170 FIND v(dout1_25) AT=1180.05n

.meas tran vdout1_26ck1170 FIND v(dout1_26) AT=1180.05n

.meas tran vdout1_27ck1170 FIND v(dout1_27) AT=1180.05n

.meas tran vdout1_28ck1170 FIND v(dout1_28) AT=1180.05n

.meas tran vdout1_29ck1170 FIND v(dout1_29) AT=1180.05n

.meas tran vdout1_30ck1170 FIND v(dout1_30) AT=1180.05n

.meas tran vdout1_31ck1170 FIND v(dout1_31) AT=1180.05n

.meas tran vdout1_32ck1170 FIND v(dout1_32) AT=1180.05n

.meas tran vdout1_33ck1170 FIND v(dout1_33) AT=1180.05n

.meas tran vdout1_34ck1170 FIND v(dout1_34) AT=1180.05n

.meas tran vdout1_35ck1170 FIND v(dout1_35) AT=1180.05n

.meas tran vdout1_36ck1170 FIND v(dout1_36) AT=1180.05n

.meas tran vdout1_37ck1170 FIND v(dout1_37) AT=1180.05n

.meas tran vdout1_38ck1170 FIND v(dout1_38) AT=1180.05n

.meas tran vdout1_39ck1170 FIND v(dout1_39) AT=1180.05n

.meas tran vdout1_40ck1170 FIND v(dout1_40) AT=1180.05n

.meas tran vdout1_41ck1170 FIND v(dout1_41) AT=1180.05n

.meas tran vdout1_42ck1170 FIND v(dout1_42) AT=1180.05n

.meas tran vdout1_43ck1170 FIND v(dout1_43) AT=1180.05n

.meas tran vdout1_44ck1170 FIND v(dout1_44) AT=1180.05n

.meas tran vdout1_45ck1170 FIND v(dout1_45) AT=1180.05n

.meas tran vdout1_46ck1170 FIND v(dout1_46) AT=1180.05n

.meas tran vdout1_47ck1170 FIND v(dout1_47) AT=1180.05n

.meas tran vdout1_48ck1170 FIND v(dout1_48) AT=1180.05n

.meas tran vdout1_49ck1170 FIND v(dout1_49) AT=1180.05n

.meas tran vdout1_50ck1170 FIND v(dout1_50) AT=1180.05n

.meas tran vdout1_51ck1170 FIND v(dout1_51) AT=1180.05n

.meas tran vdout1_52ck1170 FIND v(dout1_52) AT=1180.05n

.meas tran vdout1_53ck1170 FIND v(dout1_53) AT=1180.05n

.meas tran vdout1_54ck1170 FIND v(dout1_54) AT=1180.05n

.meas tran vdout1_55ck1170 FIND v(dout1_55) AT=1180.05n

.meas tran vdout1_56ck1170 FIND v(dout1_56) AT=1180.05n

.meas tran vdout1_57ck1170 FIND v(dout1_57) AT=1180.05n

.meas tran vdout1_58ck1170 FIND v(dout1_58) AT=1180.05n

.meas tran vdout1_59ck1170 FIND v(dout1_59) AT=1180.05n

.meas tran vdout1_60ck1170 FIND v(dout1_60) AT=1180.05n

.meas tran vdout1_61ck1170 FIND v(dout1_61) AT=1180.05n

.meas tran vdout1_62ck1170 FIND v(dout1_62) AT=1180.05n

.meas tran vdout1_63ck1170 FIND v(dout1_63) AT=1180.05n

.meas tran vdout1_64ck1170 FIND v(dout1_64) AT=1180.05n

.meas tran vdout1_65ck1170 FIND v(dout1_65) AT=1180.05n

.meas tran vdout1_66ck1170 FIND v(dout1_66) AT=1180.05n

.meas tran vdout1_67ck1170 FIND v(dout1_67) AT=1180.05n

.meas tran vdout1_68ck1170 FIND v(dout1_68) AT=1180.05n

.meas tran vdout1_69ck1170 FIND v(dout1_69) AT=1180.05n

.meas tran vdout1_70ck1170 FIND v(dout1_70) AT=1180.05n

.meas tran vdout1_71ck1170 FIND v(dout1_71) AT=1180.05n

.meas tran vdout1_72ck1170 FIND v(dout1_72) AT=1180.05n

.meas tran vdout1_73ck1170 FIND v(dout1_73) AT=1180.05n

.meas tran vdout1_74ck1170 FIND v(dout1_74) AT=1180.05n

.meas tran vdout1_75ck1170 FIND v(dout1_75) AT=1180.05n

.meas tran vdout1_76ck1170 FIND v(dout1_76) AT=1180.05n

.meas tran vdout1_77ck1170 FIND v(dout1_77) AT=1180.05n

.meas tran vdout1_78ck1170 FIND v(dout1_78) AT=1180.05n

.meas tran vdout1_79ck1170 FIND v(dout1_79) AT=1180.05n

.meas tran vdout1_80ck1170 FIND v(dout1_80) AT=1180.05n

.meas tran vdout1_81ck1170 FIND v(dout1_81) AT=1180.05n

.meas tran vdout1_82ck1170 FIND v(dout1_82) AT=1180.05n

.meas tran vdout1_83ck1170 FIND v(dout1_83) AT=1180.05n

.meas tran vdout1_84ck1170 FIND v(dout1_84) AT=1180.05n

.meas tran vdout1_85ck1170 FIND v(dout1_85) AT=1180.05n

.meas tran vdout1_86ck1170 FIND v(dout1_86) AT=1180.05n

.meas tran vdout1_87ck1170 FIND v(dout1_87) AT=1180.05n

.meas tran vdout1_88ck1170 FIND v(dout1_88) AT=1180.05n

.meas tran vdout1_89ck1170 FIND v(dout1_89) AT=1180.05n

.meas tran vdout1_90ck1170 FIND v(dout1_90) AT=1180.05n

.meas tran vdout1_91ck1170 FIND v(dout1_91) AT=1180.05n

.meas tran vdout1_92ck1170 FIND v(dout1_92) AT=1180.05n

.meas tran vdout1_93ck1170 FIND v(dout1_93) AT=1180.05n

.meas tran vdout1_94ck1170 FIND v(dout1_94) AT=1180.05n

.meas tran vdout1_95ck1170 FIND v(dout1_95) AT=1180.05n

.meas tran vdout1_96ck1170 FIND v(dout1_96) AT=1180.05n

.meas tran vdout1_97ck1170 FIND v(dout1_97) AT=1180.05n

.meas tran vdout1_98ck1170 FIND v(dout1_98) AT=1180.05n

.meas tran vdout1_99ck1170 FIND v(dout1_99) AT=1180.05n

.meas tran vdout1_100ck1170 FIND v(dout1_100) AT=1180.05n

.meas tran vdout1_101ck1170 FIND v(dout1_101) AT=1180.05n

.meas tran vdout1_102ck1170 FIND v(dout1_102) AT=1180.05n

.meas tran vdout1_103ck1170 FIND v(dout1_103) AT=1180.05n

.meas tran vdout1_104ck1170 FIND v(dout1_104) AT=1180.05n

.meas tran vdout1_105ck1170 FIND v(dout1_105) AT=1180.05n

.meas tran vdout1_106ck1170 FIND v(dout1_106) AT=1180.05n

.meas tran vdout1_107ck1170 FIND v(dout1_107) AT=1180.05n

.meas tran vdout1_108ck1170 FIND v(dout1_108) AT=1180.05n

.meas tran vdout1_109ck1170 FIND v(dout1_109) AT=1180.05n

.meas tran vdout1_110ck1170 FIND v(dout1_110) AT=1180.05n

.meas tran vdout1_111ck1170 FIND v(dout1_111) AT=1180.05n

.meas tran vdout1_112ck1170 FIND v(dout1_112) AT=1180.05n

.meas tran vdout1_113ck1170 FIND v(dout1_113) AT=1180.05n

.meas tran vdout1_114ck1170 FIND v(dout1_114) AT=1180.05n

.meas tran vdout1_115ck1170 FIND v(dout1_115) AT=1180.05n

.meas tran vdout1_116ck1170 FIND v(dout1_116) AT=1180.05n

.meas tran vdout1_117ck1170 FIND v(dout1_117) AT=1180.05n

.meas tran vdout1_118ck1170 FIND v(dout1_118) AT=1180.05n

.meas tran vdout1_119ck1170 FIND v(dout1_119) AT=1180.05n

.meas tran vdout1_120ck1170 FIND v(dout1_120) AT=1180.05n

.meas tran vdout1_121ck1170 FIND v(dout1_121) AT=1180.05n

.meas tran vdout1_122ck1170 FIND v(dout1_122) AT=1180.05n

.meas tran vdout1_123ck1170 FIND v(dout1_123) AT=1180.05n

.meas tran vdout1_124ck1170 FIND v(dout1_124) AT=1180.05n

.meas tran vdout1_125ck1170 FIND v(dout1_125) AT=1180.05n

.meas tran vdout1_126ck1170 FIND v(dout1_126) AT=1180.05n

.meas tran vdout1_127ck1170 FIND v(dout1_127) AT=1180.05n

.meas tran vdout1_128ck1170 FIND v(dout1_128) AT=1180.05n

.meas tran vdout1_129ck1170 FIND v(dout1_129) AT=1180.05n

.meas tran vdout1_130ck1170 FIND v(dout1_130) AT=1180.05n

.meas tran vdout1_131ck1170 FIND v(dout1_131) AT=1180.05n

.meas tran vdout1_132ck1170 FIND v(dout1_132) AT=1180.05n

.meas tran vdout1_133ck1170 FIND v(dout1_133) AT=1180.05n

.meas tran vdout1_134ck1170 FIND v(dout1_134) AT=1180.05n

.meas tran vdout1_135ck1170 FIND v(dout1_135) AT=1180.05n

.meas tran vdout1_136ck1170 FIND v(dout1_136) AT=1180.05n

.meas tran vdout1_137ck1170 FIND v(dout1_137) AT=1180.05n

.meas tran vdout1_138ck1170 FIND v(dout1_138) AT=1180.05n

.meas tran vdout1_139ck1170 FIND v(dout1_139) AT=1180.05n

.meas tran vdout1_140ck1170 FIND v(dout1_140) AT=1180.05n

.meas tran vdout1_141ck1170 FIND v(dout1_141) AT=1180.05n

.meas tran vdout1_142ck1170 FIND v(dout1_142) AT=1180.05n

.meas tran vdout1_143ck1170 FIND v(dout1_143) AT=1180.05n

.meas tran vdout1_144ck1170 FIND v(dout1_144) AT=1180.05n

.meas tran vdout1_145ck1170 FIND v(dout1_145) AT=1180.05n

.meas tran vdout1_146ck1170 FIND v(dout1_146) AT=1180.05n

.meas tran vdout1_147ck1170 FIND v(dout1_147) AT=1180.05n

.meas tran vdout1_148ck1170 FIND v(dout1_148) AT=1180.05n

.meas tran vdout1_149ck1170 FIND v(dout1_149) AT=1180.05n

.meas tran vdout1_150ck1170 FIND v(dout1_150) AT=1180.05n

.meas tran vdout1_151ck1170 FIND v(dout1_151) AT=1180.05n

.meas tran vdout1_152ck1170 FIND v(dout1_152) AT=1180.05n

.meas tran vdout1_153ck1170 FIND v(dout1_153) AT=1180.05n

.meas tran vdout1_154ck1170 FIND v(dout1_154) AT=1180.05n

.meas tran vdout1_155ck1170 FIND v(dout1_155) AT=1180.05n

.meas tran vdout1_156ck1170 FIND v(dout1_156) AT=1180.05n

.meas tran vdout1_157ck1170 FIND v(dout1_157) AT=1180.05n

.meas tran vdout1_158ck1170 FIND v(dout1_158) AT=1180.05n

.meas tran vdout1_159ck1170 FIND v(dout1_159) AT=1180.05n

.meas tran vdout1_160ck1170 FIND v(dout1_160) AT=1180.05n

.meas tran vdout1_161ck1170 FIND v(dout1_161) AT=1180.05n

.meas tran vdout1_162ck1170 FIND v(dout1_162) AT=1180.05n

.meas tran vdout1_163ck1170 FIND v(dout1_163) AT=1180.05n

.meas tran vdout1_164ck1170 FIND v(dout1_164) AT=1180.05n

.meas tran vdout1_165ck1170 FIND v(dout1_165) AT=1180.05n

.meas tran vdout1_166ck1170 FIND v(dout1_166) AT=1180.05n

.meas tran vdout1_167ck1170 FIND v(dout1_167) AT=1180.05n

.meas tran vdout1_168ck1170 FIND v(dout1_168) AT=1180.05n

.meas tran vdout1_169ck1170 FIND v(dout1_169) AT=1180.05n

.meas tran vdout1_170ck1170 FIND v(dout1_170) AT=1180.05n

.meas tran vdout1_171ck1170 FIND v(dout1_171) AT=1180.05n

.meas tran vdout1_172ck1170 FIND v(dout1_172) AT=1180.05n

.meas tran vdout1_173ck1170 FIND v(dout1_173) AT=1180.05n

.meas tran vdout1_174ck1170 FIND v(dout1_174) AT=1180.05n

.meas tran vdout1_175ck1170 FIND v(dout1_175) AT=1180.05n

.meas tran vdout1_176ck1170 FIND v(dout1_176) AT=1180.05n

.meas tran vdout1_177ck1170 FIND v(dout1_177) AT=1180.05n

.meas tran vdout1_178ck1170 FIND v(dout1_178) AT=1180.05n

.meas tran vdout1_179ck1170 FIND v(dout1_179) AT=1180.05n

.meas tran vdout1_180ck1170 FIND v(dout1_180) AT=1180.05n

.meas tran vdout1_181ck1170 FIND v(dout1_181) AT=1180.05n

.meas tran vdout1_182ck1170 FIND v(dout1_182) AT=1180.05n

.meas tran vdout1_183ck1170 FIND v(dout1_183) AT=1180.05n

.meas tran vdout1_184ck1170 FIND v(dout1_184) AT=1180.05n

.meas tran vdout1_185ck1170 FIND v(dout1_185) AT=1180.05n

.meas tran vdout1_186ck1170 FIND v(dout1_186) AT=1180.05n

.meas tran vdout1_187ck1170 FIND v(dout1_187) AT=1180.05n

.meas tran vdout1_188ck1170 FIND v(dout1_188) AT=1180.05n

.meas tran vdout1_189ck1170 FIND v(dout1_189) AT=1180.05n

.meas tran vdout1_190ck1170 FIND v(dout1_190) AT=1180.05n

.meas tran vdout1_191ck1170 FIND v(dout1_191) AT=1180.05n

.meas tran vdout1_192ck1170 FIND v(dout1_192) AT=1180.05n

.meas tran vdout1_193ck1170 FIND v(dout1_193) AT=1180.05n

.meas tran vdout1_194ck1170 FIND v(dout1_194) AT=1180.05n

.meas tran vdout1_195ck1170 FIND v(dout1_195) AT=1180.05n

.meas tran vdout1_196ck1170 FIND v(dout1_196) AT=1180.05n

.meas tran vdout1_197ck1170 FIND v(dout1_197) AT=1180.05n

.meas tran vdout1_198ck1170 FIND v(dout1_198) AT=1180.05n

.meas tran vdout1_199ck1170 FIND v(dout1_199) AT=1180.05n

.meas tran vdout1_200ck1170 FIND v(dout1_200) AT=1180.05n

.meas tran vdout1_201ck1170 FIND v(dout1_201) AT=1180.05n

.meas tran vdout1_202ck1170 FIND v(dout1_202) AT=1180.05n

.meas tran vdout1_203ck1170 FIND v(dout1_203) AT=1180.05n

.meas tran vdout1_204ck1170 FIND v(dout1_204) AT=1180.05n

.meas tran vdout1_205ck1170 FIND v(dout1_205) AT=1180.05n

.meas tran vdout1_206ck1170 FIND v(dout1_206) AT=1180.05n

.meas tran vdout1_207ck1170 FIND v(dout1_207) AT=1180.05n

.meas tran vdout1_208ck1170 FIND v(dout1_208) AT=1180.05n

.meas tran vdout1_209ck1170 FIND v(dout1_209) AT=1180.05n

.meas tran vdout1_210ck1170 FIND v(dout1_210) AT=1180.05n

.meas tran vdout1_211ck1170 FIND v(dout1_211) AT=1180.05n

.meas tran vdout1_212ck1170 FIND v(dout1_212) AT=1180.05n

.meas tran vdout1_213ck1170 FIND v(dout1_213) AT=1180.05n

.meas tran vdout1_214ck1170 FIND v(dout1_214) AT=1180.05n

.meas tran vdout1_215ck1170 FIND v(dout1_215) AT=1180.05n

.meas tran vdout1_216ck1170 FIND v(dout1_216) AT=1180.05n

.meas tran vdout1_217ck1170 FIND v(dout1_217) AT=1180.05n

.meas tran vdout1_218ck1170 FIND v(dout1_218) AT=1180.05n

.meas tran vdout1_219ck1170 FIND v(dout1_219) AT=1180.05n

.meas tran vdout1_220ck1170 FIND v(dout1_220) AT=1180.05n

.meas tran vdout1_221ck1170 FIND v(dout1_221) AT=1180.05n

.meas tran vdout1_222ck1170 FIND v(dout1_222) AT=1180.05n

.meas tran vdout1_223ck1170 FIND v(dout1_223) AT=1180.05n

.meas tran vdout1_224ck1170 FIND v(dout1_224) AT=1180.05n

.meas tran vdout1_225ck1170 FIND v(dout1_225) AT=1180.05n

.meas tran vdout1_226ck1170 FIND v(dout1_226) AT=1180.05n

.meas tran vdout1_227ck1170 FIND v(dout1_227) AT=1180.05n

.meas tran vdout1_228ck1170 FIND v(dout1_228) AT=1180.05n

.meas tran vdout1_229ck1170 FIND v(dout1_229) AT=1180.05n

.meas tran vdout1_230ck1170 FIND v(dout1_230) AT=1180.05n

.meas tran vdout1_231ck1170 FIND v(dout1_231) AT=1180.05n

.meas tran vdout1_232ck1170 FIND v(dout1_232) AT=1180.05n

.meas tran vdout1_233ck1170 FIND v(dout1_233) AT=1180.05n

.meas tran vdout1_234ck1170 FIND v(dout1_234) AT=1180.05n

.meas tran vdout1_235ck1170 FIND v(dout1_235) AT=1180.05n

.meas tran vdout1_236ck1170 FIND v(dout1_236) AT=1180.05n

.meas tran vdout1_237ck1170 FIND v(dout1_237) AT=1180.05n

.meas tran vdout1_238ck1170 FIND v(dout1_238) AT=1180.05n

.meas tran vdout1_239ck1170 FIND v(dout1_239) AT=1180.05n

.meas tran vdout1_240ck1170 FIND v(dout1_240) AT=1180.05n

.meas tran vdout1_241ck1170 FIND v(dout1_241) AT=1180.05n

.meas tran vdout1_242ck1170 FIND v(dout1_242) AT=1180.05n

.meas tran vdout1_243ck1170 FIND v(dout1_243) AT=1180.05n

.meas tran vdout1_244ck1170 FIND v(dout1_244) AT=1180.05n

.meas tran vdout1_245ck1170 FIND v(dout1_245) AT=1180.05n

.meas tran vdout1_246ck1170 FIND v(dout1_246) AT=1180.05n

.meas tran vdout1_247ck1170 FIND v(dout1_247) AT=1180.05n

.meas tran vdout1_248ck1170 FIND v(dout1_248) AT=1180.05n

.meas tran vdout1_249ck1170 FIND v(dout1_249) AT=1180.05n

.meas tran vdout1_250ck1170 FIND v(dout1_250) AT=1180.05n

.meas tran vdout1_251ck1170 FIND v(dout1_251) AT=1180.05n

.meas tran vdout1_252ck1170 FIND v(dout1_252) AT=1180.05n

.meas tran vdout1_253ck1170 FIND v(dout1_253) AT=1180.05n

.meas tran vdout1_254ck1170 FIND v(dout1_254) AT=1180.05n

.meas tran vdout1_255ck1170 FIND v(dout1_255) AT=1180.05n

.meas tran vdout1_256ck1170 FIND v(dout1_256) AT=1180.05n

.meas tran vdout1_0ck1250 FIND v(dout1_0) AT=1260.05n

.meas tran vdout1_1ck1250 FIND v(dout1_1) AT=1260.05n

.meas tran vdout1_2ck1250 FIND v(dout1_2) AT=1260.05n

.meas tran vdout1_3ck1250 FIND v(dout1_3) AT=1260.05n

.meas tran vdout1_4ck1250 FIND v(dout1_4) AT=1260.05n

.meas tran vdout1_5ck1250 FIND v(dout1_5) AT=1260.05n

.meas tran vdout1_6ck1250 FIND v(dout1_6) AT=1260.05n

.meas tran vdout1_7ck1250 FIND v(dout1_7) AT=1260.05n

.meas tran vdout1_8ck1250 FIND v(dout1_8) AT=1260.05n

.meas tran vdout1_9ck1250 FIND v(dout1_9) AT=1260.05n

.meas tran vdout1_10ck1250 FIND v(dout1_10) AT=1260.05n

.meas tran vdout1_11ck1250 FIND v(dout1_11) AT=1260.05n

.meas tran vdout1_12ck1250 FIND v(dout1_12) AT=1260.05n

.meas tran vdout1_13ck1250 FIND v(dout1_13) AT=1260.05n

.meas tran vdout1_14ck1250 FIND v(dout1_14) AT=1260.05n

.meas tran vdout1_15ck1250 FIND v(dout1_15) AT=1260.05n

.meas tran vdout1_16ck1250 FIND v(dout1_16) AT=1260.05n

.meas tran vdout1_17ck1250 FIND v(dout1_17) AT=1260.05n

.meas tran vdout1_18ck1250 FIND v(dout1_18) AT=1260.05n

.meas tran vdout1_19ck1250 FIND v(dout1_19) AT=1260.05n

.meas tran vdout1_20ck1250 FIND v(dout1_20) AT=1260.05n

.meas tran vdout1_21ck1250 FIND v(dout1_21) AT=1260.05n

.meas tran vdout1_22ck1250 FIND v(dout1_22) AT=1260.05n

.meas tran vdout1_23ck1250 FIND v(dout1_23) AT=1260.05n

.meas tran vdout1_24ck1250 FIND v(dout1_24) AT=1260.05n

.meas tran vdout1_25ck1250 FIND v(dout1_25) AT=1260.05n

.meas tran vdout1_26ck1250 FIND v(dout1_26) AT=1260.05n

.meas tran vdout1_27ck1250 FIND v(dout1_27) AT=1260.05n

.meas tran vdout1_28ck1250 FIND v(dout1_28) AT=1260.05n

.meas tran vdout1_29ck1250 FIND v(dout1_29) AT=1260.05n

.meas tran vdout1_30ck1250 FIND v(dout1_30) AT=1260.05n

.meas tran vdout1_31ck1250 FIND v(dout1_31) AT=1260.05n

.meas tran vdout1_32ck1250 FIND v(dout1_32) AT=1260.05n

.meas tran vdout1_33ck1250 FIND v(dout1_33) AT=1260.05n

.meas tran vdout1_34ck1250 FIND v(dout1_34) AT=1260.05n

.meas tran vdout1_35ck1250 FIND v(dout1_35) AT=1260.05n

.meas tran vdout1_36ck1250 FIND v(dout1_36) AT=1260.05n

.meas tran vdout1_37ck1250 FIND v(dout1_37) AT=1260.05n

.meas tran vdout1_38ck1250 FIND v(dout1_38) AT=1260.05n

.meas tran vdout1_39ck1250 FIND v(dout1_39) AT=1260.05n

.meas tran vdout1_40ck1250 FIND v(dout1_40) AT=1260.05n

.meas tran vdout1_41ck1250 FIND v(dout1_41) AT=1260.05n

.meas tran vdout1_42ck1250 FIND v(dout1_42) AT=1260.05n

.meas tran vdout1_43ck1250 FIND v(dout1_43) AT=1260.05n

.meas tran vdout1_44ck1250 FIND v(dout1_44) AT=1260.05n

.meas tran vdout1_45ck1250 FIND v(dout1_45) AT=1260.05n

.meas tran vdout1_46ck1250 FIND v(dout1_46) AT=1260.05n

.meas tran vdout1_47ck1250 FIND v(dout1_47) AT=1260.05n

.meas tran vdout1_48ck1250 FIND v(dout1_48) AT=1260.05n

.meas tran vdout1_49ck1250 FIND v(dout1_49) AT=1260.05n

.meas tran vdout1_50ck1250 FIND v(dout1_50) AT=1260.05n

.meas tran vdout1_51ck1250 FIND v(dout1_51) AT=1260.05n

.meas tran vdout1_52ck1250 FIND v(dout1_52) AT=1260.05n

.meas tran vdout1_53ck1250 FIND v(dout1_53) AT=1260.05n

.meas tran vdout1_54ck1250 FIND v(dout1_54) AT=1260.05n

.meas tran vdout1_55ck1250 FIND v(dout1_55) AT=1260.05n

.meas tran vdout1_56ck1250 FIND v(dout1_56) AT=1260.05n

.meas tran vdout1_57ck1250 FIND v(dout1_57) AT=1260.05n

.meas tran vdout1_58ck1250 FIND v(dout1_58) AT=1260.05n

.meas tran vdout1_59ck1250 FIND v(dout1_59) AT=1260.05n

.meas tran vdout1_60ck1250 FIND v(dout1_60) AT=1260.05n

.meas tran vdout1_61ck1250 FIND v(dout1_61) AT=1260.05n

.meas tran vdout1_62ck1250 FIND v(dout1_62) AT=1260.05n

.meas tran vdout1_63ck1250 FIND v(dout1_63) AT=1260.05n

.meas tran vdout1_64ck1250 FIND v(dout1_64) AT=1260.05n

.meas tran vdout1_65ck1250 FIND v(dout1_65) AT=1260.05n

.meas tran vdout1_66ck1250 FIND v(dout1_66) AT=1260.05n

.meas tran vdout1_67ck1250 FIND v(dout1_67) AT=1260.05n

.meas tran vdout1_68ck1250 FIND v(dout1_68) AT=1260.05n

.meas tran vdout1_69ck1250 FIND v(dout1_69) AT=1260.05n

.meas tran vdout1_70ck1250 FIND v(dout1_70) AT=1260.05n

.meas tran vdout1_71ck1250 FIND v(dout1_71) AT=1260.05n

.meas tran vdout1_72ck1250 FIND v(dout1_72) AT=1260.05n

.meas tran vdout1_73ck1250 FIND v(dout1_73) AT=1260.05n

.meas tran vdout1_74ck1250 FIND v(dout1_74) AT=1260.05n

.meas tran vdout1_75ck1250 FIND v(dout1_75) AT=1260.05n

.meas tran vdout1_76ck1250 FIND v(dout1_76) AT=1260.05n

.meas tran vdout1_77ck1250 FIND v(dout1_77) AT=1260.05n

.meas tran vdout1_78ck1250 FIND v(dout1_78) AT=1260.05n

.meas tran vdout1_79ck1250 FIND v(dout1_79) AT=1260.05n

.meas tran vdout1_80ck1250 FIND v(dout1_80) AT=1260.05n

.meas tran vdout1_81ck1250 FIND v(dout1_81) AT=1260.05n

.meas tran vdout1_82ck1250 FIND v(dout1_82) AT=1260.05n

.meas tran vdout1_83ck1250 FIND v(dout1_83) AT=1260.05n

.meas tran vdout1_84ck1250 FIND v(dout1_84) AT=1260.05n

.meas tran vdout1_85ck1250 FIND v(dout1_85) AT=1260.05n

.meas tran vdout1_86ck1250 FIND v(dout1_86) AT=1260.05n

.meas tran vdout1_87ck1250 FIND v(dout1_87) AT=1260.05n

.meas tran vdout1_88ck1250 FIND v(dout1_88) AT=1260.05n

.meas tran vdout1_89ck1250 FIND v(dout1_89) AT=1260.05n

.meas tran vdout1_90ck1250 FIND v(dout1_90) AT=1260.05n

.meas tran vdout1_91ck1250 FIND v(dout1_91) AT=1260.05n

.meas tran vdout1_92ck1250 FIND v(dout1_92) AT=1260.05n

.meas tran vdout1_93ck1250 FIND v(dout1_93) AT=1260.05n

.meas tran vdout1_94ck1250 FIND v(dout1_94) AT=1260.05n

.meas tran vdout1_95ck1250 FIND v(dout1_95) AT=1260.05n

.meas tran vdout1_96ck1250 FIND v(dout1_96) AT=1260.05n

.meas tran vdout1_97ck1250 FIND v(dout1_97) AT=1260.05n

.meas tran vdout1_98ck1250 FIND v(dout1_98) AT=1260.05n

.meas tran vdout1_99ck1250 FIND v(dout1_99) AT=1260.05n

.meas tran vdout1_100ck1250 FIND v(dout1_100) AT=1260.05n

.meas tran vdout1_101ck1250 FIND v(dout1_101) AT=1260.05n

.meas tran vdout1_102ck1250 FIND v(dout1_102) AT=1260.05n

.meas tran vdout1_103ck1250 FIND v(dout1_103) AT=1260.05n

.meas tran vdout1_104ck1250 FIND v(dout1_104) AT=1260.05n

.meas tran vdout1_105ck1250 FIND v(dout1_105) AT=1260.05n

.meas tran vdout1_106ck1250 FIND v(dout1_106) AT=1260.05n

.meas tran vdout1_107ck1250 FIND v(dout1_107) AT=1260.05n

.meas tran vdout1_108ck1250 FIND v(dout1_108) AT=1260.05n

.meas tran vdout1_109ck1250 FIND v(dout1_109) AT=1260.05n

.meas tran vdout1_110ck1250 FIND v(dout1_110) AT=1260.05n

.meas tran vdout1_111ck1250 FIND v(dout1_111) AT=1260.05n

.meas tran vdout1_112ck1250 FIND v(dout1_112) AT=1260.05n

.meas tran vdout1_113ck1250 FIND v(dout1_113) AT=1260.05n

.meas tran vdout1_114ck1250 FIND v(dout1_114) AT=1260.05n

.meas tran vdout1_115ck1250 FIND v(dout1_115) AT=1260.05n

.meas tran vdout1_116ck1250 FIND v(dout1_116) AT=1260.05n

.meas tran vdout1_117ck1250 FIND v(dout1_117) AT=1260.05n

.meas tran vdout1_118ck1250 FIND v(dout1_118) AT=1260.05n

.meas tran vdout1_119ck1250 FIND v(dout1_119) AT=1260.05n

.meas tran vdout1_120ck1250 FIND v(dout1_120) AT=1260.05n

.meas tran vdout1_121ck1250 FIND v(dout1_121) AT=1260.05n

.meas tran vdout1_122ck1250 FIND v(dout1_122) AT=1260.05n

.meas tran vdout1_123ck1250 FIND v(dout1_123) AT=1260.05n

.meas tran vdout1_124ck1250 FIND v(dout1_124) AT=1260.05n

.meas tran vdout1_125ck1250 FIND v(dout1_125) AT=1260.05n

.meas tran vdout1_126ck1250 FIND v(dout1_126) AT=1260.05n

.meas tran vdout1_127ck1250 FIND v(dout1_127) AT=1260.05n

.meas tran vdout1_128ck1250 FIND v(dout1_128) AT=1260.05n

.meas tran vdout1_129ck1250 FIND v(dout1_129) AT=1260.05n

.meas tran vdout1_130ck1250 FIND v(dout1_130) AT=1260.05n

.meas tran vdout1_131ck1250 FIND v(dout1_131) AT=1260.05n

.meas tran vdout1_132ck1250 FIND v(dout1_132) AT=1260.05n

.meas tran vdout1_133ck1250 FIND v(dout1_133) AT=1260.05n

.meas tran vdout1_134ck1250 FIND v(dout1_134) AT=1260.05n

.meas tran vdout1_135ck1250 FIND v(dout1_135) AT=1260.05n

.meas tran vdout1_136ck1250 FIND v(dout1_136) AT=1260.05n

.meas tran vdout1_137ck1250 FIND v(dout1_137) AT=1260.05n

.meas tran vdout1_138ck1250 FIND v(dout1_138) AT=1260.05n

.meas tran vdout1_139ck1250 FIND v(dout1_139) AT=1260.05n

.meas tran vdout1_140ck1250 FIND v(dout1_140) AT=1260.05n

.meas tran vdout1_141ck1250 FIND v(dout1_141) AT=1260.05n

.meas tran vdout1_142ck1250 FIND v(dout1_142) AT=1260.05n

.meas tran vdout1_143ck1250 FIND v(dout1_143) AT=1260.05n

.meas tran vdout1_144ck1250 FIND v(dout1_144) AT=1260.05n

.meas tran vdout1_145ck1250 FIND v(dout1_145) AT=1260.05n

.meas tran vdout1_146ck1250 FIND v(dout1_146) AT=1260.05n

.meas tran vdout1_147ck1250 FIND v(dout1_147) AT=1260.05n

.meas tran vdout1_148ck1250 FIND v(dout1_148) AT=1260.05n

.meas tran vdout1_149ck1250 FIND v(dout1_149) AT=1260.05n

.meas tran vdout1_150ck1250 FIND v(dout1_150) AT=1260.05n

.meas tran vdout1_151ck1250 FIND v(dout1_151) AT=1260.05n

.meas tran vdout1_152ck1250 FIND v(dout1_152) AT=1260.05n

.meas tran vdout1_153ck1250 FIND v(dout1_153) AT=1260.05n

.meas tran vdout1_154ck1250 FIND v(dout1_154) AT=1260.05n

.meas tran vdout1_155ck1250 FIND v(dout1_155) AT=1260.05n

.meas tran vdout1_156ck1250 FIND v(dout1_156) AT=1260.05n

.meas tran vdout1_157ck1250 FIND v(dout1_157) AT=1260.05n

.meas tran vdout1_158ck1250 FIND v(dout1_158) AT=1260.05n

.meas tran vdout1_159ck1250 FIND v(dout1_159) AT=1260.05n

.meas tran vdout1_160ck1250 FIND v(dout1_160) AT=1260.05n

.meas tran vdout1_161ck1250 FIND v(dout1_161) AT=1260.05n

.meas tran vdout1_162ck1250 FIND v(dout1_162) AT=1260.05n

.meas tran vdout1_163ck1250 FIND v(dout1_163) AT=1260.05n

.meas tran vdout1_164ck1250 FIND v(dout1_164) AT=1260.05n

.meas tran vdout1_165ck1250 FIND v(dout1_165) AT=1260.05n

.meas tran vdout1_166ck1250 FIND v(dout1_166) AT=1260.05n

.meas tran vdout1_167ck1250 FIND v(dout1_167) AT=1260.05n

.meas tran vdout1_168ck1250 FIND v(dout1_168) AT=1260.05n

.meas tran vdout1_169ck1250 FIND v(dout1_169) AT=1260.05n

.meas tran vdout1_170ck1250 FIND v(dout1_170) AT=1260.05n

.meas tran vdout1_171ck1250 FIND v(dout1_171) AT=1260.05n

.meas tran vdout1_172ck1250 FIND v(dout1_172) AT=1260.05n

.meas tran vdout1_173ck1250 FIND v(dout1_173) AT=1260.05n

.meas tran vdout1_174ck1250 FIND v(dout1_174) AT=1260.05n

.meas tran vdout1_175ck1250 FIND v(dout1_175) AT=1260.05n

.meas tran vdout1_176ck1250 FIND v(dout1_176) AT=1260.05n

.meas tran vdout1_177ck1250 FIND v(dout1_177) AT=1260.05n

.meas tran vdout1_178ck1250 FIND v(dout1_178) AT=1260.05n

.meas tran vdout1_179ck1250 FIND v(dout1_179) AT=1260.05n

.meas tran vdout1_180ck1250 FIND v(dout1_180) AT=1260.05n

.meas tran vdout1_181ck1250 FIND v(dout1_181) AT=1260.05n

.meas tran vdout1_182ck1250 FIND v(dout1_182) AT=1260.05n

.meas tran vdout1_183ck1250 FIND v(dout1_183) AT=1260.05n

.meas tran vdout1_184ck1250 FIND v(dout1_184) AT=1260.05n

.meas tran vdout1_185ck1250 FIND v(dout1_185) AT=1260.05n

.meas tran vdout1_186ck1250 FIND v(dout1_186) AT=1260.05n

.meas tran vdout1_187ck1250 FIND v(dout1_187) AT=1260.05n

.meas tran vdout1_188ck1250 FIND v(dout1_188) AT=1260.05n

.meas tran vdout1_189ck1250 FIND v(dout1_189) AT=1260.05n

.meas tran vdout1_190ck1250 FIND v(dout1_190) AT=1260.05n

.meas tran vdout1_191ck1250 FIND v(dout1_191) AT=1260.05n

.meas tran vdout1_192ck1250 FIND v(dout1_192) AT=1260.05n

.meas tran vdout1_193ck1250 FIND v(dout1_193) AT=1260.05n

.meas tran vdout1_194ck1250 FIND v(dout1_194) AT=1260.05n

.meas tran vdout1_195ck1250 FIND v(dout1_195) AT=1260.05n

.meas tran vdout1_196ck1250 FIND v(dout1_196) AT=1260.05n

.meas tran vdout1_197ck1250 FIND v(dout1_197) AT=1260.05n

.meas tran vdout1_198ck1250 FIND v(dout1_198) AT=1260.05n

.meas tran vdout1_199ck1250 FIND v(dout1_199) AT=1260.05n

.meas tran vdout1_200ck1250 FIND v(dout1_200) AT=1260.05n

.meas tran vdout1_201ck1250 FIND v(dout1_201) AT=1260.05n

.meas tran vdout1_202ck1250 FIND v(dout1_202) AT=1260.05n

.meas tran vdout1_203ck1250 FIND v(dout1_203) AT=1260.05n

.meas tran vdout1_204ck1250 FIND v(dout1_204) AT=1260.05n

.meas tran vdout1_205ck1250 FIND v(dout1_205) AT=1260.05n

.meas tran vdout1_206ck1250 FIND v(dout1_206) AT=1260.05n

.meas tran vdout1_207ck1250 FIND v(dout1_207) AT=1260.05n

.meas tran vdout1_208ck1250 FIND v(dout1_208) AT=1260.05n

.meas tran vdout1_209ck1250 FIND v(dout1_209) AT=1260.05n

.meas tran vdout1_210ck1250 FIND v(dout1_210) AT=1260.05n

.meas tran vdout1_211ck1250 FIND v(dout1_211) AT=1260.05n

.meas tran vdout1_212ck1250 FIND v(dout1_212) AT=1260.05n

.meas tran vdout1_213ck1250 FIND v(dout1_213) AT=1260.05n

.meas tran vdout1_214ck1250 FIND v(dout1_214) AT=1260.05n

.meas tran vdout1_215ck1250 FIND v(dout1_215) AT=1260.05n

.meas tran vdout1_216ck1250 FIND v(dout1_216) AT=1260.05n

.meas tran vdout1_217ck1250 FIND v(dout1_217) AT=1260.05n

.meas tran vdout1_218ck1250 FIND v(dout1_218) AT=1260.05n

.meas tran vdout1_219ck1250 FIND v(dout1_219) AT=1260.05n

.meas tran vdout1_220ck1250 FIND v(dout1_220) AT=1260.05n

.meas tran vdout1_221ck1250 FIND v(dout1_221) AT=1260.05n

.meas tran vdout1_222ck1250 FIND v(dout1_222) AT=1260.05n

.meas tran vdout1_223ck1250 FIND v(dout1_223) AT=1260.05n

.meas tran vdout1_224ck1250 FIND v(dout1_224) AT=1260.05n

.meas tran vdout1_225ck1250 FIND v(dout1_225) AT=1260.05n

.meas tran vdout1_226ck1250 FIND v(dout1_226) AT=1260.05n

.meas tran vdout1_227ck1250 FIND v(dout1_227) AT=1260.05n

.meas tran vdout1_228ck1250 FIND v(dout1_228) AT=1260.05n

.meas tran vdout1_229ck1250 FIND v(dout1_229) AT=1260.05n

.meas tran vdout1_230ck1250 FIND v(dout1_230) AT=1260.05n

.meas tran vdout1_231ck1250 FIND v(dout1_231) AT=1260.05n

.meas tran vdout1_232ck1250 FIND v(dout1_232) AT=1260.05n

.meas tran vdout1_233ck1250 FIND v(dout1_233) AT=1260.05n

.meas tran vdout1_234ck1250 FIND v(dout1_234) AT=1260.05n

.meas tran vdout1_235ck1250 FIND v(dout1_235) AT=1260.05n

.meas tran vdout1_236ck1250 FIND v(dout1_236) AT=1260.05n

.meas tran vdout1_237ck1250 FIND v(dout1_237) AT=1260.05n

.meas tran vdout1_238ck1250 FIND v(dout1_238) AT=1260.05n

.meas tran vdout1_239ck1250 FIND v(dout1_239) AT=1260.05n

.meas tran vdout1_240ck1250 FIND v(dout1_240) AT=1260.05n

.meas tran vdout1_241ck1250 FIND v(dout1_241) AT=1260.05n

.meas tran vdout1_242ck1250 FIND v(dout1_242) AT=1260.05n

.meas tran vdout1_243ck1250 FIND v(dout1_243) AT=1260.05n

.meas tran vdout1_244ck1250 FIND v(dout1_244) AT=1260.05n

.meas tran vdout1_245ck1250 FIND v(dout1_245) AT=1260.05n

.meas tran vdout1_246ck1250 FIND v(dout1_246) AT=1260.05n

.meas tran vdout1_247ck1250 FIND v(dout1_247) AT=1260.05n

.meas tran vdout1_248ck1250 FIND v(dout1_248) AT=1260.05n

.meas tran vdout1_249ck1250 FIND v(dout1_249) AT=1260.05n

.meas tran vdout1_250ck1250 FIND v(dout1_250) AT=1260.05n

.meas tran vdout1_251ck1250 FIND v(dout1_251) AT=1260.05n

.meas tran vdout1_252ck1250 FIND v(dout1_252) AT=1260.05n

.meas tran vdout1_253ck1250 FIND v(dout1_253) AT=1260.05n

.meas tran vdout1_254ck1250 FIND v(dout1_254) AT=1260.05n

.meas tran vdout1_255ck1250 FIND v(dout1_255) AT=1260.05n

.meas tran vdout1_256ck1250 FIND v(dout1_256) AT=1260.05n

.meas tran vdout1_0ck1260 FIND v(dout1_0) AT=1270.05n

.meas tran vdout1_1ck1260 FIND v(dout1_1) AT=1270.05n

.meas tran vdout1_2ck1260 FIND v(dout1_2) AT=1270.05n

.meas tran vdout1_3ck1260 FIND v(dout1_3) AT=1270.05n

.meas tran vdout1_4ck1260 FIND v(dout1_4) AT=1270.05n

.meas tran vdout1_5ck1260 FIND v(dout1_5) AT=1270.05n

.meas tran vdout1_6ck1260 FIND v(dout1_6) AT=1270.05n

.meas tran vdout1_7ck1260 FIND v(dout1_7) AT=1270.05n

.meas tran vdout1_8ck1260 FIND v(dout1_8) AT=1270.05n

.meas tran vdout1_9ck1260 FIND v(dout1_9) AT=1270.05n

.meas tran vdout1_10ck1260 FIND v(dout1_10) AT=1270.05n

.meas tran vdout1_11ck1260 FIND v(dout1_11) AT=1270.05n

.meas tran vdout1_12ck1260 FIND v(dout1_12) AT=1270.05n

.meas tran vdout1_13ck1260 FIND v(dout1_13) AT=1270.05n

.meas tran vdout1_14ck1260 FIND v(dout1_14) AT=1270.05n

.meas tran vdout1_15ck1260 FIND v(dout1_15) AT=1270.05n

.meas tran vdout1_16ck1260 FIND v(dout1_16) AT=1270.05n

.meas tran vdout1_17ck1260 FIND v(dout1_17) AT=1270.05n

.meas tran vdout1_18ck1260 FIND v(dout1_18) AT=1270.05n

.meas tran vdout1_19ck1260 FIND v(dout1_19) AT=1270.05n

.meas tran vdout1_20ck1260 FIND v(dout1_20) AT=1270.05n

.meas tran vdout1_21ck1260 FIND v(dout1_21) AT=1270.05n

.meas tran vdout1_22ck1260 FIND v(dout1_22) AT=1270.05n

.meas tran vdout1_23ck1260 FIND v(dout1_23) AT=1270.05n

.meas tran vdout1_24ck1260 FIND v(dout1_24) AT=1270.05n

.meas tran vdout1_25ck1260 FIND v(dout1_25) AT=1270.05n

.meas tran vdout1_26ck1260 FIND v(dout1_26) AT=1270.05n

.meas tran vdout1_27ck1260 FIND v(dout1_27) AT=1270.05n

.meas tran vdout1_28ck1260 FIND v(dout1_28) AT=1270.05n

.meas tran vdout1_29ck1260 FIND v(dout1_29) AT=1270.05n

.meas tran vdout1_30ck1260 FIND v(dout1_30) AT=1270.05n

.meas tran vdout1_31ck1260 FIND v(dout1_31) AT=1270.05n

.meas tran vdout1_32ck1260 FIND v(dout1_32) AT=1270.05n

.meas tran vdout1_33ck1260 FIND v(dout1_33) AT=1270.05n

.meas tran vdout1_34ck1260 FIND v(dout1_34) AT=1270.05n

.meas tran vdout1_35ck1260 FIND v(dout1_35) AT=1270.05n

.meas tran vdout1_36ck1260 FIND v(dout1_36) AT=1270.05n

.meas tran vdout1_37ck1260 FIND v(dout1_37) AT=1270.05n

.meas tran vdout1_38ck1260 FIND v(dout1_38) AT=1270.05n

.meas tran vdout1_39ck1260 FIND v(dout1_39) AT=1270.05n

.meas tran vdout1_40ck1260 FIND v(dout1_40) AT=1270.05n

.meas tran vdout1_41ck1260 FIND v(dout1_41) AT=1270.05n

.meas tran vdout1_42ck1260 FIND v(dout1_42) AT=1270.05n

.meas tran vdout1_43ck1260 FIND v(dout1_43) AT=1270.05n

.meas tran vdout1_44ck1260 FIND v(dout1_44) AT=1270.05n

.meas tran vdout1_45ck1260 FIND v(dout1_45) AT=1270.05n

.meas tran vdout1_46ck1260 FIND v(dout1_46) AT=1270.05n

.meas tran vdout1_47ck1260 FIND v(dout1_47) AT=1270.05n

.meas tran vdout1_48ck1260 FIND v(dout1_48) AT=1270.05n

.meas tran vdout1_49ck1260 FIND v(dout1_49) AT=1270.05n

.meas tran vdout1_50ck1260 FIND v(dout1_50) AT=1270.05n

.meas tran vdout1_51ck1260 FIND v(dout1_51) AT=1270.05n

.meas tran vdout1_52ck1260 FIND v(dout1_52) AT=1270.05n

.meas tran vdout1_53ck1260 FIND v(dout1_53) AT=1270.05n

.meas tran vdout1_54ck1260 FIND v(dout1_54) AT=1270.05n

.meas tran vdout1_55ck1260 FIND v(dout1_55) AT=1270.05n

.meas tran vdout1_56ck1260 FIND v(dout1_56) AT=1270.05n

.meas tran vdout1_57ck1260 FIND v(dout1_57) AT=1270.05n

.meas tran vdout1_58ck1260 FIND v(dout1_58) AT=1270.05n

.meas tran vdout1_59ck1260 FIND v(dout1_59) AT=1270.05n

.meas tran vdout1_60ck1260 FIND v(dout1_60) AT=1270.05n

.meas tran vdout1_61ck1260 FIND v(dout1_61) AT=1270.05n

.meas tran vdout1_62ck1260 FIND v(dout1_62) AT=1270.05n

.meas tran vdout1_63ck1260 FIND v(dout1_63) AT=1270.05n

.meas tran vdout1_64ck1260 FIND v(dout1_64) AT=1270.05n

.meas tran vdout1_65ck1260 FIND v(dout1_65) AT=1270.05n

.meas tran vdout1_66ck1260 FIND v(dout1_66) AT=1270.05n

.meas tran vdout1_67ck1260 FIND v(dout1_67) AT=1270.05n

.meas tran vdout1_68ck1260 FIND v(dout1_68) AT=1270.05n

.meas tran vdout1_69ck1260 FIND v(dout1_69) AT=1270.05n

.meas tran vdout1_70ck1260 FIND v(dout1_70) AT=1270.05n

.meas tran vdout1_71ck1260 FIND v(dout1_71) AT=1270.05n

.meas tran vdout1_72ck1260 FIND v(dout1_72) AT=1270.05n

.meas tran vdout1_73ck1260 FIND v(dout1_73) AT=1270.05n

.meas tran vdout1_74ck1260 FIND v(dout1_74) AT=1270.05n

.meas tran vdout1_75ck1260 FIND v(dout1_75) AT=1270.05n

.meas tran vdout1_76ck1260 FIND v(dout1_76) AT=1270.05n

.meas tran vdout1_77ck1260 FIND v(dout1_77) AT=1270.05n

.meas tran vdout1_78ck1260 FIND v(dout1_78) AT=1270.05n

.meas tran vdout1_79ck1260 FIND v(dout1_79) AT=1270.05n

.meas tran vdout1_80ck1260 FIND v(dout1_80) AT=1270.05n

.meas tran vdout1_81ck1260 FIND v(dout1_81) AT=1270.05n

.meas tran vdout1_82ck1260 FIND v(dout1_82) AT=1270.05n

.meas tran vdout1_83ck1260 FIND v(dout1_83) AT=1270.05n

.meas tran vdout1_84ck1260 FIND v(dout1_84) AT=1270.05n

.meas tran vdout1_85ck1260 FIND v(dout1_85) AT=1270.05n

.meas tran vdout1_86ck1260 FIND v(dout1_86) AT=1270.05n

.meas tran vdout1_87ck1260 FIND v(dout1_87) AT=1270.05n

.meas tran vdout1_88ck1260 FIND v(dout1_88) AT=1270.05n

.meas tran vdout1_89ck1260 FIND v(dout1_89) AT=1270.05n

.meas tran vdout1_90ck1260 FIND v(dout1_90) AT=1270.05n

.meas tran vdout1_91ck1260 FIND v(dout1_91) AT=1270.05n

.meas tran vdout1_92ck1260 FIND v(dout1_92) AT=1270.05n

.meas tran vdout1_93ck1260 FIND v(dout1_93) AT=1270.05n

.meas tran vdout1_94ck1260 FIND v(dout1_94) AT=1270.05n

.meas tran vdout1_95ck1260 FIND v(dout1_95) AT=1270.05n

.meas tran vdout1_96ck1260 FIND v(dout1_96) AT=1270.05n

.meas tran vdout1_97ck1260 FIND v(dout1_97) AT=1270.05n

.meas tran vdout1_98ck1260 FIND v(dout1_98) AT=1270.05n

.meas tran vdout1_99ck1260 FIND v(dout1_99) AT=1270.05n

.meas tran vdout1_100ck1260 FIND v(dout1_100) AT=1270.05n

.meas tran vdout1_101ck1260 FIND v(dout1_101) AT=1270.05n

.meas tran vdout1_102ck1260 FIND v(dout1_102) AT=1270.05n

.meas tran vdout1_103ck1260 FIND v(dout1_103) AT=1270.05n

.meas tran vdout1_104ck1260 FIND v(dout1_104) AT=1270.05n

.meas tran vdout1_105ck1260 FIND v(dout1_105) AT=1270.05n

.meas tran vdout1_106ck1260 FIND v(dout1_106) AT=1270.05n

.meas tran vdout1_107ck1260 FIND v(dout1_107) AT=1270.05n

.meas tran vdout1_108ck1260 FIND v(dout1_108) AT=1270.05n

.meas tran vdout1_109ck1260 FIND v(dout1_109) AT=1270.05n

.meas tran vdout1_110ck1260 FIND v(dout1_110) AT=1270.05n

.meas tran vdout1_111ck1260 FIND v(dout1_111) AT=1270.05n

.meas tran vdout1_112ck1260 FIND v(dout1_112) AT=1270.05n

.meas tran vdout1_113ck1260 FIND v(dout1_113) AT=1270.05n

.meas tran vdout1_114ck1260 FIND v(dout1_114) AT=1270.05n

.meas tran vdout1_115ck1260 FIND v(dout1_115) AT=1270.05n

.meas tran vdout1_116ck1260 FIND v(dout1_116) AT=1270.05n

.meas tran vdout1_117ck1260 FIND v(dout1_117) AT=1270.05n

.meas tran vdout1_118ck1260 FIND v(dout1_118) AT=1270.05n

.meas tran vdout1_119ck1260 FIND v(dout1_119) AT=1270.05n

.meas tran vdout1_120ck1260 FIND v(dout1_120) AT=1270.05n

.meas tran vdout1_121ck1260 FIND v(dout1_121) AT=1270.05n

.meas tran vdout1_122ck1260 FIND v(dout1_122) AT=1270.05n

.meas tran vdout1_123ck1260 FIND v(dout1_123) AT=1270.05n

.meas tran vdout1_124ck1260 FIND v(dout1_124) AT=1270.05n

.meas tran vdout1_125ck1260 FIND v(dout1_125) AT=1270.05n

.meas tran vdout1_126ck1260 FIND v(dout1_126) AT=1270.05n

.meas tran vdout1_127ck1260 FIND v(dout1_127) AT=1270.05n

.meas tran vdout1_128ck1260 FIND v(dout1_128) AT=1270.05n

.meas tran vdout1_129ck1260 FIND v(dout1_129) AT=1270.05n

.meas tran vdout1_130ck1260 FIND v(dout1_130) AT=1270.05n

.meas tran vdout1_131ck1260 FIND v(dout1_131) AT=1270.05n

.meas tran vdout1_132ck1260 FIND v(dout1_132) AT=1270.05n

.meas tran vdout1_133ck1260 FIND v(dout1_133) AT=1270.05n

.meas tran vdout1_134ck1260 FIND v(dout1_134) AT=1270.05n

.meas tran vdout1_135ck1260 FIND v(dout1_135) AT=1270.05n

.meas tran vdout1_136ck1260 FIND v(dout1_136) AT=1270.05n

.meas tran vdout1_137ck1260 FIND v(dout1_137) AT=1270.05n

.meas tran vdout1_138ck1260 FIND v(dout1_138) AT=1270.05n

.meas tran vdout1_139ck1260 FIND v(dout1_139) AT=1270.05n

.meas tran vdout1_140ck1260 FIND v(dout1_140) AT=1270.05n

.meas tran vdout1_141ck1260 FIND v(dout1_141) AT=1270.05n

.meas tran vdout1_142ck1260 FIND v(dout1_142) AT=1270.05n

.meas tran vdout1_143ck1260 FIND v(dout1_143) AT=1270.05n

.meas tran vdout1_144ck1260 FIND v(dout1_144) AT=1270.05n

.meas tran vdout1_145ck1260 FIND v(dout1_145) AT=1270.05n

.meas tran vdout1_146ck1260 FIND v(dout1_146) AT=1270.05n

.meas tran vdout1_147ck1260 FIND v(dout1_147) AT=1270.05n

.meas tran vdout1_148ck1260 FIND v(dout1_148) AT=1270.05n

.meas tran vdout1_149ck1260 FIND v(dout1_149) AT=1270.05n

.meas tran vdout1_150ck1260 FIND v(dout1_150) AT=1270.05n

.meas tran vdout1_151ck1260 FIND v(dout1_151) AT=1270.05n

.meas tran vdout1_152ck1260 FIND v(dout1_152) AT=1270.05n

.meas tran vdout1_153ck1260 FIND v(dout1_153) AT=1270.05n

.meas tran vdout1_154ck1260 FIND v(dout1_154) AT=1270.05n

.meas tran vdout1_155ck1260 FIND v(dout1_155) AT=1270.05n

.meas tran vdout1_156ck1260 FIND v(dout1_156) AT=1270.05n

.meas tran vdout1_157ck1260 FIND v(dout1_157) AT=1270.05n

.meas tran vdout1_158ck1260 FIND v(dout1_158) AT=1270.05n

.meas tran vdout1_159ck1260 FIND v(dout1_159) AT=1270.05n

.meas tran vdout1_160ck1260 FIND v(dout1_160) AT=1270.05n

.meas tran vdout1_161ck1260 FIND v(dout1_161) AT=1270.05n

.meas tran vdout1_162ck1260 FIND v(dout1_162) AT=1270.05n

.meas tran vdout1_163ck1260 FIND v(dout1_163) AT=1270.05n

.meas tran vdout1_164ck1260 FIND v(dout1_164) AT=1270.05n

.meas tran vdout1_165ck1260 FIND v(dout1_165) AT=1270.05n

.meas tran vdout1_166ck1260 FIND v(dout1_166) AT=1270.05n

.meas tran vdout1_167ck1260 FIND v(dout1_167) AT=1270.05n

.meas tran vdout1_168ck1260 FIND v(dout1_168) AT=1270.05n

.meas tran vdout1_169ck1260 FIND v(dout1_169) AT=1270.05n

.meas tran vdout1_170ck1260 FIND v(dout1_170) AT=1270.05n

.meas tran vdout1_171ck1260 FIND v(dout1_171) AT=1270.05n

.meas tran vdout1_172ck1260 FIND v(dout1_172) AT=1270.05n

.meas tran vdout1_173ck1260 FIND v(dout1_173) AT=1270.05n

.meas tran vdout1_174ck1260 FIND v(dout1_174) AT=1270.05n

.meas tran vdout1_175ck1260 FIND v(dout1_175) AT=1270.05n

.meas tran vdout1_176ck1260 FIND v(dout1_176) AT=1270.05n

.meas tran vdout1_177ck1260 FIND v(dout1_177) AT=1270.05n

.meas tran vdout1_178ck1260 FIND v(dout1_178) AT=1270.05n

.meas tran vdout1_179ck1260 FIND v(dout1_179) AT=1270.05n

.meas tran vdout1_180ck1260 FIND v(dout1_180) AT=1270.05n

.meas tran vdout1_181ck1260 FIND v(dout1_181) AT=1270.05n

.meas tran vdout1_182ck1260 FIND v(dout1_182) AT=1270.05n

.meas tran vdout1_183ck1260 FIND v(dout1_183) AT=1270.05n

.meas tran vdout1_184ck1260 FIND v(dout1_184) AT=1270.05n

.meas tran vdout1_185ck1260 FIND v(dout1_185) AT=1270.05n

.meas tran vdout1_186ck1260 FIND v(dout1_186) AT=1270.05n

.meas tran vdout1_187ck1260 FIND v(dout1_187) AT=1270.05n

.meas tran vdout1_188ck1260 FIND v(dout1_188) AT=1270.05n

.meas tran vdout1_189ck1260 FIND v(dout1_189) AT=1270.05n

.meas tran vdout1_190ck1260 FIND v(dout1_190) AT=1270.05n

.meas tran vdout1_191ck1260 FIND v(dout1_191) AT=1270.05n

.meas tran vdout1_192ck1260 FIND v(dout1_192) AT=1270.05n

.meas tran vdout1_193ck1260 FIND v(dout1_193) AT=1270.05n

.meas tran vdout1_194ck1260 FIND v(dout1_194) AT=1270.05n

.meas tran vdout1_195ck1260 FIND v(dout1_195) AT=1270.05n

.meas tran vdout1_196ck1260 FIND v(dout1_196) AT=1270.05n

.meas tran vdout1_197ck1260 FIND v(dout1_197) AT=1270.05n

.meas tran vdout1_198ck1260 FIND v(dout1_198) AT=1270.05n

.meas tran vdout1_199ck1260 FIND v(dout1_199) AT=1270.05n

.meas tran vdout1_200ck1260 FIND v(dout1_200) AT=1270.05n

.meas tran vdout1_201ck1260 FIND v(dout1_201) AT=1270.05n

.meas tran vdout1_202ck1260 FIND v(dout1_202) AT=1270.05n

.meas tran vdout1_203ck1260 FIND v(dout1_203) AT=1270.05n

.meas tran vdout1_204ck1260 FIND v(dout1_204) AT=1270.05n

.meas tran vdout1_205ck1260 FIND v(dout1_205) AT=1270.05n

.meas tran vdout1_206ck1260 FIND v(dout1_206) AT=1270.05n

.meas tran vdout1_207ck1260 FIND v(dout1_207) AT=1270.05n

.meas tran vdout1_208ck1260 FIND v(dout1_208) AT=1270.05n

.meas tran vdout1_209ck1260 FIND v(dout1_209) AT=1270.05n

.meas tran vdout1_210ck1260 FIND v(dout1_210) AT=1270.05n

.meas tran vdout1_211ck1260 FIND v(dout1_211) AT=1270.05n

.meas tran vdout1_212ck1260 FIND v(dout1_212) AT=1270.05n

.meas tran vdout1_213ck1260 FIND v(dout1_213) AT=1270.05n

.meas tran vdout1_214ck1260 FIND v(dout1_214) AT=1270.05n

.meas tran vdout1_215ck1260 FIND v(dout1_215) AT=1270.05n

.meas tran vdout1_216ck1260 FIND v(dout1_216) AT=1270.05n

.meas tran vdout1_217ck1260 FIND v(dout1_217) AT=1270.05n

.meas tran vdout1_218ck1260 FIND v(dout1_218) AT=1270.05n

.meas tran vdout1_219ck1260 FIND v(dout1_219) AT=1270.05n

.meas tran vdout1_220ck1260 FIND v(dout1_220) AT=1270.05n

.meas tran vdout1_221ck1260 FIND v(dout1_221) AT=1270.05n

.meas tran vdout1_222ck1260 FIND v(dout1_222) AT=1270.05n

.meas tran vdout1_223ck1260 FIND v(dout1_223) AT=1270.05n

.meas tran vdout1_224ck1260 FIND v(dout1_224) AT=1270.05n

.meas tran vdout1_225ck1260 FIND v(dout1_225) AT=1270.05n

.meas tran vdout1_226ck1260 FIND v(dout1_226) AT=1270.05n

.meas tran vdout1_227ck1260 FIND v(dout1_227) AT=1270.05n

.meas tran vdout1_228ck1260 FIND v(dout1_228) AT=1270.05n

.meas tran vdout1_229ck1260 FIND v(dout1_229) AT=1270.05n

.meas tran vdout1_230ck1260 FIND v(dout1_230) AT=1270.05n

.meas tran vdout1_231ck1260 FIND v(dout1_231) AT=1270.05n

.meas tran vdout1_232ck1260 FIND v(dout1_232) AT=1270.05n

.meas tran vdout1_233ck1260 FIND v(dout1_233) AT=1270.05n

.meas tran vdout1_234ck1260 FIND v(dout1_234) AT=1270.05n

.meas tran vdout1_235ck1260 FIND v(dout1_235) AT=1270.05n

.meas tran vdout1_236ck1260 FIND v(dout1_236) AT=1270.05n

.meas tran vdout1_237ck1260 FIND v(dout1_237) AT=1270.05n

.meas tran vdout1_238ck1260 FIND v(dout1_238) AT=1270.05n

.meas tran vdout1_239ck1260 FIND v(dout1_239) AT=1270.05n

.meas tran vdout1_240ck1260 FIND v(dout1_240) AT=1270.05n

.meas tran vdout1_241ck1260 FIND v(dout1_241) AT=1270.05n

.meas tran vdout1_242ck1260 FIND v(dout1_242) AT=1270.05n

.meas tran vdout1_243ck1260 FIND v(dout1_243) AT=1270.05n

.meas tran vdout1_244ck1260 FIND v(dout1_244) AT=1270.05n

.meas tran vdout1_245ck1260 FIND v(dout1_245) AT=1270.05n

.meas tran vdout1_246ck1260 FIND v(dout1_246) AT=1270.05n

.meas tran vdout1_247ck1260 FIND v(dout1_247) AT=1270.05n

.meas tran vdout1_248ck1260 FIND v(dout1_248) AT=1270.05n

.meas tran vdout1_249ck1260 FIND v(dout1_249) AT=1270.05n

.meas tran vdout1_250ck1260 FIND v(dout1_250) AT=1270.05n

.meas tran vdout1_251ck1260 FIND v(dout1_251) AT=1270.05n

.meas tran vdout1_252ck1260 FIND v(dout1_252) AT=1270.05n

.meas tran vdout1_253ck1260 FIND v(dout1_253) AT=1270.05n

.meas tran vdout1_254ck1260 FIND v(dout1_254) AT=1270.05n

.meas tran vdout1_255ck1260 FIND v(dout1_255) AT=1270.05n

.meas tran vdout1_256ck1260 FIND v(dout1_256) AT=1270.05n

.meas tran vdout1_0ck1360 FIND v(dout1_0) AT=1370.05n

.meas tran vdout1_1ck1360 FIND v(dout1_1) AT=1370.05n

.meas tran vdout1_2ck1360 FIND v(dout1_2) AT=1370.05n

.meas tran vdout1_3ck1360 FIND v(dout1_3) AT=1370.05n

.meas tran vdout1_4ck1360 FIND v(dout1_4) AT=1370.05n

.meas tran vdout1_5ck1360 FIND v(dout1_5) AT=1370.05n

.meas tran vdout1_6ck1360 FIND v(dout1_6) AT=1370.05n

.meas tran vdout1_7ck1360 FIND v(dout1_7) AT=1370.05n

.meas tran vdout1_8ck1360 FIND v(dout1_8) AT=1370.05n

.meas tran vdout1_9ck1360 FIND v(dout1_9) AT=1370.05n

.meas tran vdout1_10ck1360 FIND v(dout1_10) AT=1370.05n

.meas tran vdout1_11ck1360 FIND v(dout1_11) AT=1370.05n

.meas tran vdout1_12ck1360 FIND v(dout1_12) AT=1370.05n

.meas tran vdout1_13ck1360 FIND v(dout1_13) AT=1370.05n

.meas tran vdout1_14ck1360 FIND v(dout1_14) AT=1370.05n

.meas tran vdout1_15ck1360 FIND v(dout1_15) AT=1370.05n

.meas tran vdout1_16ck1360 FIND v(dout1_16) AT=1370.05n

.meas tran vdout1_17ck1360 FIND v(dout1_17) AT=1370.05n

.meas tran vdout1_18ck1360 FIND v(dout1_18) AT=1370.05n

.meas tran vdout1_19ck1360 FIND v(dout1_19) AT=1370.05n

.meas tran vdout1_20ck1360 FIND v(dout1_20) AT=1370.05n

.meas tran vdout1_21ck1360 FIND v(dout1_21) AT=1370.05n

.meas tran vdout1_22ck1360 FIND v(dout1_22) AT=1370.05n

.meas tran vdout1_23ck1360 FIND v(dout1_23) AT=1370.05n

.meas tran vdout1_24ck1360 FIND v(dout1_24) AT=1370.05n

.meas tran vdout1_25ck1360 FIND v(dout1_25) AT=1370.05n

.meas tran vdout1_26ck1360 FIND v(dout1_26) AT=1370.05n

.meas tran vdout1_27ck1360 FIND v(dout1_27) AT=1370.05n

.meas tran vdout1_28ck1360 FIND v(dout1_28) AT=1370.05n

.meas tran vdout1_29ck1360 FIND v(dout1_29) AT=1370.05n

.meas tran vdout1_30ck1360 FIND v(dout1_30) AT=1370.05n

.meas tran vdout1_31ck1360 FIND v(dout1_31) AT=1370.05n

.meas tran vdout1_32ck1360 FIND v(dout1_32) AT=1370.05n

.meas tran vdout1_33ck1360 FIND v(dout1_33) AT=1370.05n

.meas tran vdout1_34ck1360 FIND v(dout1_34) AT=1370.05n

.meas tran vdout1_35ck1360 FIND v(dout1_35) AT=1370.05n

.meas tran vdout1_36ck1360 FIND v(dout1_36) AT=1370.05n

.meas tran vdout1_37ck1360 FIND v(dout1_37) AT=1370.05n

.meas tran vdout1_38ck1360 FIND v(dout1_38) AT=1370.05n

.meas tran vdout1_39ck1360 FIND v(dout1_39) AT=1370.05n

.meas tran vdout1_40ck1360 FIND v(dout1_40) AT=1370.05n

.meas tran vdout1_41ck1360 FIND v(dout1_41) AT=1370.05n

.meas tran vdout1_42ck1360 FIND v(dout1_42) AT=1370.05n

.meas tran vdout1_43ck1360 FIND v(dout1_43) AT=1370.05n

.meas tran vdout1_44ck1360 FIND v(dout1_44) AT=1370.05n

.meas tran vdout1_45ck1360 FIND v(dout1_45) AT=1370.05n

.meas tran vdout1_46ck1360 FIND v(dout1_46) AT=1370.05n

.meas tran vdout1_47ck1360 FIND v(dout1_47) AT=1370.05n

.meas tran vdout1_48ck1360 FIND v(dout1_48) AT=1370.05n

.meas tran vdout1_49ck1360 FIND v(dout1_49) AT=1370.05n

.meas tran vdout1_50ck1360 FIND v(dout1_50) AT=1370.05n

.meas tran vdout1_51ck1360 FIND v(dout1_51) AT=1370.05n

.meas tran vdout1_52ck1360 FIND v(dout1_52) AT=1370.05n

.meas tran vdout1_53ck1360 FIND v(dout1_53) AT=1370.05n

.meas tran vdout1_54ck1360 FIND v(dout1_54) AT=1370.05n

.meas tran vdout1_55ck1360 FIND v(dout1_55) AT=1370.05n

.meas tran vdout1_56ck1360 FIND v(dout1_56) AT=1370.05n

.meas tran vdout1_57ck1360 FIND v(dout1_57) AT=1370.05n

.meas tran vdout1_58ck1360 FIND v(dout1_58) AT=1370.05n

.meas tran vdout1_59ck1360 FIND v(dout1_59) AT=1370.05n

.meas tran vdout1_60ck1360 FIND v(dout1_60) AT=1370.05n

.meas tran vdout1_61ck1360 FIND v(dout1_61) AT=1370.05n

.meas tran vdout1_62ck1360 FIND v(dout1_62) AT=1370.05n

.meas tran vdout1_63ck1360 FIND v(dout1_63) AT=1370.05n

.meas tran vdout1_64ck1360 FIND v(dout1_64) AT=1370.05n

.meas tran vdout1_65ck1360 FIND v(dout1_65) AT=1370.05n

.meas tran vdout1_66ck1360 FIND v(dout1_66) AT=1370.05n

.meas tran vdout1_67ck1360 FIND v(dout1_67) AT=1370.05n

.meas tran vdout1_68ck1360 FIND v(dout1_68) AT=1370.05n

.meas tran vdout1_69ck1360 FIND v(dout1_69) AT=1370.05n

.meas tran vdout1_70ck1360 FIND v(dout1_70) AT=1370.05n

.meas tran vdout1_71ck1360 FIND v(dout1_71) AT=1370.05n

.meas tran vdout1_72ck1360 FIND v(dout1_72) AT=1370.05n

.meas tran vdout1_73ck1360 FIND v(dout1_73) AT=1370.05n

.meas tran vdout1_74ck1360 FIND v(dout1_74) AT=1370.05n

.meas tran vdout1_75ck1360 FIND v(dout1_75) AT=1370.05n

.meas tran vdout1_76ck1360 FIND v(dout1_76) AT=1370.05n

.meas tran vdout1_77ck1360 FIND v(dout1_77) AT=1370.05n

.meas tran vdout1_78ck1360 FIND v(dout1_78) AT=1370.05n

.meas tran vdout1_79ck1360 FIND v(dout1_79) AT=1370.05n

.meas tran vdout1_80ck1360 FIND v(dout1_80) AT=1370.05n

.meas tran vdout1_81ck1360 FIND v(dout1_81) AT=1370.05n

.meas tran vdout1_82ck1360 FIND v(dout1_82) AT=1370.05n

.meas tran vdout1_83ck1360 FIND v(dout1_83) AT=1370.05n

.meas tran vdout1_84ck1360 FIND v(dout1_84) AT=1370.05n

.meas tran vdout1_85ck1360 FIND v(dout1_85) AT=1370.05n

.meas tran vdout1_86ck1360 FIND v(dout1_86) AT=1370.05n

.meas tran vdout1_87ck1360 FIND v(dout1_87) AT=1370.05n

.meas tran vdout1_88ck1360 FIND v(dout1_88) AT=1370.05n

.meas tran vdout1_89ck1360 FIND v(dout1_89) AT=1370.05n

.meas tran vdout1_90ck1360 FIND v(dout1_90) AT=1370.05n

.meas tran vdout1_91ck1360 FIND v(dout1_91) AT=1370.05n

.meas tran vdout1_92ck1360 FIND v(dout1_92) AT=1370.05n

.meas tran vdout1_93ck1360 FIND v(dout1_93) AT=1370.05n

.meas tran vdout1_94ck1360 FIND v(dout1_94) AT=1370.05n

.meas tran vdout1_95ck1360 FIND v(dout1_95) AT=1370.05n

.meas tran vdout1_96ck1360 FIND v(dout1_96) AT=1370.05n

.meas tran vdout1_97ck1360 FIND v(dout1_97) AT=1370.05n

.meas tran vdout1_98ck1360 FIND v(dout1_98) AT=1370.05n

.meas tran vdout1_99ck1360 FIND v(dout1_99) AT=1370.05n

.meas tran vdout1_100ck1360 FIND v(dout1_100) AT=1370.05n

.meas tran vdout1_101ck1360 FIND v(dout1_101) AT=1370.05n

.meas tran vdout1_102ck1360 FIND v(dout1_102) AT=1370.05n

.meas tran vdout1_103ck1360 FIND v(dout1_103) AT=1370.05n

.meas tran vdout1_104ck1360 FIND v(dout1_104) AT=1370.05n

.meas tran vdout1_105ck1360 FIND v(dout1_105) AT=1370.05n

.meas tran vdout1_106ck1360 FIND v(dout1_106) AT=1370.05n

.meas tran vdout1_107ck1360 FIND v(dout1_107) AT=1370.05n

.meas tran vdout1_108ck1360 FIND v(dout1_108) AT=1370.05n

.meas tran vdout1_109ck1360 FIND v(dout1_109) AT=1370.05n

.meas tran vdout1_110ck1360 FIND v(dout1_110) AT=1370.05n

.meas tran vdout1_111ck1360 FIND v(dout1_111) AT=1370.05n

.meas tran vdout1_112ck1360 FIND v(dout1_112) AT=1370.05n

.meas tran vdout1_113ck1360 FIND v(dout1_113) AT=1370.05n

.meas tran vdout1_114ck1360 FIND v(dout1_114) AT=1370.05n

.meas tran vdout1_115ck1360 FIND v(dout1_115) AT=1370.05n

.meas tran vdout1_116ck1360 FIND v(dout1_116) AT=1370.05n

.meas tran vdout1_117ck1360 FIND v(dout1_117) AT=1370.05n

.meas tran vdout1_118ck1360 FIND v(dout1_118) AT=1370.05n

.meas tran vdout1_119ck1360 FIND v(dout1_119) AT=1370.05n

.meas tran vdout1_120ck1360 FIND v(dout1_120) AT=1370.05n

.meas tran vdout1_121ck1360 FIND v(dout1_121) AT=1370.05n

.meas tran vdout1_122ck1360 FIND v(dout1_122) AT=1370.05n

.meas tran vdout1_123ck1360 FIND v(dout1_123) AT=1370.05n

.meas tran vdout1_124ck1360 FIND v(dout1_124) AT=1370.05n

.meas tran vdout1_125ck1360 FIND v(dout1_125) AT=1370.05n

.meas tran vdout1_126ck1360 FIND v(dout1_126) AT=1370.05n

.meas tran vdout1_127ck1360 FIND v(dout1_127) AT=1370.05n

.meas tran vdout1_128ck1360 FIND v(dout1_128) AT=1370.05n

.meas tran vdout1_129ck1360 FIND v(dout1_129) AT=1370.05n

.meas tran vdout1_130ck1360 FIND v(dout1_130) AT=1370.05n

.meas tran vdout1_131ck1360 FIND v(dout1_131) AT=1370.05n

.meas tran vdout1_132ck1360 FIND v(dout1_132) AT=1370.05n

.meas tran vdout1_133ck1360 FIND v(dout1_133) AT=1370.05n

.meas tran vdout1_134ck1360 FIND v(dout1_134) AT=1370.05n

.meas tran vdout1_135ck1360 FIND v(dout1_135) AT=1370.05n

.meas tran vdout1_136ck1360 FIND v(dout1_136) AT=1370.05n

.meas tran vdout1_137ck1360 FIND v(dout1_137) AT=1370.05n

.meas tran vdout1_138ck1360 FIND v(dout1_138) AT=1370.05n

.meas tran vdout1_139ck1360 FIND v(dout1_139) AT=1370.05n

.meas tran vdout1_140ck1360 FIND v(dout1_140) AT=1370.05n

.meas tran vdout1_141ck1360 FIND v(dout1_141) AT=1370.05n

.meas tran vdout1_142ck1360 FIND v(dout1_142) AT=1370.05n

.meas tran vdout1_143ck1360 FIND v(dout1_143) AT=1370.05n

.meas tran vdout1_144ck1360 FIND v(dout1_144) AT=1370.05n

.meas tran vdout1_145ck1360 FIND v(dout1_145) AT=1370.05n

.meas tran vdout1_146ck1360 FIND v(dout1_146) AT=1370.05n

.meas tran vdout1_147ck1360 FIND v(dout1_147) AT=1370.05n

.meas tran vdout1_148ck1360 FIND v(dout1_148) AT=1370.05n

.meas tran vdout1_149ck1360 FIND v(dout1_149) AT=1370.05n

.meas tran vdout1_150ck1360 FIND v(dout1_150) AT=1370.05n

.meas tran vdout1_151ck1360 FIND v(dout1_151) AT=1370.05n

.meas tran vdout1_152ck1360 FIND v(dout1_152) AT=1370.05n

.meas tran vdout1_153ck1360 FIND v(dout1_153) AT=1370.05n

.meas tran vdout1_154ck1360 FIND v(dout1_154) AT=1370.05n

.meas tran vdout1_155ck1360 FIND v(dout1_155) AT=1370.05n

.meas tran vdout1_156ck1360 FIND v(dout1_156) AT=1370.05n

.meas tran vdout1_157ck1360 FIND v(dout1_157) AT=1370.05n

.meas tran vdout1_158ck1360 FIND v(dout1_158) AT=1370.05n

.meas tran vdout1_159ck1360 FIND v(dout1_159) AT=1370.05n

.meas tran vdout1_160ck1360 FIND v(dout1_160) AT=1370.05n

.meas tran vdout1_161ck1360 FIND v(dout1_161) AT=1370.05n

.meas tran vdout1_162ck1360 FIND v(dout1_162) AT=1370.05n

.meas tran vdout1_163ck1360 FIND v(dout1_163) AT=1370.05n

.meas tran vdout1_164ck1360 FIND v(dout1_164) AT=1370.05n

.meas tran vdout1_165ck1360 FIND v(dout1_165) AT=1370.05n

.meas tran vdout1_166ck1360 FIND v(dout1_166) AT=1370.05n

.meas tran vdout1_167ck1360 FIND v(dout1_167) AT=1370.05n

.meas tran vdout1_168ck1360 FIND v(dout1_168) AT=1370.05n

.meas tran vdout1_169ck1360 FIND v(dout1_169) AT=1370.05n

.meas tran vdout1_170ck1360 FIND v(dout1_170) AT=1370.05n

.meas tran vdout1_171ck1360 FIND v(dout1_171) AT=1370.05n

.meas tran vdout1_172ck1360 FIND v(dout1_172) AT=1370.05n

.meas tran vdout1_173ck1360 FIND v(dout1_173) AT=1370.05n

.meas tran vdout1_174ck1360 FIND v(dout1_174) AT=1370.05n

.meas tran vdout1_175ck1360 FIND v(dout1_175) AT=1370.05n

.meas tran vdout1_176ck1360 FIND v(dout1_176) AT=1370.05n

.meas tran vdout1_177ck1360 FIND v(dout1_177) AT=1370.05n

.meas tran vdout1_178ck1360 FIND v(dout1_178) AT=1370.05n

.meas tran vdout1_179ck1360 FIND v(dout1_179) AT=1370.05n

.meas tran vdout1_180ck1360 FIND v(dout1_180) AT=1370.05n

.meas tran vdout1_181ck1360 FIND v(dout1_181) AT=1370.05n

.meas tran vdout1_182ck1360 FIND v(dout1_182) AT=1370.05n

.meas tran vdout1_183ck1360 FIND v(dout1_183) AT=1370.05n

.meas tran vdout1_184ck1360 FIND v(dout1_184) AT=1370.05n

.meas tran vdout1_185ck1360 FIND v(dout1_185) AT=1370.05n

.meas tran vdout1_186ck1360 FIND v(dout1_186) AT=1370.05n

.meas tran vdout1_187ck1360 FIND v(dout1_187) AT=1370.05n

.meas tran vdout1_188ck1360 FIND v(dout1_188) AT=1370.05n

.meas tran vdout1_189ck1360 FIND v(dout1_189) AT=1370.05n

.meas tran vdout1_190ck1360 FIND v(dout1_190) AT=1370.05n

.meas tran vdout1_191ck1360 FIND v(dout1_191) AT=1370.05n

.meas tran vdout1_192ck1360 FIND v(dout1_192) AT=1370.05n

.meas tran vdout1_193ck1360 FIND v(dout1_193) AT=1370.05n

.meas tran vdout1_194ck1360 FIND v(dout1_194) AT=1370.05n

.meas tran vdout1_195ck1360 FIND v(dout1_195) AT=1370.05n

.meas tran vdout1_196ck1360 FIND v(dout1_196) AT=1370.05n

.meas tran vdout1_197ck1360 FIND v(dout1_197) AT=1370.05n

.meas tran vdout1_198ck1360 FIND v(dout1_198) AT=1370.05n

.meas tran vdout1_199ck1360 FIND v(dout1_199) AT=1370.05n

.meas tran vdout1_200ck1360 FIND v(dout1_200) AT=1370.05n

.meas tran vdout1_201ck1360 FIND v(dout1_201) AT=1370.05n

.meas tran vdout1_202ck1360 FIND v(dout1_202) AT=1370.05n

.meas tran vdout1_203ck1360 FIND v(dout1_203) AT=1370.05n

.meas tran vdout1_204ck1360 FIND v(dout1_204) AT=1370.05n

.meas tran vdout1_205ck1360 FIND v(dout1_205) AT=1370.05n

.meas tran vdout1_206ck1360 FIND v(dout1_206) AT=1370.05n

.meas tran vdout1_207ck1360 FIND v(dout1_207) AT=1370.05n

.meas tran vdout1_208ck1360 FIND v(dout1_208) AT=1370.05n

.meas tran vdout1_209ck1360 FIND v(dout1_209) AT=1370.05n

.meas tran vdout1_210ck1360 FIND v(dout1_210) AT=1370.05n

.meas tran vdout1_211ck1360 FIND v(dout1_211) AT=1370.05n

.meas tran vdout1_212ck1360 FIND v(dout1_212) AT=1370.05n

.meas tran vdout1_213ck1360 FIND v(dout1_213) AT=1370.05n

.meas tran vdout1_214ck1360 FIND v(dout1_214) AT=1370.05n

.meas tran vdout1_215ck1360 FIND v(dout1_215) AT=1370.05n

.meas tran vdout1_216ck1360 FIND v(dout1_216) AT=1370.05n

.meas tran vdout1_217ck1360 FIND v(dout1_217) AT=1370.05n

.meas tran vdout1_218ck1360 FIND v(dout1_218) AT=1370.05n

.meas tran vdout1_219ck1360 FIND v(dout1_219) AT=1370.05n

.meas tran vdout1_220ck1360 FIND v(dout1_220) AT=1370.05n

.meas tran vdout1_221ck1360 FIND v(dout1_221) AT=1370.05n

.meas tran vdout1_222ck1360 FIND v(dout1_222) AT=1370.05n

.meas tran vdout1_223ck1360 FIND v(dout1_223) AT=1370.05n

.meas tran vdout1_224ck1360 FIND v(dout1_224) AT=1370.05n

.meas tran vdout1_225ck1360 FIND v(dout1_225) AT=1370.05n

.meas tran vdout1_226ck1360 FIND v(dout1_226) AT=1370.05n

.meas tran vdout1_227ck1360 FIND v(dout1_227) AT=1370.05n

.meas tran vdout1_228ck1360 FIND v(dout1_228) AT=1370.05n

.meas tran vdout1_229ck1360 FIND v(dout1_229) AT=1370.05n

.meas tran vdout1_230ck1360 FIND v(dout1_230) AT=1370.05n

.meas tran vdout1_231ck1360 FIND v(dout1_231) AT=1370.05n

.meas tran vdout1_232ck1360 FIND v(dout1_232) AT=1370.05n

.meas tran vdout1_233ck1360 FIND v(dout1_233) AT=1370.05n

.meas tran vdout1_234ck1360 FIND v(dout1_234) AT=1370.05n

.meas tran vdout1_235ck1360 FIND v(dout1_235) AT=1370.05n

.meas tran vdout1_236ck1360 FIND v(dout1_236) AT=1370.05n

.meas tran vdout1_237ck1360 FIND v(dout1_237) AT=1370.05n

.meas tran vdout1_238ck1360 FIND v(dout1_238) AT=1370.05n

.meas tran vdout1_239ck1360 FIND v(dout1_239) AT=1370.05n

.meas tran vdout1_240ck1360 FIND v(dout1_240) AT=1370.05n

.meas tran vdout1_241ck1360 FIND v(dout1_241) AT=1370.05n

.meas tran vdout1_242ck1360 FIND v(dout1_242) AT=1370.05n

.meas tran vdout1_243ck1360 FIND v(dout1_243) AT=1370.05n

.meas tran vdout1_244ck1360 FIND v(dout1_244) AT=1370.05n

.meas tran vdout1_245ck1360 FIND v(dout1_245) AT=1370.05n

.meas tran vdout1_246ck1360 FIND v(dout1_246) AT=1370.05n

.meas tran vdout1_247ck1360 FIND v(dout1_247) AT=1370.05n

.meas tran vdout1_248ck1360 FIND v(dout1_248) AT=1370.05n

.meas tran vdout1_249ck1360 FIND v(dout1_249) AT=1370.05n

.meas tran vdout1_250ck1360 FIND v(dout1_250) AT=1370.05n

.meas tran vdout1_251ck1360 FIND v(dout1_251) AT=1370.05n

.meas tran vdout1_252ck1360 FIND v(dout1_252) AT=1370.05n

.meas tran vdout1_253ck1360 FIND v(dout1_253) AT=1370.05n

.meas tran vdout1_254ck1360 FIND v(dout1_254) AT=1370.05n

.meas tran vdout1_255ck1360 FIND v(dout1_255) AT=1370.05n

.meas tran vdout1_256ck1360 FIND v(dout1_256) AT=1370.05n

.meas tran vdout1_0ck1410 FIND v(dout1_0) AT=1420.05n

.meas tran vdout1_1ck1410 FIND v(dout1_1) AT=1420.05n

.meas tran vdout1_2ck1410 FIND v(dout1_2) AT=1420.05n

.meas tran vdout1_3ck1410 FIND v(dout1_3) AT=1420.05n

.meas tran vdout1_4ck1410 FIND v(dout1_4) AT=1420.05n

.meas tran vdout1_5ck1410 FIND v(dout1_5) AT=1420.05n

.meas tran vdout1_6ck1410 FIND v(dout1_6) AT=1420.05n

.meas tran vdout1_7ck1410 FIND v(dout1_7) AT=1420.05n

.meas tran vdout1_8ck1410 FIND v(dout1_8) AT=1420.05n

.meas tran vdout1_9ck1410 FIND v(dout1_9) AT=1420.05n

.meas tran vdout1_10ck1410 FIND v(dout1_10) AT=1420.05n

.meas tran vdout1_11ck1410 FIND v(dout1_11) AT=1420.05n

.meas tran vdout1_12ck1410 FIND v(dout1_12) AT=1420.05n

.meas tran vdout1_13ck1410 FIND v(dout1_13) AT=1420.05n

.meas tran vdout1_14ck1410 FIND v(dout1_14) AT=1420.05n

.meas tran vdout1_15ck1410 FIND v(dout1_15) AT=1420.05n

.meas tran vdout1_16ck1410 FIND v(dout1_16) AT=1420.05n

.meas tran vdout1_17ck1410 FIND v(dout1_17) AT=1420.05n

.meas tran vdout1_18ck1410 FIND v(dout1_18) AT=1420.05n

.meas tran vdout1_19ck1410 FIND v(dout1_19) AT=1420.05n

.meas tran vdout1_20ck1410 FIND v(dout1_20) AT=1420.05n

.meas tran vdout1_21ck1410 FIND v(dout1_21) AT=1420.05n

.meas tran vdout1_22ck1410 FIND v(dout1_22) AT=1420.05n

.meas tran vdout1_23ck1410 FIND v(dout1_23) AT=1420.05n

.meas tran vdout1_24ck1410 FIND v(dout1_24) AT=1420.05n

.meas tran vdout1_25ck1410 FIND v(dout1_25) AT=1420.05n

.meas tran vdout1_26ck1410 FIND v(dout1_26) AT=1420.05n

.meas tran vdout1_27ck1410 FIND v(dout1_27) AT=1420.05n

.meas tran vdout1_28ck1410 FIND v(dout1_28) AT=1420.05n

.meas tran vdout1_29ck1410 FIND v(dout1_29) AT=1420.05n

.meas tran vdout1_30ck1410 FIND v(dout1_30) AT=1420.05n

.meas tran vdout1_31ck1410 FIND v(dout1_31) AT=1420.05n

.meas tran vdout1_32ck1410 FIND v(dout1_32) AT=1420.05n

.meas tran vdout1_33ck1410 FIND v(dout1_33) AT=1420.05n

.meas tran vdout1_34ck1410 FIND v(dout1_34) AT=1420.05n

.meas tran vdout1_35ck1410 FIND v(dout1_35) AT=1420.05n

.meas tran vdout1_36ck1410 FIND v(dout1_36) AT=1420.05n

.meas tran vdout1_37ck1410 FIND v(dout1_37) AT=1420.05n

.meas tran vdout1_38ck1410 FIND v(dout1_38) AT=1420.05n

.meas tran vdout1_39ck1410 FIND v(dout1_39) AT=1420.05n

.meas tran vdout1_40ck1410 FIND v(dout1_40) AT=1420.05n

.meas tran vdout1_41ck1410 FIND v(dout1_41) AT=1420.05n

.meas tran vdout1_42ck1410 FIND v(dout1_42) AT=1420.05n

.meas tran vdout1_43ck1410 FIND v(dout1_43) AT=1420.05n

.meas tran vdout1_44ck1410 FIND v(dout1_44) AT=1420.05n

.meas tran vdout1_45ck1410 FIND v(dout1_45) AT=1420.05n

.meas tran vdout1_46ck1410 FIND v(dout1_46) AT=1420.05n

.meas tran vdout1_47ck1410 FIND v(dout1_47) AT=1420.05n

.meas tran vdout1_48ck1410 FIND v(dout1_48) AT=1420.05n

.meas tran vdout1_49ck1410 FIND v(dout1_49) AT=1420.05n

.meas tran vdout1_50ck1410 FIND v(dout1_50) AT=1420.05n

.meas tran vdout1_51ck1410 FIND v(dout1_51) AT=1420.05n

.meas tran vdout1_52ck1410 FIND v(dout1_52) AT=1420.05n

.meas tran vdout1_53ck1410 FIND v(dout1_53) AT=1420.05n

.meas tran vdout1_54ck1410 FIND v(dout1_54) AT=1420.05n

.meas tran vdout1_55ck1410 FIND v(dout1_55) AT=1420.05n

.meas tran vdout1_56ck1410 FIND v(dout1_56) AT=1420.05n

.meas tran vdout1_57ck1410 FIND v(dout1_57) AT=1420.05n

.meas tran vdout1_58ck1410 FIND v(dout1_58) AT=1420.05n

.meas tran vdout1_59ck1410 FIND v(dout1_59) AT=1420.05n

.meas tran vdout1_60ck1410 FIND v(dout1_60) AT=1420.05n

.meas tran vdout1_61ck1410 FIND v(dout1_61) AT=1420.05n

.meas tran vdout1_62ck1410 FIND v(dout1_62) AT=1420.05n

.meas tran vdout1_63ck1410 FIND v(dout1_63) AT=1420.05n

.meas tran vdout1_64ck1410 FIND v(dout1_64) AT=1420.05n

.meas tran vdout1_65ck1410 FIND v(dout1_65) AT=1420.05n

.meas tran vdout1_66ck1410 FIND v(dout1_66) AT=1420.05n

.meas tran vdout1_67ck1410 FIND v(dout1_67) AT=1420.05n

.meas tran vdout1_68ck1410 FIND v(dout1_68) AT=1420.05n

.meas tran vdout1_69ck1410 FIND v(dout1_69) AT=1420.05n

.meas tran vdout1_70ck1410 FIND v(dout1_70) AT=1420.05n

.meas tran vdout1_71ck1410 FIND v(dout1_71) AT=1420.05n

.meas tran vdout1_72ck1410 FIND v(dout1_72) AT=1420.05n

.meas tran vdout1_73ck1410 FIND v(dout1_73) AT=1420.05n

.meas tran vdout1_74ck1410 FIND v(dout1_74) AT=1420.05n

.meas tran vdout1_75ck1410 FIND v(dout1_75) AT=1420.05n

.meas tran vdout1_76ck1410 FIND v(dout1_76) AT=1420.05n

.meas tran vdout1_77ck1410 FIND v(dout1_77) AT=1420.05n

.meas tran vdout1_78ck1410 FIND v(dout1_78) AT=1420.05n

.meas tran vdout1_79ck1410 FIND v(dout1_79) AT=1420.05n

.meas tran vdout1_80ck1410 FIND v(dout1_80) AT=1420.05n

.meas tran vdout1_81ck1410 FIND v(dout1_81) AT=1420.05n

.meas tran vdout1_82ck1410 FIND v(dout1_82) AT=1420.05n

.meas tran vdout1_83ck1410 FIND v(dout1_83) AT=1420.05n

.meas tran vdout1_84ck1410 FIND v(dout1_84) AT=1420.05n

.meas tran vdout1_85ck1410 FIND v(dout1_85) AT=1420.05n

.meas tran vdout1_86ck1410 FIND v(dout1_86) AT=1420.05n

.meas tran vdout1_87ck1410 FIND v(dout1_87) AT=1420.05n

.meas tran vdout1_88ck1410 FIND v(dout1_88) AT=1420.05n

.meas tran vdout1_89ck1410 FIND v(dout1_89) AT=1420.05n

.meas tran vdout1_90ck1410 FIND v(dout1_90) AT=1420.05n

.meas tran vdout1_91ck1410 FIND v(dout1_91) AT=1420.05n

.meas tran vdout1_92ck1410 FIND v(dout1_92) AT=1420.05n

.meas tran vdout1_93ck1410 FIND v(dout1_93) AT=1420.05n

.meas tran vdout1_94ck1410 FIND v(dout1_94) AT=1420.05n

.meas tran vdout1_95ck1410 FIND v(dout1_95) AT=1420.05n

.meas tran vdout1_96ck1410 FIND v(dout1_96) AT=1420.05n

.meas tran vdout1_97ck1410 FIND v(dout1_97) AT=1420.05n

.meas tran vdout1_98ck1410 FIND v(dout1_98) AT=1420.05n

.meas tran vdout1_99ck1410 FIND v(dout1_99) AT=1420.05n

.meas tran vdout1_100ck1410 FIND v(dout1_100) AT=1420.05n

.meas tran vdout1_101ck1410 FIND v(dout1_101) AT=1420.05n

.meas tran vdout1_102ck1410 FIND v(dout1_102) AT=1420.05n

.meas tran vdout1_103ck1410 FIND v(dout1_103) AT=1420.05n

.meas tran vdout1_104ck1410 FIND v(dout1_104) AT=1420.05n

.meas tran vdout1_105ck1410 FIND v(dout1_105) AT=1420.05n

.meas tran vdout1_106ck1410 FIND v(dout1_106) AT=1420.05n

.meas tran vdout1_107ck1410 FIND v(dout1_107) AT=1420.05n

.meas tran vdout1_108ck1410 FIND v(dout1_108) AT=1420.05n

.meas tran vdout1_109ck1410 FIND v(dout1_109) AT=1420.05n

.meas tran vdout1_110ck1410 FIND v(dout1_110) AT=1420.05n

.meas tran vdout1_111ck1410 FIND v(dout1_111) AT=1420.05n

.meas tran vdout1_112ck1410 FIND v(dout1_112) AT=1420.05n

.meas tran vdout1_113ck1410 FIND v(dout1_113) AT=1420.05n

.meas tran vdout1_114ck1410 FIND v(dout1_114) AT=1420.05n

.meas tran vdout1_115ck1410 FIND v(dout1_115) AT=1420.05n

.meas tran vdout1_116ck1410 FIND v(dout1_116) AT=1420.05n

.meas tran vdout1_117ck1410 FIND v(dout1_117) AT=1420.05n

.meas tran vdout1_118ck1410 FIND v(dout1_118) AT=1420.05n

.meas tran vdout1_119ck1410 FIND v(dout1_119) AT=1420.05n

.meas tran vdout1_120ck1410 FIND v(dout1_120) AT=1420.05n

.meas tran vdout1_121ck1410 FIND v(dout1_121) AT=1420.05n

.meas tran vdout1_122ck1410 FIND v(dout1_122) AT=1420.05n

.meas tran vdout1_123ck1410 FIND v(dout1_123) AT=1420.05n

.meas tran vdout1_124ck1410 FIND v(dout1_124) AT=1420.05n

.meas tran vdout1_125ck1410 FIND v(dout1_125) AT=1420.05n

.meas tran vdout1_126ck1410 FIND v(dout1_126) AT=1420.05n

.meas tran vdout1_127ck1410 FIND v(dout1_127) AT=1420.05n

.meas tran vdout1_128ck1410 FIND v(dout1_128) AT=1420.05n

.meas tran vdout1_129ck1410 FIND v(dout1_129) AT=1420.05n

.meas tran vdout1_130ck1410 FIND v(dout1_130) AT=1420.05n

.meas tran vdout1_131ck1410 FIND v(dout1_131) AT=1420.05n

.meas tran vdout1_132ck1410 FIND v(dout1_132) AT=1420.05n

.meas tran vdout1_133ck1410 FIND v(dout1_133) AT=1420.05n

.meas tran vdout1_134ck1410 FIND v(dout1_134) AT=1420.05n

.meas tran vdout1_135ck1410 FIND v(dout1_135) AT=1420.05n

.meas tran vdout1_136ck1410 FIND v(dout1_136) AT=1420.05n

.meas tran vdout1_137ck1410 FIND v(dout1_137) AT=1420.05n

.meas tran vdout1_138ck1410 FIND v(dout1_138) AT=1420.05n

.meas tran vdout1_139ck1410 FIND v(dout1_139) AT=1420.05n

.meas tran vdout1_140ck1410 FIND v(dout1_140) AT=1420.05n

.meas tran vdout1_141ck1410 FIND v(dout1_141) AT=1420.05n

.meas tran vdout1_142ck1410 FIND v(dout1_142) AT=1420.05n

.meas tran vdout1_143ck1410 FIND v(dout1_143) AT=1420.05n

.meas tran vdout1_144ck1410 FIND v(dout1_144) AT=1420.05n

.meas tran vdout1_145ck1410 FIND v(dout1_145) AT=1420.05n

.meas tran vdout1_146ck1410 FIND v(dout1_146) AT=1420.05n

.meas tran vdout1_147ck1410 FIND v(dout1_147) AT=1420.05n

.meas tran vdout1_148ck1410 FIND v(dout1_148) AT=1420.05n

.meas tran vdout1_149ck1410 FIND v(dout1_149) AT=1420.05n

.meas tran vdout1_150ck1410 FIND v(dout1_150) AT=1420.05n

.meas tran vdout1_151ck1410 FIND v(dout1_151) AT=1420.05n

.meas tran vdout1_152ck1410 FIND v(dout1_152) AT=1420.05n

.meas tran vdout1_153ck1410 FIND v(dout1_153) AT=1420.05n

.meas tran vdout1_154ck1410 FIND v(dout1_154) AT=1420.05n

.meas tran vdout1_155ck1410 FIND v(dout1_155) AT=1420.05n

.meas tran vdout1_156ck1410 FIND v(dout1_156) AT=1420.05n

.meas tran vdout1_157ck1410 FIND v(dout1_157) AT=1420.05n

.meas tran vdout1_158ck1410 FIND v(dout1_158) AT=1420.05n

.meas tran vdout1_159ck1410 FIND v(dout1_159) AT=1420.05n

.meas tran vdout1_160ck1410 FIND v(dout1_160) AT=1420.05n

.meas tran vdout1_161ck1410 FIND v(dout1_161) AT=1420.05n

.meas tran vdout1_162ck1410 FIND v(dout1_162) AT=1420.05n

.meas tran vdout1_163ck1410 FIND v(dout1_163) AT=1420.05n

.meas tran vdout1_164ck1410 FIND v(dout1_164) AT=1420.05n

.meas tran vdout1_165ck1410 FIND v(dout1_165) AT=1420.05n

.meas tran vdout1_166ck1410 FIND v(dout1_166) AT=1420.05n

.meas tran vdout1_167ck1410 FIND v(dout1_167) AT=1420.05n

.meas tran vdout1_168ck1410 FIND v(dout1_168) AT=1420.05n

.meas tran vdout1_169ck1410 FIND v(dout1_169) AT=1420.05n

.meas tran vdout1_170ck1410 FIND v(dout1_170) AT=1420.05n

.meas tran vdout1_171ck1410 FIND v(dout1_171) AT=1420.05n

.meas tran vdout1_172ck1410 FIND v(dout1_172) AT=1420.05n

.meas tran vdout1_173ck1410 FIND v(dout1_173) AT=1420.05n

.meas tran vdout1_174ck1410 FIND v(dout1_174) AT=1420.05n

.meas tran vdout1_175ck1410 FIND v(dout1_175) AT=1420.05n

.meas tran vdout1_176ck1410 FIND v(dout1_176) AT=1420.05n

.meas tran vdout1_177ck1410 FIND v(dout1_177) AT=1420.05n

.meas tran vdout1_178ck1410 FIND v(dout1_178) AT=1420.05n

.meas tran vdout1_179ck1410 FIND v(dout1_179) AT=1420.05n

.meas tran vdout1_180ck1410 FIND v(dout1_180) AT=1420.05n

.meas tran vdout1_181ck1410 FIND v(dout1_181) AT=1420.05n

.meas tran vdout1_182ck1410 FIND v(dout1_182) AT=1420.05n

.meas tran vdout1_183ck1410 FIND v(dout1_183) AT=1420.05n

.meas tran vdout1_184ck1410 FIND v(dout1_184) AT=1420.05n

.meas tran vdout1_185ck1410 FIND v(dout1_185) AT=1420.05n

.meas tran vdout1_186ck1410 FIND v(dout1_186) AT=1420.05n

.meas tran vdout1_187ck1410 FIND v(dout1_187) AT=1420.05n

.meas tran vdout1_188ck1410 FIND v(dout1_188) AT=1420.05n

.meas tran vdout1_189ck1410 FIND v(dout1_189) AT=1420.05n

.meas tran vdout1_190ck1410 FIND v(dout1_190) AT=1420.05n

.meas tran vdout1_191ck1410 FIND v(dout1_191) AT=1420.05n

.meas tran vdout1_192ck1410 FIND v(dout1_192) AT=1420.05n

.meas tran vdout1_193ck1410 FIND v(dout1_193) AT=1420.05n

.meas tran vdout1_194ck1410 FIND v(dout1_194) AT=1420.05n

.meas tran vdout1_195ck1410 FIND v(dout1_195) AT=1420.05n

.meas tran vdout1_196ck1410 FIND v(dout1_196) AT=1420.05n

.meas tran vdout1_197ck1410 FIND v(dout1_197) AT=1420.05n

.meas tran vdout1_198ck1410 FIND v(dout1_198) AT=1420.05n

.meas tran vdout1_199ck1410 FIND v(dout1_199) AT=1420.05n

.meas tran vdout1_200ck1410 FIND v(dout1_200) AT=1420.05n

.meas tran vdout1_201ck1410 FIND v(dout1_201) AT=1420.05n

.meas tran vdout1_202ck1410 FIND v(dout1_202) AT=1420.05n

.meas tran vdout1_203ck1410 FIND v(dout1_203) AT=1420.05n

.meas tran vdout1_204ck1410 FIND v(dout1_204) AT=1420.05n

.meas tran vdout1_205ck1410 FIND v(dout1_205) AT=1420.05n

.meas tran vdout1_206ck1410 FIND v(dout1_206) AT=1420.05n

.meas tran vdout1_207ck1410 FIND v(dout1_207) AT=1420.05n

.meas tran vdout1_208ck1410 FIND v(dout1_208) AT=1420.05n

.meas tran vdout1_209ck1410 FIND v(dout1_209) AT=1420.05n

.meas tran vdout1_210ck1410 FIND v(dout1_210) AT=1420.05n

.meas tran vdout1_211ck1410 FIND v(dout1_211) AT=1420.05n

.meas tran vdout1_212ck1410 FIND v(dout1_212) AT=1420.05n

.meas tran vdout1_213ck1410 FIND v(dout1_213) AT=1420.05n

.meas tran vdout1_214ck1410 FIND v(dout1_214) AT=1420.05n

.meas tran vdout1_215ck1410 FIND v(dout1_215) AT=1420.05n

.meas tran vdout1_216ck1410 FIND v(dout1_216) AT=1420.05n

.meas tran vdout1_217ck1410 FIND v(dout1_217) AT=1420.05n

.meas tran vdout1_218ck1410 FIND v(dout1_218) AT=1420.05n

.meas tran vdout1_219ck1410 FIND v(dout1_219) AT=1420.05n

.meas tran vdout1_220ck1410 FIND v(dout1_220) AT=1420.05n

.meas tran vdout1_221ck1410 FIND v(dout1_221) AT=1420.05n

.meas tran vdout1_222ck1410 FIND v(dout1_222) AT=1420.05n

.meas tran vdout1_223ck1410 FIND v(dout1_223) AT=1420.05n

.meas tran vdout1_224ck1410 FIND v(dout1_224) AT=1420.05n

.meas tran vdout1_225ck1410 FIND v(dout1_225) AT=1420.05n

.meas tran vdout1_226ck1410 FIND v(dout1_226) AT=1420.05n

.meas tran vdout1_227ck1410 FIND v(dout1_227) AT=1420.05n

.meas tran vdout1_228ck1410 FIND v(dout1_228) AT=1420.05n

.meas tran vdout1_229ck1410 FIND v(dout1_229) AT=1420.05n

.meas tran vdout1_230ck1410 FIND v(dout1_230) AT=1420.05n

.meas tran vdout1_231ck1410 FIND v(dout1_231) AT=1420.05n

.meas tran vdout1_232ck1410 FIND v(dout1_232) AT=1420.05n

.meas tran vdout1_233ck1410 FIND v(dout1_233) AT=1420.05n

.meas tran vdout1_234ck1410 FIND v(dout1_234) AT=1420.05n

.meas tran vdout1_235ck1410 FIND v(dout1_235) AT=1420.05n

.meas tran vdout1_236ck1410 FIND v(dout1_236) AT=1420.05n

.meas tran vdout1_237ck1410 FIND v(dout1_237) AT=1420.05n

.meas tran vdout1_238ck1410 FIND v(dout1_238) AT=1420.05n

.meas tran vdout1_239ck1410 FIND v(dout1_239) AT=1420.05n

.meas tran vdout1_240ck1410 FIND v(dout1_240) AT=1420.05n

.meas tran vdout1_241ck1410 FIND v(dout1_241) AT=1420.05n

.meas tran vdout1_242ck1410 FIND v(dout1_242) AT=1420.05n

.meas tran vdout1_243ck1410 FIND v(dout1_243) AT=1420.05n

.meas tran vdout1_244ck1410 FIND v(dout1_244) AT=1420.05n

.meas tran vdout1_245ck1410 FIND v(dout1_245) AT=1420.05n

.meas tran vdout1_246ck1410 FIND v(dout1_246) AT=1420.05n

.meas tran vdout1_247ck1410 FIND v(dout1_247) AT=1420.05n

.meas tran vdout1_248ck1410 FIND v(dout1_248) AT=1420.05n

.meas tran vdout1_249ck1410 FIND v(dout1_249) AT=1420.05n

.meas tran vdout1_250ck1410 FIND v(dout1_250) AT=1420.05n

.meas tran vdout1_251ck1410 FIND v(dout1_251) AT=1420.05n

.meas tran vdout1_252ck1410 FIND v(dout1_252) AT=1420.05n

.meas tran vdout1_253ck1410 FIND v(dout1_253) AT=1420.05n

.meas tran vdout1_254ck1410 FIND v(dout1_254) AT=1420.05n

.meas tran vdout1_255ck1410 FIND v(dout1_255) AT=1420.05n

.meas tran vdout1_256ck1410 FIND v(dout1_256) AT=1420.05n

.meas tran vdout1_0ck1420 FIND v(dout1_0) AT=1430.05n

.meas tran vdout1_1ck1420 FIND v(dout1_1) AT=1430.05n

.meas tran vdout1_2ck1420 FIND v(dout1_2) AT=1430.05n

.meas tran vdout1_3ck1420 FIND v(dout1_3) AT=1430.05n

.meas tran vdout1_4ck1420 FIND v(dout1_4) AT=1430.05n

.meas tran vdout1_5ck1420 FIND v(dout1_5) AT=1430.05n

.meas tran vdout1_6ck1420 FIND v(dout1_6) AT=1430.05n

.meas tran vdout1_7ck1420 FIND v(dout1_7) AT=1430.05n

.meas tran vdout1_8ck1420 FIND v(dout1_8) AT=1430.05n

.meas tran vdout1_9ck1420 FIND v(dout1_9) AT=1430.05n

.meas tran vdout1_10ck1420 FIND v(dout1_10) AT=1430.05n

.meas tran vdout1_11ck1420 FIND v(dout1_11) AT=1430.05n

.meas tran vdout1_12ck1420 FIND v(dout1_12) AT=1430.05n

.meas tran vdout1_13ck1420 FIND v(dout1_13) AT=1430.05n

.meas tran vdout1_14ck1420 FIND v(dout1_14) AT=1430.05n

.meas tran vdout1_15ck1420 FIND v(dout1_15) AT=1430.05n

.meas tran vdout1_16ck1420 FIND v(dout1_16) AT=1430.05n

.meas tran vdout1_17ck1420 FIND v(dout1_17) AT=1430.05n

.meas tran vdout1_18ck1420 FIND v(dout1_18) AT=1430.05n

.meas tran vdout1_19ck1420 FIND v(dout1_19) AT=1430.05n

.meas tran vdout1_20ck1420 FIND v(dout1_20) AT=1430.05n

.meas tran vdout1_21ck1420 FIND v(dout1_21) AT=1430.05n

.meas tran vdout1_22ck1420 FIND v(dout1_22) AT=1430.05n

.meas tran vdout1_23ck1420 FIND v(dout1_23) AT=1430.05n

.meas tran vdout1_24ck1420 FIND v(dout1_24) AT=1430.05n

.meas tran vdout1_25ck1420 FIND v(dout1_25) AT=1430.05n

.meas tran vdout1_26ck1420 FIND v(dout1_26) AT=1430.05n

.meas tran vdout1_27ck1420 FIND v(dout1_27) AT=1430.05n

.meas tran vdout1_28ck1420 FIND v(dout1_28) AT=1430.05n

.meas tran vdout1_29ck1420 FIND v(dout1_29) AT=1430.05n

.meas tran vdout1_30ck1420 FIND v(dout1_30) AT=1430.05n

.meas tran vdout1_31ck1420 FIND v(dout1_31) AT=1430.05n

.meas tran vdout1_32ck1420 FIND v(dout1_32) AT=1430.05n

.meas tran vdout1_33ck1420 FIND v(dout1_33) AT=1430.05n

.meas tran vdout1_34ck1420 FIND v(dout1_34) AT=1430.05n

.meas tran vdout1_35ck1420 FIND v(dout1_35) AT=1430.05n

.meas tran vdout1_36ck1420 FIND v(dout1_36) AT=1430.05n

.meas tran vdout1_37ck1420 FIND v(dout1_37) AT=1430.05n

.meas tran vdout1_38ck1420 FIND v(dout1_38) AT=1430.05n

.meas tran vdout1_39ck1420 FIND v(dout1_39) AT=1430.05n

.meas tran vdout1_40ck1420 FIND v(dout1_40) AT=1430.05n

.meas tran vdout1_41ck1420 FIND v(dout1_41) AT=1430.05n

.meas tran vdout1_42ck1420 FIND v(dout1_42) AT=1430.05n

.meas tran vdout1_43ck1420 FIND v(dout1_43) AT=1430.05n

.meas tran vdout1_44ck1420 FIND v(dout1_44) AT=1430.05n

.meas tran vdout1_45ck1420 FIND v(dout1_45) AT=1430.05n

.meas tran vdout1_46ck1420 FIND v(dout1_46) AT=1430.05n

.meas tran vdout1_47ck1420 FIND v(dout1_47) AT=1430.05n

.meas tran vdout1_48ck1420 FIND v(dout1_48) AT=1430.05n

.meas tran vdout1_49ck1420 FIND v(dout1_49) AT=1430.05n

.meas tran vdout1_50ck1420 FIND v(dout1_50) AT=1430.05n

.meas tran vdout1_51ck1420 FIND v(dout1_51) AT=1430.05n

.meas tran vdout1_52ck1420 FIND v(dout1_52) AT=1430.05n

.meas tran vdout1_53ck1420 FIND v(dout1_53) AT=1430.05n

.meas tran vdout1_54ck1420 FIND v(dout1_54) AT=1430.05n

.meas tran vdout1_55ck1420 FIND v(dout1_55) AT=1430.05n

.meas tran vdout1_56ck1420 FIND v(dout1_56) AT=1430.05n

.meas tran vdout1_57ck1420 FIND v(dout1_57) AT=1430.05n

.meas tran vdout1_58ck1420 FIND v(dout1_58) AT=1430.05n

.meas tran vdout1_59ck1420 FIND v(dout1_59) AT=1430.05n

.meas tran vdout1_60ck1420 FIND v(dout1_60) AT=1430.05n

.meas tran vdout1_61ck1420 FIND v(dout1_61) AT=1430.05n

.meas tran vdout1_62ck1420 FIND v(dout1_62) AT=1430.05n

.meas tran vdout1_63ck1420 FIND v(dout1_63) AT=1430.05n

.meas tran vdout1_64ck1420 FIND v(dout1_64) AT=1430.05n

.meas tran vdout1_65ck1420 FIND v(dout1_65) AT=1430.05n

.meas tran vdout1_66ck1420 FIND v(dout1_66) AT=1430.05n

.meas tran vdout1_67ck1420 FIND v(dout1_67) AT=1430.05n

.meas tran vdout1_68ck1420 FIND v(dout1_68) AT=1430.05n

.meas tran vdout1_69ck1420 FIND v(dout1_69) AT=1430.05n

.meas tran vdout1_70ck1420 FIND v(dout1_70) AT=1430.05n

.meas tran vdout1_71ck1420 FIND v(dout1_71) AT=1430.05n

.meas tran vdout1_72ck1420 FIND v(dout1_72) AT=1430.05n

.meas tran vdout1_73ck1420 FIND v(dout1_73) AT=1430.05n

.meas tran vdout1_74ck1420 FIND v(dout1_74) AT=1430.05n

.meas tran vdout1_75ck1420 FIND v(dout1_75) AT=1430.05n

.meas tran vdout1_76ck1420 FIND v(dout1_76) AT=1430.05n

.meas tran vdout1_77ck1420 FIND v(dout1_77) AT=1430.05n

.meas tran vdout1_78ck1420 FIND v(dout1_78) AT=1430.05n

.meas tran vdout1_79ck1420 FIND v(dout1_79) AT=1430.05n

.meas tran vdout1_80ck1420 FIND v(dout1_80) AT=1430.05n

.meas tran vdout1_81ck1420 FIND v(dout1_81) AT=1430.05n

.meas tran vdout1_82ck1420 FIND v(dout1_82) AT=1430.05n

.meas tran vdout1_83ck1420 FIND v(dout1_83) AT=1430.05n

.meas tran vdout1_84ck1420 FIND v(dout1_84) AT=1430.05n

.meas tran vdout1_85ck1420 FIND v(dout1_85) AT=1430.05n

.meas tran vdout1_86ck1420 FIND v(dout1_86) AT=1430.05n

.meas tran vdout1_87ck1420 FIND v(dout1_87) AT=1430.05n

.meas tran vdout1_88ck1420 FIND v(dout1_88) AT=1430.05n

.meas tran vdout1_89ck1420 FIND v(dout1_89) AT=1430.05n

.meas tran vdout1_90ck1420 FIND v(dout1_90) AT=1430.05n

.meas tran vdout1_91ck1420 FIND v(dout1_91) AT=1430.05n

.meas tran vdout1_92ck1420 FIND v(dout1_92) AT=1430.05n

.meas tran vdout1_93ck1420 FIND v(dout1_93) AT=1430.05n

.meas tran vdout1_94ck1420 FIND v(dout1_94) AT=1430.05n

.meas tran vdout1_95ck1420 FIND v(dout1_95) AT=1430.05n

.meas tran vdout1_96ck1420 FIND v(dout1_96) AT=1430.05n

.meas tran vdout1_97ck1420 FIND v(dout1_97) AT=1430.05n

.meas tran vdout1_98ck1420 FIND v(dout1_98) AT=1430.05n

.meas tran vdout1_99ck1420 FIND v(dout1_99) AT=1430.05n

.meas tran vdout1_100ck1420 FIND v(dout1_100) AT=1430.05n

.meas tran vdout1_101ck1420 FIND v(dout1_101) AT=1430.05n

.meas tran vdout1_102ck1420 FIND v(dout1_102) AT=1430.05n

.meas tran vdout1_103ck1420 FIND v(dout1_103) AT=1430.05n

.meas tran vdout1_104ck1420 FIND v(dout1_104) AT=1430.05n

.meas tran vdout1_105ck1420 FIND v(dout1_105) AT=1430.05n

.meas tran vdout1_106ck1420 FIND v(dout1_106) AT=1430.05n

.meas tran vdout1_107ck1420 FIND v(dout1_107) AT=1430.05n

.meas tran vdout1_108ck1420 FIND v(dout1_108) AT=1430.05n

.meas tran vdout1_109ck1420 FIND v(dout1_109) AT=1430.05n

.meas tran vdout1_110ck1420 FIND v(dout1_110) AT=1430.05n

.meas tran vdout1_111ck1420 FIND v(dout1_111) AT=1430.05n

.meas tran vdout1_112ck1420 FIND v(dout1_112) AT=1430.05n

.meas tran vdout1_113ck1420 FIND v(dout1_113) AT=1430.05n

.meas tran vdout1_114ck1420 FIND v(dout1_114) AT=1430.05n

.meas tran vdout1_115ck1420 FIND v(dout1_115) AT=1430.05n

.meas tran vdout1_116ck1420 FIND v(dout1_116) AT=1430.05n

.meas tran vdout1_117ck1420 FIND v(dout1_117) AT=1430.05n

.meas tran vdout1_118ck1420 FIND v(dout1_118) AT=1430.05n

.meas tran vdout1_119ck1420 FIND v(dout1_119) AT=1430.05n

.meas tran vdout1_120ck1420 FIND v(dout1_120) AT=1430.05n

.meas tran vdout1_121ck1420 FIND v(dout1_121) AT=1430.05n

.meas tran vdout1_122ck1420 FIND v(dout1_122) AT=1430.05n

.meas tran vdout1_123ck1420 FIND v(dout1_123) AT=1430.05n

.meas tran vdout1_124ck1420 FIND v(dout1_124) AT=1430.05n

.meas tran vdout1_125ck1420 FIND v(dout1_125) AT=1430.05n

.meas tran vdout1_126ck1420 FIND v(dout1_126) AT=1430.05n

.meas tran vdout1_127ck1420 FIND v(dout1_127) AT=1430.05n

.meas tran vdout1_128ck1420 FIND v(dout1_128) AT=1430.05n

.meas tran vdout1_129ck1420 FIND v(dout1_129) AT=1430.05n

.meas tran vdout1_130ck1420 FIND v(dout1_130) AT=1430.05n

.meas tran vdout1_131ck1420 FIND v(dout1_131) AT=1430.05n

.meas tran vdout1_132ck1420 FIND v(dout1_132) AT=1430.05n

.meas tran vdout1_133ck1420 FIND v(dout1_133) AT=1430.05n

.meas tran vdout1_134ck1420 FIND v(dout1_134) AT=1430.05n

.meas tran vdout1_135ck1420 FIND v(dout1_135) AT=1430.05n

.meas tran vdout1_136ck1420 FIND v(dout1_136) AT=1430.05n

.meas tran vdout1_137ck1420 FIND v(dout1_137) AT=1430.05n

.meas tran vdout1_138ck1420 FIND v(dout1_138) AT=1430.05n

.meas tran vdout1_139ck1420 FIND v(dout1_139) AT=1430.05n

.meas tran vdout1_140ck1420 FIND v(dout1_140) AT=1430.05n

.meas tran vdout1_141ck1420 FIND v(dout1_141) AT=1430.05n

.meas tran vdout1_142ck1420 FIND v(dout1_142) AT=1430.05n

.meas tran vdout1_143ck1420 FIND v(dout1_143) AT=1430.05n

.meas tran vdout1_144ck1420 FIND v(dout1_144) AT=1430.05n

.meas tran vdout1_145ck1420 FIND v(dout1_145) AT=1430.05n

.meas tran vdout1_146ck1420 FIND v(dout1_146) AT=1430.05n

.meas tran vdout1_147ck1420 FIND v(dout1_147) AT=1430.05n

.meas tran vdout1_148ck1420 FIND v(dout1_148) AT=1430.05n

.meas tran vdout1_149ck1420 FIND v(dout1_149) AT=1430.05n

.meas tran vdout1_150ck1420 FIND v(dout1_150) AT=1430.05n

.meas tran vdout1_151ck1420 FIND v(dout1_151) AT=1430.05n

.meas tran vdout1_152ck1420 FIND v(dout1_152) AT=1430.05n

.meas tran vdout1_153ck1420 FIND v(dout1_153) AT=1430.05n

.meas tran vdout1_154ck1420 FIND v(dout1_154) AT=1430.05n

.meas tran vdout1_155ck1420 FIND v(dout1_155) AT=1430.05n

.meas tran vdout1_156ck1420 FIND v(dout1_156) AT=1430.05n

.meas tran vdout1_157ck1420 FIND v(dout1_157) AT=1430.05n

.meas tran vdout1_158ck1420 FIND v(dout1_158) AT=1430.05n

.meas tran vdout1_159ck1420 FIND v(dout1_159) AT=1430.05n

.meas tran vdout1_160ck1420 FIND v(dout1_160) AT=1430.05n

.meas tran vdout1_161ck1420 FIND v(dout1_161) AT=1430.05n

.meas tran vdout1_162ck1420 FIND v(dout1_162) AT=1430.05n

.meas tran vdout1_163ck1420 FIND v(dout1_163) AT=1430.05n

.meas tran vdout1_164ck1420 FIND v(dout1_164) AT=1430.05n

.meas tran vdout1_165ck1420 FIND v(dout1_165) AT=1430.05n

.meas tran vdout1_166ck1420 FIND v(dout1_166) AT=1430.05n

.meas tran vdout1_167ck1420 FIND v(dout1_167) AT=1430.05n

.meas tran vdout1_168ck1420 FIND v(dout1_168) AT=1430.05n

.meas tran vdout1_169ck1420 FIND v(dout1_169) AT=1430.05n

.meas tran vdout1_170ck1420 FIND v(dout1_170) AT=1430.05n

.meas tran vdout1_171ck1420 FIND v(dout1_171) AT=1430.05n

.meas tran vdout1_172ck1420 FIND v(dout1_172) AT=1430.05n

.meas tran vdout1_173ck1420 FIND v(dout1_173) AT=1430.05n

.meas tran vdout1_174ck1420 FIND v(dout1_174) AT=1430.05n

.meas tran vdout1_175ck1420 FIND v(dout1_175) AT=1430.05n

.meas tran vdout1_176ck1420 FIND v(dout1_176) AT=1430.05n

.meas tran vdout1_177ck1420 FIND v(dout1_177) AT=1430.05n

.meas tran vdout1_178ck1420 FIND v(dout1_178) AT=1430.05n

.meas tran vdout1_179ck1420 FIND v(dout1_179) AT=1430.05n

.meas tran vdout1_180ck1420 FIND v(dout1_180) AT=1430.05n

.meas tran vdout1_181ck1420 FIND v(dout1_181) AT=1430.05n

.meas tran vdout1_182ck1420 FIND v(dout1_182) AT=1430.05n

.meas tran vdout1_183ck1420 FIND v(dout1_183) AT=1430.05n

.meas tran vdout1_184ck1420 FIND v(dout1_184) AT=1430.05n

.meas tran vdout1_185ck1420 FIND v(dout1_185) AT=1430.05n

.meas tran vdout1_186ck1420 FIND v(dout1_186) AT=1430.05n

.meas tran vdout1_187ck1420 FIND v(dout1_187) AT=1430.05n

.meas tran vdout1_188ck1420 FIND v(dout1_188) AT=1430.05n

.meas tran vdout1_189ck1420 FIND v(dout1_189) AT=1430.05n

.meas tran vdout1_190ck1420 FIND v(dout1_190) AT=1430.05n

.meas tran vdout1_191ck1420 FIND v(dout1_191) AT=1430.05n

.meas tran vdout1_192ck1420 FIND v(dout1_192) AT=1430.05n

.meas tran vdout1_193ck1420 FIND v(dout1_193) AT=1430.05n

.meas tran vdout1_194ck1420 FIND v(dout1_194) AT=1430.05n

.meas tran vdout1_195ck1420 FIND v(dout1_195) AT=1430.05n

.meas tran vdout1_196ck1420 FIND v(dout1_196) AT=1430.05n

.meas tran vdout1_197ck1420 FIND v(dout1_197) AT=1430.05n

.meas tran vdout1_198ck1420 FIND v(dout1_198) AT=1430.05n

.meas tran vdout1_199ck1420 FIND v(dout1_199) AT=1430.05n

.meas tran vdout1_200ck1420 FIND v(dout1_200) AT=1430.05n

.meas tran vdout1_201ck1420 FIND v(dout1_201) AT=1430.05n

.meas tran vdout1_202ck1420 FIND v(dout1_202) AT=1430.05n

.meas tran vdout1_203ck1420 FIND v(dout1_203) AT=1430.05n

.meas tran vdout1_204ck1420 FIND v(dout1_204) AT=1430.05n

.meas tran vdout1_205ck1420 FIND v(dout1_205) AT=1430.05n

.meas tran vdout1_206ck1420 FIND v(dout1_206) AT=1430.05n

.meas tran vdout1_207ck1420 FIND v(dout1_207) AT=1430.05n

.meas tran vdout1_208ck1420 FIND v(dout1_208) AT=1430.05n

.meas tran vdout1_209ck1420 FIND v(dout1_209) AT=1430.05n

.meas tran vdout1_210ck1420 FIND v(dout1_210) AT=1430.05n

.meas tran vdout1_211ck1420 FIND v(dout1_211) AT=1430.05n

.meas tran vdout1_212ck1420 FIND v(dout1_212) AT=1430.05n

.meas tran vdout1_213ck1420 FIND v(dout1_213) AT=1430.05n

.meas tran vdout1_214ck1420 FIND v(dout1_214) AT=1430.05n

.meas tran vdout1_215ck1420 FIND v(dout1_215) AT=1430.05n

.meas tran vdout1_216ck1420 FIND v(dout1_216) AT=1430.05n

.meas tran vdout1_217ck1420 FIND v(dout1_217) AT=1430.05n

.meas tran vdout1_218ck1420 FIND v(dout1_218) AT=1430.05n

.meas tran vdout1_219ck1420 FIND v(dout1_219) AT=1430.05n

.meas tran vdout1_220ck1420 FIND v(dout1_220) AT=1430.05n

.meas tran vdout1_221ck1420 FIND v(dout1_221) AT=1430.05n

.meas tran vdout1_222ck1420 FIND v(dout1_222) AT=1430.05n

.meas tran vdout1_223ck1420 FIND v(dout1_223) AT=1430.05n

.meas tran vdout1_224ck1420 FIND v(dout1_224) AT=1430.05n

.meas tran vdout1_225ck1420 FIND v(dout1_225) AT=1430.05n

.meas tran vdout1_226ck1420 FIND v(dout1_226) AT=1430.05n

.meas tran vdout1_227ck1420 FIND v(dout1_227) AT=1430.05n

.meas tran vdout1_228ck1420 FIND v(dout1_228) AT=1430.05n

.meas tran vdout1_229ck1420 FIND v(dout1_229) AT=1430.05n

.meas tran vdout1_230ck1420 FIND v(dout1_230) AT=1430.05n

.meas tran vdout1_231ck1420 FIND v(dout1_231) AT=1430.05n

.meas tran vdout1_232ck1420 FIND v(dout1_232) AT=1430.05n

.meas tran vdout1_233ck1420 FIND v(dout1_233) AT=1430.05n

.meas tran vdout1_234ck1420 FIND v(dout1_234) AT=1430.05n

.meas tran vdout1_235ck1420 FIND v(dout1_235) AT=1430.05n

.meas tran vdout1_236ck1420 FIND v(dout1_236) AT=1430.05n

.meas tran vdout1_237ck1420 FIND v(dout1_237) AT=1430.05n

.meas tran vdout1_238ck1420 FIND v(dout1_238) AT=1430.05n

.meas tran vdout1_239ck1420 FIND v(dout1_239) AT=1430.05n

.meas tran vdout1_240ck1420 FIND v(dout1_240) AT=1430.05n

.meas tran vdout1_241ck1420 FIND v(dout1_241) AT=1430.05n

.meas tran vdout1_242ck1420 FIND v(dout1_242) AT=1430.05n

.meas tran vdout1_243ck1420 FIND v(dout1_243) AT=1430.05n

.meas tran vdout1_244ck1420 FIND v(dout1_244) AT=1430.05n

.meas tran vdout1_245ck1420 FIND v(dout1_245) AT=1430.05n

.meas tran vdout1_246ck1420 FIND v(dout1_246) AT=1430.05n

.meas tran vdout1_247ck1420 FIND v(dout1_247) AT=1430.05n

.meas tran vdout1_248ck1420 FIND v(dout1_248) AT=1430.05n

.meas tran vdout1_249ck1420 FIND v(dout1_249) AT=1430.05n

.meas tran vdout1_250ck1420 FIND v(dout1_250) AT=1430.05n

.meas tran vdout1_251ck1420 FIND v(dout1_251) AT=1430.05n

.meas tran vdout1_252ck1420 FIND v(dout1_252) AT=1430.05n

.meas tran vdout1_253ck1420 FIND v(dout1_253) AT=1430.05n

.meas tran vdout1_254ck1420 FIND v(dout1_254) AT=1430.05n

.meas tran vdout1_255ck1420 FIND v(dout1_255) AT=1430.05n

.meas tran vdout1_256ck1420 FIND v(dout1_256) AT=1430.05n

.meas tran vdout1_0ck1500 FIND v(dout1_0) AT=1510.05n

.meas tran vdout1_1ck1500 FIND v(dout1_1) AT=1510.05n

.meas tran vdout1_2ck1500 FIND v(dout1_2) AT=1510.05n

.meas tran vdout1_3ck1500 FIND v(dout1_3) AT=1510.05n

.meas tran vdout1_4ck1500 FIND v(dout1_4) AT=1510.05n

.meas tran vdout1_5ck1500 FIND v(dout1_5) AT=1510.05n

.meas tran vdout1_6ck1500 FIND v(dout1_6) AT=1510.05n

.meas tran vdout1_7ck1500 FIND v(dout1_7) AT=1510.05n

.meas tran vdout1_8ck1500 FIND v(dout1_8) AT=1510.05n

.meas tran vdout1_9ck1500 FIND v(dout1_9) AT=1510.05n

.meas tran vdout1_10ck1500 FIND v(dout1_10) AT=1510.05n

.meas tran vdout1_11ck1500 FIND v(dout1_11) AT=1510.05n

.meas tran vdout1_12ck1500 FIND v(dout1_12) AT=1510.05n

.meas tran vdout1_13ck1500 FIND v(dout1_13) AT=1510.05n

.meas tran vdout1_14ck1500 FIND v(dout1_14) AT=1510.05n

.meas tran vdout1_15ck1500 FIND v(dout1_15) AT=1510.05n

.meas tran vdout1_16ck1500 FIND v(dout1_16) AT=1510.05n

.meas tran vdout1_17ck1500 FIND v(dout1_17) AT=1510.05n

.meas tran vdout1_18ck1500 FIND v(dout1_18) AT=1510.05n

.meas tran vdout1_19ck1500 FIND v(dout1_19) AT=1510.05n

.meas tran vdout1_20ck1500 FIND v(dout1_20) AT=1510.05n

.meas tran vdout1_21ck1500 FIND v(dout1_21) AT=1510.05n

.meas tran vdout1_22ck1500 FIND v(dout1_22) AT=1510.05n

.meas tran vdout1_23ck1500 FIND v(dout1_23) AT=1510.05n

.meas tran vdout1_24ck1500 FIND v(dout1_24) AT=1510.05n

.meas tran vdout1_25ck1500 FIND v(dout1_25) AT=1510.05n

.meas tran vdout1_26ck1500 FIND v(dout1_26) AT=1510.05n

.meas tran vdout1_27ck1500 FIND v(dout1_27) AT=1510.05n

.meas tran vdout1_28ck1500 FIND v(dout1_28) AT=1510.05n

.meas tran vdout1_29ck1500 FIND v(dout1_29) AT=1510.05n

.meas tran vdout1_30ck1500 FIND v(dout1_30) AT=1510.05n

.meas tran vdout1_31ck1500 FIND v(dout1_31) AT=1510.05n

.meas tran vdout1_32ck1500 FIND v(dout1_32) AT=1510.05n

.meas tran vdout1_33ck1500 FIND v(dout1_33) AT=1510.05n

.meas tran vdout1_34ck1500 FIND v(dout1_34) AT=1510.05n

.meas tran vdout1_35ck1500 FIND v(dout1_35) AT=1510.05n

.meas tran vdout1_36ck1500 FIND v(dout1_36) AT=1510.05n

.meas tran vdout1_37ck1500 FIND v(dout1_37) AT=1510.05n

.meas tran vdout1_38ck1500 FIND v(dout1_38) AT=1510.05n

.meas tran vdout1_39ck1500 FIND v(dout1_39) AT=1510.05n

.meas tran vdout1_40ck1500 FIND v(dout1_40) AT=1510.05n

.meas tran vdout1_41ck1500 FIND v(dout1_41) AT=1510.05n

.meas tran vdout1_42ck1500 FIND v(dout1_42) AT=1510.05n

.meas tran vdout1_43ck1500 FIND v(dout1_43) AT=1510.05n

.meas tran vdout1_44ck1500 FIND v(dout1_44) AT=1510.05n

.meas tran vdout1_45ck1500 FIND v(dout1_45) AT=1510.05n

.meas tran vdout1_46ck1500 FIND v(dout1_46) AT=1510.05n

.meas tran vdout1_47ck1500 FIND v(dout1_47) AT=1510.05n

.meas tran vdout1_48ck1500 FIND v(dout1_48) AT=1510.05n

.meas tran vdout1_49ck1500 FIND v(dout1_49) AT=1510.05n

.meas tran vdout1_50ck1500 FIND v(dout1_50) AT=1510.05n

.meas tran vdout1_51ck1500 FIND v(dout1_51) AT=1510.05n

.meas tran vdout1_52ck1500 FIND v(dout1_52) AT=1510.05n

.meas tran vdout1_53ck1500 FIND v(dout1_53) AT=1510.05n

.meas tran vdout1_54ck1500 FIND v(dout1_54) AT=1510.05n

.meas tran vdout1_55ck1500 FIND v(dout1_55) AT=1510.05n

.meas tran vdout1_56ck1500 FIND v(dout1_56) AT=1510.05n

.meas tran vdout1_57ck1500 FIND v(dout1_57) AT=1510.05n

.meas tran vdout1_58ck1500 FIND v(dout1_58) AT=1510.05n

.meas tran vdout1_59ck1500 FIND v(dout1_59) AT=1510.05n

.meas tran vdout1_60ck1500 FIND v(dout1_60) AT=1510.05n

.meas tran vdout1_61ck1500 FIND v(dout1_61) AT=1510.05n

.meas tran vdout1_62ck1500 FIND v(dout1_62) AT=1510.05n

.meas tran vdout1_63ck1500 FIND v(dout1_63) AT=1510.05n

.meas tran vdout1_64ck1500 FIND v(dout1_64) AT=1510.05n

.meas tran vdout1_65ck1500 FIND v(dout1_65) AT=1510.05n

.meas tran vdout1_66ck1500 FIND v(dout1_66) AT=1510.05n

.meas tran vdout1_67ck1500 FIND v(dout1_67) AT=1510.05n

.meas tran vdout1_68ck1500 FIND v(dout1_68) AT=1510.05n

.meas tran vdout1_69ck1500 FIND v(dout1_69) AT=1510.05n

.meas tran vdout1_70ck1500 FIND v(dout1_70) AT=1510.05n

.meas tran vdout1_71ck1500 FIND v(dout1_71) AT=1510.05n

.meas tran vdout1_72ck1500 FIND v(dout1_72) AT=1510.05n

.meas tran vdout1_73ck1500 FIND v(dout1_73) AT=1510.05n

.meas tran vdout1_74ck1500 FIND v(dout1_74) AT=1510.05n

.meas tran vdout1_75ck1500 FIND v(dout1_75) AT=1510.05n

.meas tran vdout1_76ck1500 FIND v(dout1_76) AT=1510.05n

.meas tran vdout1_77ck1500 FIND v(dout1_77) AT=1510.05n

.meas tran vdout1_78ck1500 FIND v(dout1_78) AT=1510.05n

.meas tran vdout1_79ck1500 FIND v(dout1_79) AT=1510.05n

.meas tran vdout1_80ck1500 FIND v(dout1_80) AT=1510.05n

.meas tran vdout1_81ck1500 FIND v(dout1_81) AT=1510.05n

.meas tran vdout1_82ck1500 FIND v(dout1_82) AT=1510.05n

.meas tran vdout1_83ck1500 FIND v(dout1_83) AT=1510.05n

.meas tran vdout1_84ck1500 FIND v(dout1_84) AT=1510.05n

.meas tran vdout1_85ck1500 FIND v(dout1_85) AT=1510.05n

.meas tran vdout1_86ck1500 FIND v(dout1_86) AT=1510.05n

.meas tran vdout1_87ck1500 FIND v(dout1_87) AT=1510.05n

.meas tran vdout1_88ck1500 FIND v(dout1_88) AT=1510.05n

.meas tran vdout1_89ck1500 FIND v(dout1_89) AT=1510.05n

.meas tran vdout1_90ck1500 FIND v(dout1_90) AT=1510.05n

.meas tran vdout1_91ck1500 FIND v(dout1_91) AT=1510.05n

.meas tran vdout1_92ck1500 FIND v(dout1_92) AT=1510.05n

.meas tran vdout1_93ck1500 FIND v(dout1_93) AT=1510.05n

.meas tran vdout1_94ck1500 FIND v(dout1_94) AT=1510.05n

.meas tran vdout1_95ck1500 FIND v(dout1_95) AT=1510.05n

.meas tran vdout1_96ck1500 FIND v(dout1_96) AT=1510.05n

.meas tran vdout1_97ck1500 FIND v(dout1_97) AT=1510.05n

.meas tran vdout1_98ck1500 FIND v(dout1_98) AT=1510.05n

.meas tran vdout1_99ck1500 FIND v(dout1_99) AT=1510.05n

.meas tran vdout1_100ck1500 FIND v(dout1_100) AT=1510.05n

.meas tran vdout1_101ck1500 FIND v(dout1_101) AT=1510.05n

.meas tran vdout1_102ck1500 FIND v(dout1_102) AT=1510.05n

.meas tran vdout1_103ck1500 FIND v(dout1_103) AT=1510.05n

.meas tran vdout1_104ck1500 FIND v(dout1_104) AT=1510.05n

.meas tran vdout1_105ck1500 FIND v(dout1_105) AT=1510.05n

.meas tran vdout1_106ck1500 FIND v(dout1_106) AT=1510.05n

.meas tran vdout1_107ck1500 FIND v(dout1_107) AT=1510.05n

.meas tran vdout1_108ck1500 FIND v(dout1_108) AT=1510.05n

.meas tran vdout1_109ck1500 FIND v(dout1_109) AT=1510.05n

.meas tran vdout1_110ck1500 FIND v(dout1_110) AT=1510.05n

.meas tran vdout1_111ck1500 FIND v(dout1_111) AT=1510.05n

.meas tran vdout1_112ck1500 FIND v(dout1_112) AT=1510.05n

.meas tran vdout1_113ck1500 FIND v(dout1_113) AT=1510.05n

.meas tran vdout1_114ck1500 FIND v(dout1_114) AT=1510.05n

.meas tran vdout1_115ck1500 FIND v(dout1_115) AT=1510.05n

.meas tran vdout1_116ck1500 FIND v(dout1_116) AT=1510.05n

.meas tran vdout1_117ck1500 FIND v(dout1_117) AT=1510.05n

.meas tran vdout1_118ck1500 FIND v(dout1_118) AT=1510.05n

.meas tran vdout1_119ck1500 FIND v(dout1_119) AT=1510.05n

.meas tran vdout1_120ck1500 FIND v(dout1_120) AT=1510.05n

.meas tran vdout1_121ck1500 FIND v(dout1_121) AT=1510.05n

.meas tran vdout1_122ck1500 FIND v(dout1_122) AT=1510.05n

.meas tran vdout1_123ck1500 FIND v(dout1_123) AT=1510.05n

.meas tran vdout1_124ck1500 FIND v(dout1_124) AT=1510.05n

.meas tran vdout1_125ck1500 FIND v(dout1_125) AT=1510.05n

.meas tran vdout1_126ck1500 FIND v(dout1_126) AT=1510.05n

.meas tran vdout1_127ck1500 FIND v(dout1_127) AT=1510.05n

.meas tran vdout1_128ck1500 FIND v(dout1_128) AT=1510.05n

.meas tran vdout1_129ck1500 FIND v(dout1_129) AT=1510.05n

.meas tran vdout1_130ck1500 FIND v(dout1_130) AT=1510.05n

.meas tran vdout1_131ck1500 FIND v(dout1_131) AT=1510.05n

.meas tran vdout1_132ck1500 FIND v(dout1_132) AT=1510.05n

.meas tran vdout1_133ck1500 FIND v(dout1_133) AT=1510.05n

.meas tran vdout1_134ck1500 FIND v(dout1_134) AT=1510.05n

.meas tran vdout1_135ck1500 FIND v(dout1_135) AT=1510.05n

.meas tran vdout1_136ck1500 FIND v(dout1_136) AT=1510.05n

.meas tran vdout1_137ck1500 FIND v(dout1_137) AT=1510.05n

.meas tran vdout1_138ck1500 FIND v(dout1_138) AT=1510.05n

.meas tran vdout1_139ck1500 FIND v(dout1_139) AT=1510.05n

.meas tran vdout1_140ck1500 FIND v(dout1_140) AT=1510.05n

.meas tran vdout1_141ck1500 FIND v(dout1_141) AT=1510.05n

.meas tran vdout1_142ck1500 FIND v(dout1_142) AT=1510.05n

.meas tran vdout1_143ck1500 FIND v(dout1_143) AT=1510.05n

.meas tran vdout1_144ck1500 FIND v(dout1_144) AT=1510.05n

.meas tran vdout1_145ck1500 FIND v(dout1_145) AT=1510.05n

.meas tran vdout1_146ck1500 FIND v(dout1_146) AT=1510.05n

.meas tran vdout1_147ck1500 FIND v(dout1_147) AT=1510.05n

.meas tran vdout1_148ck1500 FIND v(dout1_148) AT=1510.05n

.meas tran vdout1_149ck1500 FIND v(dout1_149) AT=1510.05n

.meas tran vdout1_150ck1500 FIND v(dout1_150) AT=1510.05n

.meas tran vdout1_151ck1500 FIND v(dout1_151) AT=1510.05n

.meas tran vdout1_152ck1500 FIND v(dout1_152) AT=1510.05n

.meas tran vdout1_153ck1500 FIND v(dout1_153) AT=1510.05n

.meas tran vdout1_154ck1500 FIND v(dout1_154) AT=1510.05n

.meas tran vdout1_155ck1500 FIND v(dout1_155) AT=1510.05n

.meas tran vdout1_156ck1500 FIND v(dout1_156) AT=1510.05n

.meas tran vdout1_157ck1500 FIND v(dout1_157) AT=1510.05n

.meas tran vdout1_158ck1500 FIND v(dout1_158) AT=1510.05n

.meas tran vdout1_159ck1500 FIND v(dout1_159) AT=1510.05n

.meas tran vdout1_160ck1500 FIND v(dout1_160) AT=1510.05n

.meas tran vdout1_161ck1500 FIND v(dout1_161) AT=1510.05n

.meas tran vdout1_162ck1500 FIND v(dout1_162) AT=1510.05n

.meas tran vdout1_163ck1500 FIND v(dout1_163) AT=1510.05n

.meas tran vdout1_164ck1500 FIND v(dout1_164) AT=1510.05n

.meas tran vdout1_165ck1500 FIND v(dout1_165) AT=1510.05n

.meas tran vdout1_166ck1500 FIND v(dout1_166) AT=1510.05n

.meas tran vdout1_167ck1500 FIND v(dout1_167) AT=1510.05n

.meas tran vdout1_168ck1500 FIND v(dout1_168) AT=1510.05n

.meas tran vdout1_169ck1500 FIND v(dout1_169) AT=1510.05n

.meas tran vdout1_170ck1500 FIND v(dout1_170) AT=1510.05n

.meas tran vdout1_171ck1500 FIND v(dout1_171) AT=1510.05n

.meas tran vdout1_172ck1500 FIND v(dout1_172) AT=1510.05n

.meas tran vdout1_173ck1500 FIND v(dout1_173) AT=1510.05n

.meas tran vdout1_174ck1500 FIND v(dout1_174) AT=1510.05n

.meas tran vdout1_175ck1500 FIND v(dout1_175) AT=1510.05n

.meas tran vdout1_176ck1500 FIND v(dout1_176) AT=1510.05n

.meas tran vdout1_177ck1500 FIND v(dout1_177) AT=1510.05n

.meas tran vdout1_178ck1500 FIND v(dout1_178) AT=1510.05n

.meas tran vdout1_179ck1500 FIND v(dout1_179) AT=1510.05n

.meas tran vdout1_180ck1500 FIND v(dout1_180) AT=1510.05n

.meas tran vdout1_181ck1500 FIND v(dout1_181) AT=1510.05n

.meas tran vdout1_182ck1500 FIND v(dout1_182) AT=1510.05n

.meas tran vdout1_183ck1500 FIND v(dout1_183) AT=1510.05n

.meas tran vdout1_184ck1500 FIND v(dout1_184) AT=1510.05n

.meas tran vdout1_185ck1500 FIND v(dout1_185) AT=1510.05n

.meas tran vdout1_186ck1500 FIND v(dout1_186) AT=1510.05n

.meas tran vdout1_187ck1500 FIND v(dout1_187) AT=1510.05n

.meas tran vdout1_188ck1500 FIND v(dout1_188) AT=1510.05n

.meas tran vdout1_189ck1500 FIND v(dout1_189) AT=1510.05n

.meas tran vdout1_190ck1500 FIND v(dout1_190) AT=1510.05n

.meas tran vdout1_191ck1500 FIND v(dout1_191) AT=1510.05n

.meas tran vdout1_192ck1500 FIND v(dout1_192) AT=1510.05n

.meas tran vdout1_193ck1500 FIND v(dout1_193) AT=1510.05n

.meas tran vdout1_194ck1500 FIND v(dout1_194) AT=1510.05n

.meas tran vdout1_195ck1500 FIND v(dout1_195) AT=1510.05n

.meas tran vdout1_196ck1500 FIND v(dout1_196) AT=1510.05n

.meas tran vdout1_197ck1500 FIND v(dout1_197) AT=1510.05n

.meas tran vdout1_198ck1500 FIND v(dout1_198) AT=1510.05n

.meas tran vdout1_199ck1500 FIND v(dout1_199) AT=1510.05n

.meas tran vdout1_200ck1500 FIND v(dout1_200) AT=1510.05n

.meas tran vdout1_201ck1500 FIND v(dout1_201) AT=1510.05n

.meas tran vdout1_202ck1500 FIND v(dout1_202) AT=1510.05n

.meas tran vdout1_203ck1500 FIND v(dout1_203) AT=1510.05n

.meas tran vdout1_204ck1500 FIND v(dout1_204) AT=1510.05n

.meas tran vdout1_205ck1500 FIND v(dout1_205) AT=1510.05n

.meas tran vdout1_206ck1500 FIND v(dout1_206) AT=1510.05n

.meas tran vdout1_207ck1500 FIND v(dout1_207) AT=1510.05n

.meas tran vdout1_208ck1500 FIND v(dout1_208) AT=1510.05n

.meas tran vdout1_209ck1500 FIND v(dout1_209) AT=1510.05n

.meas tran vdout1_210ck1500 FIND v(dout1_210) AT=1510.05n

.meas tran vdout1_211ck1500 FIND v(dout1_211) AT=1510.05n

.meas tran vdout1_212ck1500 FIND v(dout1_212) AT=1510.05n

.meas tran vdout1_213ck1500 FIND v(dout1_213) AT=1510.05n

.meas tran vdout1_214ck1500 FIND v(dout1_214) AT=1510.05n

.meas tran vdout1_215ck1500 FIND v(dout1_215) AT=1510.05n

.meas tran vdout1_216ck1500 FIND v(dout1_216) AT=1510.05n

.meas tran vdout1_217ck1500 FIND v(dout1_217) AT=1510.05n

.meas tran vdout1_218ck1500 FIND v(dout1_218) AT=1510.05n

.meas tran vdout1_219ck1500 FIND v(dout1_219) AT=1510.05n

.meas tran vdout1_220ck1500 FIND v(dout1_220) AT=1510.05n

.meas tran vdout1_221ck1500 FIND v(dout1_221) AT=1510.05n

.meas tran vdout1_222ck1500 FIND v(dout1_222) AT=1510.05n

.meas tran vdout1_223ck1500 FIND v(dout1_223) AT=1510.05n

.meas tran vdout1_224ck1500 FIND v(dout1_224) AT=1510.05n

.meas tran vdout1_225ck1500 FIND v(dout1_225) AT=1510.05n

.meas tran vdout1_226ck1500 FIND v(dout1_226) AT=1510.05n

.meas tran vdout1_227ck1500 FIND v(dout1_227) AT=1510.05n

.meas tran vdout1_228ck1500 FIND v(dout1_228) AT=1510.05n

.meas tran vdout1_229ck1500 FIND v(dout1_229) AT=1510.05n

.meas tran vdout1_230ck1500 FIND v(dout1_230) AT=1510.05n

.meas tran vdout1_231ck1500 FIND v(dout1_231) AT=1510.05n

.meas tran vdout1_232ck1500 FIND v(dout1_232) AT=1510.05n

.meas tran vdout1_233ck1500 FIND v(dout1_233) AT=1510.05n

.meas tran vdout1_234ck1500 FIND v(dout1_234) AT=1510.05n

.meas tran vdout1_235ck1500 FIND v(dout1_235) AT=1510.05n

.meas tran vdout1_236ck1500 FIND v(dout1_236) AT=1510.05n

.meas tran vdout1_237ck1500 FIND v(dout1_237) AT=1510.05n

.meas tran vdout1_238ck1500 FIND v(dout1_238) AT=1510.05n

.meas tran vdout1_239ck1500 FIND v(dout1_239) AT=1510.05n

.meas tran vdout1_240ck1500 FIND v(dout1_240) AT=1510.05n

.meas tran vdout1_241ck1500 FIND v(dout1_241) AT=1510.05n

.meas tran vdout1_242ck1500 FIND v(dout1_242) AT=1510.05n

.meas tran vdout1_243ck1500 FIND v(dout1_243) AT=1510.05n

.meas tran vdout1_244ck1500 FIND v(dout1_244) AT=1510.05n

.meas tran vdout1_245ck1500 FIND v(dout1_245) AT=1510.05n

.meas tran vdout1_246ck1500 FIND v(dout1_246) AT=1510.05n

.meas tran vdout1_247ck1500 FIND v(dout1_247) AT=1510.05n

.meas tran vdout1_248ck1500 FIND v(dout1_248) AT=1510.05n

.meas tran vdout1_249ck1500 FIND v(dout1_249) AT=1510.05n

.meas tran vdout1_250ck1500 FIND v(dout1_250) AT=1510.05n

.meas tran vdout1_251ck1500 FIND v(dout1_251) AT=1510.05n

.meas tran vdout1_252ck1500 FIND v(dout1_252) AT=1510.05n

.meas tran vdout1_253ck1500 FIND v(dout1_253) AT=1510.05n

.meas tran vdout1_254ck1500 FIND v(dout1_254) AT=1510.05n

.meas tran vdout1_255ck1500 FIND v(dout1_255) AT=1510.05n

.meas tran vdout1_256ck1500 FIND v(dout1_256) AT=1510.05n

.meas tran vdout1_0ck1510 FIND v(dout1_0) AT=1520.05n

.meas tran vdout1_1ck1510 FIND v(dout1_1) AT=1520.05n

.meas tran vdout1_2ck1510 FIND v(dout1_2) AT=1520.05n

.meas tran vdout1_3ck1510 FIND v(dout1_3) AT=1520.05n

.meas tran vdout1_4ck1510 FIND v(dout1_4) AT=1520.05n

.meas tran vdout1_5ck1510 FIND v(dout1_5) AT=1520.05n

.meas tran vdout1_6ck1510 FIND v(dout1_6) AT=1520.05n

.meas tran vdout1_7ck1510 FIND v(dout1_7) AT=1520.05n

.meas tran vdout1_8ck1510 FIND v(dout1_8) AT=1520.05n

.meas tran vdout1_9ck1510 FIND v(dout1_9) AT=1520.05n

.meas tran vdout1_10ck1510 FIND v(dout1_10) AT=1520.05n

.meas tran vdout1_11ck1510 FIND v(dout1_11) AT=1520.05n

.meas tran vdout1_12ck1510 FIND v(dout1_12) AT=1520.05n

.meas tran vdout1_13ck1510 FIND v(dout1_13) AT=1520.05n

.meas tran vdout1_14ck1510 FIND v(dout1_14) AT=1520.05n

.meas tran vdout1_15ck1510 FIND v(dout1_15) AT=1520.05n

.meas tran vdout1_16ck1510 FIND v(dout1_16) AT=1520.05n

.meas tran vdout1_17ck1510 FIND v(dout1_17) AT=1520.05n

.meas tran vdout1_18ck1510 FIND v(dout1_18) AT=1520.05n

.meas tran vdout1_19ck1510 FIND v(dout1_19) AT=1520.05n

.meas tran vdout1_20ck1510 FIND v(dout1_20) AT=1520.05n

.meas tran vdout1_21ck1510 FIND v(dout1_21) AT=1520.05n

.meas tran vdout1_22ck1510 FIND v(dout1_22) AT=1520.05n

.meas tran vdout1_23ck1510 FIND v(dout1_23) AT=1520.05n

.meas tran vdout1_24ck1510 FIND v(dout1_24) AT=1520.05n

.meas tran vdout1_25ck1510 FIND v(dout1_25) AT=1520.05n

.meas tran vdout1_26ck1510 FIND v(dout1_26) AT=1520.05n

.meas tran vdout1_27ck1510 FIND v(dout1_27) AT=1520.05n

.meas tran vdout1_28ck1510 FIND v(dout1_28) AT=1520.05n

.meas tran vdout1_29ck1510 FIND v(dout1_29) AT=1520.05n

.meas tran vdout1_30ck1510 FIND v(dout1_30) AT=1520.05n

.meas tran vdout1_31ck1510 FIND v(dout1_31) AT=1520.05n

.meas tran vdout1_32ck1510 FIND v(dout1_32) AT=1520.05n

.meas tran vdout1_33ck1510 FIND v(dout1_33) AT=1520.05n

.meas tran vdout1_34ck1510 FIND v(dout1_34) AT=1520.05n

.meas tran vdout1_35ck1510 FIND v(dout1_35) AT=1520.05n

.meas tran vdout1_36ck1510 FIND v(dout1_36) AT=1520.05n

.meas tran vdout1_37ck1510 FIND v(dout1_37) AT=1520.05n

.meas tran vdout1_38ck1510 FIND v(dout1_38) AT=1520.05n

.meas tran vdout1_39ck1510 FIND v(dout1_39) AT=1520.05n

.meas tran vdout1_40ck1510 FIND v(dout1_40) AT=1520.05n

.meas tran vdout1_41ck1510 FIND v(dout1_41) AT=1520.05n

.meas tran vdout1_42ck1510 FIND v(dout1_42) AT=1520.05n

.meas tran vdout1_43ck1510 FIND v(dout1_43) AT=1520.05n

.meas tran vdout1_44ck1510 FIND v(dout1_44) AT=1520.05n

.meas tran vdout1_45ck1510 FIND v(dout1_45) AT=1520.05n

.meas tran vdout1_46ck1510 FIND v(dout1_46) AT=1520.05n

.meas tran vdout1_47ck1510 FIND v(dout1_47) AT=1520.05n

.meas tran vdout1_48ck1510 FIND v(dout1_48) AT=1520.05n

.meas tran vdout1_49ck1510 FIND v(dout1_49) AT=1520.05n

.meas tran vdout1_50ck1510 FIND v(dout1_50) AT=1520.05n

.meas tran vdout1_51ck1510 FIND v(dout1_51) AT=1520.05n

.meas tran vdout1_52ck1510 FIND v(dout1_52) AT=1520.05n

.meas tran vdout1_53ck1510 FIND v(dout1_53) AT=1520.05n

.meas tran vdout1_54ck1510 FIND v(dout1_54) AT=1520.05n

.meas tran vdout1_55ck1510 FIND v(dout1_55) AT=1520.05n

.meas tran vdout1_56ck1510 FIND v(dout1_56) AT=1520.05n

.meas tran vdout1_57ck1510 FIND v(dout1_57) AT=1520.05n

.meas tran vdout1_58ck1510 FIND v(dout1_58) AT=1520.05n

.meas tran vdout1_59ck1510 FIND v(dout1_59) AT=1520.05n

.meas tran vdout1_60ck1510 FIND v(dout1_60) AT=1520.05n

.meas tran vdout1_61ck1510 FIND v(dout1_61) AT=1520.05n

.meas tran vdout1_62ck1510 FIND v(dout1_62) AT=1520.05n

.meas tran vdout1_63ck1510 FIND v(dout1_63) AT=1520.05n

.meas tran vdout1_64ck1510 FIND v(dout1_64) AT=1520.05n

.meas tran vdout1_65ck1510 FIND v(dout1_65) AT=1520.05n

.meas tran vdout1_66ck1510 FIND v(dout1_66) AT=1520.05n

.meas tran vdout1_67ck1510 FIND v(dout1_67) AT=1520.05n

.meas tran vdout1_68ck1510 FIND v(dout1_68) AT=1520.05n

.meas tran vdout1_69ck1510 FIND v(dout1_69) AT=1520.05n

.meas tran vdout1_70ck1510 FIND v(dout1_70) AT=1520.05n

.meas tran vdout1_71ck1510 FIND v(dout1_71) AT=1520.05n

.meas tran vdout1_72ck1510 FIND v(dout1_72) AT=1520.05n

.meas tran vdout1_73ck1510 FIND v(dout1_73) AT=1520.05n

.meas tran vdout1_74ck1510 FIND v(dout1_74) AT=1520.05n

.meas tran vdout1_75ck1510 FIND v(dout1_75) AT=1520.05n

.meas tran vdout1_76ck1510 FIND v(dout1_76) AT=1520.05n

.meas tran vdout1_77ck1510 FIND v(dout1_77) AT=1520.05n

.meas tran vdout1_78ck1510 FIND v(dout1_78) AT=1520.05n

.meas tran vdout1_79ck1510 FIND v(dout1_79) AT=1520.05n

.meas tran vdout1_80ck1510 FIND v(dout1_80) AT=1520.05n

.meas tran vdout1_81ck1510 FIND v(dout1_81) AT=1520.05n

.meas tran vdout1_82ck1510 FIND v(dout1_82) AT=1520.05n

.meas tran vdout1_83ck1510 FIND v(dout1_83) AT=1520.05n

.meas tran vdout1_84ck1510 FIND v(dout1_84) AT=1520.05n

.meas tran vdout1_85ck1510 FIND v(dout1_85) AT=1520.05n

.meas tran vdout1_86ck1510 FIND v(dout1_86) AT=1520.05n

.meas tran vdout1_87ck1510 FIND v(dout1_87) AT=1520.05n

.meas tran vdout1_88ck1510 FIND v(dout1_88) AT=1520.05n

.meas tran vdout1_89ck1510 FIND v(dout1_89) AT=1520.05n

.meas tran vdout1_90ck1510 FIND v(dout1_90) AT=1520.05n

.meas tran vdout1_91ck1510 FIND v(dout1_91) AT=1520.05n

.meas tran vdout1_92ck1510 FIND v(dout1_92) AT=1520.05n

.meas tran vdout1_93ck1510 FIND v(dout1_93) AT=1520.05n

.meas tran vdout1_94ck1510 FIND v(dout1_94) AT=1520.05n

.meas tran vdout1_95ck1510 FIND v(dout1_95) AT=1520.05n

.meas tran vdout1_96ck1510 FIND v(dout1_96) AT=1520.05n

.meas tran vdout1_97ck1510 FIND v(dout1_97) AT=1520.05n

.meas tran vdout1_98ck1510 FIND v(dout1_98) AT=1520.05n

.meas tran vdout1_99ck1510 FIND v(dout1_99) AT=1520.05n

.meas tran vdout1_100ck1510 FIND v(dout1_100) AT=1520.05n

.meas tran vdout1_101ck1510 FIND v(dout1_101) AT=1520.05n

.meas tran vdout1_102ck1510 FIND v(dout1_102) AT=1520.05n

.meas tran vdout1_103ck1510 FIND v(dout1_103) AT=1520.05n

.meas tran vdout1_104ck1510 FIND v(dout1_104) AT=1520.05n

.meas tran vdout1_105ck1510 FIND v(dout1_105) AT=1520.05n

.meas tran vdout1_106ck1510 FIND v(dout1_106) AT=1520.05n

.meas tran vdout1_107ck1510 FIND v(dout1_107) AT=1520.05n

.meas tran vdout1_108ck1510 FIND v(dout1_108) AT=1520.05n

.meas tran vdout1_109ck1510 FIND v(dout1_109) AT=1520.05n

.meas tran vdout1_110ck1510 FIND v(dout1_110) AT=1520.05n

.meas tran vdout1_111ck1510 FIND v(dout1_111) AT=1520.05n

.meas tran vdout1_112ck1510 FIND v(dout1_112) AT=1520.05n

.meas tran vdout1_113ck1510 FIND v(dout1_113) AT=1520.05n

.meas tran vdout1_114ck1510 FIND v(dout1_114) AT=1520.05n

.meas tran vdout1_115ck1510 FIND v(dout1_115) AT=1520.05n

.meas tran vdout1_116ck1510 FIND v(dout1_116) AT=1520.05n

.meas tran vdout1_117ck1510 FIND v(dout1_117) AT=1520.05n

.meas tran vdout1_118ck1510 FIND v(dout1_118) AT=1520.05n

.meas tran vdout1_119ck1510 FIND v(dout1_119) AT=1520.05n

.meas tran vdout1_120ck1510 FIND v(dout1_120) AT=1520.05n

.meas tran vdout1_121ck1510 FIND v(dout1_121) AT=1520.05n

.meas tran vdout1_122ck1510 FIND v(dout1_122) AT=1520.05n

.meas tran vdout1_123ck1510 FIND v(dout1_123) AT=1520.05n

.meas tran vdout1_124ck1510 FIND v(dout1_124) AT=1520.05n

.meas tran vdout1_125ck1510 FIND v(dout1_125) AT=1520.05n

.meas tran vdout1_126ck1510 FIND v(dout1_126) AT=1520.05n

.meas tran vdout1_127ck1510 FIND v(dout1_127) AT=1520.05n

.meas tran vdout1_128ck1510 FIND v(dout1_128) AT=1520.05n

.meas tran vdout1_129ck1510 FIND v(dout1_129) AT=1520.05n

.meas tran vdout1_130ck1510 FIND v(dout1_130) AT=1520.05n

.meas tran vdout1_131ck1510 FIND v(dout1_131) AT=1520.05n

.meas tran vdout1_132ck1510 FIND v(dout1_132) AT=1520.05n

.meas tran vdout1_133ck1510 FIND v(dout1_133) AT=1520.05n

.meas tran vdout1_134ck1510 FIND v(dout1_134) AT=1520.05n

.meas tran vdout1_135ck1510 FIND v(dout1_135) AT=1520.05n

.meas tran vdout1_136ck1510 FIND v(dout1_136) AT=1520.05n

.meas tran vdout1_137ck1510 FIND v(dout1_137) AT=1520.05n

.meas tran vdout1_138ck1510 FIND v(dout1_138) AT=1520.05n

.meas tran vdout1_139ck1510 FIND v(dout1_139) AT=1520.05n

.meas tran vdout1_140ck1510 FIND v(dout1_140) AT=1520.05n

.meas tran vdout1_141ck1510 FIND v(dout1_141) AT=1520.05n

.meas tran vdout1_142ck1510 FIND v(dout1_142) AT=1520.05n

.meas tran vdout1_143ck1510 FIND v(dout1_143) AT=1520.05n

.meas tran vdout1_144ck1510 FIND v(dout1_144) AT=1520.05n

.meas tran vdout1_145ck1510 FIND v(dout1_145) AT=1520.05n

.meas tran vdout1_146ck1510 FIND v(dout1_146) AT=1520.05n

.meas tran vdout1_147ck1510 FIND v(dout1_147) AT=1520.05n

.meas tran vdout1_148ck1510 FIND v(dout1_148) AT=1520.05n

.meas tran vdout1_149ck1510 FIND v(dout1_149) AT=1520.05n

.meas tran vdout1_150ck1510 FIND v(dout1_150) AT=1520.05n

.meas tran vdout1_151ck1510 FIND v(dout1_151) AT=1520.05n

.meas tran vdout1_152ck1510 FIND v(dout1_152) AT=1520.05n

.meas tran vdout1_153ck1510 FIND v(dout1_153) AT=1520.05n

.meas tran vdout1_154ck1510 FIND v(dout1_154) AT=1520.05n

.meas tran vdout1_155ck1510 FIND v(dout1_155) AT=1520.05n

.meas tran vdout1_156ck1510 FIND v(dout1_156) AT=1520.05n

.meas tran vdout1_157ck1510 FIND v(dout1_157) AT=1520.05n

.meas tran vdout1_158ck1510 FIND v(dout1_158) AT=1520.05n

.meas tran vdout1_159ck1510 FIND v(dout1_159) AT=1520.05n

.meas tran vdout1_160ck1510 FIND v(dout1_160) AT=1520.05n

.meas tran vdout1_161ck1510 FIND v(dout1_161) AT=1520.05n

.meas tran vdout1_162ck1510 FIND v(dout1_162) AT=1520.05n

.meas tran vdout1_163ck1510 FIND v(dout1_163) AT=1520.05n

.meas tran vdout1_164ck1510 FIND v(dout1_164) AT=1520.05n

.meas tran vdout1_165ck1510 FIND v(dout1_165) AT=1520.05n

.meas tran vdout1_166ck1510 FIND v(dout1_166) AT=1520.05n

.meas tran vdout1_167ck1510 FIND v(dout1_167) AT=1520.05n

.meas tran vdout1_168ck1510 FIND v(dout1_168) AT=1520.05n

.meas tran vdout1_169ck1510 FIND v(dout1_169) AT=1520.05n

.meas tran vdout1_170ck1510 FIND v(dout1_170) AT=1520.05n

.meas tran vdout1_171ck1510 FIND v(dout1_171) AT=1520.05n

.meas tran vdout1_172ck1510 FIND v(dout1_172) AT=1520.05n

.meas tran vdout1_173ck1510 FIND v(dout1_173) AT=1520.05n

.meas tran vdout1_174ck1510 FIND v(dout1_174) AT=1520.05n

.meas tran vdout1_175ck1510 FIND v(dout1_175) AT=1520.05n

.meas tran vdout1_176ck1510 FIND v(dout1_176) AT=1520.05n

.meas tran vdout1_177ck1510 FIND v(dout1_177) AT=1520.05n

.meas tran vdout1_178ck1510 FIND v(dout1_178) AT=1520.05n

.meas tran vdout1_179ck1510 FIND v(dout1_179) AT=1520.05n

.meas tran vdout1_180ck1510 FIND v(dout1_180) AT=1520.05n

.meas tran vdout1_181ck1510 FIND v(dout1_181) AT=1520.05n

.meas tran vdout1_182ck1510 FIND v(dout1_182) AT=1520.05n

.meas tran vdout1_183ck1510 FIND v(dout1_183) AT=1520.05n

.meas tran vdout1_184ck1510 FIND v(dout1_184) AT=1520.05n

.meas tran vdout1_185ck1510 FIND v(dout1_185) AT=1520.05n

.meas tran vdout1_186ck1510 FIND v(dout1_186) AT=1520.05n

.meas tran vdout1_187ck1510 FIND v(dout1_187) AT=1520.05n

.meas tran vdout1_188ck1510 FIND v(dout1_188) AT=1520.05n

.meas tran vdout1_189ck1510 FIND v(dout1_189) AT=1520.05n

.meas tran vdout1_190ck1510 FIND v(dout1_190) AT=1520.05n

.meas tran vdout1_191ck1510 FIND v(dout1_191) AT=1520.05n

.meas tran vdout1_192ck1510 FIND v(dout1_192) AT=1520.05n

.meas tran vdout1_193ck1510 FIND v(dout1_193) AT=1520.05n

.meas tran vdout1_194ck1510 FIND v(dout1_194) AT=1520.05n

.meas tran vdout1_195ck1510 FIND v(dout1_195) AT=1520.05n

.meas tran vdout1_196ck1510 FIND v(dout1_196) AT=1520.05n

.meas tran vdout1_197ck1510 FIND v(dout1_197) AT=1520.05n

.meas tran vdout1_198ck1510 FIND v(dout1_198) AT=1520.05n

.meas tran vdout1_199ck1510 FIND v(dout1_199) AT=1520.05n

.meas tran vdout1_200ck1510 FIND v(dout1_200) AT=1520.05n

.meas tran vdout1_201ck1510 FIND v(dout1_201) AT=1520.05n

.meas tran vdout1_202ck1510 FIND v(dout1_202) AT=1520.05n

.meas tran vdout1_203ck1510 FIND v(dout1_203) AT=1520.05n

.meas tran vdout1_204ck1510 FIND v(dout1_204) AT=1520.05n

.meas tran vdout1_205ck1510 FIND v(dout1_205) AT=1520.05n

.meas tran vdout1_206ck1510 FIND v(dout1_206) AT=1520.05n

.meas tran vdout1_207ck1510 FIND v(dout1_207) AT=1520.05n

.meas tran vdout1_208ck1510 FIND v(dout1_208) AT=1520.05n

.meas tran vdout1_209ck1510 FIND v(dout1_209) AT=1520.05n

.meas tran vdout1_210ck1510 FIND v(dout1_210) AT=1520.05n

.meas tran vdout1_211ck1510 FIND v(dout1_211) AT=1520.05n

.meas tran vdout1_212ck1510 FIND v(dout1_212) AT=1520.05n

.meas tran vdout1_213ck1510 FIND v(dout1_213) AT=1520.05n

.meas tran vdout1_214ck1510 FIND v(dout1_214) AT=1520.05n

.meas tran vdout1_215ck1510 FIND v(dout1_215) AT=1520.05n

.meas tran vdout1_216ck1510 FIND v(dout1_216) AT=1520.05n

.meas tran vdout1_217ck1510 FIND v(dout1_217) AT=1520.05n

.meas tran vdout1_218ck1510 FIND v(dout1_218) AT=1520.05n

.meas tran vdout1_219ck1510 FIND v(dout1_219) AT=1520.05n

.meas tran vdout1_220ck1510 FIND v(dout1_220) AT=1520.05n

.meas tran vdout1_221ck1510 FIND v(dout1_221) AT=1520.05n

.meas tran vdout1_222ck1510 FIND v(dout1_222) AT=1520.05n

.meas tran vdout1_223ck1510 FIND v(dout1_223) AT=1520.05n

.meas tran vdout1_224ck1510 FIND v(dout1_224) AT=1520.05n

.meas tran vdout1_225ck1510 FIND v(dout1_225) AT=1520.05n

.meas tran vdout1_226ck1510 FIND v(dout1_226) AT=1520.05n

.meas tran vdout1_227ck1510 FIND v(dout1_227) AT=1520.05n

.meas tran vdout1_228ck1510 FIND v(dout1_228) AT=1520.05n

.meas tran vdout1_229ck1510 FIND v(dout1_229) AT=1520.05n

.meas tran vdout1_230ck1510 FIND v(dout1_230) AT=1520.05n

.meas tran vdout1_231ck1510 FIND v(dout1_231) AT=1520.05n

.meas tran vdout1_232ck1510 FIND v(dout1_232) AT=1520.05n

.meas tran vdout1_233ck1510 FIND v(dout1_233) AT=1520.05n

.meas tran vdout1_234ck1510 FIND v(dout1_234) AT=1520.05n

.meas tran vdout1_235ck1510 FIND v(dout1_235) AT=1520.05n

.meas tran vdout1_236ck1510 FIND v(dout1_236) AT=1520.05n

.meas tran vdout1_237ck1510 FIND v(dout1_237) AT=1520.05n

.meas tran vdout1_238ck1510 FIND v(dout1_238) AT=1520.05n

.meas tran vdout1_239ck1510 FIND v(dout1_239) AT=1520.05n

.meas tran vdout1_240ck1510 FIND v(dout1_240) AT=1520.05n

.meas tran vdout1_241ck1510 FIND v(dout1_241) AT=1520.05n

.meas tran vdout1_242ck1510 FIND v(dout1_242) AT=1520.05n

.meas tran vdout1_243ck1510 FIND v(dout1_243) AT=1520.05n

.meas tran vdout1_244ck1510 FIND v(dout1_244) AT=1520.05n

.meas tran vdout1_245ck1510 FIND v(dout1_245) AT=1520.05n

.meas tran vdout1_246ck1510 FIND v(dout1_246) AT=1520.05n

.meas tran vdout1_247ck1510 FIND v(dout1_247) AT=1520.05n

.meas tran vdout1_248ck1510 FIND v(dout1_248) AT=1520.05n

.meas tran vdout1_249ck1510 FIND v(dout1_249) AT=1520.05n

.meas tran vdout1_250ck1510 FIND v(dout1_250) AT=1520.05n

.meas tran vdout1_251ck1510 FIND v(dout1_251) AT=1520.05n

.meas tran vdout1_252ck1510 FIND v(dout1_252) AT=1520.05n

.meas tran vdout1_253ck1510 FIND v(dout1_253) AT=1520.05n

.meas tran vdout1_254ck1510 FIND v(dout1_254) AT=1520.05n

.meas tran vdout1_255ck1510 FIND v(dout1_255) AT=1520.05n

.meas tran vdout1_256ck1510 FIND v(dout1_256) AT=1520.05n

.meas tran vdout1_0ck1520 FIND v(dout1_0) AT=1530.05n

.meas tran vdout1_1ck1520 FIND v(dout1_1) AT=1530.05n

.meas tran vdout1_2ck1520 FIND v(dout1_2) AT=1530.05n

.meas tran vdout1_3ck1520 FIND v(dout1_3) AT=1530.05n

.meas tran vdout1_4ck1520 FIND v(dout1_4) AT=1530.05n

.meas tran vdout1_5ck1520 FIND v(dout1_5) AT=1530.05n

.meas tran vdout1_6ck1520 FIND v(dout1_6) AT=1530.05n

.meas tran vdout1_7ck1520 FIND v(dout1_7) AT=1530.05n

.meas tran vdout1_8ck1520 FIND v(dout1_8) AT=1530.05n

.meas tran vdout1_9ck1520 FIND v(dout1_9) AT=1530.05n

.meas tran vdout1_10ck1520 FIND v(dout1_10) AT=1530.05n

.meas tran vdout1_11ck1520 FIND v(dout1_11) AT=1530.05n

.meas tran vdout1_12ck1520 FIND v(dout1_12) AT=1530.05n

.meas tran vdout1_13ck1520 FIND v(dout1_13) AT=1530.05n

.meas tran vdout1_14ck1520 FIND v(dout1_14) AT=1530.05n

.meas tran vdout1_15ck1520 FIND v(dout1_15) AT=1530.05n

.meas tran vdout1_16ck1520 FIND v(dout1_16) AT=1530.05n

.meas tran vdout1_17ck1520 FIND v(dout1_17) AT=1530.05n

.meas tran vdout1_18ck1520 FIND v(dout1_18) AT=1530.05n

.meas tran vdout1_19ck1520 FIND v(dout1_19) AT=1530.05n

.meas tran vdout1_20ck1520 FIND v(dout1_20) AT=1530.05n

.meas tran vdout1_21ck1520 FIND v(dout1_21) AT=1530.05n

.meas tran vdout1_22ck1520 FIND v(dout1_22) AT=1530.05n

.meas tran vdout1_23ck1520 FIND v(dout1_23) AT=1530.05n

.meas tran vdout1_24ck1520 FIND v(dout1_24) AT=1530.05n

.meas tran vdout1_25ck1520 FIND v(dout1_25) AT=1530.05n

.meas tran vdout1_26ck1520 FIND v(dout1_26) AT=1530.05n

.meas tran vdout1_27ck1520 FIND v(dout1_27) AT=1530.05n

.meas tran vdout1_28ck1520 FIND v(dout1_28) AT=1530.05n

.meas tran vdout1_29ck1520 FIND v(dout1_29) AT=1530.05n

.meas tran vdout1_30ck1520 FIND v(dout1_30) AT=1530.05n

.meas tran vdout1_31ck1520 FIND v(dout1_31) AT=1530.05n

.meas tran vdout1_32ck1520 FIND v(dout1_32) AT=1530.05n

.meas tran vdout1_33ck1520 FIND v(dout1_33) AT=1530.05n

.meas tran vdout1_34ck1520 FIND v(dout1_34) AT=1530.05n

.meas tran vdout1_35ck1520 FIND v(dout1_35) AT=1530.05n

.meas tran vdout1_36ck1520 FIND v(dout1_36) AT=1530.05n

.meas tran vdout1_37ck1520 FIND v(dout1_37) AT=1530.05n

.meas tran vdout1_38ck1520 FIND v(dout1_38) AT=1530.05n

.meas tran vdout1_39ck1520 FIND v(dout1_39) AT=1530.05n

.meas tran vdout1_40ck1520 FIND v(dout1_40) AT=1530.05n

.meas tran vdout1_41ck1520 FIND v(dout1_41) AT=1530.05n

.meas tran vdout1_42ck1520 FIND v(dout1_42) AT=1530.05n

.meas tran vdout1_43ck1520 FIND v(dout1_43) AT=1530.05n

.meas tran vdout1_44ck1520 FIND v(dout1_44) AT=1530.05n

.meas tran vdout1_45ck1520 FIND v(dout1_45) AT=1530.05n

.meas tran vdout1_46ck1520 FIND v(dout1_46) AT=1530.05n

.meas tran vdout1_47ck1520 FIND v(dout1_47) AT=1530.05n

.meas tran vdout1_48ck1520 FIND v(dout1_48) AT=1530.05n

.meas tran vdout1_49ck1520 FIND v(dout1_49) AT=1530.05n

.meas tran vdout1_50ck1520 FIND v(dout1_50) AT=1530.05n

.meas tran vdout1_51ck1520 FIND v(dout1_51) AT=1530.05n

.meas tran vdout1_52ck1520 FIND v(dout1_52) AT=1530.05n

.meas tran vdout1_53ck1520 FIND v(dout1_53) AT=1530.05n

.meas tran vdout1_54ck1520 FIND v(dout1_54) AT=1530.05n

.meas tran vdout1_55ck1520 FIND v(dout1_55) AT=1530.05n

.meas tran vdout1_56ck1520 FIND v(dout1_56) AT=1530.05n

.meas tran vdout1_57ck1520 FIND v(dout1_57) AT=1530.05n

.meas tran vdout1_58ck1520 FIND v(dout1_58) AT=1530.05n

.meas tran vdout1_59ck1520 FIND v(dout1_59) AT=1530.05n

.meas tran vdout1_60ck1520 FIND v(dout1_60) AT=1530.05n

.meas tran vdout1_61ck1520 FIND v(dout1_61) AT=1530.05n

.meas tran vdout1_62ck1520 FIND v(dout1_62) AT=1530.05n

.meas tran vdout1_63ck1520 FIND v(dout1_63) AT=1530.05n

.meas tran vdout1_64ck1520 FIND v(dout1_64) AT=1530.05n

.meas tran vdout1_65ck1520 FIND v(dout1_65) AT=1530.05n

.meas tran vdout1_66ck1520 FIND v(dout1_66) AT=1530.05n

.meas tran vdout1_67ck1520 FIND v(dout1_67) AT=1530.05n

.meas tran vdout1_68ck1520 FIND v(dout1_68) AT=1530.05n

.meas tran vdout1_69ck1520 FIND v(dout1_69) AT=1530.05n

.meas tran vdout1_70ck1520 FIND v(dout1_70) AT=1530.05n

.meas tran vdout1_71ck1520 FIND v(dout1_71) AT=1530.05n

.meas tran vdout1_72ck1520 FIND v(dout1_72) AT=1530.05n

.meas tran vdout1_73ck1520 FIND v(dout1_73) AT=1530.05n

.meas tran vdout1_74ck1520 FIND v(dout1_74) AT=1530.05n

.meas tran vdout1_75ck1520 FIND v(dout1_75) AT=1530.05n

.meas tran vdout1_76ck1520 FIND v(dout1_76) AT=1530.05n

.meas tran vdout1_77ck1520 FIND v(dout1_77) AT=1530.05n

.meas tran vdout1_78ck1520 FIND v(dout1_78) AT=1530.05n

.meas tran vdout1_79ck1520 FIND v(dout1_79) AT=1530.05n

.meas tran vdout1_80ck1520 FIND v(dout1_80) AT=1530.05n

.meas tran vdout1_81ck1520 FIND v(dout1_81) AT=1530.05n

.meas tran vdout1_82ck1520 FIND v(dout1_82) AT=1530.05n

.meas tran vdout1_83ck1520 FIND v(dout1_83) AT=1530.05n

.meas tran vdout1_84ck1520 FIND v(dout1_84) AT=1530.05n

.meas tran vdout1_85ck1520 FIND v(dout1_85) AT=1530.05n

.meas tran vdout1_86ck1520 FIND v(dout1_86) AT=1530.05n

.meas tran vdout1_87ck1520 FIND v(dout1_87) AT=1530.05n

.meas tran vdout1_88ck1520 FIND v(dout1_88) AT=1530.05n

.meas tran vdout1_89ck1520 FIND v(dout1_89) AT=1530.05n

.meas tran vdout1_90ck1520 FIND v(dout1_90) AT=1530.05n

.meas tran vdout1_91ck1520 FIND v(dout1_91) AT=1530.05n

.meas tran vdout1_92ck1520 FIND v(dout1_92) AT=1530.05n

.meas tran vdout1_93ck1520 FIND v(dout1_93) AT=1530.05n

.meas tran vdout1_94ck1520 FIND v(dout1_94) AT=1530.05n

.meas tran vdout1_95ck1520 FIND v(dout1_95) AT=1530.05n

.meas tran vdout1_96ck1520 FIND v(dout1_96) AT=1530.05n

.meas tran vdout1_97ck1520 FIND v(dout1_97) AT=1530.05n

.meas tran vdout1_98ck1520 FIND v(dout1_98) AT=1530.05n

.meas tran vdout1_99ck1520 FIND v(dout1_99) AT=1530.05n

.meas tran vdout1_100ck1520 FIND v(dout1_100) AT=1530.05n

.meas tran vdout1_101ck1520 FIND v(dout1_101) AT=1530.05n

.meas tran vdout1_102ck1520 FIND v(dout1_102) AT=1530.05n

.meas tran vdout1_103ck1520 FIND v(dout1_103) AT=1530.05n

.meas tran vdout1_104ck1520 FIND v(dout1_104) AT=1530.05n

.meas tran vdout1_105ck1520 FIND v(dout1_105) AT=1530.05n

.meas tran vdout1_106ck1520 FIND v(dout1_106) AT=1530.05n

.meas tran vdout1_107ck1520 FIND v(dout1_107) AT=1530.05n

.meas tran vdout1_108ck1520 FIND v(dout1_108) AT=1530.05n

.meas tran vdout1_109ck1520 FIND v(dout1_109) AT=1530.05n

.meas tran vdout1_110ck1520 FIND v(dout1_110) AT=1530.05n

.meas tran vdout1_111ck1520 FIND v(dout1_111) AT=1530.05n

.meas tran vdout1_112ck1520 FIND v(dout1_112) AT=1530.05n

.meas tran vdout1_113ck1520 FIND v(dout1_113) AT=1530.05n

.meas tran vdout1_114ck1520 FIND v(dout1_114) AT=1530.05n

.meas tran vdout1_115ck1520 FIND v(dout1_115) AT=1530.05n

.meas tran vdout1_116ck1520 FIND v(dout1_116) AT=1530.05n

.meas tran vdout1_117ck1520 FIND v(dout1_117) AT=1530.05n

.meas tran vdout1_118ck1520 FIND v(dout1_118) AT=1530.05n

.meas tran vdout1_119ck1520 FIND v(dout1_119) AT=1530.05n

.meas tran vdout1_120ck1520 FIND v(dout1_120) AT=1530.05n

.meas tran vdout1_121ck1520 FIND v(dout1_121) AT=1530.05n

.meas tran vdout1_122ck1520 FIND v(dout1_122) AT=1530.05n

.meas tran vdout1_123ck1520 FIND v(dout1_123) AT=1530.05n

.meas tran vdout1_124ck1520 FIND v(dout1_124) AT=1530.05n

.meas tran vdout1_125ck1520 FIND v(dout1_125) AT=1530.05n

.meas tran vdout1_126ck1520 FIND v(dout1_126) AT=1530.05n

.meas tran vdout1_127ck1520 FIND v(dout1_127) AT=1530.05n

.meas tran vdout1_128ck1520 FIND v(dout1_128) AT=1530.05n

.meas tran vdout1_129ck1520 FIND v(dout1_129) AT=1530.05n

.meas tran vdout1_130ck1520 FIND v(dout1_130) AT=1530.05n

.meas tran vdout1_131ck1520 FIND v(dout1_131) AT=1530.05n

.meas tran vdout1_132ck1520 FIND v(dout1_132) AT=1530.05n

.meas tran vdout1_133ck1520 FIND v(dout1_133) AT=1530.05n

.meas tran vdout1_134ck1520 FIND v(dout1_134) AT=1530.05n

.meas tran vdout1_135ck1520 FIND v(dout1_135) AT=1530.05n

.meas tran vdout1_136ck1520 FIND v(dout1_136) AT=1530.05n

.meas tran vdout1_137ck1520 FIND v(dout1_137) AT=1530.05n

.meas tran vdout1_138ck1520 FIND v(dout1_138) AT=1530.05n

.meas tran vdout1_139ck1520 FIND v(dout1_139) AT=1530.05n

.meas tran vdout1_140ck1520 FIND v(dout1_140) AT=1530.05n

.meas tran vdout1_141ck1520 FIND v(dout1_141) AT=1530.05n

.meas tran vdout1_142ck1520 FIND v(dout1_142) AT=1530.05n

.meas tran vdout1_143ck1520 FIND v(dout1_143) AT=1530.05n

.meas tran vdout1_144ck1520 FIND v(dout1_144) AT=1530.05n

.meas tran vdout1_145ck1520 FIND v(dout1_145) AT=1530.05n

.meas tran vdout1_146ck1520 FIND v(dout1_146) AT=1530.05n

.meas tran vdout1_147ck1520 FIND v(dout1_147) AT=1530.05n

.meas tran vdout1_148ck1520 FIND v(dout1_148) AT=1530.05n

.meas tran vdout1_149ck1520 FIND v(dout1_149) AT=1530.05n

.meas tran vdout1_150ck1520 FIND v(dout1_150) AT=1530.05n

.meas tran vdout1_151ck1520 FIND v(dout1_151) AT=1530.05n

.meas tran vdout1_152ck1520 FIND v(dout1_152) AT=1530.05n

.meas tran vdout1_153ck1520 FIND v(dout1_153) AT=1530.05n

.meas tran vdout1_154ck1520 FIND v(dout1_154) AT=1530.05n

.meas tran vdout1_155ck1520 FIND v(dout1_155) AT=1530.05n

.meas tran vdout1_156ck1520 FIND v(dout1_156) AT=1530.05n

.meas tran vdout1_157ck1520 FIND v(dout1_157) AT=1530.05n

.meas tran vdout1_158ck1520 FIND v(dout1_158) AT=1530.05n

.meas tran vdout1_159ck1520 FIND v(dout1_159) AT=1530.05n

.meas tran vdout1_160ck1520 FIND v(dout1_160) AT=1530.05n

.meas tran vdout1_161ck1520 FIND v(dout1_161) AT=1530.05n

.meas tran vdout1_162ck1520 FIND v(dout1_162) AT=1530.05n

.meas tran vdout1_163ck1520 FIND v(dout1_163) AT=1530.05n

.meas tran vdout1_164ck1520 FIND v(dout1_164) AT=1530.05n

.meas tran vdout1_165ck1520 FIND v(dout1_165) AT=1530.05n

.meas tran vdout1_166ck1520 FIND v(dout1_166) AT=1530.05n

.meas tran vdout1_167ck1520 FIND v(dout1_167) AT=1530.05n

.meas tran vdout1_168ck1520 FIND v(dout1_168) AT=1530.05n

.meas tran vdout1_169ck1520 FIND v(dout1_169) AT=1530.05n

.meas tran vdout1_170ck1520 FIND v(dout1_170) AT=1530.05n

.meas tran vdout1_171ck1520 FIND v(dout1_171) AT=1530.05n

.meas tran vdout1_172ck1520 FIND v(dout1_172) AT=1530.05n

.meas tran vdout1_173ck1520 FIND v(dout1_173) AT=1530.05n

.meas tran vdout1_174ck1520 FIND v(dout1_174) AT=1530.05n

.meas tran vdout1_175ck1520 FIND v(dout1_175) AT=1530.05n

.meas tran vdout1_176ck1520 FIND v(dout1_176) AT=1530.05n

.meas tran vdout1_177ck1520 FIND v(dout1_177) AT=1530.05n

.meas tran vdout1_178ck1520 FIND v(dout1_178) AT=1530.05n

.meas tran vdout1_179ck1520 FIND v(dout1_179) AT=1530.05n

.meas tran vdout1_180ck1520 FIND v(dout1_180) AT=1530.05n

.meas tran vdout1_181ck1520 FIND v(dout1_181) AT=1530.05n

.meas tran vdout1_182ck1520 FIND v(dout1_182) AT=1530.05n

.meas tran vdout1_183ck1520 FIND v(dout1_183) AT=1530.05n

.meas tran vdout1_184ck1520 FIND v(dout1_184) AT=1530.05n

.meas tran vdout1_185ck1520 FIND v(dout1_185) AT=1530.05n

.meas tran vdout1_186ck1520 FIND v(dout1_186) AT=1530.05n

.meas tran vdout1_187ck1520 FIND v(dout1_187) AT=1530.05n

.meas tran vdout1_188ck1520 FIND v(dout1_188) AT=1530.05n

.meas tran vdout1_189ck1520 FIND v(dout1_189) AT=1530.05n

.meas tran vdout1_190ck1520 FIND v(dout1_190) AT=1530.05n

.meas tran vdout1_191ck1520 FIND v(dout1_191) AT=1530.05n

.meas tran vdout1_192ck1520 FIND v(dout1_192) AT=1530.05n

.meas tran vdout1_193ck1520 FIND v(dout1_193) AT=1530.05n

.meas tran vdout1_194ck1520 FIND v(dout1_194) AT=1530.05n

.meas tran vdout1_195ck1520 FIND v(dout1_195) AT=1530.05n

.meas tran vdout1_196ck1520 FIND v(dout1_196) AT=1530.05n

.meas tran vdout1_197ck1520 FIND v(dout1_197) AT=1530.05n

.meas tran vdout1_198ck1520 FIND v(dout1_198) AT=1530.05n

.meas tran vdout1_199ck1520 FIND v(dout1_199) AT=1530.05n

.meas tran vdout1_200ck1520 FIND v(dout1_200) AT=1530.05n

.meas tran vdout1_201ck1520 FIND v(dout1_201) AT=1530.05n

.meas tran vdout1_202ck1520 FIND v(dout1_202) AT=1530.05n

.meas tran vdout1_203ck1520 FIND v(dout1_203) AT=1530.05n

.meas tran vdout1_204ck1520 FIND v(dout1_204) AT=1530.05n

.meas tran vdout1_205ck1520 FIND v(dout1_205) AT=1530.05n

.meas tran vdout1_206ck1520 FIND v(dout1_206) AT=1530.05n

.meas tran vdout1_207ck1520 FIND v(dout1_207) AT=1530.05n

.meas tran vdout1_208ck1520 FIND v(dout1_208) AT=1530.05n

.meas tran vdout1_209ck1520 FIND v(dout1_209) AT=1530.05n

.meas tran vdout1_210ck1520 FIND v(dout1_210) AT=1530.05n

.meas tran vdout1_211ck1520 FIND v(dout1_211) AT=1530.05n

.meas tran vdout1_212ck1520 FIND v(dout1_212) AT=1530.05n

.meas tran vdout1_213ck1520 FIND v(dout1_213) AT=1530.05n

.meas tran vdout1_214ck1520 FIND v(dout1_214) AT=1530.05n

.meas tran vdout1_215ck1520 FIND v(dout1_215) AT=1530.05n

.meas tran vdout1_216ck1520 FIND v(dout1_216) AT=1530.05n

.meas tran vdout1_217ck1520 FIND v(dout1_217) AT=1530.05n

.meas tran vdout1_218ck1520 FIND v(dout1_218) AT=1530.05n

.meas tran vdout1_219ck1520 FIND v(dout1_219) AT=1530.05n

.meas tran vdout1_220ck1520 FIND v(dout1_220) AT=1530.05n

.meas tran vdout1_221ck1520 FIND v(dout1_221) AT=1530.05n

.meas tran vdout1_222ck1520 FIND v(dout1_222) AT=1530.05n

.meas tran vdout1_223ck1520 FIND v(dout1_223) AT=1530.05n

.meas tran vdout1_224ck1520 FIND v(dout1_224) AT=1530.05n

.meas tran vdout1_225ck1520 FIND v(dout1_225) AT=1530.05n

.meas tran vdout1_226ck1520 FIND v(dout1_226) AT=1530.05n

.meas tran vdout1_227ck1520 FIND v(dout1_227) AT=1530.05n

.meas tran vdout1_228ck1520 FIND v(dout1_228) AT=1530.05n

.meas tran vdout1_229ck1520 FIND v(dout1_229) AT=1530.05n

.meas tran vdout1_230ck1520 FIND v(dout1_230) AT=1530.05n

.meas tran vdout1_231ck1520 FIND v(dout1_231) AT=1530.05n

.meas tran vdout1_232ck1520 FIND v(dout1_232) AT=1530.05n

.meas tran vdout1_233ck1520 FIND v(dout1_233) AT=1530.05n

.meas tran vdout1_234ck1520 FIND v(dout1_234) AT=1530.05n

.meas tran vdout1_235ck1520 FIND v(dout1_235) AT=1530.05n

.meas tran vdout1_236ck1520 FIND v(dout1_236) AT=1530.05n

.meas tran vdout1_237ck1520 FIND v(dout1_237) AT=1530.05n

.meas tran vdout1_238ck1520 FIND v(dout1_238) AT=1530.05n

.meas tran vdout1_239ck1520 FIND v(dout1_239) AT=1530.05n

.meas tran vdout1_240ck1520 FIND v(dout1_240) AT=1530.05n

.meas tran vdout1_241ck1520 FIND v(dout1_241) AT=1530.05n

.meas tran vdout1_242ck1520 FIND v(dout1_242) AT=1530.05n

.meas tran vdout1_243ck1520 FIND v(dout1_243) AT=1530.05n

.meas tran vdout1_244ck1520 FIND v(dout1_244) AT=1530.05n

.meas tran vdout1_245ck1520 FIND v(dout1_245) AT=1530.05n

.meas tran vdout1_246ck1520 FIND v(dout1_246) AT=1530.05n

.meas tran vdout1_247ck1520 FIND v(dout1_247) AT=1530.05n

.meas tran vdout1_248ck1520 FIND v(dout1_248) AT=1530.05n

.meas tran vdout1_249ck1520 FIND v(dout1_249) AT=1530.05n

.meas tran vdout1_250ck1520 FIND v(dout1_250) AT=1530.05n

.meas tran vdout1_251ck1520 FIND v(dout1_251) AT=1530.05n

.meas tran vdout1_252ck1520 FIND v(dout1_252) AT=1530.05n

.meas tran vdout1_253ck1520 FIND v(dout1_253) AT=1530.05n

.meas tran vdout1_254ck1520 FIND v(dout1_254) AT=1530.05n

.meas tran vdout1_255ck1520 FIND v(dout1_255) AT=1530.05n

.meas tran vdout1_256ck1520 FIND v(dout1_256) AT=1530.05n

.meas tran vdout1_0ck1530 FIND v(dout1_0) AT=1540.05n

.meas tran vdout1_1ck1530 FIND v(dout1_1) AT=1540.05n

.meas tran vdout1_2ck1530 FIND v(dout1_2) AT=1540.05n

.meas tran vdout1_3ck1530 FIND v(dout1_3) AT=1540.05n

.meas tran vdout1_4ck1530 FIND v(dout1_4) AT=1540.05n

.meas tran vdout1_5ck1530 FIND v(dout1_5) AT=1540.05n

.meas tran vdout1_6ck1530 FIND v(dout1_6) AT=1540.05n

.meas tran vdout1_7ck1530 FIND v(dout1_7) AT=1540.05n

.meas tran vdout1_8ck1530 FIND v(dout1_8) AT=1540.05n

.meas tran vdout1_9ck1530 FIND v(dout1_9) AT=1540.05n

.meas tran vdout1_10ck1530 FIND v(dout1_10) AT=1540.05n

.meas tran vdout1_11ck1530 FIND v(dout1_11) AT=1540.05n

.meas tran vdout1_12ck1530 FIND v(dout1_12) AT=1540.05n

.meas tran vdout1_13ck1530 FIND v(dout1_13) AT=1540.05n

.meas tran vdout1_14ck1530 FIND v(dout1_14) AT=1540.05n

.meas tran vdout1_15ck1530 FIND v(dout1_15) AT=1540.05n

.meas tran vdout1_16ck1530 FIND v(dout1_16) AT=1540.05n

.meas tran vdout1_17ck1530 FIND v(dout1_17) AT=1540.05n

.meas tran vdout1_18ck1530 FIND v(dout1_18) AT=1540.05n

.meas tran vdout1_19ck1530 FIND v(dout1_19) AT=1540.05n

.meas tran vdout1_20ck1530 FIND v(dout1_20) AT=1540.05n

.meas tran vdout1_21ck1530 FIND v(dout1_21) AT=1540.05n

.meas tran vdout1_22ck1530 FIND v(dout1_22) AT=1540.05n

.meas tran vdout1_23ck1530 FIND v(dout1_23) AT=1540.05n

.meas tran vdout1_24ck1530 FIND v(dout1_24) AT=1540.05n

.meas tran vdout1_25ck1530 FIND v(dout1_25) AT=1540.05n

.meas tran vdout1_26ck1530 FIND v(dout1_26) AT=1540.05n

.meas tran vdout1_27ck1530 FIND v(dout1_27) AT=1540.05n

.meas tran vdout1_28ck1530 FIND v(dout1_28) AT=1540.05n

.meas tran vdout1_29ck1530 FIND v(dout1_29) AT=1540.05n

.meas tran vdout1_30ck1530 FIND v(dout1_30) AT=1540.05n

.meas tran vdout1_31ck1530 FIND v(dout1_31) AT=1540.05n

.meas tran vdout1_32ck1530 FIND v(dout1_32) AT=1540.05n

.meas tran vdout1_33ck1530 FIND v(dout1_33) AT=1540.05n

.meas tran vdout1_34ck1530 FIND v(dout1_34) AT=1540.05n

.meas tran vdout1_35ck1530 FIND v(dout1_35) AT=1540.05n

.meas tran vdout1_36ck1530 FIND v(dout1_36) AT=1540.05n

.meas tran vdout1_37ck1530 FIND v(dout1_37) AT=1540.05n

.meas tran vdout1_38ck1530 FIND v(dout1_38) AT=1540.05n

.meas tran vdout1_39ck1530 FIND v(dout1_39) AT=1540.05n

.meas tran vdout1_40ck1530 FIND v(dout1_40) AT=1540.05n

.meas tran vdout1_41ck1530 FIND v(dout1_41) AT=1540.05n

.meas tran vdout1_42ck1530 FIND v(dout1_42) AT=1540.05n

.meas tran vdout1_43ck1530 FIND v(dout1_43) AT=1540.05n

.meas tran vdout1_44ck1530 FIND v(dout1_44) AT=1540.05n

.meas tran vdout1_45ck1530 FIND v(dout1_45) AT=1540.05n

.meas tran vdout1_46ck1530 FIND v(dout1_46) AT=1540.05n

.meas tran vdout1_47ck1530 FIND v(dout1_47) AT=1540.05n

.meas tran vdout1_48ck1530 FIND v(dout1_48) AT=1540.05n

.meas tran vdout1_49ck1530 FIND v(dout1_49) AT=1540.05n

.meas tran vdout1_50ck1530 FIND v(dout1_50) AT=1540.05n

.meas tran vdout1_51ck1530 FIND v(dout1_51) AT=1540.05n

.meas tran vdout1_52ck1530 FIND v(dout1_52) AT=1540.05n

.meas tran vdout1_53ck1530 FIND v(dout1_53) AT=1540.05n

.meas tran vdout1_54ck1530 FIND v(dout1_54) AT=1540.05n

.meas tran vdout1_55ck1530 FIND v(dout1_55) AT=1540.05n

.meas tran vdout1_56ck1530 FIND v(dout1_56) AT=1540.05n

.meas tran vdout1_57ck1530 FIND v(dout1_57) AT=1540.05n

.meas tran vdout1_58ck1530 FIND v(dout1_58) AT=1540.05n

.meas tran vdout1_59ck1530 FIND v(dout1_59) AT=1540.05n

.meas tran vdout1_60ck1530 FIND v(dout1_60) AT=1540.05n

.meas tran vdout1_61ck1530 FIND v(dout1_61) AT=1540.05n

.meas tran vdout1_62ck1530 FIND v(dout1_62) AT=1540.05n

.meas tran vdout1_63ck1530 FIND v(dout1_63) AT=1540.05n

.meas tran vdout1_64ck1530 FIND v(dout1_64) AT=1540.05n

.meas tran vdout1_65ck1530 FIND v(dout1_65) AT=1540.05n

.meas tran vdout1_66ck1530 FIND v(dout1_66) AT=1540.05n

.meas tran vdout1_67ck1530 FIND v(dout1_67) AT=1540.05n

.meas tran vdout1_68ck1530 FIND v(dout1_68) AT=1540.05n

.meas tran vdout1_69ck1530 FIND v(dout1_69) AT=1540.05n

.meas tran vdout1_70ck1530 FIND v(dout1_70) AT=1540.05n

.meas tran vdout1_71ck1530 FIND v(dout1_71) AT=1540.05n

.meas tran vdout1_72ck1530 FIND v(dout1_72) AT=1540.05n

.meas tran vdout1_73ck1530 FIND v(dout1_73) AT=1540.05n

.meas tran vdout1_74ck1530 FIND v(dout1_74) AT=1540.05n

.meas tran vdout1_75ck1530 FIND v(dout1_75) AT=1540.05n

.meas tran vdout1_76ck1530 FIND v(dout1_76) AT=1540.05n

.meas tran vdout1_77ck1530 FIND v(dout1_77) AT=1540.05n

.meas tran vdout1_78ck1530 FIND v(dout1_78) AT=1540.05n

.meas tran vdout1_79ck1530 FIND v(dout1_79) AT=1540.05n

.meas tran vdout1_80ck1530 FIND v(dout1_80) AT=1540.05n

.meas tran vdout1_81ck1530 FIND v(dout1_81) AT=1540.05n

.meas tran vdout1_82ck1530 FIND v(dout1_82) AT=1540.05n

.meas tran vdout1_83ck1530 FIND v(dout1_83) AT=1540.05n

.meas tran vdout1_84ck1530 FIND v(dout1_84) AT=1540.05n

.meas tran vdout1_85ck1530 FIND v(dout1_85) AT=1540.05n

.meas tran vdout1_86ck1530 FIND v(dout1_86) AT=1540.05n

.meas tran vdout1_87ck1530 FIND v(dout1_87) AT=1540.05n

.meas tran vdout1_88ck1530 FIND v(dout1_88) AT=1540.05n

.meas tran vdout1_89ck1530 FIND v(dout1_89) AT=1540.05n

.meas tran vdout1_90ck1530 FIND v(dout1_90) AT=1540.05n

.meas tran vdout1_91ck1530 FIND v(dout1_91) AT=1540.05n

.meas tran vdout1_92ck1530 FIND v(dout1_92) AT=1540.05n

.meas tran vdout1_93ck1530 FIND v(dout1_93) AT=1540.05n

.meas tran vdout1_94ck1530 FIND v(dout1_94) AT=1540.05n

.meas tran vdout1_95ck1530 FIND v(dout1_95) AT=1540.05n

.meas tran vdout1_96ck1530 FIND v(dout1_96) AT=1540.05n

.meas tran vdout1_97ck1530 FIND v(dout1_97) AT=1540.05n

.meas tran vdout1_98ck1530 FIND v(dout1_98) AT=1540.05n

.meas tran vdout1_99ck1530 FIND v(dout1_99) AT=1540.05n

.meas tran vdout1_100ck1530 FIND v(dout1_100) AT=1540.05n

.meas tran vdout1_101ck1530 FIND v(dout1_101) AT=1540.05n

.meas tran vdout1_102ck1530 FIND v(dout1_102) AT=1540.05n

.meas tran vdout1_103ck1530 FIND v(dout1_103) AT=1540.05n

.meas tran vdout1_104ck1530 FIND v(dout1_104) AT=1540.05n

.meas tran vdout1_105ck1530 FIND v(dout1_105) AT=1540.05n

.meas tran vdout1_106ck1530 FIND v(dout1_106) AT=1540.05n

.meas tran vdout1_107ck1530 FIND v(dout1_107) AT=1540.05n

.meas tran vdout1_108ck1530 FIND v(dout1_108) AT=1540.05n

.meas tran vdout1_109ck1530 FIND v(dout1_109) AT=1540.05n

.meas tran vdout1_110ck1530 FIND v(dout1_110) AT=1540.05n

.meas tran vdout1_111ck1530 FIND v(dout1_111) AT=1540.05n

.meas tran vdout1_112ck1530 FIND v(dout1_112) AT=1540.05n

.meas tran vdout1_113ck1530 FIND v(dout1_113) AT=1540.05n

.meas tran vdout1_114ck1530 FIND v(dout1_114) AT=1540.05n

.meas tran vdout1_115ck1530 FIND v(dout1_115) AT=1540.05n

.meas tran vdout1_116ck1530 FIND v(dout1_116) AT=1540.05n

.meas tran vdout1_117ck1530 FIND v(dout1_117) AT=1540.05n

.meas tran vdout1_118ck1530 FIND v(dout1_118) AT=1540.05n

.meas tran vdout1_119ck1530 FIND v(dout1_119) AT=1540.05n

.meas tran vdout1_120ck1530 FIND v(dout1_120) AT=1540.05n

.meas tran vdout1_121ck1530 FIND v(dout1_121) AT=1540.05n

.meas tran vdout1_122ck1530 FIND v(dout1_122) AT=1540.05n

.meas tran vdout1_123ck1530 FIND v(dout1_123) AT=1540.05n

.meas tran vdout1_124ck1530 FIND v(dout1_124) AT=1540.05n

.meas tran vdout1_125ck1530 FIND v(dout1_125) AT=1540.05n

.meas tran vdout1_126ck1530 FIND v(dout1_126) AT=1540.05n

.meas tran vdout1_127ck1530 FIND v(dout1_127) AT=1540.05n

.meas tran vdout1_128ck1530 FIND v(dout1_128) AT=1540.05n

.meas tran vdout1_129ck1530 FIND v(dout1_129) AT=1540.05n

.meas tran vdout1_130ck1530 FIND v(dout1_130) AT=1540.05n

.meas tran vdout1_131ck1530 FIND v(dout1_131) AT=1540.05n

.meas tran vdout1_132ck1530 FIND v(dout1_132) AT=1540.05n

.meas tran vdout1_133ck1530 FIND v(dout1_133) AT=1540.05n

.meas tran vdout1_134ck1530 FIND v(dout1_134) AT=1540.05n

.meas tran vdout1_135ck1530 FIND v(dout1_135) AT=1540.05n

.meas tran vdout1_136ck1530 FIND v(dout1_136) AT=1540.05n

.meas tran vdout1_137ck1530 FIND v(dout1_137) AT=1540.05n

.meas tran vdout1_138ck1530 FIND v(dout1_138) AT=1540.05n

.meas tran vdout1_139ck1530 FIND v(dout1_139) AT=1540.05n

.meas tran vdout1_140ck1530 FIND v(dout1_140) AT=1540.05n

.meas tran vdout1_141ck1530 FIND v(dout1_141) AT=1540.05n

.meas tran vdout1_142ck1530 FIND v(dout1_142) AT=1540.05n

.meas tran vdout1_143ck1530 FIND v(dout1_143) AT=1540.05n

.meas tran vdout1_144ck1530 FIND v(dout1_144) AT=1540.05n

.meas tran vdout1_145ck1530 FIND v(dout1_145) AT=1540.05n

.meas tran vdout1_146ck1530 FIND v(dout1_146) AT=1540.05n

.meas tran vdout1_147ck1530 FIND v(dout1_147) AT=1540.05n

.meas tran vdout1_148ck1530 FIND v(dout1_148) AT=1540.05n

.meas tran vdout1_149ck1530 FIND v(dout1_149) AT=1540.05n

.meas tran vdout1_150ck1530 FIND v(dout1_150) AT=1540.05n

.meas tran vdout1_151ck1530 FIND v(dout1_151) AT=1540.05n

.meas tran vdout1_152ck1530 FIND v(dout1_152) AT=1540.05n

.meas tran vdout1_153ck1530 FIND v(dout1_153) AT=1540.05n

.meas tran vdout1_154ck1530 FIND v(dout1_154) AT=1540.05n

.meas tran vdout1_155ck1530 FIND v(dout1_155) AT=1540.05n

.meas tran vdout1_156ck1530 FIND v(dout1_156) AT=1540.05n

.meas tran vdout1_157ck1530 FIND v(dout1_157) AT=1540.05n

.meas tran vdout1_158ck1530 FIND v(dout1_158) AT=1540.05n

.meas tran vdout1_159ck1530 FIND v(dout1_159) AT=1540.05n

.meas tran vdout1_160ck1530 FIND v(dout1_160) AT=1540.05n

.meas tran vdout1_161ck1530 FIND v(dout1_161) AT=1540.05n

.meas tran vdout1_162ck1530 FIND v(dout1_162) AT=1540.05n

.meas tran vdout1_163ck1530 FIND v(dout1_163) AT=1540.05n

.meas tran vdout1_164ck1530 FIND v(dout1_164) AT=1540.05n

.meas tran vdout1_165ck1530 FIND v(dout1_165) AT=1540.05n

.meas tran vdout1_166ck1530 FIND v(dout1_166) AT=1540.05n

.meas tran vdout1_167ck1530 FIND v(dout1_167) AT=1540.05n

.meas tran vdout1_168ck1530 FIND v(dout1_168) AT=1540.05n

.meas tran vdout1_169ck1530 FIND v(dout1_169) AT=1540.05n

.meas tran vdout1_170ck1530 FIND v(dout1_170) AT=1540.05n

.meas tran vdout1_171ck1530 FIND v(dout1_171) AT=1540.05n

.meas tran vdout1_172ck1530 FIND v(dout1_172) AT=1540.05n

.meas tran vdout1_173ck1530 FIND v(dout1_173) AT=1540.05n

.meas tran vdout1_174ck1530 FIND v(dout1_174) AT=1540.05n

.meas tran vdout1_175ck1530 FIND v(dout1_175) AT=1540.05n

.meas tran vdout1_176ck1530 FIND v(dout1_176) AT=1540.05n

.meas tran vdout1_177ck1530 FIND v(dout1_177) AT=1540.05n

.meas tran vdout1_178ck1530 FIND v(dout1_178) AT=1540.05n

.meas tran vdout1_179ck1530 FIND v(dout1_179) AT=1540.05n

.meas tran vdout1_180ck1530 FIND v(dout1_180) AT=1540.05n

.meas tran vdout1_181ck1530 FIND v(dout1_181) AT=1540.05n

.meas tran vdout1_182ck1530 FIND v(dout1_182) AT=1540.05n

.meas tran vdout1_183ck1530 FIND v(dout1_183) AT=1540.05n

.meas tran vdout1_184ck1530 FIND v(dout1_184) AT=1540.05n

.meas tran vdout1_185ck1530 FIND v(dout1_185) AT=1540.05n

.meas tran vdout1_186ck1530 FIND v(dout1_186) AT=1540.05n

.meas tran vdout1_187ck1530 FIND v(dout1_187) AT=1540.05n

.meas tran vdout1_188ck1530 FIND v(dout1_188) AT=1540.05n

.meas tran vdout1_189ck1530 FIND v(dout1_189) AT=1540.05n

.meas tran vdout1_190ck1530 FIND v(dout1_190) AT=1540.05n

.meas tran vdout1_191ck1530 FIND v(dout1_191) AT=1540.05n

.meas tran vdout1_192ck1530 FIND v(dout1_192) AT=1540.05n

.meas tran vdout1_193ck1530 FIND v(dout1_193) AT=1540.05n

.meas tran vdout1_194ck1530 FIND v(dout1_194) AT=1540.05n

.meas tran vdout1_195ck1530 FIND v(dout1_195) AT=1540.05n

.meas tran vdout1_196ck1530 FIND v(dout1_196) AT=1540.05n

.meas tran vdout1_197ck1530 FIND v(dout1_197) AT=1540.05n

.meas tran vdout1_198ck1530 FIND v(dout1_198) AT=1540.05n

.meas tran vdout1_199ck1530 FIND v(dout1_199) AT=1540.05n

.meas tran vdout1_200ck1530 FIND v(dout1_200) AT=1540.05n

.meas tran vdout1_201ck1530 FIND v(dout1_201) AT=1540.05n

.meas tran vdout1_202ck1530 FIND v(dout1_202) AT=1540.05n

.meas tran vdout1_203ck1530 FIND v(dout1_203) AT=1540.05n

.meas tran vdout1_204ck1530 FIND v(dout1_204) AT=1540.05n

.meas tran vdout1_205ck1530 FIND v(dout1_205) AT=1540.05n

.meas tran vdout1_206ck1530 FIND v(dout1_206) AT=1540.05n

.meas tran vdout1_207ck1530 FIND v(dout1_207) AT=1540.05n

.meas tran vdout1_208ck1530 FIND v(dout1_208) AT=1540.05n

.meas tran vdout1_209ck1530 FIND v(dout1_209) AT=1540.05n

.meas tran vdout1_210ck1530 FIND v(dout1_210) AT=1540.05n

.meas tran vdout1_211ck1530 FIND v(dout1_211) AT=1540.05n

.meas tran vdout1_212ck1530 FIND v(dout1_212) AT=1540.05n

.meas tran vdout1_213ck1530 FIND v(dout1_213) AT=1540.05n

.meas tran vdout1_214ck1530 FIND v(dout1_214) AT=1540.05n

.meas tran vdout1_215ck1530 FIND v(dout1_215) AT=1540.05n

.meas tran vdout1_216ck1530 FIND v(dout1_216) AT=1540.05n

.meas tran vdout1_217ck1530 FIND v(dout1_217) AT=1540.05n

.meas tran vdout1_218ck1530 FIND v(dout1_218) AT=1540.05n

.meas tran vdout1_219ck1530 FIND v(dout1_219) AT=1540.05n

.meas tran vdout1_220ck1530 FIND v(dout1_220) AT=1540.05n

.meas tran vdout1_221ck1530 FIND v(dout1_221) AT=1540.05n

.meas tran vdout1_222ck1530 FIND v(dout1_222) AT=1540.05n

.meas tran vdout1_223ck1530 FIND v(dout1_223) AT=1540.05n

.meas tran vdout1_224ck1530 FIND v(dout1_224) AT=1540.05n

.meas tran vdout1_225ck1530 FIND v(dout1_225) AT=1540.05n

.meas tran vdout1_226ck1530 FIND v(dout1_226) AT=1540.05n

.meas tran vdout1_227ck1530 FIND v(dout1_227) AT=1540.05n

.meas tran vdout1_228ck1530 FIND v(dout1_228) AT=1540.05n

.meas tran vdout1_229ck1530 FIND v(dout1_229) AT=1540.05n

.meas tran vdout1_230ck1530 FIND v(dout1_230) AT=1540.05n

.meas tran vdout1_231ck1530 FIND v(dout1_231) AT=1540.05n

.meas tran vdout1_232ck1530 FIND v(dout1_232) AT=1540.05n

.meas tran vdout1_233ck1530 FIND v(dout1_233) AT=1540.05n

.meas tran vdout1_234ck1530 FIND v(dout1_234) AT=1540.05n

.meas tran vdout1_235ck1530 FIND v(dout1_235) AT=1540.05n

.meas tran vdout1_236ck1530 FIND v(dout1_236) AT=1540.05n

.meas tran vdout1_237ck1530 FIND v(dout1_237) AT=1540.05n

.meas tran vdout1_238ck1530 FIND v(dout1_238) AT=1540.05n

.meas tran vdout1_239ck1530 FIND v(dout1_239) AT=1540.05n

.meas tran vdout1_240ck1530 FIND v(dout1_240) AT=1540.05n

.meas tran vdout1_241ck1530 FIND v(dout1_241) AT=1540.05n

.meas tran vdout1_242ck1530 FIND v(dout1_242) AT=1540.05n

.meas tran vdout1_243ck1530 FIND v(dout1_243) AT=1540.05n

.meas tran vdout1_244ck1530 FIND v(dout1_244) AT=1540.05n

.meas tran vdout1_245ck1530 FIND v(dout1_245) AT=1540.05n

.meas tran vdout1_246ck1530 FIND v(dout1_246) AT=1540.05n

.meas tran vdout1_247ck1530 FIND v(dout1_247) AT=1540.05n

.meas tran vdout1_248ck1530 FIND v(dout1_248) AT=1540.05n

.meas tran vdout1_249ck1530 FIND v(dout1_249) AT=1540.05n

.meas tran vdout1_250ck1530 FIND v(dout1_250) AT=1540.05n

.meas tran vdout1_251ck1530 FIND v(dout1_251) AT=1540.05n

.meas tran vdout1_252ck1530 FIND v(dout1_252) AT=1540.05n

.meas tran vdout1_253ck1530 FIND v(dout1_253) AT=1540.05n

.meas tran vdout1_254ck1530 FIND v(dout1_254) AT=1540.05n

.meas tran vdout1_255ck1530 FIND v(dout1_255) AT=1540.05n

.meas tran vdout1_256ck1530 FIND v(dout1_256) AT=1540.05n

.meas tran vdout1_0ck1600 FIND v(dout1_0) AT=1610.05n

.meas tran vdout1_1ck1600 FIND v(dout1_1) AT=1610.05n

.meas tran vdout1_2ck1600 FIND v(dout1_2) AT=1610.05n

.meas tran vdout1_3ck1600 FIND v(dout1_3) AT=1610.05n

.meas tran vdout1_4ck1600 FIND v(dout1_4) AT=1610.05n

.meas tran vdout1_5ck1600 FIND v(dout1_5) AT=1610.05n

.meas tran vdout1_6ck1600 FIND v(dout1_6) AT=1610.05n

.meas tran vdout1_7ck1600 FIND v(dout1_7) AT=1610.05n

.meas tran vdout1_8ck1600 FIND v(dout1_8) AT=1610.05n

.meas tran vdout1_9ck1600 FIND v(dout1_9) AT=1610.05n

.meas tran vdout1_10ck1600 FIND v(dout1_10) AT=1610.05n

.meas tran vdout1_11ck1600 FIND v(dout1_11) AT=1610.05n

.meas tran vdout1_12ck1600 FIND v(dout1_12) AT=1610.05n

.meas tran vdout1_13ck1600 FIND v(dout1_13) AT=1610.05n

.meas tran vdout1_14ck1600 FIND v(dout1_14) AT=1610.05n

.meas tran vdout1_15ck1600 FIND v(dout1_15) AT=1610.05n

.meas tran vdout1_16ck1600 FIND v(dout1_16) AT=1610.05n

.meas tran vdout1_17ck1600 FIND v(dout1_17) AT=1610.05n

.meas tran vdout1_18ck1600 FIND v(dout1_18) AT=1610.05n

.meas tran vdout1_19ck1600 FIND v(dout1_19) AT=1610.05n

.meas tran vdout1_20ck1600 FIND v(dout1_20) AT=1610.05n

.meas tran vdout1_21ck1600 FIND v(dout1_21) AT=1610.05n

.meas tran vdout1_22ck1600 FIND v(dout1_22) AT=1610.05n

.meas tran vdout1_23ck1600 FIND v(dout1_23) AT=1610.05n

.meas tran vdout1_24ck1600 FIND v(dout1_24) AT=1610.05n

.meas tran vdout1_25ck1600 FIND v(dout1_25) AT=1610.05n

.meas tran vdout1_26ck1600 FIND v(dout1_26) AT=1610.05n

.meas tran vdout1_27ck1600 FIND v(dout1_27) AT=1610.05n

.meas tran vdout1_28ck1600 FIND v(dout1_28) AT=1610.05n

.meas tran vdout1_29ck1600 FIND v(dout1_29) AT=1610.05n

.meas tran vdout1_30ck1600 FIND v(dout1_30) AT=1610.05n

.meas tran vdout1_31ck1600 FIND v(dout1_31) AT=1610.05n

.meas tran vdout1_32ck1600 FIND v(dout1_32) AT=1610.05n

.meas tran vdout1_33ck1600 FIND v(dout1_33) AT=1610.05n

.meas tran vdout1_34ck1600 FIND v(dout1_34) AT=1610.05n

.meas tran vdout1_35ck1600 FIND v(dout1_35) AT=1610.05n

.meas tran vdout1_36ck1600 FIND v(dout1_36) AT=1610.05n

.meas tran vdout1_37ck1600 FIND v(dout1_37) AT=1610.05n

.meas tran vdout1_38ck1600 FIND v(dout1_38) AT=1610.05n

.meas tran vdout1_39ck1600 FIND v(dout1_39) AT=1610.05n

.meas tran vdout1_40ck1600 FIND v(dout1_40) AT=1610.05n

.meas tran vdout1_41ck1600 FIND v(dout1_41) AT=1610.05n

.meas tran vdout1_42ck1600 FIND v(dout1_42) AT=1610.05n

.meas tran vdout1_43ck1600 FIND v(dout1_43) AT=1610.05n

.meas tran vdout1_44ck1600 FIND v(dout1_44) AT=1610.05n

.meas tran vdout1_45ck1600 FIND v(dout1_45) AT=1610.05n

.meas tran vdout1_46ck1600 FIND v(dout1_46) AT=1610.05n

.meas tran vdout1_47ck1600 FIND v(dout1_47) AT=1610.05n

.meas tran vdout1_48ck1600 FIND v(dout1_48) AT=1610.05n

.meas tran vdout1_49ck1600 FIND v(dout1_49) AT=1610.05n

.meas tran vdout1_50ck1600 FIND v(dout1_50) AT=1610.05n

.meas tran vdout1_51ck1600 FIND v(dout1_51) AT=1610.05n

.meas tran vdout1_52ck1600 FIND v(dout1_52) AT=1610.05n

.meas tran vdout1_53ck1600 FIND v(dout1_53) AT=1610.05n

.meas tran vdout1_54ck1600 FIND v(dout1_54) AT=1610.05n

.meas tran vdout1_55ck1600 FIND v(dout1_55) AT=1610.05n

.meas tran vdout1_56ck1600 FIND v(dout1_56) AT=1610.05n

.meas tran vdout1_57ck1600 FIND v(dout1_57) AT=1610.05n

.meas tran vdout1_58ck1600 FIND v(dout1_58) AT=1610.05n

.meas tran vdout1_59ck1600 FIND v(dout1_59) AT=1610.05n

.meas tran vdout1_60ck1600 FIND v(dout1_60) AT=1610.05n

.meas tran vdout1_61ck1600 FIND v(dout1_61) AT=1610.05n

.meas tran vdout1_62ck1600 FIND v(dout1_62) AT=1610.05n

.meas tran vdout1_63ck1600 FIND v(dout1_63) AT=1610.05n

.meas tran vdout1_64ck1600 FIND v(dout1_64) AT=1610.05n

.meas tran vdout1_65ck1600 FIND v(dout1_65) AT=1610.05n

.meas tran vdout1_66ck1600 FIND v(dout1_66) AT=1610.05n

.meas tran vdout1_67ck1600 FIND v(dout1_67) AT=1610.05n

.meas tran vdout1_68ck1600 FIND v(dout1_68) AT=1610.05n

.meas tran vdout1_69ck1600 FIND v(dout1_69) AT=1610.05n

.meas tran vdout1_70ck1600 FIND v(dout1_70) AT=1610.05n

.meas tran vdout1_71ck1600 FIND v(dout1_71) AT=1610.05n

.meas tran vdout1_72ck1600 FIND v(dout1_72) AT=1610.05n

.meas tran vdout1_73ck1600 FIND v(dout1_73) AT=1610.05n

.meas tran vdout1_74ck1600 FIND v(dout1_74) AT=1610.05n

.meas tran vdout1_75ck1600 FIND v(dout1_75) AT=1610.05n

.meas tran vdout1_76ck1600 FIND v(dout1_76) AT=1610.05n

.meas tran vdout1_77ck1600 FIND v(dout1_77) AT=1610.05n

.meas tran vdout1_78ck1600 FIND v(dout1_78) AT=1610.05n

.meas tran vdout1_79ck1600 FIND v(dout1_79) AT=1610.05n

.meas tran vdout1_80ck1600 FIND v(dout1_80) AT=1610.05n

.meas tran vdout1_81ck1600 FIND v(dout1_81) AT=1610.05n

.meas tran vdout1_82ck1600 FIND v(dout1_82) AT=1610.05n

.meas tran vdout1_83ck1600 FIND v(dout1_83) AT=1610.05n

.meas tran vdout1_84ck1600 FIND v(dout1_84) AT=1610.05n

.meas tran vdout1_85ck1600 FIND v(dout1_85) AT=1610.05n

.meas tran vdout1_86ck1600 FIND v(dout1_86) AT=1610.05n

.meas tran vdout1_87ck1600 FIND v(dout1_87) AT=1610.05n

.meas tran vdout1_88ck1600 FIND v(dout1_88) AT=1610.05n

.meas tran vdout1_89ck1600 FIND v(dout1_89) AT=1610.05n

.meas tran vdout1_90ck1600 FIND v(dout1_90) AT=1610.05n

.meas tran vdout1_91ck1600 FIND v(dout1_91) AT=1610.05n

.meas tran vdout1_92ck1600 FIND v(dout1_92) AT=1610.05n

.meas tran vdout1_93ck1600 FIND v(dout1_93) AT=1610.05n

.meas tran vdout1_94ck1600 FIND v(dout1_94) AT=1610.05n

.meas tran vdout1_95ck1600 FIND v(dout1_95) AT=1610.05n

.meas tran vdout1_96ck1600 FIND v(dout1_96) AT=1610.05n

.meas tran vdout1_97ck1600 FIND v(dout1_97) AT=1610.05n

.meas tran vdout1_98ck1600 FIND v(dout1_98) AT=1610.05n

.meas tran vdout1_99ck1600 FIND v(dout1_99) AT=1610.05n

.meas tran vdout1_100ck1600 FIND v(dout1_100) AT=1610.05n

.meas tran vdout1_101ck1600 FIND v(dout1_101) AT=1610.05n

.meas tran vdout1_102ck1600 FIND v(dout1_102) AT=1610.05n

.meas tran vdout1_103ck1600 FIND v(dout1_103) AT=1610.05n

.meas tran vdout1_104ck1600 FIND v(dout1_104) AT=1610.05n

.meas tran vdout1_105ck1600 FIND v(dout1_105) AT=1610.05n

.meas tran vdout1_106ck1600 FIND v(dout1_106) AT=1610.05n

.meas tran vdout1_107ck1600 FIND v(dout1_107) AT=1610.05n

.meas tran vdout1_108ck1600 FIND v(dout1_108) AT=1610.05n

.meas tran vdout1_109ck1600 FIND v(dout1_109) AT=1610.05n

.meas tran vdout1_110ck1600 FIND v(dout1_110) AT=1610.05n

.meas tran vdout1_111ck1600 FIND v(dout1_111) AT=1610.05n

.meas tran vdout1_112ck1600 FIND v(dout1_112) AT=1610.05n

.meas tran vdout1_113ck1600 FIND v(dout1_113) AT=1610.05n

.meas tran vdout1_114ck1600 FIND v(dout1_114) AT=1610.05n

.meas tran vdout1_115ck1600 FIND v(dout1_115) AT=1610.05n

.meas tran vdout1_116ck1600 FIND v(dout1_116) AT=1610.05n

.meas tran vdout1_117ck1600 FIND v(dout1_117) AT=1610.05n

.meas tran vdout1_118ck1600 FIND v(dout1_118) AT=1610.05n

.meas tran vdout1_119ck1600 FIND v(dout1_119) AT=1610.05n

.meas tran vdout1_120ck1600 FIND v(dout1_120) AT=1610.05n

.meas tran vdout1_121ck1600 FIND v(dout1_121) AT=1610.05n

.meas tran vdout1_122ck1600 FIND v(dout1_122) AT=1610.05n

.meas tran vdout1_123ck1600 FIND v(dout1_123) AT=1610.05n

.meas tran vdout1_124ck1600 FIND v(dout1_124) AT=1610.05n

.meas tran vdout1_125ck1600 FIND v(dout1_125) AT=1610.05n

.meas tran vdout1_126ck1600 FIND v(dout1_126) AT=1610.05n

.meas tran vdout1_127ck1600 FIND v(dout1_127) AT=1610.05n

.meas tran vdout1_128ck1600 FIND v(dout1_128) AT=1610.05n

.meas tran vdout1_129ck1600 FIND v(dout1_129) AT=1610.05n

.meas tran vdout1_130ck1600 FIND v(dout1_130) AT=1610.05n

.meas tran vdout1_131ck1600 FIND v(dout1_131) AT=1610.05n

.meas tran vdout1_132ck1600 FIND v(dout1_132) AT=1610.05n

.meas tran vdout1_133ck1600 FIND v(dout1_133) AT=1610.05n

.meas tran vdout1_134ck1600 FIND v(dout1_134) AT=1610.05n

.meas tran vdout1_135ck1600 FIND v(dout1_135) AT=1610.05n

.meas tran vdout1_136ck1600 FIND v(dout1_136) AT=1610.05n

.meas tran vdout1_137ck1600 FIND v(dout1_137) AT=1610.05n

.meas tran vdout1_138ck1600 FIND v(dout1_138) AT=1610.05n

.meas tran vdout1_139ck1600 FIND v(dout1_139) AT=1610.05n

.meas tran vdout1_140ck1600 FIND v(dout1_140) AT=1610.05n

.meas tran vdout1_141ck1600 FIND v(dout1_141) AT=1610.05n

.meas tran vdout1_142ck1600 FIND v(dout1_142) AT=1610.05n

.meas tran vdout1_143ck1600 FIND v(dout1_143) AT=1610.05n

.meas tran vdout1_144ck1600 FIND v(dout1_144) AT=1610.05n

.meas tran vdout1_145ck1600 FIND v(dout1_145) AT=1610.05n

.meas tran vdout1_146ck1600 FIND v(dout1_146) AT=1610.05n

.meas tran vdout1_147ck1600 FIND v(dout1_147) AT=1610.05n

.meas tran vdout1_148ck1600 FIND v(dout1_148) AT=1610.05n

.meas tran vdout1_149ck1600 FIND v(dout1_149) AT=1610.05n

.meas tran vdout1_150ck1600 FIND v(dout1_150) AT=1610.05n

.meas tran vdout1_151ck1600 FIND v(dout1_151) AT=1610.05n

.meas tran vdout1_152ck1600 FIND v(dout1_152) AT=1610.05n

.meas tran vdout1_153ck1600 FIND v(dout1_153) AT=1610.05n

.meas tran vdout1_154ck1600 FIND v(dout1_154) AT=1610.05n

.meas tran vdout1_155ck1600 FIND v(dout1_155) AT=1610.05n

.meas tran vdout1_156ck1600 FIND v(dout1_156) AT=1610.05n

.meas tran vdout1_157ck1600 FIND v(dout1_157) AT=1610.05n

.meas tran vdout1_158ck1600 FIND v(dout1_158) AT=1610.05n

.meas tran vdout1_159ck1600 FIND v(dout1_159) AT=1610.05n

.meas tran vdout1_160ck1600 FIND v(dout1_160) AT=1610.05n

.meas tran vdout1_161ck1600 FIND v(dout1_161) AT=1610.05n

.meas tran vdout1_162ck1600 FIND v(dout1_162) AT=1610.05n

.meas tran vdout1_163ck1600 FIND v(dout1_163) AT=1610.05n

.meas tran vdout1_164ck1600 FIND v(dout1_164) AT=1610.05n

.meas tran vdout1_165ck1600 FIND v(dout1_165) AT=1610.05n

.meas tran vdout1_166ck1600 FIND v(dout1_166) AT=1610.05n

.meas tran vdout1_167ck1600 FIND v(dout1_167) AT=1610.05n

.meas tran vdout1_168ck1600 FIND v(dout1_168) AT=1610.05n

.meas tran vdout1_169ck1600 FIND v(dout1_169) AT=1610.05n

.meas tran vdout1_170ck1600 FIND v(dout1_170) AT=1610.05n

.meas tran vdout1_171ck1600 FIND v(dout1_171) AT=1610.05n

.meas tran vdout1_172ck1600 FIND v(dout1_172) AT=1610.05n

.meas tran vdout1_173ck1600 FIND v(dout1_173) AT=1610.05n

.meas tran vdout1_174ck1600 FIND v(dout1_174) AT=1610.05n

.meas tran vdout1_175ck1600 FIND v(dout1_175) AT=1610.05n

.meas tran vdout1_176ck1600 FIND v(dout1_176) AT=1610.05n

.meas tran vdout1_177ck1600 FIND v(dout1_177) AT=1610.05n

.meas tran vdout1_178ck1600 FIND v(dout1_178) AT=1610.05n

.meas tran vdout1_179ck1600 FIND v(dout1_179) AT=1610.05n

.meas tran vdout1_180ck1600 FIND v(dout1_180) AT=1610.05n

.meas tran vdout1_181ck1600 FIND v(dout1_181) AT=1610.05n

.meas tran vdout1_182ck1600 FIND v(dout1_182) AT=1610.05n

.meas tran vdout1_183ck1600 FIND v(dout1_183) AT=1610.05n

.meas tran vdout1_184ck1600 FIND v(dout1_184) AT=1610.05n

.meas tran vdout1_185ck1600 FIND v(dout1_185) AT=1610.05n

.meas tran vdout1_186ck1600 FIND v(dout1_186) AT=1610.05n

.meas tran vdout1_187ck1600 FIND v(dout1_187) AT=1610.05n

.meas tran vdout1_188ck1600 FIND v(dout1_188) AT=1610.05n

.meas tran vdout1_189ck1600 FIND v(dout1_189) AT=1610.05n

.meas tran vdout1_190ck1600 FIND v(dout1_190) AT=1610.05n

.meas tran vdout1_191ck1600 FIND v(dout1_191) AT=1610.05n

.meas tran vdout1_192ck1600 FIND v(dout1_192) AT=1610.05n

.meas tran vdout1_193ck1600 FIND v(dout1_193) AT=1610.05n

.meas tran vdout1_194ck1600 FIND v(dout1_194) AT=1610.05n

.meas tran vdout1_195ck1600 FIND v(dout1_195) AT=1610.05n

.meas tran vdout1_196ck1600 FIND v(dout1_196) AT=1610.05n

.meas tran vdout1_197ck1600 FIND v(dout1_197) AT=1610.05n

.meas tran vdout1_198ck1600 FIND v(dout1_198) AT=1610.05n

.meas tran vdout1_199ck1600 FIND v(dout1_199) AT=1610.05n

.meas tran vdout1_200ck1600 FIND v(dout1_200) AT=1610.05n

.meas tran vdout1_201ck1600 FIND v(dout1_201) AT=1610.05n

.meas tran vdout1_202ck1600 FIND v(dout1_202) AT=1610.05n

.meas tran vdout1_203ck1600 FIND v(dout1_203) AT=1610.05n

.meas tran vdout1_204ck1600 FIND v(dout1_204) AT=1610.05n

.meas tran vdout1_205ck1600 FIND v(dout1_205) AT=1610.05n

.meas tran vdout1_206ck1600 FIND v(dout1_206) AT=1610.05n

.meas tran vdout1_207ck1600 FIND v(dout1_207) AT=1610.05n

.meas tran vdout1_208ck1600 FIND v(dout1_208) AT=1610.05n

.meas tran vdout1_209ck1600 FIND v(dout1_209) AT=1610.05n

.meas tran vdout1_210ck1600 FIND v(dout1_210) AT=1610.05n

.meas tran vdout1_211ck1600 FIND v(dout1_211) AT=1610.05n

.meas tran vdout1_212ck1600 FIND v(dout1_212) AT=1610.05n

.meas tran vdout1_213ck1600 FIND v(dout1_213) AT=1610.05n

.meas tran vdout1_214ck1600 FIND v(dout1_214) AT=1610.05n

.meas tran vdout1_215ck1600 FIND v(dout1_215) AT=1610.05n

.meas tran vdout1_216ck1600 FIND v(dout1_216) AT=1610.05n

.meas tran vdout1_217ck1600 FIND v(dout1_217) AT=1610.05n

.meas tran vdout1_218ck1600 FIND v(dout1_218) AT=1610.05n

.meas tran vdout1_219ck1600 FIND v(dout1_219) AT=1610.05n

.meas tran vdout1_220ck1600 FIND v(dout1_220) AT=1610.05n

.meas tran vdout1_221ck1600 FIND v(dout1_221) AT=1610.05n

.meas tran vdout1_222ck1600 FIND v(dout1_222) AT=1610.05n

.meas tran vdout1_223ck1600 FIND v(dout1_223) AT=1610.05n

.meas tran vdout1_224ck1600 FIND v(dout1_224) AT=1610.05n

.meas tran vdout1_225ck1600 FIND v(dout1_225) AT=1610.05n

.meas tran vdout1_226ck1600 FIND v(dout1_226) AT=1610.05n

.meas tran vdout1_227ck1600 FIND v(dout1_227) AT=1610.05n

.meas tran vdout1_228ck1600 FIND v(dout1_228) AT=1610.05n

.meas tran vdout1_229ck1600 FIND v(dout1_229) AT=1610.05n

.meas tran vdout1_230ck1600 FIND v(dout1_230) AT=1610.05n

.meas tran vdout1_231ck1600 FIND v(dout1_231) AT=1610.05n

.meas tran vdout1_232ck1600 FIND v(dout1_232) AT=1610.05n

.meas tran vdout1_233ck1600 FIND v(dout1_233) AT=1610.05n

.meas tran vdout1_234ck1600 FIND v(dout1_234) AT=1610.05n

.meas tran vdout1_235ck1600 FIND v(dout1_235) AT=1610.05n

.meas tran vdout1_236ck1600 FIND v(dout1_236) AT=1610.05n

.meas tran vdout1_237ck1600 FIND v(dout1_237) AT=1610.05n

.meas tran vdout1_238ck1600 FIND v(dout1_238) AT=1610.05n

.meas tran vdout1_239ck1600 FIND v(dout1_239) AT=1610.05n

.meas tran vdout1_240ck1600 FIND v(dout1_240) AT=1610.05n

.meas tran vdout1_241ck1600 FIND v(dout1_241) AT=1610.05n

.meas tran vdout1_242ck1600 FIND v(dout1_242) AT=1610.05n

.meas tran vdout1_243ck1600 FIND v(dout1_243) AT=1610.05n

.meas tran vdout1_244ck1600 FIND v(dout1_244) AT=1610.05n

.meas tran vdout1_245ck1600 FIND v(dout1_245) AT=1610.05n

.meas tran vdout1_246ck1600 FIND v(dout1_246) AT=1610.05n

.meas tran vdout1_247ck1600 FIND v(dout1_247) AT=1610.05n

.meas tran vdout1_248ck1600 FIND v(dout1_248) AT=1610.05n

.meas tran vdout1_249ck1600 FIND v(dout1_249) AT=1610.05n

.meas tran vdout1_250ck1600 FIND v(dout1_250) AT=1610.05n

.meas tran vdout1_251ck1600 FIND v(dout1_251) AT=1610.05n

.meas tran vdout1_252ck1600 FIND v(dout1_252) AT=1610.05n

.meas tran vdout1_253ck1600 FIND v(dout1_253) AT=1610.05n

.meas tran vdout1_254ck1600 FIND v(dout1_254) AT=1610.05n

.meas tran vdout1_255ck1600 FIND v(dout1_255) AT=1610.05n

.meas tran vdout1_256ck1600 FIND v(dout1_256) AT=1610.05n

.meas tran vdout1_0ck1610 FIND v(dout1_0) AT=1620.05n

.meas tran vdout1_1ck1610 FIND v(dout1_1) AT=1620.05n

.meas tran vdout1_2ck1610 FIND v(dout1_2) AT=1620.05n

.meas tran vdout1_3ck1610 FIND v(dout1_3) AT=1620.05n

.meas tran vdout1_4ck1610 FIND v(dout1_4) AT=1620.05n

.meas tran vdout1_5ck1610 FIND v(dout1_5) AT=1620.05n

.meas tran vdout1_6ck1610 FIND v(dout1_6) AT=1620.05n

.meas tran vdout1_7ck1610 FIND v(dout1_7) AT=1620.05n

.meas tran vdout1_8ck1610 FIND v(dout1_8) AT=1620.05n

.meas tran vdout1_9ck1610 FIND v(dout1_9) AT=1620.05n

.meas tran vdout1_10ck1610 FIND v(dout1_10) AT=1620.05n

.meas tran vdout1_11ck1610 FIND v(dout1_11) AT=1620.05n

.meas tran vdout1_12ck1610 FIND v(dout1_12) AT=1620.05n

.meas tran vdout1_13ck1610 FIND v(dout1_13) AT=1620.05n

.meas tran vdout1_14ck1610 FIND v(dout1_14) AT=1620.05n

.meas tran vdout1_15ck1610 FIND v(dout1_15) AT=1620.05n

.meas tran vdout1_16ck1610 FIND v(dout1_16) AT=1620.05n

.meas tran vdout1_17ck1610 FIND v(dout1_17) AT=1620.05n

.meas tran vdout1_18ck1610 FIND v(dout1_18) AT=1620.05n

.meas tran vdout1_19ck1610 FIND v(dout1_19) AT=1620.05n

.meas tran vdout1_20ck1610 FIND v(dout1_20) AT=1620.05n

.meas tran vdout1_21ck1610 FIND v(dout1_21) AT=1620.05n

.meas tran vdout1_22ck1610 FIND v(dout1_22) AT=1620.05n

.meas tran vdout1_23ck1610 FIND v(dout1_23) AT=1620.05n

.meas tran vdout1_24ck1610 FIND v(dout1_24) AT=1620.05n

.meas tran vdout1_25ck1610 FIND v(dout1_25) AT=1620.05n

.meas tran vdout1_26ck1610 FIND v(dout1_26) AT=1620.05n

.meas tran vdout1_27ck1610 FIND v(dout1_27) AT=1620.05n

.meas tran vdout1_28ck1610 FIND v(dout1_28) AT=1620.05n

.meas tran vdout1_29ck1610 FIND v(dout1_29) AT=1620.05n

.meas tran vdout1_30ck1610 FIND v(dout1_30) AT=1620.05n

.meas tran vdout1_31ck1610 FIND v(dout1_31) AT=1620.05n

.meas tran vdout1_32ck1610 FIND v(dout1_32) AT=1620.05n

.meas tran vdout1_33ck1610 FIND v(dout1_33) AT=1620.05n

.meas tran vdout1_34ck1610 FIND v(dout1_34) AT=1620.05n

.meas tran vdout1_35ck1610 FIND v(dout1_35) AT=1620.05n

.meas tran vdout1_36ck1610 FIND v(dout1_36) AT=1620.05n

.meas tran vdout1_37ck1610 FIND v(dout1_37) AT=1620.05n

.meas tran vdout1_38ck1610 FIND v(dout1_38) AT=1620.05n

.meas tran vdout1_39ck1610 FIND v(dout1_39) AT=1620.05n

.meas tran vdout1_40ck1610 FIND v(dout1_40) AT=1620.05n

.meas tran vdout1_41ck1610 FIND v(dout1_41) AT=1620.05n

.meas tran vdout1_42ck1610 FIND v(dout1_42) AT=1620.05n

.meas tran vdout1_43ck1610 FIND v(dout1_43) AT=1620.05n

.meas tran vdout1_44ck1610 FIND v(dout1_44) AT=1620.05n

.meas tran vdout1_45ck1610 FIND v(dout1_45) AT=1620.05n

.meas tran vdout1_46ck1610 FIND v(dout1_46) AT=1620.05n

.meas tran vdout1_47ck1610 FIND v(dout1_47) AT=1620.05n

.meas tran vdout1_48ck1610 FIND v(dout1_48) AT=1620.05n

.meas tran vdout1_49ck1610 FIND v(dout1_49) AT=1620.05n

.meas tran vdout1_50ck1610 FIND v(dout1_50) AT=1620.05n

.meas tran vdout1_51ck1610 FIND v(dout1_51) AT=1620.05n

.meas tran vdout1_52ck1610 FIND v(dout1_52) AT=1620.05n

.meas tran vdout1_53ck1610 FIND v(dout1_53) AT=1620.05n

.meas tran vdout1_54ck1610 FIND v(dout1_54) AT=1620.05n

.meas tran vdout1_55ck1610 FIND v(dout1_55) AT=1620.05n

.meas tran vdout1_56ck1610 FIND v(dout1_56) AT=1620.05n

.meas tran vdout1_57ck1610 FIND v(dout1_57) AT=1620.05n

.meas tran vdout1_58ck1610 FIND v(dout1_58) AT=1620.05n

.meas tran vdout1_59ck1610 FIND v(dout1_59) AT=1620.05n

.meas tran vdout1_60ck1610 FIND v(dout1_60) AT=1620.05n

.meas tran vdout1_61ck1610 FIND v(dout1_61) AT=1620.05n

.meas tran vdout1_62ck1610 FIND v(dout1_62) AT=1620.05n

.meas tran vdout1_63ck1610 FIND v(dout1_63) AT=1620.05n

.meas tran vdout1_64ck1610 FIND v(dout1_64) AT=1620.05n

.meas tran vdout1_65ck1610 FIND v(dout1_65) AT=1620.05n

.meas tran vdout1_66ck1610 FIND v(dout1_66) AT=1620.05n

.meas tran vdout1_67ck1610 FIND v(dout1_67) AT=1620.05n

.meas tran vdout1_68ck1610 FIND v(dout1_68) AT=1620.05n

.meas tran vdout1_69ck1610 FIND v(dout1_69) AT=1620.05n

.meas tran vdout1_70ck1610 FIND v(dout1_70) AT=1620.05n

.meas tran vdout1_71ck1610 FIND v(dout1_71) AT=1620.05n

.meas tran vdout1_72ck1610 FIND v(dout1_72) AT=1620.05n

.meas tran vdout1_73ck1610 FIND v(dout1_73) AT=1620.05n

.meas tran vdout1_74ck1610 FIND v(dout1_74) AT=1620.05n

.meas tran vdout1_75ck1610 FIND v(dout1_75) AT=1620.05n

.meas tran vdout1_76ck1610 FIND v(dout1_76) AT=1620.05n

.meas tran vdout1_77ck1610 FIND v(dout1_77) AT=1620.05n

.meas tran vdout1_78ck1610 FIND v(dout1_78) AT=1620.05n

.meas tran vdout1_79ck1610 FIND v(dout1_79) AT=1620.05n

.meas tran vdout1_80ck1610 FIND v(dout1_80) AT=1620.05n

.meas tran vdout1_81ck1610 FIND v(dout1_81) AT=1620.05n

.meas tran vdout1_82ck1610 FIND v(dout1_82) AT=1620.05n

.meas tran vdout1_83ck1610 FIND v(dout1_83) AT=1620.05n

.meas tran vdout1_84ck1610 FIND v(dout1_84) AT=1620.05n

.meas tran vdout1_85ck1610 FIND v(dout1_85) AT=1620.05n

.meas tran vdout1_86ck1610 FIND v(dout1_86) AT=1620.05n

.meas tran vdout1_87ck1610 FIND v(dout1_87) AT=1620.05n

.meas tran vdout1_88ck1610 FIND v(dout1_88) AT=1620.05n

.meas tran vdout1_89ck1610 FIND v(dout1_89) AT=1620.05n

.meas tran vdout1_90ck1610 FIND v(dout1_90) AT=1620.05n

.meas tran vdout1_91ck1610 FIND v(dout1_91) AT=1620.05n

.meas tran vdout1_92ck1610 FIND v(dout1_92) AT=1620.05n

.meas tran vdout1_93ck1610 FIND v(dout1_93) AT=1620.05n

.meas tran vdout1_94ck1610 FIND v(dout1_94) AT=1620.05n

.meas tran vdout1_95ck1610 FIND v(dout1_95) AT=1620.05n

.meas tran vdout1_96ck1610 FIND v(dout1_96) AT=1620.05n

.meas tran vdout1_97ck1610 FIND v(dout1_97) AT=1620.05n

.meas tran vdout1_98ck1610 FIND v(dout1_98) AT=1620.05n

.meas tran vdout1_99ck1610 FIND v(dout1_99) AT=1620.05n

.meas tran vdout1_100ck1610 FIND v(dout1_100) AT=1620.05n

.meas tran vdout1_101ck1610 FIND v(dout1_101) AT=1620.05n

.meas tran vdout1_102ck1610 FIND v(dout1_102) AT=1620.05n

.meas tran vdout1_103ck1610 FIND v(dout1_103) AT=1620.05n

.meas tran vdout1_104ck1610 FIND v(dout1_104) AT=1620.05n

.meas tran vdout1_105ck1610 FIND v(dout1_105) AT=1620.05n

.meas tran vdout1_106ck1610 FIND v(dout1_106) AT=1620.05n

.meas tran vdout1_107ck1610 FIND v(dout1_107) AT=1620.05n

.meas tran vdout1_108ck1610 FIND v(dout1_108) AT=1620.05n

.meas tran vdout1_109ck1610 FIND v(dout1_109) AT=1620.05n

.meas tran vdout1_110ck1610 FIND v(dout1_110) AT=1620.05n

.meas tran vdout1_111ck1610 FIND v(dout1_111) AT=1620.05n

.meas tran vdout1_112ck1610 FIND v(dout1_112) AT=1620.05n

.meas tran vdout1_113ck1610 FIND v(dout1_113) AT=1620.05n

.meas tran vdout1_114ck1610 FIND v(dout1_114) AT=1620.05n

.meas tran vdout1_115ck1610 FIND v(dout1_115) AT=1620.05n

.meas tran vdout1_116ck1610 FIND v(dout1_116) AT=1620.05n

.meas tran vdout1_117ck1610 FIND v(dout1_117) AT=1620.05n

.meas tran vdout1_118ck1610 FIND v(dout1_118) AT=1620.05n

.meas tran vdout1_119ck1610 FIND v(dout1_119) AT=1620.05n

.meas tran vdout1_120ck1610 FIND v(dout1_120) AT=1620.05n

.meas tran vdout1_121ck1610 FIND v(dout1_121) AT=1620.05n

.meas tran vdout1_122ck1610 FIND v(dout1_122) AT=1620.05n

.meas tran vdout1_123ck1610 FIND v(dout1_123) AT=1620.05n

.meas tran vdout1_124ck1610 FIND v(dout1_124) AT=1620.05n

.meas tran vdout1_125ck1610 FIND v(dout1_125) AT=1620.05n

.meas tran vdout1_126ck1610 FIND v(dout1_126) AT=1620.05n

.meas tran vdout1_127ck1610 FIND v(dout1_127) AT=1620.05n

.meas tran vdout1_128ck1610 FIND v(dout1_128) AT=1620.05n

.meas tran vdout1_129ck1610 FIND v(dout1_129) AT=1620.05n

.meas tran vdout1_130ck1610 FIND v(dout1_130) AT=1620.05n

.meas tran vdout1_131ck1610 FIND v(dout1_131) AT=1620.05n

.meas tran vdout1_132ck1610 FIND v(dout1_132) AT=1620.05n

.meas tran vdout1_133ck1610 FIND v(dout1_133) AT=1620.05n

.meas tran vdout1_134ck1610 FIND v(dout1_134) AT=1620.05n

.meas tran vdout1_135ck1610 FIND v(dout1_135) AT=1620.05n

.meas tran vdout1_136ck1610 FIND v(dout1_136) AT=1620.05n

.meas tran vdout1_137ck1610 FIND v(dout1_137) AT=1620.05n

.meas tran vdout1_138ck1610 FIND v(dout1_138) AT=1620.05n

.meas tran vdout1_139ck1610 FIND v(dout1_139) AT=1620.05n

.meas tran vdout1_140ck1610 FIND v(dout1_140) AT=1620.05n

.meas tran vdout1_141ck1610 FIND v(dout1_141) AT=1620.05n

.meas tran vdout1_142ck1610 FIND v(dout1_142) AT=1620.05n

.meas tran vdout1_143ck1610 FIND v(dout1_143) AT=1620.05n

.meas tran vdout1_144ck1610 FIND v(dout1_144) AT=1620.05n

.meas tran vdout1_145ck1610 FIND v(dout1_145) AT=1620.05n

.meas tran vdout1_146ck1610 FIND v(dout1_146) AT=1620.05n

.meas tran vdout1_147ck1610 FIND v(dout1_147) AT=1620.05n

.meas tran vdout1_148ck1610 FIND v(dout1_148) AT=1620.05n

.meas tran vdout1_149ck1610 FIND v(dout1_149) AT=1620.05n

.meas tran vdout1_150ck1610 FIND v(dout1_150) AT=1620.05n

.meas tran vdout1_151ck1610 FIND v(dout1_151) AT=1620.05n

.meas tran vdout1_152ck1610 FIND v(dout1_152) AT=1620.05n

.meas tran vdout1_153ck1610 FIND v(dout1_153) AT=1620.05n

.meas tran vdout1_154ck1610 FIND v(dout1_154) AT=1620.05n

.meas tran vdout1_155ck1610 FIND v(dout1_155) AT=1620.05n

.meas tran vdout1_156ck1610 FIND v(dout1_156) AT=1620.05n

.meas tran vdout1_157ck1610 FIND v(dout1_157) AT=1620.05n

.meas tran vdout1_158ck1610 FIND v(dout1_158) AT=1620.05n

.meas tran vdout1_159ck1610 FIND v(dout1_159) AT=1620.05n

.meas tran vdout1_160ck1610 FIND v(dout1_160) AT=1620.05n

.meas tran vdout1_161ck1610 FIND v(dout1_161) AT=1620.05n

.meas tran vdout1_162ck1610 FIND v(dout1_162) AT=1620.05n

.meas tran vdout1_163ck1610 FIND v(dout1_163) AT=1620.05n

.meas tran vdout1_164ck1610 FIND v(dout1_164) AT=1620.05n

.meas tran vdout1_165ck1610 FIND v(dout1_165) AT=1620.05n

.meas tran vdout1_166ck1610 FIND v(dout1_166) AT=1620.05n

.meas tran vdout1_167ck1610 FIND v(dout1_167) AT=1620.05n

.meas tran vdout1_168ck1610 FIND v(dout1_168) AT=1620.05n

.meas tran vdout1_169ck1610 FIND v(dout1_169) AT=1620.05n

.meas tran vdout1_170ck1610 FIND v(dout1_170) AT=1620.05n

.meas tran vdout1_171ck1610 FIND v(dout1_171) AT=1620.05n

.meas tran vdout1_172ck1610 FIND v(dout1_172) AT=1620.05n

.meas tran vdout1_173ck1610 FIND v(dout1_173) AT=1620.05n

.meas tran vdout1_174ck1610 FIND v(dout1_174) AT=1620.05n

.meas tran vdout1_175ck1610 FIND v(dout1_175) AT=1620.05n

.meas tran vdout1_176ck1610 FIND v(dout1_176) AT=1620.05n

.meas tran vdout1_177ck1610 FIND v(dout1_177) AT=1620.05n

.meas tran vdout1_178ck1610 FIND v(dout1_178) AT=1620.05n

.meas tran vdout1_179ck1610 FIND v(dout1_179) AT=1620.05n

.meas tran vdout1_180ck1610 FIND v(dout1_180) AT=1620.05n

.meas tran vdout1_181ck1610 FIND v(dout1_181) AT=1620.05n

.meas tran vdout1_182ck1610 FIND v(dout1_182) AT=1620.05n

.meas tran vdout1_183ck1610 FIND v(dout1_183) AT=1620.05n

.meas tran vdout1_184ck1610 FIND v(dout1_184) AT=1620.05n

.meas tran vdout1_185ck1610 FIND v(dout1_185) AT=1620.05n

.meas tran vdout1_186ck1610 FIND v(dout1_186) AT=1620.05n

.meas tran vdout1_187ck1610 FIND v(dout1_187) AT=1620.05n

.meas tran vdout1_188ck1610 FIND v(dout1_188) AT=1620.05n

.meas tran vdout1_189ck1610 FIND v(dout1_189) AT=1620.05n

.meas tran vdout1_190ck1610 FIND v(dout1_190) AT=1620.05n

.meas tran vdout1_191ck1610 FIND v(dout1_191) AT=1620.05n

.meas tran vdout1_192ck1610 FIND v(dout1_192) AT=1620.05n

.meas tran vdout1_193ck1610 FIND v(dout1_193) AT=1620.05n

.meas tran vdout1_194ck1610 FIND v(dout1_194) AT=1620.05n

.meas tran vdout1_195ck1610 FIND v(dout1_195) AT=1620.05n

.meas tran vdout1_196ck1610 FIND v(dout1_196) AT=1620.05n

.meas tran vdout1_197ck1610 FIND v(dout1_197) AT=1620.05n

.meas tran vdout1_198ck1610 FIND v(dout1_198) AT=1620.05n

.meas tran vdout1_199ck1610 FIND v(dout1_199) AT=1620.05n

.meas tran vdout1_200ck1610 FIND v(dout1_200) AT=1620.05n

.meas tran vdout1_201ck1610 FIND v(dout1_201) AT=1620.05n

.meas tran vdout1_202ck1610 FIND v(dout1_202) AT=1620.05n

.meas tran vdout1_203ck1610 FIND v(dout1_203) AT=1620.05n

.meas tran vdout1_204ck1610 FIND v(dout1_204) AT=1620.05n

.meas tran vdout1_205ck1610 FIND v(dout1_205) AT=1620.05n

.meas tran vdout1_206ck1610 FIND v(dout1_206) AT=1620.05n

.meas tran vdout1_207ck1610 FIND v(dout1_207) AT=1620.05n

.meas tran vdout1_208ck1610 FIND v(dout1_208) AT=1620.05n

.meas tran vdout1_209ck1610 FIND v(dout1_209) AT=1620.05n

.meas tran vdout1_210ck1610 FIND v(dout1_210) AT=1620.05n

.meas tran vdout1_211ck1610 FIND v(dout1_211) AT=1620.05n

.meas tran vdout1_212ck1610 FIND v(dout1_212) AT=1620.05n

.meas tran vdout1_213ck1610 FIND v(dout1_213) AT=1620.05n

.meas tran vdout1_214ck1610 FIND v(dout1_214) AT=1620.05n

.meas tran vdout1_215ck1610 FIND v(dout1_215) AT=1620.05n

.meas tran vdout1_216ck1610 FIND v(dout1_216) AT=1620.05n

.meas tran vdout1_217ck1610 FIND v(dout1_217) AT=1620.05n

.meas tran vdout1_218ck1610 FIND v(dout1_218) AT=1620.05n

.meas tran vdout1_219ck1610 FIND v(dout1_219) AT=1620.05n

.meas tran vdout1_220ck1610 FIND v(dout1_220) AT=1620.05n

.meas tran vdout1_221ck1610 FIND v(dout1_221) AT=1620.05n

.meas tran vdout1_222ck1610 FIND v(dout1_222) AT=1620.05n

.meas tran vdout1_223ck1610 FIND v(dout1_223) AT=1620.05n

.meas tran vdout1_224ck1610 FIND v(dout1_224) AT=1620.05n

.meas tran vdout1_225ck1610 FIND v(dout1_225) AT=1620.05n

.meas tran vdout1_226ck1610 FIND v(dout1_226) AT=1620.05n

.meas tran vdout1_227ck1610 FIND v(dout1_227) AT=1620.05n

.meas tran vdout1_228ck1610 FIND v(dout1_228) AT=1620.05n

.meas tran vdout1_229ck1610 FIND v(dout1_229) AT=1620.05n

.meas tran vdout1_230ck1610 FIND v(dout1_230) AT=1620.05n

.meas tran vdout1_231ck1610 FIND v(dout1_231) AT=1620.05n

.meas tran vdout1_232ck1610 FIND v(dout1_232) AT=1620.05n

.meas tran vdout1_233ck1610 FIND v(dout1_233) AT=1620.05n

.meas tran vdout1_234ck1610 FIND v(dout1_234) AT=1620.05n

.meas tran vdout1_235ck1610 FIND v(dout1_235) AT=1620.05n

.meas tran vdout1_236ck1610 FIND v(dout1_236) AT=1620.05n

.meas tran vdout1_237ck1610 FIND v(dout1_237) AT=1620.05n

.meas tran vdout1_238ck1610 FIND v(dout1_238) AT=1620.05n

.meas tran vdout1_239ck1610 FIND v(dout1_239) AT=1620.05n

.meas tran vdout1_240ck1610 FIND v(dout1_240) AT=1620.05n

.meas tran vdout1_241ck1610 FIND v(dout1_241) AT=1620.05n

.meas tran vdout1_242ck1610 FIND v(dout1_242) AT=1620.05n

.meas tran vdout1_243ck1610 FIND v(dout1_243) AT=1620.05n

.meas tran vdout1_244ck1610 FIND v(dout1_244) AT=1620.05n

.meas tran vdout1_245ck1610 FIND v(dout1_245) AT=1620.05n

.meas tran vdout1_246ck1610 FIND v(dout1_246) AT=1620.05n

.meas tran vdout1_247ck1610 FIND v(dout1_247) AT=1620.05n

.meas tran vdout1_248ck1610 FIND v(dout1_248) AT=1620.05n

.meas tran vdout1_249ck1610 FIND v(dout1_249) AT=1620.05n

.meas tran vdout1_250ck1610 FIND v(dout1_250) AT=1620.05n

.meas tran vdout1_251ck1610 FIND v(dout1_251) AT=1620.05n

.meas tran vdout1_252ck1610 FIND v(dout1_252) AT=1620.05n

.meas tran vdout1_253ck1610 FIND v(dout1_253) AT=1620.05n

.meas tran vdout1_254ck1610 FIND v(dout1_254) AT=1620.05n

.meas tran vdout1_255ck1610 FIND v(dout1_255) AT=1620.05n

.meas tran vdout1_256ck1610 FIND v(dout1_256) AT=1620.05n

.meas tran vdout1_0ck1660 FIND v(dout1_0) AT=1670.05n

.meas tran vdout1_1ck1660 FIND v(dout1_1) AT=1670.05n

.meas tran vdout1_2ck1660 FIND v(dout1_2) AT=1670.05n

.meas tran vdout1_3ck1660 FIND v(dout1_3) AT=1670.05n

.meas tran vdout1_4ck1660 FIND v(dout1_4) AT=1670.05n

.meas tran vdout1_5ck1660 FIND v(dout1_5) AT=1670.05n

.meas tran vdout1_6ck1660 FIND v(dout1_6) AT=1670.05n

.meas tran vdout1_7ck1660 FIND v(dout1_7) AT=1670.05n

.meas tran vdout1_8ck1660 FIND v(dout1_8) AT=1670.05n

.meas tran vdout1_9ck1660 FIND v(dout1_9) AT=1670.05n

.meas tran vdout1_10ck1660 FIND v(dout1_10) AT=1670.05n

.meas tran vdout1_11ck1660 FIND v(dout1_11) AT=1670.05n

.meas tran vdout1_12ck1660 FIND v(dout1_12) AT=1670.05n

.meas tran vdout1_13ck1660 FIND v(dout1_13) AT=1670.05n

.meas tran vdout1_14ck1660 FIND v(dout1_14) AT=1670.05n

.meas tran vdout1_15ck1660 FIND v(dout1_15) AT=1670.05n

.meas tran vdout1_16ck1660 FIND v(dout1_16) AT=1670.05n

.meas tran vdout1_17ck1660 FIND v(dout1_17) AT=1670.05n

.meas tran vdout1_18ck1660 FIND v(dout1_18) AT=1670.05n

.meas tran vdout1_19ck1660 FIND v(dout1_19) AT=1670.05n

.meas tran vdout1_20ck1660 FIND v(dout1_20) AT=1670.05n

.meas tran vdout1_21ck1660 FIND v(dout1_21) AT=1670.05n

.meas tran vdout1_22ck1660 FIND v(dout1_22) AT=1670.05n

.meas tran vdout1_23ck1660 FIND v(dout1_23) AT=1670.05n

.meas tran vdout1_24ck1660 FIND v(dout1_24) AT=1670.05n

.meas tran vdout1_25ck1660 FIND v(dout1_25) AT=1670.05n

.meas tran vdout1_26ck1660 FIND v(dout1_26) AT=1670.05n

.meas tran vdout1_27ck1660 FIND v(dout1_27) AT=1670.05n

.meas tran vdout1_28ck1660 FIND v(dout1_28) AT=1670.05n

.meas tran vdout1_29ck1660 FIND v(dout1_29) AT=1670.05n

.meas tran vdout1_30ck1660 FIND v(dout1_30) AT=1670.05n

.meas tran vdout1_31ck1660 FIND v(dout1_31) AT=1670.05n

.meas tran vdout1_32ck1660 FIND v(dout1_32) AT=1670.05n

.meas tran vdout1_33ck1660 FIND v(dout1_33) AT=1670.05n

.meas tran vdout1_34ck1660 FIND v(dout1_34) AT=1670.05n

.meas tran vdout1_35ck1660 FIND v(dout1_35) AT=1670.05n

.meas tran vdout1_36ck1660 FIND v(dout1_36) AT=1670.05n

.meas tran vdout1_37ck1660 FIND v(dout1_37) AT=1670.05n

.meas tran vdout1_38ck1660 FIND v(dout1_38) AT=1670.05n

.meas tran vdout1_39ck1660 FIND v(dout1_39) AT=1670.05n

.meas tran vdout1_40ck1660 FIND v(dout1_40) AT=1670.05n

.meas tran vdout1_41ck1660 FIND v(dout1_41) AT=1670.05n

.meas tran vdout1_42ck1660 FIND v(dout1_42) AT=1670.05n

.meas tran vdout1_43ck1660 FIND v(dout1_43) AT=1670.05n

.meas tran vdout1_44ck1660 FIND v(dout1_44) AT=1670.05n

.meas tran vdout1_45ck1660 FIND v(dout1_45) AT=1670.05n

.meas tran vdout1_46ck1660 FIND v(dout1_46) AT=1670.05n

.meas tran vdout1_47ck1660 FIND v(dout1_47) AT=1670.05n

.meas tran vdout1_48ck1660 FIND v(dout1_48) AT=1670.05n

.meas tran vdout1_49ck1660 FIND v(dout1_49) AT=1670.05n

.meas tran vdout1_50ck1660 FIND v(dout1_50) AT=1670.05n

.meas tran vdout1_51ck1660 FIND v(dout1_51) AT=1670.05n

.meas tran vdout1_52ck1660 FIND v(dout1_52) AT=1670.05n

.meas tran vdout1_53ck1660 FIND v(dout1_53) AT=1670.05n

.meas tran vdout1_54ck1660 FIND v(dout1_54) AT=1670.05n

.meas tran vdout1_55ck1660 FIND v(dout1_55) AT=1670.05n

.meas tran vdout1_56ck1660 FIND v(dout1_56) AT=1670.05n

.meas tran vdout1_57ck1660 FIND v(dout1_57) AT=1670.05n

.meas tran vdout1_58ck1660 FIND v(dout1_58) AT=1670.05n

.meas tran vdout1_59ck1660 FIND v(dout1_59) AT=1670.05n

.meas tran vdout1_60ck1660 FIND v(dout1_60) AT=1670.05n

.meas tran vdout1_61ck1660 FIND v(dout1_61) AT=1670.05n

.meas tran vdout1_62ck1660 FIND v(dout1_62) AT=1670.05n

.meas tran vdout1_63ck1660 FIND v(dout1_63) AT=1670.05n

.meas tran vdout1_64ck1660 FIND v(dout1_64) AT=1670.05n

.meas tran vdout1_65ck1660 FIND v(dout1_65) AT=1670.05n

.meas tran vdout1_66ck1660 FIND v(dout1_66) AT=1670.05n

.meas tran vdout1_67ck1660 FIND v(dout1_67) AT=1670.05n

.meas tran vdout1_68ck1660 FIND v(dout1_68) AT=1670.05n

.meas tran vdout1_69ck1660 FIND v(dout1_69) AT=1670.05n

.meas tran vdout1_70ck1660 FIND v(dout1_70) AT=1670.05n

.meas tran vdout1_71ck1660 FIND v(dout1_71) AT=1670.05n

.meas tran vdout1_72ck1660 FIND v(dout1_72) AT=1670.05n

.meas tran vdout1_73ck1660 FIND v(dout1_73) AT=1670.05n

.meas tran vdout1_74ck1660 FIND v(dout1_74) AT=1670.05n

.meas tran vdout1_75ck1660 FIND v(dout1_75) AT=1670.05n

.meas tran vdout1_76ck1660 FIND v(dout1_76) AT=1670.05n

.meas tran vdout1_77ck1660 FIND v(dout1_77) AT=1670.05n

.meas tran vdout1_78ck1660 FIND v(dout1_78) AT=1670.05n

.meas tran vdout1_79ck1660 FIND v(dout1_79) AT=1670.05n

.meas tran vdout1_80ck1660 FIND v(dout1_80) AT=1670.05n

.meas tran vdout1_81ck1660 FIND v(dout1_81) AT=1670.05n

.meas tran vdout1_82ck1660 FIND v(dout1_82) AT=1670.05n

.meas tran vdout1_83ck1660 FIND v(dout1_83) AT=1670.05n

.meas tran vdout1_84ck1660 FIND v(dout1_84) AT=1670.05n

.meas tran vdout1_85ck1660 FIND v(dout1_85) AT=1670.05n

.meas tran vdout1_86ck1660 FIND v(dout1_86) AT=1670.05n

.meas tran vdout1_87ck1660 FIND v(dout1_87) AT=1670.05n

.meas tran vdout1_88ck1660 FIND v(dout1_88) AT=1670.05n

.meas tran vdout1_89ck1660 FIND v(dout1_89) AT=1670.05n

.meas tran vdout1_90ck1660 FIND v(dout1_90) AT=1670.05n

.meas tran vdout1_91ck1660 FIND v(dout1_91) AT=1670.05n

.meas tran vdout1_92ck1660 FIND v(dout1_92) AT=1670.05n

.meas tran vdout1_93ck1660 FIND v(dout1_93) AT=1670.05n

.meas tran vdout1_94ck1660 FIND v(dout1_94) AT=1670.05n

.meas tran vdout1_95ck1660 FIND v(dout1_95) AT=1670.05n

.meas tran vdout1_96ck1660 FIND v(dout1_96) AT=1670.05n

.meas tran vdout1_97ck1660 FIND v(dout1_97) AT=1670.05n

.meas tran vdout1_98ck1660 FIND v(dout1_98) AT=1670.05n

.meas tran vdout1_99ck1660 FIND v(dout1_99) AT=1670.05n

.meas tran vdout1_100ck1660 FIND v(dout1_100) AT=1670.05n

.meas tran vdout1_101ck1660 FIND v(dout1_101) AT=1670.05n

.meas tran vdout1_102ck1660 FIND v(dout1_102) AT=1670.05n

.meas tran vdout1_103ck1660 FIND v(dout1_103) AT=1670.05n

.meas tran vdout1_104ck1660 FIND v(dout1_104) AT=1670.05n

.meas tran vdout1_105ck1660 FIND v(dout1_105) AT=1670.05n

.meas tran vdout1_106ck1660 FIND v(dout1_106) AT=1670.05n

.meas tran vdout1_107ck1660 FIND v(dout1_107) AT=1670.05n

.meas tran vdout1_108ck1660 FIND v(dout1_108) AT=1670.05n

.meas tran vdout1_109ck1660 FIND v(dout1_109) AT=1670.05n

.meas tran vdout1_110ck1660 FIND v(dout1_110) AT=1670.05n

.meas tran vdout1_111ck1660 FIND v(dout1_111) AT=1670.05n

.meas tran vdout1_112ck1660 FIND v(dout1_112) AT=1670.05n

.meas tran vdout1_113ck1660 FIND v(dout1_113) AT=1670.05n

.meas tran vdout1_114ck1660 FIND v(dout1_114) AT=1670.05n

.meas tran vdout1_115ck1660 FIND v(dout1_115) AT=1670.05n

.meas tran vdout1_116ck1660 FIND v(dout1_116) AT=1670.05n

.meas tran vdout1_117ck1660 FIND v(dout1_117) AT=1670.05n

.meas tran vdout1_118ck1660 FIND v(dout1_118) AT=1670.05n

.meas tran vdout1_119ck1660 FIND v(dout1_119) AT=1670.05n

.meas tran vdout1_120ck1660 FIND v(dout1_120) AT=1670.05n

.meas tran vdout1_121ck1660 FIND v(dout1_121) AT=1670.05n

.meas tran vdout1_122ck1660 FIND v(dout1_122) AT=1670.05n

.meas tran vdout1_123ck1660 FIND v(dout1_123) AT=1670.05n

.meas tran vdout1_124ck1660 FIND v(dout1_124) AT=1670.05n

.meas tran vdout1_125ck1660 FIND v(dout1_125) AT=1670.05n

.meas tran vdout1_126ck1660 FIND v(dout1_126) AT=1670.05n

.meas tran vdout1_127ck1660 FIND v(dout1_127) AT=1670.05n

.meas tran vdout1_128ck1660 FIND v(dout1_128) AT=1670.05n

.meas tran vdout1_129ck1660 FIND v(dout1_129) AT=1670.05n

.meas tran vdout1_130ck1660 FIND v(dout1_130) AT=1670.05n

.meas tran vdout1_131ck1660 FIND v(dout1_131) AT=1670.05n

.meas tran vdout1_132ck1660 FIND v(dout1_132) AT=1670.05n

.meas tran vdout1_133ck1660 FIND v(dout1_133) AT=1670.05n

.meas tran vdout1_134ck1660 FIND v(dout1_134) AT=1670.05n

.meas tran vdout1_135ck1660 FIND v(dout1_135) AT=1670.05n

.meas tran vdout1_136ck1660 FIND v(dout1_136) AT=1670.05n

.meas tran vdout1_137ck1660 FIND v(dout1_137) AT=1670.05n

.meas tran vdout1_138ck1660 FIND v(dout1_138) AT=1670.05n

.meas tran vdout1_139ck1660 FIND v(dout1_139) AT=1670.05n

.meas tran vdout1_140ck1660 FIND v(dout1_140) AT=1670.05n

.meas tran vdout1_141ck1660 FIND v(dout1_141) AT=1670.05n

.meas tran vdout1_142ck1660 FIND v(dout1_142) AT=1670.05n

.meas tran vdout1_143ck1660 FIND v(dout1_143) AT=1670.05n

.meas tran vdout1_144ck1660 FIND v(dout1_144) AT=1670.05n

.meas tran vdout1_145ck1660 FIND v(dout1_145) AT=1670.05n

.meas tran vdout1_146ck1660 FIND v(dout1_146) AT=1670.05n

.meas tran vdout1_147ck1660 FIND v(dout1_147) AT=1670.05n

.meas tran vdout1_148ck1660 FIND v(dout1_148) AT=1670.05n

.meas tran vdout1_149ck1660 FIND v(dout1_149) AT=1670.05n

.meas tran vdout1_150ck1660 FIND v(dout1_150) AT=1670.05n

.meas tran vdout1_151ck1660 FIND v(dout1_151) AT=1670.05n

.meas tran vdout1_152ck1660 FIND v(dout1_152) AT=1670.05n

.meas tran vdout1_153ck1660 FIND v(dout1_153) AT=1670.05n

.meas tran vdout1_154ck1660 FIND v(dout1_154) AT=1670.05n

.meas tran vdout1_155ck1660 FIND v(dout1_155) AT=1670.05n

.meas tran vdout1_156ck1660 FIND v(dout1_156) AT=1670.05n

.meas tran vdout1_157ck1660 FIND v(dout1_157) AT=1670.05n

.meas tran vdout1_158ck1660 FIND v(dout1_158) AT=1670.05n

.meas tran vdout1_159ck1660 FIND v(dout1_159) AT=1670.05n

.meas tran vdout1_160ck1660 FIND v(dout1_160) AT=1670.05n

.meas tran vdout1_161ck1660 FIND v(dout1_161) AT=1670.05n

.meas tran vdout1_162ck1660 FIND v(dout1_162) AT=1670.05n

.meas tran vdout1_163ck1660 FIND v(dout1_163) AT=1670.05n

.meas tran vdout1_164ck1660 FIND v(dout1_164) AT=1670.05n

.meas tran vdout1_165ck1660 FIND v(dout1_165) AT=1670.05n

.meas tran vdout1_166ck1660 FIND v(dout1_166) AT=1670.05n

.meas tran vdout1_167ck1660 FIND v(dout1_167) AT=1670.05n

.meas tran vdout1_168ck1660 FIND v(dout1_168) AT=1670.05n

.meas tran vdout1_169ck1660 FIND v(dout1_169) AT=1670.05n

.meas tran vdout1_170ck1660 FIND v(dout1_170) AT=1670.05n

.meas tran vdout1_171ck1660 FIND v(dout1_171) AT=1670.05n

.meas tran vdout1_172ck1660 FIND v(dout1_172) AT=1670.05n

.meas tran vdout1_173ck1660 FIND v(dout1_173) AT=1670.05n

.meas tran vdout1_174ck1660 FIND v(dout1_174) AT=1670.05n

.meas tran vdout1_175ck1660 FIND v(dout1_175) AT=1670.05n

.meas tran vdout1_176ck1660 FIND v(dout1_176) AT=1670.05n

.meas tran vdout1_177ck1660 FIND v(dout1_177) AT=1670.05n

.meas tran vdout1_178ck1660 FIND v(dout1_178) AT=1670.05n

.meas tran vdout1_179ck1660 FIND v(dout1_179) AT=1670.05n

.meas tran vdout1_180ck1660 FIND v(dout1_180) AT=1670.05n

.meas tran vdout1_181ck1660 FIND v(dout1_181) AT=1670.05n

.meas tran vdout1_182ck1660 FIND v(dout1_182) AT=1670.05n

.meas tran vdout1_183ck1660 FIND v(dout1_183) AT=1670.05n

.meas tran vdout1_184ck1660 FIND v(dout1_184) AT=1670.05n

.meas tran vdout1_185ck1660 FIND v(dout1_185) AT=1670.05n

.meas tran vdout1_186ck1660 FIND v(dout1_186) AT=1670.05n

.meas tran vdout1_187ck1660 FIND v(dout1_187) AT=1670.05n

.meas tran vdout1_188ck1660 FIND v(dout1_188) AT=1670.05n

.meas tran vdout1_189ck1660 FIND v(dout1_189) AT=1670.05n

.meas tran vdout1_190ck1660 FIND v(dout1_190) AT=1670.05n

.meas tran vdout1_191ck1660 FIND v(dout1_191) AT=1670.05n

.meas tran vdout1_192ck1660 FIND v(dout1_192) AT=1670.05n

.meas tran vdout1_193ck1660 FIND v(dout1_193) AT=1670.05n

.meas tran vdout1_194ck1660 FIND v(dout1_194) AT=1670.05n

.meas tran vdout1_195ck1660 FIND v(dout1_195) AT=1670.05n

.meas tran vdout1_196ck1660 FIND v(dout1_196) AT=1670.05n

.meas tran vdout1_197ck1660 FIND v(dout1_197) AT=1670.05n

.meas tran vdout1_198ck1660 FIND v(dout1_198) AT=1670.05n

.meas tran vdout1_199ck1660 FIND v(dout1_199) AT=1670.05n

.meas tran vdout1_200ck1660 FIND v(dout1_200) AT=1670.05n

.meas tran vdout1_201ck1660 FIND v(dout1_201) AT=1670.05n

.meas tran vdout1_202ck1660 FIND v(dout1_202) AT=1670.05n

.meas tran vdout1_203ck1660 FIND v(dout1_203) AT=1670.05n

.meas tran vdout1_204ck1660 FIND v(dout1_204) AT=1670.05n

.meas tran vdout1_205ck1660 FIND v(dout1_205) AT=1670.05n

.meas tran vdout1_206ck1660 FIND v(dout1_206) AT=1670.05n

.meas tran vdout1_207ck1660 FIND v(dout1_207) AT=1670.05n

.meas tran vdout1_208ck1660 FIND v(dout1_208) AT=1670.05n

.meas tran vdout1_209ck1660 FIND v(dout1_209) AT=1670.05n

.meas tran vdout1_210ck1660 FIND v(dout1_210) AT=1670.05n

.meas tran vdout1_211ck1660 FIND v(dout1_211) AT=1670.05n

.meas tran vdout1_212ck1660 FIND v(dout1_212) AT=1670.05n

.meas tran vdout1_213ck1660 FIND v(dout1_213) AT=1670.05n

.meas tran vdout1_214ck1660 FIND v(dout1_214) AT=1670.05n

.meas tran vdout1_215ck1660 FIND v(dout1_215) AT=1670.05n

.meas tran vdout1_216ck1660 FIND v(dout1_216) AT=1670.05n

.meas tran vdout1_217ck1660 FIND v(dout1_217) AT=1670.05n

.meas tran vdout1_218ck1660 FIND v(dout1_218) AT=1670.05n

.meas tran vdout1_219ck1660 FIND v(dout1_219) AT=1670.05n

.meas tran vdout1_220ck1660 FIND v(dout1_220) AT=1670.05n

.meas tran vdout1_221ck1660 FIND v(dout1_221) AT=1670.05n

.meas tran vdout1_222ck1660 FIND v(dout1_222) AT=1670.05n

.meas tran vdout1_223ck1660 FIND v(dout1_223) AT=1670.05n

.meas tran vdout1_224ck1660 FIND v(dout1_224) AT=1670.05n

.meas tran vdout1_225ck1660 FIND v(dout1_225) AT=1670.05n

.meas tran vdout1_226ck1660 FIND v(dout1_226) AT=1670.05n

.meas tran vdout1_227ck1660 FIND v(dout1_227) AT=1670.05n

.meas tran vdout1_228ck1660 FIND v(dout1_228) AT=1670.05n

.meas tran vdout1_229ck1660 FIND v(dout1_229) AT=1670.05n

.meas tran vdout1_230ck1660 FIND v(dout1_230) AT=1670.05n

.meas tran vdout1_231ck1660 FIND v(dout1_231) AT=1670.05n

.meas tran vdout1_232ck1660 FIND v(dout1_232) AT=1670.05n

.meas tran vdout1_233ck1660 FIND v(dout1_233) AT=1670.05n

.meas tran vdout1_234ck1660 FIND v(dout1_234) AT=1670.05n

.meas tran vdout1_235ck1660 FIND v(dout1_235) AT=1670.05n

.meas tran vdout1_236ck1660 FIND v(dout1_236) AT=1670.05n

.meas tran vdout1_237ck1660 FIND v(dout1_237) AT=1670.05n

.meas tran vdout1_238ck1660 FIND v(dout1_238) AT=1670.05n

.meas tran vdout1_239ck1660 FIND v(dout1_239) AT=1670.05n

.meas tran vdout1_240ck1660 FIND v(dout1_240) AT=1670.05n

.meas tran vdout1_241ck1660 FIND v(dout1_241) AT=1670.05n

.meas tran vdout1_242ck1660 FIND v(dout1_242) AT=1670.05n

.meas tran vdout1_243ck1660 FIND v(dout1_243) AT=1670.05n

.meas tran vdout1_244ck1660 FIND v(dout1_244) AT=1670.05n

.meas tran vdout1_245ck1660 FIND v(dout1_245) AT=1670.05n

.meas tran vdout1_246ck1660 FIND v(dout1_246) AT=1670.05n

.meas tran vdout1_247ck1660 FIND v(dout1_247) AT=1670.05n

.meas tran vdout1_248ck1660 FIND v(dout1_248) AT=1670.05n

.meas tran vdout1_249ck1660 FIND v(dout1_249) AT=1670.05n

.meas tran vdout1_250ck1660 FIND v(dout1_250) AT=1670.05n

.meas tran vdout1_251ck1660 FIND v(dout1_251) AT=1670.05n

.meas tran vdout1_252ck1660 FIND v(dout1_252) AT=1670.05n

.meas tran vdout1_253ck1660 FIND v(dout1_253) AT=1670.05n

.meas tran vdout1_254ck1660 FIND v(dout1_254) AT=1670.05n

.meas tran vdout1_255ck1660 FIND v(dout1_255) AT=1670.05n

.meas tran vdout1_256ck1660 FIND v(dout1_256) AT=1670.05n

.meas tran vdout1_0ck1670 FIND v(dout1_0) AT=1680.05n

.meas tran vdout1_1ck1670 FIND v(dout1_1) AT=1680.05n

.meas tran vdout1_2ck1670 FIND v(dout1_2) AT=1680.05n

.meas tran vdout1_3ck1670 FIND v(dout1_3) AT=1680.05n

.meas tran vdout1_4ck1670 FIND v(dout1_4) AT=1680.05n

.meas tran vdout1_5ck1670 FIND v(dout1_5) AT=1680.05n

.meas tran vdout1_6ck1670 FIND v(dout1_6) AT=1680.05n

.meas tran vdout1_7ck1670 FIND v(dout1_7) AT=1680.05n

.meas tran vdout1_8ck1670 FIND v(dout1_8) AT=1680.05n

.meas tran vdout1_9ck1670 FIND v(dout1_9) AT=1680.05n

.meas tran vdout1_10ck1670 FIND v(dout1_10) AT=1680.05n

.meas tran vdout1_11ck1670 FIND v(dout1_11) AT=1680.05n

.meas tran vdout1_12ck1670 FIND v(dout1_12) AT=1680.05n

.meas tran vdout1_13ck1670 FIND v(dout1_13) AT=1680.05n

.meas tran vdout1_14ck1670 FIND v(dout1_14) AT=1680.05n

.meas tran vdout1_15ck1670 FIND v(dout1_15) AT=1680.05n

.meas tran vdout1_16ck1670 FIND v(dout1_16) AT=1680.05n

.meas tran vdout1_17ck1670 FIND v(dout1_17) AT=1680.05n

.meas tran vdout1_18ck1670 FIND v(dout1_18) AT=1680.05n

.meas tran vdout1_19ck1670 FIND v(dout1_19) AT=1680.05n

.meas tran vdout1_20ck1670 FIND v(dout1_20) AT=1680.05n

.meas tran vdout1_21ck1670 FIND v(dout1_21) AT=1680.05n

.meas tran vdout1_22ck1670 FIND v(dout1_22) AT=1680.05n

.meas tran vdout1_23ck1670 FIND v(dout1_23) AT=1680.05n

.meas tran vdout1_24ck1670 FIND v(dout1_24) AT=1680.05n

.meas tran vdout1_25ck1670 FIND v(dout1_25) AT=1680.05n

.meas tran vdout1_26ck1670 FIND v(dout1_26) AT=1680.05n

.meas tran vdout1_27ck1670 FIND v(dout1_27) AT=1680.05n

.meas tran vdout1_28ck1670 FIND v(dout1_28) AT=1680.05n

.meas tran vdout1_29ck1670 FIND v(dout1_29) AT=1680.05n

.meas tran vdout1_30ck1670 FIND v(dout1_30) AT=1680.05n

.meas tran vdout1_31ck1670 FIND v(dout1_31) AT=1680.05n

.meas tran vdout1_32ck1670 FIND v(dout1_32) AT=1680.05n

.meas tran vdout1_33ck1670 FIND v(dout1_33) AT=1680.05n

.meas tran vdout1_34ck1670 FIND v(dout1_34) AT=1680.05n

.meas tran vdout1_35ck1670 FIND v(dout1_35) AT=1680.05n

.meas tran vdout1_36ck1670 FIND v(dout1_36) AT=1680.05n

.meas tran vdout1_37ck1670 FIND v(dout1_37) AT=1680.05n

.meas tran vdout1_38ck1670 FIND v(dout1_38) AT=1680.05n

.meas tran vdout1_39ck1670 FIND v(dout1_39) AT=1680.05n

.meas tran vdout1_40ck1670 FIND v(dout1_40) AT=1680.05n

.meas tran vdout1_41ck1670 FIND v(dout1_41) AT=1680.05n

.meas tran vdout1_42ck1670 FIND v(dout1_42) AT=1680.05n

.meas tran vdout1_43ck1670 FIND v(dout1_43) AT=1680.05n

.meas tran vdout1_44ck1670 FIND v(dout1_44) AT=1680.05n

.meas tran vdout1_45ck1670 FIND v(dout1_45) AT=1680.05n

.meas tran vdout1_46ck1670 FIND v(dout1_46) AT=1680.05n

.meas tran vdout1_47ck1670 FIND v(dout1_47) AT=1680.05n

.meas tran vdout1_48ck1670 FIND v(dout1_48) AT=1680.05n

.meas tran vdout1_49ck1670 FIND v(dout1_49) AT=1680.05n

.meas tran vdout1_50ck1670 FIND v(dout1_50) AT=1680.05n

.meas tran vdout1_51ck1670 FIND v(dout1_51) AT=1680.05n

.meas tran vdout1_52ck1670 FIND v(dout1_52) AT=1680.05n

.meas tran vdout1_53ck1670 FIND v(dout1_53) AT=1680.05n

.meas tran vdout1_54ck1670 FIND v(dout1_54) AT=1680.05n

.meas tran vdout1_55ck1670 FIND v(dout1_55) AT=1680.05n

.meas tran vdout1_56ck1670 FIND v(dout1_56) AT=1680.05n

.meas tran vdout1_57ck1670 FIND v(dout1_57) AT=1680.05n

.meas tran vdout1_58ck1670 FIND v(dout1_58) AT=1680.05n

.meas tran vdout1_59ck1670 FIND v(dout1_59) AT=1680.05n

.meas tran vdout1_60ck1670 FIND v(dout1_60) AT=1680.05n

.meas tran vdout1_61ck1670 FIND v(dout1_61) AT=1680.05n

.meas tran vdout1_62ck1670 FIND v(dout1_62) AT=1680.05n

.meas tran vdout1_63ck1670 FIND v(dout1_63) AT=1680.05n

.meas tran vdout1_64ck1670 FIND v(dout1_64) AT=1680.05n

.meas tran vdout1_65ck1670 FIND v(dout1_65) AT=1680.05n

.meas tran vdout1_66ck1670 FIND v(dout1_66) AT=1680.05n

.meas tran vdout1_67ck1670 FIND v(dout1_67) AT=1680.05n

.meas tran vdout1_68ck1670 FIND v(dout1_68) AT=1680.05n

.meas tran vdout1_69ck1670 FIND v(dout1_69) AT=1680.05n

.meas tran vdout1_70ck1670 FIND v(dout1_70) AT=1680.05n

.meas tran vdout1_71ck1670 FIND v(dout1_71) AT=1680.05n

.meas tran vdout1_72ck1670 FIND v(dout1_72) AT=1680.05n

.meas tran vdout1_73ck1670 FIND v(dout1_73) AT=1680.05n

.meas tran vdout1_74ck1670 FIND v(dout1_74) AT=1680.05n

.meas tran vdout1_75ck1670 FIND v(dout1_75) AT=1680.05n

.meas tran vdout1_76ck1670 FIND v(dout1_76) AT=1680.05n

.meas tran vdout1_77ck1670 FIND v(dout1_77) AT=1680.05n

.meas tran vdout1_78ck1670 FIND v(dout1_78) AT=1680.05n

.meas tran vdout1_79ck1670 FIND v(dout1_79) AT=1680.05n

.meas tran vdout1_80ck1670 FIND v(dout1_80) AT=1680.05n

.meas tran vdout1_81ck1670 FIND v(dout1_81) AT=1680.05n

.meas tran vdout1_82ck1670 FIND v(dout1_82) AT=1680.05n

.meas tran vdout1_83ck1670 FIND v(dout1_83) AT=1680.05n

.meas tran vdout1_84ck1670 FIND v(dout1_84) AT=1680.05n

.meas tran vdout1_85ck1670 FIND v(dout1_85) AT=1680.05n

.meas tran vdout1_86ck1670 FIND v(dout1_86) AT=1680.05n

.meas tran vdout1_87ck1670 FIND v(dout1_87) AT=1680.05n

.meas tran vdout1_88ck1670 FIND v(dout1_88) AT=1680.05n

.meas tran vdout1_89ck1670 FIND v(dout1_89) AT=1680.05n

.meas tran vdout1_90ck1670 FIND v(dout1_90) AT=1680.05n

.meas tran vdout1_91ck1670 FIND v(dout1_91) AT=1680.05n

.meas tran vdout1_92ck1670 FIND v(dout1_92) AT=1680.05n

.meas tran vdout1_93ck1670 FIND v(dout1_93) AT=1680.05n

.meas tran vdout1_94ck1670 FIND v(dout1_94) AT=1680.05n

.meas tran vdout1_95ck1670 FIND v(dout1_95) AT=1680.05n

.meas tran vdout1_96ck1670 FIND v(dout1_96) AT=1680.05n

.meas tran vdout1_97ck1670 FIND v(dout1_97) AT=1680.05n

.meas tran vdout1_98ck1670 FIND v(dout1_98) AT=1680.05n

.meas tran vdout1_99ck1670 FIND v(dout1_99) AT=1680.05n

.meas tran vdout1_100ck1670 FIND v(dout1_100) AT=1680.05n

.meas tran vdout1_101ck1670 FIND v(dout1_101) AT=1680.05n

.meas tran vdout1_102ck1670 FIND v(dout1_102) AT=1680.05n

.meas tran vdout1_103ck1670 FIND v(dout1_103) AT=1680.05n

.meas tran vdout1_104ck1670 FIND v(dout1_104) AT=1680.05n

.meas tran vdout1_105ck1670 FIND v(dout1_105) AT=1680.05n

.meas tran vdout1_106ck1670 FIND v(dout1_106) AT=1680.05n

.meas tran vdout1_107ck1670 FIND v(dout1_107) AT=1680.05n

.meas tran vdout1_108ck1670 FIND v(dout1_108) AT=1680.05n

.meas tran vdout1_109ck1670 FIND v(dout1_109) AT=1680.05n

.meas tran vdout1_110ck1670 FIND v(dout1_110) AT=1680.05n

.meas tran vdout1_111ck1670 FIND v(dout1_111) AT=1680.05n

.meas tran vdout1_112ck1670 FIND v(dout1_112) AT=1680.05n

.meas tran vdout1_113ck1670 FIND v(dout1_113) AT=1680.05n

.meas tran vdout1_114ck1670 FIND v(dout1_114) AT=1680.05n

.meas tran vdout1_115ck1670 FIND v(dout1_115) AT=1680.05n

.meas tran vdout1_116ck1670 FIND v(dout1_116) AT=1680.05n

.meas tran vdout1_117ck1670 FIND v(dout1_117) AT=1680.05n

.meas tran vdout1_118ck1670 FIND v(dout1_118) AT=1680.05n

.meas tran vdout1_119ck1670 FIND v(dout1_119) AT=1680.05n

.meas tran vdout1_120ck1670 FIND v(dout1_120) AT=1680.05n

.meas tran vdout1_121ck1670 FIND v(dout1_121) AT=1680.05n

.meas tran vdout1_122ck1670 FIND v(dout1_122) AT=1680.05n

.meas tran vdout1_123ck1670 FIND v(dout1_123) AT=1680.05n

.meas tran vdout1_124ck1670 FIND v(dout1_124) AT=1680.05n

.meas tran vdout1_125ck1670 FIND v(dout1_125) AT=1680.05n

.meas tran vdout1_126ck1670 FIND v(dout1_126) AT=1680.05n

.meas tran vdout1_127ck1670 FIND v(dout1_127) AT=1680.05n

.meas tran vdout1_128ck1670 FIND v(dout1_128) AT=1680.05n

.meas tran vdout1_129ck1670 FIND v(dout1_129) AT=1680.05n

.meas tran vdout1_130ck1670 FIND v(dout1_130) AT=1680.05n

.meas tran vdout1_131ck1670 FIND v(dout1_131) AT=1680.05n

.meas tran vdout1_132ck1670 FIND v(dout1_132) AT=1680.05n

.meas tran vdout1_133ck1670 FIND v(dout1_133) AT=1680.05n

.meas tran vdout1_134ck1670 FIND v(dout1_134) AT=1680.05n

.meas tran vdout1_135ck1670 FIND v(dout1_135) AT=1680.05n

.meas tran vdout1_136ck1670 FIND v(dout1_136) AT=1680.05n

.meas tran vdout1_137ck1670 FIND v(dout1_137) AT=1680.05n

.meas tran vdout1_138ck1670 FIND v(dout1_138) AT=1680.05n

.meas tran vdout1_139ck1670 FIND v(dout1_139) AT=1680.05n

.meas tran vdout1_140ck1670 FIND v(dout1_140) AT=1680.05n

.meas tran vdout1_141ck1670 FIND v(dout1_141) AT=1680.05n

.meas tran vdout1_142ck1670 FIND v(dout1_142) AT=1680.05n

.meas tran vdout1_143ck1670 FIND v(dout1_143) AT=1680.05n

.meas tran vdout1_144ck1670 FIND v(dout1_144) AT=1680.05n

.meas tran vdout1_145ck1670 FIND v(dout1_145) AT=1680.05n

.meas tran vdout1_146ck1670 FIND v(dout1_146) AT=1680.05n

.meas tran vdout1_147ck1670 FIND v(dout1_147) AT=1680.05n

.meas tran vdout1_148ck1670 FIND v(dout1_148) AT=1680.05n

.meas tran vdout1_149ck1670 FIND v(dout1_149) AT=1680.05n

.meas tran vdout1_150ck1670 FIND v(dout1_150) AT=1680.05n

.meas tran vdout1_151ck1670 FIND v(dout1_151) AT=1680.05n

.meas tran vdout1_152ck1670 FIND v(dout1_152) AT=1680.05n

.meas tran vdout1_153ck1670 FIND v(dout1_153) AT=1680.05n

.meas tran vdout1_154ck1670 FIND v(dout1_154) AT=1680.05n

.meas tran vdout1_155ck1670 FIND v(dout1_155) AT=1680.05n

.meas tran vdout1_156ck1670 FIND v(dout1_156) AT=1680.05n

.meas tran vdout1_157ck1670 FIND v(dout1_157) AT=1680.05n

.meas tran vdout1_158ck1670 FIND v(dout1_158) AT=1680.05n

.meas tran vdout1_159ck1670 FIND v(dout1_159) AT=1680.05n

.meas tran vdout1_160ck1670 FIND v(dout1_160) AT=1680.05n

.meas tran vdout1_161ck1670 FIND v(dout1_161) AT=1680.05n

.meas tran vdout1_162ck1670 FIND v(dout1_162) AT=1680.05n

.meas tran vdout1_163ck1670 FIND v(dout1_163) AT=1680.05n

.meas tran vdout1_164ck1670 FIND v(dout1_164) AT=1680.05n

.meas tran vdout1_165ck1670 FIND v(dout1_165) AT=1680.05n

.meas tran vdout1_166ck1670 FIND v(dout1_166) AT=1680.05n

.meas tran vdout1_167ck1670 FIND v(dout1_167) AT=1680.05n

.meas tran vdout1_168ck1670 FIND v(dout1_168) AT=1680.05n

.meas tran vdout1_169ck1670 FIND v(dout1_169) AT=1680.05n

.meas tran vdout1_170ck1670 FIND v(dout1_170) AT=1680.05n

.meas tran vdout1_171ck1670 FIND v(dout1_171) AT=1680.05n

.meas tran vdout1_172ck1670 FIND v(dout1_172) AT=1680.05n

.meas tran vdout1_173ck1670 FIND v(dout1_173) AT=1680.05n

.meas tran vdout1_174ck1670 FIND v(dout1_174) AT=1680.05n

.meas tran vdout1_175ck1670 FIND v(dout1_175) AT=1680.05n

.meas tran vdout1_176ck1670 FIND v(dout1_176) AT=1680.05n

.meas tran vdout1_177ck1670 FIND v(dout1_177) AT=1680.05n

.meas tran vdout1_178ck1670 FIND v(dout1_178) AT=1680.05n

.meas tran vdout1_179ck1670 FIND v(dout1_179) AT=1680.05n

.meas tran vdout1_180ck1670 FIND v(dout1_180) AT=1680.05n

.meas tran vdout1_181ck1670 FIND v(dout1_181) AT=1680.05n

.meas tran vdout1_182ck1670 FIND v(dout1_182) AT=1680.05n

.meas tran vdout1_183ck1670 FIND v(dout1_183) AT=1680.05n

.meas tran vdout1_184ck1670 FIND v(dout1_184) AT=1680.05n

.meas tran vdout1_185ck1670 FIND v(dout1_185) AT=1680.05n

.meas tran vdout1_186ck1670 FIND v(dout1_186) AT=1680.05n

.meas tran vdout1_187ck1670 FIND v(dout1_187) AT=1680.05n

.meas tran vdout1_188ck1670 FIND v(dout1_188) AT=1680.05n

.meas tran vdout1_189ck1670 FIND v(dout1_189) AT=1680.05n

.meas tran vdout1_190ck1670 FIND v(dout1_190) AT=1680.05n

.meas tran vdout1_191ck1670 FIND v(dout1_191) AT=1680.05n

.meas tran vdout1_192ck1670 FIND v(dout1_192) AT=1680.05n

.meas tran vdout1_193ck1670 FIND v(dout1_193) AT=1680.05n

.meas tran vdout1_194ck1670 FIND v(dout1_194) AT=1680.05n

.meas tran vdout1_195ck1670 FIND v(dout1_195) AT=1680.05n

.meas tran vdout1_196ck1670 FIND v(dout1_196) AT=1680.05n

.meas tran vdout1_197ck1670 FIND v(dout1_197) AT=1680.05n

.meas tran vdout1_198ck1670 FIND v(dout1_198) AT=1680.05n

.meas tran vdout1_199ck1670 FIND v(dout1_199) AT=1680.05n

.meas tran vdout1_200ck1670 FIND v(dout1_200) AT=1680.05n

.meas tran vdout1_201ck1670 FIND v(dout1_201) AT=1680.05n

.meas tran vdout1_202ck1670 FIND v(dout1_202) AT=1680.05n

.meas tran vdout1_203ck1670 FIND v(dout1_203) AT=1680.05n

.meas tran vdout1_204ck1670 FIND v(dout1_204) AT=1680.05n

.meas tran vdout1_205ck1670 FIND v(dout1_205) AT=1680.05n

.meas tran vdout1_206ck1670 FIND v(dout1_206) AT=1680.05n

.meas tran vdout1_207ck1670 FIND v(dout1_207) AT=1680.05n

.meas tran vdout1_208ck1670 FIND v(dout1_208) AT=1680.05n

.meas tran vdout1_209ck1670 FIND v(dout1_209) AT=1680.05n

.meas tran vdout1_210ck1670 FIND v(dout1_210) AT=1680.05n

.meas tran vdout1_211ck1670 FIND v(dout1_211) AT=1680.05n

.meas tran vdout1_212ck1670 FIND v(dout1_212) AT=1680.05n

.meas tran vdout1_213ck1670 FIND v(dout1_213) AT=1680.05n

.meas tran vdout1_214ck1670 FIND v(dout1_214) AT=1680.05n

.meas tran vdout1_215ck1670 FIND v(dout1_215) AT=1680.05n

.meas tran vdout1_216ck1670 FIND v(dout1_216) AT=1680.05n

.meas tran vdout1_217ck1670 FIND v(dout1_217) AT=1680.05n

.meas tran vdout1_218ck1670 FIND v(dout1_218) AT=1680.05n

.meas tran vdout1_219ck1670 FIND v(dout1_219) AT=1680.05n

.meas tran vdout1_220ck1670 FIND v(dout1_220) AT=1680.05n

.meas tran vdout1_221ck1670 FIND v(dout1_221) AT=1680.05n

.meas tran vdout1_222ck1670 FIND v(dout1_222) AT=1680.05n

.meas tran vdout1_223ck1670 FIND v(dout1_223) AT=1680.05n

.meas tran vdout1_224ck1670 FIND v(dout1_224) AT=1680.05n

.meas tran vdout1_225ck1670 FIND v(dout1_225) AT=1680.05n

.meas tran vdout1_226ck1670 FIND v(dout1_226) AT=1680.05n

.meas tran vdout1_227ck1670 FIND v(dout1_227) AT=1680.05n

.meas tran vdout1_228ck1670 FIND v(dout1_228) AT=1680.05n

.meas tran vdout1_229ck1670 FIND v(dout1_229) AT=1680.05n

.meas tran vdout1_230ck1670 FIND v(dout1_230) AT=1680.05n

.meas tran vdout1_231ck1670 FIND v(dout1_231) AT=1680.05n

.meas tran vdout1_232ck1670 FIND v(dout1_232) AT=1680.05n

.meas tran vdout1_233ck1670 FIND v(dout1_233) AT=1680.05n

.meas tran vdout1_234ck1670 FIND v(dout1_234) AT=1680.05n

.meas tran vdout1_235ck1670 FIND v(dout1_235) AT=1680.05n

.meas tran vdout1_236ck1670 FIND v(dout1_236) AT=1680.05n

.meas tran vdout1_237ck1670 FIND v(dout1_237) AT=1680.05n

.meas tran vdout1_238ck1670 FIND v(dout1_238) AT=1680.05n

.meas tran vdout1_239ck1670 FIND v(dout1_239) AT=1680.05n

.meas tran vdout1_240ck1670 FIND v(dout1_240) AT=1680.05n

.meas tran vdout1_241ck1670 FIND v(dout1_241) AT=1680.05n

.meas tran vdout1_242ck1670 FIND v(dout1_242) AT=1680.05n

.meas tran vdout1_243ck1670 FIND v(dout1_243) AT=1680.05n

.meas tran vdout1_244ck1670 FIND v(dout1_244) AT=1680.05n

.meas tran vdout1_245ck1670 FIND v(dout1_245) AT=1680.05n

.meas tran vdout1_246ck1670 FIND v(dout1_246) AT=1680.05n

.meas tran vdout1_247ck1670 FIND v(dout1_247) AT=1680.05n

.meas tran vdout1_248ck1670 FIND v(dout1_248) AT=1680.05n

.meas tran vdout1_249ck1670 FIND v(dout1_249) AT=1680.05n

.meas tran vdout1_250ck1670 FIND v(dout1_250) AT=1680.05n

.meas tran vdout1_251ck1670 FIND v(dout1_251) AT=1680.05n

.meas tran vdout1_252ck1670 FIND v(dout1_252) AT=1680.05n

.meas tran vdout1_253ck1670 FIND v(dout1_253) AT=1680.05n

.meas tran vdout1_254ck1670 FIND v(dout1_254) AT=1680.05n

.meas tran vdout1_255ck1670 FIND v(dout1_255) AT=1680.05n

.meas tran vdout1_256ck1670 FIND v(dout1_256) AT=1680.05n

.meas tran vdout1_0ck1680 FIND v(dout1_0) AT=1690.05n

.meas tran vdout1_1ck1680 FIND v(dout1_1) AT=1690.05n

.meas tran vdout1_2ck1680 FIND v(dout1_2) AT=1690.05n

.meas tran vdout1_3ck1680 FIND v(dout1_3) AT=1690.05n

.meas tran vdout1_4ck1680 FIND v(dout1_4) AT=1690.05n

.meas tran vdout1_5ck1680 FIND v(dout1_5) AT=1690.05n

.meas tran vdout1_6ck1680 FIND v(dout1_6) AT=1690.05n

.meas tran vdout1_7ck1680 FIND v(dout1_7) AT=1690.05n

.meas tran vdout1_8ck1680 FIND v(dout1_8) AT=1690.05n

.meas tran vdout1_9ck1680 FIND v(dout1_9) AT=1690.05n

.meas tran vdout1_10ck1680 FIND v(dout1_10) AT=1690.05n

.meas tran vdout1_11ck1680 FIND v(dout1_11) AT=1690.05n

.meas tran vdout1_12ck1680 FIND v(dout1_12) AT=1690.05n

.meas tran vdout1_13ck1680 FIND v(dout1_13) AT=1690.05n

.meas tran vdout1_14ck1680 FIND v(dout1_14) AT=1690.05n

.meas tran vdout1_15ck1680 FIND v(dout1_15) AT=1690.05n

.meas tran vdout1_16ck1680 FIND v(dout1_16) AT=1690.05n

.meas tran vdout1_17ck1680 FIND v(dout1_17) AT=1690.05n

.meas tran vdout1_18ck1680 FIND v(dout1_18) AT=1690.05n

.meas tran vdout1_19ck1680 FIND v(dout1_19) AT=1690.05n

.meas tran vdout1_20ck1680 FIND v(dout1_20) AT=1690.05n

.meas tran vdout1_21ck1680 FIND v(dout1_21) AT=1690.05n

.meas tran vdout1_22ck1680 FIND v(dout1_22) AT=1690.05n

.meas tran vdout1_23ck1680 FIND v(dout1_23) AT=1690.05n

.meas tran vdout1_24ck1680 FIND v(dout1_24) AT=1690.05n

.meas tran vdout1_25ck1680 FIND v(dout1_25) AT=1690.05n

.meas tran vdout1_26ck1680 FIND v(dout1_26) AT=1690.05n

.meas tran vdout1_27ck1680 FIND v(dout1_27) AT=1690.05n

.meas tran vdout1_28ck1680 FIND v(dout1_28) AT=1690.05n

.meas tran vdout1_29ck1680 FIND v(dout1_29) AT=1690.05n

.meas tran vdout1_30ck1680 FIND v(dout1_30) AT=1690.05n

.meas tran vdout1_31ck1680 FIND v(dout1_31) AT=1690.05n

.meas tran vdout1_32ck1680 FIND v(dout1_32) AT=1690.05n

.meas tran vdout1_33ck1680 FIND v(dout1_33) AT=1690.05n

.meas tran vdout1_34ck1680 FIND v(dout1_34) AT=1690.05n

.meas tran vdout1_35ck1680 FIND v(dout1_35) AT=1690.05n

.meas tran vdout1_36ck1680 FIND v(dout1_36) AT=1690.05n

.meas tran vdout1_37ck1680 FIND v(dout1_37) AT=1690.05n

.meas tran vdout1_38ck1680 FIND v(dout1_38) AT=1690.05n

.meas tran vdout1_39ck1680 FIND v(dout1_39) AT=1690.05n

.meas tran vdout1_40ck1680 FIND v(dout1_40) AT=1690.05n

.meas tran vdout1_41ck1680 FIND v(dout1_41) AT=1690.05n

.meas tran vdout1_42ck1680 FIND v(dout1_42) AT=1690.05n

.meas tran vdout1_43ck1680 FIND v(dout1_43) AT=1690.05n

.meas tran vdout1_44ck1680 FIND v(dout1_44) AT=1690.05n

.meas tran vdout1_45ck1680 FIND v(dout1_45) AT=1690.05n

.meas tran vdout1_46ck1680 FIND v(dout1_46) AT=1690.05n

.meas tran vdout1_47ck1680 FIND v(dout1_47) AT=1690.05n

.meas tran vdout1_48ck1680 FIND v(dout1_48) AT=1690.05n

.meas tran vdout1_49ck1680 FIND v(dout1_49) AT=1690.05n

.meas tran vdout1_50ck1680 FIND v(dout1_50) AT=1690.05n

.meas tran vdout1_51ck1680 FIND v(dout1_51) AT=1690.05n

.meas tran vdout1_52ck1680 FIND v(dout1_52) AT=1690.05n

.meas tran vdout1_53ck1680 FIND v(dout1_53) AT=1690.05n

.meas tran vdout1_54ck1680 FIND v(dout1_54) AT=1690.05n

.meas tran vdout1_55ck1680 FIND v(dout1_55) AT=1690.05n

.meas tran vdout1_56ck1680 FIND v(dout1_56) AT=1690.05n

.meas tran vdout1_57ck1680 FIND v(dout1_57) AT=1690.05n

.meas tran vdout1_58ck1680 FIND v(dout1_58) AT=1690.05n

.meas tran vdout1_59ck1680 FIND v(dout1_59) AT=1690.05n

.meas tran vdout1_60ck1680 FIND v(dout1_60) AT=1690.05n

.meas tran vdout1_61ck1680 FIND v(dout1_61) AT=1690.05n

.meas tran vdout1_62ck1680 FIND v(dout1_62) AT=1690.05n

.meas tran vdout1_63ck1680 FIND v(dout1_63) AT=1690.05n

.meas tran vdout1_64ck1680 FIND v(dout1_64) AT=1690.05n

.meas tran vdout1_65ck1680 FIND v(dout1_65) AT=1690.05n

.meas tran vdout1_66ck1680 FIND v(dout1_66) AT=1690.05n

.meas tran vdout1_67ck1680 FIND v(dout1_67) AT=1690.05n

.meas tran vdout1_68ck1680 FIND v(dout1_68) AT=1690.05n

.meas tran vdout1_69ck1680 FIND v(dout1_69) AT=1690.05n

.meas tran vdout1_70ck1680 FIND v(dout1_70) AT=1690.05n

.meas tran vdout1_71ck1680 FIND v(dout1_71) AT=1690.05n

.meas tran vdout1_72ck1680 FIND v(dout1_72) AT=1690.05n

.meas tran vdout1_73ck1680 FIND v(dout1_73) AT=1690.05n

.meas tran vdout1_74ck1680 FIND v(dout1_74) AT=1690.05n

.meas tran vdout1_75ck1680 FIND v(dout1_75) AT=1690.05n

.meas tran vdout1_76ck1680 FIND v(dout1_76) AT=1690.05n

.meas tran vdout1_77ck1680 FIND v(dout1_77) AT=1690.05n

.meas tran vdout1_78ck1680 FIND v(dout1_78) AT=1690.05n

.meas tran vdout1_79ck1680 FIND v(dout1_79) AT=1690.05n

.meas tran vdout1_80ck1680 FIND v(dout1_80) AT=1690.05n

.meas tran vdout1_81ck1680 FIND v(dout1_81) AT=1690.05n

.meas tran vdout1_82ck1680 FIND v(dout1_82) AT=1690.05n

.meas tran vdout1_83ck1680 FIND v(dout1_83) AT=1690.05n

.meas tran vdout1_84ck1680 FIND v(dout1_84) AT=1690.05n

.meas tran vdout1_85ck1680 FIND v(dout1_85) AT=1690.05n

.meas tran vdout1_86ck1680 FIND v(dout1_86) AT=1690.05n

.meas tran vdout1_87ck1680 FIND v(dout1_87) AT=1690.05n

.meas tran vdout1_88ck1680 FIND v(dout1_88) AT=1690.05n

.meas tran vdout1_89ck1680 FIND v(dout1_89) AT=1690.05n

.meas tran vdout1_90ck1680 FIND v(dout1_90) AT=1690.05n

.meas tran vdout1_91ck1680 FIND v(dout1_91) AT=1690.05n

.meas tran vdout1_92ck1680 FIND v(dout1_92) AT=1690.05n

.meas tran vdout1_93ck1680 FIND v(dout1_93) AT=1690.05n

.meas tran vdout1_94ck1680 FIND v(dout1_94) AT=1690.05n

.meas tran vdout1_95ck1680 FIND v(dout1_95) AT=1690.05n

.meas tran vdout1_96ck1680 FIND v(dout1_96) AT=1690.05n

.meas tran vdout1_97ck1680 FIND v(dout1_97) AT=1690.05n

.meas tran vdout1_98ck1680 FIND v(dout1_98) AT=1690.05n

.meas tran vdout1_99ck1680 FIND v(dout1_99) AT=1690.05n

.meas tran vdout1_100ck1680 FIND v(dout1_100) AT=1690.05n

.meas tran vdout1_101ck1680 FIND v(dout1_101) AT=1690.05n

.meas tran vdout1_102ck1680 FIND v(dout1_102) AT=1690.05n

.meas tran vdout1_103ck1680 FIND v(dout1_103) AT=1690.05n

.meas tran vdout1_104ck1680 FIND v(dout1_104) AT=1690.05n

.meas tran vdout1_105ck1680 FIND v(dout1_105) AT=1690.05n

.meas tran vdout1_106ck1680 FIND v(dout1_106) AT=1690.05n

.meas tran vdout1_107ck1680 FIND v(dout1_107) AT=1690.05n

.meas tran vdout1_108ck1680 FIND v(dout1_108) AT=1690.05n

.meas tran vdout1_109ck1680 FIND v(dout1_109) AT=1690.05n

.meas tran vdout1_110ck1680 FIND v(dout1_110) AT=1690.05n

.meas tran vdout1_111ck1680 FIND v(dout1_111) AT=1690.05n

.meas tran vdout1_112ck1680 FIND v(dout1_112) AT=1690.05n

.meas tran vdout1_113ck1680 FIND v(dout1_113) AT=1690.05n

.meas tran vdout1_114ck1680 FIND v(dout1_114) AT=1690.05n

.meas tran vdout1_115ck1680 FIND v(dout1_115) AT=1690.05n

.meas tran vdout1_116ck1680 FIND v(dout1_116) AT=1690.05n

.meas tran vdout1_117ck1680 FIND v(dout1_117) AT=1690.05n

.meas tran vdout1_118ck1680 FIND v(dout1_118) AT=1690.05n

.meas tran vdout1_119ck1680 FIND v(dout1_119) AT=1690.05n

.meas tran vdout1_120ck1680 FIND v(dout1_120) AT=1690.05n

.meas tran vdout1_121ck1680 FIND v(dout1_121) AT=1690.05n

.meas tran vdout1_122ck1680 FIND v(dout1_122) AT=1690.05n

.meas tran vdout1_123ck1680 FIND v(dout1_123) AT=1690.05n

.meas tran vdout1_124ck1680 FIND v(dout1_124) AT=1690.05n

.meas tran vdout1_125ck1680 FIND v(dout1_125) AT=1690.05n

.meas tran vdout1_126ck1680 FIND v(dout1_126) AT=1690.05n

.meas tran vdout1_127ck1680 FIND v(dout1_127) AT=1690.05n

.meas tran vdout1_128ck1680 FIND v(dout1_128) AT=1690.05n

.meas tran vdout1_129ck1680 FIND v(dout1_129) AT=1690.05n

.meas tran vdout1_130ck1680 FIND v(dout1_130) AT=1690.05n

.meas tran vdout1_131ck1680 FIND v(dout1_131) AT=1690.05n

.meas tran vdout1_132ck1680 FIND v(dout1_132) AT=1690.05n

.meas tran vdout1_133ck1680 FIND v(dout1_133) AT=1690.05n

.meas tran vdout1_134ck1680 FIND v(dout1_134) AT=1690.05n

.meas tran vdout1_135ck1680 FIND v(dout1_135) AT=1690.05n

.meas tran vdout1_136ck1680 FIND v(dout1_136) AT=1690.05n

.meas tran vdout1_137ck1680 FIND v(dout1_137) AT=1690.05n

.meas tran vdout1_138ck1680 FIND v(dout1_138) AT=1690.05n

.meas tran vdout1_139ck1680 FIND v(dout1_139) AT=1690.05n

.meas tran vdout1_140ck1680 FIND v(dout1_140) AT=1690.05n

.meas tran vdout1_141ck1680 FIND v(dout1_141) AT=1690.05n

.meas tran vdout1_142ck1680 FIND v(dout1_142) AT=1690.05n

.meas tran vdout1_143ck1680 FIND v(dout1_143) AT=1690.05n

.meas tran vdout1_144ck1680 FIND v(dout1_144) AT=1690.05n

.meas tran vdout1_145ck1680 FIND v(dout1_145) AT=1690.05n

.meas tran vdout1_146ck1680 FIND v(dout1_146) AT=1690.05n

.meas tran vdout1_147ck1680 FIND v(dout1_147) AT=1690.05n

.meas tran vdout1_148ck1680 FIND v(dout1_148) AT=1690.05n

.meas tran vdout1_149ck1680 FIND v(dout1_149) AT=1690.05n

.meas tran vdout1_150ck1680 FIND v(dout1_150) AT=1690.05n

.meas tran vdout1_151ck1680 FIND v(dout1_151) AT=1690.05n

.meas tran vdout1_152ck1680 FIND v(dout1_152) AT=1690.05n

.meas tran vdout1_153ck1680 FIND v(dout1_153) AT=1690.05n

.meas tran vdout1_154ck1680 FIND v(dout1_154) AT=1690.05n

.meas tran vdout1_155ck1680 FIND v(dout1_155) AT=1690.05n

.meas tran vdout1_156ck1680 FIND v(dout1_156) AT=1690.05n

.meas tran vdout1_157ck1680 FIND v(dout1_157) AT=1690.05n

.meas tran vdout1_158ck1680 FIND v(dout1_158) AT=1690.05n

.meas tran vdout1_159ck1680 FIND v(dout1_159) AT=1690.05n

.meas tran vdout1_160ck1680 FIND v(dout1_160) AT=1690.05n

.meas tran vdout1_161ck1680 FIND v(dout1_161) AT=1690.05n

.meas tran vdout1_162ck1680 FIND v(dout1_162) AT=1690.05n

.meas tran vdout1_163ck1680 FIND v(dout1_163) AT=1690.05n

.meas tran vdout1_164ck1680 FIND v(dout1_164) AT=1690.05n

.meas tran vdout1_165ck1680 FIND v(dout1_165) AT=1690.05n

.meas tran vdout1_166ck1680 FIND v(dout1_166) AT=1690.05n

.meas tran vdout1_167ck1680 FIND v(dout1_167) AT=1690.05n

.meas tran vdout1_168ck1680 FIND v(dout1_168) AT=1690.05n

.meas tran vdout1_169ck1680 FIND v(dout1_169) AT=1690.05n

.meas tran vdout1_170ck1680 FIND v(dout1_170) AT=1690.05n

.meas tran vdout1_171ck1680 FIND v(dout1_171) AT=1690.05n

.meas tran vdout1_172ck1680 FIND v(dout1_172) AT=1690.05n

.meas tran vdout1_173ck1680 FIND v(dout1_173) AT=1690.05n

.meas tran vdout1_174ck1680 FIND v(dout1_174) AT=1690.05n

.meas tran vdout1_175ck1680 FIND v(dout1_175) AT=1690.05n

.meas tran vdout1_176ck1680 FIND v(dout1_176) AT=1690.05n

.meas tran vdout1_177ck1680 FIND v(dout1_177) AT=1690.05n

.meas tran vdout1_178ck1680 FIND v(dout1_178) AT=1690.05n

.meas tran vdout1_179ck1680 FIND v(dout1_179) AT=1690.05n

.meas tran vdout1_180ck1680 FIND v(dout1_180) AT=1690.05n

.meas tran vdout1_181ck1680 FIND v(dout1_181) AT=1690.05n

.meas tran vdout1_182ck1680 FIND v(dout1_182) AT=1690.05n

.meas tran vdout1_183ck1680 FIND v(dout1_183) AT=1690.05n

.meas tran vdout1_184ck1680 FIND v(dout1_184) AT=1690.05n

.meas tran vdout1_185ck1680 FIND v(dout1_185) AT=1690.05n

.meas tran vdout1_186ck1680 FIND v(dout1_186) AT=1690.05n

.meas tran vdout1_187ck1680 FIND v(dout1_187) AT=1690.05n

.meas tran vdout1_188ck1680 FIND v(dout1_188) AT=1690.05n

.meas tran vdout1_189ck1680 FIND v(dout1_189) AT=1690.05n

.meas tran vdout1_190ck1680 FIND v(dout1_190) AT=1690.05n

.meas tran vdout1_191ck1680 FIND v(dout1_191) AT=1690.05n

.meas tran vdout1_192ck1680 FIND v(dout1_192) AT=1690.05n

.meas tran vdout1_193ck1680 FIND v(dout1_193) AT=1690.05n

.meas tran vdout1_194ck1680 FIND v(dout1_194) AT=1690.05n

.meas tran vdout1_195ck1680 FIND v(dout1_195) AT=1690.05n

.meas tran vdout1_196ck1680 FIND v(dout1_196) AT=1690.05n

.meas tran vdout1_197ck1680 FIND v(dout1_197) AT=1690.05n

.meas tran vdout1_198ck1680 FIND v(dout1_198) AT=1690.05n

.meas tran vdout1_199ck1680 FIND v(dout1_199) AT=1690.05n

.meas tran vdout1_200ck1680 FIND v(dout1_200) AT=1690.05n

.meas tran vdout1_201ck1680 FIND v(dout1_201) AT=1690.05n

.meas tran vdout1_202ck1680 FIND v(dout1_202) AT=1690.05n

.meas tran vdout1_203ck1680 FIND v(dout1_203) AT=1690.05n

.meas tran vdout1_204ck1680 FIND v(dout1_204) AT=1690.05n

.meas tran vdout1_205ck1680 FIND v(dout1_205) AT=1690.05n

.meas tran vdout1_206ck1680 FIND v(dout1_206) AT=1690.05n

.meas tran vdout1_207ck1680 FIND v(dout1_207) AT=1690.05n

.meas tran vdout1_208ck1680 FIND v(dout1_208) AT=1690.05n

.meas tran vdout1_209ck1680 FIND v(dout1_209) AT=1690.05n

.meas tran vdout1_210ck1680 FIND v(dout1_210) AT=1690.05n

.meas tran vdout1_211ck1680 FIND v(dout1_211) AT=1690.05n

.meas tran vdout1_212ck1680 FIND v(dout1_212) AT=1690.05n

.meas tran vdout1_213ck1680 FIND v(dout1_213) AT=1690.05n

.meas tran vdout1_214ck1680 FIND v(dout1_214) AT=1690.05n

.meas tran vdout1_215ck1680 FIND v(dout1_215) AT=1690.05n

.meas tran vdout1_216ck1680 FIND v(dout1_216) AT=1690.05n

.meas tran vdout1_217ck1680 FIND v(dout1_217) AT=1690.05n

.meas tran vdout1_218ck1680 FIND v(dout1_218) AT=1690.05n

.meas tran vdout1_219ck1680 FIND v(dout1_219) AT=1690.05n

.meas tran vdout1_220ck1680 FIND v(dout1_220) AT=1690.05n

.meas tran vdout1_221ck1680 FIND v(dout1_221) AT=1690.05n

.meas tran vdout1_222ck1680 FIND v(dout1_222) AT=1690.05n

.meas tran vdout1_223ck1680 FIND v(dout1_223) AT=1690.05n

.meas tran vdout1_224ck1680 FIND v(dout1_224) AT=1690.05n

.meas tran vdout1_225ck1680 FIND v(dout1_225) AT=1690.05n

.meas tran vdout1_226ck1680 FIND v(dout1_226) AT=1690.05n

.meas tran vdout1_227ck1680 FIND v(dout1_227) AT=1690.05n

.meas tran vdout1_228ck1680 FIND v(dout1_228) AT=1690.05n

.meas tran vdout1_229ck1680 FIND v(dout1_229) AT=1690.05n

.meas tran vdout1_230ck1680 FIND v(dout1_230) AT=1690.05n

.meas tran vdout1_231ck1680 FIND v(dout1_231) AT=1690.05n

.meas tran vdout1_232ck1680 FIND v(dout1_232) AT=1690.05n

.meas tran vdout1_233ck1680 FIND v(dout1_233) AT=1690.05n

.meas tran vdout1_234ck1680 FIND v(dout1_234) AT=1690.05n

.meas tran vdout1_235ck1680 FIND v(dout1_235) AT=1690.05n

.meas tran vdout1_236ck1680 FIND v(dout1_236) AT=1690.05n

.meas tran vdout1_237ck1680 FIND v(dout1_237) AT=1690.05n

.meas tran vdout1_238ck1680 FIND v(dout1_238) AT=1690.05n

.meas tran vdout1_239ck1680 FIND v(dout1_239) AT=1690.05n

.meas tran vdout1_240ck1680 FIND v(dout1_240) AT=1690.05n

.meas tran vdout1_241ck1680 FIND v(dout1_241) AT=1690.05n

.meas tran vdout1_242ck1680 FIND v(dout1_242) AT=1690.05n

.meas tran vdout1_243ck1680 FIND v(dout1_243) AT=1690.05n

.meas tran vdout1_244ck1680 FIND v(dout1_244) AT=1690.05n

.meas tran vdout1_245ck1680 FIND v(dout1_245) AT=1690.05n

.meas tran vdout1_246ck1680 FIND v(dout1_246) AT=1690.05n

.meas tran vdout1_247ck1680 FIND v(dout1_247) AT=1690.05n

.meas tran vdout1_248ck1680 FIND v(dout1_248) AT=1690.05n

.meas tran vdout1_249ck1680 FIND v(dout1_249) AT=1690.05n

.meas tran vdout1_250ck1680 FIND v(dout1_250) AT=1690.05n

.meas tran vdout1_251ck1680 FIND v(dout1_251) AT=1690.05n

.meas tran vdout1_252ck1680 FIND v(dout1_252) AT=1690.05n

.meas tran vdout1_253ck1680 FIND v(dout1_253) AT=1690.05n

.meas tran vdout1_254ck1680 FIND v(dout1_254) AT=1690.05n

.meas tran vdout1_255ck1680 FIND v(dout1_255) AT=1690.05n

.meas tran vdout1_256ck1680 FIND v(dout1_256) AT=1690.05n

.meas tran vdout1_0ck1690 FIND v(dout1_0) AT=1700.05n

.meas tran vdout1_1ck1690 FIND v(dout1_1) AT=1700.05n

.meas tran vdout1_2ck1690 FIND v(dout1_2) AT=1700.05n

.meas tran vdout1_3ck1690 FIND v(dout1_3) AT=1700.05n

.meas tran vdout1_4ck1690 FIND v(dout1_4) AT=1700.05n

.meas tran vdout1_5ck1690 FIND v(dout1_5) AT=1700.05n

.meas tran vdout1_6ck1690 FIND v(dout1_6) AT=1700.05n

.meas tran vdout1_7ck1690 FIND v(dout1_7) AT=1700.05n

.meas tran vdout1_8ck1690 FIND v(dout1_8) AT=1700.05n

.meas tran vdout1_9ck1690 FIND v(dout1_9) AT=1700.05n

.meas tran vdout1_10ck1690 FIND v(dout1_10) AT=1700.05n

.meas tran vdout1_11ck1690 FIND v(dout1_11) AT=1700.05n

.meas tran vdout1_12ck1690 FIND v(dout1_12) AT=1700.05n

.meas tran vdout1_13ck1690 FIND v(dout1_13) AT=1700.05n

.meas tran vdout1_14ck1690 FIND v(dout1_14) AT=1700.05n

.meas tran vdout1_15ck1690 FIND v(dout1_15) AT=1700.05n

.meas tran vdout1_16ck1690 FIND v(dout1_16) AT=1700.05n

.meas tran vdout1_17ck1690 FIND v(dout1_17) AT=1700.05n

.meas tran vdout1_18ck1690 FIND v(dout1_18) AT=1700.05n

.meas tran vdout1_19ck1690 FIND v(dout1_19) AT=1700.05n

.meas tran vdout1_20ck1690 FIND v(dout1_20) AT=1700.05n

.meas tran vdout1_21ck1690 FIND v(dout1_21) AT=1700.05n

.meas tran vdout1_22ck1690 FIND v(dout1_22) AT=1700.05n

.meas tran vdout1_23ck1690 FIND v(dout1_23) AT=1700.05n

.meas tran vdout1_24ck1690 FIND v(dout1_24) AT=1700.05n

.meas tran vdout1_25ck1690 FIND v(dout1_25) AT=1700.05n

.meas tran vdout1_26ck1690 FIND v(dout1_26) AT=1700.05n

.meas tran vdout1_27ck1690 FIND v(dout1_27) AT=1700.05n

.meas tran vdout1_28ck1690 FIND v(dout1_28) AT=1700.05n

.meas tran vdout1_29ck1690 FIND v(dout1_29) AT=1700.05n

.meas tran vdout1_30ck1690 FIND v(dout1_30) AT=1700.05n

.meas tran vdout1_31ck1690 FIND v(dout1_31) AT=1700.05n

.meas tran vdout1_32ck1690 FIND v(dout1_32) AT=1700.05n

.meas tran vdout1_33ck1690 FIND v(dout1_33) AT=1700.05n

.meas tran vdout1_34ck1690 FIND v(dout1_34) AT=1700.05n

.meas tran vdout1_35ck1690 FIND v(dout1_35) AT=1700.05n

.meas tran vdout1_36ck1690 FIND v(dout1_36) AT=1700.05n

.meas tran vdout1_37ck1690 FIND v(dout1_37) AT=1700.05n

.meas tran vdout1_38ck1690 FIND v(dout1_38) AT=1700.05n

.meas tran vdout1_39ck1690 FIND v(dout1_39) AT=1700.05n

.meas tran vdout1_40ck1690 FIND v(dout1_40) AT=1700.05n

.meas tran vdout1_41ck1690 FIND v(dout1_41) AT=1700.05n

.meas tran vdout1_42ck1690 FIND v(dout1_42) AT=1700.05n

.meas tran vdout1_43ck1690 FIND v(dout1_43) AT=1700.05n

.meas tran vdout1_44ck1690 FIND v(dout1_44) AT=1700.05n

.meas tran vdout1_45ck1690 FIND v(dout1_45) AT=1700.05n

.meas tran vdout1_46ck1690 FIND v(dout1_46) AT=1700.05n

.meas tran vdout1_47ck1690 FIND v(dout1_47) AT=1700.05n

.meas tran vdout1_48ck1690 FIND v(dout1_48) AT=1700.05n

.meas tran vdout1_49ck1690 FIND v(dout1_49) AT=1700.05n

.meas tran vdout1_50ck1690 FIND v(dout1_50) AT=1700.05n

.meas tran vdout1_51ck1690 FIND v(dout1_51) AT=1700.05n

.meas tran vdout1_52ck1690 FIND v(dout1_52) AT=1700.05n

.meas tran vdout1_53ck1690 FIND v(dout1_53) AT=1700.05n

.meas tran vdout1_54ck1690 FIND v(dout1_54) AT=1700.05n

.meas tran vdout1_55ck1690 FIND v(dout1_55) AT=1700.05n

.meas tran vdout1_56ck1690 FIND v(dout1_56) AT=1700.05n

.meas tran vdout1_57ck1690 FIND v(dout1_57) AT=1700.05n

.meas tran vdout1_58ck1690 FIND v(dout1_58) AT=1700.05n

.meas tran vdout1_59ck1690 FIND v(dout1_59) AT=1700.05n

.meas tran vdout1_60ck1690 FIND v(dout1_60) AT=1700.05n

.meas tran vdout1_61ck1690 FIND v(dout1_61) AT=1700.05n

.meas tran vdout1_62ck1690 FIND v(dout1_62) AT=1700.05n

.meas tran vdout1_63ck1690 FIND v(dout1_63) AT=1700.05n

.meas tran vdout1_64ck1690 FIND v(dout1_64) AT=1700.05n

.meas tran vdout1_65ck1690 FIND v(dout1_65) AT=1700.05n

.meas tran vdout1_66ck1690 FIND v(dout1_66) AT=1700.05n

.meas tran vdout1_67ck1690 FIND v(dout1_67) AT=1700.05n

.meas tran vdout1_68ck1690 FIND v(dout1_68) AT=1700.05n

.meas tran vdout1_69ck1690 FIND v(dout1_69) AT=1700.05n

.meas tran vdout1_70ck1690 FIND v(dout1_70) AT=1700.05n

.meas tran vdout1_71ck1690 FIND v(dout1_71) AT=1700.05n

.meas tran vdout1_72ck1690 FIND v(dout1_72) AT=1700.05n

.meas tran vdout1_73ck1690 FIND v(dout1_73) AT=1700.05n

.meas tran vdout1_74ck1690 FIND v(dout1_74) AT=1700.05n

.meas tran vdout1_75ck1690 FIND v(dout1_75) AT=1700.05n

.meas tran vdout1_76ck1690 FIND v(dout1_76) AT=1700.05n

.meas tran vdout1_77ck1690 FIND v(dout1_77) AT=1700.05n

.meas tran vdout1_78ck1690 FIND v(dout1_78) AT=1700.05n

.meas tran vdout1_79ck1690 FIND v(dout1_79) AT=1700.05n

.meas tran vdout1_80ck1690 FIND v(dout1_80) AT=1700.05n

.meas tran vdout1_81ck1690 FIND v(dout1_81) AT=1700.05n

.meas tran vdout1_82ck1690 FIND v(dout1_82) AT=1700.05n

.meas tran vdout1_83ck1690 FIND v(dout1_83) AT=1700.05n

.meas tran vdout1_84ck1690 FIND v(dout1_84) AT=1700.05n

.meas tran vdout1_85ck1690 FIND v(dout1_85) AT=1700.05n

.meas tran vdout1_86ck1690 FIND v(dout1_86) AT=1700.05n

.meas tran vdout1_87ck1690 FIND v(dout1_87) AT=1700.05n

.meas tran vdout1_88ck1690 FIND v(dout1_88) AT=1700.05n

.meas tran vdout1_89ck1690 FIND v(dout1_89) AT=1700.05n

.meas tran vdout1_90ck1690 FIND v(dout1_90) AT=1700.05n

.meas tran vdout1_91ck1690 FIND v(dout1_91) AT=1700.05n

.meas tran vdout1_92ck1690 FIND v(dout1_92) AT=1700.05n

.meas tran vdout1_93ck1690 FIND v(dout1_93) AT=1700.05n

.meas tran vdout1_94ck1690 FIND v(dout1_94) AT=1700.05n

.meas tran vdout1_95ck1690 FIND v(dout1_95) AT=1700.05n

.meas tran vdout1_96ck1690 FIND v(dout1_96) AT=1700.05n

.meas tran vdout1_97ck1690 FIND v(dout1_97) AT=1700.05n

.meas tran vdout1_98ck1690 FIND v(dout1_98) AT=1700.05n

.meas tran vdout1_99ck1690 FIND v(dout1_99) AT=1700.05n

.meas tran vdout1_100ck1690 FIND v(dout1_100) AT=1700.05n

.meas tran vdout1_101ck1690 FIND v(dout1_101) AT=1700.05n

.meas tran vdout1_102ck1690 FIND v(dout1_102) AT=1700.05n

.meas tran vdout1_103ck1690 FIND v(dout1_103) AT=1700.05n

.meas tran vdout1_104ck1690 FIND v(dout1_104) AT=1700.05n

.meas tran vdout1_105ck1690 FIND v(dout1_105) AT=1700.05n

.meas tran vdout1_106ck1690 FIND v(dout1_106) AT=1700.05n

.meas tran vdout1_107ck1690 FIND v(dout1_107) AT=1700.05n

.meas tran vdout1_108ck1690 FIND v(dout1_108) AT=1700.05n

.meas tran vdout1_109ck1690 FIND v(dout1_109) AT=1700.05n

.meas tran vdout1_110ck1690 FIND v(dout1_110) AT=1700.05n

.meas tran vdout1_111ck1690 FIND v(dout1_111) AT=1700.05n

.meas tran vdout1_112ck1690 FIND v(dout1_112) AT=1700.05n

.meas tran vdout1_113ck1690 FIND v(dout1_113) AT=1700.05n

.meas tran vdout1_114ck1690 FIND v(dout1_114) AT=1700.05n

.meas tran vdout1_115ck1690 FIND v(dout1_115) AT=1700.05n

.meas tran vdout1_116ck1690 FIND v(dout1_116) AT=1700.05n

.meas tran vdout1_117ck1690 FIND v(dout1_117) AT=1700.05n

.meas tran vdout1_118ck1690 FIND v(dout1_118) AT=1700.05n

.meas tran vdout1_119ck1690 FIND v(dout1_119) AT=1700.05n

.meas tran vdout1_120ck1690 FIND v(dout1_120) AT=1700.05n

.meas tran vdout1_121ck1690 FIND v(dout1_121) AT=1700.05n

.meas tran vdout1_122ck1690 FIND v(dout1_122) AT=1700.05n

.meas tran vdout1_123ck1690 FIND v(dout1_123) AT=1700.05n

.meas tran vdout1_124ck1690 FIND v(dout1_124) AT=1700.05n

.meas tran vdout1_125ck1690 FIND v(dout1_125) AT=1700.05n

.meas tran vdout1_126ck1690 FIND v(dout1_126) AT=1700.05n

.meas tran vdout1_127ck1690 FIND v(dout1_127) AT=1700.05n

.meas tran vdout1_128ck1690 FIND v(dout1_128) AT=1700.05n

.meas tran vdout1_129ck1690 FIND v(dout1_129) AT=1700.05n

.meas tran vdout1_130ck1690 FIND v(dout1_130) AT=1700.05n

.meas tran vdout1_131ck1690 FIND v(dout1_131) AT=1700.05n

.meas tran vdout1_132ck1690 FIND v(dout1_132) AT=1700.05n

.meas tran vdout1_133ck1690 FIND v(dout1_133) AT=1700.05n

.meas tran vdout1_134ck1690 FIND v(dout1_134) AT=1700.05n

.meas tran vdout1_135ck1690 FIND v(dout1_135) AT=1700.05n

.meas tran vdout1_136ck1690 FIND v(dout1_136) AT=1700.05n

.meas tran vdout1_137ck1690 FIND v(dout1_137) AT=1700.05n

.meas tran vdout1_138ck1690 FIND v(dout1_138) AT=1700.05n

.meas tran vdout1_139ck1690 FIND v(dout1_139) AT=1700.05n

.meas tran vdout1_140ck1690 FIND v(dout1_140) AT=1700.05n

.meas tran vdout1_141ck1690 FIND v(dout1_141) AT=1700.05n

.meas tran vdout1_142ck1690 FIND v(dout1_142) AT=1700.05n

.meas tran vdout1_143ck1690 FIND v(dout1_143) AT=1700.05n

.meas tran vdout1_144ck1690 FIND v(dout1_144) AT=1700.05n

.meas tran vdout1_145ck1690 FIND v(dout1_145) AT=1700.05n

.meas tran vdout1_146ck1690 FIND v(dout1_146) AT=1700.05n

.meas tran vdout1_147ck1690 FIND v(dout1_147) AT=1700.05n

.meas tran vdout1_148ck1690 FIND v(dout1_148) AT=1700.05n

.meas tran vdout1_149ck1690 FIND v(dout1_149) AT=1700.05n

.meas tran vdout1_150ck1690 FIND v(dout1_150) AT=1700.05n

.meas tran vdout1_151ck1690 FIND v(dout1_151) AT=1700.05n

.meas tran vdout1_152ck1690 FIND v(dout1_152) AT=1700.05n

.meas tran vdout1_153ck1690 FIND v(dout1_153) AT=1700.05n

.meas tran vdout1_154ck1690 FIND v(dout1_154) AT=1700.05n

.meas tran vdout1_155ck1690 FIND v(dout1_155) AT=1700.05n

.meas tran vdout1_156ck1690 FIND v(dout1_156) AT=1700.05n

.meas tran vdout1_157ck1690 FIND v(dout1_157) AT=1700.05n

.meas tran vdout1_158ck1690 FIND v(dout1_158) AT=1700.05n

.meas tran vdout1_159ck1690 FIND v(dout1_159) AT=1700.05n

.meas tran vdout1_160ck1690 FIND v(dout1_160) AT=1700.05n

.meas tran vdout1_161ck1690 FIND v(dout1_161) AT=1700.05n

.meas tran vdout1_162ck1690 FIND v(dout1_162) AT=1700.05n

.meas tran vdout1_163ck1690 FIND v(dout1_163) AT=1700.05n

.meas tran vdout1_164ck1690 FIND v(dout1_164) AT=1700.05n

.meas tran vdout1_165ck1690 FIND v(dout1_165) AT=1700.05n

.meas tran vdout1_166ck1690 FIND v(dout1_166) AT=1700.05n

.meas tran vdout1_167ck1690 FIND v(dout1_167) AT=1700.05n

.meas tran vdout1_168ck1690 FIND v(dout1_168) AT=1700.05n

.meas tran vdout1_169ck1690 FIND v(dout1_169) AT=1700.05n

.meas tran vdout1_170ck1690 FIND v(dout1_170) AT=1700.05n

.meas tran vdout1_171ck1690 FIND v(dout1_171) AT=1700.05n

.meas tran vdout1_172ck1690 FIND v(dout1_172) AT=1700.05n

.meas tran vdout1_173ck1690 FIND v(dout1_173) AT=1700.05n

.meas tran vdout1_174ck1690 FIND v(dout1_174) AT=1700.05n

.meas tran vdout1_175ck1690 FIND v(dout1_175) AT=1700.05n

.meas tran vdout1_176ck1690 FIND v(dout1_176) AT=1700.05n

.meas tran vdout1_177ck1690 FIND v(dout1_177) AT=1700.05n

.meas tran vdout1_178ck1690 FIND v(dout1_178) AT=1700.05n

.meas tran vdout1_179ck1690 FIND v(dout1_179) AT=1700.05n

.meas tran vdout1_180ck1690 FIND v(dout1_180) AT=1700.05n

.meas tran vdout1_181ck1690 FIND v(dout1_181) AT=1700.05n

.meas tran vdout1_182ck1690 FIND v(dout1_182) AT=1700.05n

.meas tran vdout1_183ck1690 FIND v(dout1_183) AT=1700.05n

.meas tran vdout1_184ck1690 FIND v(dout1_184) AT=1700.05n

.meas tran vdout1_185ck1690 FIND v(dout1_185) AT=1700.05n

.meas tran vdout1_186ck1690 FIND v(dout1_186) AT=1700.05n

.meas tran vdout1_187ck1690 FIND v(dout1_187) AT=1700.05n

.meas tran vdout1_188ck1690 FIND v(dout1_188) AT=1700.05n

.meas tran vdout1_189ck1690 FIND v(dout1_189) AT=1700.05n

.meas tran vdout1_190ck1690 FIND v(dout1_190) AT=1700.05n

.meas tran vdout1_191ck1690 FIND v(dout1_191) AT=1700.05n

.meas tran vdout1_192ck1690 FIND v(dout1_192) AT=1700.05n

.meas tran vdout1_193ck1690 FIND v(dout1_193) AT=1700.05n

.meas tran vdout1_194ck1690 FIND v(dout1_194) AT=1700.05n

.meas tran vdout1_195ck1690 FIND v(dout1_195) AT=1700.05n

.meas tran vdout1_196ck1690 FIND v(dout1_196) AT=1700.05n

.meas tran vdout1_197ck1690 FIND v(dout1_197) AT=1700.05n

.meas tran vdout1_198ck1690 FIND v(dout1_198) AT=1700.05n

.meas tran vdout1_199ck1690 FIND v(dout1_199) AT=1700.05n

.meas tran vdout1_200ck1690 FIND v(dout1_200) AT=1700.05n

.meas tran vdout1_201ck1690 FIND v(dout1_201) AT=1700.05n

.meas tran vdout1_202ck1690 FIND v(dout1_202) AT=1700.05n

.meas tran vdout1_203ck1690 FIND v(dout1_203) AT=1700.05n

.meas tran vdout1_204ck1690 FIND v(dout1_204) AT=1700.05n

.meas tran vdout1_205ck1690 FIND v(dout1_205) AT=1700.05n

.meas tran vdout1_206ck1690 FIND v(dout1_206) AT=1700.05n

.meas tran vdout1_207ck1690 FIND v(dout1_207) AT=1700.05n

.meas tran vdout1_208ck1690 FIND v(dout1_208) AT=1700.05n

.meas tran vdout1_209ck1690 FIND v(dout1_209) AT=1700.05n

.meas tran vdout1_210ck1690 FIND v(dout1_210) AT=1700.05n

.meas tran vdout1_211ck1690 FIND v(dout1_211) AT=1700.05n

.meas tran vdout1_212ck1690 FIND v(dout1_212) AT=1700.05n

.meas tran vdout1_213ck1690 FIND v(dout1_213) AT=1700.05n

.meas tran vdout1_214ck1690 FIND v(dout1_214) AT=1700.05n

.meas tran vdout1_215ck1690 FIND v(dout1_215) AT=1700.05n

.meas tran vdout1_216ck1690 FIND v(dout1_216) AT=1700.05n

.meas tran vdout1_217ck1690 FIND v(dout1_217) AT=1700.05n

.meas tran vdout1_218ck1690 FIND v(dout1_218) AT=1700.05n

.meas tran vdout1_219ck1690 FIND v(dout1_219) AT=1700.05n

.meas tran vdout1_220ck1690 FIND v(dout1_220) AT=1700.05n

.meas tran vdout1_221ck1690 FIND v(dout1_221) AT=1700.05n

.meas tran vdout1_222ck1690 FIND v(dout1_222) AT=1700.05n

.meas tran vdout1_223ck1690 FIND v(dout1_223) AT=1700.05n

.meas tran vdout1_224ck1690 FIND v(dout1_224) AT=1700.05n

.meas tran vdout1_225ck1690 FIND v(dout1_225) AT=1700.05n

.meas tran vdout1_226ck1690 FIND v(dout1_226) AT=1700.05n

.meas tran vdout1_227ck1690 FIND v(dout1_227) AT=1700.05n

.meas tran vdout1_228ck1690 FIND v(dout1_228) AT=1700.05n

.meas tran vdout1_229ck1690 FIND v(dout1_229) AT=1700.05n

.meas tran vdout1_230ck1690 FIND v(dout1_230) AT=1700.05n

.meas tran vdout1_231ck1690 FIND v(dout1_231) AT=1700.05n

.meas tran vdout1_232ck1690 FIND v(dout1_232) AT=1700.05n

.meas tran vdout1_233ck1690 FIND v(dout1_233) AT=1700.05n

.meas tran vdout1_234ck1690 FIND v(dout1_234) AT=1700.05n

.meas tran vdout1_235ck1690 FIND v(dout1_235) AT=1700.05n

.meas tran vdout1_236ck1690 FIND v(dout1_236) AT=1700.05n

.meas tran vdout1_237ck1690 FIND v(dout1_237) AT=1700.05n

.meas tran vdout1_238ck1690 FIND v(dout1_238) AT=1700.05n

.meas tran vdout1_239ck1690 FIND v(dout1_239) AT=1700.05n

.meas tran vdout1_240ck1690 FIND v(dout1_240) AT=1700.05n

.meas tran vdout1_241ck1690 FIND v(dout1_241) AT=1700.05n

.meas tran vdout1_242ck1690 FIND v(dout1_242) AT=1700.05n

.meas tran vdout1_243ck1690 FIND v(dout1_243) AT=1700.05n

.meas tran vdout1_244ck1690 FIND v(dout1_244) AT=1700.05n

.meas tran vdout1_245ck1690 FIND v(dout1_245) AT=1700.05n

.meas tran vdout1_246ck1690 FIND v(dout1_246) AT=1700.05n

.meas tran vdout1_247ck1690 FIND v(dout1_247) AT=1700.05n

.meas tran vdout1_248ck1690 FIND v(dout1_248) AT=1700.05n

.meas tran vdout1_249ck1690 FIND v(dout1_249) AT=1700.05n

.meas tran vdout1_250ck1690 FIND v(dout1_250) AT=1700.05n

.meas tran vdout1_251ck1690 FIND v(dout1_251) AT=1700.05n

.meas tran vdout1_252ck1690 FIND v(dout1_252) AT=1700.05n

.meas tran vdout1_253ck1690 FIND v(dout1_253) AT=1700.05n

.meas tran vdout1_254ck1690 FIND v(dout1_254) AT=1700.05n

.meas tran vdout1_255ck1690 FIND v(dout1_255) AT=1700.05n

.meas tran vdout1_256ck1690 FIND v(dout1_256) AT=1700.05n

.meas tran vdout1_0ck1710 FIND v(dout1_0) AT=1720.05n

.meas tran vdout1_1ck1710 FIND v(dout1_1) AT=1720.05n

.meas tran vdout1_2ck1710 FIND v(dout1_2) AT=1720.05n

.meas tran vdout1_3ck1710 FIND v(dout1_3) AT=1720.05n

.meas tran vdout1_4ck1710 FIND v(dout1_4) AT=1720.05n

.meas tran vdout1_5ck1710 FIND v(dout1_5) AT=1720.05n

.meas tran vdout1_6ck1710 FIND v(dout1_6) AT=1720.05n

.meas tran vdout1_7ck1710 FIND v(dout1_7) AT=1720.05n

.meas tran vdout1_8ck1710 FIND v(dout1_8) AT=1720.05n

.meas tran vdout1_9ck1710 FIND v(dout1_9) AT=1720.05n

.meas tran vdout1_10ck1710 FIND v(dout1_10) AT=1720.05n

.meas tran vdout1_11ck1710 FIND v(dout1_11) AT=1720.05n

.meas tran vdout1_12ck1710 FIND v(dout1_12) AT=1720.05n

.meas tran vdout1_13ck1710 FIND v(dout1_13) AT=1720.05n

.meas tran vdout1_14ck1710 FIND v(dout1_14) AT=1720.05n

.meas tran vdout1_15ck1710 FIND v(dout1_15) AT=1720.05n

.meas tran vdout1_16ck1710 FIND v(dout1_16) AT=1720.05n

.meas tran vdout1_17ck1710 FIND v(dout1_17) AT=1720.05n

.meas tran vdout1_18ck1710 FIND v(dout1_18) AT=1720.05n

.meas tran vdout1_19ck1710 FIND v(dout1_19) AT=1720.05n

.meas tran vdout1_20ck1710 FIND v(dout1_20) AT=1720.05n

.meas tran vdout1_21ck1710 FIND v(dout1_21) AT=1720.05n

.meas tran vdout1_22ck1710 FIND v(dout1_22) AT=1720.05n

.meas tran vdout1_23ck1710 FIND v(dout1_23) AT=1720.05n

.meas tran vdout1_24ck1710 FIND v(dout1_24) AT=1720.05n

.meas tran vdout1_25ck1710 FIND v(dout1_25) AT=1720.05n

.meas tran vdout1_26ck1710 FIND v(dout1_26) AT=1720.05n

.meas tran vdout1_27ck1710 FIND v(dout1_27) AT=1720.05n

.meas tran vdout1_28ck1710 FIND v(dout1_28) AT=1720.05n

.meas tran vdout1_29ck1710 FIND v(dout1_29) AT=1720.05n

.meas tran vdout1_30ck1710 FIND v(dout1_30) AT=1720.05n

.meas tran vdout1_31ck1710 FIND v(dout1_31) AT=1720.05n

.meas tran vdout1_32ck1710 FIND v(dout1_32) AT=1720.05n

.meas tran vdout1_33ck1710 FIND v(dout1_33) AT=1720.05n

.meas tran vdout1_34ck1710 FIND v(dout1_34) AT=1720.05n

.meas tran vdout1_35ck1710 FIND v(dout1_35) AT=1720.05n

.meas tran vdout1_36ck1710 FIND v(dout1_36) AT=1720.05n

.meas tran vdout1_37ck1710 FIND v(dout1_37) AT=1720.05n

.meas tran vdout1_38ck1710 FIND v(dout1_38) AT=1720.05n

.meas tran vdout1_39ck1710 FIND v(dout1_39) AT=1720.05n

.meas tran vdout1_40ck1710 FIND v(dout1_40) AT=1720.05n

.meas tran vdout1_41ck1710 FIND v(dout1_41) AT=1720.05n

.meas tran vdout1_42ck1710 FIND v(dout1_42) AT=1720.05n

.meas tran vdout1_43ck1710 FIND v(dout1_43) AT=1720.05n

.meas tran vdout1_44ck1710 FIND v(dout1_44) AT=1720.05n

.meas tran vdout1_45ck1710 FIND v(dout1_45) AT=1720.05n

.meas tran vdout1_46ck1710 FIND v(dout1_46) AT=1720.05n

.meas tran vdout1_47ck1710 FIND v(dout1_47) AT=1720.05n

.meas tran vdout1_48ck1710 FIND v(dout1_48) AT=1720.05n

.meas tran vdout1_49ck1710 FIND v(dout1_49) AT=1720.05n

.meas tran vdout1_50ck1710 FIND v(dout1_50) AT=1720.05n

.meas tran vdout1_51ck1710 FIND v(dout1_51) AT=1720.05n

.meas tran vdout1_52ck1710 FIND v(dout1_52) AT=1720.05n

.meas tran vdout1_53ck1710 FIND v(dout1_53) AT=1720.05n

.meas tran vdout1_54ck1710 FIND v(dout1_54) AT=1720.05n

.meas tran vdout1_55ck1710 FIND v(dout1_55) AT=1720.05n

.meas tran vdout1_56ck1710 FIND v(dout1_56) AT=1720.05n

.meas tran vdout1_57ck1710 FIND v(dout1_57) AT=1720.05n

.meas tran vdout1_58ck1710 FIND v(dout1_58) AT=1720.05n

.meas tran vdout1_59ck1710 FIND v(dout1_59) AT=1720.05n

.meas tran vdout1_60ck1710 FIND v(dout1_60) AT=1720.05n

.meas tran vdout1_61ck1710 FIND v(dout1_61) AT=1720.05n

.meas tran vdout1_62ck1710 FIND v(dout1_62) AT=1720.05n

.meas tran vdout1_63ck1710 FIND v(dout1_63) AT=1720.05n

.meas tran vdout1_64ck1710 FIND v(dout1_64) AT=1720.05n

.meas tran vdout1_65ck1710 FIND v(dout1_65) AT=1720.05n

.meas tran vdout1_66ck1710 FIND v(dout1_66) AT=1720.05n

.meas tran vdout1_67ck1710 FIND v(dout1_67) AT=1720.05n

.meas tran vdout1_68ck1710 FIND v(dout1_68) AT=1720.05n

.meas tran vdout1_69ck1710 FIND v(dout1_69) AT=1720.05n

.meas tran vdout1_70ck1710 FIND v(dout1_70) AT=1720.05n

.meas tran vdout1_71ck1710 FIND v(dout1_71) AT=1720.05n

.meas tran vdout1_72ck1710 FIND v(dout1_72) AT=1720.05n

.meas tran vdout1_73ck1710 FIND v(dout1_73) AT=1720.05n

.meas tran vdout1_74ck1710 FIND v(dout1_74) AT=1720.05n

.meas tran vdout1_75ck1710 FIND v(dout1_75) AT=1720.05n

.meas tran vdout1_76ck1710 FIND v(dout1_76) AT=1720.05n

.meas tran vdout1_77ck1710 FIND v(dout1_77) AT=1720.05n

.meas tran vdout1_78ck1710 FIND v(dout1_78) AT=1720.05n

.meas tran vdout1_79ck1710 FIND v(dout1_79) AT=1720.05n

.meas tran vdout1_80ck1710 FIND v(dout1_80) AT=1720.05n

.meas tran vdout1_81ck1710 FIND v(dout1_81) AT=1720.05n

.meas tran vdout1_82ck1710 FIND v(dout1_82) AT=1720.05n

.meas tran vdout1_83ck1710 FIND v(dout1_83) AT=1720.05n

.meas tran vdout1_84ck1710 FIND v(dout1_84) AT=1720.05n

.meas tran vdout1_85ck1710 FIND v(dout1_85) AT=1720.05n

.meas tran vdout1_86ck1710 FIND v(dout1_86) AT=1720.05n

.meas tran vdout1_87ck1710 FIND v(dout1_87) AT=1720.05n

.meas tran vdout1_88ck1710 FIND v(dout1_88) AT=1720.05n

.meas tran vdout1_89ck1710 FIND v(dout1_89) AT=1720.05n

.meas tran vdout1_90ck1710 FIND v(dout1_90) AT=1720.05n

.meas tran vdout1_91ck1710 FIND v(dout1_91) AT=1720.05n

.meas tran vdout1_92ck1710 FIND v(dout1_92) AT=1720.05n

.meas tran vdout1_93ck1710 FIND v(dout1_93) AT=1720.05n

.meas tran vdout1_94ck1710 FIND v(dout1_94) AT=1720.05n

.meas tran vdout1_95ck1710 FIND v(dout1_95) AT=1720.05n

.meas tran vdout1_96ck1710 FIND v(dout1_96) AT=1720.05n

.meas tran vdout1_97ck1710 FIND v(dout1_97) AT=1720.05n

.meas tran vdout1_98ck1710 FIND v(dout1_98) AT=1720.05n

.meas tran vdout1_99ck1710 FIND v(dout1_99) AT=1720.05n

.meas tran vdout1_100ck1710 FIND v(dout1_100) AT=1720.05n

.meas tran vdout1_101ck1710 FIND v(dout1_101) AT=1720.05n

.meas tran vdout1_102ck1710 FIND v(dout1_102) AT=1720.05n

.meas tran vdout1_103ck1710 FIND v(dout1_103) AT=1720.05n

.meas tran vdout1_104ck1710 FIND v(dout1_104) AT=1720.05n

.meas tran vdout1_105ck1710 FIND v(dout1_105) AT=1720.05n

.meas tran vdout1_106ck1710 FIND v(dout1_106) AT=1720.05n

.meas tran vdout1_107ck1710 FIND v(dout1_107) AT=1720.05n

.meas tran vdout1_108ck1710 FIND v(dout1_108) AT=1720.05n

.meas tran vdout1_109ck1710 FIND v(dout1_109) AT=1720.05n

.meas tran vdout1_110ck1710 FIND v(dout1_110) AT=1720.05n

.meas tran vdout1_111ck1710 FIND v(dout1_111) AT=1720.05n

.meas tran vdout1_112ck1710 FIND v(dout1_112) AT=1720.05n

.meas tran vdout1_113ck1710 FIND v(dout1_113) AT=1720.05n

.meas tran vdout1_114ck1710 FIND v(dout1_114) AT=1720.05n

.meas tran vdout1_115ck1710 FIND v(dout1_115) AT=1720.05n

.meas tran vdout1_116ck1710 FIND v(dout1_116) AT=1720.05n

.meas tran vdout1_117ck1710 FIND v(dout1_117) AT=1720.05n

.meas tran vdout1_118ck1710 FIND v(dout1_118) AT=1720.05n

.meas tran vdout1_119ck1710 FIND v(dout1_119) AT=1720.05n

.meas tran vdout1_120ck1710 FIND v(dout1_120) AT=1720.05n

.meas tran vdout1_121ck1710 FIND v(dout1_121) AT=1720.05n

.meas tran vdout1_122ck1710 FIND v(dout1_122) AT=1720.05n

.meas tran vdout1_123ck1710 FIND v(dout1_123) AT=1720.05n

.meas tran vdout1_124ck1710 FIND v(dout1_124) AT=1720.05n

.meas tran vdout1_125ck1710 FIND v(dout1_125) AT=1720.05n

.meas tran vdout1_126ck1710 FIND v(dout1_126) AT=1720.05n

.meas tran vdout1_127ck1710 FIND v(dout1_127) AT=1720.05n

.meas tran vdout1_128ck1710 FIND v(dout1_128) AT=1720.05n

.meas tran vdout1_129ck1710 FIND v(dout1_129) AT=1720.05n

.meas tran vdout1_130ck1710 FIND v(dout1_130) AT=1720.05n

.meas tran vdout1_131ck1710 FIND v(dout1_131) AT=1720.05n

.meas tran vdout1_132ck1710 FIND v(dout1_132) AT=1720.05n

.meas tran vdout1_133ck1710 FIND v(dout1_133) AT=1720.05n

.meas tran vdout1_134ck1710 FIND v(dout1_134) AT=1720.05n

.meas tran vdout1_135ck1710 FIND v(dout1_135) AT=1720.05n

.meas tran vdout1_136ck1710 FIND v(dout1_136) AT=1720.05n

.meas tran vdout1_137ck1710 FIND v(dout1_137) AT=1720.05n

.meas tran vdout1_138ck1710 FIND v(dout1_138) AT=1720.05n

.meas tran vdout1_139ck1710 FIND v(dout1_139) AT=1720.05n

.meas tran vdout1_140ck1710 FIND v(dout1_140) AT=1720.05n

.meas tran vdout1_141ck1710 FIND v(dout1_141) AT=1720.05n

.meas tran vdout1_142ck1710 FIND v(dout1_142) AT=1720.05n

.meas tran vdout1_143ck1710 FIND v(dout1_143) AT=1720.05n

.meas tran vdout1_144ck1710 FIND v(dout1_144) AT=1720.05n

.meas tran vdout1_145ck1710 FIND v(dout1_145) AT=1720.05n

.meas tran vdout1_146ck1710 FIND v(dout1_146) AT=1720.05n

.meas tran vdout1_147ck1710 FIND v(dout1_147) AT=1720.05n

.meas tran vdout1_148ck1710 FIND v(dout1_148) AT=1720.05n

.meas tran vdout1_149ck1710 FIND v(dout1_149) AT=1720.05n

.meas tran vdout1_150ck1710 FIND v(dout1_150) AT=1720.05n

.meas tran vdout1_151ck1710 FIND v(dout1_151) AT=1720.05n

.meas tran vdout1_152ck1710 FIND v(dout1_152) AT=1720.05n

.meas tran vdout1_153ck1710 FIND v(dout1_153) AT=1720.05n

.meas tran vdout1_154ck1710 FIND v(dout1_154) AT=1720.05n

.meas tran vdout1_155ck1710 FIND v(dout1_155) AT=1720.05n

.meas tran vdout1_156ck1710 FIND v(dout1_156) AT=1720.05n

.meas tran vdout1_157ck1710 FIND v(dout1_157) AT=1720.05n

.meas tran vdout1_158ck1710 FIND v(dout1_158) AT=1720.05n

.meas tran vdout1_159ck1710 FIND v(dout1_159) AT=1720.05n

.meas tran vdout1_160ck1710 FIND v(dout1_160) AT=1720.05n

.meas tran vdout1_161ck1710 FIND v(dout1_161) AT=1720.05n

.meas tran vdout1_162ck1710 FIND v(dout1_162) AT=1720.05n

.meas tran vdout1_163ck1710 FIND v(dout1_163) AT=1720.05n

.meas tran vdout1_164ck1710 FIND v(dout1_164) AT=1720.05n

.meas tran vdout1_165ck1710 FIND v(dout1_165) AT=1720.05n

.meas tran vdout1_166ck1710 FIND v(dout1_166) AT=1720.05n

.meas tran vdout1_167ck1710 FIND v(dout1_167) AT=1720.05n

.meas tran vdout1_168ck1710 FIND v(dout1_168) AT=1720.05n

.meas tran vdout1_169ck1710 FIND v(dout1_169) AT=1720.05n

.meas tran vdout1_170ck1710 FIND v(dout1_170) AT=1720.05n

.meas tran vdout1_171ck1710 FIND v(dout1_171) AT=1720.05n

.meas tran vdout1_172ck1710 FIND v(dout1_172) AT=1720.05n

.meas tran vdout1_173ck1710 FIND v(dout1_173) AT=1720.05n

.meas tran vdout1_174ck1710 FIND v(dout1_174) AT=1720.05n

.meas tran vdout1_175ck1710 FIND v(dout1_175) AT=1720.05n

.meas tran vdout1_176ck1710 FIND v(dout1_176) AT=1720.05n

.meas tran vdout1_177ck1710 FIND v(dout1_177) AT=1720.05n

.meas tran vdout1_178ck1710 FIND v(dout1_178) AT=1720.05n

.meas tran vdout1_179ck1710 FIND v(dout1_179) AT=1720.05n

.meas tran vdout1_180ck1710 FIND v(dout1_180) AT=1720.05n

.meas tran vdout1_181ck1710 FIND v(dout1_181) AT=1720.05n

.meas tran vdout1_182ck1710 FIND v(dout1_182) AT=1720.05n

.meas tran vdout1_183ck1710 FIND v(dout1_183) AT=1720.05n

.meas tran vdout1_184ck1710 FIND v(dout1_184) AT=1720.05n

.meas tran vdout1_185ck1710 FIND v(dout1_185) AT=1720.05n

.meas tran vdout1_186ck1710 FIND v(dout1_186) AT=1720.05n

.meas tran vdout1_187ck1710 FIND v(dout1_187) AT=1720.05n

.meas tran vdout1_188ck1710 FIND v(dout1_188) AT=1720.05n

.meas tran vdout1_189ck1710 FIND v(dout1_189) AT=1720.05n

.meas tran vdout1_190ck1710 FIND v(dout1_190) AT=1720.05n

.meas tran vdout1_191ck1710 FIND v(dout1_191) AT=1720.05n

.meas tran vdout1_192ck1710 FIND v(dout1_192) AT=1720.05n

.meas tran vdout1_193ck1710 FIND v(dout1_193) AT=1720.05n

.meas tran vdout1_194ck1710 FIND v(dout1_194) AT=1720.05n

.meas tran vdout1_195ck1710 FIND v(dout1_195) AT=1720.05n

.meas tran vdout1_196ck1710 FIND v(dout1_196) AT=1720.05n

.meas tran vdout1_197ck1710 FIND v(dout1_197) AT=1720.05n

.meas tran vdout1_198ck1710 FIND v(dout1_198) AT=1720.05n

.meas tran vdout1_199ck1710 FIND v(dout1_199) AT=1720.05n

.meas tran vdout1_200ck1710 FIND v(dout1_200) AT=1720.05n

.meas tran vdout1_201ck1710 FIND v(dout1_201) AT=1720.05n

.meas tran vdout1_202ck1710 FIND v(dout1_202) AT=1720.05n

.meas tran vdout1_203ck1710 FIND v(dout1_203) AT=1720.05n

.meas tran vdout1_204ck1710 FIND v(dout1_204) AT=1720.05n

.meas tran vdout1_205ck1710 FIND v(dout1_205) AT=1720.05n

.meas tran vdout1_206ck1710 FIND v(dout1_206) AT=1720.05n

.meas tran vdout1_207ck1710 FIND v(dout1_207) AT=1720.05n

.meas tran vdout1_208ck1710 FIND v(dout1_208) AT=1720.05n

.meas tran vdout1_209ck1710 FIND v(dout1_209) AT=1720.05n

.meas tran vdout1_210ck1710 FIND v(dout1_210) AT=1720.05n

.meas tran vdout1_211ck1710 FIND v(dout1_211) AT=1720.05n

.meas tran vdout1_212ck1710 FIND v(dout1_212) AT=1720.05n

.meas tran vdout1_213ck1710 FIND v(dout1_213) AT=1720.05n

.meas tran vdout1_214ck1710 FIND v(dout1_214) AT=1720.05n

.meas tran vdout1_215ck1710 FIND v(dout1_215) AT=1720.05n

.meas tran vdout1_216ck1710 FIND v(dout1_216) AT=1720.05n

.meas tran vdout1_217ck1710 FIND v(dout1_217) AT=1720.05n

.meas tran vdout1_218ck1710 FIND v(dout1_218) AT=1720.05n

.meas tran vdout1_219ck1710 FIND v(dout1_219) AT=1720.05n

.meas tran vdout1_220ck1710 FIND v(dout1_220) AT=1720.05n

.meas tran vdout1_221ck1710 FIND v(dout1_221) AT=1720.05n

.meas tran vdout1_222ck1710 FIND v(dout1_222) AT=1720.05n

.meas tran vdout1_223ck1710 FIND v(dout1_223) AT=1720.05n

.meas tran vdout1_224ck1710 FIND v(dout1_224) AT=1720.05n

.meas tran vdout1_225ck1710 FIND v(dout1_225) AT=1720.05n

.meas tran vdout1_226ck1710 FIND v(dout1_226) AT=1720.05n

.meas tran vdout1_227ck1710 FIND v(dout1_227) AT=1720.05n

.meas tran vdout1_228ck1710 FIND v(dout1_228) AT=1720.05n

.meas tran vdout1_229ck1710 FIND v(dout1_229) AT=1720.05n

.meas tran vdout1_230ck1710 FIND v(dout1_230) AT=1720.05n

.meas tran vdout1_231ck1710 FIND v(dout1_231) AT=1720.05n

.meas tran vdout1_232ck1710 FIND v(dout1_232) AT=1720.05n

.meas tran vdout1_233ck1710 FIND v(dout1_233) AT=1720.05n

.meas tran vdout1_234ck1710 FIND v(dout1_234) AT=1720.05n

.meas tran vdout1_235ck1710 FIND v(dout1_235) AT=1720.05n

.meas tran vdout1_236ck1710 FIND v(dout1_236) AT=1720.05n

.meas tran vdout1_237ck1710 FIND v(dout1_237) AT=1720.05n

.meas tran vdout1_238ck1710 FIND v(dout1_238) AT=1720.05n

.meas tran vdout1_239ck1710 FIND v(dout1_239) AT=1720.05n

.meas tran vdout1_240ck1710 FIND v(dout1_240) AT=1720.05n

.meas tran vdout1_241ck1710 FIND v(dout1_241) AT=1720.05n

.meas tran vdout1_242ck1710 FIND v(dout1_242) AT=1720.05n

.meas tran vdout1_243ck1710 FIND v(dout1_243) AT=1720.05n

.meas tran vdout1_244ck1710 FIND v(dout1_244) AT=1720.05n

.meas tran vdout1_245ck1710 FIND v(dout1_245) AT=1720.05n

.meas tran vdout1_246ck1710 FIND v(dout1_246) AT=1720.05n

.meas tran vdout1_247ck1710 FIND v(dout1_247) AT=1720.05n

.meas tran vdout1_248ck1710 FIND v(dout1_248) AT=1720.05n

.meas tran vdout1_249ck1710 FIND v(dout1_249) AT=1720.05n

.meas tran vdout1_250ck1710 FIND v(dout1_250) AT=1720.05n

.meas tran vdout1_251ck1710 FIND v(dout1_251) AT=1720.05n

.meas tran vdout1_252ck1710 FIND v(dout1_252) AT=1720.05n

.meas tran vdout1_253ck1710 FIND v(dout1_253) AT=1720.05n

.meas tran vdout1_254ck1710 FIND v(dout1_254) AT=1720.05n

.meas tran vdout1_255ck1710 FIND v(dout1_255) AT=1720.05n

.meas tran vdout1_256ck1710 FIND v(dout1_256) AT=1720.05n

.meas tran vdout1_0ck1790 FIND v(dout1_0) AT=1800.05n

.meas tran vdout1_1ck1790 FIND v(dout1_1) AT=1800.05n

.meas tran vdout1_2ck1790 FIND v(dout1_2) AT=1800.05n

.meas tran vdout1_3ck1790 FIND v(dout1_3) AT=1800.05n

.meas tran vdout1_4ck1790 FIND v(dout1_4) AT=1800.05n

.meas tran vdout1_5ck1790 FIND v(dout1_5) AT=1800.05n

.meas tran vdout1_6ck1790 FIND v(dout1_6) AT=1800.05n

.meas tran vdout1_7ck1790 FIND v(dout1_7) AT=1800.05n

.meas tran vdout1_8ck1790 FIND v(dout1_8) AT=1800.05n

.meas tran vdout1_9ck1790 FIND v(dout1_9) AT=1800.05n

.meas tran vdout1_10ck1790 FIND v(dout1_10) AT=1800.05n

.meas tran vdout1_11ck1790 FIND v(dout1_11) AT=1800.05n

.meas tran vdout1_12ck1790 FIND v(dout1_12) AT=1800.05n

.meas tran vdout1_13ck1790 FIND v(dout1_13) AT=1800.05n

.meas tran vdout1_14ck1790 FIND v(dout1_14) AT=1800.05n

.meas tran vdout1_15ck1790 FIND v(dout1_15) AT=1800.05n

.meas tran vdout1_16ck1790 FIND v(dout1_16) AT=1800.05n

.meas tran vdout1_17ck1790 FIND v(dout1_17) AT=1800.05n

.meas tran vdout1_18ck1790 FIND v(dout1_18) AT=1800.05n

.meas tran vdout1_19ck1790 FIND v(dout1_19) AT=1800.05n

.meas tran vdout1_20ck1790 FIND v(dout1_20) AT=1800.05n

.meas tran vdout1_21ck1790 FIND v(dout1_21) AT=1800.05n

.meas tran vdout1_22ck1790 FIND v(dout1_22) AT=1800.05n

.meas tran vdout1_23ck1790 FIND v(dout1_23) AT=1800.05n

.meas tran vdout1_24ck1790 FIND v(dout1_24) AT=1800.05n

.meas tran vdout1_25ck1790 FIND v(dout1_25) AT=1800.05n

.meas tran vdout1_26ck1790 FIND v(dout1_26) AT=1800.05n

.meas tran vdout1_27ck1790 FIND v(dout1_27) AT=1800.05n

.meas tran vdout1_28ck1790 FIND v(dout1_28) AT=1800.05n

.meas tran vdout1_29ck1790 FIND v(dout1_29) AT=1800.05n

.meas tran vdout1_30ck1790 FIND v(dout1_30) AT=1800.05n

.meas tran vdout1_31ck1790 FIND v(dout1_31) AT=1800.05n

.meas tran vdout1_32ck1790 FIND v(dout1_32) AT=1800.05n

.meas tran vdout1_33ck1790 FIND v(dout1_33) AT=1800.05n

.meas tran vdout1_34ck1790 FIND v(dout1_34) AT=1800.05n

.meas tran vdout1_35ck1790 FIND v(dout1_35) AT=1800.05n

.meas tran vdout1_36ck1790 FIND v(dout1_36) AT=1800.05n

.meas tran vdout1_37ck1790 FIND v(dout1_37) AT=1800.05n

.meas tran vdout1_38ck1790 FIND v(dout1_38) AT=1800.05n

.meas tran vdout1_39ck1790 FIND v(dout1_39) AT=1800.05n

.meas tran vdout1_40ck1790 FIND v(dout1_40) AT=1800.05n

.meas tran vdout1_41ck1790 FIND v(dout1_41) AT=1800.05n

.meas tran vdout1_42ck1790 FIND v(dout1_42) AT=1800.05n

.meas tran vdout1_43ck1790 FIND v(dout1_43) AT=1800.05n

.meas tran vdout1_44ck1790 FIND v(dout1_44) AT=1800.05n

.meas tran vdout1_45ck1790 FIND v(dout1_45) AT=1800.05n

.meas tran vdout1_46ck1790 FIND v(dout1_46) AT=1800.05n

.meas tran vdout1_47ck1790 FIND v(dout1_47) AT=1800.05n

.meas tran vdout1_48ck1790 FIND v(dout1_48) AT=1800.05n

.meas tran vdout1_49ck1790 FIND v(dout1_49) AT=1800.05n

.meas tran vdout1_50ck1790 FIND v(dout1_50) AT=1800.05n

.meas tran vdout1_51ck1790 FIND v(dout1_51) AT=1800.05n

.meas tran vdout1_52ck1790 FIND v(dout1_52) AT=1800.05n

.meas tran vdout1_53ck1790 FIND v(dout1_53) AT=1800.05n

.meas tran vdout1_54ck1790 FIND v(dout1_54) AT=1800.05n

.meas tran vdout1_55ck1790 FIND v(dout1_55) AT=1800.05n

.meas tran vdout1_56ck1790 FIND v(dout1_56) AT=1800.05n

.meas tran vdout1_57ck1790 FIND v(dout1_57) AT=1800.05n

.meas tran vdout1_58ck1790 FIND v(dout1_58) AT=1800.05n

.meas tran vdout1_59ck1790 FIND v(dout1_59) AT=1800.05n

.meas tran vdout1_60ck1790 FIND v(dout1_60) AT=1800.05n

.meas tran vdout1_61ck1790 FIND v(dout1_61) AT=1800.05n

.meas tran vdout1_62ck1790 FIND v(dout1_62) AT=1800.05n

.meas tran vdout1_63ck1790 FIND v(dout1_63) AT=1800.05n

.meas tran vdout1_64ck1790 FIND v(dout1_64) AT=1800.05n

.meas tran vdout1_65ck1790 FIND v(dout1_65) AT=1800.05n

.meas tran vdout1_66ck1790 FIND v(dout1_66) AT=1800.05n

.meas tran vdout1_67ck1790 FIND v(dout1_67) AT=1800.05n

.meas tran vdout1_68ck1790 FIND v(dout1_68) AT=1800.05n

.meas tran vdout1_69ck1790 FIND v(dout1_69) AT=1800.05n

.meas tran vdout1_70ck1790 FIND v(dout1_70) AT=1800.05n

.meas tran vdout1_71ck1790 FIND v(dout1_71) AT=1800.05n

.meas tran vdout1_72ck1790 FIND v(dout1_72) AT=1800.05n

.meas tran vdout1_73ck1790 FIND v(dout1_73) AT=1800.05n

.meas tran vdout1_74ck1790 FIND v(dout1_74) AT=1800.05n

.meas tran vdout1_75ck1790 FIND v(dout1_75) AT=1800.05n

.meas tran vdout1_76ck1790 FIND v(dout1_76) AT=1800.05n

.meas tran vdout1_77ck1790 FIND v(dout1_77) AT=1800.05n

.meas tran vdout1_78ck1790 FIND v(dout1_78) AT=1800.05n

.meas tran vdout1_79ck1790 FIND v(dout1_79) AT=1800.05n

.meas tran vdout1_80ck1790 FIND v(dout1_80) AT=1800.05n

.meas tran vdout1_81ck1790 FIND v(dout1_81) AT=1800.05n

.meas tran vdout1_82ck1790 FIND v(dout1_82) AT=1800.05n

.meas tran vdout1_83ck1790 FIND v(dout1_83) AT=1800.05n

.meas tran vdout1_84ck1790 FIND v(dout1_84) AT=1800.05n

.meas tran vdout1_85ck1790 FIND v(dout1_85) AT=1800.05n

.meas tran vdout1_86ck1790 FIND v(dout1_86) AT=1800.05n

.meas tran vdout1_87ck1790 FIND v(dout1_87) AT=1800.05n

.meas tran vdout1_88ck1790 FIND v(dout1_88) AT=1800.05n

.meas tran vdout1_89ck1790 FIND v(dout1_89) AT=1800.05n

.meas tran vdout1_90ck1790 FIND v(dout1_90) AT=1800.05n

.meas tran vdout1_91ck1790 FIND v(dout1_91) AT=1800.05n

.meas tran vdout1_92ck1790 FIND v(dout1_92) AT=1800.05n

.meas tran vdout1_93ck1790 FIND v(dout1_93) AT=1800.05n

.meas tran vdout1_94ck1790 FIND v(dout1_94) AT=1800.05n

.meas tran vdout1_95ck1790 FIND v(dout1_95) AT=1800.05n

.meas tran vdout1_96ck1790 FIND v(dout1_96) AT=1800.05n

.meas tran vdout1_97ck1790 FIND v(dout1_97) AT=1800.05n

.meas tran vdout1_98ck1790 FIND v(dout1_98) AT=1800.05n

.meas tran vdout1_99ck1790 FIND v(dout1_99) AT=1800.05n

.meas tran vdout1_100ck1790 FIND v(dout1_100) AT=1800.05n

.meas tran vdout1_101ck1790 FIND v(dout1_101) AT=1800.05n

.meas tran vdout1_102ck1790 FIND v(dout1_102) AT=1800.05n

.meas tran vdout1_103ck1790 FIND v(dout1_103) AT=1800.05n

.meas tran vdout1_104ck1790 FIND v(dout1_104) AT=1800.05n

.meas tran vdout1_105ck1790 FIND v(dout1_105) AT=1800.05n

.meas tran vdout1_106ck1790 FIND v(dout1_106) AT=1800.05n

.meas tran vdout1_107ck1790 FIND v(dout1_107) AT=1800.05n

.meas tran vdout1_108ck1790 FIND v(dout1_108) AT=1800.05n

.meas tran vdout1_109ck1790 FIND v(dout1_109) AT=1800.05n

.meas tran vdout1_110ck1790 FIND v(dout1_110) AT=1800.05n

.meas tran vdout1_111ck1790 FIND v(dout1_111) AT=1800.05n

.meas tran vdout1_112ck1790 FIND v(dout1_112) AT=1800.05n

.meas tran vdout1_113ck1790 FIND v(dout1_113) AT=1800.05n

.meas tran vdout1_114ck1790 FIND v(dout1_114) AT=1800.05n

.meas tran vdout1_115ck1790 FIND v(dout1_115) AT=1800.05n

.meas tran vdout1_116ck1790 FIND v(dout1_116) AT=1800.05n

.meas tran vdout1_117ck1790 FIND v(dout1_117) AT=1800.05n

.meas tran vdout1_118ck1790 FIND v(dout1_118) AT=1800.05n

.meas tran vdout1_119ck1790 FIND v(dout1_119) AT=1800.05n

.meas tran vdout1_120ck1790 FIND v(dout1_120) AT=1800.05n

.meas tran vdout1_121ck1790 FIND v(dout1_121) AT=1800.05n

.meas tran vdout1_122ck1790 FIND v(dout1_122) AT=1800.05n

.meas tran vdout1_123ck1790 FIND v(dout1_123) AT=1800.05n

.meas tran vdout1_124ck1790 FIND v(dout1_124) AT=1800.05n

.meas tran vdout1_125ck1790 FIND v(dout1_125) AT=1800.05n

.meas tran vdout1_126ck1790 FIND v(dout1_126) AT=1800.05n

.meas tran vdout1_127ck1790 FIND v(dout1_127) AT=1800.05n

.meas tran vdout1_128ck1790 FIND v(dout1_128) AT=1800.05n

.meas tran vdout1_129ck1790 FIND v(dout1_129) AT=1800.05n

.meas tran vdout1_130ck1790 FIND v(dout1_130) AT=1800.05n

.meas tran vdout1_131ck1790 FIND v(dout1_131) AT=1800.05n

.meas tran vdout1_132ck1790 FIND v(dout1_132) AT=1800.05n

.meas tran vdout1_133ck1790 FIND v(dout1_133) AT=1800.05n

.meas tran vdout1_134ck1790 FIND v(dout1_134) AT=1800.05n

.meas tran vdout1_135ck1790 FIND v(dout1_135) AT=1800.05n

.meas tran vdout1_136ck1790 FIND v(dout1_136) AT=1800.05n

.meas tran vdout1_137ck1790 FIND v(dout1_137) AT=1800.05n

.meas tran vdout1_138ck1790 FIND v(dout1_138) AT=1800.05n

.meas tran vdout1_139ck1790 FIND v(dout1_139) AT=1800.05n

.meas tran vdout1_140ck1790 FIND v(dout1_140) AT=1800.05n

.meas tran vdout1_141ck1790 FIND v(dout1_141) AT=1800.05n

.meas tran vdout1_142ck1790 FIND v(dout1_142) AT=1800.05n

.meas tran vdout1_143ck1790 FIND v(dout1_143) AT=1800.05n

.meas tran vdout1_144ck1790 FIND v(dout1_144) AT=1800.05n

.meas tran vdout1_145ck1790 FIND v(dout1_145) AT=1800.05n

.meas tran vdout1_146ck1790 FIND v(dout1_146) AT=1800.05n

.meas tran vdout1_147ck1790 FIND v(dout1_147) AT=1800.05n

.meas tran vdout1_148ck1790 FIND v(dout1_148) AT=1800.05n

.meas tran vdout1_149ck1790 FIND v(dout1_149) AT=1800.05n

.meas tran vdout1_150ck1790 FIND v(dout1_150) AT=1800.05n

.meas tran vdout1_151ck1790 FIND v(dout1_151) AT=1800.05n

.meas tran vdout1_152ck1790 FIND v(dout1_152) AT=1800.05n

.meas tran vdout1_153ck1790 FIND v(dout1_153) AT=1800.05n

.meas tran vdout1_154ck1790 FIND v(dout1_154) AT=1800.05n

.meas tran vdout1_155ck1790 FIND v(dout1_155) AT=1800.05n

.meas tran vdout1_156ck1790 FIND v(dout1_156) AT=1800.05n

.meas tran vdout1_157ck1790 FIND v(dout1_157) AT=1800.05n

.meas tran vdout1_158ck1790 FIND v(dout1_158) AT=1800.05n

.meas tran vdout1_159ck1790 FIND v(dout1_159) AT=1800.05n

.meas tran vdout1_160ck1790 FIND v(dout1_160) AT=1800.05n

.meas tran vdout1_161ck1790 FIND v(dout1_161) AT=1800.05n

.meas tran vdout1_162ck1790 FIND v(dout1_162) AT=1800.05n

.meas tran vdout1_163ck1790 FIND v(dout1_163) AT=1800.05n

.meas tran vdout1_164ck1790 FIND v(dout1_164) AT=1800.05n

.meas tran vdout1_165ck1790 FIND v(dout1_165) AT=1800.05n

.meas tran vdout1_166ck1790 FIND v(dout1_166) AT=1800.05n

.meas tran vdout1_167ck1790 FIND v(dout1_167) AT=1800.05n

.meas tran vdout1_168ck1790 FIND v(dout1_168) AT=1800.05n

.meas tran vdout1_169ck1790 FIND v(dout1_169) AT=1800.05n

.meas tran vdout1_170ck1790 FIND v(dout1_170) AT=1800.05n

.meas tran vdout1_171ck1790 FIND v(dout1_171) AT=1800.05n

.meas tran vdout1_172ck1790 FIND v(dout1_172) AT=1800.05n

.meas tran vdout1_173ck1790 FIND v(dout1_173) AT=1800.05n

.meas tran vdout1_174ck1790 FIND v(dout1_174) AT=1800.05n

.meas tran vdout1_175ck1790 FIND v(dout1_175) AT=1800.05n

.meas tran vdout1_176ck1790 FIND v(dout1_176) AT=1800.05n

.meas tran vdout1_177ck1790 FIND v(dout1_177) AT=1800.05n

.meas tran vdout1_178ck1790 FIND v(dout1_178) AT=1800.05n

.meas tran vdout1_179ck1790 FIND v(dout1_179) AT=1800.05n

.meas tran vdout1_180ck1790 FIND v(dout1_180) AT=1800.05n

.meas tran vdout1_181ck1790 FIND v(dout1_181) AT=1800.05n

.meas tran vdout1_182ck1790 FIND v(dout1_182) AT=1800.05n

.meas tran vdout1_183ck1790 FIND v(dout1_183) AT=1800.05n

.meas tran vdout1_184ck1790 FIND v(dout1_184) AT=1800.05n

.meas tran vdout1_185ck1790 FIND v(dout1_185) AT=1800.05n

.meas tran vdout1_186ck1790 FIND v(dout1_186) AT=1800.05n

.meas tran vdout1_187ck1790 FIND v(dout1_187) AT=1800.05n

.meas tran vdout1_188ck1790 FIND v(dout1_188) AT=1800.05n

.meas tran vdout1_189ck1790 FIND v(dout1_189) AT=1800.05n

.meas tran vdout1_190ck1790 FIND v(dout1_190) AT=1800.05n

.meas tran vdout1_191ck1790 FIND v(dout1_191) AT=1800.05n

.meas tran vdout1_192ck1790 FIND v(dout1_192) AT=1800.05n

.meas tran vdout1_193ck1790 FIND v(dout1_193) AT=1800.05n

.meas tran vdout1_194ck1790 FIND v(dout1_194) AT=1800.05n

.meas tran vdout1_195ck1790 FIND v(dout1_195) AT=1800.05n

.meas tran vdout1_196ck1790 FIND v(dout1_196) AT=1800.05n

.meas tran vdout1_197ck1790 FIND v(dout1_197) AT=1800.05n

.meas tran vdout1_198ck1790 FIND v(dout1_198) AT=1800.05n

.meas tran vdout1_199ck1790 FIND v(dout1_199) AT=1800.05n

.meas tran vdout1_200ck1790 FIND v(dout1_200) AT=1800.05n

.meas tran vdout1_201ck1790 FIND v(dout1_201) AT=1800.05n

.meas tran vdout1_202ck1790 FIND v(dout1_202) AT=1800.05n

.meas tran vdout1_203ck1790 FIND v(dout1_203) AT=1800.05n

.meas tran vdout1_204ck1790 FIND v(dout1_204) AT=1800.05n

.meas tran vdout1_205ck1790 FIND v(dout1_205) AT=1800.05n

.meas tran vdout1_206ck1790 FIND v(dout1_206) AT=1800.05n

.meas tran vdout1_207ck1790 FIND v(dout1_207) AT=1800.05n

.meas tran vdout1_208ck1790 FIND v(dout1_208) AT=1800.05n

.meas tran vdout1_209ck1790 FIND v(dout1_209) AT=1800.05n

.meas tran vdout1_210ck1790 FIND v(dout1_210) AT=1800.05n

.meas tran vdout1_211ck1790 FIND v(dout1_211) AT=1800.05n

.meas tran vdout1_212ck1790 FIND v(dout1_212) AT=1800.05n

.meas tran vdout1_213ck1790 FIND v(dout1_213) AT=1800.05n

.meas tran vdout1_214ck1790 FIND v(dout1_214) AT=1800.05n

.meas tran vdout1_215ck1790 FIND v(dout1_215) AT=1800.05n

.meas tran vdout1_216ck1790 FIND v(dout1_216) AT=1800.05n

.meas tran vdout1_217ck1790 FIND v(dout1_217) AT=1800.05n

.meas tran vdout1_218ck1790 FIND v(dout1_218) AT=1800.05n

.meas tran vdout1_219ck1790 FIND v(dout1_219) AT=1800.05n

.meas tran vdout1_220ck1790 FIND v(dout1_220) AT=1800.05n

.meas tran vdout1_221ck1790 FIND v(dout1_221) AT=1800.05n

.meas tran vdout1_222ck1790 FIND v(dout1_222) AT=1800.05n

.meas tran vdout1_223ck1790 FIND v(dout1_223) AT=1800.05n

.meas tran vdout1_224ck1790 FIND v(dout1_224) AT=1800.05n

.meas tran vdout1_225ck1790 FIND v(dout1_225) AT=1800.05n

.meas tran vdout1_226ck1790 FIND v(dout1_226) AT=1800.05n

.meas tran vdout1_227ck1790 FIND v(dout1_227) AT=1800.05n

.meas tran vdout1_228ck1790 FIND v(dout1_228) AT=1800.05n

.meas tran vdout1_229ck1790 FIND v(dout1_229) AT=1800.05n

.meas tran vdout1_230ck1790 FIND v(dout1_230) AT=1800.05n

.meas tran vdout1_231ck1790 FIND v(dout1_231) AT=1800.05n

.meas tran vdout1_232ck1790 FIND v(dout1_232) AT=1800.05n

.meas tran vdout1_233ck1790 FIND v(dout1_233) AT=1800.05n

.meas tran vdout1_234ck1790 FIND v(dout1_234) AT=1800.05n

.meas tran vdout1_235ck1790 FIND v(dout1_235) AT=1800.05n

.meas tran vdout1_236ck1790 FIND v(dout1_236) AT=1800.05n

.meas tran vdout1_237ck1790 FIND v(dout1_237) AT=1800.05n

.meas tran vdout1_238ck1790 FIND v(dout1_238) AT=1800.05n

.meas tran vdout1_239ck1790 FIND v(dout1_239) AT=1800.05n

.meas tran vdout1_240ck1790 FIND v(dout1_240) AT=1800.05n

.meas tran vdout1_241ck1790 FIND v(dout1_241) AT=1800.05n

.meas tran vdout1_242ck1790 FIND v(dout1_242) AT=1800.05n

.meas tran vdout1_243ck1790 FIND v(dout1_243) AT=1800.05n

.meas tran vdout1_244ck1790 FIND v(dout1_244) AT=1800.05n

.meas tran vdout1_245ck1790 FIND v(dout1_245) AT=1800.05n

.meas tran vdout1_246ck1790 FIND v(dout1_246) AT=1800.05n

.meas tran vdout1_247ck1790 FIND v(dout1_247) AT=1800.05n

.meas tran vdout1_248ck1790 FIND v(dout1_248) AT=1800.05n

.meas tran vdout1_249ck1790 FIND v(dout1_249) AT=1800.05n

.meas tran vdout1_250ck1790 FIND v(dout1_250) AT=1800.05n

.meas tran vdout1_251ck1790 FIND v(dout1_251) AT=1800.05n

.meas tran vdout1_252ck1790 FIND v(dout1_252) AT=1800.05n

.meas tran vdout1_253ck1790 FIND v(dout1_253) AT=1800.05n

.meas tran vdout1_254ck1790 FIND v(dout1_254) AT=1800.05n

.meas tran vdout1_255ck1790 FIND v(dout1_255) AT=1800.05n

.meas tran vdout1_256ck1790 FIND v(dout1_256) AT=1800.05n

.meas tran vdout1_0ck1860 FIND v(dout1_0) AT=1870.05n

.meas tran vdout1_1ck1860 FIND v(dout1_1) AT=1870.05n

.meas tran vdout1_2ck1860 FIND v(dout1_2) AT=1870.05n

.meas tran vdout1_3ck1860 FIND v(dout1_3) AT=1870.05n

.meas tran vdout1_4ck1860 FIND v(dout1_4) AT=1870.05n

.meas tran vdout1_5ck1860 FIND v(dout1_5) AT=1870.05n

.meas tran vdout1_6ck1860 FIND v(dout1_6) AT=1870.05n

.meas tran vdout1_7ck1860 FIND v(dout1_7) AT=1870.05n

.meas tran vdout1_8ck1860 FIND v(dout1_8) AT=1870.05n

.meas tran vdout1_9ck1860 FIND v(dout1_9) AT=1870.05n

.meas tran vdout1_10ck1860 FIND v(dout1_10) AT=1870.05n

.meas tran vdout1_11ck1860 FIND v(dout1_11) AT=1870.05n

.meas tran vdout1_12ck1860 FIND v(dout1_12) AT=1870.05n

.meas tran vdout1_13ck1860 FIND v(dout1_13) AT=1870.05n

.meas tran vdout1_14ck1860 FIND v(dout1_14) AT=1870.05n

.meas tran vdout1_15ck1860 FIND v(dout1_15) AT=1870.05n

.meas tran vdout1_16ck1860 FIND v(dout1_16) AT=1870.05n

.meas tran vdout1_17ck1860 FIND v(dout1_17) AT=1870.05n

.meas tran vdout1_18ck1860 FIND v(dout1_18) AT=1870.05n

.meas tran vdout1_19ck1860 FIND v(dout1_19) AT=1870.05n

.meas tran vdout1_20ck1860 FIND v(dout1_20) AT=1870.05n

.meas tran vdout1_21ck1860 FIND v(dout1_21) AT=1870.05n

.meas tran vdout1_22ck1860 FIND v(dout1_22) AT=1870.05n

.meas tran vdout1_23ck1860 FIND v(dout1_23) AT=1870.05n

.meas tran vdout1_24ck1860 FIND v(dout1_24) AT=1870.05n

.meas tran vdout1_25ck1860 FIND v(dout1_25) AT=1870.05n

.meas tran vdout1_26ck1860 FIND v(dout1_26) AT=1870.05n

.meas tran vdout1_27ck1860 FIND v(dout1_27) AT=1870.05n

.meas tran vdout1_28ck1860 FIND v(dout1_28) AT=1870.05n

.meas tran vdout1_29ck1860 FIND v(dout1_29) AT=1870.05n

.meas tran vdout1_30ck1860 FIND v(dout1_30) AT=1870.05n

.meas tran vdout1_31ck1860 FIND v(dout1_31) AT=1870.05n

.meas tran vdout1_32ck1860 FIND v(dout1_32) AT=1870.05n

.meas tran vdout1_33ck1860 FIND v(dout1_33) AT=1870.05n

.meas tran vdout1_34ck1860 FIND v(dout1_34) AT=1870.05n

.meas tran vdout1_35ck1860 FIND v(dout1_35) AT=1870.05n

.meas tran vdout1_36ck1860 FIND v(dout1_36) AT=1870.05n

.meas tran vdout1_37ck1860 FIND v(dout1_37) AT=1870.05n

.meas tran vdout1_38ck1860 FIND v(dout1_38) AT=1870.05n

.meas tran vdout1_39ck1860 FIND v(dout1_39) AT=1870.05n

.meas tran vdout1_40ck1860 FIND v(dout1_40) AT=1870.05n

.meas tran vdout1_41ck1860 FIND v(dout1_41) AT=1870.05n

.meas tran vdout1_42ck1860 FIND v(dout1_42) AT=1870.05n

.meas tran vdout1_43ck1860 FIND v(dout1_43) AT=1870.05n

.meas tran vdout1_44ck1860 FIND v(dout1_44) AT=1870.05n

.meas tran vdout1_45ck1860 FIND v(dout1_45) AT=1870.05n

.meas tran vdout1_46ck1860 FIND v(dout1_46) AT=1870.05n

.meas tran vdout1_47ck1860 FIND v(dout1_47) AT=1870.05n

.meas tran vdout1_48ck1860 FIND v(dout1_48) AT=1870.05n

.meas tran vdout1_49ck1860 FIND v(dout1_49) AT=1870.05n

.meas tran vdout1_50ck1860 FIND v(dout1_50) AT=1870.05n

.meas tran vdout1_51ck1860 FIND v(dout1_51) AT=1870.05n

.meas tran vdout1_52ck1860 FIND v(dout1_52) AT=1870.05n

.meas tran vdout1_53ck1860 FIND v(dout1_53) AT=1870.05n

.meas tran vdout1_54ck1860 FIND v(dout1_54) AT=1870.05n

.meas tran vdout1_55ck1860 FIND v(dout1_55) AT=1870.05n

.meas tran vdout1_56ck1860 FIND v(dout1_56) AT=1870.05n

.meas tran vdout1_57ck1860 FIND v(dout1_57) AT=1870.05n

.meas tran vdout1_58ck1860 FIND v(dout1_58) AT=1870.05n

.meas tran vdout1_59ck1860 FIND v(dout1_59) AT=1870.05n

.meas tran vdout1_60ck1860 FIND v(dout1_60) AT=1870.05n

.meas tran vdout1_61ck1860 FIND v(dout1_61) AT=1870.05n

.meas tran vdout1_62ck1860 FIND v(dout1_62) AT=1870.05n

.meas tran vdout1_63ck1860 FIND v(dout1_63) AT=1870.05n

.meas tran vdout1_64ck1860 FIND v(dout1_64) AT=1870.05n

.meas tran vdout1_65ck1860 FIND v(dout1_65) AT=1870.05n

.meas tran vdout1_66ck1860 FIND v(dout1_66) AT=1870.05n

.meas tran vdout1_67ck1860 FIND v(dout1_67) AT=1870.05n

.meas tran vdout1_68ck1860 FIND v(dout1_68) AT=1870.05n

.meas tran vdout1_69ck1860 FIND v(dout1_69) AT=1870.05n

.meas tran vdout1_70ck1860 FIND v(dout1_70) AT=1870.05n

.meas tran vdout1_71ck1860 FIND v(dout1_71) AT=1870.05n

.meas tran vdout1_72ck1860 FIND v(dout1_72) AT=1870.05n

.meas tran vdout1_73ck1860 FIND v(dout1_73) AT=1870.05n

.meas tran vdout1_74ck1860 FIND v(dout1_74) AT=1870.05n

.meas tran vdout1_75ck1860 FIND v(dout1_75) AT=1870.05n

.meas tran vdout1_76ck1860 FIND v(dout1_76) AT=1870.05n

.meas tran vdout1_77ck1860 FIND v(dout1_77) AT=1870.05n

.meas tran vdout1_78ck1860 FIND v(dout1_78) AT=1870.05n

.meas tran vdout1_79ck1860 FIND v(dout1_79) AT=1870.05n

.meas tran vdout1_80ck1860 FIND v(dout1_80) AT=1870.05n

.meas tran vdout1_81ck1860 FIND v(dout1_81) AT=1870.05n

.meas tran vdout1_82ck1860 FIND v(dout1_82) AT=1870.05n

.meas tran vdout1_83ck1860 FIND v(dout1_83) AT=1870.05n

.meas tran vdout1_84ck1860 FIND v(dout1_84) AT=1870.05n

.meas tran vdout1_85ck1860 FIND v(dout1_85) AT=1870.05n

.meas tran vdout1_86ck1860 FIND v(dout1_86) AT=1870.05n

.meas tran vdout1_87ck1860 FIND v(dout1_87) AT=1870.05n

.meas tran vdout1_88ck1860 FIND v(dout1_88) AT=1870.05n

.meas tran vdout1_89ck1860 FIND v(dout1_89) AT=1870.05n

.meas tran vdout1_90ck1860 FIND v(dout1_90) AT=1870.05n

.meas tran vdout1_91ck1860 FIND v(dout1_91) AT=1870.05n

.meas tran vdout1_92ck1860 FIND v(dout1_92) AT=1870.05n

.meas tran vdout1_93ck1860 FIND v(dout1_93) AT=1870.05n

.meas tran vdout1_94ck1860 FIND v(dout1_94) AT=1870.05n

.meas tran vdout1_95ck1860 FIND v(dout1_95) AT=1870.05n

.meas tran vdout1_96ck1860 FIND v(dout1_96) AT=1870.05n

.meas tran vdout1_97ck1860 FIND v(dout1_97) AT=1870.05n

.meas tran vdout1_98ck1860 FIND v(dout1_98) AT=1870.05n

.meas tran vdout1_99ck1860 FIND v(dout1_99) AT=1870.05n

.meas tran vdout1_100ck1860 FIND v(dout1_100) AT=1870.05n

.meas tran vdout1_101ck1860 FIND v(dout1_101) AT=1870.05n

.meas tran vdout1_102ck1860 FIND v(dout1_102) AT=1870.05n

.meas tran vdout1_103ck1860 FIND v(dout1_103) AT=1870.05n

.meas tran vdout1_104ck1860 FIND v(dout1_104) AT=1870.05n

.meas tran vdout1_105ck1860 FIND v(dout1_105) AT=1870.05n

.meas tran vdout1_106ck1860 FIND v(dout1_106) AT=1870.05n

.meas tran vdout1_107ck1860 FIND v(dout1_107) AT=1870.05n

.meas tran vdout1_108ck1860 FIND v(dout1_108) AT=1870.05n

.meas tran vdout1_109ck1860 FIND v(dout1_109) AT=1870.05n

.meas tran vdout1_110ck1860 FIND v(dout1_110) AT=1870.05n

.meas tran vdout1_111ck1860 FIND v(dout1_111) AT=1870.05n

.meas tran vdout1_112ck1860 FIND v(dout1_112) AT=1870.05n

.meas tran vdout1_113ck1860 FIND v(dout1_113) AT=1870.05n

.meas tran vdout1_114ck1860 FIND v(dout1_114) AT=1870.05n

.meas tran vdout1_115ck1860 FIND v(dout1_115) AT=1870.05n

.meas tran vdout1_116ck1860 FIND v(dout1_116) AT=1870.05n

.meas tran vdout1_117ck1860 FIND v(dout1_117) AT=1870.05n

.meas tran vdout1_118ck1860 FIND v(dout1_118) AT=1870.05n

.meas tran vdout1_119ck1860 FIND v(dout1_119) AT=1870.05n

.meas tran vdout1_120ck1860 FIND v(dout1_120) AT=1870.05n

.meas tran vdout1_121ck1860 FIND v(dout1_121) AT=1870.05n

.meas tran vdout1_122ck1860 FIND v(dout1_122) AT=1870.05n

.meas tran vdout1_123ck1860 FIND v(dout1_123) AT=1870.05n

.meas tran vdout1_124ck1860 FIND v(dout1_124) AT=1870.05n

.meas tran vdout1_125ck1860 FIND v(dout1_125) AT=1870.05n

.meas tran vdout1_126ck1860 FIND v(dout1_126) AT=1870.05n

.meas tran vdout1_127ck1860 FIND v(dout1_127) AT=1870.05n

.meas tran vdout1_128ck1860 FIND v(dout1_128) AT=1870.05n

.meas tran vdout1_129ck1860 FIND v(dout1_129) AT=1870.05n

.meas tran vdout1_130ck1860 FIND v(dout1_130) AT=1870.05n

.meas tran vdout1_131ck1860 FIND v(dout1_131) AT=1870.05n

.meas tran vdout1_132ck1860 FIND v(dout1_132) AT=1870.05n

.meas tran vdout1_133ck1860 FIND v(dout1_133) AT=1870.05n

.meas tran vdout1_134ck1860 FIND v(dout1_134) AT=1870.05n

.meas tran vdout1_135ck1860 FIND v(dout1_135) AT=1870.05n

.meas tran vdout1_136ck1860 FIND v(dout1_136) AT=1870.05n

.meas tran vdout1_137ck1860 FIND v(dout1_137) AT=1870.05n

.meas tran vdout1_138ck1860 FIND v(dout1_138) AT=1870.05n

.meas tran vdout1_139ck1860 FIND v(dout1_139) AT=1870.05n

.meas tran vdout1_140ck1860 FIND v(dout1_140) AT=1870.05n

.meas tran vdout1_141ck1860 FIND v(dout1_141) AT=1870.05n

.meas tran vdout1_142ck1860 FIND v(dout1_142) AT=1870.05n

.meas tran vdout1_143ck1860 FIND v(dout1_143) AT=1870.05n

.meas tran vdout1_144ck1860 FIND v(dout1_144) AT=1870.05n

.meas tran vdout1_145ck1860 FIND v(dout1_145) AT=1870.05n

.meas tran vdout1_146ck1860 FIND v(dout1_146) AT=1870.05n

.meas tran vdout1_147ck1860 FIND v(dout1_147) AT=1870.05n

.meas tran vdout1_148ck1860 FIND v(dout1_148) AT=1870.05n

.meas tran vdout1_149ck1860 FIND v(dout1_149) AT=1870.05n

.meas tran vdout1_150ck1860 FIND v(dout1_150) AT=1870.05n

.meas tran vdout1_151ck1860 FIND v(dout1_151) AT=1870.05n

.meas tran vdout1_152ck1860 FIND v(dout1_152) AT=1870.05n

.meas tran vdout1_153ck1860 FIND v(dout1_153) AT=1870.05n

.meas tran vdout1_154ck1860 FIND v(dout1_154) AT=1870.05n

.meas tran vdout1_155ck1860 FIND v(dout1_155) AT=1870.05n

.meas tran vdout1_156ck1860 FIND v(dout1_156) AT=1870.05n

.meas tran vdout1_157ck1860 FIND v(dout1_157) AT=1870.05n

.meas tran vdout1_158ck1860 FIND v(dout1_158) AT=1870.05n

.meas tran vdout1_159ck1860 FIND v(dout1_159) AT=1870.05n

.meas tran vdout1_160ck1860 FIND v(dout1_160) AT=1870.05n

.meas tran vdout1_161ck1860 FIND v(dout1_161) AT=1870.05n

.meas tran vdout1_162ck1860 FIND v(dout1_162) AT=1870.05n

.meas tran vdout1_163ck1860 FIND v(dout1_163) AT=1870.05n

.meas tran vdout1_164ck1860 FIND v(dout1_164) AT=1870.05n

.meas tran vdout1_165ck1860 FIND v(dout1_165) AT=1870.05n

.meas tran vdout1_166ck1860 FIND v(dout1_166) AT=1870.05n

.meas tran vdout1_167ck1860 FIND v(dout1_167) AT=1870.05n

.meas tran vdout1_168ck1860 FIND v(dout1_168) AT=1870.05n

.meas tran vdout1_169ck1860 FIND v(dout1_169) AT=1870.05n

.meas tran vdout1_170ck1860 FIND v(dout1_170) AT=1870.05n

.meas tran vdout1_171ck1860 FIND v(dout1_171) AT=1870.05n

.meas tran vdout1_172ck1860 FIND v(dout1_172) AT=1870.05n

.meas tran vdout1_173ck1860 FIND v(dout1_173) AT=1870.05n

.meas tran vdout1_174ck1860 FIND v(dout1_174) AT=1870.05n

.meas tran vdout1_175ck1860 FIND v(dout1_175) AT=1870.05n

.meas tran vdout1_176ck1860 FIND v(dout1_176) AT=1870.05n

.meas tran vdout1_177ck1860 FIND v(dout1_177) AT=1870.05n

.meas tran vdout1_178ck1860 FIND v(dout1_178) AT=1870.05n

.meas tran vdout1_179ck1860 FIND v(dout1_179) AT=1870.05n

.meas tran vdout1_180ck1860 FIND v(dout1_180) AT=1870.05n

.meas tran vdout1_181ck1860 FIND v(dout1_181) AT=1870.05n

.meas tran vdout1_182ck1860 FIND v(dout1_182) AT=1870.05n

.meas tran vdout1_183ck1860 FIND v(dout1_183) AT=1870.05n

.meas tran vdout1_184ck1860 FIND v(dout1_184) AT=1870.05n

.meas tran vdout1_185ck1860 FIND v(dout1_185) AT=1870.05n

.meas tran vdout1_186ck1860 FIND v(dout1_186) AT=1870.05n

.meas tran vdout1_187ck1860 FIND v(dout1_187) AT=1870.05n

.meas tran vdout1_188ck1860 FIND v(dout1_188) AT=1870.05n

.meas tran vdout1_189ck1860 FIND v(dout1_189) AT=1870.05n

.meas tran vdout1_190ck1860 FIND v(dout1_190) AT=1870.05n

.meas tran vdout1_191ck1860 FIND v(dout1_191) AT=1870.05n

.meas tran vdout1_192ck1860 FIND v(dout1_192) AT=1870.05n

.meas tran vdout1_193ck1860 FIND v(dout1_193) AT=1870.05n

.meas tran vdout1_194ck1860 FIND v(dout1_194) AT=1870.05n

.meas tran vdout1_195ck1860 FIND v(dout1_195) AT=1870.05n

.meas tran vdout1_196ck1860 FIND v(dout1_196) AT=1870.05n

.meas tran vdout1_197ck1860 FIND v(dout1_197) AT=1870.05n

.meas tran vdout1_198ck1860 FIND v(dout1_198) AT=1870.05n

.meas tran vdout1_199ck1860 FIND v(dout1_199) AT=1870.05n

.meas tran vdout1_200ck1860 FIND v(dout1_200) AT=1870.05n

.meas tran vdout1_201ck1860 FIND v(dout1_201) AT=1870.05n

.meas tran vdout1_202ck1860 FIND v(dout1_202) AT=1870.05n

.meas tran vdout1_203ck1860 FIND v(dout1_203) AT=1870.05n

.meas tran vdout1_204ck1860 FIND v(dout1_204) AT=1870.05n

.meas tran vdout1_205ck1860 FIND v(dout1_205) AT=1870.05n

.meas tran vdout1_206ck1860 FIND v(dout1_206) AT=1870.05n

.meas tran vdout1_207ck1860 FIND v(dout1_207) AT=1870.05n

.meas tran vdout1_208ck1860 FIND v(dout1_208) AT=1870.05n

.meas tran vdout1_209ck1860 FIND v(dout1_209) AT=1870.05n

.meas tran vdout1_210ck1860 FIND v(dout1_210) AT=1870.05n

.meas tran vdout1_211ck1860 FIND v(dout1_211) AT=1870.05n

.meas tran vdout1_212ck1860 FIND v(dout1_212) AT=1870.05n

.meas tran vdout1_213ck1860 FIND v(dout1_213) AT=1870.05n

.meas tran vdout1_214ck1860 FIND v(dout1_214) AT=1870.05n

.meas tran vdout1_215ck1860 FIND v(dout1_215) AT=1870.05n

.meas tran vdout1_216ck1860 FIND v(dout1_216) AT=1870.05n

.meas tran vdout1_217ck1860 FIND v(dout1_217) AT=1870.05n

.meas tran vdout1_218ck1860 FIND v(dout1_218) AT=1870.05n

.meas tran vdout1_219ck1860 FIND v(dout1_219) AT=1870.05n

.meas tran vdout1_220ck1860 FIND v(dout1_220) AT=1870.05n

.meas tran vdout1_221ck1860 FIND v(dout1_221) AT=1870.05n

.meas tran vdout1_222ck1860 FIND v(dout1_222) AT=1870.05n

.meas tran vdout1_223ck1860 FIND v(dout1_223) AT=1870.05n

.meas tran vdout1_224ck1860 FIND v(dout1_224) AT=1870.05n

.meas tran vdout1_225ck1860 FIND v(dout1_225) AT=1870.05n

.meas tran vdout1_226ck1860 FIND v(dout1_226) AT=1870.05n

.meas tran vdout1_227ck1860 FIND v(dout1_227) AT=1870.05n

.meas tran vdout1_228ck1860 FIND v(dout1_228) AT=1870.05n

.meas tran vdout1_229ck1860 FIND v(dout1_229) AT=1870.05n

.meas tran vdout1_230ck1860 FIND v(dout1_230) AT=1870.05n

.meas tran vdout1_231ck1860 FIND v(dout1_231) AT=1870.05n

.meas tran vdout1_232ck1860 FIND v(dout1_232) AT=1870.05n

.meas tran vdout1_233ck1860 FIND v(dout1_233) AT=1870.05n

.meas tran vdout1_234ck1860 FIND v(dout1_234) AT=1870.05n

.meas tran vdout1_235ck1860 FIND v(dout1_235) AT=1870.05n

.meas tran vdout1_236ck1860 FIND v(dout1_236) AT=1870.05n

.meas tran vdout1_237ck1860 FIND v(dout1_237) AT=1870.05n

.meas tran vdout1_238ck1860 FIND v(dout1_238) AT=1870.05n

.meas tran vdout1_239ck1860 FIND v(dout1_239) AT=1870.05n

.meas tran vdout1_240ck1860 FIND v(dout1_240) AT=1870.05n

.meas tran vdout1_241ck1860 FIND v(dout1_241) AT=1870.05n

.meas tran vdout1_242ck1860 FIND v(dout1_242) AT=1870.05n

.meas tran vdout1_243ck1860 FIND v(dout1_243) AT=1870.05n

.meas tran vdout1_244ck1860 FIND v(dout1_244) AT=1870.05n

.meas tran vdout1_245ck1860 FIND v(dout1_245) AT=1870.05n

.meas tran vdout1_246ck1860 FIND v(dout1_246) AT=1870.05n

.meas tran vdout1_247ck1860 FIND v(dout1_247) AT=1870.05n

.meas tran vdout1_248ck1860 FIND v(dout1_248) AT=1870.05n

.meas tran vdout1_249ck1860 FIND v(dout1_249) AT=1870.05n

.meas tran vdout1_250ck1860 FIND v(dout1_250) AT=1870.05n

.meas tran vdout1_251ck1860 FIND v(dout1_251) AT=1870.05n

.meas tran vdout1_252ck1860 FIND v(dout1_252) AT=1870.05n

.meas tran vdout1_253ck1860 FIND v(dout1_253) AT=1870.05n

.meas tran vdout1_254ck1860 FIND v(dout1_254) AT=1870.05n

.meas tran vdout1_255ck1860 FIND v(dout1_255) AT=1870.05n

.meas tran vdout1_256ck1860 FIND v(dout1_256) AT=1870.05n

.meas tran vdout1_0ck1870 FIND v(dout1_0) AT=1880.05n

.meas tran vdout1_1ck1870 FIND v(dout1_1) AT=1880.05n

.meas tran vdout1_2ck1870 FIND v(dout1_2) AT=1880.05n

.meas tran vdout1_3ck1870 FIND v(dout1_3) AT=1880.05n

.meas tran vdout1_4ck1870 FIND v(dout1_4) AT=1880.05n

.meas tran vdout1_5ck1870 FIND v(dout1_5) AT=1880.05n

.meas tran vdout1_6ck1870 FIND v(dout1_6) AT=1880.05n

.meas tran vdout1_7ck1870 FIND v(dout1_7) AT=1880.05n

.meas tran vdout1_8ck1870 FIND v(dout1_8) AT=1880.05n

.meas tran vdout1_9ck1870 FIND v(dout1_9) AT=1880.05n

.meas tran vdout1_10ck1870 FIND v(dout1_10) AT=1880.05n

.meas tran vdout1_11ck1870 FIND v(dout1_11) AT=1880.05n

.meas tran vdout1_12ck1870 FIND v(dout1_12) AT=1880.05n

.meas tran vdout1_13ck1870 FIND v(dout1_13) AT=1880.05n

.meas tran vdout1_14ck1870 FIND v(dout1_14) AT=1880.05n

.meas tran vdout1_15ck1870 FIND v(dout1_15) AT=1880.05n

.meas tran vdout1_16ck1870 FIND v(dout1_16) AT=1880.05n

.meas tran vdout1_17ck1870 FIND v(dout1_17) AT=1880.05n

.meas tran vdout1_18ck1870 FIND v(dout1_18) AT=1880.05n

.meas tran vdout1_19ck1870 FIND v(dout1_19) AT=1880.05n

.meas tran vdout1_20ck1870 FIND v(dout1_20) AT=1880.05n

.meas tran vdout1_21ck1870 FIND v(dout1_21) AT=1880.05n

.meas tran vdout1_22ck1870 FIND v(dout1_22) AT=1880.05n

.meas tran vdout1_23ck1870 FIND v(dout1_23) AT=1880.05n

.meas tran vdout1_24ck1870 FIND v(dout1_24) AT=1880.05n

.meas tran vdout1_25ck1870 FIND v(dout1_25) AT=1880.05n

.meas tran vdout1_26ck1870 FIND v(dout1_26) AT=1880.05n

.meas tran vdout1_27ck1870 FIND v(dout1_27) AT=1880.05n

.meas tran vdout1_28ck1870 FIND v(dout1_28) AT=1880.05n

.meas tran vdout1_29ck1870 FIND v(dout1_29) AT=1880.05n

.meas tran vdout1_30ck1870 FIND v(dout1_30) AT=1880.05n

.meas tran vdout1_31ck1870 FIND v(dout1_31) AT=1880.05n

.meas tran vdout1_32ck1870 FIND v(dout1_32) AT=1880.05n

.meas tran vdout1_33ck1870 FIND v(dout1_33) AT=1880.05n

.meas tran vdout1_34ck1870 FIND v(dout1_34) AT=1880.05n

.meas tran vdout1_35ck1870 FIND v(dout1_35) AT=1880.05n

.meas tran vdout1_36ck1870 FIND v(dout1_36) AT=1880.05n

.meas tran vdout1_37ck1870 FIND v(dout1_37) AT=1880.05n

.meas tran vdout1_38ck1870 FIND v(dout1_38) AT=1880.05n

.meas tran vdout1_39ck1870 FIND v(dout1_39) AT=1880.05n

.meas tran vdout1_40ck1870 FIND v(dout1_40) AT=1880.05n

.meas tran vdout1_41ck1870 FIND v(dout1_41) AT=1880.05n

.meas tran vdout1_42ck1870 FIND v(dout1_42) AT=1880.05n

.meas tran vdout1_43ck1870 FIND v(dout1_43) AT=1880.05n

.meas tran vdout1_44ck1870 FIND v(dout1_44) AT=1880.05n

.meas tran vdout1_45ck1870 FIND v(dout1_45) AT=1880.05n

.meas tran vdout1_46ck1870 FIND v(dout1_46) AT=1880.05n

.meas tran vdout1_47ck1870 FIND v(dout1_47) AT=1880.05n

.meas tran vdout1_48ck1870 FIND v(dout1_48) AT=1880.05n

.meas tran vdout1_49ck1870 FIND v(dout1_49) AT=1880.05n

.meas tran vdout1_50ck1870 FIND v(dout1_50) AT=1880.05n

.meas tran vdout1_51ck1870 FIND v(dout1_51) AT=1880.05n

.meas tran vdout1_52ck1870 FIND v(dout1_52) AT=1880.05n

.meas tran vdout1_53ck1870 FIND v(dout1_53) AT=1880.05n

.meas tran vdout1_54ck1870 FIND v(dout1_54) AT=1880.05n

.meas tran vdout1_55ck1870 FIND v(dout1_55) AT=1880.05n

.meas tran vdout1_56ck1870 FIND v(dout1_56) AT=1880.05n

.meas tran vdout1_57ck1870 FIND v(dout1_57) AT=1880.05n

.meas tran vdout1_58ck1870 FIND v(dout1_58) AT=1880.05n

.meas tran vdout1_59ck1870 FIND v(dout1_59) AT=1880.05n

.meas tran vdout1_60ck1870 FIND v(dout1_60) AT=1880.05n

.meas tran vdout1_61ck1870 FIND v(dout1_61) AT=1880.05n

.meas tran vdout1_62ck1870 FIND v(dout1_62) AT=1880.05n

.meas tran vdout1_63ck1870 FIND v(dout1_63) AT=1880.05n

.meas tran vdout1_64ck1870 FIND v(dout1_64) AT=1880.05n

.meas tran vdout1_65ck1870 FIND v(dout1_65) AT=1880.05n

.meas tran vdout1_66ck1870 FIND v(dout1_66) AT=1880.05n

.meas tran vdout1_67ck1870 FIND v(dout1_67) AT=1880.05n

.meas tran vdout1_68ck1870 FIND v(dout1_68) AT=1880.05n

.meas tran vdout1_69ck1870 FIND v(dout1_69) AT=1880.05n

.meas tran vdout1_70ck1870 FIND v(dout1_70) AT=1880.05n

.meas tran vdout1_71ck1870 FIND v(dout1_71) AT=1880.05n

.meas tran vdout1_72ck1870 FIND v(dout1_72) AT=1880.05n

.meas tran vdout1_73ck1870 FIND v(dout1_73) AT=1880.05n

.meas tran vdout1_74ck1870 FIND v(dout1_74) AT=1880.05n

.meas tran vdout1_75ck1870 FIND v(dout1_75) AT=1880.05n

.meas tran vdout1_76ck1870 FIND v(dout1_76) AT=1880.05n

.meas tran vdout1_77ck1870 FIND v(dout1_77) AT=1880.05n

.meas tran vdout1_78ck1870 FIND v(dout1_78) AT=1880.05n

.meas tran vdout1_79ck1870 FIND v(dout1_79) AT=1880.05n

.meas tran vdout1_80ck1870 FIND v(dout1_80) AT=1880.05n

.meas tran vdout1_81ck1870 FIND v(dout1_81) AT=1880.05n

.meas tran vdout1_82ck1870 FIND v(dout1_82) AT=1880.05n

.meas tran vdout1_83ck1870 FIND v(dout1_83) AT=1880.05n

.meas tran vdout1_84ck1870 FIND v(dout1_84) AT=1880.05n

.meas tran vdout1_85ck1870 FIND v(dout1_85) AT=1880.05n

.meas tran vdout1_86ck1870 FIND v(dout1_86) AT=1880.05n

.meas tran vdout1_87ck1870 FIND v(dout1_87) AT=1880.05n

.meas tran vdout1_88ck1870 FIND v(dout1_88) AT=1880.05n

.meas tran vdout1_89ck1870 FIND v(dout1_89) AT=1880.05n

.meas tran vdout1_90ck1870 FIND v(dout1_90) AT=1880.05n

.meas tran vdout1_91ck1870 FIND v(dout1_91) AT=1880.05n

.meas tran vdout1_92ck1870 FIND v(dout1_92) AT=1880.05n

.meas tran vdout1_93ck1870 FIND v(dout1_93) AT=1880.05n

.meas tran vdout1_94ck1870 FIND v(dout1_94) AT=1880.05n

.meas tran vdout1_95ck1870 FIND v(dout1_95) AT=1880.05n

.meas tran vdout1_96ck1870 FIND v(dout1_96) AT=1880.05n

.meas tran vdout1_97ck1870 FIND v(dout1_97) AT=1880.05n

.meas tran vdout1_98ck1870 FIND v(dout1_98) AT=1880.05n

.meas tran vdout1_99ck1870 FIND v(dout1_99) AT=1880.05n

.meas tran vdout1_100ck1870 FIND v(dout1_100) AT=1880.05n

.meas tran vdout1_101ck1870 FIND v(dout1_101) AT=1880.05n

.meas tran vdout1_102ck1870 FIND v(dout1_102) AT=1880.05n

.meas tran vdout1_103ck1870 FIND v(dout1_103) AT=1880.05n

.meas tran vdout1_104ck1870 FIND v(dout1_104) AT=1880.05n

.meas tran vdout1_105ck1870 FIND v(dout1_105) AT=1880.05n

.meas tran vdout1_106ck1870 FIND v(dout1_106) AT=1880.05n

.meas tran vdout1_107ck1870 FIND v(dout1_107) AT=1880.05n

.meas tran vdout1_108ck1870 FIND v(dout1_108) AT=1880.05n

.meas tran vdout1_109ck1870 FIND v(dout1_109) AT=1880.05n

.meas tran vdout1_110ck1870 FIND v(dout1_110) AT=1880.05n

.meas tran vdout1_111ck1870 FIND v(dout1_111) AT=1880.05n

.meas tran vdout1_112ck1870 FIND v(dout1_112) AT=1880.05n

.meas tran vdout1_113ck1870 FIND v(dout1_113) AT=1880.05n

.meas tran vdout1_114ck1870 FIND v(dout1_114) AT=1880.05n

.meas tran vdout1_115ck1870 FIND v(dout1_115) AT=1880.05n

.meas tran vdout1_116ck1870 FIND v(dout1_116) AT=1880.05n

.meas tran vdout1_117ck1870 FIND v(dout1_117) AT=1880.05n

.meas tran vdout1_118ck1870 FIND v(dout1_118) AT=1880.05n

.meas tran vdout1_119ck1870 FIND v(dout1_119) AT=1880.05n

.meas tran vdout1_120ck1870 FIND v(dout1_120) AT=1880.05n

.meas tran vdout1_121ck1870 FIND v(dout1_121) AT=1880.05n

.meas tran vdout1_122ck1870 FIND v(dout1_122) AT=1880.05n

.meas tran vdout1_123ck1870 FIND v(dout1_123) AT=1880.05n

.meas tran vdout1_124ck1870 FIND v(dout1_124) AT=1880.05n

.meas tran vdout1_125ck1870 FIND v(dout1_125) AT=1880.05n

.meas tran vdout1_126ck1870 FIND v(dout1_126) AT=1880.05n

.meas tran vdout1_127ck1870 FIND v(dout1_127) AT=1880.05n

.meas tran vdout1_128ck1870 FIND v(dout1_128) AT=1880.05n

.meas tran vdout1_129ck1870 FIND v(dout1_129) AT=1880.05n

.meas tran vdout1_130ck1870 FIND v(dout1_130) AT=1880.05n

.meas tran vdout1_131ck1870 FIND v(dout1_131) AT=1880.05n

.meas tran vdout1_132ck1870 FIND v(dout1_132) AT=1880.05n

.meas tran vdout1_133ck1870 FIND v(dout1_133) AT=1880.05n

.meas tran vdout1_134ck1870 FIND v(dout1_134) AT=1880.05n

.meas tran vdout1_135ck1870 FIND v(dout1_135) AT=1880.05n

.meas tran vdout1_136ck1870 FIND v(dout1_136) AT=1880.05n

.meas tran vdout1_137ck1870 FIND v(dout1_137) AT=1880.05n

.meas tran vdout1_138ck1870 FIND v(dout1_138) AT=1880.05n

.meas tran vdout1_139ck1870 FIND v(dout1_139) AT=1880.05n

.meas tran vdout1_140ck1870 FIND v(dout1_140) AT=1880.05n

.meas tran vdout1_141ck1870 FIND v(dout1_141) AT=1880.05n

.meas tran vdout1_142ck1870 FIND v(dout1_142) AT=1880.05n

.meas tran vdout1_143ck1870 FIND v(dout1_143) AT=1880.05n

.meas tran vdout1_144ck1870 FIND v(dout1_144) AT=1880.05n

.meas tran vdout1_145ck1870 FIND v(dout1_145) AT=1880.05n

.meas tran vdout1_146ck1870 FIND v(dout1_146) AT=1880.05n

.meas tran vdout1_147ck1870 FIND v(dout1_147) AT=1880.05n

.meas tran vdout1_148ck1870 FIND v(dout1_148) AT=1880.05n

.meas tran vdout1_149ck1870 FIND v(dout1_149) AT=1880.05n

.meas tran vdout1_150ck1870 FIND v(dout1_150) AT=1880.05n

.meas tran vdout1_151ck1870 FIND v(dout1_151) AT=1880.05n

.meas tran vdout1_152ck1870 FIND v(dout1_152) AT=1880.05n

.meas tran vdout1_153ck1870 FIND v(dout1_153) AT=1880.05n

.meas tran vdout1_154ck1870 FIND v(dout1_154) AT=1880.05n

.meas tran vdout1_155ck1870 FIND v(dout1_155) AT=1880.05n

.meas tran vdout1_156ck1870 FIND v(dout1_156) AT=1880.05n

.meas tran vdout1_157ck1870 FIND v(dout1_157) AT=1880.05n

.meas tran vdout1_158ck1870 FIND v(dout1_158) AT=1880.05n

.meas tran vdout1_159ck1870 FIND v(dout1_159) AT=1880.05n

.meas tran vdout1_160ck1870 FIND v(dout1_160) AT=1880.05n

.meas tran vdout1_161ck1870 FIND v(dout1_161) AT=1880.05n

.meas tran vdout1_162ck1870 FIND v(dout1_162) AT=1880.05n

.meas tran vdout1_163ck1870 FIND v(dout1_163) AT=1880.05n

.meas tran vdout1_164ck1870 FIND v(dout1_164) AT=1880.05n

.meas tran vdout1_165ck1870 FIND v(dout1_165) AT=1880.05n

.meas tran vdout1_166ck1870 FIND v(dout1_166) AT=1880.05n

.meas tran vdout1_167ck1870 FIND v(dout1_167) AT=1880.05n

.meas tran vdout1_168ck1870 FIND v(dout1_168) AT=1880.05n

.meas tran vdout1_169ck1870 FIND v(dout1_169) AT=1880.05n

.meas tran vdout1_170ck1870 FIND v(dout1_170) AT=1880.05n

.meas tran vdout1_171ck1870 FIND v(dout1_171) AT=1880.05n

.meas tran vdout1_172ck1870 FIND v(dout1_172) AT=1880.05n

.meas tran vdout1_173ck1870 FIND v(dout1_173) AT=1880.05n

.meas tran vdout1_174ck1870 FIND v(dout1_174) AT=1880.05n

.meas tran vdout1_175ck1870 FIND v(dout1_175) AT=1880.05n

.meas tran vdout1_176ck1870 FIND v(dout1_176) AT=1880.05n

.meas tran vdout1_177ck1870 FIND v(dout1_177) AT=1880.05n

.meas tran vdout1_178ck1870 FIND v(dout1_178) AT=1880.05n

.meas tran vdout1_179ck1870 FIND v(dout1_179) AT=1880.05n

.meas tran vdout1_180ck1870 FIND v(dout1_180) AT=1880.05n

.meas tran vdout1_181ck1870 FIND v(dout1_181) AT=1880.05n

.meas tran vdout1_182ck1870 FIND v(dout1_182) AT=1880.05n

.meas tran vdout1_183ck1870 FIND v(dout1_183) AT=1880.05n

.meas tran vdout1_184ck1870 FIND v(dout1_184) AT=1880.05n

.meas tran vdout1_185ck1870 FIND v(dout1_185) AT=1880.05n

.meas tran vdout1_186ck1870 FIND v(dout1_186) AT=1880.05n

.meas tran vdout1_187ck1870 FIND v(dout1_187) AT=1880.05n

.meas tran vdout1_188ck1870 FIND v(dout1_188) AT=1880.05n

.meas tran vdout1_189ck1870 FIND v(dout1_189) AT=1880.05n

.meas tran vdout1_190ck1870 FIND v(dout1_190) AT=1880.05n

.meas tran vdout1_191ck1870 FIND v(dout1_191) AT=1880.05n

.meas tran vdout1_192ck1870 FIND v(dout1_192) AT=1880.05n

.meas tran vdout1_193ck1870 FIND v(dout1_193) AT=1880.05n

.meas tran vdout1_194ck1870 FIND v(dout1_194) AT=1880.05n

.meas tran vdout1_195ck1870 FIND v(dout1_195) AT=1880.05n

.meas tran vdout1_196ck1870 FIND v(dout1_196) AT=1880.05n

.meas tran vdout1_197ck1870 FIND v(dout1_197) AT=1880.05n

.meas tran vdout1_198ck1870 FIND v(dout1_198) AT=1880.05n

.meas tran vdout1_199ck1870 FIND v(dout1_199) AT=1880.05n

.meas tran vdout1_200ck1870 FIND v(dout1_200) AT=1880.05n

.meas tran vdout1_201ck1870 FIND v(dout1_201) AT=1880.05n

.meas tran vdout1_202ck1870 FIND v(dout1_202) AT=1880.05n

.meas tran vdout1_203ck1870 FIND v(dout1_203) AT=1880.05n

.meas tran vdout1_204ck1870 FIND v(dout1_204) AT=1880.05n

.meas tran vdout1_205ck1870 FIND v(dout1_205) AT=1880.05n

.meas tran vdout1_206ck1870 FIND v(dout1_206) AT=1880.05n

.meas tran vdout1_207ck1870 FIND v(dout1_207) AT=1880.05n

.meas tran vdout1_208ck1870 FIND v(dout1_208) AT=1880.05n

.meas tran vdout1_209ck1870 FIND v(dout1_209) AT=1880.05n

.meas tran vdout1_210ck1870 FIND v(dout1_210) AT=1880.05n

.meas tran vdout1_211ck1870 FIND v(dout1_211) AT=1880.05n

.meas tran vdout1_212ck1870 FIND v(dout1_212) AT=1880.05n

.meas tran vdout1_213ck1870 FIND v(dout1_213) AT=1880.05n

.meas tran vdout1_214ck1870 FIND v(dout1_214) AT=1880.05n

.meas tran vdout1_215ck1870 FIND v(dout1_215) AT=1880.05n

.meas tran vdout1_216ck1870 FIND v(dout1_216) AT=1880.05n

.meas tran vdout1_217ck1870 FIND v(dout1_217) AT=1880.05n

.meas tran vdout1_218ck1870 FIND v(dout1_218) AT=1880.05n

.meas tran vdout1_219ck1870 FIND v(dout1_219) AT=1880.05n

.meas tran vdout1_220ck1870 FIND v(dout1_220) AT=1880.05n

.meas tran vdout1_221ck1870 FIND v(dout1_221) AT=1880.05n

.meas tran vdout1_222ck1870 FIND v(dout1_222) AT=1880.05n

.meas tran vdout1_223ck1870 FIND v(dout1_223) AT=1880.05n

.meas tran vdout1_224ck1870 FIND v(dout1_224) AT=1880.05n

.meas tran vdout1_225ck1870 FIND v(dout1_225) AT=1880.05n

.meas tran vdout1_226ck1870 FIND v(dout1_226) AT=1880.05n

.meas tran vdout1_227ck1870 FIND v(dout1_227) AT=1880.05n

.meas tran vdout1_228ck1870 FIND v(dout1_228) AT=1880.05n

.meas tran vdout1_229ck1870 FIND v(dout1_229) AT=1880.05n

.meas tran vdout1_230ck1870 FIND v(dout1_230) AT=1880.05n

.meas tran vdout1_231ck1870 FIND v(dout1_231) AT=1880.05n

.meas tran vdout1_232ck1870 FIND v(dout1_232) AT=1880.05n

.meas tran vdout1_233ck1870 FIND v(dout1_233) AT=1880.05n

.meas tran vdout1_234ck1870 FIND v(dout1_234) AT=1880.05n

.meas tran vdout1_235ck1870 FIND v(dout1_235) AT=1880.05n

.meas tran vdout1_236ck1870 FIND v(dout1_236) AT=1880.05n

.meas tran vdout1_237ck1870 FIND v(dout1_237) AT=1880.05n

.meas tran vdout1_238ck1870 FIND v(dout1_238) AT=1880.05n

.meas tran vdout1_239ck1870 FIND v(dout1_239) AT=1880.05n

.meas tran vdout1_240ck1870 FIND v(dout1_240) AT=1880.05n

.meas tran vdout1_241ck1870 FIND v(dout1_241) AT=1880.05n

.meas tran vdout1_242ck1870 FIND v(dout1_242) AT=1880.05n

.meas tran vdout1_243ck1870 FIND v(dout1_243) AT=1880.05n

.meas tran vdout1_244ck1870 FIND v(dout1_244) AT=1880.05n

.meas tran vdout1_245ck1870 FIND v(dout1_245) AT=1880.05n

.meas tran vdout1_246ck1870 FIND v(dout1_246) AT=1880.05n

.meas tran vdout1_247ck1870 FIND v(dout1_247) AT=1880.05n

.meas tran vdout1_248ck1870 FIND v(dout1_248) AT=1880.05n

.meas tran vdout1_249ck1870 FIND v(dout1_249) AT=1880.05n

.meas tran vdout1_250ck1870 FIND v(dout1_250) AT=1880.05n

.meas tran vdout1_251ck1870 FIND v(dout1_251) AT=1880.05n

.meas tran vdout1_252ck1870 FIND v(dout1_252) AT=1880.05n

.meas tran vdout1_253ck1870 FIND v(dout1_253) AT=1880.05n

.meas tran vdout1_254ck1870 FIND v(dout1_254) AT=1880.05n

.meas tran vdout1_255ck1870 FIND v(dout1_255) AT=1880.05n

.meas tran vdout1_256ck1870 FIND v(dout1_256) AT=1880.05n

.meas tran vdout1_0ck1900 FIND v(dout1_0) AT=1910.05n

.meas tran vdout1_1ck1900 FIND v(dout1_1) AT=1910.05n

.meas tran vdout1_2ck1900 FIND v(dout1_2) AT=1910.05n

.meas tran vdout1_3ck1900 FIND v(dout1_3) AT=1910.05n

.meas tran vdout1_4ck1900 FIND v(dout1_4) AT=1910.05n

.meas tran vdout1_5ck1900 FIND v(dout1_5) AT=1910.05n

.meas tran vdout1_6ck1900 FIND v(dout1_6) AT=1910.05n

.meas tran vdout1_7ck1900 FIND v(dout1_7) AT=1910.05n

.meas tran vdout1_8ck1900 FIND v(dout1_8) AT=1910.05n

.meas tran vdout1_9ck1900 FIND v(dout1_9) AT=1910.05n

.meas tran vdout1_10ck1900 FIND v(dout1_10) AT=1910.05n

.meas tran vdout1_11ck1900 FIND v(dout1_11) AT=1910.05n

.meas tran vdout1_12ck1900 FIND v(dout1_12) AT=1910.05n

.meas tran vdout1_13ck1900 FIND v(dout1_13) AT=1910.05n

.meas tran vdout1_14ck1900 FIND v(dout1_14) AT=1910.05n

.meas tran vdout1_15ck1900 FIND v(dout1_15) AT=1910.05n

.meas tran vdout1_16ck1900 FIND v(dout1_16) AT=1910.05n

.meas tran vdout1_17ck1900 FIND v(dout1_17) AT=1910.05n

.meas tran vdout1_18ck1900 FIND v(dout1_18) AT=1910.05n

.meas tran vdout1_19ck1900 FIND v(dout1_19) AT=1910.05n

.meas tran vdout1_20ck1900 FIND v(dout1_20) AT=1910.05n

.meas tran vdout1_21ck1900 FIND v(dout1_21) AT=1910.05n

.meas tran vdout1_22ck1900 FIND v(dout1_22) AT=1910.05n

.meas tran vdout1_23ck1900 FIND v(dout1_23) AT=1910.05n

.meas tran vdout1_24ck1900 FIND v(dout1_24) AT=1910.05n

.meas tran vdout1_25ck1900 FIND v(dout1_25) AT=1910.05n

.meas tran vdout1_26ck1900 FIND v(dout1_26) AT=1910.05n

.meas tran vdout1_27ck1900 FIND v(dout1_27) AT=1910.05n

.meas tran vdout1_28ck1900 FIND v(dout1_28) AT=1910.05n

.meas tran vdout1_29ck1900 FIND v(dout1_29) AT=1910.05n

.meas tran vdout1_30ck1900 FIND v(dout1_30) AT=1910.05n

.meas tran vdout1_31ck1900 FIND v(dout1_31) AT=1910.05n

.meas tran vdout1_32ck1900 FIND v(dout1_32) AT=1910.05n

.meas tran vdout1_33ck1900 FIND v(dout1_33) AT=1910.05n

.meas tran vdout1_34ck1900 FIND v(dout1_34) AT=1910.05n

.meas tran vdout1_35ck1900 FIND v(dout1_35) AT=1910.05n

.meas tran vdout1_36ck1900 FIND v(dout1_36) AT=1910.05n

.meas tran vdout1_37ck1900 FIND v(dout1_37) AT=1910.05n

.meas tran vdout1_38ck1900 FIND v(dout1_38) AT=1910.05n

.meas tran vdout1_39ck1900 FIND v(dout1_39) AT=1910.05n

.meas tran vdout1_40ck1900 FIND v(dout1_40) AT=1910.05n

.meas tran vdout1_41ck1900 FIND v(dout1_41) AT=1910.05n

.meas tran vdout1_42ck1900 FIND v(dout1_42) AT=1910.05n

.meas tran vdout1_43ck1900 FIND v(dout1_43) AT=1910.05n

.meas tran vdout1_44ck1900 FIND v(dout1_44) AT=1910.05n

.meas tran vdout1_45ck1900 FIND v(dout1_45) AT=1910.05n

.meas tran vdout1_46ck1900 FIND v(dout1_46) AT=1910.05n

.meas tran vdout1_47ck1900 FIND v(dout1_47) AT=1910.05n

.meas tran vdout1_48ck1900 FIND v(dout1_48) AT=1910.05n

.meas tran vdout1_49ck1900 FIND v(dout1_49) AT=1910.05n

.meas tran vdout1_50ck1900 FIND v(dout1_50) AT=1910.05n

.meas tran vdout1_51ck1900 FIND v(dout1_51) AT=1910.05n

.meas tran vdout1_52ck1900 FIND v(dout1_52) AT=1910.05n

.meas tran vdout1_53ck1900 FIND v(dout1_53) AT=1910.05n

.meas tran vdout1_54ck1900 FIND v(dout1_54) AT=1910.05n

.meas tran vdout1_55ck1900 FIND v(dout1_55) AT=1910.05n

.meas tran vdout1_56ck1900 FIND v(dout1_56) AT=1910.05n

.meas tran vdout1_57ck1900 FIND v(dout1_57) AT=1910.05n

.meas tran vdout1_58ck1900 FIND v(dout1_58) AT=1910.05n

.meas tran vdout1_59ck1900 FIND v(dout1_59) AT=1910.05n

.meas tran vdout1_60ck1900 FIND v(dout1_60) AT=1910.05n

.meas tran vdout1_61ck1900 FIND v(dout1_61) AT=1910.05n

.meas tran vdout1_62ck1900 FIND v(dout1_62) AT=1910.05n

.meas tran vdout1_63ck1900 FIND v(dout1_63) AT=1910.05n

.meas tran vdout1_64ck1900 FIND v(dout1_64) AT=1910.05n

.meas tran vdout1_65ck1900 FIND v(dout1_65) AT=1910.05n

.meas tran vdout1_66ck1900 FIND v(dout1_66) AT=1910.05n

.meas tran vdout1_67ck1900 FIND v(dout1_67) AT=1910.05n

.meas tran vdout1_68ck1900 FIND v(dout1_68) AT=1910.05n

.meas tran vdout1_69ck1900 FIND v(dout1_69) AT=1910.05n

.meas tran vdout1_70ck1900 FIND v(dout1_70) AT=1910.05n

.meas tran vdout1_71ck1900 FIND v(dout1_71) AT=1910.05n

.meas tran vdout1_72ck1900 FIND v(dout1_72) AT=1910.05n

.meas tran vdout1_73ck1900 FIND v(dout1_73) AT=1910.05n

.meas tran vdout1_74ck1900 FIND v(dout1_74) AT=1910.05n

.meas tran vdout1_75ck1900 FIND v(dout1_75) AT=1910.05n

.meas tran vdout1_76ck1900 FIND v(dout1_76) AT=1910.05n

.meas tran vdout1_77ck1900 FIND v(dout1_77) AT=1910.05n

.meas tran vdout1_78ck1900 FIND v(dout1_78) AT=1910.05n

.meas tran vdout1_79ck1900 FIND v(dout1_79) AT=1910.05n

.meas tran vdout1_80ck1900 FIND v(dout1_80) AT=1910.05n

.meas tran vdout1_81ck1900 FIND v(dout1_81) AT=1910.05n

.meas tran vdout1_82ck1900 FIND v(dout1_82) AT=1910.05n

.meas tran vdout1_83ck1900 FIND v(dout1_83) AT=1910.05n

.meas tran vdout1_84ck1900 FIND v(dout1_84) AT=1910.05n

.meas tran vdout1_85ck1900 FIND v(dout1_85) AT=1910.05n

.meas tran vdout1_86ck1900 FIND v(dout1_86) AT=1910.05n

.meas tran vdout1_87ck1900 FIND v(dout1_87) AT=1910.05n

.meas tran vdout1_88ck1900 FIND v(dout1_88) AT=1910.05n

.meas tran vdout1_89ck1900 FIND v(dout1_89) AT=1910.05n

.meas tran vdout1_90ck1900 FIND v(dout1_90) AT=1910.05n

.meas tran vdout1_91ck1900 FIND v(dout1_91) AT=1910.05n

.meas tran vdout1_92ck1900 FIND v(dout1_92) AT=1910.05n

.meas tran vdout1_93ck1900 FIND v(dout1_93) AT=1910.05n

.meas tran vdout1_94ck1900 FIND v(dout1_94) AT=1910.05n

.meas tran vdout1_95ck1900 FIND v(dout1_95) AT=1910.05n

.meas tran vdout1_96ck1900 FIND v(dout1_96) AT=1910.05n

.meas tran vdout1_97ck1900 FIND v(dout1_97) AT=1910.05n

.meas tran vdout1_98ck1900 FIND v(dout1_98) AT=1910.05n

.meas tran vdout1_99ck1900 FIND v(dout1_99) AT=1910.05n

.meas tran vdout1_100ck1900 FIND v(dout1_100) AT=1910.05n

.meas tran vdout1_101ck1900 FIND v(dout1_101) AT=1910.05n

.meas tran vdout1_102ck1900 FIND v(dout1_102) AT=1910.05n

.meas tran vdout1_103ck1900 FIND v(dout1_103) AT=1910.05n

.meas tran vdout1_104ck1900 FIND v(dout1_104) AT=1910.05n

.meas tran vdout1_105ck1900 FIND v(dout1_105) AT=1910.05n

.meas tran vdout1_106ck1900 FIND v(dout1_106) AT=1910.05n

.meas tran vdout1_107ck1900 FIND v(dout1_107) AT=1910.05n

.meas tran vdout1_108ck1900 FIND v(dout1_108) AT=1910.05n

.meas tran vdout1_109ck1900 FIND v(dout1_109) AT=1910.05n

.meas tran vdout1_110ck1900 FIND v(dout1_110) AT=1910.05n

.meas tran vdout1_111ck1900 FIND v(dout1_111) AT=1910.05n

.meas tran vdout1_112ck1900 FIND v(dout1_112) AT=1910.05n

.meas tran vdout1_113ck1900 FIND v(dout1_113) AT=1910.05n

.meas tran vdout1_114ck1900 FIND v(dout1_114) AT=1910.05n

.meas tran vdout1_115ck1900 FIND v(dout1_115) AT=1910.05n

.meas tran vdout1_116ck1900 FIND v(dout1_116) AT=1910.05n

.meas tran vdout1_117ck1900 FIND v(dout1_117) AT=1910.05n

.meas tran vdout1_118ck1900 FIND v(dout1_118) AT=1910.05n

.meas tran vdout1_119ck1900 FIND v(dout1_119) AT=1910.05n

.meas tran vdout1_120ck1900 FIND v(dout1_120) AT=1910.05n

.meas tran vdout1_121ck1900 FIND v(dout1_121) AT=1910.05n

.meas tran vdout1_122ck1900 FIND v(dout1_122) AT=1910.05n

.meas tran vdout1_123ck1900 FIND v(dout1_123) AT=1910.05n

.meas tran vdout1_124ck1900 FIND v(dout1_124) AT=1910.05n

.meas tran vdout1_125ck1900 FIND v(dout1_125) AT=1910.05n

.meas tran vdout1_126ck1900 FIND v(dout1_126) AT=1910.05n

.meas tran vdout1_127ck1900 FIND v(dout1_127) AT=1910.05n

.meas tran vdout1_128ck1900 FIND v(dout1_128) AT=1910.05n

.meas tran vdout1_129ck1900 FIND v(dout1_129) AT=1910.05n

.meas tran vdout1_130ck1900 FIND v(dout1_130) AT=1910.05n

.meas tran vdout1_131ck1900 FIND v(dout1_131) AT=1910.05n

.meas tran vdout1_132ck1900 FIND v(dout1_132) AT=1910.05n

.meas tran vdout1_133ck1900 FIND v(dout1_133) AT=1910.05n

.meas tran vdout1_134ck1900 FIND v(dout1_134) AT=1910.05n

.meas tran vdout1_135ck1900 FIND v(dout1_135) AT=1910.05n

.meas tran vdout1_136ck1900 FIND v(dout1_136) AT=1910.05n

.meas tran vdout1_137ck1900 FIND v(dout1_137) AT=1910.05n

.meas tran vdout1_138ck1900 FIND v(dout1_138) AT=1910.05n

.meas tran vdout1_139ck1900 FIND v(dout1_139) AT=1910.05n

.meas tran vdout1_140ck1900 FIND v(dout1_140) AT=1910.05n

.meas tran vdout1_141ck1900 FIND v(dout1_141) AT=1910.05n

.meas tran vdout1_142ck1900 FIND v(dout1_142) AT=1910.05n

.meas tran vdout1_143ck1900 FIND v(dout1_143) AT=1910.05n

.meas tran vdout1_144ck1900 FIND v(dout1_144) AT=1910.05n

.meas tran vdout1_145ck1900 FIND v(dout1_145) AT=1910.05n

.meas tran vdout1_146ck1900 FIND v(dout1_146) AT=1910.05n

.meas tran vdout1_147ck1900 FIND v(dout1_147) AT=1910.05n

.meas tran vdout1_148ck1900 FIND v(dout1_148) AT=1910.05n

.meas tran vdout1_149ck1900 FIND v(dout1_149) AT=1910.05n

.meas tran vdout1_150ck1900 FIND v(dout1_150) AT=1910.05n

.meas tran vdout1_151ck1900 FIND v(dout1_151) AT=1910.05n

.meas tran vdout1_152ck1900 FIND v(dout1_152) AT=1910.05n

.meas tran vdout1_153ck1900 FIND v(dout1_153) AT=1910.05n

.meas tran vdout1_154ck1900 FIND v(dout1_154) AT=1910.05n

.meas tran vdout1_155ck1900 FIND v(dout1_155) AT=1910.05n

.meas tran vdout1_156ck1900 FIND v(dout1_156) AT=1910.05n

.meas tran vdout1_157ck1900 FIND v(dout1_157) AT=1910.05n

.meas tran vdout1_158ck1900 FIND v(dout1_158) AT=1910.05n

.meas tran vdout1_159ck1900 FIND v(dout1_159) AT=1910.05n

.meas tran vdout1_160ck1900 FIND v(dout1_160) AT=1910.05n

.meas tran vdout1_161ck1900 FIND v(dout1_161) AT=1910.05n

.meas tran vdout1_162ck1900 FIND v(dout1_162) AT=1910.05n

.meas tran vdout1_163ck1900 FIND v(dout1_163) AT=1910.05n

.meas tran vdout1_164ck1900 FIND v(dout1_164) AT=1910.05n

.meas tran vdout1_165ck1900 FIND v(dout1_165) AT=1910.05n

.meas tran vdout1_166ck1900 FIND v(dout1_166) AT=1910.05n

.meas tran vdout1_167ck1900 FIND v(dout1_167) AT=1910.05n

.meas tran vdout1_168ck1900 FIND v(dout1_168) AT=1910.05n

.meas tran vdout1_169ck1900 FIND v(dout1_169) AT=1910.05n

.meas tran vdout1_170ck1900 FIND v(dout1_170) AT=1910.05n

.meas tran vdout1_171ck1900 FIND v(dout1_171) AT=1910.05n

.meas tran vdout1_172ck1900 FIND v(dout1_172) AT=1910.05n

.meas tran vdout1_173ck1900 FIND v(dout1_173) AT=1910.05n

.meas tran vdout1_174ck1900 FIND v(dout1_174) AT=1910.05n

.meas tran vdout1_175ck1900 FIND v(dout1_175) AT=1910.05n

.meas tran vdout1_176ck1900 FIND v(dout1_176) AT=1910.05n

.meas tran vdout1_177ck1900 FIND v(dout1_177) AT=1910.05n

.meas tran vdout1_178ck1900 FIND v(dout1_178) AT=1910.05n

.meas tran vdout1_179ck1900 FIND v(dout1_179) AT=1910.05n

.meas tran vdout1_180ck1900 FIND v(dout1_180) AT=1910.05n

.meas tran vdout1_181ck1900 FIND v(dout1_181) AT=1910.05n

.meas tran vdout1_182ck1900 FIND v(dout1_182) AT=1910.05n

.meas tran vdout1_183ck1900 FIND v(dout1_183) AT=1910.05n

.meas tran vdout1_184ck1900 FIND v(dout1_184) AT=1910.05n

.meas tran vdout1_185ck1900 FIND v(dout1_185) AT=1910.05n

.meas tran vdout1_186ck1900 FIND v(dout1_186) AT=1910.05n

.meas tran vdout1_187ck1900 FIND v(dout1_187) AT=1910.05n

.meas tran vdout1_188ck1900 FIND v(dout1_188) AT=1910.05n

.meas tran vdout1_189ck1900 FIND v(dout1_189) AT=1910.05n

.meas tran vdout1_190ck1900 FIND v(dout1_190) AT=1910.05n

.meas tran vdout1_191ck1900 FIND v(dout1_191) AT=1910.05n

.meas tran vdout1_192ck1900 FIND v(dout1_192) AT=1910.05n

.meas tran vdout1_193ck1900 FIND v(dout1_193) AT=1910.05n

.meas tran vdout1_194ck1900 FIND v(dout1_194) AT=1910.05n

.meas tran vdout1_195ck1900 FIND v(dout1_195) AT=1910.05n

.meas tran vdout1_196ck1900 FIND v(dout1_196) AT=1910.05n

.meas tran vdout1_197ck1900 FIND v(dout1_197) AT=1910.05n

.meas tran vdout1_198ck1900 FIND v(dout1_198) AT=1910.05n

.meas tran vdout1_199ck1900 FIND v(dout1_199) AT=1910.05n

.meas tran vdout1_200ck1900 FIND v(dout1_200) AT=1910.05n

.meas tran vdout1_201ck1900 FIND v(dout1_201) AT=1910.05n

.meas tran vdout1_202ck1900 FIND v(dout1_202) AT=1910.05n

.meas tran vdout1_203ck1900 FIND v(dout1_203) AT=1910.05n

.meas tran vdout1_204ck1900 FIND v(dout1_204) AT=1910.05n

.meas tran vdout1_205ck1900 FIND v(dout1_205) AT=1910.05n

.meas tran vdout1_206ck1900 FIND v(dout1_206) AT=1910.05n

.meas tran vdout1_207ck1900 FIND v(dout1_207) AT=1910.05n

.meas tran vdout1_208ck1900 FIND v(dout1_208) AT=1910.05n

.meas tran vdout1_209ck1900 FIND v(dout1_209) AT=1910.05n

.meas tran vdout1_210ck1900 FIND v(dout1_210) AT=1910.05n

.meas tran vdout1_211ck1900 FIND v(dout1_211) AT=1910.05n

.meas tran vdout1_212ck1900 FIND v(dout1_212) AT=1910.05n

.meas tran vdout1_213ck1900 FIND v(dout1_213) AT=1910.05n

.meas tran vdout1_214ck1900 FIND v(dout1_214) AT=1910.05n

.meas tran vdout1_215ck1900 FIND v(dout1_215) AT=1910.05n

.meas tran vdout1_216ck1900 FIND v(dout1_216) AT=1910.05n

.meas tran vdout1_217ck1900 FIND v(dout1_217) AT=1910.05n

.meas tran vdout1_218ck1900 FIND v(dout1_218) AT=1910.05n

.meas tran vdout1_219ck1900 FIND v(dout1_219) AT=1910.05n

.meas tran vdout1_220ck1900 FIND v(dout1_220) AT=1910.05n

.meas tran vdout1_221ck1900 FIND v(dout1_221) AT=1910.05n

.meas tran vdout1_222ck1900 FIND v(dout1_222) AT=1910.05n

.meas tran vdout1_223ck1900 FIND v(dout1_223) AT=1910.05n

.meas tran vdout1_224ck1900 FIND v(dout1_224) AT=1910.05n

.meas tran vdout1_225ck1900 FIND v(dout1_225) AT=1910.05n

.meas tran vdout1_226ck1900 FIND v(dout1_226) AT=1910.05n

.meas tran vdout1_227ck1900 FIND v(dout1_227) AT=1910.05n

.meas tran vdout1_228ck1900 FIND v(dout1_228) AT=1910.05n

.meas tran vdout1_229ck1900 FIND v(dout1_229) AT=1910.05n

.meas tran vdout1_230ck1900 FIND v(dout1_230) AT=1910.05n

.meas tran vdout1_231ck1900 FIND v(dout1_231) AT=1910.05n

.meas tran vdout1_232ck1900 FIND v(dout1_232) AT=1910.05n

.meas tran vdout1_233ck1900 FIND v(dout1_233) AT=1910.05n

.meas tran vdout1_234ck1900 FIND v(dout1_234) AT=1910.05n

.meas tran vdout1_235ck1900 FIND v(dout1_235) AT=1910.05n

.meas tran vdout1_236ck1900 FIND v(dout1_236) AT=1910.05n

.meas tran vdout1_237ck1900 FIND v(dout1_237) AT=1910.05n

.meas tran vdout1_238ck1900 FIND v(dout1_238) AT=1910.05n

.meas tran vdout1_239ck1900 FIND v(dout1_239) AT=1910.05n

.meas tran vdout1_240ck1900 FIND v(dout1_240) AT=1910.05n

.meas tran vdout1_241ck1900 FIND v(dout1_241) AT=1910.05n

.meas tran vdout1_242ck1900 FIND v(dout1_242) AT=1910.05n

.meas tran vdout1_243ck1900 FIND v(dout1_243) AT=1910.05n

.meas tran vdout1_244ck1900 FIND v(dout1_244) AT=1910.05n

.meas tran vdout1_245ck1900 FIND v(dout1_245) AT=1910.05n

.meas tran vdout1_246ck1900 FIND v(dout1_246) AT=1910.05n

.meas tran vdout1_247ck1900 FIND v(dout1_247) AT=1910.05n

.meas tran vdout1_248ck1900 FIND v(dout1_248) AT=1910.05n

.meas tran vdout1_249ck1900 FIND v(dout1_249) AT=1910.05n

.meas tran vdout1_250ck1900 FIND v(dout1_250) AT=1910.05n

.meas tran vdout1_251ck1900 FIND v(dout1_251) AT=1910.05n

.meas tran vdout1_252ck1900 FIND v(dout1_252) AT=1910.05n

.meas tran vdout1_253ck1900 FIND v(dout1_253) AT=1910.05n

.meas tran vdout1_254ck1900 FIND v(dout1_254) AT=1910.05n

.meas tran vdout1_255ck1900 FIND v(dout1_255) AT=1910.05n

.meas tran vdout1_256ck1900 FIND v(dout1_256) AT=1910.05n

.meas tran vdout1_0ck1920 FIND v(dout1_0) AT=1930.05n

.meas tran vdout1_1ck1920 FIND v(dout1_1) AT=1930.05n

.meas tran vdout1_2ck1920 FIND v(dout1_2) AT=1930.05n

.meas tran vdout1_3ck1920 FIND v(dout1_3) AT=1930.05n

.meas tran vdout1_4ck1920 FIND v(dout1_4) AT=1930.05n

.meas tran vdout1_5ck1920 FIND v(dout1_5) AT=1930.05n

.meas tran vdout1_6ck1920 FIND v(dout1_6) AT=1930.05n

.meas tran vdout1_7ck1920 FIND v(dout1_7) AT=1930.05n

.meas tran vdout1_8ck1920 FIND v(dout1_8) AT=1930.05n

.meas tran vdout1_9ck1920 FIND v(dout1_9) AT=1930.05n

.meas tran vdout1_10ck1920 FIND v(dout1_10) AT=1930.05n

.meas tran vdout1_11ck1920 FIND v(dout1_11) AT=1930.05n

.meas tran vdout1_12ck1920 FIND v(dout1_12) AT=1930.05n

.meas tran vdout1_13ck1920 FIND v(dout1_13) AT=1930.05n

.meas tran vdout1_14ck1920 FIND v(dout1_14) AT=1930.05n

.meas tran vdout1_15ck1920 FIND v(dout1_15) AT=1930.05n

.meas tran vdout1_16ck1920 FIND v(dout1_16) AT=1930.05n

.meas tran vdout1_17ck1920 FIND v(dout1_17) AT=1930.05n

.meas tran vdout1_18ck1920 FIND v(dout1_18) AT=1930.05n

.meas tran vdout1_19ck1920 FIND v(dout1_19) AT=1930.05n

.meas tran vdout1_20ck1920 FIND v(dout1_20) AT=1930.05n

.meas tran vdout1_21ck1920 FIND v(dout1_21) AT=1930.05n

.meas tran vdout1_22ck1920 FIND v(dout1_22) AT=1930.05n

.meas tran vdout1_23ck1920 FIND v(dout1_23) AT=1930.05n

.meas tran vdout1_24ck1920 FIND v(dout1_24) AT=1930.05n

.meas tran vdout1_25ck1920 FIND v(dout1_25) AT=1930.05n

.meas tran vdout1_26ck1920 FIND v(dout1_26) AT=1930.05n

.meas tran vdout1_27ck1920 FIND v(dout1_27) AT=1930.05n

.meas tran vdout1_28ck1920 FIND v(dout1_28) AT=1930.05n

.meas tran vdout1_29ck1920 FIND v(dout1_29) AT=1930.05n

.meas tran vdout1_30ck1920 FIND v(dout1_30) AT=1930.05n

.meas tran vdout1_31ck1920 FIND v(dout1_31) AT=1930.05n

.meas tran vdout1_32ck1920 FIND v(dout1_32) AT=1930.05n

.meas tran vdout1_33ck1920 FIND v(dout1_33) AT=1930.05n

.meas tran vdout1_34ck1920 FIND v(dout1_34) AT=1930.05n

.meas tran vdout1_35ck1920 FIND v(dout1_35) AT=1930.05n

.meas tran vdout1_36ck1920 FIND v(dout1_36) AT=1930.05n

.meas tran vdout1_37ck1920 FIND v(dout1_37) AT=1930.05n

.meas tran vdout1_38ck1920 FIND v(dout1_38) AT=1930.05n

.meas tran vdout1_39ck1920 FIND v(dout1_39) AT=1930.05n

.meas tran vdout1_40ck1920 FIND v(dout1_40) AT=1930.05n

.meas tran vdout1_41ck1920 FIND v(dout1_41) AT=1930.05n

.meas tran vdout1_42ck1920 FIND v(dout1_42) AT=1930.05n

.meas tran vdout1_43ck1920 FIND v(dout1_43) AT=1930.05n

.meas tran vdout1_44ck1920 FIND v(dout1_44) AT=1930.05n

.meas tran vdout1_45ck1920 FIND v(dout1_45) AT=1930.05n

.meas tran vdout1_46ck1920 FIND v(dout1_46) AT=1930.05n

.meas tran vdout1_47ck1920 FIND v(dout1_47) AT=1930.05n

.meas tran vdout1_48ck1920 FIND v(dout1_48) AT=1930.05n

.meas tran vdout1_49ck1920 FIND v(dout1_49) AT=1930.05n

.meas tran vdout1_50ck1920 FIND v(dout1_50) AT=1930.05n

.meas tran vdout1_51ck1920 FIND v(dout1_51) AT=1930.05n

.meas tran vdout1_52ck1920 FIND v(dout1_52) AT=1930.05n

.meas tran vdout1_53ck1920 FIND v(dout1_53) AT=1930.05n

.meas tran vdout1_54ck1920 FIND v(dout1_54) AT=1930.05n

.meas tran vdout1_55ck1920 FIND v(dout1_55) AT=1930.05n

.meas tran vdout1_56ck1920 FIND v(dout1_56) AT=1930.05n

.meas tran vdout1_57ck1920 FIND v(dout1_57) AT=1930.05n

.meas tran vdout1_58ck1920 FIND v(dout1_58) AT=1930.05n

.meas tran vdout1_59ck1920 FIND v(dout1_59) AT=1930.05n

.meas tran vdout1_60ck1920 FIND v(dout1_60) AT=1930.05n

.meas tran vdout1_61ck1920 FIND v(dout1_61) AT=1930.05n

.meas tran vdout1_62ck1920 FIND v(dout1_62) AT=1930.05n

.meas tran vdout1_63ck1920 FIND v(dout1_63) AT=1930.05n

.meas tran vdout1_64ck1920 FIND v(dout1_64) AT=1930.05n

.meas tran vdout1_65ck1920 FIND v(dout1_65) AT=1930.05n

.meas tran vdout1_66ck1920 FIND v(dout1_66) AT=1930.05n

.meas tran vdout1_67ck1920 FIND v(dout1_67) AT=1930.05n

.meas tran vdout1_68ck1920 FIND v(dout1_68) AT=1930.05n

.meas tran vdout1_69ck1920 FIND v(dout1_69) AT=1930.05n

.meas tran vdout1_70ck1920 FIND v(dout1_70) AT=1930.05n

.meas tran vdout1_71ck1920 FIND v(dout1_71) AT=1930.05n

.meas tran vdout1_72ck1920 FIND v(dout1_72) AT=1930.05n

.meas tran vdout1_73ck1920 FIND v(dout1_73) AT=1930.05n

.meas tran vdout1_74ck1920 FIND v(dout1_74) AT=1930.05n

.meas tran vdout1_75ck1920 FIND v(dout1_75) AT=1930.05n

.meas tran vdout1_76ck1920 FIND v(dout1_76) AT=1930.05n

.meas tran vdout1_77ck1920 FIND v(dout1_77) AT=1930.05n

.meas tran vdout1_78ck1920 FIND v(dout1_78) AT=1930.05n

.meas tran vdout1_79ck1920 FIND v(dout1_79) AT=1930.05n

.meas tran vdout1_80ck1920 FIND v(dout1_80) AT=1930.05n

.meas tran vdout1_81ck1920 FIND v(dout1_81) AT=1930.05n

.meas tran vdout1_82ck1920 FIND v(dout1_82) AT=1930.05n

.meas tran vdout1_83ck1920 FIND v(dout1_83) AT=1930.05n

.meas tran vdout1_84ck1920 FIND v(dout1_84) AT=1930.05n

.meas tran vdout1_85ck1920 FIND v(dout1_85) AT=1930.05n

.meas tran vdout1_86ck1920 FIND v(dout1_86) AT=1930.05n

.meas tran vdout1_87ck1920 FIND v(dout1_87) AT=1930.05n

.meas tran vdout1_88ck1920 FIND v(dout1_88) AT=1930.05n

.meas tran vdout1_89ck1920 FIND v(dout1_89) AT=1930.05n

.meas tran vdout1_90ck1920 FIND v(dout1_90) AT=1930.05n

.meas tran vdout1_91ck1920 FIND v(dout1_91) AT=1930.05n

.meas tran vdout1_92ck1920 FIND v(dout1_92) AT=1930.05n

.meas tran vdout1_93ck1920 FIND v(dout1_93) AT=1930.05n

.meas tran vdout1_94ck1920 FIND v(dout1_94) AT=1930.05n

.meas tran vdout1_95ck1920 FIND v(dout1_95) AT=1930.05n

.meas tran vdout1_96ck1920 FIND v(dout1_96) AT=1930.05n

.meas tran vdout1_97ck1920 FIND v(dout1_97) AT=1930.05n

.meas tran vdout1_98ck1920 FIND v(dout1_98) AT=1930.05n

.meas tran vdout1_99ck1920 FIND v(dout1_99) AT=1930.05n

.meas tran vdout1_100ck1920 FIND v(dout1_100) AT=1930.05n

.meas tran vdout1_101ck1920 FIND v(dout1_101) AT=1930.05n

.meas tran vdout1_102ck1920 FIND v(dout1_102) AT=1930.05n

.meas tran vdout1_103ck1920 FIND v(dout1_103) AT=1930.05n

.meas tran vdout1_104ck1920 FIND v(dout1_104) AT=1930.05n

.meas tran vdout1_105ck1920 FIND v(dout1_105) AT=1930.05n

.meas tran vdout1_106ck1920 FIND v(dout1_106) AT=1930.05n

.meas tran vdout1_107ck1920 FIND v(dout1_107) AT=1930.05n

.meas tran vdout1_108ck1920 FIND v(dout1_108) AT=1930.05n

.meas tran vdout1_109ck1920 FIND v(dout1_109) AT=1930.05n

.meas tran vdout1_110ck1920 FIND v(dout1_110) AT=1930.05n

.meas tran vdout1_111ck1920 FIND v(dout1_111) AT=1930.05n

.meas tran vdout1_112ck1920 FIND v(dout1_112) AT=1930.05n

.meas tran vdout1_113ck1920 FIND v(dout1_113) AT=1930.05n

.meas tran vdout1_114ck1920 FIND v(dout1_114) AT=1930.05n

.meas tran vdout1_115ck1920 FIND v(dout1_115) AT=1930.05n

.meas tran vdout1_116ck1920 FIND v(dout1_116) AT=1930.05n

.meas tran vdout1_117ck1920 FIND v(dout1_117) AT=1930.05n

.meas tran vdout1_118ck1920 FIND v(dout1_118) AT=1930.05n

.meas tran vdout1_119ck1920 FIND v(dout1_119) AT=1930.05n

.meas tran vdout1_120ck1920 FIND v(dout1_120) AT=1930.05n

.meas tran vdout1_121ck1920 FIND v(dout1_121) AT=1930.05n

.meas tran vdout1_122ck1920 FIND v(dout1_122) AT=1930.05n

.meas tran vdout1_123ck1920 FIND v(dout1_123) AT=1930.05n

.meas tran vdout1_124ck1920 FIND v(dout1_124) AT=1930.05n

.meas tran vdout1_125ck1920 FIND v(dout1_125) AT=1930.05n

.meas tran vdout1_126ck1920 FIND v(dout1_126) AT=1930.05n

.meas tran vdout1_127ck1920 FIND v(dout1_127) AT=1930.05n

.meas tran vdout1_128ck1920 FIND v(dout1_128) AT=1930.05n

.meas tran vdout1_129ck1920 FIND v(dout1_129) AT=1930.05n

.meas tran vdout1_130ck1920 FIND v(dout1_130) AT=1930.05n

.meas tran vdout1_131ck1920 FIND v(dout1_131) AT=1930.05n

.meas tran vdout1_132ck1920 FIND v(dout1_132) AT=1930.05n

.meas tran vdout1_133ck1920 FIND v(dout1_133) AT=1930.05n

.meas tran vdout1_134ck1920 FIND v(dout1_134) AT=1930.05n

.meas tran vdout1_135ck1920 FIND v(dout1_135) AT=1930.05n

.meas tran vdout1_136ck1920 FIND v(dout1_136) AT=1930.05n

.meas tran vdout1_137ck1920 FIND v(dout1_137) AT=1930.05n

.meas tran vdout1_138ck1920 FIND v(dout1_138) AT=1930.05n

.meas tran vdout1_139ck1920 FIND v(dout1_139) AT=1930.05n

.meas tran vdout1_140ck1920 FIND v(dout1_140) AT=1930.05n

.meas tran vdout1_141ck1920 FIND v(dout1_141) AT=1930.05n

.meas tran vdout1_142ck1920 FIND v(dout1_142) AT=1930.05n

.meas tran vdout1_143ck1920 FIND v(dout1_143) AT=1930.05n

.meas tran vdout1_144ck1920 FIND v(dout1_144) AT=1930.05n

.meas tran vdout1_145ck1920 FIND v(dout1_145) AT=1930.05n

.meas tran vdout1_146ck1920 FIND v(dout1_146) AT=1930.05n

.meas tran vdout1_147ck1920 FIND v(dout1_147) AT=1930.05n

.meas tran vdout1_148ck1920 FIND v(dout1_148) AT=1930.05n

.meas tran vdout1_149ck1920 FIND v(dout1_149) AT=1930.05n

.meas tran vdout1_150ck1920 FIND v(dout1_150) AT=1930.05n

.meas tran vdout1_151ck1920 FIND v(dout1_151) AT=1930.05n

.meas tran vdout1_152ck1920 FIND v(dout1_152) AT=1930.05n

.meas tran vdout1_153ck1920 FIND v(dout1_153) AT=1930.05n

.meas tran vdout1_154ck1920 FIND v(dout1_154) AT=1930.05n

.meas tran vdout1_155ck1920 FIND v(dout1_155) AT=1930.05n

.meas tran vdout1_156ck1920 FIND v(dout1_156) AT=1930.05n

.meas tran vdout1_157ck1920 FIND v(dout1_157) AT=1930.05n

.meas tran vdout1_158ck1920 FIND v(dout1_158) AT=1930.05n

.meas tran vdout1_159ck1920 FIND v(dout1_159) AT=1930.05n

.meas tran vdout1_160ck1920 FIND v(dout1_160) AT=1930.05n

.meas tran vdout1_161ck1920 FIND v(dout1_161) AT=1930.05n

.meas tran vdout1_162ck1920 FIND v(dout1_162) AT=1930.05n

.meas tran vdout1_163ck1920 FIND v(dout1_163) AT=1930.05n

.meas tran vdout1_164ck1920 FIND v(dout1_164) AT=1930.05n

.meas tran vdout1_165ck1920 FIND v(dout1_165) AT=1930.05n

.meas tran vdout1_166ck1920 FIND v(dout1_166) AT=1930.05n

.meas tran vdout1_167ck1920 FIND v(dout1_167) AT=1930.05n

.meas tran vdout1_168ck1920 FIND v(dout1_168) AT=1930.05n

.meas tran vdout1_169ck1920 FIND v(dout1_169) AT=1930.05n

.meas tran vdout1_170ck1920 FIND v(dout1_170) AT=1930.05n

.meas tran vdout1_171ck1920 FIND v(dout1_171) AT=1930.05n

.meas tran vdout1_172ck1920 FIND v(dout1_172) AT=1930.05n

.meas tran vdout1_173ck1920 FIND v(dout1_173) AT=1930.05n

.meas tran vdout1_174ck1920 FIND v(dout1_174) AT=1930.05n

.meas tran vdout1_175ck1920 FIND v(dout1_175) AT=1930.05n

.meas tran vdout1_176ck1920 FIND v(dout1_176) AT=1930.05n

.meas tran vdout1_177ck1920 FIND v(dout1_177) AT=1930.05n

.meas tran vdout1_178ck1920 FIND v(dout1_178) AT=1930.05n

.meas tran vdout1_179ck1920 FIND v(dout1_179) AT=1930.05n

.meas tran vdout1_180ck1920 FIND v(dout1_180) AT=1930.05n

.meas tran vdout1_181ck1920 FIND v(dout1_181) AT=1930.05n

.meas tran vdout1_182ck1920 FIND v(dout1_182) AT=1930.05n

.meas tran vdout1_183ck1920 FIND v(dout1_183) AT=1930.05n

.meas tran vdout1_184ck1920 FIND v(dout1_184) AT=1930.05n

.meas tran vdout1_185ck1920 FIND v(dout1_185) AT=1930.05n

.meas tran vdout1_186ck1920 FIND v(dout1_186) AT=1930.05n

.meas tran vdout1_187ck1920 FIND v(dout1_187) AT=1930.05n

.meas tran vdout1_188ck1920 FIND v(dout1_188) AT=1930.05n

.meas tran vdout1_189ck1920 FIND v(dout1_189) AT=1930.05n

.meas tran vdout1_190ck1920 FIND v(dout1_190) AT=1930.05n

.meas tran vdout1_191ck1920 FIND v(dout1_191) AT=1930.05n

.meas tran vdout1_192ck1920 FIND v(dout1_192) AT=1930.05n

.meas tran vdout1_193ck1920 FIND v(dout1_193) AT=1930.05n

.meas tran vdout1_194ck1920 FIND v(dout1_194) AT=1930.05n

.meas tran vdout1_195ck1920 FIND v(dout1_195) AT=1930.05n

.meas tran vdout1_196ck1920 FIND v(dout1_196) AT=1930.05n

.meas tran vdout1_197ck1920 FIND v(dout1_197) AT=1930.05n

.meas tran vdout1_198ck1920 FIND v(dout1_198) AT=1930.05n

.meas tran vdout1_199ck1920 FIND v(dout1_199) AT=1930.05n

.meas tran vdout1_200ck1920 FIND v(dout1_200) AT=1930.05n

.meas tran vdout1_201ck1920 FIND v(dout1_201) AT=1930.05n

.meas tran vdout1_202ck1920 FIND v(dout1_202) AT=1930.05n

.meas tran vdout1_203ck1920 FIND v(dout1_203) AT=1930.05n

.meas tran vdout1_204ck1920 FIND v(dout1_204) AT=1930.05n

.meas tran vdout1_205ck1920 FIND v(dout1_205) AT=1930.05n

.meas tran vdout1_206ck1920 FIND v(dout1_206) AT=1930.05n

.meas tran vdout1_207ck1920 FIND v(dout1_207) AT=1930.05n

.meas tran vdout1_208ck1920 FIND v(dout1_208) AT=1930.05n

.meas tran vdout1_209ck1920 FIND v(dout1_209) AT=1930.05n

.meas tran vdout1_210ck1920 FIND v(dout1_210) AT=1930.05n

.meas tran vdout1_211ck1920 FIND v(dout1_211) AT=1930.05n

.meas tran vdout1_212ck1920 FIND v(dout1_212) AT=1930.05n

.meas tran vdout1_213ck1920 FIND v(dout1_213) AT=1930.05n

.meas tran vdout1_214ck1920 FIND v(dout1_214) AT=1930.05n

.meas tran vdout1_215ck1920 FIND v(dout1_215) AT=1930.05n

.meas tran vdout1_216ck1920 FIND v(dout1_216) AT=1930.05n

.meas tran vdout1_217ck1920 FIND v(dout1_217) AT=1930.05n

.meas tran vdout1_218ck1920 FIND v(dout1_218) AT=1930.05n

.meas tran vdout1_219ck1920 FIND v(dout1_219) AT=1930.05n

.meas tran vdout1_220ck1920 FIND v(dout1_220) AT=1930.05n

.meas tran vdout1_221ck1920 FIND v(dout1_221) AT=1930.05n

.meas tran vdout1_222ck1920 FIND v(dout1_222) AT=1930.05n

.meas tran vdout1_223ck1920 FIND v(dout1_223) AT=1930.05n

.meas tran vdout1_224ck1920 FIND v(dout1_224) AT=1930.05n

.meas tran vdout1_225ck1920 FIND v(dout1_225) AT=1930.05n

.meas tran vdout1_226ck1920 FIND v(dout1_226) AT=1930.05n

.meas tran vdout1_227ck1920 FIND v(dout1_227) AT=1930.05n

.meas tran vdout1_228ck1920 FIND v(dout1_228) AT=1930.05n

.meas tran vdout1_229ck1920 FIND v(dout1_229) AT=1930.05n

.meas tran vdout1_230ck1920 FIND v(dout1_230) AT=1930.05n

.meas tran vdout1_231ck1920 FIND v(dout1_231) AT=1930.05n

.meas tran vdout1_232ck1920 FIND v(dout1_232) AT=1930.05n

.meas tran vdout1_233ck1920 FIND v(dout1_233) AT=1930.05n

.meas tran vdout1_234ck1920 FIND v(dout1_234) AT=1930.05n

.meas tran vdout1_235ck1920 FIND v(dout1_235) AT=1930.05n

.meas tran vdout1_236ck1920 FIND v(dout1_236) AT=1930.05n

.meas tran vdout1_237ck1920 FIND v(dout1_237) AT=1930.05n

.meas tran vdout1_238ck1920 FIND v(dout1_238) AT=1930.05n

.meas tran vdout1_239ck1920 FIND v(dout1_239) AT=1930.05n

.meas tran vdout1_240ck1920 FIND v(dout1_240) AT=1930.05n

.meas tran vdout1_241ck1920 FIND v(dout1_241) AT=1930.05n

.meas tran vdout1_242ck1920 FIND v(dout1_242) AT=1930.05n

.meas tran vdout1_243ck1920 FIND v(dout1_243) AT=1930.05n

.meas tran vdout1_244ck1920 FIND v(dout1_244) AT=1930.05n

.meas tran vdout1_245ck1920 FIND v(dout1_245) AT=1930.05n

.meas tran vdout1_246ck1920 FIND v(dout1_246) AT=1930.05n

.meas tran vdout1_247ck1920 FIND v(dout1_247) AT=1930.05n

.meas tran vdout1_248ck1920 FIND v(dout1_248) AT=1930.05n

.meas tran vdout1_249ck1920 FIND v(dout1_249) AT=1930.05n

.meas tran vdout1_250ck1920 FIND v(dout1_250) AT=1930.05n

.meas tran vdout1_251ck1920 FIND v(dout1_251) AT=1930.05n

.meas tran vdout1_252ck1920 FIND v(dout1_252) AT=1930.05n

.meas tran vdout1_253ck1920 FIND v(dout1_253) AT=1930.05n

.meas tran vdout1_254ck1920 FIND v(dout1_254) AT=1930.05n

.meas tran vdout1_255ck1920 FIND v(dout1_255) AT=1930.05n

.meas tran vdout1_256ck1920 FIND v(dout1_256) AT=1930.05n

.meas tran vdout1_0ck1940 FIND v(dout1_0) AT=1950.05n

.meas tran vdout1_1ck1940 FIND v(dout1_1) AT=1950.05n

.meas tran vdout1_2ck1940 FIND v(dout1_2) AT=1950.05n

.meas tran vdout1_3ck1940 FIND v(dout1_3) AT=1950.05n

.meas tran vdout1_4ck1940 FIND v(dout1_4) AT=1950.05n

.meas tran vdout1_5ck1940 FIND v(dout1_5) AT=1950.05n

.meas tran vdout1_6ck1940 FIND v(dout1_6) AT=1950.05n

.meas tran vdout1_7ck1940 FIND v(dout1_7) AT=1950.05n

.meas tran vdout1_8ck1940 FIND v(dout1_8) AT=1950.05n

.meas tran vdout1_9ck1940 FIND v(dout1_9) AT=1950.05n

.meas tran vdout1_10ck1940 FIND v(dout1_10) AT=1950.05n

.meas tran vdout1_11ck1940 FIND v(dout1_11) AT=1950.05n

.meas tran vdout1_12ck1940 FIND v(dout1_12) AT=1950.05n

.meas tran vdout1_13ck1940 FIND v(dout1_13) AT=1950.05n

.meas tran vdout1_14ck1940 FIND v(dout1_14) AT=1950.05n

.meas tran vdout1_15ck1940 FIND v(dout1_15) AT=1950.05n

.meas tran vdout1_16ck1940 FIND v(dout1_16) AT=1950.05n

.meas tran vdout1_17ck1940 FIND v(dout1_17) AT=1950.05n

.meas tran vdout1_18ck1940 FIND v(dout1_18) AT=1950.05n

.meas tran vdout1_19ck1940 FIND v(dout1_19) AT=1950.05n

.meas tran vdout1_20ck1940 FIND v(dout1_20) AT=1950.05n

.meas tran vdout1_21ck1940 FIND v(dout1_21) AT=1950.05n

.meas tran vdout1_22ck1940 FIND v(dout1_22) AT=1950.05n

.meas tran vdout1_23ck1940 FIND v(dout1_23) AT=1950.05n

.meas tran vdout1_24ck1940 FIND v(dout1_24) AT=1950.05n

.meas tran vdout1_25ck1940 FIND v(dout1_25) AT=1950.05n

.meas tran vdout1_26ck1940 FIND v(dout1_26) AT=1950.05n

.meas tran vdout1_27ck1940 FIND v(dout1_27) AT=1950.05n

.meas tran vdout1_28ck1940 FIND v(dout1_28) AT=1950.05n

.meas tran vdout1_29ck1940 FIND v(dout1_29) AT=1950.05n

.meas tran vdout1_30ck1940 FIND v(dout1_30) AT=1950.05n

.meas tran vdout1_31ck1940 FIND v(dout1_31) AT=1950.05n

.meas tran vdout1_32ck1940 FIND v(dout1_32) AT=1950.05n

.meas tran vdout1_33ck1940 FIND v(dout1_33) AT=1950.05n

.meas tran vdout1_34ck1940 FIND v(dout1_34) AT=1950.05n

.meas tran vdout1_35ck1940 FIND v(dout1_35) AT=1950.05n

.meas tran vdout1_36ck1940 FIND v(dout1_36) AT=1950.05n

.meas tran vdout1_37ck1940 FIND v(dout1_37) AT=1950.05n

.meas tran vdout1_38ck1940 FIND v(dout1_38) AT=1950.05n

.meas tran vdout1_39ck1940 FIND v(dout1_39) AT=1950.05n

.meas tran vdout1_40ck1940 FIND v(dout1_40) AT=1950.05n

.meas tran vdout1_41ck1940 FIND v(dout1_41) AT=1950.05n

.meas tran vdout1_42ck1940 FIND v(dout1_42) AT=1950.05n

.meas tran vdout1_43ck1940 FIND v(dout1_43) AT=1950.05n

.meas tran vdout1_44ck1940 FIND v(dout1_44) AT=1950.05n

.meas tran vdout1_45ck1940 FIND v(dout1_45) AT=1950.05n

.meas tran vdout1_46ck1940 FIND v(dout1_46) AT=1950.05n

.meas tran vdout1_47ck1940 FIND v(dout1_47) AT=1950.05n

.meas tran vdout1_48ck1940 FIND v(dout1_48) AT=1950.05n

.meas tran vdout1_49ck1940 FIND v(dout1_49) AT=1950.05n

.meas tran vdout1_50ck1940 FIND v(dout1_50) AT=1950.05n

.meas tran vdout1_51ck1940 FIND v(dout1_51) AT=1950.05n

.meas tran vdout1_52ck1940 FIND v(dout1_52) AT=1950.05n

.meas tran vdout1_53ck1940 FIND v(dout1_53) AT=1950.05n

.meas tran vdout1_54ck1940 FIND v(dout1_54) AT=1950.05n

.meas tran vdout1_55ck1940 FIND v(dout1_55) AT=1950.05n

.meas tran vdout1_56ck1940 FIND v(dout1_56) AT=1950.05n

.meas tran vdout1_57ck1940 FIND v(dout1_57) AT=1950.05n

.meas tran vdout1_58ck1940 FIND v(dout1_58) AT=1950.05n

.meas tran vdout1_59ck1940 FIND v(dout1_59) AT=1950.05n

.meas tran vdout1_60ck1940 FIND v(dout1_60) AT=1950.05n

.meas tran vdout1_61ck1940 FIND v(dout1_61) AT=1950.05n

.meas tran vdout1_62ck1940 FIND v(dout1_62) AT=1950.05n

.meas tran vdout1_63ck1940 FIND v(dout1_63) AT=1950.05n

.meas tran vdout1_64ck1940 FIND v(dout1_64) AT=1950.05n

.meas tran vdout1_65ck1940 FIND v(dout1_65) AT=1950.05n

.meas tran vdout1_66ck1940 FIND v(dout1_66) AT=1950.05n

.meas tran vdout1_67ck1940 FIND v(dout1_67) AT=1950.05n

.meas tran vdout1_68ck1940 FIND v(dout1_68) AT=1950.05n

.meas tran vdout1_69ck1940 FIND v(dout1_69) AT=1950.05n

.meas tran vdout1_70ck1940 FIND v(dout1_70) AT=1950.05n

.meas tran vdout1_71ck1940 FIND v(dout1_71) AT=1950.05n

.meas tran vdout1_72ck1940 FIND v(dout1_72) AT=1950.05n

.meas tran vdout1_73ck1940 FIND v(dout1_73) AT=1950.05n

.meas tran vdout1_74ck1940 FIND v(dout1_74) AT=1950.05n

.meas tran vdout1_75ck1940 FIND v(dout1_75) AT=1950.05n

.meas tran vdout1_76ck1940 FIND v(dout1_76) AT=1950.05n

.meas tran vdout1_77ck1940 FIND v(dout1_77) AT=1950.05n

.meas tran vdout1_78ck1940 FIND v(dout1_78) AT=1950.05n

.meas tran vdout1_79ck1940 FIND v(dout1_79) AT=1950.05n

.meas tran vdout1_80ck1940 FIND v(dout1_80) AT=1950.05n

.meas tran vdout1_81ck1940 FIND v(dout1_81) AT=1950.05n

.meas tran vdout1_82ck1940 FIND v(dout1_82) AT=1950.05n

.meas tran vdout1_83ck1940 FIND v(dout1_83) AT=1950.05n

.meas tran vdout1_84ck1940 FIND v(dout1_84) AT=1950.05n

.meas tran vdout1_85ck1940 FIND v(dout1_85) AT=1950.05n

.meas tran vdout1_86ck1940 FIND v(dout1_86) AT=1950.05n

.meas tran vdout1_87ck1940 FIND v(dout1_87) AT=1950.05n

.meas tran vdout1_88ck1940 FIND v(dout1_88) AT=1950.05n

.meas tran vdout1_89ck1940 FIND v(dout1_89) AT=1950.05n

.meas tran vdout1_90ck1940 FIND v(dout1_90) AT=1950.05n

.meas tran vdout1_91ck1940 FIND v(dout1_91) AT=1950.05n

.meas tran vdout1_92ck1940 FIND v(dout1_92) AT=1950.05n

.meas tran vdout1_93ck1940 FIND v(dout1_93) AT=1950.05n

.meas tran vdout1_94ck1940 FIND v(dout1_94) AT=1950.05n

.meas tran vdout1_95ck1940 FIND v(dout1_95) AT=1950.05n

.meas tran vdout1_96ck1940 FIND v(dout1_96) AT=1950.05n

.meas tran vdout1_97ck1940 FIND v(dout1_97) AT=1950.05n

.meas tran vdout1_98ck1940 FIND v(dout1_98) AT=1950.05n

.meas tran vdout1_99ck1940 FIND v(dout1_99) AT=1950.05n

.meas tran vdout1_100ck1940 FIND v(dout1_100) AT=1950.05n

.meas tran vdout1_101ck1940 FIND v(dout1_101) AT=1950.05n

.meas tran vdout1_102ck1940 FIND v(dout1_102) AT=1950.05n

.meas tran vdout1_103ck1940 FIND v(dout1_103) AT=1950.05n

.meas tran vdout1_104ck1940 FIND v(dout1_104) AT=1950.05n

.meas tran vdout1_105ck1940 FIND v(dout1_105) AT=1950.05n

.meas tran vdout1_106ck1940 FIND v(dout1_106) AT=1950.05n

.meas tran vdout1_107ck1940 FIND v(dout1_107) AT=1950.05n

.meas tran vdout1_108ck1940 FIND v(dout1_108) AT=1950.05n

.meas tran vdout1_109ck1940 FIND v(dout1_109) AT=1950.05n

.meas tran vdout1_110ck1940 FIND v(dout1_110) AT=1950.05n

.meas tran vdout1_111ck1940 FIND v(dout1_111) AT=1950.05n

.meas tran vdout1_112ck1940 FIND v(dout1_112) AT=1950.05n

.meas tran vdout1_113ck1940 FIND v(dout1_113) AT=1950.05n

.meas tran vdout1_114ck1940 FIND v(dout1_114) AT=1950.05n

.meas tran vdout1_115ck1940 FIND v(dout1_115) AT=1950.05n

.meas tran vdout1_116ck1940 FIND v(dout1_116) AT=1950.05n

.meas tran vdout1_117ck1940 FIND v(dout1_117) AT=1950.05n

.meas tran vdout1_118ck1940 FIND v(dout1_118) AT=1950.05n

.meas tran vdout1_119ck1940 FIND v(dout1_119) AT=1950.05n

.meas tran vdout1_120ck1940 FIND v(dout1_120) AT=1950.05n

.meas tran vdout1_121ck1940 FIND v(dout1_121) AT=1950.05n

.meas tran vdout1_122ck1940 FIND v(dout1_122) AT=1950.05n

.meas tran vdout1_123ck1940 FIND v(dout1_123) AT=1950.05n

.meas tran vdout1_124ck1940 FIND v(dout1_124) AT=1950.05n

.meas tran vdout1_125ck1940 FIND v(dout1_125) AT=1950.05n

.meas tran vdout1_126ck1940 FIND v(dout1_126) AT=1950.05n

.meas tran vdout1_127ck1940 FIND v(dout1_127) AT=1950.05n

.meas tran vdout1_128ck1940 FIND v(dout1_128) AT=1950.05n

.meas tran vdout1_129ck1940 FIND v(dout1_129) AT=1950.05n

.meas tran vdout1_130ck1940 FIND v(dout1_130) AT=1950.05n

.meas tran vdout1_131ck1940 FIND v(dout1_131) AT=1950.05n

.meas tran vdout1_132ck1940 FIND v(dout1_132) AT=1950.05n

.meas tran vdout1_133ck1940 FIND v(dout1_133) AT=1950.05n

.meas tran vdout1_134ck1940 FIND v(dout1_134) AT=1950.05n

.meas tran vdout1_135ck1940 FIND v(dout1_135) AT=1950.05n

.meas tran vdout1_136ck1940 FIND v(dout1_136) AT=1950.05n

.meas tran vdout1_137ck1940 FIND v(dout1_137) AT=1950.05n

.meas tran vdout1_138ck1940 FIND v(dout1_138) AT=1950.05n

.meas tran vdout1_139ck1940 FIND v(dout1_139) AT=1950.05n

.meas tran vdout1_140ck1940 FIND v(dout1_140) AT=1950.05n

.meas tran vdout1_141ck1940 FIND v(dout1_141) AT=1950.05n

.meas tran vdout1_142ck1940 FIND v(dout1_142) AT=1950.05n

.meas tran vdout1_143ck1940 FIND v(dout1_143) AT=1950.05n

.meas tran vdout1_144ck1940 FIND v(dout1_144) AT=1950.05n

.meas tran vdout1_145ck1940 FIND v(dout1_145) AT=1950.05n

.meas tran vdout1_146ck1940 FIND v(dout1_146) AT=1950.05n

.meas tran vdout1_147ck1940 FIND v(dout1_147) AT=1950.05n

.meas tran vdout1_148ck1940 FIND v(dout1_148) AT=1950.05n

.meas tran vdout1_149ck1940 FIND v(dout1_149) AT=1950.05n

.meas tran vdout1_150ck1940 FIND v(dout1_150) AT=1950.05n

.meas tran vdout1_151ck1940 FIND v(dout1_151) AT=1950.05n

.meas tran vdout1_152ck1940 FIND v(dout1_152) AT=1950.05n

.meas tran vdout1_153ck1940 FIND v(dout1_153) AT=1950.05n

.meas tran vdout1_154ck1940 FIND v(dout1_154) AT=1950.05n

.meas tran vdout1_155ck1940 FIND v(dout1_155) AT=1950.05n

.meas tran vdout1_156ck1940 FIND v(dout1_156) AT=1950.05n

.meas tran vdout1_157ck1940 FIND v(dout1_157) AT=1950.05n

.meas tran vdout1_158ck1940 FIND v(dout1_158) AT=1950.05n

.meas tran vdout1_159ck1940 FIND v(dout1_159) AT=1950.05n

.meas tran vdout1_160ck1940 FIND v(dout1_160) AT=1950.05n

.meas tran vdout1_161ck1940 FIND v(dout1_161) AT=1950.05n

.meas tran vdout1_162ck1940 FIND v(dout1_162) AT=1950.05n

.meas tran vdout1_163ck1940 FIND v(dout1_163) AT=1950.05n

.meas tran vdout1_164ck1940 FIND v(dout1_164) AT=1950.05n

.meas tran vdout1_165ck1940 FIND v(dout1_165) AT=1950.05n

.meas tran vdout1_166ck1940 FIND v(dout1_166) AT=1950.05n

.meas tran vdout1_167ck1940 FIND v(dout1_167) AT=1950.05n

.meas tran vdout1_168ck1940 FIND v(dout1_168) AT=1950.05n

.meas tran vdout1_169ck1940 FIND v(dout1_169) AT=1950.05n

.meas tran vdout1_170ck1940 FIND v(dout1_170) AT=1950.05n

.meas tran vdout1_171ck1940 FIND v(dout1_171) AT=1950.05n

.meas tran vdout1_172ck1940 FIND v(dout1_172) AT=1950.05n

.meas tran vdout1_173ck1940 FIND v(dout1_173) AT=1950.05n

.meas tran vdout1_174ck1940 FIND v(dout1_174) AT=1950.05n

.meas tran vdout1_175ck1940 FIND v(dout1_175) AT=1950.05n

.meas tran vdout1_176ck1940 FIND v(dout1_176) AT=1950.05n

.meas tran vdout1_177ck1940 FIND v(dout1_177) AT=1950.05n

.meas tran vdout1_178ck1940 FIND v(dout1_178) AT=1950.05n

.meas tran vdout1_179ck1940 FIND v(dout1_179) AT=1950.05n

.meas tran vdout1_180ck1940 FIND v(dout1_180) AT=1950.05n

.meas tran vdout1_181ck1940 FIND v(dout1_181) AT=1950.05n

.meas tran vdout1_182ck1940 FIND v(dout1_182) AT=1950.05n

.meas tran vdout1_183ck1940 FIND v(dout1_183) AT=1950.05n

.meas tran vdout1_184ck1940 FIND v(dout1_184) AT=1950.05n

.meas tran vdout1_185ck1940 FIND v(dout1_185) AT=1950.05n

.meas tran vdout1_186ck1940 FIND v(dout1_186) AT=1950.05n

.meas tran vdout1_187ck1940 FIND v(dout1_187) AT=1950.05n

.meas tran vdout1_188ck1940 FIND v(dout1_188) AT=1950.05n

.meas tran vdout1_189ck1940 FIND v(dout1_189) AT=1950.05n

.meas tran vdout1_190ck1940 FIND v(dout1_190) AT=1950.05n

.meas tran vdout1_191ck1940 FIND v(dout1_191) AT=1950.05n

.meas tran vdout1_192ck1940 FIND v(dout1_192) AT=1950.05n

.meas tran vdout1_193ck1940 FIND v(dout1_193) AT=1950.05n

.meas tran vdout1_194ck1940 FIND v(dout1_194) AT=1950.05n

.meas tran vdout1_195ck1940 FIND v(dout1_195) AT=1950.05n

.meas tran vdout1_196ck1940 FIND v(dout1_196) AT=1950.05n

.meas tran vdout1_197ck1940 FIND v(dout1_197) AT=1950.05n

.meas tran vdout1_198ck1940 FIND v(dout1_198) AT=1950.05n

.meas tran vdout1_199ck1940 FIND v(dout1_199) AT=1950.05n

.meas tran vdout1_200ck1940 FIND v(dout1_200) AT=1950.05n

.meas tran vdout1_201ck1940 FIND v(dout1_201) AT=1950.05n

.meas tran vdout1_202ck1940 FIND v(dout1_202) AT=1950.05n

.meas tran vdout1_203ck1940 FIND v(dout1_203) AT=1950.05n

.meas tran vdout1_204ck1940 FIND v(dout1_204) AT=1950.05n

.meas tran vdout1_205ck1940 FIND v(dout1_205) AT=1950.05n

.meas tran vdout1_206ck1940 FIND v(dout1_206) AT=1950.05n

.meas tran vdout1_207ck1940 FIND v(dout1_207) AT=1950.05n

.meas tran vdout1_208ck1940 FIND v(dout1_208) AT=1950.05n

.meas tran vdout1_209ck1940 FIND v(dout1_209) AT=1950.05n

.meas tran vdout1_210ck1940 FIND v(dout1_210) AT=1950.05n

.meas tran vdout1_211ck1940 FIND v(dout1_211) AT=1950.05n

.meas tran vdout1_212ck1940 FIND v(dout1_212) AT=1950.05n

.meas tran vdout1_213ck1940 FIND v(dout1_213) AT=1950.05n

.meas tran vdout1_214ck1940 FIND v(dout1_214) AT=1950.05n

.meas tran vdout1_215ck1940 FIND v(dout1_215) AT=1950.05n

.meas tran vdout1_216ck1940 FIND v(dout1_216) AT=1950.05n

.meas tran vdout1_217ck1940 FIND v(dout1_217) AT=1950.05n

.meas tran vdout1_218ck1940 FIND v(dout1_218) AT=1950.05n

.meas tran vdout1_219ck1940 FIND v(dout1_219) AT=1950.05n

.meas tran vdout1_220ck1940 FIND v(dout1_220) AT=1950.05n

.meas tran vdout1_221ck1940 FIND v(dout1_221) AT=1950.05n

.meas tran vdout1_222ck1940 FIND v(dout1_222) AT=1950.05n

.meas tran vdout1_223ck1940 FIND v(dout1_223) AT=1950.05n

.meas tran vdout1_224ck1940 FIND v(dout1_224) AT=1950.05n

.meas tran vdout1_225ck1940 FIND v(dout1_225) AT=1950.05n

.meas tran vdout1_226ck1940 FIND v(dout1_226) AT=1950.05n

.meas tran vdout1_227ck1940 FIND v(dout1_227) AT=1950.05n

.meas tran vdout1_228ck1940 FIND v(dout1_228) AT=1950.05n

.meas tran vdout1_229ck1940 FIND v(dout1_229) AT=1950.05n

.meas tran vdout1_230ck1940 FIND v(dout1_230) AT=1950.05n

.meas tran vdout1_231ck1940 FIND v(dout1_231) AT=1950.05n

.meas tran vdout1_232ck1940 FIND v(dout1_232) AT=1950.05n

.meas tran vdout1_233ck1940 FIND v(dout1_233) AT=1950.05n

.meas tran vdout1_234ck1940 FIND v(dout1_234) AT=1950.05n

.meas tran vdout1_235ck1940 FIND v(dout1_235) AT=1950.05n

.meas tran vdout1_236ck1940 FIND v(dout1_236) AT=1950.05n

.meas tran vdout1_237ck1940 FIND v(dout1_237) AT=1950.05n

.meas tran vdout1_238ck1940 FIND v(dout1_238) AT=1950.05n

.meas tran vdout1_239ck1940 FIND v(dout1_239) AT=1950.05n

.meas tran vdout1_240ck1940 FIND v(dout1_240) AT=1950.05n

.meas tran vdout1_241ck1940 FIND v(dout1_241) AT=1950.05n

.meas tran vdout1_242ck1940 FIND v(dout1_242) AT=1950.05n

.meas tran vdout1_243ck1940 FIND v(dout1_243) AT=1950.05n

.meas tran vdout1_244ck1940 FIND v(dout1_244) AT=1950.05n

.meas tran vdout1_245ck1940 FIND v(dout1_245) AT=1950.05n

.meas tran vdout1_246ck1940 FIND v(dout1_246) AT=1950.05n

.meas tran vdout1_247ck1940 FIND v(dout1_247) AT=1950.05n

.meas tran vdout1_248ck1940 FIND v(dout1_248) AT=1950.05n

.meas tran vdout1_249ck1940 FIND v(dout1_249) AT=1950.05n

.meas tran vdout1_250ck1940 FIND v(dout1_250) AT=1950.05n

.meas tran vdout1_251ck1940 FIND v(dout1_251) AT=1950.05n

.meas tran vdout1_252ck1940 FIND v(dout1_252) AT=1950.05n

.meas tran vdout1_253ck1940 FIND v(dout1_253) AT=1950.05n

.meas tran vdout1_254ck1940 FIND v(dout1_254) AT=1950.05n

.meas tran vdout1_255ck1940 FIND v(dout1_255) AT=1950.05n

.meas tran vdout1_256ck1940 FIND v(dout1_256) AT=1950.05n

.meas tran vdout1_0ck1960 FIND v(dout1_0) AT=1970.05n

.meas tran vdout1_1ck1960 FIND v(dout1_1) AT=1970.05n

.meas tran vdout1_2ck1960 FIND v(dout1_2) AT=1970.05n

.meas tran vdout1_3ck1960 FIND v(dout1_3) AT=1970.05n

.meas tran vdout1_4ck1960 FIND v(dout1_4) AT=1970.05n

.meas tran vdout1_5ck1960 FIND v(dout1_5) AT=1970.05n

.meas tran vdout1_6ck1960 FIND v(dout1_6) AT=1970.05n

.meas tran vdout1_7ck1960 FIND v(dout1_7) AT=1970.05n

.meas tran vdout1_8ck1960 FIND v(dout1_8) AT=1970.05n

.meas tran vdout1_9ck1960 FIND v(dout1_9) AT=1970.05n

.meas tran vdout1_10ck1960 FIND v(dout1_10) AT=1970.05n

.meas tran vdout1_11ck1960 FIND v(dout1_11) AT=1970.05n

.meas tran vdout1_12ck1960 FIND v(dout1_12) AT=1970.05n

.meas tran vdout1_13ck1960 FIND v(dout1_13) AT=1970.05n

.meas tran vdout1_14ck1960 FIND v(dout1_14) AT=1970.05n

.meas tran vdout1_15ck1960 FIND v(dout1_15) AT=1970.05n

.meas tran vdout1_16ck1960 FIND v(dout1_16) AT=1970.05n

.meas tran vdout1_17ck1960 FIND v(dout1_17) AT=1970.05n

.meas tran vdout1_18ck1960 FIND v(dout1_18) AT=1970.05n

.meas tran vdout1_19ck1960 FIND v(dout1_19) AT=1970.05n

.meas tran vdout1_20ck1960 FIND v(dout1_20) AT=1970.05n

.meas tran vdout1_21ck1960 FIND v(dout1_21) AT=1970.05n

.meas tran vdout1_22ck1960 FIND v(dout1_22) AT=1970.05n

.meas tran vdout1_23ck1960 FIND v(dout1_23) AT=1970.05n

.meas tran vdout1_24ck1960 FIND v(dout1_24) AT=1970.05n

.meas tran vdout1_25ck1960 FIND v(dout1_25) AT=1970.05n

.meas tran vdout1_26ck1960 FIND v(dout1_26) AT=1970.05n

.meas tran vdout1_27ck1960 FIND v(dout1_27) AT=1970.05n

.meas tran vdout1_28ck1960 FIND v(dout1_28) AT=1970.05n

.meas tran vdout1_29ck1960 FIND v(dout1_29) AT=1970.05n

.meas tran vdout1_30ck1960 FIND v(dout1_30) AT=1970.05n

.meas tran vdout1_31ck1960 FIND v(dout1_31) AT=1970.05n

.meas tran vdout1_32ck1960 FIND v(dout1_32) AT=1970.05n

.meas tran vdout1_33ck1960 FIND v(dout1_33) AT=1970.05n

.meas tran vdout1_34ck1960 FIND v(dout1_34) AT=1970.05n

.meas tran vdout1_35ck1960 FIND v(dout1_35) AT=1970.05n

.meas tran vdout1_36ck1960 FIND v(dout1_36) AT=1970.05n

.meas tran vdout1_37ck1960 FIND v(dout1_37) AT=1970.05n

.meas tran vdout1_38ck1960 FIND v(dout1_38) AT=1970.05n

.meas tran vdout1_39ck1960 FIND v(dout1_39) AT=1970.05n

.meas tran vdout1_40ck1960 FIND v(dout1_40) AT=1970.05n

.meas tran vdout1_41ck1960 FIND v(dout1_41) AT=1970.05n

.meas tran vdout1_42ck1960 FIND v(dout1_42) AT=1970.05n

.meas tran vdout1_43ck1960 FIND v(dout1_43) AT=1970.05n

.meas tran vdout1_44ck1960 FIND v(dout1_44) AT=1970.05n

.meas tran vdout1_45ck1960 FIND v(dout1_45) AT=1970.05n

.meas tran vdout1_46ck1960 FIND v(dout1_46) AT=1970.05n

.meas tran vdout1_47ck1960 FIND v(dout1_47) AT=1970.05n

.meas tran vdout1_48ck1960 FIND v(dout1_48) AT=1970.05n

.meas tran vdout1_49ck1960 FIND v(dout1_49) AT=1970.05n

.meas tran vdout1_50ck1960 FIND v(dout1_50) AT=1970.05n

.meas tran vdout1_51ck1960 FIND v(dout1_51) AT=1970.05n

.meas tran vdout1_52ck1960 FIND v(dout1_52) AT=1970.05n

.meas tran vdout1_53ck1960 FIND v(dout1_53) AT=1970.05n

.meas tran vdout1_54ck1960 FIND v(dout1_54) AT=1970.05n

.meas tran vdout1_55ck1960 FIND v(dout1_55) AT=1970.05n

.meas tran vdout1_56ck1960 FIND v(dout1_56) AT=1970.05n

.meas tran vdout1_57ck1960 FIND v(dout1_57) AT=1970.05n

.meas tran vdout1_58ck1960 FIND v(dout1_58) AT=1970.05n

.meas tran vdout1_59ck1960 FIND v(dout1_59) AT=1970.05n

.meas tran vdout1_60ck1960 FIND v(dout1_60) AT=1970.05n

.meas tran vdout1_61ck1960 FIND v(dout1_61) AT=1970.05n

.meas tran vdout1_62ck1960 FIND v(dout1_62) AT=1970.05n

.meas tran vdout1_63ck1960 FIND v(dout1_63) AT=1970.05n

.meas tran vdout1_64ck1960 FIND v(dout1_64) AT=1970.05n

.meas tran vdout1_65ck1960 FIND v(dout1_65) AT=1970.05n

.meas tran vdout1_66ck1960 FIND v(dout1_66) AT=1970.05n

.meas tran vdout1_67ck1960 FIND v(dout1_67) AT=1970.05n

.meas tran vdout1_68ck1960 FIND v(dout1_68) AT=1970.05n

.meas tran vdout1_69ck1960 FIND v(dout1_69) AT=1970.05n

.meas tran vdout1_70ck1960 FIND v(dout1_70) AT=1970.05n

.meas tran vdout1_71ck1960 FIND v(dout1_71) AT=1970.05n

.meas tran vdout1_72ck1960 FIND v(dout1_72) AT=1970.05n

.meas tran vdout1_73ck1960 FIND v(dout1_73) AT=1970.05n

.meas tran vdout1_74ck1960 FIND v(dout1_74) AT=1970.05n

.meas tran vdout1_75ck1960 FIND v(dout1_75) AT=1970.05n

.meas tran vdout1_76ck1960 FIND v(dout1_76) AT=1970.05n

.meas tran vdout1_77ck1960 FIND v(dout1_77) AT=1970.05n

.meas tran vdout1_78ck1960 FIND v(dout1_78) AT=1970.05n

.meas tran vdout1_79ck1960 FIND v(dout1_79) AT=1970.05n

.meas tran vdout1_80ck1960 FIND v(dout1_80) AT=1970.05n

.meas tran vdout1_81ck1960 FIND v(dout1_81) AT=1970.05n

.meas tran vdout1_82ck1960 FIND v(dout1_82) AT=1970.05n

.meas tran vdout1_83ck1960 FIND v(dout1_83) AT=1970.05n

.meas tran vdout1_84ck1960 FIND v(dout1_84) AT=1970.05n

.meas tran vdout1_85ck1960 FIND v(dout1_85) AT=1970.05n

.meas tran vdout1_86ck1960 FIND v(dout1_86) AT=1970.05n

.meas tran vdout1_87ck1960 FIND v(dout1_87) AT=1970.05n

.meas tran vdout1_88ck1960 FIND v(dout1_88) AT=1970.05n

.meas tran vdout1_89ck1960 FIND v(dout1_89) AT=1970.05n

.meas tran vdout1_90ck1960 FIND v(dout1_90) AT=1970.05n

.meas tran vdout1_91ck1960 FIND v(dout1_91) AT=1970.05n

.meas tran vdout1_92ck1960 FIND v(dout1_92) AT=1970.05n

.meas tran vdout1_93ck1960 FIND v(dout1_93) AT=1970.05n

.meas tran vdout1_94ck1960 FIND v(dout1_94) AT=1970.05n

.meas tran vdout1_95ck1960 FIND v(dout1_95) AT=1970.05n

.meas tran vdout1_96ck1960 FIND v(dout1_96) AT=1970.05n

.meas tran vdout1_97ck1960 FIND v(dout1_97) AT=1970.05n

.meas tran vdout1_98ck1960 FIND v(dout1_98) AT=1970.05n

.meas tran vdout1_99ck1960 FIND v(dout1_99) AT=1970.05n

.meas tran vdout1_100ck1960 FIND v(dout1_100) AT=1970.05n

.meas tran vdout1_101ck1960 FIND v(dout1_101) AT=1970.05n

.meas tran vdout1_102ck1960 FIND v(dout1_102) AT=1970.05n

.meas tran vdout1_103ck1960 FIND v(dout1_103) AT=1970.05n

.meas tran vdout1_104ck1960 FIND v(dout1_104) AT=1970.05n

.meas tran vdout1_105ck1960 FIND v(dout1_105) AT=1970.05n

.meas tran vdout1_106ck1960 FIND v(dout1_106) AT=1970.05n

.meas tran vdout1_107ck1960 FIND v(dout1_107) AT=1970.05n

.meas tran vdout1_108ck1960 FIND v(dout1_108) AT=1970.05n

.meas tran vdout1_109ck1960 FIND v(dout1_109) AT=1970.05n

.meas tran vdout1_110ck1960 FIND v(dout1_110) AT=1970.05n

.meas tran vdout1_111ck1960 FIND v(dout1_111) AT=1970.05n

.meas tran vdout1_112ck1960 FIND v(dout1_112) AT=1970.05n

.meas tran vdout1_113ck1960 FIND v(dout1_113) AT=1970.05n

.meas tran vdout1_114ck1960 FIND v(dout1_114) AT=1970.05n

.meas tran vdout1_115ck1960 FIND v(dout1_115) AT=1970.05n

.meas tran vdout1_116ck1960 FIND v(dout1_116) AT=1970.05n

.meas tran vdout1_117ck1960 FIND v(dout1_117) AT=1970.05n

.meas tran vdout1_118ck1960 FIND v(dout1_118) AT=1970.05n

.meas tran vdout1_119ck1960 FIND v(dout1_119) AT=1970.05n

.meas tran vdout1_120ck1960 FIND v(dout1_120) AT=1970.05n

.meas tran vdout1_121ck1960 FIND v(dout1_121) AT=1970.05n

.meas tran vdout1_122ck1960 FIND v(dout1_122) AT=1970.05n

.meas tran vdout1_123ck1960 FIND v(dout1_123) AT=1970.05n

.meas tran vdout1_124ck1960 FIND v(dout1_124) AT=1970.05n

.meas tran vdout1_125ck1960 FIND v(dout1_125) AT=1970.05n

.meas tran vdout1_126ck1960 FIND v(dout1_126) AT=1970.05n

.meas tran vdout1_127ck1960 FIND v(dout1_127) AT=1970.05n

.meas tran vdout1_128ck1960 FIND v(dout1_128) AT=1970.05n

.meas tran vdout1_129ck1960 FIND v(dout1_129) AT=1970.05n

.meas tran vdout1_130ck1960 FIND v(dout1_130) AT=1970.05n

.meas tran vdout1_131ck1960 FIND v(dout1_131) AT=1970.05n

.meas tran vdout1_132ck1960 FIND v(dout1_132) AT=1970.05n

.meas tran vdout1_133ck1960 FIND v(dout1_133) AT=1970.05n

.meas tran vdout1_134ck1960 FIND v(dout1_134) AT=1970.05n

.meas tran vdout1_135ck1960 FIND v(dout1_135) AT=1970.05n

.meas tran vdout1_136ck1960 FIND v(dout1_136) AT=1970.05n

.meas tran vdout1_137ck1960 FIND v(dout1_137) AT=1970.05n

.meas tran vdout1_138ck1960 FIND v(dout1_138) AT=1970.05n

.meas tran vdout1_139ck1960 FIND v(dout1_139) AT=1970.05n

.meas tran vdout1_140ck1960 FIND v(dout1_140) AT=1970.05n

.meas tran vdout1_141ck1960 FIND v(dout1_141) AT=1970.05n

.meas tran vdout1_142ck1960 FIND v(dout1_142) AT=1970.05n

.meas tran vdout1_143ck1960 FIND v(dout1_143) AT=1970.05n

.meas tran vdout1_144ck1960 FIND v(dout1_144) AT=1970.05n

.meas tran vdout1_145ck1960 FIND v(dout1_145) AT=1970.05n

.meas tran vdout1_146ck1960 FIND v(dout1_146) AT=1970.05n

.meas tran vdout1_147ck1960 FIND v(dout1_147) AT=1970.05n

.meas tran vdout1_148ck1960 FIND v(dout1_148) AT=1970.05n

.meas tran vdout1_149ck1960 FIND v(dout1_149) AT=1970.05n

.meas tran vdout1_150ck1960 FIND v(dout1_150) AT=1970.05n

.meas tran vdout1_151ck1960 FIND v(dout1_151) AT=1970.05n

.meas tran vdout1_152ck1960 FIND v(dout1_152) AT=1970.05n

.meas tran vdout1_153ck1960 FIND v(dout1_153) AT=1970.05n

.meas tran vdout1_154ck1960 FIND v(dout1_154) AT=1970.05n

.meas tran vdout1_155ck1960 FIND v(dout1_155) AT=1970.05n

.meas tran vdout1_156ck1960 FIND v(dout1_156) AT=1970.05n

.meas tran vdout1_157ck1960 FIND v(dout1_157) AT=1970.05n

.meas tran vdout1_158ck1960 FIND v(dout1_158) AT=1970.05n

.meas tran vdout1_159ck1960 FIND v(dout1_159) AT=1970.05n

.meas tran vdout1_160ck1960 FIND v(dout1_160) AT=1970.05n

.meas tran vdout1_161ck1960 FIND v(dout1_161) AT=1970.05n

.meas tran vdout1_162ck1960 FIND v(dout1_162) AT=1970.05n

.meas tran vdout1_163ck1960 FIND v(dout1_163) AT=1970.05n

.meas tran vdout1_164ck1960 FIND v(dout1_164) AT=1970.05n

.meas tran vdout1_165ck1960 FIND v(dout1_165) AT=1970.05n

.meas tran vdout1_166ck1960 FIND v(dout1_166) AT=1970.05n

.meas tran vdout1_167ck1960 FIND v(dout1_167) AT=1970.05n

.meas tran vdout1_168ck1960 FIND v(dout1_168) AT=1970.05n

.meas tran vdout1_169ck1960 FIND v(dout1_169) AT=1970.05n

.meas tran vdout1_170ck1960 FIND v(dout1_170) AT=1970.05n

.meas tran vdout1_171ck1960 FIND v(dout1_171) AT=1970.05n

.meas tran vdout1_172ck1960 FIND v(dout1_172) AT=1970.05n

.meas tran vdout1_173ck1960 FIND v(dout1_173) AT=1970.05n

.meas tran vdout1_174ck1960 FIND v(dout1_174) AT=1970.05n

.meas tran vdout1_175ck1960 FIND v(dout1_175) AT=1970.05n

.meas tran vdout1_176ck1960 FIND v(dout1_176) AT=1970.05n

.meas tran vdout1_177ck1960 FIND v(dout1_177) AT=1970.05n

.meas tran vdout1_178ck1960 FIND v(dout1_178) AT=1970.05n

.meas tran vdout1_179ck1960 FIND v(dout1_179) AT=1970.05n

.meas tran vdout1_180ck1960 FIND v(dout1_180) AT=1970.05n

.meas tran vdout1_181ck1960 FIND v(dout1_181) AT=1970.05n

.meas tran vdout1_182ck1960 FIND v(dout1_182) AT=1970.05n

.meas tran vdout1_183ck1960 FIND v(dout1_183) AT=1970.05n

.meas tran vdout1_184ck1960 FIND v(dout1_184) AT=1970.05n

.meas tran vdout1_185ck1960 FIND v(dout1_185) AT=1970.05n

.meas tran vdout1_186ck1960 FIND v(dout1_186) AT=1970.05n

.meas tran vdout1_187ck1960 FIND v(dout1_187) AT=1970.05n

.meas tran vdout1_188ck1960 FIND v(dout1_188) AT=1970.05n

.meas tran vdout1_189ck1960 FIND v(dout1_189) AT=1970.05n

.meas tran vdout1_190ck1960 FIND v(dout1_190) AT=1970.05n

.meas tran vdout1_191ck1960 FIND v(dout1_191) AT=1970.05n

.meas tran vdout1_192ck1960 FIND v(dout1_192) AT=1970.05n

.meas tran vdout1_193ck1960 FIND v(dout1_193) AT=1970.05n

.meas tran vdout1_194ck1960 FIND v(dout1_194) AT=1970.05n

.meas tran vdout1_195ck1960 FIND v(dout1_195) AT=1970.05n

.meas tran vdout1_196ck1960 FIND v(dout1_196) AT=1970.05n

.meas tran vdout1_197ck1960 FIND v(dout1_197) AT=1970.05n

.meas tran vdout1_198ck1960 FIND v(dout1_198) AT=1970.05n

.meas tran vdout1_199ck1960 FIND v(dout1_199) AT=1970.05n

.meas tran vdout1_200ck1960 FIND v(dout1_200) AT=1970.05n

.meas tran vdout1_201ck1960 FIND v(dout1_201) AT=1970.05n

.meas tran vdout1_202ck1960 FIND v(dout1_202) AT=1970.05n

.meas tran vdout1_203ck1960 FIND v(dout1_203) AT=1970.05n

.meas tran vdout1_204ck1960 FIND v(dout1_204) AT=1970.05n

.meas tran vdout1_205ck1960 FIND v(dout1_205) AT=1970.05n

.meas tran vdout1_206ck1960 FIND v(dout1_206) AT=1970.05n

.meas tran vdout1_207ck1960 FIND v(dout1_207) AT=1970.05n

.meas tran vdout1_208ck1960 FIND v(dout1_208) AT=1970.05n

.meas tran vdout1_209ck1960 FIND v(dout1_209) AT=1970.05n

.meas tran vdout1_210ck1960 FIND v(dout1_210) AT=1970.05n

.meas tran vdout1_211ck1960 FIND v(dout1_211) AT=1970.05n

.meas tran vdout1_212ck1960 FIND v(dout1_212) AT=1970.05n

.meas tran vdout1_213ck1960 FIND v(dout1_213) AT=1970.05n

.meas tran vdout1_214ck1960 FIND v(dout1_214) AT=1970.05n

.meas tran vdout1_215ck1960 FIND v(dout1_215) AT=1970.05n

.meas tran vdout1_216ck1960 FIND v(dout1_216) AT=1970.05n

.meas tran vdout1_217ck1960 FIND v(dout1_217) AT=1970.05n

.meas tran vdout1_218ck1960 FIND v(dout1_218) AT=1970.05n

.meas tran vdout1_219ck1960 FIND v(dout1_219) AT=1970.05n

.meas tran vdout1_220ck1960 FIND v(dout1_220) AT=1970.05n

.meas tran vdout1_221ck1960 FIND v(dout1_221) AT=1970.05n

.meas tran vdout1_222ck1960 FIND v(dout1_222) AT=1970.05n

.meas tran vdout1_223ck1960 FIND v(dout1_223) AT=1970.05n

.meas tran vdout1_224ck1960 FIND v(dout1_224) AT=1970.05n

.meas tran vdout1_225ck1960 FIND v(dout1_225) AT=1970.05n

.meas tran vdout1_226ck1960 FIND v(dout1_226) AT=1970.05n

.meas tran vdout1_227ck1960 FIND v(dout1_227) AT=1970.05n

.meas tran vdout1_228ck1960 FIND v(dout1_228) AT=1970.05n

.meas tran vdout1_229ck1960 FIND v(dout1_229) AT=1970.05n

.meas tran vdout1_230ck1960 FIND v(dout1_230) AT=1970.05n

.meas tran vdout1_231ck1960 FIND v(dout1_231) AT=1970.05n

.meas tran vdout1_232ck1960 FIND v(dout1_232) AT=1970.05n

.meas tran vdout1_233ck1960 FIND v(dout1_233) AT=1970.05n

.meas tran vdout1_234ck1960 FIND v(dout1_234) AT=1970.05n

.meas tran vdout1_235ck1960 FIND v(dout1_235) AT=1970.05n

.meas tran vdout1_236ck1960 FIND v(dout1_236) AT=1970.05n

.meas tran vdout1_237ck1960 FIND v(dout1_237) AT=1970.05n

.meas tran vdout1_238ck1960 FIND v(dout1_238) AT=1970.05n

.meas tran vdout1_239ck1960 FIND v(dout1_239) AT=1970.05n

.meas tran vdout1_240ck1960 FIND v(dout1_240) AT=1970.05n

.meas tran vdout1_241ck1960 FIND v(dout1_241) AT=1970.05n

.meas tran vdout1_242ck1960 FIND v(dout1_242) AT=1970.05n

.meas tran vdout1_243ck1960 FIND v(dout1_243) AT=1970.05n

.meas tran vdout1_244ck1960 FIND v(dout1_244) AT=1970.05n

.meas tran vdout1_245ck1960 FIND v(dout1_245) AT=1970.05n

.meas tran vdout1_246ck1960 FIND v(dout1_246) AT=1970.05n

.meas tran vdout1_247ck1960 FIND v(dout1_247) AT=1970.05n

.meas tran vdout1_248ck1960 FIND v(dout1_248) AT=1970.05n

.meas tran vdout1_249ck1960 FIND v(dout1_249) AT=1970.05n

.meas tran vdout1_250ck1960 FIND v(dout1_250) AT=1970.05n

.meas tran vdout1_251ck1960 FIND v(dout1_251) AT=1970.05n

.meas tran vdout1_252ck1960 FIND v(dout1_252) AT=1970.05n

.meas tran vdout1_253ck1960 FIND v(dout1_253) AT=1970.05n

.meas tran vdout1_254ck1960 FIND v(dout1_254) AT=1970.05n

.meas tran vdout1_255ck1960 FIND v(dout1_255) AT=1970.05n

.meas tran vdout1_256ck1960 FIND v(dout1_256) AT=1970.05n

.meas tran vdout1_0ck2020 FIND v(dout1_0) AT=2030.05n

.meas tran vdout1_1ck2020 FIND v(dout1_1) AT=2030.05n

.meas tran vdout1_2ck2020 FIND v(dout1_2) AT=2030.05n

.meas tran vdout1_3ck2020 FIND v(dout1_3) AT=2030.05n

.meas tran vdout1_4ck2020 FIND v(dout1_4) AT=2030.05n

.meas tran vdout1_5ck2020 FIND v(dout1_5) AT=2030.05n

.meas tran vdout1_6ck2020 FIND v(dout1_6) AT=2030.05n

.meas tran vdout1_7ck2020 FIND v(dout1_7) AT=2030.05n

.meas tran vdout1_8ck2020 FIND v(dout1_8) AT=2030.05n

.meas tran vdout1_9ck2020 FIND v(dout1_9) AT=2030.05n

.meas tran vdout1_10ck2020 FIND v(dout1_10) AT=2030.05n

.meas tran vdout1_11ck2020 FIND v(dout1_11) AT=2030.05n

.meas tran vdout1_12ck2020 FIND v(dout1_12) AT=2030.05n

.meas tran vdout1_13ck2020 FIND v(dout1_13) AT=2030.05n

.meas tran vdout1_14ck2020 FIND v(dout1_14) AT=2030.05n

.meas tran vdout1_15ck2020 FIND v(dout1_15) AT=2030.05n

.meas tran vdout1_16ck2020 FIND v(dout1_16) AT=2030.05n

.meas tran vdout1_17ck2020 FIND v(dout1_17) AT=2030.05n

.meas tran vdout1_18ck2020 FIND v(dout1_18) AT=2030.05n

.meas tran vdout1_19ck2020 FIND v(dout1_19) AT=2030.05n

.meas tran vdout1_20ck2020 FIND v(dout1_20) AT=2030.05n

.meas tran vdout1_21ck2020 FIND v(dout1_21) AT=2030.05n

.meas tran vdout1_22ck2020 FIND v(dout1_22) AT=2030.05n

.meas tran vdout1_23ck2020 FIND v(dout1_23) AT=2030.05n

.meas tran vdout1_24ck2020 FIND v(dout1_24) AT=2030.05n

.meas tran vdout1_25ck2020 FIND v(dout1_25) AT=2030.05n

.meas tran vdout1_26ck2020 FIND v(dout1_26) AT=2030.05n

.meas tran vdout1_27ck2020 FIND v(dout1_27) AT=2030.05n

.meas tran vdout1_28ck2020 FIND v(dout1_28) AT=2030.05n

.meas tran vdout1_29ck2020 FIND v(dout1_29) AT=2030.05n

.meas tran vdout1_30ck2020 FIND v(dout1_30) AT=2030.05n

.meas tran vdout1_31ck2020 FIND v(dout1_31) AT=2030.05n

.meas tran vdout1_32ck2020 FIND v(dout1_32) AT=2030.05n

.meas tran vdout1_33ck2020 FIND v(dout1_33) AT=2030.05n

.meas tran vdout1_34ck2020 FIND v(dout1_34) AT=2030.05n

.meas tran vdout1_35ck2020 FIND v(dout1_35) AT=2030.05n

.meas tran vdout1_36ck2020 FIND v(dout1_36) AT=2030.05n

.meas tran vdout1_37ck2020 FIND v(dout1_37) AT=2030.05n

.meas tran vdout1_38ck2020 FIND v(dout1_38) AT=2030.05n

.meas tran vdout1_39ck2020 FIND v(dout1_39) AT=2030.05n

.meas tran vdout1_40ck2020 FIND v(dout1_40) AT=2030.05n

.meas tran vdout1_41ck2020 FIND v(dout1_41) AT=2030.05n

.meas tran vdout1_42ck2020 FIND v(dout1_42) AT=2030.05n

.meas tran vdout1_43ck2020 FIND v(dout1_43) AT=2030.05n

.meas tran vdout1_44ck2020 FIND v(dout1_44) AT=2030.05n

.meas tran vdout1_45ck2020 FIND v(dout1_45) AT=2030.05n

.meas tran vdout1_46ck2020 FIND v(dout1_46) AT=2030.05n

.meas tran vdout1_47ck2020 FIND v(dout1_47) AT=2030.05n

.meas tran vdout1_48ck2020 FIND v(dout1_48) AT=2030.05n

.meas tran vdout1_49ck2020 FIND v(dout1_49) AT=2030.05n

.meas tran vdout1_50ck2020 FIND v(dout1_50) AT=2030.05n

.meas tran vdout1_51ck2020 FIND v(dout1_51) AT=2030.05n

.meas tran vdout1_52ck2020 FIND v(dout1_52) AT=2030.05n

.meas tran vdout1_53ck2020 FIND v(dout1_53) AT=2030.05n

.meas tran vdout1_54ck2020 FIND v(dout1_54) AT=2030.05n

.meas tran vdout1_55ck2020 FIND v(dout1_55) AT=2030.05n

.meas tran vdout1_56ck2020 FIND v(dout1_56) AT=2030.05n

.meas tran vdout1_57ck2020 FIND v(dout1_57) AT=2030.05n

.meas tran vdout1_58ck2020 FIND v(dout1_58) AT=2030.05n

.meas tran vdout1_59ck2020 FIND v(dout1_59) AT=2030.05n

.meas tran vdout1_60ck2020 FIND v(dout1_60) AT=2030.05n

.meas tran vdout1_61ck2020 FIND v(dout1_61) AT=2030.05n

.meas tran vdout1_62ck2020 FIND v(dout1_62) AT=2030.05n

.meas tran vdout1_63ck2020 FIND v(dout1_63) AT=2030.05n

.meas tran vdout1_64ck2020 FIND v(dout1_64) AT=2030.05n

.meas tran vdout1_65ck2020 FIND v(dout1_65) AT=2030.05n

.meas tran vdout1_66ck2020 FIND v(dout1_66) AT=2030.05n

.meas tran vdout1_67ck2020 FIND v(dout1_67) AT=2030.05n

.meas tran vdout1_68ck2020 FIND v(dout1_68) AT=2030.05n

.meas tran vdout1_69ck2020 FIND v(dout1_69) AT=2030.05n

.meas tran vdout1_70ck2020 FIND v(dout1_70) AT=2030.05n

.meas tran vdout1_71ck2020 FIND v(dout1_71) AT=2030.05n

.meas tran vdout1_72ck2020 FIND v(dout1_72) AT=2030.05n

.meas tran vdout1_73ck2020 FIND v(dout1_73) AT=2030.05n

.meas tran vdout1_74ck2020 FIND v(dout1_74) AT=2030.05n

.meas tran vdout1_75ck2020 FIND v(dout1_75) AT=2030.05n

.meas tran vdout1_76ck2020 FIND v(dout1_76) AT=2030.05n

.meas tran vdout1_77ck2020 FIND v(dout1_77) AT=2030.05n

.meas tran vdout1_78ck2020 FIND v(dout1_78) AT=2030.05n

.meas tran vdout1_79ck2020 FIND v(dout1_79) AT=2030.05n

.meas tran vdout1_80ck2020 FIND v(dout1_80) AT=2030.05n

.meas tran vdout1_81ck2020 FIND v(dout1_81) AT=2030.05n

.meas tran vdout1_82ck2020 FIND v(dout1_82) AT=2030.05n

.meas tran vdout1_83ck2020 FIND v(dout1_83) AT=2030.05n

.meas tran vdout1_84ck2020 FIND v(dout1_84) AT=2030.05n

.meas tran vdout1_85ck2020 FIND v(dout1_85) AT=2030.05n

.meas tran vdout1_86ck2020 FIND v(dout1_86) AT=2030.05n

.meas tran vdout1_87ck2020 FIND v(dout1_87) AT=2030.05n

.meas tran vdout1_88ck2020 FIND v(dout1_88) AT=2030.05n

.meas tran vdout1_89ck2020 FIND v(dout1_89) AT=2030.05n

.meas tran vdout1_90ck2020 FIND v(dout1_90) AT=2030.05n

.meas tran vdout1_91ck2020 FIND v(dout1_91) AT=2030.05n

.meas tran vdout1_92ck2020 FIND v(dout1_92) AT=2030.05n

.meas tran vdout1_93ck2020 FIND v(dout1_93) AT=2030.05n

.meas tran vdout1_94ck2020 FIND v(dout1_94) AT=2030.05n

.meas tran vdout1_95ck2020 FIND v(dout1_95) AT=2030.05n

.meas tran vdout1_96ck2020 FIND v(dout1_96) AT=2030.05n

.meas tran vdout1_97ck2020 FIND v(dout1_97) AT=2030.05n

.meas tran vdout1_98ck2020 FIND v(dout1_98) AT=2030.05n

.meas tran vdout1_99ck2020 FIND v(dout1_99) AT=2030.05n

.meas tran vdout1_100ck2020 FIND v(dout1_100) AT=2030.05n

.meas tran vdout1_101ck2020 FIND v(dout1_101) AT=2030.05n

.meas tran vdout1_102ck2020 FIND v(dout1_102) AT=2030.05n

.meas tran vdout1_103ck2020 FIND v(dout1_103) AT=2030.05n

.meas tran vdout1_104ck2020 FIND v(dout1_104) AT=2030.05n

.meas tran vdout1_105ck2020 FIND v(dout1_105) AT=2030.05n

.meas tran vdout1_106ck2020 FIND v(dout1_106) AT=2030.05n

.meas tran vdout1_107ck2020 FIND v(dout1_107) AT=2030.05n

.meas tran vdout1_108ck2020 FIND v(dout1_108) AT=2030.05n

.meas tran vdout1_109ck2020 FIND v(dout1_109) AT=2030.05n

.meas tran vdout1_110ck2020 FIND v(dout1_110) AT=2030.05n

.meas tran vdout1_111ck2020 FIND v(dout1_111) AT=2030.05n

.meas tran vdout1_112ck2020 FIND v(dout1_112) AT=2030.05n

.meas tran vdout1_113ck2020 FIND v(dout1_113) AT=2030.05n

.meas tran vdout1_114ck2020 FIND v(dout1_114) AT=2030.05n

.meas tran vdout1_115ck2020 FIND v(dout1_115) AT=2030.05n

.meas tran vdout1_116ck2020 FIND v(dout1_116) AT=2030.05n

.meas tran vdout1_117ck2020 FIND v(dout1_117) AT=2030.05n

.meas tran vdout1_118ck2020 FIND v(dout1_118) AT=2030.05n

.meas tran vdout1_119ck2020 FIND v(dout1_119) AT=2030.05n

.meas tran vdout1_120ck2020 FIND v(dout1_120) AT=2030.05n

.meas tran vdout1_121ck2020 FIND v(dout1_121) AT=2030.05n

.meas tran vdout1_122ck2020 FIND v(dout1_122) AT=2030.05n

.meas tran vdout1_123ck2020 FIND v(dout1_123) AT=2030.05n

.meas tran vdout1_124ck2020 FIND v(dout1_124) AT=2030.05n

.meas tran vdout1_125ck2020 FIND v(dout1_125) AT=2030.05n

.meas tran vdout1_126ck2020 FIND v(dout1_126) AT=2030.05n

.meas tran vdout1_127ck2020 FIND v(dout1_127) AT=2030.05n

.meas tran vdout1_128ck2020 FIND v(dout1_128) AT=2030.05n

.meas tran vdout1_129ck2020 FIND v(dout1_129) AT=2030.05n

.meas tran vdout1_130ck2020 FIND v(dout1_130) AT=2030.05n

.meas tran vdout1_131ck2020 FIND v(dout1_131) AT=2030.05n

.meas tran vdout1_132ck2020 FIND v(dout1_132) AT=2030.05n

.meas tran vdout1_133ck2020 FIND v(dout1_133) AT=2030.05n

.meas tran vdout1_134ck2020 FIND v(dout1_134) AT=2030.05n

.meas tran vdout1_135ck2020 FIND v(dout1_135) AT=2030.05n

.meas tran vdout1_136ck2020 FIND v(dout1_136) AT=2030.05n

.meas tran vdout1_137ck2020 FIND v(dout1_137) AT=2030.05n

.meas tran vdout1_138ck2020 FIND v(dout1_138) AT=2030.05n

.meas tran vdout1_139ck2020 FIND v(dout1_139) AT=2030.05n

.meas tran vdout1_140ck2020 FIND v(dout1_140) AT=2030.05n

.meas tran vdout1_141ck2020 FIND v(dout1_141) AT=2030.05n

.meas tran vdout1_142ck2020 FIND v(dout1_142) AT=2030.05n

.meas tran vdout1_143ck2020 FIND v(dout1_143) AT=2030.05n

.meas tran vdout1_144ck2020 FIND v(dout1_144) AT=2030.05n

.meas tran vdout1_145ck2020 FIND v(dout1_145) AT=2030.05n

.meas tran vdout1_146ck2020 FIND v(dout1_146) AT=2030.05n

.meas tran vdout1_147ck2020 FIND v(dout1_147) AT=2030.05n

.meas tran vdout1_148ck2020 FIND v(dout1_148) AT=2030.05n

.meas tran vdout1_149ck2020 FIND v(dout1_149) AT=2030.05n

.meas tran vdout1_150ck2020 FIND v(dout1_150) AT=2030.05n

.meas tran vdout1_151ck2020 FIND v(dout1_151) AT=2030.05n

.meas tran vdout1_152ck2020 FIND v(dout1_152) AT=2030.05n

.meas tran vdout1_153ck2020 FIND v(dout1_153) AT=2030.05n

.meas tran vdout1_154ck2020 FIND v(dout1_154) AT=2030.05n

.meas tran vdout1_155ck2020 FIND v(dout1_155) AT=2030.05n

.meas tran vdout1_156ck2020 FIND v(dout1_156) AT=2030.05n

.meas tran vdout1_157ck2020 FIND v(dout1_157) AT=2030.05n

.meas tran vdout1_158ck2020 FIND v(dout1_158) AT=2030.05n

.meas tran vdout1_159ck2020 FIND v(dout1_159) AT=2030.05n

.meas tran vdout1_160ck2020 FIND v(dout1_160) AT=2030.05n

.meas tran vdout1_161ck2020 FIND v(dout1_161) AT=2030.05n

.meas tran vdout1_162ck2020 FIND v(dout1_162) AT=2030.05n

.meas tran vdout1_163ck2020 FIND v(dout1_163) AT=2030.05n

.meas tran vdout1_164ck2020 FIND v(dout1_164) AT=2030.05n

.meas tran vdout1_165ck2020 FIND v(dout1_165) AT=2030.05n

.meas tran vdout1_166ck2020 FIND v(dout1_166) AT=2030.05n

.meas tran vdout1_167ck2020 FIND v(dout1_167) AT=2030.05n

.meas tran vdout1_168ck2020 FIND v(dout1_168) AT=2030.05n

.meas tran vdout1_169ck2020 FIND v(dout1_169) AT=2030.05n

.meas tran vdout1_170ck2020 FIND v(dout1_170) AT=2030.05n

.meas tran vdout1_171ck2020 FIND v(dout1_171) AT=2030.05n

.meas tran vdout1_172ck2020 FIND v(dout1_172) AT=2030.05n

.meas tran vdout1_173ck2020 FIND v(dout1_173) AT=2030.05n

.meas tran vdout1_174ck2020 FIND v(dout1_174) AT=2030.05n

.meas tran vdout1_175ck2020 FIND v(dout1_175) AT=2030.05n

.meas tran vdout1_176ck2020 FIND v(dout1_176) AT=2030.05n

.meas tran vdout1_177ck2020 FIND v(dout1_177) AT=2030.05n

.meas tran vdout1_178ck2020 FIND v(dout1_178) AT=2030.05n

.meas tran vdout1_179ck2020 FIND v(dout1_179) AT=2030.05n

.meas tran vdout1_180ck2020 FIND v(dout1_180) AT=2030.05n

.meas tran vdout1_181ck2020 FIND v(dout1_181) AT=2030.05n

.meas tran vdout1_182ck2020 FIND v(dout1_182) AT=2030.05n

.meas tran vdout1_183ck2020 FIND v(dout1_183) AT=2030.05n

.meas tran vdout1_184ck2020 FIND v(dout1_184) AT=2030.05n

.meas tran vdout1_185ck2020 FIND v(dout1_185) AT=2030.05n

.meas tran vdout1_186ck2020 FIND v(dout1_186) AT=2030.05n

.meas tran vdout1_187ck2020 FIND v(dout1_187) AT=2030.05n

.meas tran vdout1_188ck2020 FIND v(dout1_188) AT=2030.05n

.meas tran vdout1_189ck2020 FIND v(dout1_189) AT=2030.05n

.meas tran vdout1_190ck2020 FIND v(dout1_190) AT=2030.05n

.meas tran vdout1_191ck2020 FIND v(dout1_191) AT=2030.05n

.meas tran vdout1_192ck2020 FIND v(dout1_192) AT=2030.05n

.meas tran vdout1_193ck2020 FIND v(dout1_193) AT=2030.05n

.meas tran vdout1_194ck2020 FIND v(dout1_194) AT=2030.05n

.meas tran vdout1_195ck2020 FIND v(dout1_195) AT=2030.05n

.meas tran vdout1_196ck2020 FIND v(dout1_196) AT=2030.05n

.meas tran vdout1_197ck2020 FIND v(dout1_197) AT=2030.05n

.meas tran vdout1_198ck2020 FIND v(dout1_198) AT=2030.05n

.meas tran vdout1_199ck2020 FIND v(dout1_199) AT=2030.05n

.meas tran vdout1_200ck2020 FIND v(dout1_200) AT=2030.05n

.meas tran vdout1_201ck2020 FIND v(dout1_201) AT=2030.05n

.meas tran vdout1_202ck2020 FIND v(dout1_202) AT=2030.05n

.meas tran vdout1_203ck2020 FIND v(dout1_203) AT=2030.05n

.meas tran vdout1_204ck2020 FIND v(dout1_204) AT=2030.05n

.meas tran vdout1_205ck2020 FIND v(dout1_205) AT=2030.05n

.meas tran vdout1_206ck2020 FIND v(dout1_206) AT=2030.05n

.meas tran vdout1_207ck2020 FIND v(dout1_207) AT=2030.05n

.meas tran vdout1_208ck2020 FIND v(dout1_208) AT=2030.05n

.meas tran vdout1_209ck2020 FIND v(dout1_209) AT=2030.05n

.meas tran vdout1_210ck2020 FIND v(dout1_210) AT=2030.05n

.meas tran vdout1_211ck2020 FIND v(dout1_211) AT=2030.05n

.meas tran vdout1_212ck2020 FIND v(dout1_212) AT=2030.05n

.meas tran vdout1_213ck2020 FIND v(dout1_213) AT=2030.05n

.meas tran vdout1_214ck2020 FIND v(dout1_214) AT=2030.05n

.meas tran vdout1_215ck2020 FIND v(dout1_215) AT=2030.05n

.meas tran vdout1_216ck2020 FIND v(dout1_216) AT=2030.05n

.meas tran vdout1_217ck2020 FIND v(dout1_217) AT=2030.05n

.meas tran vdout1_218ck2020 FIND v(dout1_218) AT=2030.05n

.meas tran vdout1_219ck2020 FIND v(dout1_219) AT=2030.05n

.meas tran vdout1_220ck2020 FIND v(dout1_220) AT=2030.05n

.meas tran vdout1_221ck2020 FIND v(dout1_221) AT=2030.05n

.meas tran vdout1_222ck2020 FIND v(dout1_222) AT=2030.05n

.meas tran vdout1_223ck2020 FIND v(dout1_223) AT=2030.05n

.meas tran vdout1_224ck2020 FIND v(dout1_224) AT=2030.05n

.meas tran vdout1_225ck2020 FIND v(dout1_225) AT=2030.05n

.meas tran vdout1_226ck2020 FIND v(dout1_226) AT=2030.05n

.meas tran vdout1_227ck2020 FIND v(dout1_227) AT=2030.05n

.meas tran vdout1_228ck2020 FIND v(dout1_228) AT=2030.05n

.meas tran vdout1_229ck2020 FIND v(dout1_229) AT=2030.05n

.meas tran vdout1_230ck2020 FIND v(dout1_230) AT=2030.05n

.meas tran vdout1_231ck2020 FIND v(dout1_231) AT=2030.05n

.meas tran vdout1_232ck2020 FIND v(dout1_232) AT=2030.05n

.meas tran vdout1_233ck2020 FIND v(dout1_233) AT=2030.05n

.meas tran vdout1_234ck2020 FIND v(dout1_234) AT=2030.05n

.meas tran vdout1_235ck2020 FIND v(dout1_235) AT=2030.05n

.meas tran vdout1_236ck2020 FIND v(dout1_236) AT=2030.05n

.meas tran vdout1_237ck2020 FIND v(dout1_237) AT=2030.05n

.meas tran vdout1_238ck2020 FIND v(dout1_238) AT=2030.05n

.meas tran vdout1_239ck2020 FIND v(dout1_239) AT=2030.05n

.meas tran vdout1_240ck2020 FIND v(dout1_240) AT=2030.05n

.meas tran vdout1_241ck2020 FIND v(dout1_241) AT=2030.05n

.meas tran vdout1_242ck2020 FIND v(dout1_242) AT=2030.05n

.meas tran vdout1_243ck2020 FIND v(dout1_243) AT=2030.05n

.meas tran vdout1_244ck2020 FIND v(dout1_244) AT=2030.05n

.meas tran vdout1_245ck2020 FIND v(dout1_245) AT=2030.05n

.meas tran vdout1_246ck2020 FIND v(dout1_246) AT=2030.05n

.meas tran vdout1_247ck2020 FIND v(dout1_247) AT=2030.05n

.meas tran vdout1_248ck2020 FIND v(dout1_248) AT=2030.05n

.meas tran vdout1_249ck2020 FIND v(dout1_249) AT=2030.05n

.meas tran vdout1_250ck2020 FIND v(dout1_250) AT=2030.05n

.meas tran vdout1_251ck2020 FIND v(dout1_251) AT=2030.05n

.meas tran vdout1_252ck2020 FIND v(dout1_252) AT=2030.05n

.meas tran vdout1_253ck2020 FIND v(dout1_253) AT=2030.05n

.meas tran vdout1_254ck2020 FIND v(dout1_254) AT=2030.05n

.meas tran vdout1_255ck2020 FIND v(dout1_255) AT=2030.05n

.meas tran vdout1_256ck2020 FIND v(dout1_256) AT=2030.05n

.meas tran vdout1_0ck2040 FIND v(dout1_0) AT=2050.05n

.meas tran vdout1_1ck2040 FIND v(dout1_1) AT=2050.05n

.meas tran vdout1_2ck2040 FIND v(dout1_2) AT=2050.05n

.meas tran vdout1_3ck2040 FIND v(dout1_3) AT=2050.05n

.meas tran vdout1_4ck2040 FIND v(dout1_4) AT=2050.05n

.meas tran vdout1_5ck2040 FIND v(dout1_5) AT=2050.05n

.meas tran vdout1_6ck2040 FIND v(dout1_6) AT=2050.05n

.meas tran vdout1_7ck2040 FIND v(dout1_7) AT=2050.05n

.meas tran vdout1_8ck2040 FIND v(dout1_8) AT=2050.05n

.meas tran vdout1_9ck2040 FIND v(dout1_9) AT=2050.05n

.meas tran vdout1_10ck2040 FIND v(dout1_10) AT=2050.05n

.meas tran vdout1_11ck2040 FIND v(dout1_11) AT=2050.05n

.meas tran vdout1_12ck2040 FIND v(dout1_12) AT=2050.05n

.meas tran vdout1_13ck2040 FIND v(dout1_13) AT=2050.05n

.meas tran vdout1_14ck2040 FIND v(dout1_14) AT=2050.05n

.meas tran vdout1_15ck2040 FIND v(dout1_15) AT=2050.05n

.meas tran vdout1_16ck2040 FIND v(dout1_16) AT=2050.05n

.meas tran vdout1_17ck2040 FIND v(dout1_17) AT=2050.05n

.meas tran vdout1_18ck2040 FIND v(dout1_18) AT=2050.05n

.meas tran vdout1_19ck2040 FIND v(dout1_19) AT=2050.05n

.meas tran vdout1_20ck2040 FIND v(dout1_20) AT=2050.05n

.meas tran vdout1_21ck2040 FIND v(dout1_21) AT=2050.05n

.meas tran vdout1_22ck2040 FIND v(dout1_22) AT=2050.05n

.meas tran vdout1_23ck2040 FIND v(dout1_23) AT=2050.05n

.meas tran vdout1_24ck2040 FIND v(dout1_24) AT=2050.05n

.meas tran vdout1_25ck2040 FIND v(dout1_25) AT=2050.05n

.meas tran vdout1_26ck2040 FIND v(dout1_26) AT=2050.05n

.meas tran vdout1_27ck2040 FIND v(dout1_27) AT=2050.05n

.meas tran vdout1_28ck2040 FIND v(dout1_28) AT=2050.05n

.meas tran vdout1_29ck2040 FIND v(dout1_29) AT=2050.05n

.meas tran vdout1_30ck2040 FIND v(dout1_30) AT=2050.05n

.meas tran vdout1_31ck2040 FIND v(dout1_31) AT=2050.05n

.meas tran vdout1_32ck2040 FIND v(dout1_32) AT=2050.05n

.meas tran vdout1_33ck2040 FIND v(dout1_33) AT=2050.05n

.meas tran vdout1_34ck2040 FIND v(dout1_34) AT=2050.05n

.meas tran vdout1_35ck2040 FIND v(dout1_35) AT=2050.05n

.meas tran vdout1_36ck2040 FIND v(dout1_36) AT=2050.05n

.meas tran vdout1_37ck2040 FIND v(dout1_37) AT=2050.05n

.meas tran vdout1_38ck2040 FIND v(dout1_38) AT=2050.05n

.meas tran vdout1_39ck2040 FIND v(dout1_39) AT=2050.05n

.meas tran vdout1_40ck2040 FIND v(dout1_40) AT=2050.05n

.meas tran vdout1_41ck2040 FIND v(dout1_41) AT=2050.05n

.meas tran vdout1_42ck2040 FIND v(dout1_42) AT=2050.05n

.meas tran vdout1_43ck2040 FIND v(dout1_43) AT=2050.05n

.meas tran vdout1_44ck2040 FIND v(dout1_44) AT=2050.05n

.meas tran vdout1_45ck2040 FIND v(dout1_45) AT=2050.05n

.meas tran vdout1_46ck2040 FIND v(dout1_46) AT=2050.05n

.meas tran vdout1_47ck2040 FIND v(dout1_47) AT=2050.05n

.meas tran vdout1_48ck2040 FIND v(dout1_48) AT=2050.05n

.meas tran vdout1_49ck2040 FIND v(dout1_49) AT=2050.05n

.meas tran vdout1_50ck2040 FIND v(dout1_50) AT=2050.05n

.meas tran vdout1_51ck2040 FIND v(dout1_51) AT=2050.05n

.meas tran vdout1_52ck2040 FIND v(dout1_52) AT=2050.05n

.meas tran vdout1_53ck2040 FIND v(dout1_53) AT=2050.05n

.meas tran vdout1_54ck2040 FIND v(dout1_54) AT=2050.05n

.meas tran vdout1_55ck2040 FIND v(dout1_55) AT=2050.05n

.meas tran vdout1_56ck2040 FIND v(dout1_56) AT=2050.05n

.meas tran vdout1_57ck2040 FIND v(dout1_57) AT=2050.05n

.meas tran vdout1_58ck2040 FIND v(dout1_58) AT=2050.05n

.meas tran vdout1_59ck2040 FIND v(dout1_59) AT=2050.05n

.meas tran vdout1_60ck2040 FIND v(dout1_60) AT=2050.05n

.meas tran vdout1_61ck2040 FIND v(dout1_61) AT=2050.05n

.meas tran vdout1_62ck2040 FIND v(dout1_62) AT=2050.05n

.meas tran vdout1_63ck2040 FIND v(dout1_63) AT=2050.05n

.meas tran vdout1_64ck2040 FIND v(dout1_64) AT=2050.05n

.meas tran vdout1_65ck2040 FIND v(dout1_65) AT=2050.05n

.meas tran vdout1_66ck2040 FIND v(dout1_66) AT=2050.05n

.meas tran vdout1_67ck2040 FIND v(dout1_67) AT=2050.05n

.meas tran vdout1_68ck2040 FIND v(dout1_68) AT=2050.05n

.meas tran vdout1_69ck2040 FIND v(dout1_69) AT=2050.05n

.meas tran vdout1_70ck2040 FIND v(dout1_70) AT=2050.05n

.meas tran vdout1_71ck2040 FIND v(dout1_71) AT=2050.05n

.meas tran vdout1_72ck2040 FIND v(dout1_72) AT=2050.05n

.meas tran vdout1_73ck2040 FIND v(dout1_73) AT=2050.05n

.meas tran vdout1_74ck2040 FIND v(dout1_74) AT=2050.05n

.meas tran vdout1_75ck2040 FIND v(dout1_75) AT=2050.05n

.meas tran vdout1_76ck2040 FIND v(dout1_76) AT=2050.05n

.meas tran vdout1_77ck2040 FIND v(dout1_77) AT=2050.05n

.meas tran vdout1_78ck2040 FIND v(dout1_78) AT=2050.05n

.meas tran vdout1_79ck2040 FIND v(dout1_79) AT=2050.05n

.meas tran vdout1_80ck2040 FIND v(dout1_80) AT=2050.05n

.meas tran vdout1_81ck2040 FIND v(dout1_81) AT=2050.05n

.meas tran vdout1_82ck2040 FIND v(dout1_82) AT=2050.05n

.meas tran vdout1_83ck2040 FIND v(dout1_83) AT=2050.05n

.meas tran vdout1_84ck2040 FIND v(dout1_84) AT=2050.05n

.meas tran vdout1_85ck2040 FIND v(dout1_85) AT=2050.05n

.meas tran vdout1_86ck2040 FIND v(dout1_86) AT=2050.05n

.meas tran vdout1_87ck2040 FIND v(dout1_87) AT=2050.05n

.meas tran vdout1_88ck2040 FIND v(dout1_88) AT=2050.05n

.meas tran vdout1_89ck2040 FIND v(dout1_89) AT=2050.05n

.meas tran vdout1_90ck2040 FIND v(dout1_90) AT=2050.05n

.meas tran vdout1_91ck2040 FIND v(dout1_91) AT=2050.05n

.meas tran vdout1_92ck2040 FIND v(dout1_92) AT=2050.05n

.meas tran vdout1_93ck2040 FIND v(dout1_93) AT=2050.05n

.meas tran vdout1_94ck2040 FIND v(dout1_94) AT=2050.05n

.meas tran vdout1_95ck2040 FIND v(dout1_95) AT=2050.05n

.meas tran vdout1_96ck2040 FIND v(dout1_96) AT=2050.05n

.meas tran vdout1_97ck2040 FIND v(dout1_97) AT=2050.05n

.meas tran vdout1_98ck2040 FIND v(dout1_98) AT=2050.05n

.meas tran vdout1_99ck2040 FIND v(dout1_99) AT=2050.05n

.meas tran vdout1_100ck2040 FIND v(dout1_100) AT=2050.05n

.meas tran vdout1_101ck2040 FIND v(dout1_101) AT=2050.05n

.meas tran vdout1_102ck2040 FIND v(dout1_102) AT=2050.05n

.meas tran vdout1_103ck2040 FIND v(dout1_103) AT=2050.05n

.meas tran vdout1_104ck2040 FIND v(dout1_104) AT=2050.05n

.meas tran vdout1_105ck2040 FIND v(dout1_105) AT=2050.05n

.meas tran vdout1_106ck2040 FIND v(dout1_106) AT=2050.05n

.meas tran vdout1_107ck2040 FIND v(dout1_107) AT=2050.05n

.meas tran vdout1_108ck2040 FIND v(dout1_108) AT=2050.05n

.meas tran vdout1_109ck2040 FIND v(dout1_109) AT=2050.05n

.meas tran vdout1_110ck2040 FIND v(dout1_110) AT=2050.05n

.meas tran vdout1_111ck2040 FIND v(dout1_111) AT=2050.05n

.meas tran vdout1_112ck2040 FIND v(dout1_112) AT=2050.05n

.meas tran vdout1_113ck2040 FIND v(dout1_113) AT=2050.05n

.meas tran vdout1_114ck2040 FIND v(dout1_114) AT=2050.05n

.meas tran vdout1_115ck2040 FIND v(dout1_115) AT=2050.05n

.meas tran vdout1_116ck2040 FIND v(dout1_116) AT=2050.05n

.meas tran vdout1_117ck2040 FIND v(dout1_117) AT=2050.05n

.meas tran vdout1_118ck2040 FIND v(dout1_118) AT=2050.05n

.meas tran vdout1_119ck2040 FIND v(dout1_119) AT=2050.05n

.meas tran vdout1_120ck2040 FIND v(dout1_120) AT=2050.05n

.meas tran vdout1_121ck2040 FIND v(dout1_121) AT=2050.05n

.meas tran vdout1_122ck2040 FIND v(dout1_122) AT=2050.05n

.meas tran vdout1_123ck2040 FIND v(dout1_123) AT=2050.05n

.meas tran vdout1_124ck2040 FIND v(dout1_124) AT=2050.05n

.meas tran vdout1_125ck2040 FIND v(dout1_125) AT=2050.05n

.meas tran vdout1_126ck2040 FIND v(dout1_126) AT=2050.05n

.meas tran vdout1_127ck2040 FIND v(dout1_127) AT=2050.05n

.meas tran vdout1_128ck2040 FIND v(dout1_128) AT=2050.05n

.meas tran vdout1_129ck2040 FIND v(dout1_129) AT=2050.05n

.meas tran vdout1_130ck2040 FIND v(dout1_130) AT=2050.05n

.meas tran vdout1_131ck2040 FIND v(dout1_131) AT=2050.05n

.meas tran vdout1_132ck2040 FIND v(dout1_132) AT=2050.05n

.meas tran vdout1_133ck2040 FIND v(dout1_133) AT=2050.05n

.meas tran vdout1_134ck2040 FIND v(dout1_134) AT=2050.05n

.meas tran vdout1_135ck2040 FIND v(dout1_135) AT=2050.05n

.meas tran vdout1_136ck2040 FIND v(dout1_136) AT=2050.05n

.meas tran vdout1_137ck2040 FIND v(dout1_137) AT=2050.05n

.meas tran vdout1_138ck2040 FIND v(dout1_138) AT=2050.05n

.meas tran vdout1_139ck2040 FIND v(dout1_139) AT=2050.05n

.meas tran vdout1_140ck2040 FIND v(dout1_140) AT=2050.05n

.meas tran vdout1_141ck2040 FIND v(dout1_141) AT=2050.05n

.meas tran vdout1_142ck2040 FIND v(dout1_142) AT=2050.05n

.meas tran vdout1_143ck2040 FIND v(dout1_143) AT=2050.05n

.meas tran vdout1_144ck2040 FIND v(dout1_144) AT=2050.05n

.meas tran vdout1_145ck2040 FIND v(dout1_145) AT=2050.05n

.meas tran vdout1_146ck2040 FIND v(dout1_146) AT=2050.05n

.meas tran vdout1_147ck2040 FIND v(dout1_147) AT=2050.05n

.meas tran vdout1_148ck2040 FIND v(dout1_148) AT=2050.05n

.meas tran vdout1_149ck2040 FIND v(dout1_149) AT=2050.05n

.meas tran vdout1_150ck2040 FIND v(dout1_150) AT=2050.05n

.meas tran vdout1_151ck2040 FIND v(dout1_151) AT=2050.05n

.meas tran vdout1_152ck2040 FIND v(dout1_152) AT=2050.05n

.meas tran vdout1_153ck2040 FIND v(dout1_153) AT=2050.05n

.meas tran vdout1_154ck2040 FIND v(dout1_154) AT=2050.05n

.meas tran vdout1_155ck2040 FIND v(dout1_155) AT=2050.05n

.meas tran vdout1_156ck2040 FIND v(dout1_156) AT=2050.05n

.meas tran vdout1_157ck2040 FIND v(dout1_157) AT=2050.05n

.meas tran vdout1_158ck2040 FIND v(dout1_158) AT=2050.05n

.meas tran vdout1_159ck2040 FIND v(dout1_159) AT=2050.05n

.meas tran vdout1_160ck2040 FIND v(dout1_160) AT=2050.05n

.meas tran vdout1_161ck2040 FIND v(dout1_161) AT=2050.05n

.meas tran vdout1_162ck2040 FIND v(dout1_162) AT=2050.05n

.meas tran vdout1_163ck2040 FIND v(dout1_163) AT=2050.05n

.meas tran vdout1_164ck2040 FIND v(dout1_164) AT=2050.05n

.meas tran vdout1_165ck2040 FIND v(dout1_165) AT=2050.05n

.meas tran vdout1_166ck2040 FIND v(dout1_166) AT=2050.05n

.meas tran vdout1_167ck2040 FIND v(dout1_167) AT=2050.05n

.meas tran vdout1_168ck2040 FIND v(dout1_168) AT=2050.05n

.meas tran vdout1_169ck2040 FIND v(dout1_169) AT=2050.05n

.meas tran vdout1_170ck2040 FIND v(dout1_170) AT=2050.05n

.meas tran vdout1_171ck2040 FIND v(dout1_171) AT=2050.05n

.meas tran vdout1_172ck2040 FIND v(dout1_172) AT=2050.05n

.meas tran vdout1_173ck2040 FIND v(dout1_173) AT=2050.05n

.meas tran vdout1_174ck2040 FIND v(dout1_174) AT=2050.05n

.meas tran vdout1_175ck2040 FIND v(dout1_175) AT=2050.05n

.meas tran vdout1_176ck2040 FIND v(dout1_176) AT=2050.05n

.meas tran vdout1_177ck2040 FIND v(dout1_177) AT=2050.05n

.meas tran vdout1_178ck2040 FIND v(dout1_178) AT=2050.05n

.meas tran vdout1_179ck2040 FIND v(dout1_179) AT=2050.05n

.meas tran vdout1_180ck2040 FIND v(dout1_180) AT=2050.05n

.meas tran vdout1_181ck2040 FIND v(dout1_181) AT=2050.05n

.meas tran vdout1_182ck2040 FIND v(dout1_182) AT=2050.05n

.meas tran vdout1_183ck2040 FIND v(dout1_183) AT=2050.05n

.meas tran vdout1_184ck2040 FIND v(dout1_184) AT=2050.05n

.meas tran vdout1_185ck2040 FIND v(dout1_185) AT=2050.05n

.meas tran vdout1_186ck2040 FIND v(dout1_186) AT=2050.05n

.meas tran vdout1_187ck2040 FIND v(dout1_187) AT=2050.05n

.meas tran vdout1_188ck2040 FIND v(dout1_188) AT=2050.05n

.meas tran vdout1_189ck2040 FIND v(dout1_189) AT=2050.05n

.meas tran vdout1_190ck2040 FIND v(dout1_190) AT=2050.05n

.meas tran vdout1_191ck2040 FIND v(dout1_191) AT=2050.05n

.meas tran vdout1_192ck2040 FIND v(dout1_192) AT=2050.05n

.meas tran vdout1_193ck2040 FIND v(dout1_193) AT=2050.05n

.meas tran vdout1_194ck2040 FIND v(dout1_194) AT=2050.05n

.meas tran vdout1_195ck2040 FIND v(dout1_195) AT=2050.05n

.meas tran vdout1_196ck2040 FIND v(dout1_196) AT=2050.05n

.meas tran vdout1_197ck2040 FIND v(dout1_197) AT=2050.05n

.meas tran vdout1_198ck2040 FIND v(dout1_198) AT=2050.05n

.meas tran vdout1_199ck2040 FIND v(dout1_199) AT=2050.05n

.meas tran vdout1_200ck2040 FIND v(dout1_200) AT=2050.05n

.meas tran vdout1_201ck2040 FIND v(dout1_201) AT=2050.05n

.meas tran vdout1_202ck2040 FIND v(dout1_202) AT=2050.05n

.meas tran vdout1_203ck2040 FIND v(dout1_203) AT=2050.05n

.meas tran vdout1_204ck2040 FIND v(dout1_204) AT=2050.05n

.meas tran vdout1_205ck2040 FIND v(dout1_205) AT=2050.05n

.meas tran vdout1_206ck2040 FIND v(dout1_206) AT=2050.05n

.meas tran vdout1_207ck2040 FIND v(dout1_207) AT=2050.05n

.meas tran vdout1_208ck2040 FIND v(dout1_208) AT=2050.05n

.meas tran vdout1_209ck2040 FIND v(dout1_209) AT=2050.05n

.meas tran vdout1_210ck2040 FIND v(dout1_210) AT=2050.05n

.meas tran vdout1_211ck2040 FIND v(dout1_211) AT=2050.05n

.meas tran vdout1_212ck2040 FIND v(dout1_212) AT=2050.05n

.meas tran vdout1_213ck2040 FIND v(dout1_213) AT=2050.05n

.meas tran vdout1_214ck2040 FIND v(dout1_214) AT=2050.05n

.meas tran vdout1_215ck2040 FIND v(dout1_215) AT=2050.05n

.meas tran vdout1_216ck2040 FIND v(dout1_216) AT=2050.05n

.meas tran vdout1_217ck2040 FIND v(dout1_217) AT=2050.05n

.meas tran vdout1_218ck2040 FIND v(dout1_218) AT=2050.05n

.meas tran vdout1_219ck2040 FIND v(dout1_219) AT=2050.05n

.meas tran vdout1_220ck2040 FIND v(dout1_220) AT=2050.05n

.meas tran vdout1_221ck2040 FIND v(dout1_221) AT=2050.05n

.meas tran vdout1_222ck2040 FIND v(dout1_222) AT=2050.05n

.meas tran vdout1_223ck2040 FIND v(dout1_223) AT=2050.05n

.meas tran vdout1_224ck2040 FIND v(dout1_224) AT=2050.05n

.meas tran vdout1_225ck2040 FIND v(dout1_225) AT=2050.05n

.meas tran vdout1_226ck2040 FIND v(dout1_226) AT=2050.05n

.meas tran vdout1_227ck2040 FIND v(dout1_227) AT=2050.05n

.meas tran vdout1_228ck2040 FIND v(dout1_228) AT=2050.05n

.meas tran vdout1_229ck2040 FIND v(dout1_229) AT=2050.05n

.meas tran vdout1_230ck2040 FIND v(dout1_230) AT=2050.05n

.meas tran vdout1_231ck2040 FIND v(dout1_231) AT=2050.05n

.meas tran vdout1_232ck2040 FIND v(dout1_232) AT=2050.05n

.meas tran vdout1_233ck2040 FIND v(dout1_233) AT=2050.05n

.meas tran vdout1_234ck2040 FIND v(dout1_234) AT=2050.05n

.meas tran vdout1_235ck2040 FIND v(dout1_235) AT=2050.05n

.meas tran vdout1_236ck2040 FIND v(dout1_236) AT=2050.05n

.meas tran vdout1_237ck2040 FIND v(dout1_237) AT=2050.05n

.meas tran vdout1_238ck2040 FIND v(dout1_238) AT=2050.05n

.meas tran vdout1_239ck2040 FIND v(dout1_239) AT=2050.05n

.meas tran vdout1_240ck2040 FIND v(dout1_240) AT=2050.05n

.meas tran vdout1_241ck2040 FIND v(dout1_241) AT=2050.05n

.meas tran vdout1_242ck2040 FIND v(dout1_242) AT=2050.05n

.meas tran vdout1_243ck2040 FIND v(dout1_243) AT=2050.05n

.meas tran vdout1_244ck2040 FIND v(dout1_244) AT=2050.05n

.meas tran vdout1_245ck2040 FIND v(dout1_245) AT=2050.05n

.meas tran vdout1_246ck2040 FIND v(dout1_246) AT=2050.05n

.meas tran vdout1_247ck2040 FIND v(dout1_247) AT=2050.05n

.meas tran vdout1_248ck2040 FIND v(dout1_248) AT=2050.05n

.meas tran vdout1_249ck2040 FIND v(dout1_249) AT=2050.05n

.meas tran vdout1_250ck2040 FIND v(dout1_250) AT=2050.05n

.meas tran vdout1_251ck2040 FIND v(dout1_251) AT=2050.05n

.meas tran vdout1_252ck2040 FIND v(dout1_252) AT=2050.05n

.meas tran vdout1_253ck2040 FIND v(dout1_253) AT=2050.05n

.meas tran vdout1_254ck2040 FIND v(dout1_254) AT=2050.05n

.meas tran vdout1_255ck2040 FIND v(dout1_255) AT=2050.05n

.meas tran vdout1_256ck2040 FIND v(dout1_256) AT=2050.05n
