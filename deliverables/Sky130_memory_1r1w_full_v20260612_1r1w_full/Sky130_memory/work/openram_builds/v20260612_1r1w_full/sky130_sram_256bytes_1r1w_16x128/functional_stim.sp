* Functional test stimulus file for 10ns period

* SS process corner
.lib "/Sky130_memory/pdk/sky130A/libs.tech/ngspice/sky130.lib.spice" ss
.include "/tmp/openram_ryan_34307_temp/sram.sp"

* Global Power Supplies
Vvdd vdd 0 1.7

*Nodes gnd and 0 are the same global ground node in ngspice/hspice/xa. Otherwise, this source may be needed.
*Vgnd gnd 0 0.0

* Instantiation of the SRAM
Xsky130_sram_256bytes_1r1w_16x128 din0_0 din0_1 din0_2 din0_3 din0_4 din0_5 din0_6 din0_7 din0_8 din0_9 din0_10 din0_11 din0_12 din0_13 din0_14 din0_15 din0_16 a0_0 a0_1 a0_2 a0_3 a0_4 a0_5 a0_6 a0_7 a1_0 a1_1 a1_2 a1_3 a1_4 a1_5 a1_6 a1_7 CSB0 CSB1 clk0 clk1 SPARE_WEN0_0 dout1_0 dout1_1 dout1_2 dout1_3 dout1_4 dout1_5 dout1_6 dout1_7 dout1_8 dout1_9 dout1_10 dout1_11 dout1_12 dout1_13 dout1_14 dout1_15 dout1_16 vdd gnd sky130_sram_256bytes_1r1w_16x128

* SRAM output loads
CD10 dout1_0  0 27.56f
CD11 dout1_1  0 27.56f
CD12 dout1_2  0 27.56f
CD13 dout1_3  0 27.56f
CD14 dout1_4  0 27.56f
CD15 dout1_5  0 27.56f
CD16 dout1_6  0 27.56f
CD17 dout1_7  0 27.56f
CD18 dout1_8  0 27.56f
CD19 dout1_9  0 27.56f
CD110 dout1_10  0 27.56f
CD111 dout1_11  0 27.56f
CD112 dout1_12  0 27.56f
CD113 dout1_13  0 27.56f
CD114 dout1_14  0 27.56f
CD115 dout1_15  0 27.56f
CD116 dout1_16  0 27.56f

* Important signals for debug
* bl:	xsram:xbank0:bl_0_1
* br:	xsram:xbank0:br_0_1
* s_en:	xsram:s_en
* q:	xsram:xbank0:xbitcell_array:xbitcell_array:xbit_r0_c0.Q
* qbar:	xsram:xbank0:xbitcell_array:xbitcell_array:xbit_r0_c0.Q_bar

* Sequence of operations
*	Idle during cycle 0 (0ns - 10ns)
*	Writing 0+1010011111000100  to  address 00000000 (from port 0) during cycle 1 (10ns - 20ns)
*	Writing 0+0110111110111110  to  address 00000001 (from port 0) during cycle 2 (20ns - 30ns)
*	Writing 0+1001110110000001  to  address 10000000 (from port 0) during cycle 3 (30ns - 40ns)
*	Reading 0+1010011111000100 from address 00000000 (from port 1) during cycle 4 (40ns - 50ns)
*	Reading 0+1010011111000100 from address 00000000 (from port 1) during cycle 6 (60ns - 70ns)
*	Writing 0+0000011011011101  to  address 10000000 (from port 0) during cycle 7 (70ns - 80ns)
*	Writing 0+1000010100011110  to  address 10000000 (from port 0) during cycle 8 (80ns - 90ns)
*	Writing 0+1000001110101011  to  address 10000000 (from port 0) during cycle 9 (90ns - 100ns)
*	Writing 0+1010001000011100  to  address 00000000 (from port 0) during cycle 10 (100ns - 110ns)
*	Reading 0+0110111110111110 from address 00000001 (from port 1) during cycle 11 (110ns - 120ns)
*	Writing 0+0100100101010100  to  address 10000000 (from port 0) during cycle 12 (120ns - 130ns)
*	Writing 0+1000100111111100  to  address 10000000 (from port 0) during cycle 13 (130ns - 140ns)
*	Reading 0+0110111110111110 from address 00000001 (from port 1) during cycle 13 (130ns - 140ns)
*	Writing 0+0101000000001010  to  address 00000001 (from port 0) during cycle 15 (150ns - 160ns)
*	Writing 0+1110101110101110  to  address 10000000 (from port 0) during cycle 16 (160ns - 170ns)
*	Reading 0+0101000000001010 from address 00000001 (from port 1) during cycle 16 (160ns - 170ns)
*	Writing 0+0001110010010001  to  address 00000001 (from port 0) during cycle 18 (180ns - 190ns)
*	Reading 0+1110101110101110 from address 10000000 (from port 1) during cycle 18 (180ns - 190ns)
*	Writing 0+1010010010100111  to  address 00000001 (from port 0) during cycle 19 (190ns - 200ns)
*	Reading 0+1110101110101110 from address 10000000 (from port 1) during cycle 19 (190ns - 200ns)
*	Writing 0+0000110011010100  to  address 01111111 (from port 0) during cycle 20 (200ns - 210ns)
*	Writing 0+0101101011000100  to  address 01111111 (from port 0) during cycle 21 (210ns - 220ns)
*	Writing 0+1111101100010101  to  address 01111111 (from port 0) during cycle 22 (220ns - 230ns)
*	Reading 0+1010010010100111 from address 00000001 (from port 1) during cycle 22 (220ns - 230ns)
*	Writing 0+0101010000111001  to  address 00000000 (from port 0) during cycle 23 (230ns - 240ns)
*	Reading 0+1010010010100111 from address 00000001 (from port 1) during cycle 24 (240ns - 250ns)
*	Reading 0+1110101110101110 from address 10000000 (from port 1) during cycle 27 (270ns - 280ns)
*	Reading 0+1110101110101110 from address 10000000 (from port 1) during cycle 28 (280ns - 290ns)
*	Writing 0+0101100111011011  to  address 01111111 (from port 0) during cycle 29 (290ns - 300ns)
*	Reading 0+1110101110101110 from address 10000000 (from port 1) during cycle 29 (290ns - 300ns)
*	Reading 0+0101010000111001 from address 00000000 (from port 1) during cycle 31 (310ns - 320ns)
*	Writing 0+1011001111000100  to  address 00000000 (from port 0) during cycle 32 (320ns - 330ns)
*	Reading 0+0101100111011011 from address 01111111 (from port 1) during cycle 32 (320ns - 330ns)
*	Reading 0+1110101110101110 from address 10000000 (from port 1) during cycle 34 (340ns - 350ns)
*	Reading 0+1010010010100111 from address 00000001 (from port 1) during cycle 35 (350ns - 360ns)
*	Reading 0+0101100111011011 from address 01111111 (from port 1) during cycle 36 (360ns - 370ns)
*	Writing 0+0010111010110010  to  address 01111111 (from port 0) during cycle 37 (370ns - 380ns)
*	Reading 0+1110101110101110 from address 10000000 (from port 1) during cycle 37 (370ns - 380ns)
*	Writing 0+1100111110100011  to  address 01111111 (from port 0) during cycle 38 (380ns - 390ns)
*	Writing 0+0111111011001011  to  address 00000000 (from port 0) during cycle 39 (390ns - 400ns)
*	Writing 0+1100101100001001  to  address 00000001 (from port 0) during cycle 40 (400ns - 410ns)
*	Reading 0+1100101100001001 from address 00000001 (from port 1) during cycle 42 (420ns - 430ns)
*	Reading 0+1100101100001001 from address 00000001 (from port 1) during cycle 45 (450ns - 460ns)
*	Writing 0+1000110101110010  to  address 01111111 (from port 0) during cycle 46 (460ns - 470ns)
*	Reading 0+1000110101110010 from address 01111111 (from port 1) during cycle 47 (470ns - 480ns)
*	Writing 0+1000100111001101  to  address 10000000 (from port 0) during cycle 48 (480ns - 490ns)
*	Writing 0+1010101111000001  to  address 01111111 (from port 0) during cycle 49 (490ns - 500ns)
*	Writing 0+0110101110101001  to  address 00000001 (from port 0) during cycle 50 (500ns - 510ns)
*	Reading 0+0111111011001011 from address 00000000 (from port 1) during cycle 50 (500ns - 510ns)
*	Writing 0+1100100110111111  to  address 00000000 (from port 0) during cycle 51 (510ns - 520ns)
*	Reading 0+1010101111000001 from address 01111111 (from port 1) during cycle 52 (520ns - 530ns)
*	Reading 0+1100100110111111 from address 00000000 (from port 1) during cycle 55 (550ns - 560ns)
*	Reading 0+0110101110101001 from address 00000001 (from port 1) during cycle 56 (560ns - 570ns)
*	Writing 0+1011101100001001  to  address 00000001 (from port 0) during cycle 57 (570ns - 580ns)
*	Reading 0+1100100110111111 from address 00000000 (from port 1) during cycle 57 (570ns - 580ns)
*	Reading 0+1100100110111111 from address 00000000 (from port 1) during cycle 58 (580ns - 590ns)
*	Reading 0+1000100111001101 from address 10000000 (from port 1) during cycle 59 (590ns - 600ns)
*	Reading 0+1000100111001101 from address 10000000 (from port 1) during cycle 60 (600ns - 610ns)
*	Writing 0+1011010110001000  to  address 00000000 (from port 0) during cycle 62 (620ns - 630ns)
*	Writing 0+0001010010010010  to  address 01111111 (from port 0) during cycle 63 (630ns - 640ns)
*	Reading 0+1000100111001101 from address 10000000 (from port 1) during cycle 65 (650ns - 660ns)
*	Reading 0+1000100111001101 from address 10000000 (from port 1) during cycle 66 (660ns - 670ns)
*	Writing 0+0110101111000000  to  address 10000000 (from port 0) during cycle 67 (670ns - 680ns)
*	Writing 0+1010011101010111  to  address 01111111 (from port 0) during cycle 68 (680ns - 690ns)
*	Reading 0+0110101111000000 from address 10000000 (from port 1) during cycle 68 (680ns - 690ns)
*	Writing 0+0011110110100010  to  address 00000001 (from port 0) during cycle 69 (690ns - 700ns)
*	Writing 0+1100001011101100  to  address 01111111 (from port 0) during cycle 70 (700ns - 710ns)
*	Reading 0+0011110110100010 from address 00000001 (from port 1) during cycle 70 (700ns - 710ns)
*	Reading 0+0011110110100010 from address 00000001 (from port 1) during cycle 71 (710ns - 720ns)
*	Writing 0+0101001100011111  to  address 01111111 (from port 0) during cycle 72 (720ns - 730ns)
*	Writing 0+1010111101110011  to  address 00000001 (from port 0) during cycle 75 (750ns - 760ns)
*	Writing 0+0000110101011101  to  address 00000001 (from port 0) during cycle 76 (760ns - 770ns)
*	Reading 0+0101001100011111 from address 01111111 (from port 1) during cycle 76 (760ns - 770ns)
*	Writing 0+1011101100100001  to  address 00000001 (from port 0) during cycle 77 (770ns - 780ns)
*	Reading 0+1011010110001000 from address 00000000 (from port 1) during cycle 77 (770ns - 780ns)
*	Reading 0+1011101100100001 from address 00000001 (from port 1) during cycle 78 (780ns - 790ns)
*	Writing 0+1011011110011010  to  address 00000000 (from port 0) during cycle 79 (790ns - 800ns)
*	Reading 0+1011101100100001 from address 00000001 (from port 1) during cycle 79 (790ns - 800ns)
*	Writing 0+1011000010010101  to  address 01111111 (from port 0) during cycle 80 (800ns - 810ns)
*	Reading 0+1011011110011010 from address 00000000 (from port 1) during cycle 81 (810ns - 820ns)
*	Writing 0+0010010100111001  to  address 00000000 (from port 0) during cycle 82 (820ns - 830ns)
*	Writing 0+0110011100101100  to  address 10000000 (from port 0) during cycle 83 (830ns - 840ns)
*	Reading 0+1011101100100001 from address 00000001 (from port 1) during cycle 85 (850ns - 860ns)
*	Writing 0+1000000110001001  to  address 01111111 (from port 0) during cycle 86 (860ns - 870ns)
*	Reading 0+0010010100111001 from address 00000000 (from port 1) during cycle 87 (870ns - 880ns)
*	Reading 0+0010010100111001 from address 00000000 (from port 1) during cycle 89 (890ns - 900ns)
*	Writing 0+0111110101111001  to  address 00000001 (from port 0) during cycle 90 (900ns - 910ns)
*	Writing 0+1011010010101000  to  address 00000000 (from port 0) during cycle 91 (910ns - 920ns)
*	Writing 0+1001111110011000  to  address 01111111 (from port 0) during cycle 92 (920ns - 930ns)
*	Writing 0+1111000100110001  to  address 01111111 (from port 0) during cycle 93 (930ns - 940ns)
*	Reading 0+0110011100101100 from address 10000000 (from port 1) during cycle 93 (930ns - 940ns)
*	Writing 0+0011010011111100  to  address 01111111 (from port 0) during cycle 94 (940ns - 950ns)
*	Writing 0+1001101111011001  to  address 10000000 (from port 0) during cycle 95 (950ns - 960ns)
*	Writing 0+1010000111010001  to  address 00000000 (from port 0) during cycle 97 (970ns - 980ns)
*	Reading 0+1001101111011001 from address 10000000 (from port 1) during cycle 97 (970ns - 980ns)
*	Writing 0+0100000110010000  to  address 01111111 (from port 0) during cycle 98 (980ns - 990ns)
*	Writing 0+1010001110110111  to  address 00000000 (from port 0) during cycle 99 (990ns - 1000ns)
*	Writing 0+1101010010011010  to  address 10000000 (from port 0) during cycle 100 (1000ns - 1010ns)
*	Writing 0+1000001010001010  to  address 00000000 (from port 0) during cycle 103 (1030ns - 1040ns)
*	Writing 0+1001000101000000  to  address 01111111 (from port 0) during cycle 104 (1040ns - 1050ns)
*	Writing 0+0111111001000001  to  address 00000001 (from port 0) during cycle 105 (1050ns - 1060ns)
*	Reading 0+1000001010001010 from address 00000000 (from port 1) during cycle 105 (1050ns - 1060ns)
*	Writing 0+1111101110001011  to  address 00000001 (from port 0) during cycle 106 (1060ns - 1070ns)
*	Reading 0+1001000101000000 from address 01111111 (from port 1) during cycle 106 (1060ns - 1070ns)
*	Writing 0+0101010110000110  to  address 00000001 (from port 0) during cycle 108 (1080ns - 1090ns)
*	Reading 0+1101010010011010 from address 10000000 (from port 1) during cycle 108 (1080ns - 1090ns)
*	Reading 0+1001000101000000 from address 01111111 (from port 1) during cycle 109 (1090ns - 1100ns)
*	Writing 0+1110110110001010  to  address 00000000 (from port 0) during cycle 110 (1100ns - 1110ns)
*	Reading 0+0101010110000110 from address 00000001 (from port 1) during cycle 110 (1100ns - 1110ns)
*	Reading 0+1101010010011010 from address 10000000 (from port 1) during cycle 111 (1110ns - 1120ns)
*	Reading 0+1001000101000000 from address 01111111 (from port 1) during cycle 113 (1130ns - 1140ns)
*	Reading 0+1101010010011010 from address 10000000 (from port 1) during cycle 114 (1140ns - 1150ns)
*	Writing 0+0010111100100100  to  address 01111111 (from port 0) during cycle 116 (1160ns - 1170ns)
*	Writing 0+0101111100101100  to  address 01111111 (from port 0) during cycle 117 (1170ns - 1180ns)
*	Writing 0+1010111001001001  to  address 10000000 (from port 0) during cycle 118 (1180ns - 1190ns)
*	Reading 0+0101111100101100 from address 01111111 (from port 1) during cycle 118 (1180ns - 1190ns)
*	Reading 0+0101111100101100 from address 01111111 (from port 1) during cycle 119 (1190ns - 1200ns)
*	Reading 0+1110110110001010 from address 00000000 (from port 1) during cycle 120 (1200ns - 1210ns)
*	Reading 0+0101010110000110 from address 00000001 (from port 1) during cycle 122 (1220ns - 1230ns)
*	Writing 0+1000110101011000  to  address 01111111 (from port 0) during cycle 123 (1230ns - 1240ns)
*	Reading 0+1110110110001010 from address 00000000 (from port 1) during cycle 123 (1230ns - 1240ns)
*	Writing 0+1110101001010011  to  address 01111111 (from port 0) during cycle 124 (1240ns - 1250ns)
*	Writing 0+1011100100100110  to  address 01111111 (from port 0) during cycle 125 (1250ns - 1260ns)
*	Writing 0+0111010110001100  to  address 01111111 (from port 0) during cycle 126 (1260ns - 1270ns)
*	Reading 0+0101010110000110 from address 00000001 (from port 1) during cycle 126 (1260ns - 1270ns)
*	Writing 0+0000100011011110  to  address 00000001 (from port 0) during cycle 128 (1280ns - 1290ns)
*	Writing 0+0001101001110111  to  address 00000001 (from port 0) during cycle 130 (1300ns - 1310ns)
*	Writing 0+0011101001011011  to  address 01111111 (from port 0) during cycle 133 (1330ns - 1340ns)
*	Reading 0+1110110110001010 from address 00000000 (from port 1) during cycle 133 (1330ns - 1340ns)
*	Writing 0+0101111011111111  to  address 01111111 (from port 0) during cycle 134 (1340ns - 1350ns)
*	Reading 0+0101111011111111 from address 01111111 (from port 1) during cycle 139 (1390ns - 1400ns)
*	Writing 0+0001000010110011  to  address 00000000 (from port 0) during cycle 140 (1400ns - 1410ns)
*	Reading 0+0001000010110011 from address 00000000 (from port 1) during cycle 142 (1420ns - 1430ns)
*	Writing 0+0011011101101010  to  address 10000000 (from port 0) during cycle 143 (1430ns - 1440ns)
*	Writing 0+1100001010011000  to  address 00000000 (from port 0) during cycle 144 (1440ns - 1450ns)
*	Reading 0+0101111011111111 from address 01111111 (from port 1) during cycle 144 (1440ns - 1450ns)
*	Reading 0+0101111011111111 from address 01111111 (from port 1) during cycle 145 (1450ns - 1460ns)
*	Writing 0+1011011001110100  to  address 00000000 (from port 0) during cycle 148 (1480ns - 1490ns)
*	Reading 0+0011011101101010 from address 10000000 (from port 1) during cycle 148 (1480ns - 1490ns)
*	Reading 0+0101111011111111 from address 01111111 (from port 1) during cycle 150 (1500ns - 1510ns)
*	Writing 0+1111000100001110  to  address 00000001 (from port 0) during cycle 151 (1510ns - 1520ns)
*	Reading 0+0011011101101010 from address 10000000 (from port 1) during cycle 151 (1510ns - 1520ns)
*	Writing 0+0101010001011110  to  address 01111111 (from port 0) during cycle 152 (1520ns - 1530ns)
*	Writing 0+0101011011101100  to  address 10000000 (from port 0) during cycle 154 (1540ns - 1550ns)
*	Reading 0+1011011001110100 from address 00000000 (from port 1) during cycle 154 (1540ns - 1550ns)
*	Reading 0+0101011011101100 from address 10000000 (from port 1) during cycle 156 (1560ns - 1570ns)
*	Writing 0+0110100001001001  to  address 00000001 (from port 0) during cycle 157 (1570ns - 1580ns)
*	Writing 0+1000000100111110  to  address 10000000 (from port 0) during cycle 158 (1580ns - 1590ns)
*	Reading 0+0101010001011110 from address 01111111 (from port 1) during cycle 158 (1580ns - 1590ns)
*	Reading 0+0110100001001001 from address 00000001 (from port 1) during cycle 162 (1620ns - 1630ns)
*	Writing 0+1000100010011000  to  address 01111111 (from port 0) during cycle 163 (1630ns - 1640ns)
*	Writing 0+1010001110010011  to  address 10000000 (from port 0) during cycle 165 (1650ns - 1660ns)
*	Writing 0+0101010101011110  to  address 01111111 (from port 0) during cycle 166 (1660ns - 1670ns)
*	Reading 0+0110100001001001 from address 00000001 (from port 1) during cycle 166 (1660ns - 1670ns)
*	Reading 0+0110100001001001 from address 00000001 (from port 1) during cycle 168 (1680ns - 1690ns)
*	Writing 0+0110111000110011  to  address 01111111 (from port 0) during cycle 169 (1690ns - 1700ns)
*	Writing 0+1011101000111010  to  address 00000000 (from port 0) during cycle 170 (1700ns - 1710ns)
*	Writing 0+0101010001011100  to  address 00000001 (from port 0) during cycle 171 (1710ns - 1720ns)
*	Reading 0+1011101000111010 from address 00000000 (from port 1) during cycle 173 (1730ns - 1740ns)
*	Writing 0+0011011011000011  to  address 10000000 (from port 0) during cycle 174 (1740ns - 1750ns)
*	Reading 0+0101010001011100 from address 00000001 (from port 1) during cycle 174 (1740ns - 1750ns)
*	Writing 0+0111001100101011  to  address 10000000 (from port 0) during cycle 175 (1750ns - 1760ns)
*	Writing 0+1010100101000111  to  address 01111111 (from port 0) during cycle 176 (1760ns - 1770ns)
*	Writing 0+0101101010011110  to  address 00000000 (from port 0) during cycle 177 (1770ns - 1780ns)
*	Writing 0+1000100100011000  to  address 01111111 (from port 0) during cycle 178 (1780ns - 1790ns)
*	Writing 0+1111010100111011  to  address 01111111 (from port 0) during cycle 179 (1790ns - 1800ns)
*	Reading 0+0101101010011110 from address 00000000 (from port 1) during cycle 179 (1790ns - 1800ns)
*	Writing 0+0110001100000111  to  address 10000000 (from port 0) during cycle 180 (1800ns - 1810ns)
*	Writing 0+1100111111001110  to  address 01111111 (from port 0) during cycle 182 (1820ns - 1830ns)
*	Writing 0+1110100001110111  to  address 00000001 (from port 0) during cycle 183 (1830ns - 1840ns)
*	Reading 0+0110001100000111 from address 10000000 (from port 1) during cycle 183 (1830ns - 1840ns)
*	Reading 0+1100111111001110 from address 01111111 (from port 1) during cycle 186 (1860ns - 1870ns)
*	Writing 0+0011010011101100  to  address 01111111 (from port 0) during cycle 187 (1870ns - 1880ns)
*	Writing 0+0001101010011110  to  address 00000000 (from port 0) during cycle 190 (1900ns - 1910ns)
*	Writing 0+1100110110111100  to  address 01111111 (from port 0) during cycle 191 (1910ns - 1920ns)
*	Writing 0+1101111111110010  to  address 00000000 (from port 0) during cycle 192 (1920ns - 1930ns)
*	Writing 0+0000011101100100  to  address 01111111 (from port 0) during cycle 193 (1930ns - 1940ns)
*	Writing 0+0011000101100111  to  address 00000000 (from port 0) during cycle 195 (1950ns - 1960ns)
*	Reading 0+0000011101100100 from address 01111111 (from port 1) during cycle 195 (1950ns - 1960ns)
*	Writing 0+1000101100110001  to  address 00000001 (from port 0) during cycle 196 (1960ns - 1970ns)
*	Writing 0+0010011111100000  to  address 00000000 (from port 0) during cycle 197 (1970ns - 1980ns)
*	Reading 0+1000101100110001 from address 00000001 (from port 1) during cycle 197 (1970ns - 1980ns)
*	Writing 0+0100100100000111  to  address 01111111 (from port 0) during cycle 199 (1990ns - 2000ns)
*	Reading 0+0010011111100000 from address 00000000 (from port 1) during cycle 201 (2010ns - 2020ns)
*	Writing 0+0110110110010101  to  address 00000001 (from port 0) during cycle 202 (2020ns - 2030ns)
*	Writing 0+1111111101001101  to  address 01111111 (from port 0) during cycle 204 (2040ns - 2050ns)
*	Reading 0+0010011111100000 from address 00000000 (from port 1) during cycle 204 (2040ns - 2050ns)
*	Idle during cycle 205 (2050ns - 2060ns)

* Generation of data and address signals
* (time, data): [(0, 0), (10, 0), (20, 0), (30, 1), (40, 1), (50, 1), (60, 1), (70, 1), (80, 0), (90, 1), (100, 0), (110, 0), (120, 0), (130, 0), (140, 0), (150, 0), (160, 0), (170, 0), (180, 1), (190, 1), (200, 0), (210, 0), (220, 1), (230, 1), (240, 1), (250, 1), (260, 1), (270, 1), (280, 1), (290, 1), (300, 1), (310, 1), (320, 0), (330, 0), (340, 0), (350, 0), (360, 0), (370, 0), (380, 1), (390, 1), (400, 1), (410, 1), (420, 1), (430, 1), (440, 1), (450, 1), (460, 0), (470, 0), (480, 1), (490, 1), (500, 1), (510, 1), (520, 1), (530, 1), (540, 1), (550, 1), (560, 1), (570, 1), (580, 1), (590, 1), (600, 1), (610, 1), (620, 0), (630, 0), (640, 0), (650, 0), (660, 0), (670, 0), (680, 1), (690, 0), (700, 0), (710, 0), (720, 1), (730, 1), (740, 1), (750, 1), (760, 1), (770, 1), (780, 1), (790, 0), (800, 1), (810, 1), (820, 1), (830, 0), (840, 0), (850, 0), (860, 1), (870, 1), (880, 1), (890, 1), (900, 1), (910, 0), (920, 0), (930, 1), (940, 0), (950, 1), (960, 1), (970, 1), (980, 0), (990, 1), (1000, 0), (1010, 0), (1020, 0), (1030, 0), (1040, 0), (1050, 1), (1060, 1), (1070, 1), (1080, 0), (1090, 0), (1100, 0), (1110, 0), (1120, 0), (1130, 0), (1140, 0), (1150, 0), (1160, 0), (1170, 0), (1180, 1), (1190, 1), (1200, 1), (1210, 1), (1220, 1), (1230, 0), (1240, 1), (1250, 0), (1260, 0), (1270, 0), (1280, 0), (1290, 0), (1300, 1), (1310, 1), (1320, 1), (1330, 1), (1340, 1), (1350, 1), (1360, 1), (1370, 1), (1380, 1), (1390, 1), (1400, 1), (1410, 1), (1420, 1), (1430, 0), (1440, 0), (1450, 0), (1460, 0), (1470, 0), (1480, 0), (1490, 0), (1500, 0), (1510, 0), (1520, 0), (1530, 0), (1540, 0), (1550, 0), (1560, 0), (1570, 1), (1580, 0), (1590, 0), (1600, 0), (1610, 0), (1620, 0), (1630, 0), (1640, 0), (1650, 1), (1660, 0), (1670, 0), (1680, 0), (1690, 1), (1700, 0), (1710, 0), (1720, 0), (1730, 0), (1740, 1), (1750, 1), (1760, 1), (1770, 0), (1780, 0), (1790, 1), (1800, 1), (1810, 1), (1820, 0), (1830, 1), (1840, 1), (1850, 1), (1860, 1), (1870, 0), (1880, 0), (1890, 0), (1900, 0), (1910, 0), (1920, 0), (1930, 0), (1940, 0), (1950, 1), (1960, 1), (1970, 0), (1980, 0), (1990, 1), (2000, 1), (2010, 1), (2020, 1), (2030, 1), (2040, 1), (2050, 1)]
Vdin0_0  din0_0  0 PWL (0n 0.0v 9.495n 0.0v 9.505n 0.0v 19.495n 0.0v 19.505n 0.0v 29.495n 0.0v 29.505n 1.7v 39.495n 1.7v 39.505n 1.7v 49.495n 1.7v 49.505n 1.7v 59.495n 1.7v 59.505n 1.7v 69.495n 1.7v 69.505n 1.7v 79.495n 1.7v 79.505n 0.0v 89.495n 0.0v 89.505n 1.7v 99.495n 1.7v 99.505n 0.0v 109.495n 0.0v 109.505n 0.0v 119.495n 0.0v 119.505n 0.0v 129.495n 0.0v 129.505n 0.0v 139.495n 0.0v 139.505n 0.0v 149.495n 0.0v 149.505n 0.0v 159.495n 0.0v 159.505n 0.0v 169.495n 0.0v 169.505n 0.0v 179.495n 0.0v 179.505n 1.7v 189.495n 1.7v 189.505n 1.7v 199.495n 1.7v 199.505n 0.0v 209.495n 0.0v 209.505n 0.0v 219.495n 0.0v 219.505n 1.7v 229.495n 1.7v 229.505n 1.7v 239.495n 1.7v 239.505n 1.7v 249.495n 1.7v 249.505n 1.7v 259.495n 1.7v 259.505n 1.7v 269.495n 1.7v 269.505n 1.7v 279.495n 1.7v 279.505n 1.7v 289.495n 1.7v 289.505n 1.7v 299.495n 1.7v 299.505n 1.7v 309.495n 1.7v 309.505n 1.7v 319.495n 1.7v 319.505n 0.0v 329.495n 0.0v 329.505n 0.0v 339.495n 0.0v 339.505n 0.0v 349.495n 0.0v 349.505n 0.0v 359.495n 0.0v 359.505n 0.0v 369.495n 0.0v 369.505n 0.0v 379.495n 0.0v 379.505n 1.7v 389.495n 1.7v 389.505n 1.7v 399.495n 1.7v 399.505n 1.7v 409.495n 1.7v 409.505n 1.7v 419.495n 1.7v 419.505n 1.7v 429.495n 1.7v 429.505n 1.7v 439.495n 1.7v 439.505n 1.7v 449.495n 1.7v 449.505n 1.7v 459.495n 1.7v 459.505n 0.0v 469.495n 0.0v 469.505n 0.0v 479.495n 0.0v 479.505n 1.7v 489.495n 1.7v 489.505n 1.7v 499.495n 1.7v 499.505n 1.7v 509.495n 1.7v 509.505n 1.7v 519.495n 1.7v 519.505n 1.7v 529.495n 1.7v 529.505n 1.7v 539.495n 1.7v 539.505n 1.7v 549.495n 1.7v 549.505n 1.7v 559.495n 1.7v 559.505n 1.7v 569.495n 1.7v 569.505n 1.7v 579.495n 1.7v 579.505n 1.7v 589.495n 1.7v 589.505n 1.7v 599.495n 1.7v 599.505n 1.7v 609.495n 1.7v 609.505n 1.7v 619.495n 1.7v 619.505n 0.0v 629.495n 0.0v 629.505n 0.0v 639.495n 0.0v 639.505n 0.0v 649.495n 0.0v 649.505n 0.0v 659.495n 0.0v 659.505n 0.0v 669.495n 0.0v 669.505n 0.0v 679.495n 0.0v 679.505n 1.7v 689.495n 1.7v 689.505n 0.0v 699.495n 0.0v 699.505n 0.0v 709.495n 0.0v 709.505n 0.0v 719.495n 0.0v 719.505n 1.7v 729.495n 1.7v 729.505n 1.7v 739.495n 1.7v 739.505n 1.7v 749.495n 1.7v 749.505n 1.7v 759.495n 1.7v 759.505n 1.7v 769.495n 1.7v 769.505n 1.7v 779.495n 1.7v 779.505n 1.7v 789.495n 1.7v 789.505n 0.0v 799.495n 0.0v 799.505n 1.7v 809.495n 1.7v 809.505n 1.7v 819.495n 1.7v 819.505n 1.7v 829.495n 1.7v 829.505n 0.0v 839.495n 0.0v 839.505n 0.0v 849.495n 0.0v 849.505n 0.0v 859.495n 0.0v 859.505n 1.7v 869.495n 1.7v 869.505n 1.7v 879.495n 1.7v 879.505n 1.7v 889.495n 1.7v 889.505n 1.7v 899.495n 1.7v 899.505n 1.7v 909.495n 1.7v 909.505n 0.0v 919.495n 0.0v 919.505n 0.0v 929.495n 0.0v 929.505n 1.7v 939.495n 1.7v 939.505n 0.0v 949.495n 0.0v 949.505n 1.7v 959.495n 1.7v 959.505n 1.7v 969.495n 1.7v 969.505n 1.7v 979.495n 1.7v 979.505n 0.0v 989.495n 0.0v 989.505n 1.7v 999.495n 1.7v 999.505n 0.0v 1009.495n 0.0v 1009.505n 0.0v 1019.495n 0.0v 1019.505n 0.0v 1029.495n 0.0v 1029.505n 0.0v 1039.495n 0.0v 1039.505n 0.0v 1049.495n 0.0v 1049.505n 1.7v 1059.495n 1.7v 1059.505n 1.7v 1069.495n 1.7v 1069.505n 1.7v 1079.495n 1.7v 1079.505n 0.0v 1089.495n 0.0v 1089.505n 0.0v 1099.495n 0.0v 1099.505n 0.0v 1109.495n 0.0v 1109.505n 0.0v 1119.495n 0.0v 1119.505n 0.0v 1129.495n 0.0v 1129.505n 0.0v 1139.495n 0.0v 1139.505n 0.0v 1149.495n 0.0v 1149.505n 0.0v 1159.495n 0.0v 1159.505n 0.0v 1169.495n 0.0v 1169.505n 0.0v 1179.495n 0.0v 1179.505n 1.7v 1189.495n 1.7v 1189.505n 1.7v 1199.495n 1.7v 1199.505n 1.7v 1209.495n 1.7v 1209.505n 1.7v 1219.495n 1.7v 1219.505n 1.7v 1229.495n 1.7v 1229.505n 0.0v 1239.495n 0.0v 1239.505n 1.7v 1249.495n 1.7v 1249.505n 0.0v 1259.495n 0.0v 1259.505n 0.0v 1269.495n 0.0v 1269.505n 0.0v 1279.495n 0.0v 1279.505n 0.0v 1289.495n 0.0v 1289.505n 0.0v 1299.495n 0.0v 1299.505n 1.7v 1309.495n 1.7v 1309.505n 1.7v 1319.495n 1.7v 1319.505n 1.7v 1329.495n 1.7v 1329.505n 1.7v 1339.495n 1.7v 1339.505n 1.7v 1349.495n 1.7v 1349.505n 1.7v 1359.495n 1.7v 1359.505n 1.7v 1369.495n 1.7v 1369.505n 1.7v 1379.495n 1.7v 1379.505n 1.7v 1389.495n 1.7v 1389.505n 1.7v 1399.495n 1.7v 1399.505n 1.7v 1409.495n 1.7v 1409.505n 1.7v 1419.495n 1.7v 1419.505n 1.7v 1429.495n 1.7v 1429.505n 0.0v 1439.495n 0.0v 1439.505n 0.0v 1449.495n 0.0v 1449.505n 0.0v 1459.495n 0.0v 1459.505n 0.0v 1469.495n 0.0v 1469.505n 0.0v 1479.495n 0.0v 1479.505n 0.0v 1489.495n 0.0v 1489.505n 0.0v 1499.495n 0.0v 1499.505n 0.0v 1509.495n 0.0v 1509.505n 0.0v 1519.495n 0.0v 1519.505n 0.0v 1529.495n 0.0v 1529.505n 0.0v 1539.495n 0.0v 1539.505n 0.0v 1549.495n 0.0v 1549.505n 0.0v 1559.495n 0.0v 1559.505n 0.0v 1569.495n 0.0v 1569.505n 1.7v 1579.495n 1.7v 1579.505n 0.0v 1589.495n 0.0v 1589.505n 0.0v 1599.495n 0.0v 1599.505n 0.0v 1609.495n 0.0v 1609.505n 0.0v 1619.495n 0.0v 1619.505n 0.0v 1629.495n 0.0v 1629.505n 0.0v 1639.495n 0.0v 1639.505n 0.0v 1649.495n 0.0v 1649.505n 1.7v 1659.495n 1.7v 1659.505n 0.0v 1669.495n 0.0v 1669.505n 0.0v 1679.495n 0.0v 1679.505n 0.0v 1689.495n 0.0v 1689.505n 1.7v 1699.495n 1.7v 1699.505n 0.0v 1709.495n 0.0v 1709.505n 0.0v 1719.495n 0.0v 1719.505n 0.0v 1729.495n 0.0v 1729.505n 0.0v 1739.495n 0.0v 1739.505n 1.7v 1749.495n 1.7v 1749.505n 1.7v 1759.495n 1.7v 1759.505n 1.7v 1769.495n 1.7v 1769.505n 0.0v 1779.495n 0.0v 1779.505n 0.0v 1789.495n 0.0v 1789.505n 1.7v 1799.495n 1.7v 1799.505n 1.7v 1809.495n 1.7v 1809.505n 1.7v 1819.495n 1.7v 1819.505n 0.0v 1829.495n 0.0v 1829.505n 1.7v 1839.495n 1.7v 1839.505n 1.7v 1849.495n 1.7v 1849.505n 1.7v 1859.495n 1.7v 1859.505n 1.7v 1869.495n 1.7v 1869.505n 0.0v 1879.495n 0.0v 1879.505n 0.0v 1889.495n 0.0v 1889.505n 0.0v 1899.495n 0.0v 1899.505n 0.0v 1909.495n 0.0v 1909.505n 0.0v 1919.495n 0.0v 1919.505n 0.0v 1929.495n 0.0v 1929.505n 0.0v 1939.495n 0.0v 1939.505n 0.0v 1949.495n 0.0v 1949.505n 1.7v 1959.495n 1.7v 1959.505n 1.7v 1969.495n 1.7v 1969.505n 0.0v 1979.495n 0.0v 1979.505n 0.0v 1989.495n 0.0v 1989.505n 1.7v 1999.495n 1.7v 1999.505n 1.7v 2009.495n 1.7v 2009.505n 1.7v 2019.495n 1.7v 2019.505n 1.7v 2029.495n 1.7v 2029.505n 1.7v 2039.495n 1.7v 2039.505n 1.7v 2049.495n 1.7v 2049.505n 1.7v )
* (time, data): [(0, 0), (10, 0), (20, 1), (30, 0), (40, 0), (50, 0), (60, 0), (70, 0), (80, 1), (90, 1), (100, 0), (110, 0), (120, 0), (130, 0), (140, 0), (150, 1), (160, 1), (170, 1), (180, 0), (190, 1), (200, 0), (210, 0), (220, 0), (230, 0), (240, 0), (250, 0), (260, 0), (270, 0), (280, 0), (290, 1), (300, 1), (310, 1), (320, 0), (330, 0), (340, 0), (350, 0), (360, 0), (370, 1), (380, 1), (390, 1), (400, 0), (410, 0), (420, 0), (430, 0), (440, 0), (450, 0), (460, 1), (470, 1), (480, 0), (490, 0), (500, 0), (510, 1), (520, 1), (530, 1), (540, 1), (550, 1), (560, 1), (570, 0), (580, 0), (590, 0), (600, 0), (610, 0), (620, 0), (630, 1), (640, 1), (650, 1), (660, 1), (670, 0), (680, 1), (690, 1), (700, 0), (710, 0), (720, 1), (730, 1), (740, 1), (750, 1), (760, 0), (770, 0), (780, 0), (790, 1), (800, 0), (810, 0), (820, 0), (830, 0), (840, 0), (850, 0), (860, 0), (870, 0), (880, 0), (890, 0), (900, 0), (910, 0), (920, 0), (930, 0), (940, 0), (950, 0), (960, 0), (970, 0), (980, 0), (990, 1), (1000, 1), (1010, 1), (1020, 1), (1030, 1), (1040, 0), (1050, 0), (1060, 1), (1070, 1), (1080, 1), (1090, 1), (1100, 1), (1110, 1), (1120, 1), (1130, 1), (1140, 1), (1150, 1), (1160, 0), (1170, 0), (1180, 0), (1190, 0), (1200, 0), (1210, 0), (1220, 0), (1230, 0), (1240, 1), (1250, 1), (1260, 0), (1270, 0), (1280, 1), (1290, 1), (1300, 1), (1310, 1), (1320, 1), (1330, 1), (1340, 1), (1350, 1), (1360, 1), (1370, 1), (1380, 1), (1390, 1), (1400, 1), (1410, 1), (1420, 1), (1430, 1), (1440, 0), (1450, 0), (1460, 0), (1470, 0), (1480, 0), (1490, 0), (1500, 0), (1510, 1), (1520, 1), (1530, 1), (1540, 0), (1550, 0), (1560, 0), (1570, 0), (1580, 1), (1590, 1), (1600, 1), (1610, 1), (1620, 1), (1630, 0), (1640, 0), (1650, 1), (1660, 1), (1670, 1), (1680, 1), (1690, 1), (1700, 1), (1710, 0), (1720, 0), (1730, 0), (1740, 1), (1750, 1), (1760, 1), (1770, 1), (1780, 0), (1790, 1), (1800, 1), (1810, 1), (1820, 1), (1830, 1), (1840, 1), (1850, 1), (1860, 1), (1870, 0), (1880, 0), (1890, 0), (1900, 1), (1910, 0), (1920, 1), (1930, 0), (1940, 0), (1950, 1), (1960, 0), (1970, 0), (1980, 0), (1990, 1), (2000, 1), (2010, 1), (2020, 0), (2030, 0), (2040, 0), (2050, 0)]
Vdin0_1  din0_1  0 PWL (0n 0.0v 9.495n 0.0v 9.505n 0.0v 19.495n 0.0v 19.505n 1.7v 29.495n 1.7v 29.505n 0.0v 39.495n 0.0v 39.505n 0.0v 49.495n 0.0v 49.505n 0.0v 59.495n 0.0v 59.505n 0.0v 69.495n 0.0v 69.505n 0.0v 79.495n 0.0v 79.505n 1.7v 89.495n 1.7v 89.505n 1.7v 99.495n 1.7v 99.505n 0.0v 109.495n 0.0v 109.505n 0.0v 119.495n 0.0v 119.505n 0.0v 129.495n 0.0v 129.505n 0.0v 139.495n 0.0v 139.505n 0.0v 149.495n 0.0v 149.505n 1.7v 159.495n 1.7v 159.505n 1.7v 169.495n 1.7v 169.505n 1.7v 179.495n 1.7v 179.505n 0.0v 189.495n 0.0v 189.505n 1.7v 199.495n 1.7v 199.505n 0.0v 209.495n 0.0v 209.505n 0.0v 219.495n 0.0v 219.505n 0.0v 229.495n 0.0v 229.505n 0.0v 239.495n 0.0v 239.505n 0.0v 249.495n 0.0v 249.505n 0.0v 259.495n 0.0v 259.505n 0.0v 269.495n 0.0v 269.505n 0.0v 279.495n 0.0v 279.505n 0.0v 289.495n 0.0v 289.505n 1.7v 299.495n 1.7v 299.505n 1.7v 309.495n 1.7v 309.505n 1.7v 319.495n 1.7v 319.505n 0.0v 329.495n 0.0v 329.505n 0.0v 339.495n 0.0v 339.505n 0.0v 349.495n 0.0v 349.505n 0.0v 359.495n 0.0v 359.505n 0.0v 369.495n 0.0v 369.505n 1.7v 379.495n 1.7v 379.505n 1.7v 389.495n 1.7v 389.505n 1.7v 399.495n 1.7v 399.505n 0.0v 409.495n 0.0v 409.505n 0.0v 419.495n 0.0v 419.505n 0.0v 429.495n 0.0v 429.505n 0.0v 439.495n 0.0v 439.505n 0.0v 449.495n 0.0v 449.505n 0.0v 459.495n 0.0v 459.505n 1.7v 469.495n 1.7v 469.505n 1.7v 479.495n 1.7v 479.505n 0.0v 489.495n 0.0v 489.505n 0.0v 499.495n 0.0v 499.505n 0.0v 509.495n 0.0v 509.505n 1.7v 519.495n 1.7v 519.505n 1.7v 529.495n 1.7v 529.505n 1.7v 539.495n 1.7v 539.505n 1.7v 549.495n 1.7v 549.505n 1.7v 559.495n 1.7v 559.505n 1.7v 569.495n 1.7v 569.505n 0.0v 579.495n 0.0v 579.505n 0.0v 589.495n 0.0v 589.505n 0.0v 599.495n 0.0v 599.505n 0.0v 609.495n 0.0v 609.505n 0.0v 619.495n 0.0v 619.505n 0.0v 629.495n 0.0v 629.505n 1.7v 639.495n 1.7v 639.505n 1.7v 649.495n 1.7v 649.505n 1.7v 659.495n 1.7v 659.505n 1.7v 669.495n 1.7v 669.505n 0.0v 679.495n 0.0v 679.505n 1.7v 689.495n 1.7v 689.505n 1.7v 699.495n 1.7v 699.505n 0.0v 709.495n 0.0v 709.505n 0.0v 719.495n 0.0v 719.505n 1.7v 729.495n 1.7v 729.505n 1.7v 739.495n 1.7v 739.505n 1.7v 749.495n 1.7v 749.505n 1.7v 759.495n 1.7v 759.505n 0.0v 769.495n 0.0v 769.505n 0.0v 779.495n 0.0v 779.505n 0.0v 789.495n 0.0v 789.505n 1.7v 799.495n 1.7v 799.505n 0.0v 809.495n 0.0v 809.505n 0.0v 819.495n 0.0v 819.505n 0.0v 829.495n 0.0v 829.505n 0.0v 839.495n 0.0v 839.505n 0.0v 849.495n 0.0v 849.505n 0.0v 859.495n 0.0v 859.505n 0.0v 869.495n 0.0v 869.505n 0.0v 879.495n 0.0v 879.505n 0.0v 889.495n 0.0v 889.505n 0.0v 899.495n 0.0v 899.505n 0.0v 909.495n 0.0v 909.505n 0.0v 919.495n 0.0v 919.505n 0.0v 929.495n 0.0v 929.505n 0.0v 939.495n 0.0v 939.505n 0.0v 949.495n 0.0v 949.505n 0.0v 959.495n 0.0v 959.505n 0.0v 969.495n 0.0v 969.505n 0.0v 979.495n 0.0v 979.505n 0.0v 989.495n 0.0v 989.505n 1.7v 999.495n 1.7v 999.505n 1.7v 1009.495n 1.7v 1009.505n 1.7v 1019.495n 1.7v 1019.505n 1.7v 1029.495n 1.7v 1029.505n 1.7v 1039.495n 1.7v 1039.505n 0.0v 1049.495n 0.0v 1049.505n 0.0v 1059.495n 0.0v 1059.505n 1.7v 1069.495n 1.7v 1069.505n 1.7v 1079.495n 1.7v 1079.505n 1.7v 1089.495n 1.7v 1089.505n 1.7v 1099.495n 1.7v 1099.505n 1.7v 1109.495n 1.7v 1109.505n 1.7v 1119.495n 1.7v 1119.505n 1.7v 1129.495n 1.7v 1129.505n 1.7v 1139.495n 1.7v 1139.505n 1.7v 1149.495n 1.7v 1149.505n 1.7v 1159.495n 1.7v 1159.505n 0.0v 1169.495n 0.0v 1169.505n 0.0v 1179.495n 0.0v 1179.505n 0.0v 1189.495n 0.0v 1189.505n 0.0v 1199.495n 0.0v 1199.505n 0.0v 1209.495n 0.0v 1209.505n 0.0v 1219.495n 0.0v 1219.505n 0.0v 1229.495n 0.0v 1229.505n 0.0v 1239.495n 0.0v 1239.505n 1.7v 1249.495n 1.7v 1249.505n 1.7v 1259.495n 1.7v 1259.505n 0.0v 1269.495n 0.0v 1269.505n 0.0v 1279.495n 0.0v 1279.505n 1.7v 1289.495n 1.7v 1289.505n 1.7v 1299.495n 1.7v 1299.505n 1.7v 1309.495n 1.7v 1309.505n 1.7v 1319.495n 1.7v 1319.505n 1.7v 1329.495n 1.7v 1329.505n 1.7v 1339.495n 1.7v 1339.505n 1.7v 1349.495n 1.7v 1349.505n 1.7v 1359.495n 1.7v 1359.505n 1.7v 1369.495n 1.7v 1369.505n 1.7v 1379.495n 1.7v 1379.505n 1.7v 1389.495n 1.7v 1389.505n 1.7v 1399.495n 1.7v 1399.505n 1.7v 1409.495n 1.7v 1409.505n 1.7v 1419.495n 1.7v 1419.505n 1.7v 1429.495n 1.7v 1429.505n 1.7v 1439.495n 1.7v 1439.505n 0.0v 1449.495n 0.0v 1449.505n 0.0v 1459.495n 0.0v 1459.505n 0.0v 1469.495n 0.0v 1469.505n 0.0v 1479.495n 0.0v 1479.505n 0.0v 1489.495n 0.0v 1489.505n 0.0v 1499.495n 0.0v 1499.505n 0.0v 1509.495n 0.0v 1509.505n 1.7v 1519.495n 1.7v 1519.505n 1.7v 1529.495n 1.7v 1529.505n 1.7v 1539.495n 1.7v 1539.505n 0.0v 1549.495n 0.0v 1549.505n 0.0v 1559.495n 0.0v 1559.505n 0.0v 1569.495n 0.0v 1569.505n 0.0v 1579.495n 0.0v 1579.505n 1.7v 1589.495n 1.7v 1589.505n 1.7v 1599.495n 1.7v 1599.505n 1.7v 1609.495n 1.7v 1609.505n 1.7v 1619.495n 1.7v 1619.505n 1.7v 1629.495n 1.7v 1629.505n 0.0v 1639.495n 0.0v 1639.505n 0.0v 1649.495n 0.0v 1649.505n 1.7v 1659.495n 1.7v 1659.505n 1.7v 1669.495n 1.7v 1669.505n 1.7v 1679.495n 1.7v 1679.505n 1.7v 1689.495n 1.7v 1689.505n 1.7v 1699.495n 1.7v 1699.505n 1.7v 1709.495n 1.7v 1709.505n 0.0v 1719.495n 0.0v 1719.505n 0.0v 1729.495n 0.0v 1729.505n 0.0v 1739.495n 0.0v 1739.505n 1.7v 1749.495n 1.7v 1749.505n 1.7v 1759.495n 1.7v 1759.505n 1.7v 1769.495n 1.7v 1769.505n 1.7v 1779.495n 1.7v 1779.505n 0.0v 1789.495n 0.0v 1789.505n 1.7v 1799.495n 1.7v 1799.505n 1.7v 1809.495n 1.7v 1809.505n 1.7v 1819.495n 1.7v 1819.505n 1.7v 1829.495n 1.7v 1829.505n 1.7v 1839.495n 1.7v 1839.505n 1.7v 1849.495n 1.7v 1849.505n 1.7v 1859.495n 1.7v 1859.505n 1.7v 1869.495n 1.7v 1869.505n 0.0v 1879.495n 0.0v 1879.505n 0.0v 1889.495n 0.0v 1889.505n 0.0v 1899.495n 0.0v 1899.505n 1.7v 1909.495n 1.7v 1909.505n 0.0v 1919.495n 0.0v 1919.505n 1.7v 1929.495n 1.7v 1929.505n 0.0v 1939.495n 0.0v 1939.505n 0.0v 1949.495n 0.0v 1949.505n 1.7v 1959.495n 1.7v 1959.505n 0.0v 1969.495n 0.0v 1969.505n 0.0v 1979.495n 0.0v 1979.505n 0.0v 1989.495n 0.0v 1989.505n 1.7v 1999.495n 1.7v 1999.505n 1.7v 2009.495n 1.7v 2009.505n 1.7v 2019.495n 1.7v 2019.505n 0.0v 2029.495n 0.0v 2029.505n 0.0v 2039.495n 0.0v 2039.505n 0.0v 2049.495n 0.0v 2049.505n 0.0v )
* (time, data): [(0, 0), (10, 1), (20, 1), (30, 0), (40, 0), (50, 0), (60, 0), (70, 1), (80, 1), (90, 0), (100, 1), (110, 1), (120, 1), (130, 1), (140, 1), (150, 0), (160, 1), (170, 1), (180, 0), (190, 1), (200, 1), (210, 1), (220, 1), (230, 0), (240, 0), (250, 0), (260, 0), (270, 0), (280, 0), (290, 0), (300, 0), (310, 0), (320, 1), (330, 1), (340, 1), (350, 1), (360, 1), (370, 0), (380, 0), (390, 0), (400, 0), (410, 0), (420, 0), (430, 0), (440, 0), (450, 0), (460, 0), (470, 0), (480, 1), (490, 0), (500, 0), (510, 1), (520, 1), (530, 1), (540, 1), (550, 1), (560, 1), (570, 0), (580, 0), (590, 0), (600, 0), (610, 0), (620, 0), (630, 0), (640, 0), (650, 0), (660, 0), (670, 0), (680, 1), (690, 0), (700, 1), (710, 1), (720, 1), (730, 1), (740, 1), (750, 0), (760, 1), (770, 0), (780, 0), (790, 0), (800, 1), (810, 1), (820, 0), (830, 1), (840, 1), (850, 1), (860, 0), (870, 0), (880, 0), (890, 0), (900, 0), (910, 0), (920, 0), (930, 0), (940, 1), (950, 0), (960, 0), (970, 0), (980, 0), (990, 1), (1000, 0), (1010, 0), (1020, 0), (1030, 0), (1040, 0), (1050, 0), (1060, 0), (1070, 0), (1080, 1), (1090, 1), (1100, 0), (1110, 0), (1120, 0), (1130, 0), (1140, 0), (1150, 0), (1160, 1), (1170, 1), (1180, 0), (1190, 0), (1200, 0), (1210, 0), (1220, 0), (1230, 0), (1240, 0), (1250, 1), (1260, 1), (1270, 1), (1280, 1), (1290, 1), (1300, 1), (1310, 1), (1320, 1), (1330, 0), (1340, 1), (1350, 1), (1360, 1), (1370, 1), (1380, 1), (1390, 1), (1400, 0), (1410, 0), (1420, 0), (1430, 0), (1440, 0), (1450, 0), (1460, 0), (1470, 0), (1480, 1), (1490, 1), (1500, 1), (1510, 1), (1520, 1), (1530, 1), (1540, 1), (1550, 1), (1560, 1), (1570, 0), (1580, 1), (1590, 1), (1600, 1), (1610, 1), (1620, 1), (1630, 0), (1640, 0), (1650, 0), (1660, 1), (1670, 1), (1680, 1), (1690, 0), (1700, 0), (1710, 1), (1720, 1), (1730, 1), (1740, 0), (1750, 0), (1760, 1), (1770, 1), (1780, 0), (1790, 0), (1800, 1), (1810, 1), (1820, 1), (1830, 1), (1840, 1), (1850, 1), (1860, 1), (1870, 1), (1880, 1), (1890, 1), (1900, 1), (1910, 1), (1920, 0), (1930, 1), (1940, 1), (1950, 1), (1960, 0), (1970, 0), (1980, 0), (1990, 1), (2000, 1), (2010, 1), (2020, 1), (2030, 1), (2040, 1), (2050, 1)]
Vdin0_2  din0_2  0 PWL (0n 0.0v 9.495n 0.0v 9.505n 1.7v 19.495n 1.7v 19.505n 1.7v 29.495n 1.7v 29.505n 0.0v 39.495n 0.0v 39.505n 0.0v 49.495n 0.0v 49.505n 0.0v 59.495n 0.0v 59.505n 0.0v 69.495n 0.0v 69.505n 1.7v 79.495n 1.7v 79.505n 1.7v 89.495n 1.7v 89.505n 0.0v 99.495n 0.0v 99.505n 1.7v 109.495n 1.7v 109.505n 1.7v 119.495n 1.7v 119.505n 1.7v 129.495n 1.7v 129.505n 1.7v 139.495n 1.7v 139.505n 1.7v 149.495n 1.7v 149.505n 0.0v 159.495n 0.0v 159.505n 1.7v 169.495n 1.7v 169.505n 1.7v 179.495n 1.7v 179.505n 0.0v 189.495n 0.0v 189.505n 1.7v 199.495n 1.7v 199.505n 1.7v 209.495n 1.7v 209.505n 1.7v 219.495n 1.7v 219.505n 1.7v 229.495n 1.7v 229.505n 0.0v 239.495n 0.0v 239.505n 0.0v 249.495n 0.0v 249.505n 0.0v 259.495n 0.0v 259.505n 0.0v 269.495n 0.0v 269.505n 0.0v 279.495n 0.0v 279.505n 0.0v 289.495n 0.0v 289.505n 0.0v 299.495n 0.0v 299.505n 0.0v 309.495n 0.0v 309.505n 0.0v 319.495n 0.0v 319.505n 1.7v 329.495n 1.7v 329.505n 1.7v 339.495n 1.7v 339.505n 1.7v 349.495n 1.7v 349.505n 1.7v 359.495n 1.7v 359.505n 1.7v 369.495n 1.7v 369.505n 0.0v 379.495n 0.0v 379.505n 0.0v 389.495n 0.0v 389.505n 0.0v 399.495n 0.0v 399.505n 0.0v 409.495n 0.0v 409.505n 0.0v 419.495n 0.0v 419.505n 0.0v 429.495n 0.0v 429.505n 0.0v 439.495n 0.0v 439.505n 0.0v 449.495n 0.0v 449.505n 0.0v 459.495n 0.0v 459.505n 0.0v 469.495n 0.0v 469.505n 0.0v 479.495n 0.0v 479.505n 1.7v 489.495n 1.7v 489.505n 0.0v 499.495n 0.0v 499.505n 0.0v 509.495n 0.0v 509.505n 1.7v 519.495n 1.7v 519.505n 1.7v 529.495n 1.7v 529.505n 1.7v 539.495n 1.7v 539.505n 1.7v 549.495n 1.7v 549.505n 1.7v 559.495n 1.7v 559.505n 1.7v 569.495n 1.7v 569.505n 0.0v 579.495n 0.0v 579.505n 0.0v 589.495n 0.0v 589.505n 0.0v 599.495n 0.0v 599.505n 0.0v 609.495n 0.0v 609.505n 0.0v 619.495n 0.0v 619.505n 0.0v 629.495n 0.0v 629.505n 0.0v 639.495n 0.0v 639.505n 0.0v 649.495n 0.0v 649.505n 0.0v 659.495n 0.0v 659.505n 0.0v 669.495n 0.0v 669.505n 0.0v 679.495n 0.0v 679.505n 1.7v 689.495n 1.7v 689.505n 0.0v 699.495n 0.0v 699.505n 1.7v 709.495n 1.7v 709.505n 1.7v 719.495n 1.7v 719.505n 1.7v 729.495n 1.7v 729.505n 1.7v 739.495n 1.7v 739.505n 1.7v 749.495n 1.7v 749.505n 0.0v 759.495n 0.0v 759.505n 1.7v 769.495n 1.7v 769.505n 0.0v 779.495n 0.0v 779.505n 0.0v 789.495n 0.0v 789.505n 0.0v 799.495n 0.0v 799.505n 1.7v 809.495n 1.7v 809.505n 1.7v 819.495n 1.7v 819.505n 0.0v 829.495n 0.0v 829.505n 1.7v 839.495n 1.7v 839.505n 1.7v 849.495n 1.7v 849.505n 1.7v 859.495n 1.7v 859.505n 0.0v 869.495n 0.0v 869.505n 0.0v 879.495n 0.0v 879.505n 0.0v 889.495n 0.0v 889.505n 0.0v 899.495n 0.0v 899.505n 0.0v 909.495n 0.0v 909.505n 0.0v 919.495n 0.0v 919.505n 0.0v 929.495n 0.0v 929.505n 0.0v 939.495n 0.0v 939.505n 1.7v 949.495n 1.7v 949.505n 0.0v 959.495n 0.0v 959.505n 0.0v 969.495n 0.0v 969.505n 0.0v 979.495n 0.0v 979.505n 0.0v 989.495n 0.0v 989.505n 1.7v 999.495n 1.7v 999.505n 0.0v 1009.495n 0.0v 1009.505n 0.0v 1019.495n 0.0v 1019.505n 0.0v 1029.495n 0.0v 1029.505n 0.0v 1039.495n 0.0v 1039.505n 0.0v 1049.495n 0.0v 1049.505n 0.0v 1059.495n 0.0v 1059.505n 0.0v 1069.495n 0.0v 1069.505n 0.0v 1079.495n 0.0v 1079.505n 1.7v 1089.495n 1.7v 1089.505n 1.7v 1099.495n 1.7v 1099.505n 0.0v 1109.495n 0.0v 1109.505n 0.0v 1119.495n 0.0v 1119.505n 0.0v 1129.495n 0.0v 1129.505n 0.0v 1139.495n 0.0v 1139.505n 0.0v 1149.495n 0.0v 1149.505n 0.0v 1159.495n 0.0v 1159.505n 1.7v 1169.495n 1.7v 1169.505n 1.7v 1179.495n 1.7v 1179.505n 0.0v 1189.495n 0.0v 1189.505n 0.0v 1199.495n 0.0v 1199.505n 0.0v 1209.495n 0.0v 1209.505n 0.0v 1219.495n 0.0v 1219.505n 0.0v 1229.495n 0.0v 1229.505n 0.0v 1239.495n 0.0v 1239.505n 0.0v 1249.495n 0.0v 1249.505n 1.7v 1259.495n 1.7v 1259.505n 1.7v 1269.495n 1.7v 1269.505n 1.7v 1279.495n 1.7v 1279.505n 1.7v 1289.495n 1.7v 1289.505n 1.7v 1299.495n 1.7v 1299.505n 1.7v 1309.495n 1.7v 1309.505n 1.7v 1319.495n 1.7v 1319.505n 1.7v 1329.495n 1.7v 1329.505n 0.0v 1339.495n 0.0v 1339.505n 1.7v 1349.495n 1.7v 1349.505n 1.7v 1359.495n 1.7v 1359.505n 1.7v 1369.495n 1.7v 1369.505n 1.7v 1379.495n 1.7v 1379.505n 1.7v 1389.495n 1.7v 1389.505n 1.7v 1399.495n 1.7v 1399.505n 0.0v 1409.495n 0.0v 1409.505n 0.0v 1419.495n 0.0v 1419.505n 0.0v 1429.495n 0.0v 1429.505n 0.0v 1439.495n 0.0v 1439.505n 0.0v 1449.495n 0.0v 1449.505n 0.0v 1459.495n 0.0v 1459.505n 0.0v 1469.495n 0.0v 1469.505n 0.0v 1479.495n 0.0v 1479.505n 1.7v 1489.495n 1.7v 1489.505n 1.7v 1499.495n 1.7v 1499.505n 1.7v 1509.495n 1.7v 1509.505n 1.7v 1519.495n 1.7v 1519.505n 1.7v 1529.495n 1.7v 1529.505n 1.7v 1539.495n 1.7v 1539.505n 1.7v 1549.495n 1.7v 1549.505n 1.7v 1559.495n 1.7v 1559.505n 1.7v 1569.495n 1.7v 1569.505n 0.0v 1579.495n 0.0v 1579.505n 1.7v 1589.495n 1.7v 1589.505n 1.7v 1599.495n 1.7v 1599.505n 1.7v 1609.495n 1.7v 1609.505n 1.7v 1619.495n 1.7v 1619.505n 1.7v 1629.495n 1.7v 1629.505n 0.0v 1639.495n 0.0v 1639.505n 0.0v 1649.495n 0.0v 1649.505n 0.0v 1659.495n 0.0v 1659.505n 1.7v 1669.495n 1.7v 1669.505n 1.7v 1679.495n 1.7v 1679.505n 1.7v 1689.495n 1.7v 1689.505n 0.0v 1699.495n 0.0v 1699.505n 0.0v 1709.495n 0.0v 1709.505n 1.7v 1719.495n 1.7v 1719.505n 1.7v 1729.495n 1.7v 1729.505n 1.7v 1739.495n 1.7v 1739.505n 0.0v 1749.495n 0.0v 1749.505n 0.0v 1759.495n 0.0v 1759.505n 1.7v 1769.495n 1.7v 1769.505n 1.7v 1779.495n 1.7v 1779.505n 0.0v 1789.495n 0.0v 1789.505n 0.0v 1799.495n 0.0v 1799.505n 1.7v 1809.495n 1.7v 1809.505n 1.7v 1819.495n 1.7v 1819.505n 1.7v 1829.495n 1.7v 1829.505n 1.7v 1839.495n 1.7v 1839.505n 1.7v 1849.495n 1.7v 1849.505n 1.7v 1859.495n 1.7v 1859.505n 1.7v 1869.495n 1.7v 1869.505n 1.7v 1879.495n 1.7v 1879.505n 1.7v 1889.495n 1.7v 1889.505n 1.7v 1899.495n 1.7v 1899.505n 1.7v 1909.495n 1.7v 1909.505n 1.7v 1919.495n 1.7v 1919.505n 0.0v 1929.495n 0.0v 1929.505n 1.7v 1939.495n 1.7v 1939.505n 1.7v 1949.495n 1.7v 1949.505n 1.7v 1959.495n 1.7v 1959.505n 0.0v 1969.495n 0.0v 1969.505n 0.0v 1979.495n 0.0v 1979.505n 0.0v 1989.495n 0.0v 1989.505n 1.7v 1999.495n 1.7v 1999.505n 1.7v 2009.495n 1.7v 2009.505n 1.7v 2019.495n 1.7v 2019.505n 1.7v 2029.495n 1.7v 2029.505n 1.7v 2039.495n 1.7v 2039.505n 1.7v 2049.495n 1.7v 2049.505n 1.7v )
* (time, data): [(0, 0), (10, 0), (20, 1), (30, 0), (40, 0), (50, 0), (60, 0), (70, 1), (80, 1), (90, 1), (100, 1), (110, 1), (120, 0), (130, 1), (140, 1), (150, 1), (160, 1), (170, 1), (180, 0), (190, 0), (200, 0), (210, 0), (220, 0), (230, 1), (240, 1), (250, 1), (260, 1), (270, 1), (280, 1), (290, 1), (300, 1), (310, 1), (320, 0), (330, 0), (340, 0), (350, 0), (360, 0), (370, 0), (380, 0), (390, 1), (400, 1), (410, 1), (420, 1), (430, 1), (440, 1), (450, 1), (460, 0), (470, 0), (480, 1), (490, 0), (500, 1), (510, 1), (520, 1), (530, 1), (540, 1), (550, 1), (560, 1), (570, 1), (580, 1), (590, 1), (600, 1), (610, 1), (620, 1), (630, 0), (640, 0), (650, 0), (660, 0), (670, 0), (680, 0), (690, 0), (700, 1), (710, 1), (720, 1), (730, 1), (740, 1), (750, 0), (760, 1), (770, 0), (780, 0), (790, 1), (800, 0), (810, 0), (820, 1), (830, 1), (840, 1), (850, 1), (860, 1), (870, 1), (880, 1), (890, 1), (900, 1), (910, 1), (920, 1), (930, 0), (940, 1), (950, 1), (960, 1), (970, 0), (980, 0), (990, 0), (1000, 1), (1010, 1), (1020, 1), (1030, 1), (1040, 0), (1050, 0), (1060, 1), (1070, 1), (1080, 0), (1090, 0), (1100, 1), (1110, 1), (1120, 1), (1130, 1), (1140, 1), (1150, 1), (1160, 0), (1170, 1), (1180, 1), (1190, 1), (1200, 1), (1210, 1), (1220, 1), (1230, 1), (1240, 0), (1250, 0), (1260, 1), (1270, 1), (1280, 1), (1290, 1), (1300, 0), (1310, 0), (1320, 0), (1330, 1), (1340, 1), (1350, 1), (1360, 1), (1370, 1), (1380, 1), (1390, 1), (1400, 0), (1410, 0), (1420, 0), (1430, 1), (1440, 1), (1450, 1), (1460, 1), (1470, 1), (1480, 0), (1490, 0), (1500, 0), (1510, 1), (1520, 1), (1530, 1), (1540, 1), (1550, 1), (1560, 1), (1570, 1), (1580, 1), (1590, 1), (1600, 1), (1610, 1), (1620, 1), (1630, 1), (1640, 1), (1650, 0), (1660, 1), (1670, 1), (1680, 1), (1690, 0), (1700, 1), (1710, 1), (1720, 1), (1730, 1), (1740, 0), (1750, 1), (1760, 0), (1770, 1), (1780, 1), (1790, 1), (1800, 0), (1810, 0), (1820, 1), (1830, 0), (1840, 0), (1850, 0), (1860, 0), (1870, 1), (1880, 1), (1890, 1), (1900, 1), (1910, 1), (1920, 0), (1930, 0), (1940, 0), (1950, 0), (1960, 0), (1970, 0), (1980, 0), (1990, 0), (2000, 0), (2010, 0), (2020, 0), (2030, 0), (2040, 1), (2050, 1)]
Vdin0_3  din0_3  0 PWL (0n 0.0v 9.495n 0.0v 9.505n 0.0v 19.495n 0.0v 19.505n 1.7v 29.495n 1.7v 29.505n 0.0v 39.495n 0.0v 39.505n 0.0v 49.495n 0.0v 49.505n 0.0v 59.495n 0.0v 59.505n 0.0v 69.495n 0.0v 69.505n 1.7v 79.495n 1.7v 79.505n 1.7v 89.495n 1.7v 89.505n 1.7v 99.495n 1.7v 99.505n 1.7v 109.495n 1.7v 109.505n 1.7v 119.495n 1.7v 119.505n 0.0v 129.495n 0.0v 129.505n 1.7v 139.495n 1.7v 139.505n 1.7v 149.495n 1.7v 149.505n 1.7v 159.495n 1.7v 159.505n 1.7v 169.495n 1.7v 169.505n 1.7v 179.495n 1.7v 179.505n 0.0v 189.495n 0.0v 189.505n 0.0v 199.495n 0.0v 199.505n 0.0v 209.495n 0.0v 209.505n 0.0v 219.495n 0.0v 219.505n 0.0v 229.495n 0.0v 229.505n 1.7v 239.495n 1.7v 239.505n 1.7v 249.495n 1.7v 249.505n 1.7v 259.495n 1.7v 259.505n 1.7v 269.495n 1.7v 269.505n 1.7v 279.495n 1.7v 279.505n 1.7v 289.495n 1.7v 289.505n 1.7v 299.495n 1.7v 299.505n 1.7v 309.495n 1.7v 309.505n 1.7v 319.495n 1.7v 319.505n 0.0v 329.495n 0.0v 329.505n 0.0v 339.495n 0.0v 339.505n 0.0v 349.495n 0.0v 349.505n 0.0v 359.495n 0.0v 359.505n 0.0v 369.495n 0.0v 369.505n 0.0v 379.495n 0.0v 379.505n 0.0v 389.495n 0.0v 389.505n 1.7v 399.495n 1.7v 399.505n 1.7v 409.495n 1.7v 409.505n 1.7v 419.495n 1.7v 419.505n 1.7v 429.495n 1.7v 429.505n 1.7v 439.495n 1.7v 439.505n 1.7v 449.495n 1.7v 449.505n 1.7v 459.495n 1.7v 459.505n 0.0v 469.495n 0.0v 469.505n 0.0v 479.495n 0.0v 479.505n 1.7v 489.495n 1.7v 489.505n 0.0v 499.495n 0.0v 499.505n 1.7v 509.495n 1.7v 509.505n 1.7v 519.495n 1.7v 519.505n 1.7v 529.495n 1.7v 529.505n 1.7v 539.495n 1.7v 539.505n 1.7v 549.495n 1.7v 549.505n 1.7v 559.495n 1.7v 559.505n 1.7v 569.495n 1.7v 569.505n 1.7v 579.495n 1.7v 579.505n 1.7v 589.495n 1.7v 589.505n 1.7v 599.495n 1.7v 599.505n 1.7v 609.495n 1.7v 609.505n 1.7v 619.495n 1.7v 619.505n 1.7v 629.495n 1.7v 629.505n 0.0v 639.495n 0.0v 639.505n 0.0v 649.495n 0.0v 649.505n 0.0v 659.495n 0.0v 659.505n 0.0v 669.495n 0.0v 669.505n 0.0v 679.495n 0.0v 679.505n 0.0v 689.495n 0.0v 689.505n 0.0v 699.495n 0.0v 699.505n 1.7v 709.495n 1.7v 709.505n 1.7v 719.495n 1.7v 719.505n 1.7v 729.495n 1.7v 729.505n 1.7v 739.495n 1.7v 739.505n 1.7v 749.495n 1.7v 749.505n 0.0v 759.495n 0.0v 759.505n 1.7v 769.495n 1.7v 769.505n 0.0v 779.495n 0.0v 779.505n 0.0v 789.495n 0.0v 789.505n 1.7v 799.495n 1.7v 799.505n 0.0v 809.495n 0.0v 809.505n 0.0v 819.495n 0.0v 819.505n 1.7v 829.495n 1.7v 829.505n 1.7v 839.495n 1.7v 839.505n 1.7v 849.495n 1.7v 849.505n 1.7v 859.495n 1.7v 859.505n 1.7v 869.495n 1.7v 869.505n 1.7v 879.495n 1.7v 879.505n 1.7v 889.495n 1.7v 889.505n 1.7v 899.495n 1.7v 899.505n 1.7v 909.495n 1.7v 909.505n 1.7v 919.495n 1.7v 919.505n 1.7v 929.495n 1.7v 929.505n 0.0v 939.495n 0.0v 939.505n 1.7v 949.495n 1.7v 949.505n 1.7v 959.495n 1.7v 959.505n 1.7v 969.495n 1.7v 969.505n 0.0v 979.495n 0.0v 979.505n 0.0v 989.495n 0.0v 989.505n 0.0v 999.495n 0.0v 999.505n 1.7v 1009.495n 1.7v 1009.505n 1.7v 1019.495n 1.7v 1019.505n 1.7v 1029.495n 1.7v 1029.505n 1.7v 1039.495n 1.7v 1039.505n 0.0v 1049.495n 0.0v 1049.505n 0.0v 1059.495n 0.0v 1059.505n 1.7v 1069.495n 1.7v 1069.505n 1.7v 1079.495n 1.7v 1079.505n 0.0v 1089.495n 0.0v 1089.505n 0.0v 1099.495n 0.0v 1099.505n 1.7v 1109.495n 1.7v 1109.505n 1.7v 1119.495n 1.7v 1119.505n 1.7v 1129.495n 1.7v 1129.505n 1.7v 1139.495n 1.7v 1139.505n 1.7v 1149.495n 1.7v 1149.505n 1.7v 1159.495n 1.7v 1159.505n 0.0v 1169.495n 0.0v 1169.505n 1.7v 1179.495n 1.7v 1179.505n 1.7v 1189.495n 1.7v 1189.505n 1.7v 1199.495n 1.7v 1199.505n 1.7v 1209.495n 1.7v 1209.505n 1.7v 1219.495n 1.7v 1219.505n 1.7v 1229.495n 1.7v 1229.505n 1.7v 1239.495n 1.7v 1239.505n 0.0v 1249.495n 0.0v 1249.505n 0.0v 1259.495n 0.0v 1259.505n 1.7v 1269.495n 1.7v 1269.505n 1.7v 1279.495n 1.7v 1279.505n 1.7v 1289.495n 1.7v 1289.505n 1.7v 1299.495n 1.7v 1299.505n 0.0v 1309.495n 0.0v 1309.505n 0.0v 1319.495n 0.0v 1319.505n 0.0v 1329.495n 0.0v 1329.505n 1.7v 1339.495n 1.7v 1339.505n 1.7v 1349.495n 1.7v 1349.505n 1.7v 1359.495n 1.7v 1359.505n 1.7v 1369.495n 1.7v 1369.505n 1.7v 1379.495n 1.7v 1379.505n 1.7v 1389.495n 1.7v 1389.505n 1.7v 1399.495n 1.7v 1399.505n 0.0v 1409.495n 0.0v 1409.505n 0.0v 1419.495n 0.0v 1419.505n 0.0v 1429.495n 0.0v 1429.505n 1.7v 1439.495n 1.7v 1439.505n 1.7v 1449.495n 1.7v 1449.505n 1.7v 1459.495n 1.7v 1459.505n 1.7v 1469.495n 1.7v 1469.505n 1.7v 1479.495n 1.7v 1479.505n 0.0v 1489.495n 0.0v 1489.505n 0.0v 1499.495n 0.0v 1499.505n 0.0v 1509.495n 0.0v 1509.505n 1.7v 1519.495n 1.7v 1519.505n 1.7v 1529.495n 1.7v 1529.505n 1.7v 1539.495n 1.7v 1539.505n 1.7v 1549.495n 1.7v 1549.505n 1.7v 1559.495n 1.7v 1559.505n 1.7v 1569.495n 1.7v 1569.505n 1.7v 1579.495n 1.7v 1579.505n 1.7v 1589.495n 1.7v 1589.505n 1.7v 1599.495n 1.7v 1599.505n 1.7v 1609.495n 1.7v 1609.505n 1.7v 1619.495n 1.7v 1619.505n 1.7v 1629.495n 1.7v 1629.505n 1.7v 1639.495n 1.7v 1639.505n 1.7v 1649.495n 1.7v 1649.505n 0.0v 1659.495n 0.0v 1659.505n 1.7v 1669.495n 1.7v 1669.505n 1.7v 1679.495n 1.7v 1679.505n 1.7v 1689.495n 1.7v 1689.505n 0.0v 1699.495n 0.0v 1699.505n 1.7v 1709.495n 1.7v 1709.505n 1.7v 1719.495n 1.7v 1719.505n 1.7v 1729.495n 1.7v 1729.505n 1.7v 1739.495n 1.7v 1739.505n 0.0v 1749.495n 0.0v 1749.505n 1.7v 1759.495n 1.7v 1759.505n 0.0v 1769.495n 0.0v 1769.505n 1.7v 1779.495n 1.7v 1779.505n 1.7v 1789.495n 1.7v 1789.505n 1.7v 1799.495n 1.7v 1799.505n 0.0v 1809.495n 0.0v 1809.505n 0.0v 1819.495n 0.0v 1819.505n 1.7v 1829.495n 1.7v 1829.505n 0.0v 1839.495n 0.0v 1839.505n 0.0v 1849.495n 0.0v 1849.505n 0.0v 1859.495n 0.0v 1859.505n 0.0v 1869.495n 0.0v 1869.505n 1.7v 1879.495n 1.7v 1879.505n 1.7v 1889.495n 1.7v 1889.505n 1.7v 1899.495n 1.7v 1899.505n 1.7v 1909.495n 1.7v 1909.505n 1.7v 1919.495n 1.7v 1919.505n 0.0v 1929.495n 0.0v 1929.505n 0.0v 1939.495n 0.0v 1939.505n 0.0v 1949.495n 0.0v 1949.505n 0.0v 1959.495n 0.0v 1959.505n 0.0v 1969.495n 0.0v 1969.505n 0.0v 1979.495n 0.0v 1979.505n 0.0v 1989.495n 0.0v 1989.505n 0.0v 1999.495n 0.0v 1999.505n 0.0v 2009.495n 0.0v 2009.505n 0.0v 2019.495n 0.0v 2019.505n 0.0v 2029.495n 0.0v 2029.505n 0.0v 2039.495n 0.0v 2039.505n 1.7v 2049.495n 1.7v 2049.505n 1.7v )
* (time, data): [(0, 0), (10, 0), (20, 1), (30, 0), (40, 0), (50, 0), (60, 0), (70, 1), (80, 1), (90, 0), (100, 1), (110, 1), (120, 1), (130, 1), (140, 1), (150, 0), (160, 0), (170, 0), (180, 1), (190, 0), (200, 1), (210, 0), (220, 1), (230, 1), (240, 1), (250, 1), (260, 1), (270, 1), (280, 1), (290, 1), (300, 1), (310, 1), (320, 0), (330, 0), (340, 0), (350, 0), (360, 0), (370, 1), (380, 0), (390, 0), (400, 0), (410, 0), (420, 0), (430, 0), (440, 0), (450, 0), (460, 1), (470, 1), (480, 0), (490, 0), (500, 0), (510, 1), (520, 1), (530, 1), (540, 1), (550, 1), (560, 1), (570, 0), (580, 0), (590, 0), (600, 0), (610, 0), (620, 0), (630, 1), (640, 1), (650, 1), (660, 1), (670, 0), (680, 1), (690, 0), (700, 0), (710, 0), (720, 1), (730, 1), (740, 1), (750, 1), (760, 1), (770, 0), (780, 0), (790, 1), (800, 1), (810, 1), (820, 1), (830, 0), (840, 0), (850, 0), (860, 0), (870, 0), (880, 0), (890, 0), (900, 1), (910, 0), (920, 1), (930, 1), (940, 1), (950, 1), (960, 1), (970, 1), (980, 1), (990, 1), (1000, 1), (1010, 1), (1020, 1), (1030, 0), (1040, 0), (1050, 0), (1060, 0), (1070, 0), (1080, 0), (1090, 0), (1100, 0), (1110, 0), (1120, 0), (1130, 0), (1140, 0), (1150, 0), (1160, 0), (1170, 0), (1180, 0), (1190, 0), (1200, 0), (1210, 0), (1220, 0), (1230, 1), (1240, 1), (1250, 0), (1260, 0), (1270, 0), (1280, 1), (1290, 1), (1300, 1), (1310, 1), (1320, 1), (1330, 1), (1340, 1), (1350, 1), (1360, 1), (1370, 1), (1380, 1), (1390, 1), (1400, 1), (1410, 1), (1420, 1), (1430, 0), (1440, 1), (1450, 1), (1460, 1), (1470, 1), (1480, 1), (1490, 1), (1500, 1), (1510, 0), (1520, 1), (1530, 1), (1540, 0), (1550, 0), (1560, 0), (1570, 0), (1580, 1), (1590, 1), (1600, 1), (1610, 1), (1620, 1), (1630, 1), (1640, 1), (1650, 1), (1660, 1), (1670, 1), (1680, 1), (1690, 1), (1700, 1), (1710, 1), (1720, 1), (1730, 1), (1740, 0), (1750, 0), (1760, 0), (1770, 1), (1780, 1), (1790, 1), (1800, 0), (1810, 0), (1820, 0), (1830, 1), (1840, 1), (1850, 1), (1860, 1), (1870, 0), (1880, 0), (1890, 0), (1900, 1), (1910, 1), (1920, 1), (1930, 0), (1940, 0), (1950, 0), (1960, 1), (1970, 0), (1980, 0), (1990, 0), (2000, 0), (2010, 0), (2020, 1), (2030, 1), (2040, 0), (2050, 0)]
Vdin0_4  din0_4  0 PWL (0n 0.0v 9.495n 0.0v 9.505n 0.0v 19.495n 0.0v 19.505n 1.7v 29.495n 1.7v 29.505n 0.0v 39.495n 0.0v 39.505n 0.0v 49.495n 0.0v 49.505n 0.0v 59.495n 0.0v 59.505n 0.0v 69.495n 0.0v 69.505n 1.7v 79.495n 1.7v 79.505n 1.7v 89.495n 1.7v 89.505n 0.0v 99.495n 0.0v 99.505n 1.7v 109.495n 1.7v 109.505n 1.7v 119.495n 1.7v 119.505n 1.7v 129.495n 1.7v 129.505n 1.7v 139.495n 1.7v 139.505n 1.7v 149.495n 1.7v 149.505n 0.0v 159.495n 0.0v 159.505n 0.0v 169.495n 0.0v 169.505n 0.0v 179.495n 0.0v 179.505n 1.7v 189.495n 1.7v 189.505n 0.0v 199.495n 0.0v 199.505n 1.7v 209.495n 1.7v 209.505n 0.0v 219.495n 0.0v 219.505n 1.7v 229.495n 1.7v 229.505n 1.7v 239.495n 1.7v 239.505n 1.7v 249.495n 1.7v 249.505n 1.7v 259.495n 1.7v 259.505n 1.7v 269.495n 1.7v 269.505n 1.7v 279.495n 1.7v 279.505n 1.7v 289.495n 1.7v 289.505n 1.7v 299.495n 1.7v 299.505n 1.7v 309.495n 1.7v 309.505n 1.7v 319.495n 1.7v 319.505n 0.0v 329.495n 0.0v 329.505n 0.0v 339.495n 0.0v 339.505n 0.0v 349.495n 0.0v 349.505n 0.0v 359.495n 0.0v 359.505n 0.0v 369.495n 0.0v 369.505n 1.7v 379.495n 1.7v 379.505n 0.0v 389.495n 0.0v 389.505n 0.0v 399.495n 0.0v 399.505n 0.0v 409.495n 0.0v 409.505n 0.0v 419.495n 0.0v 419.505n 0.0v 429.495n 0.0v 429.505n 0.0v 439.495n 0.0v 439.505n 0.0v 449.495n 0.0v 449.505n 0.0v 459.495n 0.0v 459.505n 1.7v 469.495n 1.7v 469.505n 1.7v 479.495n 1.7v 479.505n 0.0v 489.495n 0.0v 489.505n 0.0v 499.495n 0.0v 499.505n 0.0v 509.495n 0.0v 509.505n 1.7v 519.495n 1.7v 519.505n 1.7v 529.495n 1.7v 529.505n 1.7v 539.495n 1.7v 539.505n 1.7v 549.495n 1.7v 549.505n 1.7v 559.495n 1.7v 559.505n 1.7v 569.495n 1.7v 569.505n 0.0v 579.495n 0.0v 579.505n 0.0v 589.495n 0.0v 589.505n 0.0v 599.495n 0.0v 599.505n 0.0v 609.495n 0.0v 609.505n 0.0v 619.495n 0.0v 619.505n 0.0v 629.495n 0.0v 629.505n 1.7v 639.495n 1.7v 639.505n 1.7v 649.495n 1.7v 649.505n 1.7v 659.495n 1.7v 659.505n 1.7v 669.495n 1.7v 669.505n 0.0v 679.495n 0.0v 679.505n 1.7v 689.495n 1.7v 689.505n 0.0v 699.495n 0.0v 699.505n 0.0v 709.495n 0.0v 709.505n 0.0v 719.495n 0.0v 719.505n 1.7v 729.495n 1.7v 729.505n 1.7v 739.495n 1.7v 739.505n 1.7v 749.495n 1.7v 749.505n 1.7v 759.495n 1.7v 759.505n 1.7v 769.495n 1.7v 769.505n 0.0v 779.495n 0.0v 779.505n 0.0v 789.495n 0.0v 789.505n 1.7v 799.495n 1.7v 799.505n 1.7v 809.495n 1.7v 809.505n 1.7v 819.495n 1.7v 819.505n 1.7v 829.495n 1.7v 829.505n 0.0v 839.495n 0.0v 839.505n 0.0v 849.495n 0.0v 849.505n 0.0v 859.495n 0.0v 859.505n 0.0v 869.495n 0.0v 869.505n 0.0v 879.495n 0.0v 879.505n 0.0v 889.495n 0.0v 889.505n 0.0v 899.495n 0.0v 899.505n 1.7v 909.495n 1.7v 909.505n 0.0v 919.495n 0.0v 919.505n 1.7v 929.495n 1.7v 929.505n 1.7v 939.495n 1.7v 939.505n 1.7v 949.495n 1.7v 949.505n 1.7v 959.495n 1.7v 959.505n 1.7v 969.495n 1.7v 969.505n 1.7v 979.495n 1.7v 979.505n 1.7v 989.495n 1.7v 989.505n 1.7v 999.495n 1.7v 999.505n 1.7v 1009.495n 1.7v 1009.505n 1.7v 1019.495n 1.7v 1019.505n 1.7v 1029.495n 1.7v 1029.505n 0.0v 1039.495n 0.0v 1039.505n 0.0v 1049.495n 0.0v 1049.505n 0.0v 1059.495n 0.0v 1059.505n 0.0v 1069.495n 0.0v 1069.505n 0.0v 1079.495n 0.0v 1079.505n 0.0v 1089.495n 0.0v 1089.505n 0.0v 1099.495n 0.0v 1099.505n 0.0v 1109.495n 0.0v 1109.505n 0.0v 1119.495n 0.0v 1119.505n 0.0v 1129.495n 0.0v 1129.505n 0.0v 1139.495n 0.0v 1139.505n 0.0v 1149.495n 0.0v 1149.505n 0.0v 1159.495n 0.0v 1159.505n 0.0v 1169.495n 0.0v 1169.505n 0.0v 1179.495n 0.0v 1179.505n 0.0v 1189.495n 0.0v 1189.505n 0.0v 1199.495n 0.0v 1199.505n 0.0v 1209.495n 0.0v 1209.505n 0.0v 1219.495n 0.0v 1219.505n 0.0v 1229.495n 0.0v 1229.505n 1.7v 1239.495n 1.7v 1239.505n 1.7v 1249.495n 1.7v 1249.505n 0.0v 1259.495n 0.0v 1259.505n 0.0v 1269.495n 0.0v 1269.505n 0.0v 1279.495n 0.0v 1279.505n 1.7v 1289.495n 1.7v 1289.505n 1.7v 1299.495n 1.7v 1299.505n 1.7v 1309.495n 1.7v 1309.505n 1.7v 1319.495n 1.7v 1319.505n 1.7v 1329.495n 1.7v 1329.505n 1.7v 1339.495n 1.7v 1339.505n 1.7v 1349.495n 1.7v 1349.505n 1.7v 1359.495n 1.7v 1359.505n 1.7v 1369.495n 1.7v 1369.505n 1.7v 1379.495n 1.7v 1379.505n 1.7v 1389.495n 1.7v 1389.505n 1.7v 1399.495n 1.7v 1399.505n 1.7v 1409.495n 1.7v 1409.505n 1.7v 1419.495n 1.7v 1419.505n 1.7v 1429.495n 1.7v 1429.505n 0.0v 1439.495n 0.0v 1439.505n 1.7v 1449.495n 1.7v 1449.505n 1.7v 1459.495n 1.7v 1459.505n 1.7v 1469.495n 1.7v 1469.505n 1.7v 1479.495n 1.7v 1479.505n 1.7v 1489.495n 1.7v 1489.505n 1.7v 1499.495n 1.7v 1499.505n 1.7v 1509.495n 1.7v 1509.505n 0.0v 1519.495n 0.0v 1519.505n 1.7v 1529.495n 1.7v 1529.505n 1.7v 1539.495n 1.7v 1539.505n 0.0v 1549.495n 0.0v 1549.505n 0.0v 1559.495n 0.0v 1559.505n 0.0v 1569.495n 0.0v 1569.505n 0.0v 1579.495n 0.0v 1579.505n 1.7v 1589.495n 1.7v 1589.505n 1.7v 1599.495n 1.7v 1599.505n 1.7v 1609.495n 1.7v 1609.505n 1.7v 1619.495n 1.7v 1619.505n 1.7v 1629.495n 1.7v 1629.505n 1.7v 1639.495n 1.7v 1639.505n 1.7v 1649.495n 1.7v 1649.505n 1.7v 1659.495n 1.7v 1659.505n 1.7v 1669.495n 1.7v 1669.505n 1.7v 1679.495n 1.7v 1679.505n 1.7v 1689.495n 1.7v 1689.505n 1.7v 1699.495n 1.7v 1699.505n 1.7v 1709.495n 1.7v 1709.505n 1.7v 1719.495n 1.7v 1719.505n 1.7v 1729.495n 1.7v 1729.505n 1.7v 1739.495n 1.7v 1739.505n 0.0v 1749.495n 0.0v 1749.505n 0.0v 1759.495n 0.0v 1759.505n 0.0v 1769.495n 0.0v 1769.505n 1.7v 1779.495n 1.7v 1779.505n 1.7v 1789.495n 1.7v 1789.505n 1.7v 1799.495n 1.7v 1799.505n 0.0v 1809.495n 0.0v 1809.505n 0.0v 1819.495n 0.0v 1819.505n 0.0v 1829.495n 0.0v 1829.505n 1.7v 1839.495n 1.7v 1839.505n 1.7v 1849.495n 1.7v 1849.505n 1.7v 1859.495n 1.7v 1859.505n 1.7v 1869.495n 1.7v 1869.505n 0.0v 1879.495n 0.0v 1879.505n 0.0v 1889.495n 0.0v 1889.505n 0.0v 1899.495n 0.0v 1899.505n 1.7v 1909.495n 1.7v 1909.505n 1.7v 1919.495n 1.7v 1919.505n 1.7v 1929.495n 1.7v 1929.505n 0.0v 1939.495n 0.0v 1939.505n 0.0v 1949.495n 0.0v 1949.505n 0.0v 1959.495n 0.0v 1959.505n 1.7v 1969.495n 1.7v 1969.505n 0.0v 1979.495n 0.0v 1979.505n 0.0v 1989.495n 0.0v 1989.505n 0.0v 1999.495n 0.0v 1999.505n 0.0v 2009.495n 0.0v 2009.505n 0.0v 2019.495n 0.0v 2019.505n 1.7v 2029.495n 1.7v 2029.505n 1.7v 2039.495n 1.7v 2039.505n 0.0v 2049.495n 0.0v 2049.505n 0.0v )
* (time, data): [(0, 0), (10, 0), (20, 1), (30, 0), (40, 0), (50, 0), (60, 0), (70, 0), (80, 0), (90, 1), (100, 0), (110, 0), (120, 0), (130, 1), (140, 1), (150, 0), (160, 1), (170, 1), (180, 0), (190, 1), (200, 0), (210, 0), (220, 0), (230, 1), (240, 1), (250, 1), (260, 1), (270, 1), (280, 1), (290, 0), (300, 0), (310, 0), (320, 0), (330, 0), (340, 0), (350, 0), (360, 0), (370, 1), (380, 1), (390, 0), (400, 0), (410, 0), (420, 0), (430, 0), (440, 0), (450, 0), (460, 1), (470, 1), (480, 0), (490, 0), (500, 1), (510, 1), (520, 1), (530, 1), (540, 1), (550, 1), (560, 1), (570, 0), (580, 0), (590, 0), (600, 0), (610, 0), (620, 0), (630, 0), (640, 0), (650, 0), (660, 0), (670, 0), (680, 0), (690, 1), (700, 1), (710, 1), (720, 0), (730, 0), (740, 0), (750, 1), (760, 0), (770, 1), (780, 1), (790, 0), (800, 0), (810, 0), (820, 1), (830, 1), (840, 1), (850, 1), (860, 0), (870, 0), (880, 0), (890, 0), (900, 1), (910, 1), (920, 0), (930, 1), (940, 1), (950, 0), (960, 0), (970, 0), (980, 0), (990, 1), (1000, 0), (1010, 0), (1020, 0), (1030, 0), (1040, 0), (1050, 0), (1060, 0), (1070, 0), (1080, 0), (1090, 0), (1100, 0), (1110, 0), (1120, 0), (1130, 0), (1140, 0), (1150, 0), (1160, 1), (1170, 1), (1180, 0), (1190, 0), (1200, 0), (1210, 0), (1220, 0), (1230, 0), (1240, 0), (1250, 1), (1260, 0), (1270, 0), (1280, 0), (1290, 0), (1300, 1), (1310, 1), (1320, 1), (1330, 0), (1340, 1), (1350, 1), (1360, 1), (1370, 1), (1380, 1), (1390, 1), (1400, 1), (1410, 1), (1420, 1), (1430, 1), (1440, 0), (1450, 0), (1460, 0), (1470, 0), (1480, 1), (1490, 1), (1500, 1), (1510, 0), (1520, 0), (1530, 0), (1540, 1), (1550, 1), (1560, 1), (1570, 0), (1580, 1), (1590, 1), (1600, 1), (1610, 1), (1620, 1), (1630, 0), (1640, 0), (1650, 0), (1660, 0), (1670, 0), (1680, 0), (1690, 1), (1700, 1), (1710, 0), (1720, 0), (1730, 0), (1740, 0), (1750, 1), (1760, 0), (1770, 0), (1780, 0), (1790, 1), (1800, 0), (1810, 0), (1820, 0), (1830, 1), (1840, 1), (1850, 1), (1860, 1), (1870, 1), (1880, 1), (1890, 1), (1900, 0), (1910, 1), (1920, 1), (1930, 1), (1940, 1), (1950, 1), (1960, 1), (1970, 1), (1980, 1), (1990, 0), (2000, 0), (2010, 0), (2020, 0), (2030, 0), (2040, 0), (2050, 0)]
Vdin0_5  din0_5  0 PWL (0n 0.0v 9.495n 0.0v 9.505n 0.0v 19.495n 0.0v 19.505n 1.7v 29.495n 1.7v 29.505n 0.0v 39.495n 0.0v 39.505n 0.0v 49.495n 0.0v 49.505n 0.0v 59.495n 0.0v 59.505n 0.0v 69.495n 0.0v 69.505n 0.0v 79.495n 0.0v 79.505n 0.0v 89.495n 0.0v 89.505n 1.7v 99.495n 1.7v 99.505n 0.0v 109.495n 0.0v 109.505n 0.0v 119.495n 0.0v 119.505n 0.0v 129.495n 0.0v 129.505n 1.7v 139.495n 1.7v 139.505n 1.7v 149.495n 1.7v 149.505n 0.0v 159.495n 0.0v 159.505n 1.7v 169.495n 1.7v 169.505n 1.7v 179.495n 1.7v 179.505n 0.0v 189.495n 0.0v 189.505n 1.7v 199.495n 1.7v 199.505n 0.0v 209.495n 0.0v 209.505n 0.0v 219.495n 0.0v 219.505n 0.0v 229.495n 0.0v 229.505n 1.7v 239.495n 1.7v 239.505n 1.7v 249.495n 1.7v 249.505n 1.7v 259.495n 1.7v 259.505n 1.7v 269.495n 1.7v 269.505n 1.7v 279.495n 1.7v 279.505n 1.7v 289.495n 1.7v 289.505n 0.0v 299.495n 0.0v 299.505n 0.0v 309.495n 0.0v 309.505n 0.0v 319.495n 0.0v 319.505n 0.0v 329.495n 0.0v 329.505n 0.0v 339.495n 0.0v 339.505n 0.0v 349.495n 0.0v 349.505n 0.0v 359.495n 0.0v 359.505n 0.0v 369.495n 0.0v 369.505n 1.7v 379.495n 1.7v 379.505n 1.7v 389.495n 1.7v 389.505n 0.0v 399.495n 0.0v 399.505n 0.0v 409.495n 0.0v 409.505n 0.0v 419.495n 0.0v 419.505n 0.0v 429.495n 0.0v 429.505n 0.0v 439.495n 0.0v 439.505n 0.0v 449.495n 0.0v 449.505n 0.0v 459.495n 0.0v 459.505n 1.7v 469.495n 1.7v 469.505n 1.7v 479.495n 1.7v 479.505n 0.0v 489.495n 0.0v 489.505n 0.0v 499.495n 0.0v 499.505n 1.7v 509.495n 1.7v 509.505n 1.7v 519.495n 1.7v 519.505n 1.7v 529.495n 1.7v 529.505n 1.7v 539.495n 1.7v 539.505n 1.7v 549.495n 1.7v 549.505n 1.7v 559.495n 1.7v 559.505n 1.7v 569.495n 1.7v 569.505n 0.0v 579.495n 0.0v 579.505n 0.0v 589.495n 0.0v 589.505n 0.0v 599.495n 0.0v 599.505n 0.0v 609.495n 0.0v 609.505n 0.0v 619.495n 0.0v 619.505n 0.0v 629.495n 0.0v 629.505n 0.0v 639.495n 0.0v 639.505n 0.0v 649.495n 0.0v 649.505n 0.0v 659.495n 0.0v 659.505n 0.0v 669.495n 0.0v 669.505n 0.0v 679.495n 0.0v 679.505n 0.0v 689.495n 0.0v 689.505n 1.7v 699.495n 1.7v 699.505n 1.7v 709.495n 1.7v 709.505n 1.7v 719.495n 1.7v 719.505n 0.0v 729.495n 0.0v 729.505n 0.0v 739.495n 0.0v 739.505n 0.0v 749.495n 0.0v 749.505n 1.7v 759.495n 1.7v 759.505n 0.0v 769.495n 0.0v 769.505n 1.7v 779.495n 1.7v 779.505n 1.7v 789.495n 1.7v 789.505n 0.0v 799.495n 0.0v 799.505n 0.0v 809.495n 0.0v 809.505n 0.0v 819.495n 0.0v 819.505n 1.7v 829.495n 1.7v 829.505n 1.7v 839.495n 1.7v 839.505n 1.7v 849.495n 1.7v 849.505n 1.7v 859.495n 1.7v 859.505n 0.0v 869.495n 0.0v 869.505n 0.0v 879.495n 0.0v 879.505n 0.0v 889.495n 0.0v 889.505n 0.0v 899.495n 0.0v 899.505n 1.7v 909.495n 1.7v 909.505n 1.7v 919.495n 1.7v 919.505n 0.0v 929.495n 0.0v 929.505n 1.7v 939.495n 1.7v 939.505n 1.7v 949.495n 1.7v 949.505n 0.0v 959.495n 0.0v 959.505n 0.0v 969.495n 0.0v 969.505n 0.0v 979.495n 0.0v 979.505n 0.0v 989.495n 0.0v 989.505n 1.7v 999.495n 1.7v 999.505n 0.0v 1009.495n 0.0v 1009.505n 0.0v 1019.495n 0.0v 1019.505n 0.0v 1029.495n 0.0v 1029.505n 0.0v 1039.495n 0.0v 1039.505n 0.0v 1049.495n 0.0v 1049.505n 0.0v 1059.495n 0.0v 1059.505n 0.0v 1069.495n 0.0v 1069.505n 0.0v 1079.495n 0.0v 1079.505n 0.0v 1089.495n 0.0v 1089.505n 0.0v 1099.495n 0.0v 1099.505n 0.0v 1109.495n 0.0v 1109.505n 0.0v 1119.495n 0.0v 1119.505n 0.0v 1129.495n 0.0v 1129.505n 0.0v 1139.495n 0.0v 1139.505n 0.0v 1149.495n 0.0v 1149.505n 0.0v 1159.495n 0.0v 1159.505n 1.7v 1169.495n 1.7v 1169.505n 1.7v 1179.495n 1.7v 1179.505n 0.0v 1189.495n 0.0v 1189.505n 0.0v 1199.495n 0.0v 1199.505n 0.0v 1209.495n 0.0v 1209.505n 0.0v 1219.495n 0.0v 1219.505n 0.0v 1229.495n 0.0v 1229.505n 0.0v 1239.495n 0.0v 1239.505n 0.0v 1249.495n 0.0v 1249.505n 1.7v 1259.495n 1.7v 1259.505n 0.0v 1269.495n 0.0v 1269.505n 0.0v 1279.495n 0.0v 1279.505n 0.0v 1289.495n 0.0v 1289.505n 0.0v 1299.495n 0.0v 1299.505n 1.7v 1309.495n 1.7v 1309.505n 1.7v 1319.495n 1.7v 1319.505n 1.7v 1329.495n 1.7v 1329.505n 0.0v 1339.495n 0.0v 1339.505n 1.7v 1349.495n 1.7v 1349.505n 1.7v 1359.495n 1.7v 1359.505n 1.7v 1369.495n 1.7v 1369.505n 1.7v 1379.495n 1.7v 1379.505n 1.7v 1389.495n 1.7v 1389.505n 1.7v 1399.495n 1.7v 1399.505n 1.7v 1409.495n 1.7v 1409.505n 1.7v 1419.495n 1.7v 1419.505n 1.7v 1429.495n 1.7v 1429.505n 1.7v 1439.495n 1.7v 1439.505n 0.0v 1449.495n 0.0v 1449.505n 0.0v 1459.495n 0.0v 1459.505n 0.0v 1469.495n 0.0v 1469.505n 0.0v 1479.495n 0.0v 1479.505n 1.7v 1489.495n 1.7v 1489.505n 1.7v 1499.495n 1.7v 1499.505n 1.7v 1509.495n 1.7v 1509.505n 0.0v 1519.495n 0.0v 1519.505n 0.0v 1529.495n 0.0v 1529.505n 0.0v 1539.495n 0.0v 1539.505n 1.7v 1549.495n 1.7v 1549.505n 1.7v 1559.495n 1.7v 1559.505n 1.7v 1569.495n 1.7v 1569.505n 0.0v 1579.495n 0.0v 1579.505n 1.7v 1589.495n 1.7v 1589.505n 1.7v 1599.495n 1.7v 1599.505n 1.7v 1609.495n 1.7v 1609.505n 1.7v 1619.495n 1.7v 1619.505n 1.7v 1629.495n 1.7v 1629.505n 0.0v 1639.495n 0.0v 1639.505n 0.0v 1649.495n 0.0v 1649.505n 0.0v 1659.495n 0.0v 1659.505n 0.0v 1669.495n 0.0v 1669.505n 0.0v 1679.495n 0.0v 1679.505n 0.0v 1689.495n 0.0v 1689.505n 1.7v 1699.495n 1.7v 1699.505n 1.7v 1709.495n 1.7v 1709.505n 0.0v 1719.495n 0.0v 1719.505n 0.0v 1729.495n 0.0v 1729.505n 0.0v 1739.495n 0.0v 1739.505n 0.0v 1749.495n 0.0v 1749.505n 1.7v 1759.495n 1.7v 1759.505n 0.0v 1769.495n 0.0v 1769.505n 0.0v 1779.495n 0.0v 1779.505n 0.0v 1789.495n 0.0v 1789.505n 1.7v 1799.495n 1.7v 1799.505n 0.0v 1809.495n 0.0v 1809.505n 0.0v 1819.495n 0.0v 1819.505n 0.0v 1829.495n 0.0v 1829.505n 1.7v 1839.495n 1.7v 1839.505n 1.7v 1849.495n 1.7v 1849.505n 1.7v 1859.495n 1.7v 1859.505n 1.7v 1869.495n 1.7v 1869.505n 1.7v 1879.495n 1.7v 1879.505n 1.7v 1889.495n 1.7v 1889.505n 1.7v 1899.495n 1.7v 1899.505n 0.0v 1909.495n 0.0v 1909.505n 1.7v 1919.495n 1.7v 1919.505n 1.7v 1929.495n 1.7v 1929.505n 1.7v 1939.495n 1.7v 1939.505n 1.7v 1949.495n 1.7v 1949.505n 1.7v 1959.495n 1.7v 1959.505n 1.7v 1969.495n 1.7v 1969.505n 1.7v 1979.495n 1.7v 1979.505n 1.7v 1989.495n 1.7v 1989.505n 0.0v 1999.495n 0.0v 1999.505n 0.0v 2009.495n 0.0v 2009.505n 0.0v 2019.495n 0.0v 2019.505n 0.0v 2029.495n 0.0v 2029.505n 0.0v 2039.495n 0.0v 2039.505n 0.0v 2049.495n 0.0v 2049.505n 0.0v )
* (time, data): [(0, 0), (10, 1), (20, 0), (30, 0), (40, 0), (50, 0), (60, 0), (70, 1), (80, 0), (90, 0), (100, 0), (110, 0), (120, 1), (130, 1), (140, 1), (150, 0), (160, 0), (170, 0), (180, 0), (190, 0), (200, 1), (210, 1), (220, 0), (230, 0), (240, 0), (250, 0), (260, 0), (270, 0), (280, 0), (290, 1), (300, 1), (310, 1), (320, 1), (330, 1), (340, 1), (350, 1), (360, 1), (370, 0), (380, 0), (390, 1), (400, 0), (410, 0), (420, 0), (430, 0), (440, 0), (450, 0), (460, 1), (470, 1), (480, 1), (490, 1), (500, 0), (510, 0), (520, 0), (530, 0), (540, 0), (550, 0), (560, 0), (570, 0), (580, 0), (590, 0), (600, 0), (610, 0), (620, 0), (630, 0), (640, 0), (650, 0), (660, 0), (670, 1), (680, 1), (690, 0), (700, 1), (710, 1), (720, 0), (730, 0), (740, 0), (750, 1), (760, 1), (770, 0), (780, 0), (790, 0), (800, 0), (810, 0), (820, 0), (830, 0), (840, 0), (850, 0), (860, 0), (870, 0), (880, 0), (890, 0), (900, 1), (910, 0), (920, 0), (930, 0), (940, 1), (950, 1), (960, 1), (970, 1), (980, 0), (990, 0), (1000, 0), (1010, 0), (1020, 0), (1030, 0), (1040, 1), (1050, 1), (1060, 0), (1070, 0), (1080, 0), (1090, 0), (1100, 0), (1110, 0), (1120, 0), (1130, 0), (1140, 0), (1150, 0), (1160, 0), (1170, 0), (1180, 1), (1190, 1), (1200, 1), (1210, 1), (1220, 1), (1230, 1), (1240, 1), (1250, 0), (1260, 0), (1270, 0), (1280, 1), (1290, 1), (1300, 1), (1310, 1), (1320, 1), (1330, 1), (1340, 1), (1350, 1), (1360, 1), (1370, 1), (1380, 1), (1390, 1), (1400, 0), (1410, 0), (1420, 0), (1430, 1), (1440, 0), (1450, 0), (1460, 0), (1470, 0), (1480, 1), (1490, 1), (1500, 1), (1510, 0), (1520, 1), (1530, 1), (1540, 1), (1550, 1), (1560, 1), (1570, 1), (1580, 0), (1590, 0), (1600, 0), (1610, 0), (1620, 0), (1630, 0), (1640, 0), (1650, 0), (1660, 1), (1670, 1), (1680, 1), (1690, 0), (1700, 0), (1710, 1), (1720, 1), (1730, 1), (1740, 1), (1750, 0), (1760, 1), (1770, 0), (1780, 0), (1790, 0), (1800, 0), (1810, 0), (1820, 1), (1830, 1), (1840, 1), (1850, 1), (1860, 1), (1870, 1), (1880, 1), (1890, 1), (1900, 0), (1910, 0), (1920, 1), (1930, 1), (1940, 1), (1950, 1), (1960, 0), (1970, 1), (1980, 1), (1990, 0), (2000, 0), (2010, 0), (2020, 0), (2030, 0), (2040, 1), (2050, 1)]
Vdin0_6  din0_6  0 PWL (0n 0.0v 9.495n 0.0v 9.505n 1.7v 19.495n 1.7v 19.505n 0.0v 29.495n 0.0v 29.505n 0.0v 39.495n 0.0v 39.505n 0.0v 49.495n 0.0v 49.505n 0.0v 59.495n 0.0v 59.505n 0.0v 69.495n 0.0v 69.505n 1.7v 79.495n 1.7v 79.505n 0.0v 89.495n 0.0v 89.505n 0.0v 99.495n 0.0v 99.505n 0.0v 109.495n 0.0v 109.505n 0.0v 119.495n 0.0v 119.505n 1.7v 129.495n 1.7v 129.505n 1.7v 139.495n 1.7v 139.505n 1.7v 149.495n 1.7v 149.505n 0.0v 159.495n 0.0v 159.505n 0.0v 169.495n 0.0v 169.505n 0.0v 179.495n 0.0v 179.505n 0.0v 189.495n 0.0v 189.505n 0.0v 199.495n 0.0v 199.505n 1.7v 209.495n 1.7v 209.505n 1.7v 219.495n 1.7v 219.505n 0.0v 229.495n 0.0v 229.505n 0.0v 239.495n 0.0v 239.505n 0.0v 249.495n 0.0v 249.505n 0.0v 259.495n 0.0v 259.505n 0.0v 269.495n 0.0v 269.505n 0.0v 279.495n 0.0v 279.505n 0.0v 289.495n 0.0v 289.505n 1.7v 299.495n 1.7v 299.505n 1.7v 309.495n 1.7v 309.505n 1.7v 319.495n 1.7v 319.505n 1.7v 329.495n 1.7v 329.505n 1.7v 339.495n 1.7v 339.505n 1.7v 349.495n 1.7v 349.505n 1.7v 359.495n 1.7v 359.505n 1.7v 369.495n 1.7v 369.505n 0.0v 379.495n 0.0v 379.505n 0.0v 389.495n 0.0v 389.505n 1.7v 399.495n 1.7v 399.505n 0.0v 409.495n 0.0v 409.505n 0.0v 419.495n 0.0v 419.505n 0.0v 429.495n 0.0v 429.505n 0.0v 439.495n 0.0v 439.505n 0.0v 449.495n 0.0v 449.505n 0.0v 459.495n 0.0v 459.505n 1.7v 469.495n 1.7v 469.505n 1.7v 479.495n 1.7v 479.505n 1.7v 489.495n 1.7v 489.505n 1.7v 499.495n 1.7v 499.505n 0.0v 509.495n 0.0v 509.505n 0.0v 519.495n 0.0v 519.505n 0.0v 529.495n 0.0v 529.505n 0.0v 539.495n 0.0v 539.505n 0.0v 549.495n 0.0v 549.505n 0.0v 559.495n 0.0v 559.505n 0.0v 569.495n 0.0v 569.505n 0.0v 579.495n 0.0v 579.505n 0.0v 589.495n 0.0v 589.505n 0.0v 599.495n 0.0v 599.505n 0.0v 609.495n 0.0v 609.505n 0.0v 619.495n 0.0v 619.505n 0.0v 629.495n 0.0v 629.505n 0.0v 639.495n 0.0v 639.505n 0.0v 649.495n 0.0v 649.505n 0.0v 659.495n 0.0v 659.505n 0.0v 669.495n 0.0v 669.505n 1.7v 679.495n 1.7v 679.505n 1.7v 689.495n 1.7v 689.505n 0.0v 699.495n 0.0v 699.505n 1.7v 709.495n 1.7v 709.505n 1.7v 719.495n 1.7v 719.505n 0.0v 729.495n 0.0v 729.505n 0.0v 739.495n 0.0v 739.505n 0.0v 749.495n 0.0v 749.505n 1.7v 759.495n 1.7v 759.505n 1.7v 769.495n 1.7v 769.505n 0.0v 779.495n 0.0v 779.505n 0.0v 789.495n 0.0v 789.505n 0.0v 799.495n 0.0v 799.505n 0.0v 809.495n 0.0v 809.505n 0.0v 819.495n 0.0v 819.505n 0.0v 829.495n 0.0v 829.505n 0.0v 839.495n 0.0v 839.505n 0.0v 849.495n 0.0v 849.505n 0.0v 859.495n 0.0v 859.505n 0.0v 869.495n 0.0v 869.505n 0.0v 879.495n 0.0v 879.505n 0.0v 889.495n 0.0v 889.505n 0.0v 899.495n 0.0v 899.505n 1.7v 909.495n 1.7v 909.505n 0.0v 919.495n 0.0v 919.505n 0.0v 929.495n 0.0v 929.505n 0.0v 939.495n 0.0v 939.505n 1.7v 949.495n 1.7v 949.505n 1.7v 959.495n 1.7v 959.505n 1.7v 969.495n 1.7v 969.505n 1.7v 979.495n 1.7v 979.505n 0.0v 989.495n 0.0v 989.505n 0.0v 999.495n 0.0v 999.505n 0.0v 1009.495n 0.0v 1009.505n 0.0v 1019.495n 0.0v 1019.505n 0.0v 1029.495n 0.0v 1029.505n 0.0v 1039.495n 0.0v 1039.505n 1.7v 1049.495n 1.7v 1049.505n 1.7v 1059.495n 1.7v 1059.505n 0.0v 1069.495n 0.0v 1069.505n 0.0v 1079.495n 0.0v 1079.505n 0.0v 1089.495n 0.0v 1089.505n 0.0v 1099.495n 0.0v 1099.505n 0.0v 1109.495n 0.0v 1109.505n 0.0v 1119.495n 0.0v 1119.505n 0.0v 1129.495n 0.0v 1129.505n 0.0v 1139.495n 0.0v 1139.505n 0.0v 1149.495n 0.0v 1149.505n 0.0v 1159.495n 0.0v 1159.505n 0.0v 1169.495n 0.0v 1169.505n 0.0v 1179.495n 0.0v 1179.505n 1.7v 1189.495n 1.7v 1189.505n 1.7v 1199.495n 1.7v 1199.505n 1.7v 1209.495n 1.7v 1209.505n 1.7v 1219.495n 1.7v 1219.505n 1.7v 1229.495n 1.7v 1229.505n 1.7v 1239.495n 1.7v 1239.505n 1.7v 1249.495n 1.7v 1249.505n 0.0v 1259.495n 0.0v 1259.505n 0.0v 1269.495n 0.0v 1269.505n 0.0v 1279.495n 0.0v 1279.505n 1.7v 1289.495n 1.7v 1289.505n 1.7v 1299.495n 1.7v 1299.505n 1.7v 1309.495n 1.7v 1309.505n 1.7v 1319.495n 1.7v 1319.505n 1.7v 1329.495n 1.7v 1329.505n 1.7v 1339.495n 1.7v 1339.505n 1.7v 1349.495n 1.7v 1349.505n 1.7v 1359.495n 1.7v 1359.505n 1.7v 1369.495n 1.7v 1369.505n 1.7v 1379.495n 1.7v 1379.505n 1.7v 1389.495n 1.7v 1389.505n 1.7v 1399.495n 1.7v 1399.505n 0.0v 1409.495n 0.0v 1409.505n 0.0v 1419.495n 0.0v 1419.505n 0.0v 1429.495n 0.0v 1429.505n 1.7v 1439.495n 1.7v 1439.505n 0.0v 1449.495n 0.0v 1449.505n 0.0v 1459.495n 0.0v 1459.505n 0.0v 1469.495n 0.0v 1469.505n 0.0v 1479.495n 0.0v 1479.505n 1.7v 1489.495n 1.7v 1489.505n 1.7v 1499.495n 1.7v 1499.505n 1.7v 1509.495n 1.7v 1509.505n 0.0v 1519.495n 0.0v 1519.505n 1.7v 1529.495n 1.7v 1529.505n 1.7v 1539.495n 1.7v 1539.505n 1.7v 1549.495n 1.7v 1549.505n 1.7v 1559.495n 1.7v 1559.505n 1.7v 1569.495n 1.7v 1569.505n 1.7v 1579.495n 1.7v 1579.505n 0.0v 1589.495n 0.0v 1589.505n 0.0v 1599.495n 0.0v 1599.505n 0.0v 1609.495n 0.0v 1609.505n 0.0v 1619.495n 0.0v 1619.505n 0.0v 1629.495n 0.0v 1629.505n 0.0v 1639.495n 0.0v 1639.505n 0.0v 1649.495n 0.0v 1649.505n 0.0v 1659.495n 0.0v 1659.505n 1.7v 1669.495n 1.7v 1669.505n 1.7v 1679.495n 1.7v 1679.505n 1.7v 1689.495n 1.7v 1689.505n 0.0v 1699.495n 0.0v 1699.505n 0.0v 1709.495n 0.0v 1709.505n 1.7v 1719.495n 1.7v 1719.505n 1.7v 1729.495n 1.7v 1729.505n 1.7v 1739.495n 1.7v 1739.505n 1.7v 1749.495n 1.7v 1749.505n 0.0v 1759.495n 0.0v 1759.505n 1.7v 1769.495n 1.7v 1769.505n 0.0v 1779.495n 0.0v 1779.505n 0.0v 1789.495n 0.0v 1789.505n 0.0v 1799.495n 0.0v 1799.505n 0.0v 1809.495n 0.0v 1809.505n 0.0v 1819.495n 0.0v 1819.505n 1.7v 1829.495n 1.7v 1829.505n 1.7v 1839.495n 1.7v 1839.505n 1.7v 1849.495n 1.7v 1849.505n 1.7v 1859.495n 1.7v 1859.505n 1.7v 1869.495n 1.7v 1869.505n 1.7v 1879.495n 1.7v 1879.505n 1.7v 1889.495n 1.7v 1889.505n 1.7v 1899.495n 1.7v 1899.505n 0.0v 1909.495n 0.0v 1909.505n 0.0v 1919.495n 0.0v 1919.505n 1.7v 1929.495n 1.7v 1929.505n 1.7v 1939.495n 1.7v 1939.505n 1.7v 1949.495n 1.7v 1949.505n 1.7v 1959.495n 1.7v 1959.505n 0.0v 1969.495n 0.0v 1969.505n 1.7v 1979.495n 1.7v 1979.505n 1.7v 1989.495n 1.7v 1989.505n 0.0v 1999.495n 0.0v 1999.505n 0.0v 2009.495n 0.0v 2009.505n 0.0v 2019.495n 0.0v 2019.505n 0.0v 2029.495n 0.0v 2029.505n 0.0v 2039.495n 0.0v 2039.505n 1.7v 2049.495n 1.7v 2049.505n 1.7v )
* (time, data): [(0, 0), (10, 1), (20, 1), (30, 1), (40, 1), (50, 1), (60, 1), (70, 1), (80, 0), (90, 1), (100, 0), (110, 0), (120, 0), (130, 1), (140, 1), (150, 0), (160, 1), (170, 1), (180, 1), (190, 1), (200, 1), (210, 1), (220, 0), (230, 0), (240, 0), (250, 0), (260, 0), (270, 0), (280, 0), (290, 1), (300, 1), (310, 1), (320, 1), (330, 1), (340, 1), (350, 1), (360, 1), (370, 1), (380, 1), (390, 1), (400, 0), (410, 0), (420, 0), (430, 0), (440, 0), (450, 0), (460, 0), (470, 0), (480, 1), (490, 1), (500, 1), (510, 1), (520, 1), (530, 1), (540, 1), (550, 1), (560, 1), (570, 0), (580, 0), (590, 0), (600, 0), (610, 0), (620, 1), (630, 1), (640, 1), (650, 1), (660, 1), (670, 1), (680, 0), (690, 1), (700, 1), (710, 1), (720, 0), (730, 0), (740, 0), (750, 0), (760, 0), (770, 0), (780, 0), (790, 1), (800, 1), (810, 1), (820, 0), (830, 0), (840, 0), (850, 0), (860, 1), (870, 1), (880, 1), (890, 1), (900, 0), (910, 1), (920, 1), (930, 0), (940, 1), (950, 1), (960, 1), (970, 1), (980, 1), (990, 1), (1000, 1), (1010, 1), (1020, 1), (1030, 1), (1040, 0), (1050, 0), (1060, 1), (1070, 1), (1080, 1), (1090, 1), (1100, 1), (1110, 1), (1120, 1), (1130, 1), (1140, 1), (1150, 1), (1160, 0), (1170, 0), (1180, 0), (1190, 0), (1200, 0), (1210, 0), (1220, 0), (1230, 0), (1240, 0), (1250, 0), (1260, 1), (1270, 1), (1280, 1), (1290, 1), (1300, 0), (1310, 0), (1320, 0), (1330, 0), (1340, 1), (1350, 1), (1360, 1), (1370, 1), (1380, 1), (1390, 1), (1400, 1), (1410, 1), (1420, 1), (1430, 0), (1440, 1), (1450, 1), (1460, 1), (1470, 1), (1480, 0), (1490, 0), (1500, 0), (1510, 0), (1520, 0), (1530, 0), (1540, 1), (1550, 1), (1560, 1), (1570, 0), (1580, 0), (1590, 0), (1600, 0), (1610, 0), (1620, 0), (1630, 1), (1640, 1), (1650, 1), (1660, 0), (1670, 0), (1680, 0), (1690, 0), (1700, 0), (1710, 0), (1720, 0), (1730, 0), (1740, 1), (1750, 0), (1760, 0), (1770, 1), (1780, 0), (1790, 0), (1800, 0), (1810, 0), (1820, 1), (1830, 0), (1840, 0), (1850, 0), (1860, 0), (1870, 1), (1880, 1), (1890, 1), (1900, 1), (1910, 1), (1920, 1), (1930, 0), (1940, 0), (1950, 0), (1960, 0), (1970, 1), (1980, 1), (1990, 0), (2000, 0), (2010, 0), (2020, 1), (2030, 1), (2040, 0), (2050, 0)]
Vdin0_7  din0_7  0 PWL (0n 0.0v 9.495n 0.0v 9.505n 1.7v 19.495n 1.7v 19.505n 1.7v 29.495n 1.7v 29.505n 1.7v 39.495n 1.7v 39.505n 1.7v 49.495n 1.7v 49.505n 1.7v 59.495n 1.7v 59.505n 1.7v 69.495n 1.7v 69.505n 1.7v 79.495n 1.7v 79.505n 0.0v 89.495n 0.0v 89.505n 1.7v 99.495n 1.7v 99.505n 0.0v 109.495n 0.0v 109.505n 0.0v 119.495n 0.0v 119.505n 0.0v 129.495n 0.0v 129.505n 1.7v 139.495n 1.7v 139.505n 1.7v 149.495n 1.7v 149.505n 0.0v 159.495n 0.0v 159.505n 1.7v 169.495n 1.7v 169.505n 1.7v 179.495n 1.7v 179.505n 1.7v 189.495n 1.7v 189.505n 1.7v 199.495n 1.7v 199.505n 1.7v 209.495n 1.7v 209.505n 1.7v 219.495n 1.7v 219.505n 0.0v 229.495n 0.0v 229.505n 0.0v 239.495n 0.0v 239.505n 0.0v 249.495n 0.0v 249.505n 0.0v 259.495n 0.0v 259.505n 0.0v 269.495n 0.0v 269.505n 0.0v 279.495n 0.0v 279.505n 0.0v 289.495n 0.0v 289.505n 1.7v 299.495n 1.7v 299.505n 1.7v 309.495n 1.7v 309.505n 1.7v 319.495n 1.7v 319.505n 1.7v 329.495n 1.7v 329.505n 1.7v 339.495n 1.7v 339.505n 1.7v 349.495n 1.7v 349.505n 1.7v 359.495n 1.7v 359.505n 1.7v 369.495n 1.7v 369.505n 1.7v 379.495n 1.7v 379.505n 1.7v 389.495n 1.7v 389.505n 1.7v 399.495n 1.7v 399.505n 0.0v 409.495n 0.0v 409.505n 0.0v 419.495n 0.0v 419.505n 0.0v 429.495n 0.0v 429.505n 0.0v 439.495n 0.0v 439.505n 0.0v 449.495n 0.0v 449.505n 0.0v 459.495n 0.0v 459.505n 0.0v 469.495n 0.0v 469.505n 0.0v 479.495n 0.0v 479.505n 1.7v 489.495n 1.7v 489.505n 1.7v 499.495n 1.7v 499.505n 1.7v 509.495n 1.7v 509.505n 1.7v 519.495n 1.7v 519.505n 1.7v 529.495n 1.7v 529.505n 1.7v 539.495n 1.7v 539.505n 1.7v 549.495n 1.7v 549.505n 1.7v 559.495n 1.7v 559.505n 1.7v 569.495n 1.7v 569.505n 0.0v 579.495n 0.0v 579.505n 0.0v 589.495n 0.0v 589.505n 0.0v 599.495n 0.0v 599.505n 0.0v 609.495n 0.0v 609.505n 0.0v 619.495n 0.0v 619.505n 1.7v 629.495n 1.7v 629.505n 1.7v 639.495n 1.7v 639.505n 1.7v 649.495n 1.7v 649.505n 1.7v 659.495n 1.7v 659.505n 1.7v 669.495n 1.7v 669.505n 1.7v 679.495n 1.7v 679.505n 0.0v 689.495n 0.0v 689.505n 1.7v 699.495n 1.7v 699.505n 1.7v 709.495n 1.7v 709.505n 1.7v 719.495n 1.7v 719.505n 0.0v 729.495n 0.0v 729.505n 0.0v 739.495n 0.0v 739.505n 0.0v 749.495n 0.0v 749.505n 0.0v 759.495n 0.0v 759.505n 0.0v 769.495n 0.0v 769.505n 0.0v 779.495n 0.0v 779.505n 0.0v 789.495n 0.0v 789.505n 1.7v 799.495n 1.7v 799.505n 1.7v 809.495n 1.7v 809.505n 1.7v 819.495n 1.7v 819.505n 0.0v 829.495n 0.0v 829.505n 0.0v 839.495n 0.0v 839.505n 0.0v 849.495n 0.0v 849.505n 0.0v 859.495n 0.0v 859.505n 1.7v 869.495n 1.7v 869.505n 1.7v 879.495n 1.7v 879.505n 1.7v 889.495n 1.7v 889.505n 1.7v 899.495n 1.7v 899.505n 0.0v 909.495n 0.0v 909.505n 1.7v 919.495n 1.7v 919.505n 1.7v 929.495n 1.7v 929.505n 0.0v 939.495n 0.0v 939.505n 1.7v 949.495n 1.7v 949.505n 1.7v 959.495n 1.7v 959.505n 1.7v 969.495n 1.7v 969.505n 1.7v 979.495n 1.7v 979.505n 1.7v 989.495n 1.7v 989.505n 1.7v 999.495n 1.7v 999.505n 1.7v 1009.495n 1.7v 1009.505n 1.7v 1019.495n 1.7v 1019.505n 1.7v 1029.495n 1.7v 1029.505n 1.7v 1039.495n 1.7v 1039.505n 0.0v 1049.495n 0.0v 1049.505n 0.0v 1059.495n 0.0v 1059.505n 1.7v 1069.495n 1.7v 1069.505n 1.7v 1079.495n 1.7v 1079.505n 1.7v 1089.495n 1.7v 1089.505n 1.7v 1099.495n 1.7v 1099.505n 1.7v 1109.495n 1.7v 1109.505n 1.7v 1119.495n 1.7v 1119.505n 1.7v 1129.495n 1.7v 1129.505n 1.7v 1139.495n 1.7v 1139.505n 1.7v 1149.495n 1.7v 1149.505n 1.7v 1159.495n 1.7v 1159.505n 0.0v 1169.495n 0.0v 1169.505n 0.0v 1179.495n 0.0v 1179.505n 0.0v 1189.495n 0.0v 1189.505n 0.0v 1199.495n 0.0v 1199.505n 0.0v 1209.495n 0.0v 1209.505n 0.0v 1219.495n 0.0v 1219.505n 0.0v 1229.495n 0.0v 1229.505n 0.0v 1239.495n 0.0v 1239.505n 0.0v 1249.495n 0.0v 1249.505n 0.0v 1259.495n 0.0v 1259.505n 1.7v 1269.495n 1.7v 1269.505n 1.7v 1279.495n 1.7v 1279.505n 1.7v 1289.495n 1.7v 1289.505n 1.7v 1299.495n 1.7v 1299.505n 0.0v 1309.495n 0.0v 1309.505n 0.0v 1319.495n 0.0v 1319.505n 0.0v 1329.495n 0.0v 1329.505n 0.0v 1339.495n 0.0v 1339.505n 1.7v 1349.495n 1.7v 1349.505n 1.7v 1359.495n 1.7v 1359.505n 1.7v 1369.495n 1.7v 1369.505n 1.7v 1379.495n 1.7v 1379.505n 1.7v 1389.495n 1.7v 1389.505n 1.7v 1399.495n 1.7v 1399.505n 1.7v 1409.495n 1.7v 1409.505n 1.7v 1419.495n 1.7v 1419.505n 1.7v 1429.495n 1.7v 1429.505n 0.0v 1439.495n 0.0v 1439.505n 1.7v 1449.495n 1.7v 1449.505n 1.7v 1459.495n 1.7v 1459.505n 1.7v 1469.495n 1.7v 1469.505n 1.7v 1479.495n 1.7v 1479.505n 0.0v 1489.495n 0.0v 1489.505n 0.0v 1499.495n 0.0v 1499.505n 0.0v 1509.495n 0.0v 1509.505n 0.0v 1519.495n 0.0v 1519.505n 0.0v 1529.495n 0.0v 1529.505n 0.0v 1539.495n 0.0v 1539.505n 1.7v 1549.495n 1.7v 1549.505n 1.7v 1559.495n 1.7v 1559.505n 1.7v 1569.495n 1.7v 1569.505n 0.0v 1579.495n 0.0v 1579.505n 0.0v 1589.495n 0.0v 1589.505n 0.0v 1599.495n 0.0v 1599.505n 0.0v 1609.495n 0.0v 1609.505n 0.0v 1619.495n 0.0v 1619.505n 0.0v 1629.495n 0.0v 1629.505n 1.7v 1639.495n 1.7v 1639.505n 1.7v 1649.495n 1.7v 1649.505n 1.7v 1659.495n 1.7v 1659.505n 0.0v 1669.495n 0.0v 1669.505n 0.0v 1679.495n 0.0v 1679.505n 0.0v 1689.495n 0.0v 1689.505n 0.0v 1699.495n 0.0v 1699.505n 0.0v 1709.495n 0.0v 1709.505n 0.0v 1719.495n 0.0v 1719.505n 0.0v 1729.495n 0.0v 1729.505n 0.0v 1739.495n 0.0v 1739.505n 1.7v 1749.495n 1.7v 1749.505n 0.0v 1759.495n 0.0v 1759.505n 0.0v 1769.495n 0.0v 1769.505n 1.7v 1779.495n 1.7v 1779.505n 0.0v 1789.495n 0.0v 1789.505n 0.0v 1799.495n 0.0v 1799.505n 0.0v 1809.495n 0.0v 1809.505n 0.0v 1819.495n 0.0v 1819.505n 1.7v 1829.495n 1.7v 1829.505n 0.0v 1839.495n 0.0v 1839.505n 0.0v 1849.495n 0.0v 1849.505n 0.0v 1859.495n 0.0v 1859.505n 0.0v 1869.495n 0.0v 1869.505n 1.7v 1879.495n 1.7v 1879.505n 1.7v 1889.495n 1.7v 1889.505n 1.7v 1899.495n 1.7v 1899.505n 1.7v 1909.495n 1.7v 1909.505n 1.7v 1919.495n 1.7v 1919.505n 1.7v 1929.495n 1.7v 1929.505n 0.0v 1939.495n 0.0v 1939.505n 0.0v 1949.495n 0.0v 1949.505n 0.0v 1959.495n 0.0v 1959.505n 0.0v 1969.495n 0.0v 1969.505n 1.7v 1979.495n 1.7v 1979.505n 1.7v 1989.495n 1.7v 1989.505n 0.0v 1999.495n 0.0v 1999.505n 0.0v 2009.495n 0.0v 2009.505n 0.0v 2019.495n 0.0v 2019.505n 1.7v 2029.495n 1.7v 2029.505n 1.7v 2039.495n 1.7v 2039.505n 0.0v 2049.495n 0.0v 2049.505n 0.0v )
* (time, data): [(0, 0), (10, 1), (20, 1), (30, 1), (40, 1), (50, 1), (60, 1), (70, 0), (80, 1), (90, 1), (100, 0), (110, 0), (120, 1), (130, 1), (140, 1), (150, 0), (160, 1), (170, 1), (180, 0), (190, 0), (200, 0), (210, 0), (220, 1), (230, 0), (240, 0), (250, 0), (260, 0), (270, 0), (280, 0), (290, 1), (300, 1), (310, 1), (320, 1), (330, 1), (340, 1), (350, 1), (360, 1), (370, 0), (380, 1), (390, 0), (400, 1), (410, 1), (420, 1), (430, 1), (440, 1), (450, 1), (460, 1), (470, 1), (480, 1), (490, 1), (500, 1), (510, 1), (520, 1), (530, 1), (540, 1), (550, 1), (560, 1), (570, 1), (580, 1), (590, 1), (600, 1), (610, 1), (620, 1), (630, 0), (640, 0), (650, 0), (660, 0), (670, 1), (680, 1), (690, 1), (700, 0), (710, 0), (720, 1), (730, 1), (740, 1), (750, 1), (760, 1), (770, 1), (780, 1), (790, 1), (800, 0), (810, 0), (820, 1), (830, 1), (840, 1), (850, 1), (860, 1), (870, 1), (880, 1), (890, 1), (900, 1), (910, 0), (920, 1), (930, 1), (940, 0), (950, 1), (960, 1), (970, 1), (980, 1), (990, 1), (1000, 0), (1010, 0), (1020, 0), (1030, 0), (1040, 1), (1050, 0), (1060, 1), (1070, 1), (1080, 1), (1090, 1), (1100, 1), (1110, 1), (1120, 1), (1130, 1), (1140, 1), (1150, 1), (1160, 1), (1170, 1), (1180, 0), (1190, 0), (1200, 0), (1210, 0), (1220, 0), (1230, 1), (1240, 0), (1250, 1), (1260, 1), (1270, 1), (1280, 0), (1290, 0), (1300, 0), (1310, 0), (1320, 0), (1330, 0), (1340, 0), (1350, 0), (1360, 0), (1370, 0), (1380, 0), (1390, 0), (1400, 0), (1410, 0), (1420, 0), (1430, 1), (1440, 0), (1450, 0), (1460, 0), (1470, 0), (1480, 0), (1490, 0), (1500, 0), (1510, 1), (1520, 0), (1530, 0), (1540, 0), (1550, 0), (1560, 0), (1570, 0), (1580, 1), (1590, 1), (1600, 1), (1610, 1), (1620, 1), (1630, 0), (1640, 0), (1650, 1), (1660, 1), (1670, 1), (1680, 1), (1690, 0), (1700, 0), (1710, 0), (1720, 0), (1730, 0), (1740, 0), (1750, 1), (1760, 1), (1770, 0), (1780, 1), (1790, 1), (1800, 1), (1810, 1), (1820, 1), (1830, 0), (1840, 0), (1850, 0), (1860, 0), (1870, 0), (1880, 0), (1890, 0), (1900, 0), (1910, 1), (1920, 1), (1930, 1), (1940, 1), (1950, 1), (1960, 1), (1970, 1), (1980, 1), (1990, 1), (2000, 1), (2010, 1), (2020, 1), (2030, 1), (2040, 1), (2050, 1)]
Vdin0_8  din0_8  0 PWL (0n 0.0v 9.495n 0.0v 9.505n 1.7v 19.495n 1.7v 19.505n 1.7v 29.495n 1.7v 29.505n 1.7v 39.495n 1.7v 39.505n 1.7v 49.495n 1.7v 49.505n 1.7v 59.495n 1.7v 59.505n 1.7v 69.495n 1.7v 69.505n 0.0v 79.495n 0.0v 79.505n 1.7v 89.495n 1.7v 89.505n 1.7v 99.495n 1.7v 99.505n 0.0v 109.495n 0.0v 109.505n 0.0v 119.495n 0.0v 119.505n 1.7v 129.495n 1.7v 129.505n 1.7v 139.495n 1.7v 139.505n 1.7v 149.495n 1.7v 149.505n 0.0v 159.495n 0.0v 159.505n 1.7v 169.495n 1.7v 169.505n 1.7v 179.495n 1.7v 179.505n 0.0v 189.495n 0.0v 189.505n 0.0v 199.495n 0.0v 199.505n 0.0v 209.495n 0.0v 209.505n 0.0v 219.495n 0.0v 219.505n 1.7v 229.495n 1.7v 229.505n 0.0v 239.495n 0.0v 239.505n 0.0v 249.495n 0.0v 249.505n 0.0v 259.495n 0.0v 259.505n 0.0v 269.495n 0.0v 269.505n 0.0v 279.495n 0.0v 279.505n 0.0v 289.495n 0.0v 289.505n 1.7v 299.495n 1.7v 299.505n 1.7v 309.495n 1.7v 309.505n 1.7v 319.495n 1.7v 319.505n 1.7v 329.495n 1.7v 329.505n 1.7v 339.495n 1.7v 339.505n 1.7v 349.495n 1.7v 349.505n 1.7v 359.495n 1.7v 359.505n 1.7v 369.495n 1.7v 369.505n 0.0v 379.495n 0.0v 379.505n 1.7v 389.495n 1.7v 389.505n 0.0v 399.495n 0.0v 399.505n 1.7v 409.495n 1.7v 409.505n 1.7v 419.495n 1.7v 419.505n 1.7v 429.495n 1.7v 429.505n 1.7v 439.495n 1.7v 439.505n 1.7v 449.495n 1.7v 449.505n 1.7v 459.495n 1.7v 459.505n 1.7v 469.495n 1.7v 469.505n 1.7v 479.495n 1.7v 479.505n 1.7v 489.495n 1.7v 489.505n 1.7v 499.495n 1.7v 499.505n 1.7v 509.495n 1.7v 509.505n 1.7v 519.495n 1.7v 519.505n 1.7v 529.495n 1.7v 529.505n 1.7v 539.495n 1.7v 539.505n 1.7v 549.495n 1.7v 549.505n 1.7v 559.495n 1.7v 559.505n 1.7v 569.495n 1.7v 569.505n 1.7v 579.495n 1.7v 579.505n 1.7v 589.495n 1.7v 589.505n 1.7v 599.495n 1.7v 599.505n 1.7v 609.495n 1.7v 609.505n 1.7v 619.495n 1.7v 619.505n 1.7v 629.495n 1.7v 629.505n 0.0v 639.495n 0.0v 639.505n 0.0v 649.495n 0.0v 649.505n 0.0v 659.495n 0.0v 659.505n 0.0v 669.495n 0.0v 669.505n 1.7v 679.495n 1.7v 679.505n 1.7v 689.495n 1.7v 689.505n 1.7v 699.495n 1.7v 699.505n 0.0v 709.495n 0.0v 709.505n 0.0v 719.495n 0.0v 719.505n 1.7v 729.495n 1.7v 729.505n 1.7v 739.495n 1.7v 739.505n 1.7v 749.495n 1.7v 749.505n 1.7v 759.495n 1.7v 759.505n 1.7v 769.495n 1.7v 769.505n 1.7v 779.495n 1.7v 779.505n 1.7v 789.495n 1.7v 789.505n 1.7v 799.495n 1.7v 799.505n 0.0v 809.495n 0.0v 809.505n 0.0v 819.495n 0.0v 819.505n 1.7v 829.495n 1.7v 829.505n 1.7v 839.495n 1.7v 839.505n 1.7v 849.495n 1.7v 849.505n 1.7v 859.495n 1.7v 859.505n 1.7v 869.495n 1.7v 869.505n 1.7v 879.495n 1.7v 879.505n 1.7v 889.495n 1.7v 889.505n 1.7v 899.495n 1.7v 899.505n 1.7v 909.495n 1.7v 909.505n 0.0v 919.495n 0.0v 919.505n 1.7v 929.495n 1.7v 929.505n 1.7v 939.495n 1.7v 939.505n 0.0v 949.495n 0.0v 949.505n 1.7v 959.495n 1.7v 959.505n 1.7v 969.495n 1.7v 969.505n 1.7v 979.495n 1.7v 979.505n 1.7v 989.495n 1.7v 989.505n 1.7v 999.495n 1.7v 999.505n 0.0v 1009.495n 0.0v 1009.505n 0.0v 1019.495n 0.0v 1019.505n 0.0v 1029.495n 0.0v 1029.505n 0.0v 1039.495n 0.0v 1039.505n 1.7v 1049.495n 1.7v 1049.505n 0.0v 1059.495n 0.0v 1059.505n 1.7v 1069.495n 1.7v 1069.505n 1.7v 1079.495n 1.7v 1079.505n 1.7v 1089.495n 1.7v 1089.505n 1.7v 1099.495n 1.7v 1099.505n 1.7v 1109.495n 1.7v 1109.505n 1.7v 1119.495n 1.7v 1119.505n 1.7v 1129.495n 1.7v 1129.505n 1.7v 1139.495n 1.7v 1139.505n 1.7v 1149.495n 1.7v 1149.505n 1.7v 1159.495n 1.7v 1159.505n 1.7v 1169.495n 1.7v 1169.505n 1.7v 1179.495n 1.7v 1179.505n 0.0v 1189.495n 0.0v 1189.505n 0.0v 1199.495n 0.0v 1199.505n 0.0v 1209.495n 0.0v 1209.505n 0.0v 1219.495n 0.0v 1219.505n 0.0v 1229.495n 0.0v 1229.505n 1.7v 1239.495n 1.7v 1239.505n 0.0v 1249.495n 0.0v 1249.505n 1.7v 1259.495n 1.7v 1259.505n 1.7v 1269.495n 1.7v 1269.505n 1.7v 1279.495n 1.7v 1279.505n 0.0v 1289.495n 0.0v 1289.505n 0.0v 1299.495n 0.0v 1299.505n 0.0v 1309.495n 0.0v 1309.505n 0.0v 1319.495n 0.0v 1319.505n 0.0v 1329.495n 0.0v 1329.505n 0.0v 1339.495n 0.0v 1339.505n 0.0v 1349.495n 0.0v 1349.505n 0.0v 1359.495n 0.0v 1359.505n 0.0v 1369.495n 0.0v 1369.505n 0.0v 1379.495n 0.0v 1379.505n 0.0v 1389.495n 0.0v 1389.505n 0.0v 1399.495n 0.0v 1399.505n 0.0v 1409.495n 0.0v 1409.505n 0.0v 1419.495n 0.0v 1419.505n 0.0v 1429.495n 0.0v 1429.505n 1.7v 1439.495n 1.7v 1439.505n 0.0v 1449.495n 0.0v 1449.505n 0.0v 1459.495n 0.0v 1459.505n 0.0v 1469.495n 0.0v 1469.505n 0.0v 1479.495n 0.0v 1479.505n 0.0v 1489.495n 0.0v 1489.505n 0.0v 1499.495n 0.0v 1499.505n 0.0v 1509.495n 0.0v 1509.505n 1.7v 1519.495n 1.7v 1519.505n 0.0v 1529.495n 0.0v 1529.505n 0.0v 1539.495n 0.0v 1539.505n 0.0v 1549.495n 0.0v 1549.505n 0.0v 1559.495n 0.0v 1559.505n 0.0v 1569.495n 0.0v 1569.505n 0.0v 1579.495n 0.0v 1579.505n 1.7v 1589.495n 1.7v 1589.505n 1.7v 1599.495n 1.7v 1599.505n 1.7v 1609.495n 1.7v 1609.505n 1.7v 1619.495n 1.7v 1619.505n 1.7v 1629.495n 1.7v 1629.505n 0.0v 1639.495n 0.0v 1639.505n 0.0v 1649.495n 0.0v 1649.505n 1.7v 1659.495n 1.7v 1659.505n 1.7v 1669.495n 1.7v 1669.505n 1.7v 1679.495n 1.7v 1679.505n 1.7v 1689.495n 1.7v 1689.505n 0.0v 1699.495n 0.0v 1699.505n 0.0v 1709.495n 0.0v 1709.505n 0.0v 1719.495n 0.0v 1719.505n 0.0v 1729.495n 0.0v 1729.505n 0.0v 1739.495n 0.0v 1739.505n 0.0v 1749.495n 0.0v 1749.505n 1.7v 1759.495n 1.7v 1759.505n 1.7v 1769.495n 1.7v 1769.505n 0.0v 1779.495n 0.0v 1779.505n 1.7v 1789.495n 1.7v 1789.505n 1.7v 1799.495n 1.7v 1799.505n 1.7v 1809.495n 1.7v 1809.505n 1.7v 1819.495n 1.7v 1819.505n 1.7v 1829.495n 1.7v 1829.505n 0.0v 1839.495n 0.0v 1839.505n 0.0v 1849.495n 0.0v 1849.505n 0.0v 1859.495n 0.0v 1859.505n 0.0v 1869.495n 0.0v 1869.505n 0.0v 1879.495n 0.0v 1879.505n 0.0v 1889.495n 0.0v 1889.505n 0.0v 1899.495n 0.0v 1899.505n 0.0v 1909.495n 0.0v 1909.505n 1.7v 1919.495n 1.7v 1919.505n 1.7v 1929.495n 1.7v 1929.505n 1.7v 1939.495n 1.7v 1939.505n 1.7v 1949.495n 1.7v 1949.505n 1.7v 1959.495n 1.7v 1959.505n 1.7v 1969.495n 1.7v 1969.505n 1.7v 1979.495n 1.7v 1979.505n 1.7v 1989.495n 1.7v 1989.505n 1.7v 1999.495n 1.7v 1999.505n 1.7v 2009.495n 1.7v 2009.505n 1.7v 2019.495n 1.7v 2019.505n 1.7v 2029.495n 1.7v 2029.505n 1.7v 2039.495n 1.7v 2039.505n 1.7v 2049.495n 1.7v 2049.505n 1.7v )
* (time, data): [(0, 0), (10, 1), (20, 1), (30, 0), (40, 0), (50, 0), (60, 0), (70, 1), (80, 0), (90, 1), (100, 1), (110, 1), (120, 0), (130, 0), (140, 0), (150, 0), (160, 1), (170, 1), (180, 0), (190, 0), (200, 0), (210, 1), (220, 1), (230, 0), (240, 0), (250, 0), (260, 0), (270, 0), (280, 0), (290, 0), (300, 0), (310, 0), (320, 1), (330, 1), (340, 1), (350, 1), (360, 1), (370, 1), (380, 1), (390, 1), (400, 1), (410, 1), (420, 1), (430, 1), (440, 1), (450, 1), (460, 0), (470, 0), (480, 0), (490, 1), (500, 1), (510, 0), (520, 0), (530, 0), (540, 0), (550, 0), (560, 0), (570, 1), (580, 1), (590, 1), (600, 1), (610, 1), (620, 0), (630, 0), (640, 0), (650, 0), (660, 0), (670, 1), (680, 1), (690, 0), (700, 1), (710, 1), (720, 1), (730, 1), (740, 1), (750, 1), (760, 0), (770, 1), (780, 1), (790, 1), (800, 0), (810, 0), (820, 0), (830, 1), (840, 1), (850, 1), (860, 0), (870, 0), (880, 0), (890, 0), (900, 0), (910, 0), (920, 1), (930, 0), (940, 0), (950, 1), (960, 1), (970, 0), (980, 0), (990, 1), (1000, 0), (1010, 0), (1020, 0), (1030, 1), (1040, 0), (1050, 1), (1060, 1), (1070, 1), (1080, 0), (1090, 0), (1100, 0), (1110, 0), (1120, 0), (1130, 0), (1140, 0), (1150, 0), (1160, 1), (1170, 1), (1180, 1), (1190, 1), (1200, 1), (1210, 1), (1220, 1), (1230, 0), (1240, 1), (1250, 0), (1260, 0), (1270, 0), (1280, 0), (1290, 0), (1300, 1), (1310, 1), (1320, 1), (1330, 1), (1340, 1), (1350, 1), (1360, 1), (1370, 1), (1380, 1), (1390, 1), (1400, 0), (1410, 0), (1420, 0), (1430, 1), (1440, 1), (1450, 1), (1460, 1), (1470, 1), (1480, 1), (1490, 1), (1500, 1), (1510, 0), (1520, 0), (1530, 0), (1540, 1), (1550, 1), (1560, 1), (1570, 0), (1580, 0), (1590, 0), (1600, 0), (1610, 0), (1620, 0), (1630, 0), (1640, 0), (1650, 1), (1660, 0), (1670, 0), (1680, 0), (1690, 1), (1700, 1), (1710, 0), (1720, 0), (1730, 0), (1740, 1), (1750, 1), (1760, 0), (1770, 1), (1780, 0), (1790, 0), (1800, 1), (1810, 1), (1820, 1), (1830, 0), (1840, 0), (1850, 0), (1860, 0), (1870, 0), (1880, 0), (1890, 0), (1900, 1), (1910, 0), (1920, 1), (1930, 1), (1940, 1), (1950, 0), (1960, 1), (1970, 1), (1980, 1), (1990, 0), (2000, 0), (2010, 0), (2020, 0), (2030, 0), (2040, 1), (2050, 1)]
Vdin0_9  din0_9  0 PWL (0n 0.0v 9.495n 0.0v 9.505n 1.7v 19.495n 1.7v 19.505n 1.7v 29.495n 1.7v 29.505n 0.0v 39.495n 0.0v 39.505n 0.0v 49.495n 0.0v 49.505n 0.0v 59.495n 0.0v 59.505n 0.0v 69.495n 0.0v 69.505n 1.7v 79.495n 1.7v 79.505n 0.0v 89.495n 0.0v 89.505n 1.7v 99.495n 1.7v 99.505n 1.7v 109.495n 1.7v 109.505n 1.7v 119.495n 1.7v 119.505n 0.0v 129.495n 0.0v 129.505n 0.0v 139.495n 0.0v 139.505n 0.0v 149.495n 0.0v 149.505n 0.0v 159.495n 0.0v 159.505n 1.7v 169.495n 1.7v 169.505n 1.7v 179.495n 1.7v 179.505n 0.0v 189.495n 0.0v 189.505n 0.0v 199.495n 0.0v 199.505n 0.0v 209.495n 0.0v 209.505n 1.7v 219.495n 1.7v 219.505n 1.7v 229.495n 1.7v 229.505n 0.0v 239.495n 0.0v 239.505n 0.0v 249.495n 0.0v 249.505n 0.0v 259.495n 0.0v 259.505n 0.0v 269.495n 0.0v 269.505n 0.0v 279.495n 0.0v 279.505n 0.0v 289.495n 0.0v 289.505n 0.0v 299.495n 0.0v 299.505n 0.0v 309.495n 0.0v 309.505n 0.0v 319.495n 0.0v 319.505n 1.7v 329.495n 1.7v 329.505n 1.7v 339.495n 1.7v 339.505n 1.7v 349.495n 1.7v 349.505n 1.7v 359.495n 1.7v 359.505n 1.7v 369.495n 1.7v 369.505n 1.7v 379.495n 1.7v 379.505n 1.7v 389.495n 1.7v 389.505n 1.7v 399.495n 1.7v 399.505n 1.7v 409.495n 1.7v 409.505n 1.7v 419.495n 1.7v 419.505n 1.7v 429.495n 1.7v 429.505n 1.7v 439.495n 1.7v 439.505n 1.7v 449.495n 1.7v 449.505n 1.7v 459.495n 1.7v 459.505n 0.0v 469.495n 0.0v 469.505n 0.0v 479.495n 0.0v 479.505n 0.0v 489.495n 0.0v 489.505n 1.7v 499.495n 1.7v 499.505n 1.7v 509.495n 1.7v 509.505n 0.0v 519.495n 0.0v 519.505n 0.0v 529.495n 0.0v 529.505n 0.0v 539.495n 0.0v 539.505n 0.0v 549.495n 0.0v 549.505n 0.0v 559.495n 0.0v 559.505n 0.0v 569.495n 0.0v 569.505n 1.7v 579.495n 1.7v 579.505n 1.7v 589.495n 1.7v 589.505n 1.7v 599.495n 1.7v 599.505n 1.7v 609.495n 1.7v 609.505n 1.7v 619.495n 1.7v 619.505n 0.0v 629.495n 0.0v 629.505n 0.0v 639.495n 0.0v 639.505n 0.0v 649.495n 0.0v 649.505n 0.0v 659.495n 0.0v 659.505n 0.0v 669.495n 0.0v 669.505n 1.7v 679.495n 1.7v 679.505n 1.7v 689.495n 1.7v 689.505n 0.0v 699.495n 0.0v 699.505n 1.7v 709.495n 1.7v 709.505n 1.7v 719.495n 1.7v 719.505n 1.7v 729.495n 1.7v 729.505n 1.7v 739.495n 1.7v 739.505n 1.7v 749.495n 1.7v 749.505n 1.7v 759.495n 1.7v 759.505n 0.0v 769.495n 0.0v 769.505n 1.7v 779.495n 1.7v 779.505n 1.7v 789.495n 1.7v 789.505n 1.7v 799.495n 1.7v 799.505n 0.0v 809.495n 0.0v 809.505n 0.0v 819.495n 0.0v 819.505n 0.0v 829.495n 0.0v 829.505n 1.7v 839.495n 1.7v 839.505n 1.7v 849.495n 1.7v 849.505n 1.7v 859.495n 1.7v 859.505n 0.0v 869.495n 0.0v 869.505n 0.0v 879.495n 0.0v 879.505n 0.0v 889.495n 0.0v 889.505n 0.0v 899.495n 0.0v 899.505n 0.0v 909.495n 0.0v 909.505n 0.0v 919.495n 0.0v 919.505n 1.7v 929.495n 1.7v 929.505n 0.0v 939.495n 0.0v 939.505n 0.0v 949.495n 0.0v 949.505n 1.7v 959.495n 1.7v 959.505n 1.7v 969.495n 1.7v 969.505n 0.0v 979.495n 0.0v 979.505n 0.0v 989.495n 0.0v 989.505n 1.7v 999.495n 1.7v 999.505n 0.0v 1009.495n 0.0v 1009.505n 0.0v 1019.495n 0.0v 1019.505n 0.0v 1029.495n 0.0v 1029.505n 1.7v 1039.495n 1.7v 1039.505n 0.0v 1049.495n 0.0v 1049.505n 1.7v 1059.495n 1.7v 1059.505n 1.7v 1069.495n 1.7v 1069.505n 1.7v 1079.495n 1.7v 1079.505n 0.0v 1089.495n 0.0v 1089.505n 0.0v 1099.495n 0.0v 1099.505n 0.0v 1109.495n 0.0v 1109.505n 0.0v 1119.495n 0.0v 1119.505n 0.0v 1129.495n 0.0v 1129.505n 0.0v 1139.495n 0.0v 1139.505n 0.0v 1149.495n 0.0v 1149.505n 0.0v 1159.495n 0.0v 1159.505n 1.7v 1169.495n 1.7v 1169.505n 1.7v 1179.495n 1.7v 1179.505n 1.7v 1189.495n 1.7v 1189.505n 1.7v 1199.495n 1.7v 1199.505n 1.7v 1209.495n 1.7v 1209.505n 1.7v 1219.495n 1.7v 1219.505n 1.7v 1229.495n 1.7v 1229.505n 0.0v 1239.495n 0.0v 1239.505n 1.7v 1249.495n 1.7v 1249.505n 0.0v 1259.495n 0.0v 1259.505n 0.0v 1269.495n 0.0v 1269.505n 0.0v 1279.495n 0.0v 1279.505n 0.0v 1289.495n 0.0v 1289.505n 0.0v 1299.495n 0.0v 1299.505n 1.7v 1309.495n 1.7v 1309.505n 1.7v 1319.495n 1.7v 1319.505n 1.7v 1329.495n 1.7v 1329.505n 1.7v 1339.495n 1.7v 1339.505n 1.7v 1349.495n 1.7v 1349.505n 1.7v 1359.495n 1.7v 1359.505n 1.7v 1369.495n 1.7v 1369.505n 1.7v 1379.495n 1.7v 1379.505n 1.7v 1389.495n 1.7v 1389.505n 1.7v 1399.495n 1.7v 1399.505n 0.0v 1409.495n 0.0v 1409.505n 0.0v 1419.495n 0.0v 1419.505n 0.0v 1429.495n 0.0v 1429.505n 1.7v 1439.495n 1.7v 1439.505n 1.7v 1449.495n 1.7v 1449.505n 1.7v 1459.495n 1.7v 1459.505n 1.7v 1469.495n 1.7v 1469.505n 1.7v 1479.495n 1.7v 1479.505n 1.7v 1489.495n 1.7v 1489.505n 1.7v 1499.495n 1.7v 1499.505n 1.7v 1509.495n 1.7v 1509.505n 0.0v 1519.495n 0.0v 1519.505n 0.0v 1529.495n 0.0v 1529.505n 0.0v 1539.495n 0.0v 1539.505n 1.7v 1549.495n 1.7v 1549.505n 1.7v 1559.495n 1.7v 1559.505n 1.7v 1569.495n 1.7v 1569.505n 0.0v 1579.495n 0.0v 1579.505n 0.0v 1589.495n 0.0v 1589.505n 0.0v 1599.495n 0.0v 1599.505n 0.0v 1609.495n 0.0v 1609.505n 0.0v 1619.495n 0.0v 1619.505n 0.0v 1629.495n 0.0v 1629.505n 0.0v 1639.495n 0.0v 1639.505n 0.0v 1649.495n 0.0v 1649.505n 1.7v 1659.495n 1.7v 1659.505n 0.0v 1669.495n 0.0v 1669.505n 0.0v 1679.495n 0.0v 1679.505n 0.0v 1689.495n 0.0v 1689.505n 1.7v 1699.495n 1.7v 1699.505n 1.7v 1709.495n 1.7v 1709.505n 0.0v 1719.495n 0.0v 1719.505n 0.0v 1729.495n 0.0v 1729.505n 0.0v 1739.495n 0.0v 1739.505n 1.7v 1749.495n 1.7v 1749.505n 1.7v 1759.495n 1.7v 1759.505n 0.0v 1769.495n 0.0v 1769.505n 1.7v 1779.495n 1.7v 1779.505n 0.0v 1789.495n 0.0v 1789.505n 0.0v 1799.495n 0.0v 1799.505n 1.7v 1809.495n 1.7v 1809.505n 1.7v 1819.495n 1.7v 1819.505n 1.7v 1829.495n 1.7v 1829.505n 0.0v 1839.495n 0.0v 1839.505n 0.0v 1849.495n 0.0v 1849.505n 0.0v 1859.495n 0.0v 1859.505n 0.0v 1869.495n 0.0v 1869.505n 0.0v 1879.495n 0.0v 1879.505n 0.0v 1889.495n 0.0v 1889.505n 0.0v 1899.495n 0.0v 1899.505n 1.7v 1909.495n 1.7v 1909.505n 0.0v 1919.495n 0.0v 1919.505n 1.7v 1929.495n 1.7v 1929.505n 1.7v 1939.495n 1.7v 1939.505n 1.7v 1949.495n 1.7v 1949.505n 0.0v 1959.495n 0.0v 1959.505n 1.7v 1969.495n 1.7v 1969.505n 1.7v 1979.495n 1.7v 1979.505n 1.7v 1989.495n 1.7v 1989.505n 0.0v 1999.495n 0.0v 1999.505n 0.0v 2009.495n 0.0v 2009.505n 0.0v 2019.495n 0.0v 2019.505n 0.0v 2029.495n 0.0v 2029.505n 0.0v 2039.495n 0.0v 2039.505n 1.7v 2049.495n 1.7v 2049.505n 1.7v )
* (time, data): [(0, 0), (10, 1), (20, 1), (30, 1), (40, 1), (50, 1), (60, 1), (70, 1), (80, 1), (90, 0), (100, 0), (110, 0), (120, 0), (130, 0), (140, 0), (150, 0), (160, 0), (170, 0), (180, 1), (190, 1), (200, 1), (210, 0), (220, 0), (230, 1), (240, 1), (250, 1), (260, 1), (270, 1), (280, 1), (290, 0), (300, 0), (310, 0), (320, 0), (330, 0), (340, 0), (350, 0), (360, 0), (370, 1), (380, 1), (390, 1), (400, 0), (410, 0), (420, 0), (430, 0), (440, 0), (450, 0), (460, 1), (470, 1), (480, 0), (490, 0), (500, 0), (510, 0), (520, 0), (530, 0), (540, 0), (550, 0), (560, 0), (570, 0), (580, 0), (590, 0), (600, 0), (610, 0), (620, 1), (630, 1), (640, 1), (650, 1), (660, 1), (670, 0), (680, 1), (690, 1), (700, 0), (710, 0), (720, 0), (730, 0), (740, 0), (750, 1), (760, 1), (770, 0), (780, 0), (790, 1), (800, 0), (810, 0), (820, 1), (830, 1), (840, 1), (850, 1), (860, 0), (870, 0), (880, 0), (890, 0), (900, 1), (910, 1), (920, 1), (930, 0), (940, 1), (950, 0), (960, 0), (970, 0), (980, 0), (990, 0), (1000, 1), (1010, 1), (1020, 1), (1030, 0), (1040, 0), (1050, 1), (1060, 0), (1070, 0), (1080, 1), (1090, 1), (1100, 1), (1110, 1), (1120, 1), (1130, 1), (1140, 1), (1150, 1), (1160, 1), (1170, 1), (1180, 1), (1190, 1), (1200, 1), (1210, 1), (1220, 1), (1230, 1), (1240, 0), (1250, 0), (1260, 1), (1270, 1), (1280, 0), (1290, 0), (1300, 0), (1310, 0), (1320, 0), (1330, 0), (1340, 1), (1350, 1), (1360, 1), (1370, 1), (1380, 1), (1390, 1), (1400, 0), (1410, 0), (1420, 0), (1430, 1), (1440, 0), (1450, 0), (1460, 0), (1470, 0), (1480, 1), (1490, 1), (1500, 1), (1510, 0), (1520, 1), (1530, 1), (1540, 1), (1550, 1), (1560, 1), (1570, 0), (1580, 0), (1590, 0), (1600, 0), (1610, 0), (1620, 0), (1630, 0), (1640, 0), (1650, 0), (1660, 1), (1670, 1), (1680, 1), (1690, 1), (1700, 0), (1710, 1), (1720, 1), (1730, 1), (1740, 1), (1750, 0), (1760, 0), (1770, 0), (1780, 0), (1790, 1), (1800, 0), (1810, 0), (1820, 1), (1830, 0), (1840, 0), (1850, 0), (1860, 0), (1870, 1), (1880, 1), (1890, 1), (1900, 0), (1910, 1), (1920, 1), (1930, 1), (1940, 1), (1950, 0), (1960, 0), (1970, 1), (1980, 1), (1990, 0), (2000, 0), (2010, 0), (2020, 1), (2030, 1), (2040, 1), (2050, 1)]
Vdin0_10  din0_10  0 PWL (0n 0.0v 9.495n 0.0v 9.505n 1.7v 19.495n 1.7v 19.505n 1.7v 29.495n 1.7v 29.505n 1.7v 39.495n 1.7v 39.505n 1.7v 49.495n 1.7v 49.505n 1.7v 59.495n 1.7v 59.505n 1.7v 69.495n 1.7v 69.505n 1.7v 79.495n 1.7v 79.505n 1.7v 89.495n 1.7v 89.505n 0.0v 99.495n 0.0v 99.505n 0.0v 109.495n 0.0v 109.505n 0.0v 119.495n 0.0v 119.505n 0.0v 129.495n 0.0v 129.505n 0.0v 139.495n 0.0v 139.505n 0.0v 149.495n 0.0v 149.505n 0.0v 159.495n 0.0v 159.505n 0.0v 169.495n 0.0v 169.505n 0.0v 179.495n 0.0v 179.505n 1.7v 189.495n 1.7v 189.505n 1.7v 199.495n 1.7v 199.505n 1.7v 209.495n 1.7v 209.505n 0.0v 219.495n 0.0v 219.505n 0.0v 229.495n 0.0v 229.505n 1.7v 239.495n 1.7v 239.505n 1.7v 249.495n 1.7v 249.505n 1.7v 259.495n 1.7v 259.505n 1.7v 269.495n 1.7v 269.505n 1.7v 279.495n 1.7v 279.505n 1.7v 289.495n 1.7v 289.505n 0.0v 299.495n 0.0v 299.505n 0.0v 309.495n 0.0v 309.505n 0.0v 319.495n 0.0v 319.505n 0.0v 329.495n 0.0v 329.505n 0.0v 339.495n 0.0v 339.505n 0.0v 349.495n 0.0v 349.505n 0.0v 359.495n 0.0v 359.505n 0.0v 369.495n 0.0v 369.505n 1.7v 379.495n 1.7v 379.505n 1.7v 389.495n 1.7v 389.505n 1.7v 399.495n 1.7v 399.505n 0.0v 409.495n 0.0v 409.505n 0.0v 419.495n 0.0v 419.505n 0.0v 429.495n 0.0v 429.505n 0.0v 439.495n 0.0v 439.505n 0.0v 449.495n 0.0v 449.505n 0.0v 459.495n 0.0v 459.505n 1.7v 469.495n 1.7v 469.505n 1.7v 479.495n 1.7v 479.505n 0.0v 489.495n 0.0v 489.505n 0.0v 499.495n 0.0v 499.505n 0.0v 509.495n 0.0v 509.505n 0.0v 519.495n 0.0v 519.505n 0.0v 529.495n 0.0v 529.505n 0.0v 539.495n 0.0v 539.505n 0.0v 549.495n 0.0v 549.505n 0.0v 559.495n 0.0v 559.505n 0.0v 569.495n 0.0v 569.505n 0.0v 579.495n 0.0v 579.505n 0.0v 589.495n 0.0v 589.505n 0.0v 599.495n 0.0v 599.505n 0.0v 609.495n 0.0v 609.505n 0.0v 619.495n 0.0v 619.505n 1.7v 629.495n 1.7v 629.505n 1.7v 639.495n 1.7v 639.505n 1.7v 649.495n 1.7v 649.505n 1.7v 659.495n 1.7v 659.505n 1.7v 669.495n 1.7v 669.505n 0.0v 679.495n 0.0v 679.505n 1.7v 689.495n 1.7v 689.505n 1.7v 699.495n 1.7v 699.505n 0.0v 709.495n 0.0v 709.505n 0.0v 719.495n 0.0v 719.505n 0.0v 729.495n 0.0v 729.505n 0.0v 739.495n 0.0v 739.505n 0.0v 749.495n 0.0v 749.505n 1.7v 759.495n 1.7v 759.505n 1.7v 769.495n 1.7v 769.505n 0.0v 779.495n 0.0v 779.505n 0.0v 789.495n 0.0v 789.505n 1.7v 799.495n 1.7v 799.505n 0.0v 809.495n 0.0v 809.505n 0.0v 819.495n 0.0v 819.505n 1.7v 829.495n 1.7v 829.505n 1.7v 839.495n 1.7v 839.505n 1.7v 849.495n 1.7v 849.505n 1.7v 859.495n 1.7v 859.505n 0.0v 869.495n 0.0v 869.505n 0.0v 879.495n 0.0v 879.505n 0.0v 889.495n 0.0v 889.505n 0.0v 899.495n 0.0v 899.505n 1.7v 909.495n 1.7v 909.505n 1.7v 919.495n 1.7v 919.505n 1.7v 929.495n 1.7v 929.505n 0.0v 939.495n 0.0v 939.505n 1.7v 949.495n 1.7v 949.505n 0.0v 959.495n 0.0v 959.505n 0.0v 969.495n 0.0v 969.505n 0.0v 979.495n 0.0v 979.505n 0.0v 989.495n 0.0v 989.505n 0.0v 999.495n 0.0v 999.505n 1.7v 1009.495n 1.7v 1009.505n 1.7v 1019.495n 1.7v 1019.505n 1.7v 1029.495n 1.7v 1029.505n 0.0v 1039.495n 0.0v 1039.505n 0.0v 1049.495n 0.0v 1049.505n 1.7v 1059.495n 1.7v 1059.505n 0.0v 1069.495n 0.0v 1069.505n 0.0v 1079.495n 0.0v 1079.505n 1.7v 1089.495n 1.7v 1089.505n 1.7v 1099.495n 1.7v 1099.505n 1.7v 1109.495n 1.7v 1109.505n 1.7v 1119.495n 1.7v 1119.505n 1.7v 1129.495n 1.7v 1129.505n 1.7v 1139.495n 1.7v 1139.505n 1.7v 1149.495n 1.7v 1149.505n 1.7v 1159.495n 1.7v 1159.505n 1.7v 1169.495n 1.7v 1169.505n 1.7v 1179.495n 1.7v 1179.505n 1.7v 1189.495n 1.7v 1189.505n 1.7v 1199.495n 1.7v 1199.505n 1.7v 1209.495n 1.7v 1209.505n 1.7v 1219.495n 1.7v 1219.505n 1.7v 1229.495n 1.7v 1229.505n 1.7v 1239.495n 1.7v 1239.505n 0.0v 1249.495n 0.0v 1249.505n 0.0v 1259.495n 0.0v 1259.505n 1.7v 1269.495n 1.7v 1269.505n 1.7v 1279.495n 1.7v 1279.505n 0.0v 1289.495n 0.0v 1289.505n 0.0v 1299.495n 0.0v 1299.505n 0.0v 1309.495n 0.0v 1309.505n 0.0v 1319.495n 0.0v 1319.505n 0.0v 1329.495n 0.0v 1329.505n 0.0v 1339.495n 0.0v 1339.505n 1.7v 1349.495n 1.7v 1349.505n 1.7v 1359.495n 1.7v 1359.505n 1.7v 1369.495n 1.7v 1369.505n 1.7v 1379.495n 1.7v 1379.505n 1.7v 1389.495n 1.7v 1389.505n 1.7v 1399.495n 1.7v 1399.505n 0.0v 1409.495n 0.0v 1409.505n 0.0v 1419.495n 0.0v 1419.505n 0.0v 1429.495n 0.0v 1429.505n 1.7v 1439.495n 1.7v 1439.505n 0.0v 1449.495n 0.0v 1449.505n 0.0v 1459.495n 0.0v 1459.505n 0.0v 1469.495n 0.0v 1469.505n 0.0v 1479.495n 0.0v 1479.505n 1.7v 1489.495n 1.7v 1489.505n 1.7v 1499.495n 1.7v 1499.505n 1.7v 1509.495n 1.7v 1509.505n 0.0v 1519.495n 0.0v 1519.505n 1.7v 1529.495n 1.7v 1529.505n 1.7v 1539.495n 1.7v 1539.505n 1.7v 1549.495n 1.7v 1549.505n 1.7v 1559.495n 1.7v 1559.505n 1.7v 1569.495n 1.7v 1569.505n 0.0v 1579.495n 0.0v 1579.505n 0.0v 1589.495n 0.0v 1589.505n 0.0v 1599.495n 0.0v 1599.505n 0.0v 1609.495n 0.0v 1609.505n 0.0v 1619.495n 0.0v 1619.505n 0.0v 1629.495n 0.0v 1629.505n 0.0v 1639.495n 0.0v 1639.505n 0.0v 1649.495n 0.0v 1649.505n 0.0v 1659.495n 0.0v 1659.505n 1.7v 1669.495n 1.7v 1669.505n 1.7v 1679.495n 1.7v 1679.505n 1.7v 1689.495n 1.7v 1689.505n 1.7v 1699.495n 1.7v 1699.505n 0.0v 1709.495n 0.0v 1709.505n 1.7v 1719.495n 1.7v 1719.505n 1.7v 1729.495n 1.7v 1729.505n 1.7v 1739.495n 1.7v 1739.505n 1.7v 1749.495n 1.7v 1749.505n 0.0v 1759.495n 0.0v 1759.505n 0.0v 1769.495n 0.0v 1769.505n 0.0v 1779.495n 0.0v 1779.505n 0.0v 1789.495n 0.0v 1789.505n 1.7v 1799.495n 1.7v 1799.505n 0.0v 1809.495n 0.0v 1809.505n 0.0v 1819.495n 0.0v 1819.505n 1.7v 1829.495n 1.7v 1829.505n 0.0v 1839.495n 0.0v 1839.505n 0.0v 1849.495n 0.0v 1849.505n 0.0v 1859.495n 0.0v 1859.505n 0.0v 1869.495n 0.0v 1869.505n 1.7v 1879.495n 1.7v 1879.505n 1.7v 1889.495n 1.7v 1889.505n 1.7v 1899.495n 1.7v 1899.505n 0.0v 1909.495n 0.0v 1909.505n 1.7v 1919.495n 1.7v 1919.505n 1.7v 1929.495n 1.7v 1929.505n 1.7v 1939.495n 1.7v 1939.505n 1.7v 1949.495n 1.7v 1949.505n 0.0v 1959.495n 0.0v 1959.505n 0.0v 1969.495n 0.0v 1969.505n 1.7v 1979.495n 1.7v 1979.505n 1.7v 1989.495n 1.7v 1989.505n 0.0v 1999.495n 0.0v 1999.505n 0.0v 2009.495n 0.0v 2009.505n 0.0v 2019.495n 0.0v 2019.505n 1.7v 2029.495n 1.7v 2029.505n 1.7v 2039.495n 1.7v 2039.505n 1.7v 2049.495n 1.7v 2049.505n 1.7v )
* (time, data): [(0, 0), (10, 0), (20, 1), (30, 1), (40, 1), (50, 1), (60, 1), (70, 0), (80, 0), (90, 0), (100, 0), (110, 0), (120, 1), (130, 1), (140, 1), (150, 0), (160, 1), (170, 1), (180, 1), (190, 0), (200, 1), (210, 1), (220, 1), (230, 0), (240, 0), (250, 0), (260, 0), (270, 0), (280, 0), (290, 1), (300, 1), (310, 1), (320, 0), (330, 0), (340, 0), (350, 0), (360, 0), (370, 1), (380, 1), (390, 1), (400, 1), (410, 1), (420, 1), (430, 1), (440, 1), (450, 1), (460, 1), (470, 1), (480, 1), (490, 1), (500, 1), (510, 1), (520, 1), (530, 1), (540, 1), (550, 1), (560, 1), (570, 1), (580, 1), (590, 1), (600, 1), (610, 1), (620, 0), (630, 0), (640, 0), (650, 0), (660, 0), (670, 1), (680, 0), (690, 1), (700, 0), (710, 0), (720, 0), (730, 0), (740, 0), (750, 1), (760, 1), (770, 1), (780, 1), (790, 0), (800, 0), (810, 0), (820, 0), (830, 0), (840, 0), (850, 0), (860, 0), (870, 0), (880, 0), (890, 0), (900, 1), (910, 0), (920, 1), (930, 0), (940, 0), (950, 1), (960, 1), (970, 0), (980, 0), (990, 0), (1000, 0), (1010, 0), (1020, 0), (1030, 0), (1040, 0), (1050, 1), (1060, 1), (1070, 1), (1080, 0), (1090, 0), (1100, 1), (1110, 1), (1120, 1), (1130, 1), (1140, 1), (1150, 1), (1160, 1), (1170, 1), (1180, 1), (1190, 1), (1200, 1), (1210, 1), (1220, 1), (1230, 1), (1240, 1), (1250, 1), (1260, 0), (1270, 0), (1280, 1), (1290, 1), (1300, 1), (1310, 1), (1320, 1), (1330, 1), (1340, 1), (1350, 1), (1360, 1), (1370, 1), (1380, 1), (1390, 1), (1400, 0), (1410, 0), (1420, 0), (1430, 0), (1440, 0), (1450, 0), (1460, 0), (1470, 0), (1480, 0), (1490, 0), (1500, 0), (1510, 0), (1520, 0), (1530, 0), (1540, 0), (1550, 0), (1560, 0), (1570, 1), (1580, 0), (1590, 0), (1600, 0), (1610, 0), (1620, 0), (1630, 1), (1640, 1), (1650, 0), (1660, 0), (1670, 0), (1680, 0), (1690, 1), (1700, 1), (1710, 0), (1720, 0), (1730, 0), (1740, 0), (1750, 0), (1760, 1), (1770, 1), (1780, 1), (1790, 0), (1800, 0), (1810, 0), (1820, 1), (1830, 1), (1840, 1), (1850, 1), (1860, 1), (1870, 0), (1880, 0), (1890, 0), (1900, 1), (1910, 1), (1920, 1), (1930, 0), (1940, 0), (1950, 0), (1960, 1), (1970, 0), (1980, 0), (1990, 1), (2000, 1), (2010, 1), (2020, 1), (2030, 1), (2040, 1), (2050, 1)]
Vdin0_11  din0_11  0 PWL (0n 0.0v 9.495n 0.0v 9.505n 0.0v 19.495n 0.0v 19.505n 1.7v 29.495n 1.7v 29.505n 1.7v 39.495n 1.7v 39.505n 1.7v 49.495n 1.7v 49.505n 1.7v 59.495n 1.7v 59.505n 1.7v 69.495n 1.7v 69.505n 0.0v 79.495n 0.0v 79.505n 0.0v 89.495n 0.0v 89.505n 0.0v 99.495n 0.0v 99.505n 0.0v 109.495n 0.0v 109.505n 0.0v 119.495n 0.0v 119.505n 1.7v 129.495n 1.7v 129.505n 1.7v 139.495n 1.7v 139.505n 1.7v 149.495n 1.7v 149.505n 0.0v 159.495n 0.0v 159.505n 1.7v 169.495n 1.7v 169.505n 1.7v 179.495n 1.7v 179.505n 1.7v 189.495n 1.7v 189.505n 0.0v 199.495n 0.0v 199.505n 1.7v 209.495n 1.7v 209.505n 1.7v 219.495n 1.7v 219.505n 1.7v 229.495n 1.7v 229.505n 0.0v 239.495n 0.0v 239.505n 0.0v 249.495n 0.0v 249.505n 0.0v 259.495n 0.0v 259.505n 0.0v 269.495n 0.0v 269.505n 0.0v 279.495n 0.0v 279.505n 0.0v 289.495n 0.0v 289.505n 1.7v 299.495n 1.7v 299.505n 1.7v 309.495n 1.7v 309.505n 1.7v 319.495n 1.7v 319.505n 0.0v 329.495n 0.0v 329.505n 0.0v 339.495n 0.0v 339.505n 0.0v 349.495n 0.0v 349.505n 0.0v 359.495n 0.0v 359.505n 0.0v 369.495n 0.0v 369.505n 1.7v 379.495n 1.7v 379.505n 1.7v 389.495n 1.7v 389.505n 1.7v 399.495n 1.7v 399.505n 1.7v 409.495n 1.7v 409.505n 1.7v 419.495n 1.7v 419.505n 1.7v 429.495n 1.7v 429.505n 1.7v 439.495n 1.7v 439.505n 1.7v 449.495n 1.7v 449.505n 1.7v 459.495n 1.7v 459.505n 1.7v 469.495n 1.7v 469.505n 1.7v 479.495n 1.7v 479.505n 1.7v 489.495n 1.7v 489.505n 1.7v 499.495n 1.7v 499.505n 1.7v 509.495n 1.7v 509.505n 1.7v 519.495n 1.7v 519.505n 1.7v 529.495n 1.7v 529.505n 1.7v 539.495n 1.7v 539.505n 1.7v 549.495n 1.7v 549.505n 1.7v 559.495n 1.7v 559.505n 1.7v 569.495n 1.7v 569.505n 1.7v 579.495n 1.7v 579.505n 1.7v 589.495n 1.7v 589.505n 1.7v 599.495n 1.7v 599.505n 1.7v 609.495n 1.7v 609.505n 1.7v 619.495n 1.7v 619.505n 0.0v 629.495n 0.0v 629.505n 0.0v 639.495n 0.0v 639.505n 0.0v 649.495n 0.0v 649.505n 0.0v 659.495n 0.0v 659.505n 0.0v 669.495n 0.0v 669.505n 1.7v 679.495n 1.7v 679.505n 0.0v 689.495n 0.0v 689.505n 1.7v 699.495n 1.7v 699.505n 0.0v 709.495n 0.0v 709.505n 0.0v 719.495n 0.0v 719.505n 0.0v 729.495n 0.0v 729.505n 0.0v 739.495n 0.0v 739.505n 0.0v 749.495n 0.0v 749.505n 1.7v 759.495n 1.7v 759.505n 1.7v 769.495n 1.7v 769.505n 1.7v 779.495n 1.7v 779.505n 1.7v 789.495n 1.7v 789.505n 0.0v 799.495n 0.0v 799.505n 0.0v 809.495n 0.0v 809.505n 0.0v 819.495n 0.0v 819.505n 0.0v 829.495n 0.0v 829.505n 0.0v 839.495n 0.0v 839.505n 0.0v 849.495n 0.0v 849.505n 0.0v 859.495n 0.0v 859.505n 0.0v 869.495n 0.0v 869.505n 0.0v 879.495n 0.0v 879.505n 0.0v 889.495n 0.0v 889.505n 0.0v 899.495n 0.0v 899.505n 1.7v 909.495n 1.7v 909.505n 0.0v 919.495n 0.0v 919.505n 1.7v 929.495n 1.7v 929.505n 0.0v 939.495n 0.0v 939.505n 0.0v 949.495n 0.0v 949.505n 1.7v 959.495n 1.7v 959.505n 1.7v 969.495n 1.7v 969.505n 0.0v 979.495n 0.0v 979.505n 0.0v 989.495n 0.0v 989.505n 0.0v 999.495n 0.0v 999.505n 0.0v 1009.495n 0.0v 1009.505n 0.0v 1019.495n 0.0v 1019.505n 0.0v 1029.495n 0.0v 1029.505n 0.0v 1039.495n 0.0v 1039.505n 0.0v 1049.495n 0.0v 1049.505n 1.7v 1059.495n 1.7v 1059.505n 1.7v 1069.495n 1.7v 1069.505n 1.7v 1079.495n 1.7v 1079.505n 0.0v 1089.495n 0.0v 1089.505n 0.0v 1099.495n 0.0v 1099.505n 1.7v 1109.495n 1.7v 1109.505n 1.7v 1119.495n 1.7v 1119.505n 1.7v 1129.495n 1.7v 1129.505n 1.7v 1139.495n 1.7v 1139.505n 1.7v 1149.495n 1.7v 1149.505n 1.7v 1159.495n 1.7v 1159.505n 1.7v 1169.495n 1.7v 1169.505n 1.7v 1179.495n 1.7v 1179.505n 1.7v 1189.495n 1.7v 1189.505n 1.7v 1199.495n 1.7v 1199.505n 1.7v 1209.495n 1.7v 1209.505n 1.7v 1219.495n 1.7v 1219.505n 1.7v 1229.495n 1.7v 1229.505n 1.7v 1239.495n 1.7v 1239.505n 1.7v 1249.495n 1.7v 1249.505n 1.7v 1259.495n 1.7v 1259.505n 0.0v 1269.495n 0.0v 1269.505n 0.0v 1279.495n 0.0v 1279.505n 1.7v 1289.495n 1.7v 1289.505n 1.7v 1299.495n 1.7v 1299.505n 1.7v 1309.495n 1.7v 1309.505n 1.7v 1319.495n 1.7v 1319.505n 1.7v 1329.495n 1.7v 1329.505n 1.7v 1339.495n 1.7v 1339.505n 1.7v 1349.495n 1.7v 1349.505n 1.7v 1359.495n 1.7v 1359.505n 1.7v 1369.495n 1.7v 1369.505n 1.7v 1379.495n 1.7v 1379.505n 1.7v 1389.495n 1.7v 1389.505n 1.7v 1399.495n 1.7v 1399.505n 0.0v 1409.495n 0.0v 1409.505n 0.0v 1419.495n 0.0v 1419.505n 0.0v 1429.495n 0.0v 1429.505n 0.0v 1439.495n 0.0v 1439.505n 0.0v 1449.495n 0.0v 1449.505n 0.0v 1459.495n 0.0v 1459.505n 0.0v 1469.495n 0.0v 1469.505n 0.0v 1479.495n 0.0v 1479.505n 0.0v 1489.495n 0.0v 1489.505n 0.0v 1499.495n 0.0v 1499.505n 0.0v 1509.495n 0.0v 1509.505n 0.0v 1519.495n 0.0v 1519.505n 0.0v 1529.495n 0.0v 1529.505n 0.0v 1539.495n 0.0v 1539.505n 0.0v 1549.495n 0.0v 1549.505n 0.0v 1559.495n 0.0v 1559.505n 0.0v 1569.495n 0.0v 1569.505n 1.7v 1579.495n 1.7v 1579.505n 0.0v 1589.495n 0.0v 1589.505n 0.0v 1599.495n 0.0v 1599.505n 0.0v 1609.495n 0.0v 1609.505n 0.0v 1619.495n 0.0v 1619.505n 0.0v 1629.495n 0.0v 1629.505n 1.7v 1639.495n 1.7v 1639.505n 1.7v 1649.495n 1.7v 1649.505n 0.0v 1659.495n 0.0v 1659.505n 0.0v 1669.495n 0.0v 1669.505n 0.0v 1679.495n 0.0v 1679.505n 0.0v 1689.495n 0.0v 1689.505n 1.7v 1699.495n 1.7v 1699.505n 1.7v 1709.495n 1.7v 1709.505n 0.0v 1719.495n 0.0v 1719.505n 0.0v 1729.495n 0.0v 1729.505n 0.0v 1739.495n 0.0v 1739.505n 0.0v 1749.495n 0.0v 1749.505n 0.0v 1759.495n 0.0v 1759.505n 1.7v 1769.495n 1.7v 1769.505n 1.7v 1779.495n 1.7v 1779.505n 1.7v 1789.495n 1.7v 1789.505n 0.0v 1799.495n 0.0v 1799.505n 0.0v 1809.495n 0.0v 1809.505n 0.0v 1819.495n 0.0v 1819.505n 1.7v 1829.495n 1.7v 1829.505n 1.7v 1839.495n 1.7v 1839.505n 1.7v 1849.495n 1.7v 1849.505n 1.7v 1859.495n 1.7v 1859.505n 1.7v 1869.495n 1.7v 1869.505n 0.0v 1879.495n 0.0v 1879.505n 0.0v 1889.495n 0.0v 1889.505n 0.0v 1899.495n 0.0v 1899.505n 1.7v 1909.495n 1.7v 1909.505n 1.7v 1919.495n 1.7v 1919.505n 1.7v 1929.495n 1.7v 1929.505n 0.0v 1939.495n 0.0v 1939.505n 0.0v 1949.495n 0.0v 1949.505n 0.0v 1959.495n 0.0v 1959.505n 1.7v 1969.495n 1.7v 1969.505n 0.0v 1979.495n 0.0v 1979.505n 0.0v 1989.495n 0.0v 1989.505n 1.7v 1999.495n 1.7v 1999.505n 1.7v 2009.495n 1.7v 2009.505n 1.7v 2019.495n 1.7v 2019.505n 1.7v 2029.495n 1.7v 2029.505n 1.7v 2039.495n 1.7v 2039.505n 1.7v 2049.495n 1.7v 2049.505n 1.7v )
* (time, data): [(0, 0), (10, 0), (20, 0), (30, 1), (40, 1), (50, 1), (60, 1), (70, 0), (80, 0), (90, 0), (100, 0), (110, 0), (120, 0), (130, 0), (140, 0), (150, 1), (160, 0), (170, 0), (180, 1), (190, 0), (200, 0), (210, 1), (220, 1), (230, 1), (240, 1), (250, 1), (260, 1), (270, 1), (280, 1), (290, 1), (300, 1), (310, 1), (320, 1), (330, 1), (340, 1), (350, 1), (360, 1), (370, 0), (380, 0), (390, 1), (400, 0), (410, 0), (420, 0), (430, 0), (440, 0), (450, 0), (460, 0), (470, 0), (480, 0), (490, 0), (500, 0), (510, 0), (520, 0), (530, 0), (540, 0), (550, 0), (560, 0), (570, 1), (580, 1), (590, 1), (600, 1), (610, 1), (620, 1), (630, 1), (640, 1), (650, 1), (660, 1), (670, 0), (680, 0), (690, 1), (700, 0), (710, 0), (720, 1), (730, 1), (740, 1), (750, 0), (760, 0), (770, 1), (780, 1), (790, 1), (800, 1), (810, 1), (820, 0), (830, 0), (840, 0), (850, 0), (860, 0), (870, 0), (880, 0), (890, 0), (900, 1), (910, 1), (920, 1), (930, 1), (940, 1), (950, 1), (960, 1), (970, 0), (980, 0), (990, 0), (1000, 1), (1010, 1), (1020, 1), (1030, 0), (1040, 1), (1050, 1), (1060, 1), (1070, 1), (1080, 1), (1090, 1), (1100, 0), (1110, 0), (1120, 0), (1130, 0), (1140, 0), (1150, 0), (1160, 0), (1170, 1), (1180, 0), (1190, 0), (1200, 0), (1210, 0), (1220, 0), (1230, 0), (1240, 0), (1250, 1), (1260, 1), (1270, 1), (1280, 0), (1290, 0), (1300, 1), (1310, 1), (1320, 1), (1330, 1), (1340, 1), (1350, 1), (1360, 1), (1370, 1), (1380, 1), (1390, 1), (1400, 1), (1410, 1), (1420, 1), (1430, 1), (1440, 0), (1450, 0), (1460, 0), (1470, 0), (1480, 1), (1490, 1), (1500, 1), (1510, 1), (1520, 1), (1530, 1), (1540, 1), (1550, 1), (1560, 1), (1570, 0), (1580, 0), (1590, 0), (1600, 0), (1610, 0), (1620, 0), (1630, 0), (1640, 0), (1650, 0), (1660, 1), (1670, 1), (1680, 1), (1690, 0), (1700, 1), (1710, 1), (1720, 1), (1730, 1), (1740, 1), (1750, 1), (1760, 0), (1770, 1), (1780, 0), (1790, 1), (1800, 0), (1810, 0), (1820, 0), (1830, 0), (1840, 0), (1850, 0), (1860, 0), (1870, 1), (1880, 1), (1890, 1), (1900, 1), (1910, 0), (1920, 1), (1930, 0), (1940, 0), (1950, 1), (1960, 0), (1970, 0), (1980, 0), (1990, 0), (2000, 0), (2010, 0), (2020, 0), (2030, 0), (2040, 1), (2050, 1)]
Vdin0_12  din0_12  0 PWL (0n 0.0v 9.495n 0.0v 9.505n 0.0v 19.495n 0.0v 19.505n 0.0v 29.495n 0.0v 29.505n 1.7v 39.495n 1.7v 39.505n 1.7v 49.495n 1.7v 49.505n 1.7v 59.495n 1.7v 59.505n 1.7v 69.495n 1.7v 69.505n 0.0v 79.495n 0.0v 79.505n 0.0v 89.495n 0.0v 89.505n 0.0v 99.495n 0.0v 99.505n 0.0v 109.495n 0.0v 109.505n 0.0v 119.495n 0.0v 119.505n 0.0v 129.495n 0.0v 129.505n 0.0v 139.495n 0.0v 139.505n 0.0v 149.495n 0.0v 149.505n 1.7v 159.495n 1.7v 159.505n 0.0v 169.495n 0.0v 169.505n 0.0v 179.495n 0.0v 179.505n 1.7v 189.495n 1.7v 189.505n 0.0v 199.495n 0.0v 199.505n 0.0v 209.495n 0.0v 209.505n 1.7v 219.495n 1.7v 219.505n 1.7v 229.495n 1.7v 229.505n 1.7v 239.495n 1.7v 239.505n 1.7v 249.495n 1.7v 249.505n 1.7v 259.495n 1.7v 259.505n 1.7v 269.495n 1.7v 269.505n 1.7v 279.495n 1.7v 279.505n 1.7v 289.495n 1.7v 289.505n 1.7v 299.495n 1.7v 299.505n 1.7v 309.495n 1.7v 309.505n 1.7v 319.495n 1.7v 319.505n 1.7v 329.495n 1.7v 329.505n 1.7v 339.495n 1.7v 339.505n 1.7v 349.495n 1.7v 349.505n 1.7v 359.495n 1.7v 359.505n 1.7v 369.495n 1.7v 369.505n 0.0v 379.495n 0.0v 379.505n 0.0v 389.495n 0.0v 389.505n 1.7v 399.495n 1.7v 399.505n 0.0v 409.495n 0.0v 409.505n 0.0v 419.495n 0.0v 419.505n 0.0v 429.495n 0.0v 429.505n 0.0v 439.495n 0.0v 439.505n 0.0v 449.495n 0.0v 449.505n 0.0v 459.495n 0.0v 459.505n 0.0v 469.495n 0.0v 469.505n 0.0v 479.495n 0.0v 479.505n 0.0v 489.495n 0.0v 489.505n 0.0v 499.495n 0.0v 499.505n 0.0v 509.495n 0.0v 509.505n 0.0v 519.495n 0.0v 519.505n 0.0v 529.495n 0.0v 529.505n 0.0v 539.495n 0.0v 539.505n 0.0v 549.495n 0.0v 549.505n 0.0v 559.495n 0.0v 559.505n 0.0v 569.495n 0.0v 569.505n 1.7v 579.495n 1.7v 579.505n 1.7v 589.495n 1.7v 589.505n 1.7v 599.495n 1.7v 599.505n 1.7v 609.495n 1.7v 609.505n 1.7v 619.495n 1.7v 619.505n 1.7v 629.495n 1.7v 629.505n 1.7v 639.495n 1.7v 639.505n 1.7v 649.495n 1.7v 649.505n 1.7v 659.495n 1.7v 659.505n 1.7v 669.495n 1.7v 669.505n 0.0v 679.495n 0.0v 679.505n 0.0v 689.495n 0.0v 689.505n 1.7v 699.495n 1.7v 699.505n 0.0v 709.495n 0.0v 709.505n 0.0v 719.495n 0.0v 719.505n 1.7v 729.495n 1.7v 729.505n 1.7v 739.495n 1.7v 739.505n 1.7v 749.495n 1.7v 749.505n 0.0v 759.495n 0.0v 759.505n 0.0v 769.495n 0.0v 769.505n 1.7v 779.495n 1.7v 779.505n 1.7v 789.495n 1.7v 789.505n 1.7v 799.495n 1.7v 799.505n 1.7v 809.495n 1.7v 809.505n 1.7v 819.495n 1.7v 819.505n 0.0v 829.495n 0.0v 829.505n 0.0v 839.495n 0.0v 839.505n 0.0v 849.495n 0.0v 849.505n 0.0v 859.495n 0.0v 859.505n 0.0v 869.495n 0.0v 869.505n 0.0v 879.495n 0.0v 879.505n 0.0v 889.495n 0.0v 889.505n 0.0v 899.495n 0.0v 899.505n 1.7v 909.495n 1.7v 909.505n 1.7v 919.495n 1.7v 919.505n 1.7v 929.495n 1.7v 929.505n 1.7v 939.495n 1.7v 939.505n 1.7v 949.495n 1.7v 949.505n 1.7v 959.495n 1.7v 959.505n 1.7v 969.495n 1.7v 969.505n 0.0v 979.495n 0.0v 979.505n 0.0v 989.495n 0.0v 989.505n 0.0v 999.495n 0.0v 999.505n 1.7v 1009.495n 1.7v 1009.505n 1.7v 1019.495n 1.7v 1019.505n 1.7v 1029.495n 1.7v 1029.505n 0.0v 1039.495n 0.0v 1039.505n 1.7v 1049.495n 1.7v 1049.505n 1.7v 1059.495n 1.7v 1059.505n 1.7v 1069.495n 1.7v 1069.505n 1.7v 1079.495n 1.7v 1079.505n 1.7v 1089.495n 1.7v 1089.505n 1.7v 1099.495n 1.7v 1099.505n 0.0v 1109.495n 0.0v 1109.505n 0.0v 1119.495n 0.0v 1119.505n 0.0v 1129.495n 0.0v 1129.505n 0.0v 1139.495n 0.0v 1139.505n 0.0v 1149.495n 0.0v 1149.505n 0.0v 1159.495n 0.0v 1159.505n 0.0v 1169.495n 0.0v 1169.505n 1.7v 1179.495n 1.7v 1179.505n 0.0v 1189.495n 0.0v 1189.505n 0.0v 1199.495n 0.0v 1199.505n 0.0v 1209.495n 0.0v 1209.505n 0.0v 1219.495n 0.0v 1219.505n 0.0v 1229.495n 0.0v 1229.505n 0.0v 1239.495n 0.0v 1239.505n 0.0v 1249.495n 0.0v 1249.505n 1.7v 1259.495n 1.7v 1259.505n 1.7v 1269.495n 1.7v 1269.505n 1.7v 1279.495n 1.7v 1279.505n 0.0v 1289.495n 0.0v 1289.505n 0.0v 1299.495n 0.0v 1299.505n 1.7v 1309.495n 1.7v 1309.505n 1.7v 1319.495n 1.7v 1319.505n 1.7v 1329.495n 1.7v 1329.505n 1.7v 1339.495n 1.7v 1339.505n 1.7v 1349.495n 1.7v 1349.505n 1.7v 1359.495n 1.7v 1359.505n 1.7v 1369.495n 1.7v 1369.505n 1.7v 1379.495n 1.7v 1379.505n 1.7v 1389.495n 1.7v 1389.505n 1.7v 1399.495n 1.7v 1399.505n 1.7v 1409.495n 1.7v 1409.505n 1.7v 1419.495n 1.7v 1419.505n 1.7v 1429.495n 1.7v 1429.505n 1.7v 1439.495n 1.7v 1439.505n 0.0v 1449.495n 0.0v 1449.505n 0.0v 1459.495n 0.0v 1459.505n 0.0v 1469.495n 0.0v 1469.505n 0.0v 1479.495n 0.0v 1479.505n 1.7v 1489.495n 1.7v 1489.505n 1.7v 1499.495n 1.7v 1499.505n 1.7v 1509.495n 1.7v 1509.505n 1.7v 1519.495n 1.7v 1519.505n 1.7v 1529.495n 1.7v 1529.505n 1.7v 1539.495n 1.7v 1539.505n 1.7v 1549.495n 1.7v 1549.505n 1.7v 1559.495n 1.7v 1559.505n 1.7v 1569.495n 1.7v 1569.505n 0.0v 1579.495n 0.0v 1579.505n 0.0v 1589.495n 0.0v 1589.505n 0.0v 1599.495n 0.0v 1599.505n 0.0v 1609.495n 0.0v 1609.505n 0.0v 1619.495n 0.0v 1619.505n 0.0v 1629.495n 0.0v 1629.505n 0.0v 1639.495n 0.0v 1639.505n 0.0v 1649.495n 0.0v 1649.505n 0.0v 1659.495n 0.0v 1659.505n 1.7v 1669.495n 1.7v 1669.505n 1.7v 1679.495n 1.7v 1679.505n 1.7v 1689.495n 1.7v 1689.505n 0.0v 1699.495n 0.0v 1699.505n 1.7v 1709.495n 1.7v 1709.505n 1.7v 1719.495n 1.7v 1719.505n 1.7v 1729.495n 1.7v 1729.505n 1.7v 1739.495n 1.7v 1739.505n 1.7v 1749.495n 1.7v 1749.505n 1.7v 1759.495n 1.7v 1759.505n 0.0v 1769.495n 0.0v 1769.505n 1.7v 1779.495n 1.7v 1779.505n 0.0v 1789.495n 0.0v 1789.505n 1.7v 1799.495n 1.7v 1799.505n 0.0v 1809.495n 0.0v 1809.505n 0.0v 1819.495n 0.0v 1819.505n 0.0v 1829.495n 0.0v 1829.505n 0.0v 1839.495n 0.0v 1839.505n 0.0v 1849.495n 0.0v 1849.505n 0.0v 1859.495n 0.0v 1859.505n 0.0v 1869.495n 0.0v 1869.505n 1.7v 1879.495n 1.7v 1879.505n 1.7v 1889.495n 1.7v 1889.505n 1.7v 1899.495n 1.7v 1899.505n 1.7v 1909.495n 1.7v 1909.505n 0.0v 1919.495n 0.0v 1919.505n 1.7v 1929.495n 1.7v 1929.505n 0.0v 1939.495n 0.0v 1939.505n 0.0v 1949.495n 0.0v 1949.505n 1.7v 1959.495n 1.7v 1959.505n 0.0v 1969.495n 0.0v 1969.505n 0.0v 1979.495n 0.0v 1979.505n 0.0v 1989.495n 0.0v 1989.505n 0.0v 1999.495n 0.0v 1999.505n 0.0v 2009.495n 0.0v 2009.505n 0.0v 2019.495n 0.0v 2019.505n 0.0v 2029.495n 0.0v 2029.505n 0.0v 2039.495n 0.0v 2039.505n 1.7v 2049.495n 1.7v 2049.505n 1.7v )
* (time, data): [(0, 0), (10, 1), (20, 1), (30, 0), (40, 0), (50, 0), (60, 0), (70, 0), (80, 0), (90, 0), (100, 1), (110, 1), (120, 0), (130, 0), (140, 0), (150, 0), (160, 1), (170, 1), (180, 0), (190, 1), (200, 0), (210, 0), (220, 1), (230, 0), (240, 0), (250, 0), (260, 0), (270, 0), (280, 0), (290, 0), (300, 0), (310, 0), (320, 1), (330, 1), (340, 1), (350, 1), (360, 1), (370, 1), (380, 0), (390, 1), (400, 0), (410, 0), (420, 0), (430, 0), (440, 0), (450, 0), (460, 0), (470, 0), (480, 0), (490, 1), (500, 1), (510, 0), (520, 0), (530, 0), (540, 0), (550, 0), (560, 0), (570, 1), (580, 1), (590, 1), (600, 1), (610, 1), (620, 1), (630, 0), (640, 0), (650, 0), (660, 0), (670, 1), (680, 1), (690, 1), (700, 0), (710, 0), (720, 0), (730, 0), (740, 0), (750, 1), (760, 0), (770, 1), (780, 1), (790, 1), (800, 1), (810, 1), (820, 1), (830, 1), (840, 1), (850, 1), (860, 0), (870, 0), (880, 0), (890, 0), (900, 1), (910, 1), (920, 0), (930, 1), (940, 1), (950, 0), (960, 0), (970, 1), (980, 0), (990, 1), (1000, 0), (1010, 0), (1020, 0), (1030, 0), (1040, 0), (1050, 1), (1060, 1), (1070, 1), (1080, 0), (1090, 0), (1100, 1), (1110, 1), (1120, 1), (1130, 1), (1140, 1), (1150, 1), (1160, 1), (1170, 0), (1180, 1), (1190, 1), (1200, 1), (1210, 1), (1220, 1), (1230, 0), (1240, 1), (1250, 1), (1260, 1), (1270, 1), (1280, 0), (1290, 0), (1300, 0), (1310, 0), (1320, 0), (1330, 1), (1340, 0), (1350, 0), (1360, 0), (1370, 0), (1380, 0), (1390, 0), (1400, 0), (1410, 0), (1420, 0), (1430, 1), (1440, 0), (1450, 0), (1460, 0), (1470, 0), (1480, 1), (1490, 1), (1500, 1), (1510, 1), (1520, 0), (1530, 0), (1540, 0), (1550, 0), (1560, 0), (1570, 1), (1580, 0), (1590, 0), (1600, 0), (1610, 0), (1620, 0), (1630, 0), (1640, 0), (1650, 1), (1660, 0), (1670, 0), (1680, 0), (1690, 1), (1700, 1), (1710, 0), (1720, 0), (1730, 0), (1740, 1), (1750, 1), (1760, 1), (1770, 0), (1780, 0), (1790, 1), (1800, 1), (1810, 1), (1820, 0), (1830, 1), (1840, 1), (1850, 1), (1860, 1), (1870, 1), (1880, 1), (1890, 1), (1900, 0), (1910, 0), (1920, 0), (1930, 0), (1940, 0), (1950, 1), (1960, 0), (1970, 1), (1980, 1), (1990, 0), (2000, 0), (2010, 0), (2020, 1), (2030, 1), (2040, 1), (2050, 1)]
Vdin0_13  din0_13  0 PWL (0n 0.0v 9.495n 0.0v 9.505n 1.7v 19.495n 1.7v 19.505n 1.7v 29.495n 1.7v 29.505n 0.0v 39.495n 0.0v 39.505n 0.0v 49.495n 0.0v 49.505n 0.0v 59.495n 0.0v 59.505n 0.0v 69.495n 0.0v 69.505n 0.0v 79.495n 0.0v 79.505n 0.0v 89.495n 0.0v 89.505n 0.0v 99.495n 0.0v 99.505n 1.7v 109.495n 1.7v 109.505n 1.7v 119.495n 1.7v 119.505n 0.0v 129.495n 0.0v 129.505n 0.0v 139.495n 0.0v 139.505n 0.0v 149.495n 0.0v 149.505n 0.0v 159.495n 0.0v 159.505n 1.7v 169.495n 1.7v 169.505n 1.7v 179.495n 1.7v 179.505n 0.0v 189.495n 0.0v 189.505n 1.7v 199.495n 1.7v 199.505n 0.0v 209.495n 0.0v 209.505n 0.0v 219.495n 0.0v 219.505n 1.7v 229.495n 1.7v 229.505n 0.0v 239.495n 0.0v 239.505n 0.0v 249.495n 0.0v 249.505n 0.0v 259.495n 0.0v 259.505n 0.0v 269.495n 0.0v 269.505n 0.0v 279.495n 0.0v 279.505n 0.0v 289.495n 0.0v 289.505n 0.0v 299.495n 0.0v 299.505n 0.0v 309.495n 0.0v 309.505n 0.0v 319.495n 0.0v 319.505n 1.7v 329.495n 1.7v 329.505n 1.7v 339.495n 1.7v 339.505n 1.7v 349.495n 1.7v 349.505n 1.7v 359.495n 1.7v 359.505n 1.7v 369.495n 1.7v 369.505n 1.7v 379.495n 1.7v 379.505n 0.0v 389.495n 0.0v 389.505n 1.7v 399.495n 1.7v 399.505n 0.0v 409.495n 0.0v 409.505n 0.0v 419.495n 0.0v 419.505n 0.0v 429.495n 0.0v 429.505n 0.0v 439.495n 0.0v 439.505n 0.0v 449.495n 0.0v 449.505n 0.0v 459.495n 0.0v 459.505n 0.0v 469.495n 0.0v 469.505n 0.0v 479.495n 0.0v 479.505n 0.0v 489.495n 0.0v 489.505n 1.7v 499.495n 1.7v 499.505n 1.7v 509.495n 1.7v 509.505n 0.0v 519.495n 0.0v 519.505n 0.0v 529.495n 0.0v 529.505n 0.0v 539.495n 0.0v 539.505n 0.0v 549.495n 0.0v 549.505n 0.0v 559.495n 0.0v 559.505n 0.0v 569.495n 0.0v 569.505n 1.7v 579.495n 1.7v 579.505n 1.7v 589.495n 1.7v 589.505n 1.7v 599.495n 1.7v 599.505n 1.7v 609.495n 1.7v 609.505n 1.7v 619.495n 1.7v 619.505n 1.7v 629.495n 1.7v 629.505n 0.0v 639.495n 0.0v 639.505n 0.0v 649.495n 0.0v 649.505n 0.0v 659.495n 0.0v 659.505n 0.0v 669.495n 0.0v 669.505n 1.7v 679.495n 1.7v 679.505n 1.7v 689.495n 1.7v 689.505n 1.7v 699.495n 1.7v 699.505n 0.0v 709.495n 0.0v 709.505n 0.0v 719.495n 0.0v 719.505n 0.0v 729.495n 0.0v 729.505n 0.0v 739.495n 0.0v 739.505n 0.0v 749.495n 0.0v 749.505n 1.7v 759.495n 1.7v 759.505n 0.0v 769.495n 0.0v 769.505n 1.7v 779.495n 1.7v 779.505n 1.7v 789.495n 1.7v 789.505n 1.7v 799.495n 1.7v 799.505n 1.7v 809.495n 1.7v 809.505n 1.7v 819.495n 1.7v 819.505n 1.7v 829.495n 1.7v 829.505n 1.7v 839.495n 1.7v 839.505n 1.7v 849.495n 1.7v 849.505n 1.7v 859.495n 1.7v 859.505n 0.0v 869.495n 0.0v 869.505n 0.0v 879.495n 0.0v 879.505n 0.0v 889.495n 0.0v 889.505n 0.0v 899.495n 0.0v 899.505n 1.7v 909.495n 1.7v 909.505n 1.7v 919.495n 1.7v 919.505n 0.0v 929.495n 0.0v 929.505n 1.7v 939.495n 1.7v 939.505n 1.7v 949.495n 1.7v 949.505n 0.0v 959.495n 0.0v 959.505n 0.0v 969.495n 0.0v 969.505n 1.7v 979.495n 1.7v 979.505n 0.0v 989.495n 0.0v 989.505n 1.7v 999.495n 1.7v 999.505n 0.0v 1009.495n 0.0v 1009.505n 0.0v 1019.495n 0.0v 1019.505n 0.0v 1029.495n 0.0v 1029.505n 0.0v 1039.495n 0.0v 1039.505n 0.0v 1049.495n 0.0v 1049.505n 1.7v 1059.495n 1.7v 1059.505n 1.7v 1069.495n 1.7v 1069.505n 1.7v 1079.495n 1.7v 1079.505n 0.0v 1089.495n 0.0v 1089.505n 0.0v 1099.495n 0.0v 1099.505n 1.7v 1109.495n 1.7v 1109.505n 1.7v 1119.495n 1.7v 1119.505n 1.7v 1129.495n 1.7v 1129.505n 1.7v 1139.495n 1.7v 1139.505n 1.7v 1149.495n 1.7v 1149.505n 1.7v 1159.495n 1.7v 1159.505n 1.7v 1169.495n 1.7v 1169.505n 0.0v 1179.495n 0.0v 1179.505n 1.7v 1189.495n 1.7v 1189.505n 1.7v 1199.495n 1.7v 1199.505n 1.7v 1209.495n 1.7v 1209.505n 1.7v 1219.495n 1.7v 1219.505n 1.7v 1229.495n 1.7v 1229.505n 0.0v 1239.495n 0.0v 1239.505n 1.7v 1249.495n 1.7v 1249.505n 1.7v 1259.495n 1.7v 1259.505n 1.7v 1269.495n 1.7v 1269.505n 1.7v 1279.495n 1.7v 1279.505n 0.0v 1289.495n 0.0v 1289.505n 0.0v 1299.495n 0.0v 1299.505n 0.0v 1309.495n 0.0v 1309.505n 0.0v 1319.495n 0.0v 1319.505n 0.0v 1329.495n 0.0v 1329.505n 1.7v 1339.495n 1.7v 1339.505n 0.0v 1349.495n 0.0v 1349.505n 0.0v 1359.495n 0.0v 1359.505n 0.0v 1369.495n 0.0v 1369.505n 0.0v 1379.495n 0.0v 1379.505n 0.0v 1389.495n 0.0v 1389.505n 0.0v 1399.495n 0.0v 1399.505n 0.0v 1409.495n 0.0v 1409.505n 0.0v 1419.495n 0.0v 1419.505n 0.0v 1429.495n 0.0v 1429.505n 1.7v 1439.495n 1.7v 1439.505n 0.0v 1449.495n 0.0v 1449.505n 0.0v 1459.495n 0.0v 1459.505n 0.0v 1469.495n 0.0v 1469.505n 0.0v 1479.495n 0.0v 1479.505n 1.7v 1489.495n 1.7v 1489.505n 1.7v 1499.495n 1.7v 1499.505n 1.7v 1509.495n 1.7v 1509.505n 1.7v 1519.495n 1.7v 1519.505n 0.0v 1529.495n 0.0v 1529.505n 0.0v 1539.495n 0.0v 1539.505n 0.0v 1549.495n 0.0v 1549.505n 0.0v 1559.495n 0.0v 1559.505n 0.0v 1569.495n 0.0v 1569.505n 1.7v 1579.495n 1.7v 1579.505n 0.0v 1589.495n 0.0v 1589.505n 0.0v 1599.495n 0.0v 1599.505n 0.0v 1609.495n 0.0v 1609.505n 0.0v 1619.495n 0.0v 1619.505n 0.0v 1629.495n 0.0v 1629.505n 0.0v 1639.495n 0.0v 1639.505n 0.0v 1649.495n 0.0v 1649.505n 1.7v 1659.495n 1.7v 1659.505n 0.0v 1669.495n 0.0v 1669.505n 0.0v 1679.495n 0.0v 1679.505n 0.0v 1689.495n 0.0v 1689.505n 1.7v 1699.495n 1.7v 1699.505n 1.7v 1709.495n 1.7v 1709.505n 0.0v 1719.495n 0.0v 1719.505n 0.0v 1729.495n 0.0v 1729.505n 0.0v 1739.495n 0.0v 1739.505n 1.7v 1749.495n 1.7v 1749.505n 1.7v 1759.495n 1.7v 1759.505n 1.7v 1769.495n 1.7v 1769.505n 0.0v 1779.495n 0.0v 1779.505n 0.0v 1789.495n 0.0v 1789.505n 1.7v 1799.495n 1.7v 1799.505n 1.7v 1809.495n 1.7v 1809.505n 1.7v 1819.495n 1.7v 1819.505n 0.0v 1829.495n 0.0v 1829.505n 1.7v 1839.495n 1.7v 1839.505n 1.7v 1849.495n 1.7v 1849.505n 1.7v 1859.495n 1.7v 1859.505n 1.7v 1869.495n 1.7v 1869.505n 1.7v 1879.495n 1.7v 1879.505n 1.7v 1889.495n 1.7v 1889.505n 1.7v 1899.495n 1.7v 1899.505n 0.0v 1909.495n 0.0v 1909.505n 0.0v 1919.495n 0.0v 1919.505n 0.0v 1929.495n 0.0v 1929.505n 0.0v 1939.495n 0.0v 1939.505n 0.0v 1949.495n 0.0v 1949.505n 1.7v 1959.495n 1.7v 1959.505n 0.0v 1969.495n 0.0v 1969.505n 1.7v 1979.495n 1.7v 1979.505n 1.7v 1989.495n 1.7v 1989.505n 0.0v 1999.495n 0.0v 1999.505n 0.0v 2009.495n 0.0v 2009.505n 0.0v 2019.495n 0.0v 2019.505n 1.7v 2029.495n 1.7v 2029.505n 1.7v 2039.495n 1.7v 2039.505n 1.7v 2049.495n 1.7v 2049.505n 1.7v )
* (time, data): [(0, 0), (10, 0), (20, 1), (30, 0), (40, 0), (50, 0), (60, 0), (70, 0), (80, 0), (90, 0), (100, 0), (110, 0), (120, 1), (130, 0), (140, 0), (150, 1), (160, 1), (170, 1), (180, 0), (190, 0), (200, 0), (210, 1), (220, 1), (230, 1), (240, 1), (250, 1), (260, 1), (270, 1), (280, 1), (290, 1), (300, 1), (310, 1), (320, 0), (330, 0), (340, 0), (350, 0), (360, 0), (370, 0), (380, 1), (390, 1), (400, 1), (410, 1), (420, 1), (430, 1), (440, 1), (450, 1), (460, 0), (470, 0), (480, 0), (490, 0), (500, 1), (510, 1), (520, 1), (530, 1), (540, 1), (550, 1), (560, 1), (570, 0), (580, 0), (590, 0), (600, 0), (610, 0), (620, 0), (630, 0), (640, 0), (650, 0), (660, 0), (670, 1), (680, 0), (690, 0), (700, 1), (710, 1), (720, 1), (730, 1), (740, 1), (750, 0), (760, 0), (770, 0), (780, 0), (790, 0), (800, 0), (810, 0), (820, 0), (830, 1), (840, 1), (850, 1), (860, 0), (870, 0), (880, 0), (890, 0), (900, 1), (910, 0), (920, 0), (930, 1), (940, 0), (950, 0), (960, 0), (970, 0), (980, 1), (990, 0), (1000, 1), (1010, 1), (1020, 1), (1030, 0), (1040, 0), (1050, 1), (1060, 1), (1070, 1), (1080, 1), (1090, 1), (1100, 1), (1110, 1), (1120, 1), (1130, 1), (1140, 1), (1150, 1), (1160, 0), (1170, 1), (1180, 0), (1190, 0), (1200, 0), (1210, 0), (1220, 0), (1230, 0), (1240, 1), (1250, 0), (1260, 1), (1270, 1), (1280, 0), (1290, 0), (1300, 0), (1310, 0), (1320, 0), (1330, 0), (1340, 1), (1350, 1), (1360, 1), (1370, 1), (1380, 1), (1390, 1), (1400, 0), (1410, 0), (1420, 0), (1430, 0), (1440, 1), (1450, 1), (1460, 1), (1470, 1), (1480, 0), (1490, 0), (1500, 0), (1510, 1), (1520, 1), (1530, 1), (1540, 1), (1550, 1), (1560, 1), (1570, 1), (1580, 0), (1590, 0), (1600, 0), (1610, 0), (1620, 0), (1630, 0), (1640, 0), (1650, 0), (1660, 1), (1670, 1), (1680, 1), (1690, 1), (1700, 0), (1710, 1), (1720, 1), (1730, 1), (1740, 0), (1750, 1), (1760, 0), (1770, 1), (1780, 0), (1790, 1), (1800, 1), (1810, 1), (1820, 1), (1830, 1), (1840, 1), (1850, 1), (1860, 1), (1870, 0), (1880, 0), (1890, 0), (1900, 0), (1910, 1), (1920, 1), (1930, 0), (1940, 0), (1950, 0), (1960, 0), (1970, 0), (1980, 0), (1990, 1), (2000, 1), (2010, 1), (2020, 1), (2030, 1), (2040, 1), (2050, 1)]
Vdin0_14  din0_14  0 PWL (0n 0.0v 9.495n 0.0v 9.505n 0.0v 19.495n 0.0v 19.505n 1.7v 29.495n 1.7v 29.505n 0.0v 39.495n 0.0v 39.505n 0.0v 49.495n 0.0v 49.505n 0.0v 59.495n 0.0v 59.505n 0.0v 69.495n 0.0v 69.505n 0.0v 79.495n 0.0v 79.505n 0.0v 89.495n 0.0v 89.505n 0.0v 99.495n 0.0v 99.505n 0.0v 109.495n 0.0v 109.505n 0.0v 119.495n 0.0v 119.505n 1.7v 129.495n 1.7v 129.505n 0.0v 139.495n 0.0v 139.505n 0.0v 149.495n 0.0v 149.505n 1.7v 159.495n 1.7v 159.505n 1.7v 169.495n 1.7v 169.505n 1.7v 179.495n 1.7v 179.505n 0.0v 189.495n 0.0v 189.505n 0.0v 199.495n 0.0v 199.505n 0.0v 209.495n 0.0v 209.505n 1.7v 219.495n 1.7v 219.505n 1.7v 229.495n 1.7v 229.505n 1.7v 239.495n 1.7v 239.505n 1.7v 249.495n 1.7v 249.505n 1.7v 259.495n 1.7v 259.505n 1.7v 269.495n 1.7v 269.505n 1.7v 279.495n 1.7v 279.505n 1.7v 289.495n 1.7v 289.505n 1.7v 299.495n 1.7v 299.505n 1.7v 309.495n 1.7v 309.505n 1.7v 319.495n 1.7v 319.505n 0.0v 329.495n 0.0v 329.505n 0.0v 339.495n 0.0v 339.505n 0.0v 349.495n 0.0v 349.505n 0.0v 359.495n 0.0v 359.505n 0.0v 369.495n 0.0v 369.505n 0.0v 379.495n 0.0v 379.505n 1.7v 389.495n 1.7v 389.505n 1.7v 399.495n 1.7v 399.505n 1.7v 409.495n 1.7v 409.505n 1.7v 419.495n 1.7v 419.505n 1.7v 429.495n 1.7v 429.505n 1.7v 439.495n 1.7v 439.505n 1.7v 449.495n 1.7v 449.505n 1.7v 459.495n 1.7v 459.505n 0.0v 469.495n 0.0v 469.505n 0.0v 479.495n 0.0v 479.505n 0.0v 489.495n 0.0v 489.505n 0.0v 499.495n 0.0v 499.505n 1.7v 509.495n 1.7v 509.505n 1.7v 519.495n 1.7v 519.505n 1.7v 529.495n 1.7v 529.505n 1.7v 539.495n 1.7v 539.505n 1.7v 549.495n 1.7v 549.505n 1.7v 559.495n 1.7v 559.505n 1.7v 569.495n 1.7v 569.505n 0.0v 579.495n 0.0v 579.505n 0.0v 589.495n 0.0v 589.505n 0.0v 599.495n 0.0v 599.505n 0.0v 609.495n 0.0v 609.505n 0.0v 619.495n 0.0v 619.505n 0.0v 629.495n 0.0v 629.505n 0.0v 639.495n 0.0v 639.505n 0.0v 649.495n 0.0v 649.505n 0.0v 659.495n 0.0v 659.505n 0.0v 669.495n 0.0v 669.505n 1.7v 679.495n 1.7v 679.505n 0.0v 689.495n 0.0v 689.505n 0.0v 699.495n 0.0v 699.505n 1.7v 709.495n 1.7v 709.505n 1.7v 719.495n 1.7v 719.505n 1.7v 729.495n 1.7v 729.505n 1.7v 739.495n 1.7v 739.505n 1.7v 749.495n 1.7v 749.505n 0.0v 759.495n 0.0v 759.505n 0.0v 769.495n 0.0v 769.505n 0.0v 779.495n 0.0v 779.505n 0.0v 789.495n 0.0v 789.505n 0.0v 799.495n 0.0v 799.505n 0.0v 809.495n 0.0v 809.505n 0.0v 819.495n 0.0v 819.505n 0.0v 829.495n 0.0v 829.505n 1.7v 839.495n 1.7v 839.505n 1.7v 849.495n 1.7v 849.505n 1.7v 859.495n 1.7v 859.505n 0.0v 869.495n 0.0v 869.505n 0.0v 879.495n 0.0v 879.505n 0.0v 889.495n 0.0v 889.505n 0.0v 899.495n 0.0v 899.505n 1.7v 909.495n 1.7v 909.505n 0.0v 919.495n 0.0v 919.505n 0.0v 929.495n 0.0v 929.505n 1.7v 939.495n 1.7v 939.505n 0.0v 949.495n 0.0v 949.505n 0.0v 959.495n 0.0v 959.505n 0.0v 969.495n 0.0v 969.505n 0.0v 979.495n 0.0v 979.505n 1.7v 989.495n 1.7v 989.505n 0.0v 999.495n 0.0v 999.505n 1.7v 1009.495n 1.7v 1009.505n 1.7v 1019.495n 1.7v 1019.505n 1.7v 1029.495n 1.7v 1029.505n 0.0v 1039.495n 0.0v 1039.505n 0.0v 1049.495n 0.0v 1049.505n 1.7v 1059.495n 1.7v 1059.505n 1.7v 1069.495n 1.7v 1069.505n 1.7v 1079.495n 1.7v 1079.505n 1.7v 1089.495n 1.7v 1089.505n 1.7v 1099.495n 1.7v 1099.505n 1.7v 1109.495n 1.7v 1109.505n 1.7v 1119.495n 1.7v 1119.505n 1.7v 1129.495n 1.7v 1129.505n 1.7v 1139.495n 1.7v 1139.505n 1.7v 1149.495n 1.7v 1149.505n 1.7v 1159.495n 1.7v 1159.505n 0.0v 1169.495n 0.0v 1169.505n 1.7v 1179.495n 1.7v 1179.505n 0.0v 1189.495n 0.0v 1189.505n 0.0v 1199.495n 0.0v 1199.505n 0.0v 1209.495n 0.0v 1209.505n 0.0v 1219.495n 0.0v 1219.505n 0.0v 1229.495n 0.0v 1229.505n 0.0v 1239.495n 0.0v 1239.505n 1.7v 1249.495n 1.7v 1249.505n 0.0v 1259.495n 0.0v 1259.505n 1.7v 1269.495n 1.7v 1269.505n 1.7v 1279.495n 1.7v 1279.505n 0.0v 1289.495n 0.0v 1289.505n 0.0v 1299.495n 0.0v 1299.505n 0.0v 1309.495n 0.0v 1309.505n 0.0v 1319.495n 0.0v 1319.505n 0.0v 1329.495n 0.0v 1329.505n 0.0v 1339.495n 0.0v 1339.505n 1.7v 1349.495n 1.7v 1349.505n 1.7v 1359.495n 1.7v 1359.505n 1.7v 1369.495n 1.7v 1369.505n 1.7v 1379.495n 1.7v 1379.505n 1.7v 1389.495n 1.7v 1389.505n 1.7v 1399.495n 1.7v 1399.505n 0.0v 1409.495n 0.0v 1409.505n 0.0v 1419.495n 0.0v 1419.505n 0.0v 1429.495n 0.0v 1429.505n 0.0v 1439.495n 0.0v 1439.505n 1.7v 1449.495n 1.7v 1449.505n 1.7v 1459.495n 1.7v 1459.505n 1.7v 1469.495n 1.7v 1469.505n 1.7v 1479.495n 1.7v 1479.505n 0.0v 1489.495n 0.0v 1489.505n 0.0v 1499.495n 0.0v 1499.505n 0.0v 1509.495n 0.0v 1509.505n 1.7v 1519.495n 1.7v 1519.505n 1.7v 1529.495n 1.7v 1529.505n 1.7v 1539.495n 1.7v 1539.505n 1.7v 1549.495n 1.7v 1549.505n 1.7v 1559.495n 1.7v 1559.505n 1.7v 1569.495n 1.7v 1569.505n 1.7v 1579.495n 1.7v 1579.505n 0.0v 1589.495n 0.0v 1589.505n 0.0v 1599.495n 0.0v 1599.505n 0.0v 1609.495n 0.0v 1609.505n 0.0v 1619.495n 0.0v 1619.505n 0.0v 1629.495n 0.0v 1629.505n 0.0v 1639.495n 0.0v 1639.505n 0.0v 1649.495n 0.0v 1649.505n 0.0v 1659.495n 0.0v 1659.505n 1.7v 1669.495n 1.7v 1669.505n 1.7v 1679.495n 1.7v 1679.505n 1.7v 1689.495n 1.7v 1689.505n 1.7v 1699.495n 1.7v 1699.505n 0.0v 1709.495n 0.0v 1709.505n 1.7v 1719.495n 1.7v 1719.505n 1.7v 1729.495n 1.7v 1729.505n 1.7v 1739.495n 1.7v 1739.505n 0.0v 1749.495n 0.0v 1749.505n 1.7v 1759.495n 1.7v 1759.505n 0.0v 1769.495n 0.0v 1769.505n 1.7v 1779.495n 1.7v 1779.505n 0.0v 1789.495n 0.0v 1789.505n 1.7v 1799.495n 1.7v 1799.505n 1.7v 1809.495n 1.7v 1809.505n 1.7v 1819.495n 1.7v 1819.505n 1.7v 1829.495n 1.7v 1829.505n 1.7v 1839.495n 1.7v 1839.505n 1.7v 1849.495n 1.7v 1849.505n 1.7v 1859.495n 1.7v 1859.505n 1.7v 1869.495n 1.7v 1869.505n 0.0v 1879.495n 0.0v 1879.505n 0.0v 1889.495n 0.0v 1889.505n 0.0v 1899.495n 0.0v 1899.505n 0.0v 1909.495n 0.0v 1909.505n 1.7v 1919.495n 1.7v 1919.505n 1.7v 1929.495n 1.7v 1929.505n 0.0v 1939.495n 0.0v 1939.505n 0.0v 1949.495n 0.0v 1949.505n 0.0v 1959.495n 0.0v 1959.505n 0.0v 1969.495n 0.0v 1969.505n 0.0v 1979.495n 0.0v 1979.505n 0.0v 1989.495n 0.0v 1989.505n 1.7v 1999.495n 1.7v 1999.505n 1.7v 2009.495n 1.7v 2009.505n 1.7v 2019.495n 1.7v 2019.505n 1.7v 2029.495n 1.7v 2029.505n 1.7v 2039.495n 1.7v 2039.505n 1.7v 2049.495n 1.7v 2049.505n 1.7v )
* (time, data): [(0, 0), (10, 1), (20, 0), (30, 1), (40, 1), (50, 1), (60, 1), (70, 0), (80, 1), (90, 1), (100, 1), (110, 1), (120, 0), (130, 1), (140, 1), (150, 0), (160, 1), (170, 1), (180, 0), (190, 1), (200, 0), (210, 0), (220, 1), (230, 0), (240, 0), (250, 0), (260, 0), (270, 0), (280, 0), (290, 0), (300, 0), (310, 0), (320, 1), (330, 1), (340, 1), (350, 1), (360, 1), (370, 0), (380, 1), (390, 0), (400, 1), (410, 1), (420, 1), (430, 1), (440, 1), (450, 1), (460, 1), (470, 1), (480, 1), (490, 1), (500, 0), (510, 1), (520, 1), (530, 1), (540, 1), (550, 1), (560, 1), (570, 1), (580, 1), (590, 1), (600, 1), (610, 1), (620, 1), (630, 0), (640, 0), (650, 0), (660, 0), (670, 0), (680, 1), (690, 0), (700, 1), (710, 1), (720, 0), (730, 0), (740, 0), (750, 1), (760, 0), (770, 1), (780, 1), (790, 1), (800, 1), (810, 1), (820, 0), (830, 0), (840, 0), (850, 0), (860, 1), (870, 1), (880, 1), (890, 1), (900, 0), (910, 1), (920, 1), (930, 1), (940, 0), (950, 1), (960, 1), (970, 1), (980, 0), (990, 1), (1000, 1), (1010, 1), (1020, 1), (1030, 1), (1040, 1), (1050, 0), (1060, 1), (1070, 1), (1080, 0), (1090, 0), (1100, 1), (1110, 1), (1120, 1), (1130, 1), (1140, 1), (1150, 1), (1160, 0), (1170, 0), (1180, 1), (1190, 1), (1200, 1), (1210, 1), (1220, 1), (1230, 1), (1240, 1), (1250, 1), (1260, 0), (1270, 0), (1280, 0), (1290, 0), (1300, 0), (1310, 0), (1320, 0), (1330, 0), (1340, 0), (1350, 0), (1360, 0), (1370, 0), (1380, 0), (1390, 0), (1400, 0), (1410, 0), (1420, 0), (1430, 0), (1440, 1), (1450, 1), (1460, 1), (1470, 1), (1480, 1), (1490, 1), (1500, 1), (1510, 1), (1520, 0), (1530, 0), (1540, 0), (1550, 0), (1560, 0), (1570, 0), (1580, 1), (1590, 1), (1600, 1), (1610, 1), (1620, 1), (1630, 1), (1640, 1), (1650, 1), (1660, 0), (1670, 0), (1680, 0), (1690, 0), (1700, 1), (1710, 0), (1720, 0), (1730, 0), (1740, 0), (1750, 0), (1760, 1), (1770, 0), (1780, 1), (1790, 1), (1800, 0), (1810, 0), (1820, 1), (1830, 1), (1840, 1), (1850, 1), (1860, 1), (1870, 0), (1880, 0), (1890, 0), (1900, 0), (1910, 1), (1920, 1), (1930, 0), (1940, 0), (1950, 0), (1960, 1), (1970, 0), (1980, 0), (1990, 0), (2000, 0), (2010, 0), (2020, 0), (2030, 0), (2040, 1), (2050, 1)]
Vdin0_15  din0_15  0 PWL (0n 0.0v 9.495n 0.0v 9.505n 1.7v 19.495n 1.7v 19.505n 0.0v 29.495n 0.0v 29.505n 1.7v 39.495n 1.7v 39.505n 1.7v 49.495n 1.7v 49.505n 1.7v 59.495n 1.7v 59.505n 1.7v 69.495n 1.7v 69.505n 0.0v 79.495n 0.0v 79.505n 1.7v 89.495n 1.7v 89.505n 1.7v 99.495n 1.7v 99.505n 1.7v 109.495n 1.7v 109.505n 1.7v 119.495n 1.7v 119.505n 0.0v 129.495n 0.0v 129.505n 1.7v 139.495n 1.7v 139.505n 1.7v 149.495n 1.7v 149.505n 0.0v 159.495n 0.0v 159.505n 1.7v 169.495n 1.7v 169.505n 1.7v 179.495n 1.7v 179.505n 0.0v 189.495n 0.0v 189.505n 1.7v 199.495n 1.7v 199.505n 0.0v 209.495n 0.0v 209.505n 0.0v 219.495n 0.0v 219.505n 1.7v 229.495n 1.7v 229.505n 0.0v 239.495n 0.0v 239.505n 0.0v 249.495n 0.0v 249.505n 0.0v 259.495n 0.0v 259.505n 0.0v 269.495n 0.0v 269.505n 0.0v 279.495n 0.0v 279.505n 0.0v 289.495n 0.0v 289.505n 0.0v 299.495n 0.0v 299.505n 0.0v 309.495n 0.0v 309.505n 0.0v 319.495n 0.0v 319.505n 1.7v 329.495n 1.7v 329.505n 1.7v 339.495n 1.7v 339.505n 1.7v 349.495n 1.7v 349.505n 1.7v 359.495n 1.7v 359.505n 1.7v 369.495n 1.7v 369.505n 0.0v 379.495n 0.0v 379.505n 1.7v 389.495n 1.7v 389.505n 0.0v 399.495n 0.0v 399.505n 1.7v 409.495n 1.7v 409.505n 1.7v 419.495n 1.7v 419.505n 1.7v 429.495n 1.7v 429.505n 1.7v 439.495n 1.7v 439.505n 1.7v 449.495n 1.7v 449.505n 1.7v 459.495n 1.7v 459.505n 1.7v 469.495n 1.7v 469.505n 1.7v 479.495n 1.7v 479.505n 1.7v 489.495n 1.7v 489.505n 1.7v 499.495n 1.7v 499.505n 0.0v 509.495n 0.0v 509.505n 1.7v 519.495n 1.7v 519.505n 1.7v 529.495n 1.7v 529.505n 1.7v 539.495n 1.7v 539.505n 1.7v 549.495n 1.7v 549.505n 1.7v 559.495n 1.7v 559.505n 1.7v 569.495n 1.7v 569.505n 1.7v 579.495n 1.7v 579.505n 1.7v 589.495n 1.7v 589.505n 1.7v 599.495n 1.7v 599.505n 1.7v 609.495n 1.7v 609.505n 1.7v 619.495n 1.7v 619.505n 1.7v 629.495n 1.7v 629.505n 0.0v 639.495n 0.0v 639.505n 0.0v 649.495n 0.0v 649.505n 0.0v 659.495n 0.0v 659.505n 0.0v 669.495n 0.0v 669.505n 0.0v 679.495n 0.0v 679.505n 1.7v 689.495n 1.7v 689.505n 0.0v 699.495n 0.0v 699.505n 1.7v 709.495n 1.7v 709.505n 1.7v 719.495n 1.7v 719.505n 0.0v 729.495n 0.0v 729.505n 0.0v 739.495n 0.0v 739.505n 0.0v 749.495n 0.0v 749.505n 1.7v 759.495n 1.7v 759.505n 0.0v 769.495n 0.0v 769.505n 1.7v 779.495n 1.7v 779.505n 1.7v 789.495n 1.7v 789.505n 1.7v 799.495n 1.7v 799.505n 1.7v 809.495n 1.7v 809.505n 1.7v 819.495n 1.7v 819.505n 0.0v 829.495n 0.0v 829.505n 0.0v 839.495n 0.0v 839.505n 0.0v 849.495n 0.0v 849.505n 0.0v 859.495n 0.0v 859.505n 1.7v 869.495n 1.7v 869.505n 1.7v 879.495n 1.7v 879.505n 1.7v 889.495n 1.7v 889.505n 1.7v 899.495n 1.7v 899.505n 0.0v 909.495n 0.0v 909.505n 1.7v 919.495n 1.7v 919.505n 1.7v 929.495n 1.7v 929.505n 1.7v 939.495n 1.7v 939.505n 0.0v 949.495n 0.0v 949.505n 1.7v 959.495n 1.7v 959.505n 1.7v 969.495n 1.7v 969.505n 1.7v 979.495n 1.7v 979.505n 0.0v 989.495n 0.0v 989.505n 1.7v 999.495n 1.7v 999.505n 1.7v 1009.495n 1.7v 1009.505n 1.7v 1019.495n 1.7v 1019.505n 1.7v 1029.495n 1.7v 1029.505n 1.7v 1039.495n 1.7v 1039.505n 1.7v 1049.495n 1.7v 1049.505n 0.0v 1059.495n 0.0v 1059.505n 1.7v 1069.495n 1.7v 1069.505n 1.7v 1079.495n 1.7v 1079.505n 0.0v 1089.495n 0.0v 1089.505n 0.0v 1099.495n 0.0v 1099.505n 1.7v 1109.495n 1.7v 1109.505n 1.7v 1119.495n 1.7v 1119.505n 1.7v 1129.495n 1.7v 1129.505n 1.7v 1139.495n 1.7v 1139.505n 1.7v 1149.495n 1.7v 1149.505n 1.7v 1159.495n 1.7v 1159.505n 0.0v 1169.495n 0.0v 1169.505n 0.0v 1179.495n 0.0v 1179.505n 1.7v 1189.495n 1.7v 1189.505n 1.7v 1199.495n 1.7v 1199.505n 1.7v 1209.495n 1.7v 1209.505n 1.7v 1219.495n 1.7v 1219.505n 1.7v 1229.495n 1.7v 1229.505n 1.7v 1239.495n 1.7v 1239.505n 1.7v 1249.495n 1.7v 1249.505n 1.7v 1259.495n 1.7v 1259.505n 0.0v 1269.495n 0.0v 1269.505n 0.0v 1279.495n 0.0v 1279.505n 0.0v 1289.495n 0.0v 1289.505n 0.0v 1299.495n 0.0v 1299.505n 0.0v 1309.495n 0.0v 1309.505n 0.0v 1319.495n 0.0v 1319.505n 0.0v 1329.495n 0.0v 1329.505n 0.0v 1339.495n 0.0v 1339.505n 0.0v 1349.495n 0.0v 1349.505n 0.0v 1359.495n 0.0v 1359.505n 0.0v 1369.495n 0.0v 1369.505n 0.0v 1379.495n 0.0v 1379.505n 0.0v 1389.495n 0.0v 1389.505n 0.0v 1399.495n 0.0v 1399.505n 0.0v 1409.495n 0.0v 1409.505n 0.0v 1419.495n 0.0v 1419.505n 0.0v 1429.495n 0.0v 1429.505n 0.0v 1439.495n 0.0v 1439.505n 1.7v 1449.495n 1.7v 1449.505n 1.7v 1459.495n 1.7v 1459.505n 1.7v 1469.495n 1.7v 1469.505n 1.7v 1479.495n 1.7v 1479.505n 1.7v 1489.495n 1.7v 1489.505n 1.7v 1499.495n 1.7v 1499.505n 1.7v 1509.495n 1.7v 1509.505n 1.7v 1519.495n 1.7v 1519.505n 0.0v 1529.495n 0.0v 1529.505n 0.0v 1539.495n 0.0v 1539.505n 0.0v 1549.495n 0.0v 1549.505n 0.0v 1559.495n 0.0v 1559.505n 0.0v 1569.495n 0.0v 1569.505n 0.0v 1579.495n 0.0v 1579.505n 1.7v 1589.495n 1.7v 1589.505n 1.7v 1599.495n 1.7v 1599.505n 1.7v 1609.495n 1.7v 1609.505n 1.7v 1619.495n 1.7v 1619.505n 1.7v 1629.495n 1.7v 1629.505n 1.7v 1639.495n 1.7v 1639.505n 1.7v 1649.495n 1.7v 1649.505n 1.7v 1659.495n 1.7v 1659.505n 0.0v 1669.495n 0.0v 1669.505n 0.0v 1679.495n 0.0v 1679.505n 0.0v 1689.495n 0.0v 1689.505n 0.0v 1699.495n 0.0v 1699.505n 1.7v 1709.495n 1.7v 1709.505n 0.0v 1719.495n 0.0v 1719.505n 0.0v 1729.495n 0.0v 1729.505n 0.0v 1739.495n 0.0v 1739.505n 0.0v 1749.495n 0.0v 1749.505n 0.0v 1759.495n 0.0v 1759.505n 1.7v 1769.495n 1.7v 1769.505n 0.0v 1779.495n 0.0v 1779.505n 1.7v 1789.495n 1.7v 1789.505n 1.7v 1799.495n 1.7v 1799.505n 0.0v 1809.495n 0.0v 1809.505n 0.0v 1819.495n 0.0v 1819.505n 1.7v 1829.495n 1.7v 1829.505n 1.7v 1839.495n 1.7v 1839.505n 1.7v 1849.495n 1.7v 1849.505n 1.7v 1859.495n 1.7v 1859.505n 1.7v 1869.495n 1.7v 1869.505n 0.0v 1879.495n 0.0v 1879.505n 0.0v 1889.495n 0.0v 1889.505n 0.0v 1899.495n 0.0v 1899.505n 0.0v 1909.495n 0.0v 1909.505n 1.7v 1919.495n 1.7v 1919.505n 1.7v 1929.495n 1.7v 1929.505n 0.0v 1939.495n 0.0v 1939.505n 0.0v 1949.495n 0.0v 1949.505n 0.0v 1959.495n 0.0v 1959.505n 1.7v 1969.495n 1.7v 1969.505n 0.0v 1979.495n 0.0v 1979.505n 0.0v 1989.495n 0.0v 1989.505n 0.0v 1999.495n 0.0v 1999.505n 0.0v 2009.495n 0.0v 2009.505n 0.0v 2019.495n 0.0v 2019.505n 0.0v 2029.495n 0.0v 2029.505n 0.0v 2039.495n 0.0v 2039.505n 1.7v 2049.495n 1.7v 2049.505n 1.7v )
* (time, data): [(0, 0), (10, 0), (20, 0), (30, 0), (40, 0), (50, 0), (60, 0), (70, 0), (80, 0), (90, 0), (100, 0), (110, 0), (120, 0), (130, 0), (140, 0), (150, 0), (160, 0), (170, 0), (180, 0), (190, 0), (200, 0), (210, 0), (220, 0), (230, 0), (240, 0), (250, 0), (260, 0), (270, 0), (280, 0), (290, 0), (300, 0), (310, 0), (320, 0), (330, 0), (340, 0), (350, 0), (360, 0), (370, 0), (380, 0), (390, 0), (400, 0), (410, 0), (420, 0), (430, 0), (440, 0), (450, 0), (460, 0), (470, 0), (480, 0), (490, 0), (500, 0), (510, 0), (520, 0), (530, 0), (540, 0), (550, 0), (560, 0), (570, 0), (580, 0), (590, 0), (600, 0), (610, 0), (620, 0), (630, 0), (640, 0), (650, 0), (660, 0), (670, 0), (680, 0), (690, 0), (700, 0), (710, 0), (720, 0), (730, 0), (740, 0), (750, 0), (760, 0), (770, 0), (780, 0), (790, 0), (800, 0), (810, 0), (820, 0), (830, 0), (840, 0), (850, 0), (860, 0), (870, 0), (880, 0), (890, 0), (900, 0), (910, 0), (920, 0), (930, 0), (940, 0), (950, 0), (960, 0), (970, 0), (980, 0), (990, 0), (1000, 0), (1010, 0), (1020, 0), (1030, 0), (1040, 0), (1050, 0), (1060, 0), (1070, 0), (1080, 0), (1090, 0), (1100, 0), (1110, 0), (1120, 0), (1130, 0), (1140, 0), (1150, 0), (1160, 0), (1170, 0), (1180, 0), (1190, 0), (1200, 0), (1210, 0), (1220, 0), (1230, 0), (1240, 0), (1250, 0), (1260, 0), (1270, 0), (1280, 0), (1290, 0), (1300, 0), (1310, 0), (1320, 0), (1330, 0), (1340, 0), (1350, 0), (1360, 0), (1370, 0), (1380, 0), (1390, 0), (1400, 0), (1410, 0), (1420, 0), (1430, 0), (1440, 0), (1450, 0), (1460, 0), (1470, 0), (1480, 0), (1490, 0), (1500, 0), (1510, 0), (1520, 0), (1530, 0), (1540, 0), (1550, 0), (1560, 0), (1570, 0), (1580, 0), (1590, 0), (1600, 0), (1610, 0), (1620, 0), (1630, 0), (1640, 0), (1650, 0), (1660, 0), (1670, 0), (1680, 0), (1690, 0), (1700, 0), (1710, 0), (1720, 0), (1730, 0), (1740, 0), (1750, 0), (1760, 0), (1770, 0), (1780, 0), (1790, 0), (1800, 0), (1810, 0), (1820, 0), (1830, 0), (1840, 0), (1850, 0), (1860, 0), (1870, 0), (1880, 0), (1890, 0), (1900, 0), (1910, 0), (1920, 0), (1930, 0), (1940, 0), (1950, 0), (1960, 0), (1970, 0), (1980, 0), (1990, 0), (2000, 0), (2010, 0), (2020, 0), (2030, 0), (2040, 0), (2050, 0)]
Vdin0_16  din0_16  0 PWL (0n 0.0v 9.495n 0.0v 9.505n 0.0v 19.495n 0.0v 19.505n 0.0v 29.495n 0.0v 29.505n 0.0v 39.495n 0.0v 39.505n 0.0v 49.495n 0.0v 49.505n 0.0v 59.495n 0.0v 59.505n 0.0v 69.495n 0.0v 69.505n 0.0v 79.495n 0.0v 79.505n 0.0v 89.495n 0.0v 89.505n 0.0v 99.495n 0.0v 99.505n 0.0v 109.495n 0.0v 109.505n 0.0v 119.495n 0.0v 119.505n 0.0v 129.495n 0.0v 129.505n 0.0v 139.495n 0.0v 139.505n 0.0v 149.495n 0.0v 149.505n 0.0v 159.495n 0.0v 159.505n 0.0v 169.495n 0.0v 169.505n 0.0v 179.495n 0.0v 179.505n 0.0v 189.495n 0.0v 189.505n 0.0v 199.495n 0.0v 199.505n 0.0v 209.495n 0.0v 209.505n 0.0v 219.495n 0.0v 219.505n 0.0v 229.495n 0.0v 229.505n 0.0v 239.495n 0.0v 239.505n 0.0v 249.495n 0.0v 249.505n 0.0v 259.495n 0.0v 259.505n 0.0v 269.495n 0.0v 269.505n 0.0v 279.495n 0.0v 279.505n 0.0v 289.495n 0.0v 289.505n 0.0v 299.495n 0.0v 299.505n 0.0v 309.495n 0.0v 309.505n 0.0v 319.495n 0.0v 319.505n 0.0v 329.495n 0.0v 329.505n 0.0v 339.495n 0.0v 339.505n 0.0v 349.495n 0.0v 349.505n 0.0v 359.495n 0.0v 359.505n 0.0v 369.495n 0.0v 369.505n 0.0v 379.495n 0.0v 379.505n 0.0v 389.495n 0.0v 389.505n 0.0v 399.495n 0.0v 399.505n 0.0v 409.495n 0.0v 409.505n 0.0v 419.495n 0.0v 419.505n 0.0v 429.495n 0.0v 429.505n 0.0v 439.495n 0.0v 439.505n 0.0v 449.495n 0.0v 449.505n 0.0v 459.495n 0.0v 459.505n 0.0v 469.495n 0.0v 469.505n 0.0v 479.495n 0.0v 479.505n 0.0v 489.495n 0.0v 489.505n 0.0v 499.495n 0.0v 499.505n 0.0v 509.495n 0.0v 509.505n 0.0v 519.495n 0.0v 519.505n 0.0v 529.495n 0.0v 529.505n 0.0v 539.495n 0.0v 539.505n 0.0v 549.495n 0.0v 549.505n 0.0v 559.495n 0.0v 559.505n 0.0v 569.495n 0.0v 569.505n 0.0v 579.495n 0.0v 579.505n 0.0v 589.495n 0.0v 589.505n 0.0v 599.495n 0.0v 599.505n 0.0v 609.495n 0.0v 609.505n 0.0v 619.495n 0.0v 619.505n 0.0v 629.495n 0.0v 629.505n 0.0v 639.495n 0.0v 639.505n 0.0v 649.495n 0.0v 649.505n 0.0v 659.495n 0.0v 659.505n 0.0v 669.495n 0.0v 669.505n 0.0v 679.495n 0.0v 679.505n 0.0v 689.495n 0.0v 689.505n 0.0v 699.495n 0.0v 699.505n 0.0v 709.495n 0.0v 709.505n 0.0v 719.495n 0.0v 719.505n 0.0v 729.495n 0.0v 729.505n 0.0v 739.495n 0.0v 739.505n 0.0v 749.495n 0.0v 749.505n 0.0v 759.495n 0.0v 759.505n 0.0v 769.495n 0.0v 769.505n 0.0v 779.495n 0.0v 779.505n 0.0v 789.495n 0.0v 789.505n 0.0v 799.495n 0.0v 799.505n 0.0v 809.495n 0.0v 809.505n 0.0v 819.495n 0.0v 819.505n 0.0v 829.495n 0.0v 829.505n 0.0v 839.495n 0.0v 839.505n 0.0v 849.495n 0.0v 849.505n 0.0v 859.495n 0.0v 859.505n 0.0v 869.495n 0.0v 869.505n 0.0v 879.495n 0.0v 879.505n 0.0v 889.495n 0.0v 889.505n 0.0v 899.495n 0.0v 899.505n 0.0v 909.495n 0.0v 909.505n 0.0v 919.495n 0.0v 919.505n 0.0v 929.495n 0.0v 929.505n 0.0v 939.495n 0.0v 939.505n 0.0v 949.495n 0.0v 949.505n 0.0v 959.495n 0.0v 959.505n 0.0v 969.495n 0.0v 969.505n 0.0v 979.495n 0.0v 979.505n 0.0v 989.495n 0.0v 989.505n 0.0v 999.495n 0.0v 999.505n 0.0v 1009.495n 0.0v 1009.505n 0.0v 1019.495n 0.0v 1019.505n 0.0v 1029.495n 0.0v 1029.505n 0.0v 1039.495n 0.0v 1039.505n 0.0v 1049.495n 0.0v 1049.505n 0.0v 1059.495n 0.0v 1059.505n 0.0v 1069.495n 0.0v 1069.505n 0.0v 1079.495n 0.0v 1079.505n 0.0v 1089.495n 0.0v 1089.505n 0.0v 1099.495n 0.0v 1099.505n 0.0v 1109.495n 0.0v 1109.505n 0.0v 1119.495n 0.0v 1119.505n 0.0v 1129.495n 0.0v 1129.505n 0.0v 1139.495n 0.0v 1139.505n 0.0v 1149.495n 0.0v 1149.505n 0.0v 1159.495n 0.0v 1159.505n 0.0v 1169.495n 0.0v 1169.505n 0.0v 1179.495n 0.0v 1179.505n 0.0v 1189.495n 0.0v 1189.505n 0.0v 1199.495n 0.0v 1199.505n 0.0v 1209.495n 0.0v 1209.505n 0.0v 1219.495n 0.0v 1219.505n 0.0v 1229.495n 0.0v 1229.505n 0.0v 1239.495n 0.0v 1239.505n 0.0v 1249.495n 0.0v 1249.505n 0.0v 1259.495n 0.0v 1259.505n 0.0v 1269.495n 0.0v 1269.505n 0.0v 1279.495n 0.0v 1279.505n 0.0v 1289.495n 0.0v 1289.505n 0.0v 1299.495n 0.0v 1299.505n 0.0v 1309.495n 0.0v 1309.505n 0.0v 1319.495n 0.0v 1319.505n 0.0v 1329.495n 0.0v 1329.505n 0.0v 1339.495n 0.0v 1339.505n 0.0v 1349.495n 0.0v 1349.505n 0.0v 1359.495n 0.0v 1359.505n 0.0v 1369.495n 0.0v 1369.505n 0.0v 1379.495n 0.0v 1379.505n 0.0v 1389.495n 0.0v 1389.505n 0.0v 1399.495n 0.0v 1399.505n 0.0v 1409.495n 0.0v 1409.505n 0.0v 1419.495n 0.0v 1419.505n 0.0v 1429.495n 0.0v 1429.505n 0.0v 1439.495n 0.0v 1439.505n 0.0v 1449.495n 0.0v 1449.505n 0.0v 1459.495n 0.0v 1459.505n 0.0v 1469.495n 0.0v 1469.505n 0.0v 1479.495n 0.0v 1479.505n 0.0v 1489.495n 0.0v 1489.505n 0.0v 1499.495n 0.0v 1499.505n 0.0v 1509.495n 0.0v 1509.505n 0.0v 1519.495n 0.0v 1519.505n 0.0v 1529.495n 0.0v 1529.505n 0.0v 1539.495n 0.0v 1539.505n 0.0v 1549.495n 0.0v 1549.505n 0.0v 1559.495n 0.0v 1559.505n 0.0v 1569.495n 0.0v 1569.505n 0.0v 1579.495n 0.0v 1579.505n 0.0v 1589.495n 0.0v 1589.505n 0.0v 1599.495n 0.0v 1599.505n 0.0v 1609.495n 0.0v 1609.505n 0.0v 1619.495n 0.0v 1619.505n 0.0v 1629.495n 0.0v 1629.505n 0.0v 1639.495n 0.0v 1639.505n 0.0v 1649.495n 0.0v 1649.505n 0.0v 1659.495n 0.0v 1659.505n 0.0v 1669.495n 0.0v 1669.505n 0.0v 1679.495n 0.0v 1679.505n 0.0v 1689.495n 0.0v 1689.505n 0.0v 1699.495n 0.0v 1699.505n 0.0v 1709.495n 0.0v 1709.505n 0.0v 1719.495n 0.0v 1719.505n 0.0v 1729.495n 0.0v 1729.505n 0.0v 1739.495n 0.0v 1739.505n 0.0v 1749.495n 0.0v 1749.505n 0.0v 1759.495n 0.0v 1759.505n 0.0v 1769.495n 0.0v 1769.505n 0.0v 1779.495n 0.0v 1779.505n 0.0v 1789.495n 0.0v 1789.505n 0.0v 1799.495n 0.0v 1799.505n 0.0v 1809.495n 0.0v 1809.505n 0.0v 1819.495n 0.0v 1819.505n 0.0v 1829.495n 0.0v 1829.505n 0.0v 1839.495n 0.0v 1839.505n 0.0v 1849.495n 0.0v 1849.505n 0.0v 1859.495n 0.0v 1859.505n 0.0v 1869.495n 0.0v 1869.505n 0.0v 1879.495n 0.0v 1879.505n 0.0v 1889.495n 0.0v 1889.505n 0.0v 1899.495n 0.0v 1899.505n 0.0v 1909.495n 0.0v 1909.505n 0.0v 1919.495n 0.0v 1919.505n 0.0v 1929.495n 0.0v 1929.505n 0.0v 1939.495n 0.0v 1939.505n 0.0v 1949.495n 0.0v 1949.505n 0.0v 1959.495n 0.0v 1959.505n 0.0v 1969.495n 0.0v 1969.505n 0.0v 1979.495n 0.0v 1979.505n 0.0v 1989.495n 0.0v 1989.505n 0.0v 1999.495n 0.0v 1999.505n 0.0v 2009.495n 0.0v 2009.505n 0.0v 2019.495n 0.0v 2019.505n 0.0v 2029.495n 0.0v 2029.505n 0.0v 2039.495n 0.0v 2039.505n 0.0v 2049.495n 0.0v 2049.505n 0.0v )
* (time, data): [(0, 0), (10, 0), (20, 1), (30, 0), (40, 0), (50, 0), (60, 0), (70, 0), (80, 0), (90, 0), (100, 0), (110, 0), (120, 0), (130, 0), (140, 0), (150, 1), (160, 0), (170, 0), (180, 1), (190, 1), (200, 1), (210, 1), (220, 1), (230, 0), (240, 0), (250, 0), (260, 0), (270, 0), (280, 0), (290, 1), (300, 1), (310, 1), (320, 0), (330, 0), (340, 0), (350, 0), (360, 0), (370, 1), (380, 1), (390, 0), (400, 1), (410, 1), (420, 1), (430, 1), (440, 1), (450, 1), (460, 1), (470, 1), (480, 0), (490, 1), (500, 1), (510, 0), (520, 0), (530, 0), (540, 0), (550, 0), (560, 0), (570, 1), (580, 1), (590, 1), (600, 1), (610, 1), (620, 0), (630, 1), (640, 1), (650, 1), (660, 1), (670, 0), (680, 1), (690, 1), (700, 1), (710, 1), (720, 1), (730, 1), (740, 1), (750, 1), (760, 1), (770, 1), (780, 1), (790, 0), (800, 1), (810, 1), (820, 0), (830, 0), (840, 0), (850, 0), (860, 1), (870, 1), (880, 1), (890, 1), (900, 1), (910, 0), (920, 1), (930, 1), (940, 1), (950, 0), (960, 0), (970, 0), (980, 1), (990, 0), (1000, 0), (1010, 0), (1020, 0), (1030, 0), (1040, 1), (1050, 1), (1060, 1), (1070, 1), (1080, 1), (1090, 1), (1100, 0), (1110, 0), (1120, 0), (1130, 0), (1140, 0), (1150, 0), (1160, 1), (1170, 1), (1180, 0), (1190, 0), (1200, 0), (1210, 0), (1220, 0), (1230, 1), (1240, 1), (1250, 1), (1260, 1), (1270, 1), (1280, 1), (1290, 1), (1300, 1), (1310, 1), (1320, 1), (1330, 1), (1340, 1), (1350, 1), (1360, 1), (1370, 1), (1380, 1), (1390, 1), (1400, 0), (1410, 0), (1420, 0), (1430, 0), (1440, 0), (1450, 0), (1460, 0), (1470, 0), (1480, 0), (1490, 0), (1500, 0), (1510, 1), (1520, 1), (1530, 1), (1540, 0), (1550, 0), (1560, 0), (1570, 1), (1580, 0), (1590, 0), (1600, 0), (1610, 0), (1620, 0), (1630, 1), (1640, 1), (1650, 0), (1660, 1), (1670, 1), (1680, 1), (1690, 1), (1700, 0), (1710, 1), (1720, 1), (1730, 1), (1740, 0), (1750, 0), (1760, 1), (1770, 0), (1780, 1), (1790, 1), (1800, 0), (1810, 0), (1820, 1), (1830, 1), (1840, 1), (1850, 1), (1860, 1), (1870, 1), (1880, 1), (1890, 1), (1900, 0), (1910, 1), (1920, 0), (1930, 1), (1940, 1), (1950, 0), (1960, 1), (1970, 0), (1980, 0), (1990, 1), (2000, 1), (2010, 1), (2020, 1), (2030, 1), (2040, 1), (2050, 1)]
Va0_0  a0_0  0 PWL (0n 0.0v 9.495n 0.0v 9.505n 0.0v 19.495n 0.0v 19.505n 1.7v 29.495n 1.7v 29.505n 0.0v 39.495n 0.0v 39.505n 0.0v 49.495n 0.0v 49.505n 0.0v 59.495n 0.0v 59.505n 0.0v 69.495n 0.0v 69.505n 0.0v 79.495n 0.0v 79.505n 0.0v 89.495n 0.0v 89.505n 0.0v 99.495n 0.0v 99.505n 0.0v 109.495n 0.0v 109.505n 0.0v 119.495n 0.0v 119.505n 0.0v 129.495n 0.0v 129.505n 0.0v 139.495n 0.0v 139.505n 0.0v 149.495n 0.0v 149.505n 1.7v 159.495n 1.7v 159.505n 0.0v 169.495n 0.0v 169.505n 0.0v 179.495n 0.0v 179.505n 1.7v 189.495n 1.7v 189.505n 1.7v 199.495n 1.7v 199.505n 1.7v 209.495n 1.7v 209.505n 1.7v 219.495n 1.7v 219.505n 1.7v 229.495n 1.7v 229.505n 0.0v 239.495n 0.0v 239.505n 0.0v 249.495n 0.0v 249.505n 0.0v 259.495n 0.0v 259.505n 0.0v 269.495n 0.0v 269.505n 0.0v 279.495n 0.0v 279.505n 0.0v 289.495n 0.0v 289.505n 1.7v 299.495n 1.7v 299.505n 1.7v 309.495n 1.7v 309.505n 1.7v 319.495n 1.7v 319.505n 0.0v 329.495n 0.0v 329.505n 0.0v 339.495n 0.0v 339.505n 0.0v 349.495n 0.0v 349.505n 0.0v 359.495n 0.0v 359.505n 0.0v 369.495n 0.0v 369.505n 1.7v 379.495n 1.7v 379.505n 1.7v 389.495n 1.7v 389.505n 0.0v 399.495n 0.0v 399.505n 1.7v 409.495n 1.7v 409.505n 1.7v 419.495n 1.7v 419.505n 1.7v 429.495n 1.7v 429.505n 1.7v 439.495n 1.7v 439.505n 1.7v 449.495n 1.7v 449.505n 1.7v 459.495n 1.7v 459.505n 1.7v 469.495n 1.7v 469.505n 1.7v 479.495n 1.7v 479.505n 0.0v 489.495n 0.0v 489.505n 1.7v 499.495n 1.7v 499.505n 1.7v 509.495n 1.7v 509.505n 0.0v 519.495n 0.0v 519.505n 0.0v 529.495n 0.0v 529.505n 0.0v 539.495n 0.0v 539.505n 0.0v 549.495n 0.0v 549.505n 0.0v 559.495n 0.0v 559.505n 0.0v 569.495n 0.0v 569.505n 1.7v 579.495n 1.7v 579.505n 1.7v 589.495n 1.7v 589.505n 1.7v 599.495n 1.7v 599.505n 1.7v 609.495n 1.7v 609.505n 1.7v 619.495n 1.7v 619.505n 0.0v 629.495n 0.0v 629.505n 1.7v 639.495n 1.7v 639.505n 1.7v 649.495n 1.7v 649.505n 1.7v 659.495n 1.7v 659.505n 1.7v 669.495n 1.7v 669.505n 0.0v 679.495n 0.0v 679.505n 1.7v 689.495n 1.7v 689.505n 1.7v 699.495n 1.7v 699.505n 1.7v 709.495n 1.7v 709.505n 1.7v 719.495n 1.7v 719.505n 1.7v 729.495n 1.7v 729.505n 1.7v 739.495n 1.7v 739.505n 1.7v 749.495n 1.7v 749.505n 1.7v 759.495n 1.7v 759.505n 1.7v 769.495n 1.7v 769.505n 1.7v 779.495n 1.7v 779.505n 1.7v 789.495n 1.7v 789.505n 0.0v 799.495n 0.0v 799.505n 1.7v 809.495n 1.7v 809.505n 1.7v 819.495n 1.7v 819.505n 0.0v 829.495n 0.0v 829.505n 0.0v 839.495n 0.0v 839.505n 0.0v 849.495n 0.0v 849.505n 0.0v 859.495n 0.0v 859.505n 1.7v 869.495n 1.7v 869.505n 1.7v 879.495n 1.7v 879.505n 1.7v 889.495n 1.7v 889.505n 1.7v 899.495n 1.7v 899.505n 1.7v 909.495n 1.7v 909.505n 0.0v 919.495n 0.0v 919.505n 1.7v 929.495n 1.7v 929.505n 1.7v 939.495n 1.7v 939.505n 1.7v 949.495n 1.7v 949.505n 0.0v 959.495n 0.0v 959.505n 0.0v 969.495n 0.0v 969.505n 0.0v 979.495n 0.0v 979.505n 1.7v 989.495n 1.7v 989.505n 0.0v 999.495n 0.0v 999.505n 0.0v 1009.495n 0.0v 1009.505n 0.0v 1019.495n 0.0v 1019.505n 0.0v 1029.495n 0.0v 1029.505n 0.0v 1039.495n 0.0v 1039.505n 1.7v 1049.495n 1.7v 1049.505n 1.7v 1059.495n 1.7v 1059.505n 1.7v 1069.495n 1.7v 1069.505n 1.7v 1079.495n 1.7v 1079.505n 1.7v 1089.495n 1.7v 1089.505n 1.7v 1099.495n 1.7v 1099.505n 0.0v 1109.495n 0.0v 1109.505n 0.0v 1119.495n 0.0v 1119.505n 0.0v 1129.495n 0.0v 1129.505n 0.0v 1139.495n 0.0v 1139.505n 0.0v 1149.495n 0.0v 1149.505n 0.0v 1159.495n 0.0v 1159.505n 1.7v 1169.495n 1.7v 1169.505n 1.7v 1179.495n 1.7v 1179.505n 0.0v 1189.495n 0.0v 1189.505n 0.0v 1199.495n 0.0v 1199.505n 0.0v 1209.495n 0.0v 1209.505n 0.0v 1219.495n 0.0v 1219.505n 0.0v 1229.495n 0.0v 1229.505n 1.7v 1239.495n 1.7v 1239.505n 1.7v 1249.495n 1.7v 1249.505n 1.7v 1259.495n 1.7v 1259.505n 1.7v 1269.495n 1.7v 1269.505n 1.7v 1279.495n 1.7v 1279.505n 1.7v 1289.495n 1.7v 1289.505n 1.7v 1299.495n 1.7v 1299.505n 1.7v 1309.495n 1.7v 1309.505n 1.7v 1319.495n 1.7v 1319.505n 1.7v 1329.495n 1.7v 1329.505n 1.7v 1339.495n 1.7v 1339.505n 1.7v 1349.495n 1.7v 1349.505n 1.7v 1359.495n 1.7v 1359.505n 1.7v 1369.495n 1.7v 1369.505n 1.7v 1379.495n 1.7v 1379.505n 1.7v 1389.495n 1.7v 1389.505n 1.7v 1399.495n 1.7v 1399.505n 0.0v 1409.495n 0.0v 1409.505n 0.0v 1419.495n 0.0v 1419.505n 0.0v 1429.495n 0.0v 1429.505n 0.0v 1439.495n 0.0v 1439.505n 0.0v 1449.495n 0.0v 1449.505n 0.0v 1459.495n 0.0v 1459.505n 0.0v 1469.495n 0.0v 1469.505n 0.0v 1479.495n 0.0v 1479.505n 0.0v 1489.495n 0.0v 1489.505n 0.0v 1499.495n 0.0v 1499.505n 0.0v 1509.495n 0.0v 1509.505n 1.7v 1519.495n 1.7v 1519.505n 1.7v 1529.495n 1.7v 1529.505n 1.7v 1539.495n 1.7v 1539.505n 0.0v 1549.495n 0.0v 1549.505n 0.0v 1559.495n 0.0v 1559.505n 0.0v 1569.495n 0.0v 1569.505n 1.7v 1579.495n 1.7v 1579.505n 0.0v 1589.495n 0.0v 1589.505n 0.0v 1599.495n 0.0v 1599.505n 0.0v 1609.495n 0.0v 1609.505n 0.0v 1619.495n 0.0v 1619.505n 0.0v 1629.495n 0.0v 1629.505n 1.7v 1639.495n 1.7v 1639.505n 1.7v 1649.495n 1.7v 1649.505n 0.0v 1659.495n 0.0v 1659.505n 1.7v 1669.495n 1.7v 1669.505n 1.7v 1679.495n 1.7v 1679.505n 1.7v 1689.495n 1.7v 1689.505n 1.7v 1699.495n 1.7v 1699.505n 0.0v 1709.495n 0.0v 1709.505n 1.7v 1719.495n 1.7v 1719.505n 1.7v 1729.495n 1.7v 1729.505n 1.7v 1739.495n 1.7v 1739.505n 0.0v 1749.495n 0.0v 1749.505n 0.0v 1759.495n 0.0v 1759.505n 1.7v 1769.495n 1.7v 1769.505n 0.0v 1779.495n 0.0v 1779.505n 1.7v 1789.495n 1.7v 1789.505n 1.7v 1799.495n 1.7v 1799.505n 0.0v 1809.495n 0.0v 1809.505n 0.0v 1819.495n 0.0v 1819.505n 1.7v 1829.495n 1.7v 1829.505n 1.7v 1839.495n 1.7v 1839.505n 1.7v 1849.495n 1.7v 1849.505n 1.7v 1859.495n 1.7v 1859.505n 1.7v 1869.495n 1.7v 1869.505n 1.7v 1879.495n 1.7v 1879.505n 1.7v 1889.495n 1.7v 1889.505n 1.7v 1899.495n 1.7v 1899.505n 0.0v 1909.495n 0.0v 1909.505n 1.7v 1919.495n 1.7v 1919.505n 0.0v 1929.495n 0.0v 1929.505n 1.7v 1939.495n 1.7v 1939.505n 1.7v 1949.495n 1.7v 1949.505n 0.0v 1959.495n 0.0v 1959.505n 1.7v 1969.495n 1.7v 1969.505n 0.0v 1979.495n 0.0v 1979.505n 0.0v 1989.495n 0.0v 1989.505n 1.7v 1999.495n 1.7v 1999.505n 1.7v 2009.495n 1.7v 2009.505n 1.7v 2019.495n 1.7v 2019.505n 1.7v 2029.495n 1.7v 2029.505n 1.7v 2039.495n 1.7v 2039.505n 1.7v 2049.495n 1.7v 2049.505n 1.7v )
* (time, data): [(0, 0), (10, 0), (20, 0), (30, 0), (40, 0), (50, 0), (60, 0), (70, 0), (80, 0), (90, 0), (100, 0), (110, 0), (120, 0), (130, 0), (140, 0), (150, 0), (160, 0), (170, 0), (180, 0), (190, 0), (200, 1), (210, 1), (220, 1), (230, 0), (240, 0), (250, 0), (260, 0), (270, 0), (280, 0), (290, 1), (300, 1), (310, 1), (320, 0), (330, 0), (340, 0), (350, 0), (360, 0), (370, 1), (380, 1), (390, 0), (400, 0), (410, 0), (420, 0), (430, 0), (440, 0), (450, 0), (460, 1), (470, 1), (480, 0), (490, 1), (500, 0), (510, 0), (520, 0), (530, 0), (540, 0), (550, 0), (560, 0), (570, 0), (580, 0), (590, 0), (600, 0), (610, 0), (620, 0), (630, 1), (640, 1), (650, 1), (660, 1), (670, 0), (680, 1), (690, 0), (700, 1), (710, 1), (720, 1), (730, 1), (740, 1), (750, 0), (760, 0), (770, 0), (780, 0), (790, 0), (800, 1), (810, 1), (820, 0), (830, 0), (840, 0), (850, 0), (860, 1), (870, 1), (880, 1), (890, 1), (900, 0), (910, 0), (920, 1), (930, 1), (940, 1), (950, 0), (960, 0), (970, 0), (980, 1), (990, 0), (1000, 0), (1010, 0), (1020, 0), (1030, 0), (1040, 1), (1050, 0), (1060, 0), (1070, 0), (1080, 0), (1090, 0), (1100, 0), (1110, 0), (1120, 0), (1130, 0), (1140, 0), (1150, 0), (1160, 1), (1170, 1), (1180, 0), (1190, 0), (1200, 0), (1210, 0), (1220, 0), (1230, 1), (1240, 1), (1250, 1), (1260, 1), (1270, 1), (1280, 0), (1290, 0), (1300, 0), (1310, 0), (1320, 0), (1330, 1), (1340, 1), (1350, 1), (1360, 1), (1370, 1), (1380, 1), (1390, 1), (1400, 0), (1410, 0), (1420, 0), (1430, 0), (1440, 0), (1450, 0), (1460, 0), (1470, 0), (1480, 0), (1490, 0), (1500, 0), (1510, 0), (1520, 1), (1530, 1), (1540, 0), (1550, 0), (1560, 0), (1570, 0), (1580, 0), (1590, 0), (1600, 0), (1610, 0), (1620, 0), (1630, 1), (1640, 1), (1650, 0), (1660, 1), (1670, 1), (1680, 1), (1690, 1), (1700, 0), (1710, 0), (1720, 0), (1730, 0), (1740, 0), (1750, 0), (1760, 1), (1770, 0), (1780, 1), (1790, 1), (1800, 0), (1810, 0), (1820, 1), (1830, 0), (1840, 0), (1850, 0), (1860, 0), (1870, 1), (1880, 1), (1890, 1), (1900, 0), (1910, 1), (1920, 0), (1930, 1), (1940, 1), (1950, 0), (1960, 0), (1970, 0), (1980, 0), (1990, 1), (2000, 1), (2010, 1), (2020, 0), (2030, 0), (2040, 1), (2050, 1)]
Va0_1  a0_1  0 PWL (0n 0.0v 9.495n 0.0v 9.505n 0.0v 19.495n 0.0v 19.505n 0.0v 29.495n 0.0v 29.505n 0.0v 39.495n 0.0v 39.505n 0.0v 49.495n 0.0v 49.505n 0.0v 59.495n 0.0v 59.505n 0.0v 69.495n 0.0v 69.505n 0.0v 79.495n 0.0v 79.505n 0.0v 89.495n 0.0v 89.505n 0.0v 99.495n 0.0v 99.505n 0.0v 109.495n 0.0v 109.505n 0.0v 119.495n 0.0v 119.505n 0.0v 129.495n 0.0v 129.505n 0.0v 139.495n 0.0v 139.505n 0.0v 149.495n 0.0v 149.505n 0.0v 159.495n 0.0v 159.505n 0.0v 169.495n 0.0v 169.505n 0.0v 179.495n 0.0v 179.505n 0.0v 189.495n 0.0v 189.505n 0.0v 199.495n 0.0v 199.505n 1.7v 209.495n 1.7v 209.505n 1.7v 219.495n 1.7v 219.505n 1.7v 229.495n 1.7v 229.505n 0.0v 239.495n 0.0v 239.505n 0.0v 249.495n 0.0v 249.505n 0.0v 259.495n 0.0v 259.505n 0.0v 269.495n 0.0v 269.505n 0.0v 279.495n 0.0v 279.505n 0.0v 289.495n 0.0v 289.505n 1.7v 299.495n 1.7v 299.505n 1.7v 309.495n 1.7v 309.505n 1.7v 319.495n 1.7v 319.505n 0.0v 329.495n 0.0v 329.505n 0.0v 339.495n 0.0v 339.505n 0.0v 349.495n 0.0v 349.505n 0.0v 359.495n 0.0v 359.505n 0.0v 369.495n 0.0v 369.505n 1.7v 379.495n 1.7v 379.505n 1.7v 389.495n 1.7v 389.505n 0.0v 399.495n 0.0v 399.505n 0.0v 409.495n 0.0v 409.505n 0.0v 419.495n 0.0v 419.505n 0.0v 429.495n 0.0v 429.505n 0.0v 439.495n 0.0v 439.505n 0.0v 449.495n 0.0v 449.505n 0.0v 459.495n 0.0v 459.505n 1.7v 469.495n 1.7v 469.505n 1.7v 479.495n 1.7v 479.505n 0.0v 489.495n 0.0v 489.505n 1.7v 499.495n 1.7v 499.505n 0.0v 509.495n 0.0v 509.505n 0.0v 519.495n 0.0v 519.505n 0.0v 529.495n 0.0v 529.505n 0.0v 539.495n 0.0v 539.505n 0.0v 549.495n 0.0v 549.505n 0.0v 559.495n 0.0v 559.505n 0.0v 569.495n 0.0v 569.505n 0.0v 579.495n 0.0v 579.505n 0.0v 589.495n 0.0v 589.505n 0.0v 599.495n 0.0v 599.505n 0.0v 609.495n 0.0v 609.505n 0.0v 619.495n 0.0v 619.505n 0.0v 629.495n 0.0v 629.505n 1.7v 639.495n 1.7v 639.505n 1.7v 649.495n 1.7v 649.505n 1.7v 659.495n 1.7v 659.505n 1.7v 669.495n 1.7v 669.505n 0.0v 679.495n 0.0v 679.505n 1.7v 689.495n 1.7v 689.505n 0.0v 699.495n 0.0v 699.505n 1.7v 709.495n 1.7v 709.505n 1.7v 719.495n 1.7v 719.505n 1.7v 729.495n 1.7v 729.505n 1.7v 739.495n 1.7v 739.505n 1.7v 749.495n 1.7v 749.505n 0.0v 759.495n 0.0v 759.505n 0.0v 769.495n 0.0v 769.505n 0.0v 779.495n 0.0v 779.505n 0.0v 789.495n 0.0v 789.505n 0.0v 799.495n 0.0v 799.505n 1.7v 809.495n 1.7v 809.505n 1.7v 819.495n 1.7v 819.505n 0.0v 829.495n 0.0v 829.505n 0.0v 839.495n 0.0v 839.505n 0.0v 849.495n 0.0v 849.505n 0.0v 859.495n 0.0v 859.505n 1.7v 869.495n 1.7v 869.505n 1.7v 879.495n 1.7v 879.505n 1.7v 889.495n 1.7v 889.505n 1.7v 899.495n 1.7v 899.505n 0.0v 909.495n 0.0v 909.505n 0.0v 919.495n 0.0v 919.505n 1.7v 929.495n 1.7v 929.505n 1.7v 939.495n 1.7v 939.505n 1.7v 949.495n 1.7v 949.505n 0.0v 959.495n 0.0v 959.505n 0.0v 969.495n 0.0v 969.505n 0.0v 979.495n 0.0v 979.505n 1.7v 989.495n 1.7v 989.505n 0.0v 999.495n 0.0v 999.505n 0.0v 1009.495n 0.0v 1009.505n 0.0v 1019.495n 0.0v 1019.505n 0.0v 1029.495n 0.0v 1029.505n 0.0v 1039.495n 0.0v 1039.505n 1.7v 1049.495n 1.7v 1049.505n 0.0v 1059.495n 0.0v 1059.505n 0.0v 1069.495n 0.0v 1069.505n 0.0v 1079.495n 0.0v 1079.505n 0.0v 1089.495n 0.0v 1089.505n 0.0v 1099.495n 0.0v 1099.505n 0.0v 1109.495n 0.0v 1109.505n 0.0v 1119.495n 0.0v 1119.505n 0.0v 1129.495n 0.0v 1129.505n 0.0v 1139.495n 0.0v 1139.505n 0.0v 1149.495n 0.0v 1149.505n 0.0v 1159.495n 0.0v 1159.505n 1.7v 1169.495n 1.7v 1169.505n 1.7v 1179.495n 1.7v 1179.505n 0.0v 1189.495n 0.0v 1189.505n 0.0v 1199.495n 0.0v 1199.505n 0.0v 1209.495n 0.0v 1209.505n 0.0v 1219.495n 0.0v 1219.505n 0.0v 1229.495n 0.0v 1229.505n 1.7v 1239.495n 1.7v 1239.505n 1.7v 1249.495n 1.7v 1249.505n 1.7v 1259.495n 1.7v 1259.505n 1.7v 1269.495n 1.7v 1269.505n 1.7v 1279.495n 1.7v 1279.505n 0.0v 1289.495n 0.0v 1289.505n 0.0v 1299.495n 0.0v 1299.505n 0.0v 1309.495n 0.0v 1309.505n 0.0v 1319.495n 0.0v 1319.505n 0.0v 1329.495n 0.0v 1329.505n 1.7v 1339.495n 1.7v 1339.505n 1.7v 1349.495n 1.7v 1349.505n 1.7v 1359.495n 1.7v 1359.505n 1.7v 1369.495n 1.7v 1369.505n 1.7v 1379.495n 1.7v 1379.505n 1.7v 1389.495n 1.7v 1389.505n 1.7v 1399.495n 1.7v 1399.505n 0.0v 1409.495n 0.0v 1409.505n 0.0v 1419.495n 0.0v 1419.505n 0.0v 1429.495n 0.0v 1429.505n 0.0v 1439.495n 0.0v 1439.505n 0.0v 1449.495n 0.0v 1449.505n 0.0v 1459.495n 0.0v 1459.505n 0.0v 1469.495n 0.0v 1469.505n 0.0v 1479.495n 0.0v 1479.505n 0.0v 1489.495n 0.0v 1489.505n 0.0v 1499.495n 0.0v 1499.505n 0.0v 1509.495n 0.0v 1509.505n 0.0v 1519.495n 0.0v 1519.505n 1.7v 1529.495n 1.7v 1529.505n 1.7v 1539.495n 1.7v 1539.505n 0.0v 1549.495n 0.0v 1549.505n 0.0v 1559.495n 0.0v 1559.505n 0.0v 1569.495n 0.0v 1569.505n 0.0v 1579.495n 0.0v 1579.505n 0.0v 1589.495n 0.0v 1589.505n 0.0v 1599.495n 0.0v 1599.505n 0.0v 1609.495n 0.0v 1609.505n 0.0v 1619.495n 0.0v 1619.505n 0.0v 1629.495n 0.0v 1629.505n 1.7v 1639.495n 1.7v 1639.505n 1.7v 1649.495n 1.7v 1649.505n 0.0v 1659.495n 0.0v 1659.505n 1.7v 1669.495n 1.7v 1669.505n 1.7v 1679.495n 1.7v 1679.505n 1.7v 1689.495n 1.7v 1689.505n 1.7v 1699.495n 1.7v 1699.505n 0.0v 1709.495n 0.0v 1709.505n 0.0v 1719.495n 0.0v 1719.505n 0.0v 1729.495n 0.0v 1729.505n 0.0v 1739.495n 0.0v 1739.505n 0.0v 1749.495n 0.0v 1749.505n 0.0v 1759.495n 0.0v 1759.505n 1.7v 1769.495n 1.7v 1769.505n 0.0v 1779.495n 0.0v 1779.505n 1.7v 1789.495n 1.7v 1789.505n 1.7v 1799.495n 1.7v 1799.505n 0.0v 1809.495n 0.0v 1809.505n 0.0v 1819.495n 0.0v 1819.505n 1.7v 1829.495n 1.7v 1829.505n 0.0v 1839.495n 0.0v 1839.505n 0.0v 1849.495n 0.0v 1849.505n 0.0v 1859.495n 0.0v 1859.505n 0.0v 1869.495n 0.0v 1869.505n 1.7v 1879.495n 1.7v 1879.505n 1.7v 1889.495n 1.7v 1889.505n 1.7v 1899.495n 1.7v 1899.505n 0.0v 1909.495n 0.0v 1909.505n 1.7v 1919.495n 1.7v 1919.505n 0.0v 1929.495n 0.0v 1929.505n 1.7v 1939.495n 1.7v 1939.505n 1.7v 1949.495n 1.7v 1949.505n 0.0v 1959.495n 0.0v 1959.505n 0.0v 1969.495n 0.0v 1969.505n 0.0v 1979.495n 0.0v 1979.505n 0.0v 1989.495n 0.0v 1989.505n 1.7v 1999.495n 1.7v 1999.505n 1.7v 2009.495n 1.7v 2009.505n 1.7v 2019.495n 1.7v 2019.505n 0.0v 2029.495n 0.0v 2029.505n 0.0v 2039.495n 0.0v 2039.505n 1.7v 2049.495n 1.7v 2049.505n 1.7v )
* (time, data): [(0, 0), (10, 0), (20, 0), (30, 0), (40, 0), (50, 0), (60, 0), (70, 0), (80, 0), (90, 0), (100, 0), (110, 0), (120, 0), (130, 0), (140, 0), (150, 0), (160, 0), (170, 0), (180, 0), (190, 0), (200, 1), (210, 1), (220, 1), (230, 0), (240, 0), (250, 0), (260, 0), (270, 0), (280, 0), (290, 1), (300, 1), (310, 1), (320, 0), (330, 0), (340, 0), (350, 0), (360, 0), (370, 1), (380, 1), (390, 0), (400, 0), (410, 0), (420, 0), (430, 0), (440, 0), (450, 0), (460, 1), (470, 1), (480, 0), (490, 1), (500, 0), (510, 0), (520, 0), (530, 0), (540, 0), (550, 0), (560, 0), (570, 0), (580, 0), (590, 0), (600, 0), (610, 0), (620, 0), (630, 1), (640, 1), (650, 1), (660, 1), (670, 0), (680, 1), (690, 0), (700, 1), (710, 1), (720, 1), (730, 1), (740, 1), (750, 0), (760, 0), (770, 0), (780, 0), (790, 0), (800, 1), (810, 1), (820, 0), (830, 0), (840, 0), (850, 0), (860, 1), (870, 1), (880, 1), (890, 1), (900, 0), (910, 0), (920, 1), (930, 1), (940, 1), (950, 0), (960, 0), (970, 0), (980, 1), (990, 0), (1000, 0), (1010, 0), (1020, 0), (1030, 0), (1040, 1), (1050, 0), (1060, 0), (1070, 0), (1080, 0), (1090, 0), (1100, 0), (1110, 0), (1120, 0), (1130, 0), (1140, 0), (1150, 0), (1160, 1), (1170, 1), (1180, 0), (1190, 0), (1200, 0), (1210, 0), (1220, 0), (1230, 1), (1240, 1), (1250, 1), (1260, 1), (1270, 1), (1280, 0), (1290, 0), (1300, 0), (1310, 0), (1320, 0), (1330, 1), (1340, 1), (1350, 1), (1360, 1), (1370, 1), (1380, 1), (1390, 1), (1400, 0), (1410, 0), (1420, 0), (1430, 0), (1440, 0), (1450, 0), (1460, 0), (1470, 0), (1480, 0), (1490, 0), (1500, 0), (1510, 0), (1520, 1), (1530, 1), (1540, 0), (1550, 0), (1560, 0), (1570, 0), (1580, 0), (1590, 0), (1600, 0), (1610, 0), (1620, 0), (1630, 1), (1640, 1), (1650, 0), (1660, 1), (1670, 1), (1680, 1), (1690, 1), (1700, 0), (1710, 0), (1720, 0), (1730, 0), (1740, 0), (1750, 0), (1760, 1), (1770, 0), (1780, 1), (1790, 1), (1800, 0), (1810, 0), (1820, 1), (1830, 0), (1840, 0), (1850, 0), (1860, 0), (1870, 1), (1880, 1), (1890, 1), (1900, 0), (1910, 1), (1920, 0), (1930, 1), (1940, 1), (1950, 0), (1960, 0), (1970, 0), (1980, 0), (1990, 1), (2000, 1), (2010, 1), (2020, 0), (2030, 0), (2040, 1), (2050, 1)]
Va0_2  a0_2  0 PWL (0n 0.0v 9.495n 0.0v 9.505n 0.0v 19.495n 0.0v 19.505n 0.0v 29.495n 0.0v 29.505n 0.0v 39.495n 0.0v 39.505n 0.0v 49.495n 0.0v 49.505n 0.0v 59.495n 0.0v 59.505n 0.0v 69.495n 0.0v 69.505n 0.0v 79.495n 0.0v 79.505n 0.0v 89.495n 0.0v 89.505n 0.0v 99.495n 0.0v 99.505n 0.0v 109.495n 0.0v 109.505n 0.0v 119.495n 0.0v 119.505n 0.0v 129.495n 0.0v 129.505n 0.0v 139.495n 0.0v 139.505n 0.0v 149.495n 0.0v 149.505n 0.0v 159.495n 0.0v 159.505n 0.0v 169.495n 0.0v 169.505n 0.0v 179.495n 0.0v 179.505n 0.0v 189.495n 0.0v 189.505n 0.0v 199.495n 0.0v 199.505n 1.7v 209.495n 1.7v 209.505n 1.7v 219.495n 1.7v 219.505n 1.7v 229.495n 1.7v 229.505n 0.0v 239.495n 0.0v 239.505n 0.0v 249.495n 0.0v 249.505n 0.0v 259.495n 0.0v 259.505n 0.0v 269.495n 0.0v 269.505n 0.0v 279.495n 0.0v 279.505n 0.0v 289.495n 0.0v 289.505n 1.7v 299.495n 1.7v 299.505n 1.7v 309.495n 1.7v 309.505n 1.7v 319.495n 1.7v 319.505n 0.0v 329.495n 0.0v 329.505n 0.0v 339.495n 0.0v 339.505n 0.0v 349.495n 0.0v 349.505n 0.0v 359.495n 0.0v 359.505n 0.0v 369.495n 0.0v 369.505n 1.7v 379.495n 1.7v 379.505n 1.7v 389.495n 1.7v 389.505n 0.0v 399.495n 0.0v 399.505n 0.0v 409.495n 0.0v 409.505n 0.0v 419.495n 0.0v 419.505n 0.0v 429.495n 0.0v 429.505n 0.0v 439.495n 0.0v 439.505n 0.0v 449.495n 0.0v 449.505n 0.0v 459.495n 0.0v 459.505n 1.7v 469.495n 1.7v 469.505n 1.7v 479.495n 1.7v 479.505n 0.0v 489.495n 0.0v 489.505n 1.7v 499.495n 1.7v 499.505n 0.0v 509.495n 0.0v 509.505n 0.0v 519.495n 0.0v 519.505n 0.0v 529.495n 0.0v 529.505n 0.0v 539.495n 0.0v 539.505n 0.0v 549.495n 0.0v 549.505n 0.0v 559.495n 0.0v 559.505n 0.0v 569.495n 0.0v 569.505n 0.0v 579.495n 0.0v 579.505n 0.0v 589.495n 0.0v 589.505n 0.0v 599.495n 0.0v 599.505n 0.0v 609.495n 0.0v 609.505n 0.0v 619.495n 0.0v 619.505n 0.0v 629.495n 0.0v 629.505n 1.7v 639.495n 1.7v 639.505n 1.7v 649.495n 1.7v 649.505n 1.7v 659.495n 1.7v 659.505n 1.7v 669.495n 1.7v 669.505n 0.0v 679.495n 0.0v 679.505n 1.7v 689.495n 1.7v 689.505n 0.0v 699.495n 0.0v 699.505n 1.7v 709.495n 1.7v 709.505n 1.7v 719.495n 1.7v 719.505n 1.7v 729.495n 1.7v 729.505n 1.7v 739.495n 1.7v 739.505n 1.7v 749.495n 1.7v 749.505n 0.0v 759.495n 0.0v 759.505n 0.0v 769.495n 0.0v 769.505n 0.0v 779.495n 0.0v 779.505n 0.0v 789.495n 0.0v 789.505n 0.0v 799.495n 0.0v 799.505n 1.7v 809.495n 1.7v 809.505n 1.7v 819.495n 1.7v 819.505n 0.0v 829.495n 0.0v 829.505n 0.0v 839.495n 0.0v 839.505n 0.0v 849.495n 0.0v 849.505n 0.0v 859.495n 0.0v 859.505n 1.7v 869.495n 1.7v 869.505n 1.7v 879.495n 1.7v 879.505n 1.7v 889.495n 1.7v 889.505n 1.7v 899.495n 1.7v 899.505n 0.0v 909.495n 0.0v 909.505n 0.0v 919.495n 0.0v 919.505n 1.7v 929.495n 1.7v 929.505n 1.7v 939.495n 1.7v 939.505n 1.7v 949.495n 1.7v 949.505n 0.0v 959.495n 0.0v 959.505n 0.0v 969.495n 0.0v 969.505n 0.0v 979.495n 0.0v 979.505n 1.7v 989.495n 1.7v 989.505n 0.0v 999.495n 0.0v 999.505n 0.0v 1009.495n 0.0v 1009.505n 0.0v 1019.495n 0.0v 1019.505n 0.0v 1029.495n 0.0v 1029.505n 0.0v 1039.495n 0.0v 1039.505n 1.7v 1049.495n 1.7v 1049.505n 0.0v 1059.495n 0.0v 1059.505n 0.0v 1069.495n 0.0v 1069.505n 0.0v 1079.495n 0.0v 1079.505n 0.0v 1089.495n 0.0v 1089.505n 0.0v 1099.495n 0.0v 1099.505n 0.0v 1109.495n 0.0v 1109.505n 0.0v 1119.495n 0.0v 1119.505n 0.0v 1129.495n 0.0v 1129.505n 0.0v 1139.495n 0.0v 1139.505n 0.0v 1149.495n 0.0v 1149.505n 0.0v 1159.495n 0.0v 1159.505n 1.7v 1169.495n 1.7v 1169.505n 1.7v 1179.495n 1.7v 1179.505n 0.0v 1189.495n 0.0v 1189.505n 0.0v 1199.495n 0.0v 1199.505n 0.0v 1209.495n 0.0v 1209.505n 0.0v 1219.495n 0.0v 1219.505n 0.0v 1229.495n 0.0v 1229.505n 1.7v 1239.495n 1.7v 1239.505n 1.7v 1249.495n 1.7v 1249.505n 1.7v 1259.495n 1.7v 1259.505n 1.7v 1269.495n 1.7v 1269.505n 1.7v 1279.495n 1.7v 1279.505n 0.0v 1289.495n 0.0v 1289.505n 0.0v 1299.495n 0.0v 1299.505n 0.0v 1309.495n 0.0v 1309.505n 0.0v 1319.495n 0.0v 1319.505n 0.0v 1329.495n 0.0v 1329.505n 1.7v 1339.495n 1.7v 1339.505n 1.7v 1349.495n 1.7v 1349.505n 1.7v 1359.495n 1.7v 1359.505n 1.7v 1369.495n 1.7v 1369.505n 1.7v 1379.495n 1.7v 1379.505n 1.7v 1389.495n 1.7v 1389.505n 1.7v 1399.495n 1.7v 1399.505n 0.0v 1409.495n 0.0v 1409.505n 0.0v 1419.495n 0.0v 1419.505n 0.0v 1429.495n 0.0v 1429.505n 0.0v 1439.495n 0.0v 1439.505n 0.0v 1449.495n 0.0v 1449.505n 0.0v 1459.495n 0.0v 1459.505n 0.0v 1469.495n 0.0v 1469.505n 0.0v 1479.495n 0.0v 1479.505n 0.0v 1489.495n 0.0v 1489.505n 0.0v 1499.495n 0.0v 1499.505n 0.0v 1509.495n 0.0v 1509.505n 0.0v 1519.495n 0.0v 1519.505n 1.7v 1529.495n 1.7v 1529.505n 1.7v 1539.495n 1.7v 1539.505n 0.0v 1549.495n 0.0v 1549.505n 0.0v 1559.495n 0.0v 1559.505n 0.0v 1569.495n 0.0v 1569.505n 0.0v 1579.495n 0.0v 1579.505n 0.0v 1589.495n 0.0v 1589.505n 0.0v 1599.495n 0.0v 1599.505n 0.0v 1609.495n 0.0v 1609.505n 0.0v 1619.495n 0.0v 1619.505n 0.0v 1629.495n 0.0v 1629.505n 1.7v 1639.495n 1.7v 1639.505n 1.7v 1649.495n 1.7v 1649.505n 0.0v 1659.495n 0.0v 1659.505n 1.7v 1669.495n 1.7v 1669.505n 1.7v 1679.495n 1.7v 1679.505n 1.7v 1689.495n 1.7v 1689.505n 1.7v 1699.495n 1.7v 1699.505n 0.0v 1709.495n 0.0v 1709.505n 0.0v 1719.495n 0.0v 1719.505n 0.0v 1729.495n 0.0v 1729.505n 0.0v 1739.495n 0.0v 1739.505n 0.0v 1749.495n 0.0v 1749.505n 0.0v 1759.495n 0.0v 1759.505n 1.7v 1769.495n 1.7v 1769.505n 0.0v 1779.495n 0.0v 1779.505n 1.7v 1789.495n 1.7v 1789.505n 1.7v 1799.495n 1.7v 1799.505n 0.0v 1809.495n 0.0v 1809.505n 0.0v 1819.495n 0.0v 1819.505n 1.7v 1829.495n 1.7v 1829.505n 0.0v 1839.495n 0.0v 1839.505n 0.0v 1849.495n 0.0v 1849.505n 0.0v 1859.495n 0.0v 1859.505n 0.0v 1869.495n 0.0v 1869.505n 1.7v 1879.495n 1.7v 1879.505n 1.7v 1889.495n 1.7v 1889.505n 1.7v 1899.495n 1.7v 1899.505n 0.0v 1909.495n 0.0v 1909.505n 1.7v 1919.495n 1.7v 1919.505n 0.0v 1929.495n 0.0v 1929.505n 1.7v 1939.495n 1.7v 1939.505n 1.7v 1949.495n 1.7v 1949.505n 0.0v 1959.495n 0.0v 1959.505n 0.0v 1969.495n 0.0v 1969.505n 0.0v 1979.495n 0.0v 1979.505n 0.0v 1989.495n 0.0v 1989.505n 1.7v 1999.495n 1.7v 1999.505n 1.7v 2009.495n 1.7v 2009.505n 1.7v 2019.495n 1.7v 2019.505n 0.0v 2029.495n 0.0v 2029.505n 0.0v 2039.495n 0.0v 2039.505n 1.7v 2049.495n 1.7v 2049.505n 1.7v )
* (time, data): [(0, 0), (10, 0), (20, 0), (30, 0), (40, 0), (50, 0), (60, 0), (70, 0), (80, 0), (90, 0), (100, 0), (110, 0), (120, 0), (130, 0), (140, 0), (150, 0), (160, 0), (170, 0), (180, 0), (190, 0), (200, 1), (210, 1), (220, 1), (230, 0), (240, 0), (250, 0), (260, 0), (270, 0), (280, 0), (290, 1), (300, 1), (310, 1), (320, 0), (330, 0), (340, 0), (350, 0), (360, 0), (370, 1), (380, 1), (390, 0), (400, 0), (410, 0), (420, 0), (430, 0), (440, 0), (450, 0), (460, 1), (470, 1), (480, 0), (490, 1), (500, 0), (510, 0), (520, 0), (530, 0), (540, 0), (550, 0), (560, 0), (570, 0), (580, 0), (590, 0), (600, 0), (610, 0), (620, 0), (630, 1), (640, 1), (650, 1), (660, 1), (670, 0), (680, 1), (690, 0), (700, 1), (710, 1), (720, 1), (730, 1), (740, 1), (750, 0), (760, 0), (770, 0), (780, 0), (790, 0), (800, 1), (810, 1), (820, 0), (830, 0), (840, 0), (850, 0), (860, 1), (870, 1), (880, 1), (890, 1), (900, 0), (910, 0), (920, 1), (930, 1), (940, 1), (950, 0), (960, 0), (970, 0), (980, 1), (990, 0), (1000, 0), (1010, 0), (1020, 0), (1030, 0), (1040, 1), (1050, 0), (1060, 0), (1070, 0), (1080, 0), (1090, 0), (1100, 0), (1110, 0), (1120, 0), (1130, 0), (1140, 0), (1150, 0), (1160, 1), (1170, 1), (1180, 0), (1190, 0), (1200, 0), (1210, 0), (1220, 0), (1230, 1), (1240, 1), (1250, 1), (1260, 1), (1270, 1), (1280, 0), (1290, 0), (1300, 0), (1310, 0), (1320, 0), (1330, 1), (1340, 1), (1350, 1), (1360, 1), (1370, 1), (1380, 1), (1390, 1), (1400, 0), (1410, 0), (1420, 0), (1430, 0), (1440, 0), (1450, 0), (1460, 0), (1470, 0), (1480, 0), (1490, 0), (1500, 0), (1510, 0), (1520, 1), (1530, 1), (1540, 0), (1550, 0), (1560, 0), (1570, 0), (1580, 0), (1590, 0), (1600, 0), (1610, 0), (1620, 0), (1630, 1), (1640, 1), (1650, 0), (1660, 1), (1670, 1), (1680, 1), (1690, 1), (1700, 0), (1710, 0), (1720, 0), (1730, 0), (1740, 0), (1750, 0), (1760, 1), (1770, 0), (1780, 1), (1790, 1), (1800, 0), (1810, 0), (1820, 1), (1830, 0), (1840, 0), (1850, 0), (1860, 0), (1870, 1), (1880, 1), (1890, 1), (1900, 0), (1910, 1), (1920, 0), (1930, 1), (1940, 1), (1950, 0), (1960, 0), (1970, 0), (1980, 0), (1990, 1), (2000, 1), (2010, 1), (2020, 0), (2030, 0), (2040, 1), (2050, 1)]
Va0_3  a0_3  0 PWL (0n 0.0v 9.495n 0.0v 9.505n 0.0v 19.495n 0.0v 19.505n 0.0v 29.495n 0.0v 29.505n 0.0v 39.495n 0.0v 39.505n 0.0v 49.495n 0.0v 49.505n 0.0v 59.495n 0.0v 59.505n 0.0v 69.495n 0.0v 69.505n 0.0v 79.495n 0.0v 79.505n 0.0v 89.495n 0.0v 89.505n 0.0v 99.495n 0.0v 99.505n 0.0v 109.495n 0.0v 109.505n 0.0v 119.495n 0.0v 119.505n 0.0v 129.495n 0.0v 129.505n 0.0v 139.495n 0.0v 139.505n 0.0v 149.495n 0.0v 149.505n 0.0v 159.495n 0.0v 159.505n 0.0v 169.495n 0.0v 169.505n 0.0v 179.495n 0.0v 179.505n 0.0v 189.495n 0.0v 189.505n 0.0v 199.495n 0.0v 199.505n 1.7v 209.495n 1.7v 209.505n 1.7v 219.495n 1.7v 219.505n 1.7v 229.495n 1.7v 229.505n 0.0v 239.495n 0.0v 239.505n 0.0v 249.495n 0.0v 249.505n 0.0v 259.495n 0.0v 259.505n 0.0v 269.495n 0.0v 269.505n 0.0v 279.495n 0.0v 279.505n 0.0v 289.495n 0.0v 289.505n 1.7v 299.495n 1.7v 299.505n 1.7v 309.495n 1.7v 309.505n 1.7v 319.495n 1.7v 319.505n 0.0v 329.495n 0.0v 329.505n 0.0v 339.495n 0.0v 339.505n 0.0v 349.495n 0.0v 349.505n 0.0v 359.495n 0.0v 359.505n 0.0v 369.495n 0.0v 369.505n 1.7v 379.495n 1.7v 379.505n 1.7v 389.495n 1.7v 389.505n 0.0v 399.495n 0.0v 399.505n 0.0v 409.495n 0.0v 409.505n 0.0v 419.495n 0.0v 419.505n 0.0v 429.495n 0.0v 429.505n 0.0v 439.495n 0.0v 439.505n 0.0v 449.495n 0.0v 449.505n 0.0v 459.495n 0.0v 459.505n 1.7v 469.495n 1.7v 469.505n 1.7v 479.495n 1.7v 479.505n 0.0v 489.495n 0.0v 489.505n 1.7v 499.495n 1.7v 499.505n 0.0v 509.495n 0.0v 509.505n 0.0v 519.495n 0.0v 519.505n 0.0v 529.495n 0.0v 529.505n 0.0v 539.495n 0.0v 539.505n 0.0v 549.495n 0.0v 549.505n 0.0v 559.495n 0.0v 559.505n 0.0v 569.495n 0.0v 569.505n 0.0v 579.495n 0.0v 579.505n 0.0v 589.495n 0.0v 589.505n 0.0v 599.495n 0.0v 599.505n 0.0v 609.495n 0.0v 609.505n 0.0v 619.495n 0.0v 619.505n 0.0v 629.495n 0.0v 629.505n 1.7v 639.495n 1.7v 639.505n 1.7v 649.495n 1.7v 649.505n 1.7v 659.495n 1.7v 659.505n 1.7v 669.495n 1.7v 669.505n 0.0v 679.495n 0.0v 679.505n 1.7v 689.495n 1.7v 689.505n 0.0v 699.495n 0.0v 699.505n 1.7v 709.495n 1.7v 709.505n 1.7v 719.495n 1.7v 719.505n 1.7v 729.495n 1.7v 729.505n 1.7v 739.495n 1.7v 739.505n 1.7v 749.495n 1.7v 749.505n 0.0v 759.495n 0.0v 759.505n 0.0v 769.495n 0.0v 769.505n 0.0v 779.495n 0.0v 779.505n 0.0v 789.495n 0.0v 789.505n 0.0v 799.495n 0.0v 799.505n 1.7v 809.495n 1.7v 809.505n 1.7v 819.495n 1.7v 819.505n 0.0v 829.495n 0.0v 829.505n 0.0v 839.495n 0.0v 839.505n 0.0v 849.495n 0.0v 849.505n 0.0v 859.495n 0.0v 859.505n 1.7v 869.495n 1.7v 869.505n 1.7v 879.495n 1.7v 879.505n 1.7v 889.495n 1.7v 889.505n 1.7v 899.495n 1.7v 899.505n 0.0v 909.495n 0.0v 909.505n 0.0v 919.495n 0.0v 919.505n 1.7v 929.495n 1.7v 929.505n 1.7v 939.495n 1.7v 939.505n 1.7v 949.495n 1.7v 949.505n 0.0v 959.495n 0.0v 959.505n 0.0v 969.495n 0.0v 969.505n 0.0v 979.495n 0.0v 979.505n 1.7v 989.495n 1.7v 989.505n 0.0v 999.495n 0.0v 999.505n 0.0v 1009.495n 0.0v 1009.505n 0.0v 1019.495n 0.0v 1019.505n 0.0v 1029.495n 0.0v 1029.505n 0.0v 1039.495n 0.0v 1039.505n 1.7v 1049.495n 1.7v 1049.505n 0.0v 1059.495n 0.0v 1059.505n 0.0v 1069.495n 0.0v 1069.505n 0.0v 1079.495n 0.0v 1079.505n 0.0v 1089.495n 0.0v 1089.505n 0.0v 1099.495n 0.0v 1099.505n 0.0v 1109.495n 0.0v 1109.505n 0.0v 1119.495n 0.0v 1119.505n 0.0v 1129.495n 0.0v 1129.505n 0.0v 1139.495n 0.0v 1139.505n 0.0v 1149.495n 0.0v 1149.505n 0.0v 1159.495n 0.0v 1159.505n 1.7v 1169.495n 1.7v 1169.505n 1.7v 1179.495n 1.7v 1179.505n 0.0v 1189.495n 0.0v 1189.505n 0.0v 1199.495n 0.0v 1199.505n 0.0v 1209.495n 0.0v 1209.505n 0.0v 1219.495n 0.0v 1219.505n 0.0v 1229.495n 0.0v 1229.505n 1.7v 1239.495n 1.7v 1239.505n 1.7v 1249.495n 1.7v 1249.505n 1.7v 1259.495n 1.7v 1259.505n 1.7v 1269.495n 1.7v 1269.505n 1.7v 1279.495n 1.7v 1279.505n 0.0v 1289.495n 0.0v 1289.505n 0.0v 1299.495n 0.0v 1299.505n 0.0v 1309.495n 0.0v 1309.505n 0.0v 1319.495n 0.0v 1319.505n 0.0v 1329.495n 0.0v 1329.505n 1.7v 1339.495n 1.7v 1339.505n 1.7v 1349.495n 1.7v 1349.505n 1.7v 1359.495n 1.7v 1359.505n 1.7v 1369.495n 1.7v 1369.505n 1.7v 1379.495n 1.7v 1379.505n 1.7v 1389.495n 1.7v 1389.505n 1.7v 1399.495n 1.7v 1399.505n 0.0v 1409.495n 0.0v 1409.505n 0.0v 1419.495n 0.0v 1419.505n 0.0v 1429.495n 0.0v 1429.505n 0.0v 1439.495n 0.0v 1439.505n 0.0v 1449.495n 0.0v 1449.505n 0.0v 1459.495n 0.0v 1459.505n 0.0v 1469.495n 0.0v 1469.505n 0.0v 1479.495n 0.0v 1479.505n 0.0v 1489.495n 0.0v 1489.505n 0.0v 1499.495n 0.0v 1499.505n 0.0v 1509.495n 0.0v 1509.505n 0.0v 1519.495n 0.0v 1519.505n 1.7v 1529.495n 1.7v 1529.505n 1.7v 1539.495n 1.7v 1539.505n 0.0v 1549.495n 0.0v 1549.505n 0.0v 1559.495n 0.0v 1559.505n 0.0v 1569.495n 0.0v 1569.505n 0.0v 1579.495n 0.0v 1579.505n 0.0v 1589.495n 0.0v 1589.505n 0.0v 1599.495n 0.0v 1599.505n 0.0v 1609.495n 0.0v 1609.505n 0.0v 1619.495n 0.0v 1619.505n 0.0v 1629.495n 0.0v 1629.505n 1.7v 1639.495n 1.7v 1639.505n 1.7v 1649.495n 1.7v 1649.505n 0.0v 1659.495n 0.0v 1659.505n 1.7v 1669.495n 1.7v 1669.505n 1.7v 1679.495n 1.7v 1679.505n 1.7v 1689.495n 1.7v 1689.505n 1.7v 1699.495n 1.7v 1699.505n 0.0v 1709.495n 0.0v 1709.505n 0.0v 1719.495n 0.0v 1719.505n 0.0v 1729.495n 0.0v 1729.505n 0.0v 1739.495n 0.0v 1739.505n 0.0v 1749.495n 0.0v 1749.505n 0.0v 1759.495n 0.0v 1759.505n 1.7v 1769.495n 1.7v 1769.505n 0.0v 1779.495n 0.0v 1779.505n 1.7v 1789.495n 1.7v 1789.505n 1.7v 1799.495n 1.7v 1799.505n 0.0v 1809.495n 0.0v 1809.505n 0.0v 1819.495n 0.0v 1819.505n 1.7v 1829.495n 1.7v 1829.505n 0.0v 1839.495n 0.0v 1839.505n 0.0v 1849.495n 0.0v 1849.505n 0.0v 1859.495n 0.0v 1859.505n 0.0v 1869.495n 0.0v 1869.505n 1.7v 1879.495n 1.7v 1879.505n 1.7v 1889.495n 1.7v 1889.505n 1.7v 1899.495n 1.7v 1899.505n 0.0v 1909.495n 0.0v 1909.505n 1.7v 1919.495n 1.7v 1919.505n 0.0v 1929.495n 0.0v 1929.505n 1.7v 1939.495n 1.7v 1939.505n 1.7v 1949.495n 1.7v 1949.505n 0.0v 1959.495n 0.0v 1959.505n 0.0v 1969.495n 0.0v 1969.505n 0.0v 1979.495n 0.0v 1979.505n 0.0v 1989.495n 0.0v 1989.505n 1.7v 1999.495n 1.7v 1999.505n 1.7v 2009.495n 1.7v 2009.505n 1.7v 2019.495n 1.7v 2019.505n 0.0v 2029.495n 0.0v 2029.505n 0.0v 2039.495n 0.0v 2039.505n 1.7v 2049.495n 1.7v 2049.505n 1.7v )
* (time, data): [(0, 0), (10, 0), (20, 0), (30, 0), (40, 0), (50, 0), (60, 0), (70, 0), (80, 0), (90, 0), (100, 0), (110, 0), (120, 0), (130, 0), (140, 0), (150, 0), (160, 0), (170, 0), (180, 0), (190, 0), (200, 1), (210, 1), (220, 1), (230, 0), (240, 0), (250, 0), (260, 0), (270, 0), (280, 0), (290, 1), (300, 1), (310, 1), (320, 0), (330, 0), (340, 0), (350, 0), (360, 0), (370, 1), (380, 1), (390, 0), (400, 0), (410, 0), (420, 0), (430, 0), (440, 0), (450, 0), (460, 1), (470, 1), (480, 0), (490, 1), (500, 0), (510, 0), (520, 0), (530, 0), (540, 0), (550, 0), (560, 0), (570, 0), (580, 0), (590, 0), (600, 0), (610, 0), (620, 0), (630, 1), (640, 1), (650, 1), (660, 1), (670, 0), (680, 1), (690, 0), (700, 1), (710, 1), (720, 1), (730, 1), (740, 1), (750, 0), (760, 0), (770, 0), (780, 0), (790, 0), (800, 1), (810, 1), (820, 0), (830, 0), (840, 0), (850, 0), (860, 1), (870, 1), (880, 1), (890, 1), (900, 0), (910, 0), (920, 1), (930, 1), (940, 1), (950, 0), (960, 0), (970, 0), (980, 1), (990, 0), (1000, 0), (1010, 0), (1020, 0), (1030, 0), (1040, 1), (1050, 0), (1060, 0), (1070, 0), (1080, 0), (1090, 0), (1100, 0), (1110, 0), (1120, 0), (1130, 0), (1140, 0), (1150, 0), (1160, 1), (1170, 1), (1180, 0), (1190, 0), (1200, 0), (1210, 0), (1220, 0), (1230, 1), (1240, 1), (1250, 1), (1260, 1), (1270, 1), (1280, 0), (1290, 0), (1300, 0), (1310, 0), (1320, 0), (1330, 1), (1340, 1), (1350, 1), (1360, 1), (1370, 1), (1380, 1), (1390, 1), (1400, 0), (1410, 0), (1420, 0), (1430, 0), (1440, 0), (1450, 0), (1460, 0), (1470, 0), (1480, 0), (1490, 0), (1500, 0), (1510, 0), (1520, 1), (1530, 1), (1540, 0), (1550, 0), (1560, 0), (1570, 0), (1580, 0), (1590, 0), (1600, 0), (1610, 0), (1620, 0), (1630, 1), (1640, 1), (1650, 0), (1660, 1), (1670, 1), (1680, 1), (1690, 1), (1700, 0), (1710, 0), (1720, 0), (1730, 0), (1740, 0), (1750, 0), (1760, 1), (1770, 0), (1780, 1), (1790, 1), (1800, 0), (1810, 0), (1820, 1), (1830, 0), (1840, 0), (1850, 0), (1860, 0), (1870, 1), (1880, 1), (1890, 1), (1900, 0), (1910, 1), (1920, 0), (1930, 1), (1940, 1), (1950, 0), (1960, 0), (1970, 0), (1980, 0), (1990, 1), (2000, 1), (2010, 1), (2020, 0), (2030, 0), (2040, 1), (2050, 1)]
Va0_4  a0_4  0 PWL (0n 0.0v 9.495n 0.0v 9.505n 0.0v 19.495n 0.0v 19.505n 0.0v 29.495n 0.0v 29.505n 0.0v 39.495n 0.0v 39.505n 0.0v 49.495n 0.0v 49.505n 0.0v 59.495n 0.0v 59.505n 0.0v 69.495n 0.0v 69.505n 0.0v 79.495n 0.0v 79.505n 0.0v 89.495n 0.0v 89.505n 0.0v 99.495n 0.0v 99.505n 0.0v 109.495n 0.0v 109.505n 0.0v 119.495n 0.0v 119.505n 0.0v 129.495n 0.0v 129.505n 0.0v 139.495n 0.0v 139.505n 0.0v 149.495n 0.0v 149.505n 0.0v 159.495n 0.0v 159.505n 0.0v 169.495n 0.0v 169.505n 0.0v 179.495n 0.0v 179.505n 0.0v 189.495n 0.0v 189.505n 0.0v 199.495n 0.0v 199.505n 1.7v 209.495n 1.7v 209.505n 1.7v 219.495n 1.7v 219.505n 1.7v 229.495n 1.7v 229.505n 0.0v 239.495n 0.0v 239.505n 0.0v 249.495n 0.0v 249.505n 0.0v 259.495n 0.0v 259.505n 0.0v 269.495n 0.0v 269.505n 0.0v 279.495n 0.0v 279.505n 0.0v 289.495n 0.0v 289.505n 1.7v 299.495n 1.7v 299.505n 1.7v 309.495n 1.7v 309.505n 1.7v 319.495n 1.7v 319.505n 0.0v 329.495n 0.0v 329.505n 0.0v 339.495n 0.0v 339.505n 0.0v 349.495n 0.0v 349.505n 0.0v 359.495n 0.0v 359.505n 0.0v 369.495n 0.0v 369.505n 1.7v 379.495n 1.7v 379.505n 1.7v 389.495n 1.7v 389.505n 0.0v 399.495n 0.0v 399.505n 0.0v 409.495n 0.0v 409.505n 0.0v 419.495n 0.0v 419.505n 0.0v 429.495n 0.0v 429.505n 0.0v 439.495n 0.0v 439.505n 0.0v 449.495n 0.0v 449.505n 0.0v 459.495n 0.0v 459.505n 1.7v 469.495n 1.7v 469.505n 1.7v 479.495n 1.7v 479.505n 0.0v 489.495n 0.0v 489.505n 1.7v 499.495n 1.7v 499.505n 0.0v 509.495n 0.0v 509.505n 0.0v 519.495n 0.0v 519.505n 0.0v 529.495n 0.0v 529.505n 0.0v 539.495n 0.0v 539.505n 0.0v 549.495n 0.0v 549.505n 0.0v 559.495n 0.0v 559.505n 0.0v 569.495n 0.0v 569.505n 0.0v 579.495n 0.0v 579.505n 0.0v 589.495n 0.0v 589.505n 0.0v 599.495n 0.0v 599.505n 0.0v 609.495n 0.0v 609.505n 0.0v 619.495n 0.0v 619.505n 0.0v 629.495n 0.0v 629.505n 1.7v 639.495n 1.7v 639.505n 1.7v 649.495n 1.7v 649.505n 1.7v 659.495n 1.7v 659.505n 1.7v 669.495n 1.7v 669.505n 0.0v 679.495n 0.0v 679.505n 1.7v 689.495n 1.7v 689.505n 0.0v 699.495n 0.0v 699.505n 1.7v 709.495n 1.7v 709.505n 1.7v 719.495n 1.7v 719.505n 1.7v 729.495n 1.7v 729.505n 1.7v 739.495n 1.7v 739.505n 1.7v 749.495n 1.7v 749.505n 0.0v 759.495n 0.0v 759.505n 0.0v 769.495n 0.0v 769.505n 0.0v 779.495n 0.0v 779.505n 0.0v 789.495n 0.0v 789.505n 0.0v 799.495n 0.0v 799.505n 1.7v 809.495n 1.7v 809.505n 1.7v 819.495n 1.7v 819.505n 0.0v 829.495n 0.0v 829.505n 0.0v 839.495n 0.0v 839.505n 0.0v 849.495n 0.0v 849.505n 0.0v 859.495n 0.0v 859.505n 1.7v 869.495n 1.7v 869.505n 1.7v 879.495n 1.7v 879.505n 1.7v 889.495n 1.7v 889.505n 1.7v 899.495n 1.7v 899.505n 0.0v 909.495n 0.0v 909.505n 0.0v 919.495n 0.0v 919.505n 1.7v 929.495n 1.7v 929.505n 1.7v 939.495n 1.7v 939.505n 1.7v 949.495n 1.7v 949.505n 0.0v 959.495n 0.0v 959.505n 0.0v 969.495n 0.0v 969.505n 0.0v 979.495n 0.0v 979.505n 1.7v 989.495n 1.7v 989.505n 0.0v 999.495n 0.0v 999.505n 0.0v 1009.495n 0.0v 1009.505n 0.0v 1019.495n 0.0v 1019.505n 0.0v 1029.495n 0.0v 1029.505n 0.0v 1039.495n 0.0v 1039.505n 1.7v 1049.495n 1.7v 1049.505n 0.0v 1059.495n 0.0v 1059.505n 0.0v 1069.495n 0.0v 1069.505n 0.0v 1079.495n 0.0v 1079.505n 0.0v 1089.495n 0.0v 1089.505n 0.0v 1099.495n 0.0v 1099.505n 0.0v 1109.495n 0.0v 1109.505n 0.0v 1119.495n 0.0v 1119.505n 0.0v 1129.495n 0.0v 1129.505n 0.0v 1139.495n 0.0v 1139.505n 0.0v 1149.495n 0.0v 1149.505n 0.0v 1159.495n 0.0v 1159.505n 1.7v 1169.495n 1.7v 1169.505n 1.7v 1179.495n 1.7v 1179.505n 0.0v 1189.495n 0.0v 1189.505n 0.0v 1199.495n 0.0v 1199.505n 0.0v 1209.495n 0.0v 1209.505n 0.0v 1219.495n 0.0v 1219.505n 0.0v 1229.495n 0.0v 1229.505n 1.7v 1239.495n 1.7v 1239.505n 1.7v 1249.495n 1.7v 1249.505n 1.7v 1259.495n 1.7v 1259.505n 1.7v 1269.495n 1.7v 1269.505n 1.7v 1279.495n 1.7v 1279.505n 0.0v 1289.495n 0.0v 1289.505n 0.0v 1299.495n 0.0v 1299.505n 0.0v 1309.495n 0.0v 1309.505n 0.0v 1319.495n 0.0v 1319.505n 0.0v 1329.495n 0.0v 1329.505n 1.7v 1339.495n 1.7v 1339.505n 1.7v 1349.495n 1.7v 1349.505n 1.7v 1359.495n 1.7v 1359.505n 1.7v 1369.495n 1.7v 1369.505n 1.7v 1379.495n 1.7v 1379.505n 1.7v 1389.495n 1.7v 1389.505n 1.7v 1399.495n 1.7v 1399.505n 0.0v 1409.495n 0.0v 1409.505n 0.0v 1419.495n 0.0v 1419.505n 0.0v 1429.495n 0.0v 1429.505n 0.0v 1439.495n 0.0v 1439.505n 0.0v 1449.495n 0.0v 1449.505n 0.0v 1459.495n 0.0v 1459.505n 0.0v 1469.495n 0.0v 1469.505n 0.0v 1479.495n 0.0v 1479.505n 0.0v 1489.495n 0.0v 1489.505n 0.0v 1499.495n 0.0v 1499.505n 0.0v 1509.495n 0.0v 1509.505n 0.0v 1519.495n 0.0v 1519.505n 1.7v 1529.495n 1.7v 1529.505n 1.7v 1539.495n 1.7v 1539.505n 0.0v 1549.495n 0.0v 1549.505n 0.0v 1559.495n 0.0v 1559.505n 0.0v 1569.495n 0.0v 1569.505n 0.0v 1579.495n 0.0v 1579.505n 0.0v 1589.495n 0.0v 1589.505n 0.0v 1599.495n 0.0v 1599.505n 0.0v 1609.495n 0.0v 1609.505n 0.0v 1619.495n 0.0v 1619.505n 0.0v 1629.495n 0.0v 1629.505n 1.7v 1639.495n 1.7v 1639.505n 1.7v 1649.495n 1.7v 1649.505n 0.0v 1659.495n 0.0v 1659.505n 1.7v 1669.495n 1.7v 1669.505n 1.7v 1679.495n 1.7v 1679.505n 1.7v 1689.495n 1.7v 1689.505n 1.7v 1699.495n 1.7v 1699.505n 0.0v 1709.495n 0.0v 1709.505n 0.0v 1719.495n 0.0v 1719.505n 0.0v 1729.495n 0.0v 1729.505n 0.0v 1739.495n 0.0v 1739.505n 0.0v 1749.495n 0.0v 1749.505n 0.0v 1759.495n 0.0v 1759.505n 1.7v 1769.495n 1.7v 1769.505n 0.0v 1779.495n 0.0v 1779.505n 1.7v 1789.495n 1.7v 1789.505n 1.7v 1799.495n 1.7v 1799.505n 0.0v 1809.495n 0.0v 1809.505n 0.0v 1819.495n 0.0v 1819.505n 1.7v 1829.495n 1.7v 1829.505n 0.0v 1839.495n 0.0v 1839.505n 0.0v 1849.495n 0.0v 1849.505n 0.0v 1859.495n 0.0v 1859.505n 0.0v 1869.495n 0.0v 1869.505n 1.7v 1879.495n 1.7v 1879.505n 1.7v 1889.495n 1.7v 1889.505n 1.7v 1899.495n 1.7v 1899.505n 0.0v 1909.495n 0.0v 1909.505n 1.7v 1919.495n 1.7v 1919.505n 0.0v 1929.495n 0.0v 1929.505n 1.7v 1939.495n 1.7v 1939.505n 1.7v 1949.495n 1.7v 1949.505n 0.0v 1959.495n 0.0v 1959.505n 0.0v 1969.495n 0.0v 1969.505n 0.0v 1979.495n 0.0v 1979.505n 0.0v 1989.495n 0.0v 1989.505n 1.7v 1999.495n 1.7v 1999.505n 1.7v 2009.495n 1.7v 2009.505n 1.7v 2019.495n 1.7v 2019.505n 0.0v 2029.495n 0.0v 2029.505n 0.0v 2039.495n 0.0v 2039.505n 1.7v 2049.495n 1.7v 2049.505n 1.7v )
* (time, data): [(0, 0), (10, 0), (20, 0), (30, 0), (40, 0), (50, 0), (60, 0), (70, 0), (80, 0), (90, 0), (100, 0), (110, 0), (120, 0), (130, 0), (140, 0), (150, 0), (160, 0), (170, 0), (180, 0), (190, 0), (200, 1), (210, 1), (220, 1), (230, 0), (240, 0), (250, 0), (260, 0), (270, 0), (280, 0), (290, 1), (300, 1), (310, 1), (320, 0), (330, 0), (340, 0), (350, 0), (360, 0), (370, 1), (380, 1), (390, 0), (400, 0), (410, 0), (420, 0), (430, 0), (440, 0), (450, 0), (460, 1), (470, 1), (480, 0), (490, 1), (500, 0), (510, 0), (520, 0), (530, 0), (540, 0), (550, 0), (560, 0), (570, 0), (580, 0), (590, 0), (600, 0), (610, 0), (620, 0), (630, 1), (640, 1), (650, 1), (660, 1), (670, 0), (680, 1), (690, 0), (700, 1), (710, 1), (720, 1), (730, 1), (740, 1), (750, 0), (760, 0), (770, 0), (780, 0), (790, 0), (800, 1), (810, 1), (820, 0), (830, 0), (840, 0), (850, 0), (860, 1), (870, 1), (880, 1), (890, 1), (900, 0), (910, 0), (920, 1), (930, 1), (940, 1), (950, 0), (960, 0), (970, 0), (980, 1), (990, 0), (1000, 0), (1010, 0), (1020, 0), (1030, 0), (1040, 1), (1050, 0), (1060, 0), (1070, 0), (1080, 0), (1090, 0), (1100, 0), (1110, 0), (1120, 0), (1130, 0), (1140, 0), (1150, 0), (1160, 1), (1170, 1), (1180, 0), (1190, 0), (1200, 0), (1210, 0), (1220, 0), (1230, 1), (1240, 1), (1250, 1), (1260, 1), (1270, 1), (1280, 0), (1290, 0), (1300, 0), (1310, 0), (1320, 0), (1330, 1), (1340, 1), (1350, 1), (1360, 1), (1370, 1), (1380, 1), (1390, 1), (1400, 0), (1410, 0), (1420, 0), (1430, 0), (1440, 0), (1450, 0), (1460, 0), (1470, 0), (1480, 0), (1490, 0), (1500, 0), (1510, 0), (1520, 1), (1530, 1), (1540, 0), (1550, 0), (1560, 0), (1570, 0), (1580, 0), (1590, 0), (1600, 0), (1610, 0), (1620, 0), (1630, 1), (1640, 1), (1650, 0), (1660, 1), (1670, 1), (1680, 1), (1690, 1), (1700, 0), (1710, 0), (1720, 0), (1730, 0), (1740, 0), (1750, 0), (1760, 1), (1770, 0), (1780, 1), (1790, 1), (1800, 0), (1810, 0), (1820, 1), (1830, 0), (1840, 0), (1850, 0), (1860, 0), (1870, 1), (1880, 1), (1890, 1), (1900, 0), (1910, 1), (1920, 0), (1930, 1), (1940, 1), (1950, 0), (1960, 0), (1970, 0), (1980, 0), (1990, 1), (2000, 1), (2010, 1), (2020, 0), (2030, 0), (2040, 1), (2050, 1)]
Va0_5  a0_5  0 PWL (0n 0.0v 9.495n 0.0v 9.505n 0.0v 19.495n 0.0v 19.505n 0.0v 29.495n 0.0v 29.505n 0.0v 39.495n 0.0v 39.505n 0.0v 49.495n 0.0v 49.505n 0.0v 59.495n 0.0v 59.505n 0.0v 69.495n 0.0v 69.505n 0.0v 79.495n 0.0v 79.505n 0.0v 89.495n 0.0v 89.505n 0.0v 99.495n 0.0v 99.505n 0.0v 109.495n 0.0v 109.505n 0.0v 119.495n 0.0v 119.505n 0.0v 129.495n 0.0v 129.505n 0.0v 139.495n 0.0v 139.505n 0.0v 149.495n 0.0v 149.505n 0.0v 159.495n 0.0v 159.505n 0.0v 169.495n 0.0v 169.505n 0.0v 179.495n 0.0v 179.505n 0.0v 189.495n 0.0v 189.505n 0.0v 199.495n 0.0v 199.505n 1.7v 209.495n 1.7v 209.505n 1.7v 219.495n 1.7v 219.505n 1.7v 229.495n 1.7v 229.505n 0.0v 239.495n 0.0v 239.505n 0.0v 249.495n 0.0v 249.505n 0.0v 259.495n 0.0v 259.505n 0.0v 269.495n 0.0v 269.505n 0.0v 279.495n 0.0v 279.505n 0.0v 289.495n 0.0v 289.505n 1.7v 299.495n 1.7v 299.505n 1.7v 309.495n 1.7v 309.505n 1.7v 319.495n 1.7v 319.505n 0.0v 329.495n 0.0v 329.505n 0.0v 339.495n 0.0v 339.505n 0.0v 349.495n 0.0v 349.505n 0.0v 359.495n 0.0v 359.505n 0.0v 369.495n 0.0v 369.505n 1.7v 379.495n 1.7v 379.505n 1.7v 389.495n 1.7v 389.505n 0.0v 399.495n 0.0v 399.505n 0.0v 409.495n 0.0v 409.505n 0.0v 419.495n 0.0v 419.505n 0.0v 429.495n 0.0v 429.505n 0.0v 439.495n 0.0v 439.505n 0.0v 449.495n 0.0v 449.505n 0.0v 459.495n 0.0v 459.505n 1.7v 469.495n 1.7v 469.505n 1.7v 479.495n 1.7v 479.505n 0.0v 489.495n 0.0v 489.505n 1.7v 499.495n 1.7v 499.505n 0.0v 509.495n 0.0v 509.505n 0.0v 519.495n 0.0v 519.505n 0.0v 529.495n 0.0v 529.505n 0.0v 539.495n 0.0v 539.505n 0.0v 549.495n 0.0v 549.505n 0.0v 559.495n 0.0v 559.505n 0.0v 569.495n 0.0v 569.505n 0.0v 579.495n 0.0v 579.505n 0.0v 589.495n 0.0v 589.505n 0.0v 599.495n 0.0v 599.505n 0.0v 609.495n 0.0v 609.505n 0.0v 619.495n 0.0v 619.505n 0.0v 629.495n 0.0v 629.505n 1.7v 639.495n 1.7v 639.505n 1.7v 649.495n 1.7v 649.505n 1.7v 659.495n 1.7v 659.505n 1.7v 669.495n 1.7v 669.505n 0.0v 679.495n 0.0v 679.505n 1.7v 689.495n 1.7v 689.505n 0.0v 699.495n 0.0v 699.505n 1.7v 709.495n 1.7v 709.505n 1.7v 719.495n 1.7v 719.505n 1.7v 729.495n 1.7v 729.505n 1.7v 739.495n 1.7v 739.505n 1.7v 749.495n 1.7v 749.505n 0.0v 759.495n 0.0v 759.505n 0.0v 769.495n 0.0v 769.505n 0.0v 779.495n 0.0v 779.505n 0.0v 789.495n 0.0v 789.505n 0.0v 799.495n 0.0v 799.505n 1.7v 809.495n 1.7v 809.505n 1.7v 819.495n 1.7v 819.505n 0.0v 829.495n 0.0v 829.505n 0.0v 839.495n 0.0v 839.505n 0.0v 849.495n 0.0v 849.505n 0.0v 859.495n 0.0v 859.505n 1.7v 869.495n 1.7v 869.505n 1.7v 879.495n 1.7v 879.505n 1.7v 889.495n 1.7v 889.505n 1.7v 899.495n 1.7v 899.505n 0.0v 909.495n 0.0v 909.505n 0.0v 919.495n 0.0v 919.505n 1.7v 929.495n 1.7v 929.505n 1.7v 939.495n 1.7v 939.505n 1.7v 949.495n 1.7v 949.505n 0.0v 959.495n 0.0v 959.505n 0.0v 969.495n 0.0v 969.505n 0.0v 979.495n 0.0v 979.505n 1.7v 989.495n 1.7v 989.505n 0.0v 999.495n 0.0v 999.505n 0.0v 1009.495n 0.0v 1009.505n 0.0v 1019.495n 0.0v 1019.505n 0.0v 1029.495n 0.0v 1029.505n 0.0v 1039.495n 0.0v 1039.505n 1.7v 1049.495n 1.7v 1049.505n 0.0v 1059.495n 0.0v 1059.505n 0.0v 1069.495n 0.0v 1069.505n 0.0v 1079.495n 0.0v 1079.505n 0.0v 1089.495n 0.0v 1089.505n 0.0v 1099.495n 0.0v 1099.505n 0.0v 1109.495n 0.0v 1109.505n 0.0v 1119.495n 0.0v 1119.505n 0.0v 1129.495n 0.0v 1129.505n 0.0v 1139.495n 0.0v 1139.505n 0.0v 1149.495n 0.0v 1149.505n 0.0v 1159.495n 0.0v 1159.505n 1.7v 1169.495n 1.7v 1169.505n 1.7v 1179.495n 1.7v 1179.505n 0.0v 1189.495n 0.0v 1189.505n 0.0v 1199.495n 0.0v 1199.505n 0.0v 1209.495n 0.0v 1209.505n 0.0v 1219.495n 0.0v 1219.505n 0.0v 1229.495n 0.0v 1229.505n 1.7v 1239.495n 1.7v 1239.505n 1.7v 1249.495n 1.7v 1249.505n 1.7v 1259.495n 1.7v 1259.505n 1.7v 1269.495n 1.7v 1269.505n 1.7v 1279.495n 1.7v 1279.505n 0.0v 1289.495n 0.0v 1289.505n 0.0v 1299.495n 0.0v 1299.505n 0.0v 1309.495n 0.0v 1309.505n 0.0v 1319.495n 0.0v 1319.505n 0.0v 1329.495n 0.0v 1329.505n 1.7v 1339.495n 1.7v 1339.505n 1.7v 1349.495n 1.7v 1349.505n 1.7v 1359.495n 1.7v 1359.505n 1.7v 1369.495n 1.7v 1369.505n 1.7v 1379.495n 1.7v 1379.505n 1.7v 1389.495n 1.7v 1389.505n 1.7v 1399.495n 1.7v 1399.505n 0.0v 1409.495n 0.0v 1409.505n 0.0v 1419.495n 0.0v 1419.505n 0.0v 1429.495n 0.0v 1429.505n 0.0v 1439.495n 0.0v 1439.505n 0.0v 1449.495n 0.0v 1449.505n 0.0v 1459.495n 0.0v 1459.505n 0.0v 1469.495n 0.0v 1469.505n 0.0v 1479.495n 0.0v 1479.505n 0.0v 1489.495n 0.0v 1489.505n 0.0v 1499.495n 0.0v 1499.505n 0.0v 1509.495n 0.0v 1509.505n 0.0v 1519.495n 0.0v 1519.505n 1.7v 1529.495n 1.7v 1529.505n 1.7v 1539.495n 1.7v 1539.505n 0.0v 1549.495n 0.0v 1549.505n 0.0v 1559.495n 0.0v 1559.505n 0.0v 1569.495n 0.0v 1569.505n 0.0v 1579.495n 0.0v 1579.505n 0.0v 1589.495n 0.0v 1589.505n 0.0v 1599.495n 0.0v 1599.505n 0.0v 1609.495n 0.0v 1609.505n 0.0v 1619.495n 0.0v 1619.505n 0.0v 1629.495n 0.0v 1629.505n 1.7v 1639.495n 1.7v 1639.505n 1.7v 1649.495n 1.7v 1649.505n 0.0v 1659.495n 0.0v 1659.505n 1.7v 1669.495n 1.7v 1669.505n 1.7v 1679.495n 1.7v 1679.505n 1.7v 1689.495n 1.7v 1689.505n 1.7v 1699.495n 1.7v 1699.505n 0.0v 1709.495n 0.0v 1709.505n 0.0v 1719.495n 0.0v 1719.505n 0.0v 1729.495n 0.0v 1729.505n 0.0v 1739.495n 0.0v 1739.505n 0.0v 1749.495n 0.0v 1749.505n 0.0v 1759.495n 0.0v 1759.505n 1.7v 1769.495n 1.7v 1769.505n 0.0v 1779.495n 0.0v 1779.505n 1.7v 1789.495n 1.7v 1789.505n 1.7v 1799.495n 1.7v 1799.505n 0.0v 1809.495n 0.0v 1809.505n 0.0v 1819.495n 0.0v 1819.505n 1.7v 1829.495n 1.7v 1829.505n 0.0v 1839.495n 0.0v 1839.505n 0.0v 1849.495n 0.0v 1849.505n 0.0v 1859.495n 0.0v 1859.505n 0.0v 1869.495n 0.0v 1869.505n 1.7v 1879.495n 1.7v 1879.505n 1.7v 1889.495n 1.7v 1889.505n 1.7v 1899.495n 1.7v 1899.505n 0.0v 1909.495n 0.0v 1909.505n 1.7v 1919.495n 1.7v 1919.505n 0.0v 1929.495n 0.0v 1929.505n 1.7v 1939.495n 1.7v 1939.505n 1.7v 1949.495n 1.7v 1949.505n 0.0v 1959.495n 0.0v 1959.505n 0.0v 1969.495n 0.0v 1969.505n 0.0v 1979.495n 0.0v 1979.505n 0.0v 1989.495n 0.0v 1989.505n 1.7v 1999.495n 1.7v 1999.505n 1.7v 2009.495n 1.7v 2009.505n 1.7v 2019.495n 1.7v 2019.505n 0.0v 2029.495n 0.0v 2029.505n 0.0v 2039.495n 0.0v 2039.505n 1.7v 2049.495n 1.7v 2049.505n 1.7v )
* (time, data): [(0, 0), (10, 0), (20, 0), (30, 0), (40, 0), (50, 0), (60, 0), (70, 0), (80, 0), (90, 0), (100, 0), (110, 0), (120, 0), (130, 0), (140, 0), (150, 0), (160, 0), (170, 0), (180, 0), (190, 0), (200, 1), (210, 1), (220, 1), (230, 0), (240, 0), (250, 0), (260, 0), (270, 0), (280, 0), (290, 1), (300, 1), (310, 1), (320, 0), (330, 0), (340, 0), (350, 0), (360, 0), (370, 1), (380, 1), (390, 0), (400, 0), (410, 0), (420, 0), (430, 0), (440, 0), (450, 0), (460, 1), (470, 1), (480, 0), (490, 1), (500, 0), (510, 0), (520, 0), (530, 0), (540, 0), (550, 0), (560, 0), (570, 0), (580, 0), (590, 0), (600, 0), (610, 0), (620, 0), (630, 1), (640, 1), (650, 1), (660, 1), (670, 0), (680, 1), (690, 0), (700, 1), (710, 1), (720, 1), (730, 1), (740, 1), (750, 0), (760, 0), (770, 0), (780, 0), (790, 0), (800, 1), (810, 1), (820, 0), (830, 0), (840, 0), (850, 0), (860, 1), (870, 1), (880, 1), (890, 1), (900, 0), (910, 0), (920, 1), (930, 1), (940, 1), (950, 0), (960, 0), (970, 0), (980, 1), (990, 0), (1000, 0), (1010, 0), (1020, 0), (1030, 0), (1040, 1), (1050, 0), (1060, 0), (1070, 0), (1080, 0), (1090, 0), (1100, 0), (1110, 0), (1120, 0), (1130, 0), (1140, 0), (1150, 0), (1160, 1), (1170, 1), (1180, 0), (1190, 0), (1200, 0), (1210, 0), (1220, 0), (1230, 1), (1240, 1), (1250, 1), (1260, 1), (1270, 1), (1280, 0), (1290, 0), (1300, 0), (1310, 0), (1320, 0), (1330, 1), (1340, 1), (1350, 1), (1360, 1), (1370, 1), (1380, 1), (1390, 1), (1400, 0), (1410, 0), (1420, 0), (1430, 0), (1440, 0), (1450, 0), (1460, 0), (1470, 0), (1480, 0), (1490, 0), (1500, 0), (1510, 0), (1520, 1), (1530, 1), (1540, 0), (1550, 0), (1560, 0), (1570, 0), (1580, 0), (1590, 0), (1600, 0), (1610, 0), (1620, 0), (1630, 1), (1640, 1), (1650, 0), (1660, 1), (1670, 1), (1680, 1), (1690, 1), (1700, 0), (1710, 0), (1720, 0), (1730, 0), (1740, 0), (1750, 0), (1760, 1), (1770, 0), (1780, 1), (1790, 1), (1800, 0), (1810, 0), (1820, 1), (1830, 0), (1840, 0), (1850, 0), (1860, 0), (1870, 1), (1880, 1), (1890, 1), (1900, 0), (1910, 1), (1920, 0), (1930, 1), (1940, 1), (1950, 0), (1960, 0), (1970, 0), (1980, 0), (1990, 1), (2000, 1), (2010, 1), (2020, 0), (2030, 0), (2040, 1), (2050, 1)]
Va0_6  a0_6  0 PWL (0n 0.0v 9.495n 0.0v 9.505n 0.0v 19.495n 0.0v 19.505n 0.0v 29.495n 0.0v 29.505n 0.0v 39.495n 0.0v 39.505n 0.0v 49.495n 0.0v 49.505n 0.0v 59.495n 0.0v 59.505n 0.0v 69.495n 0.0v 69.505n 0.0v 79.495n 0.0v 79.505n 0.0v 89.495n 0.0v 89.505n 0.0v 99.495n 0.0v 99.505n 0.0v 109.495n 0.0v 109.505n 0.0v 119.495n 0.0v 119.505n 0.0v 129.495n 0.0v 129.505n 0.0v 139.495n 0.0v 139.505n 0.0v 149.495n 0.0v 149.505n 0.0v 159.495n 0.0v 159.505n 0.0v 169.495n 0.0v 169.505n 0.0v 179.495n 0.0v 179.505n 0.0v 189.495n 0.0v 189.505n 0.0v 199.495n 0.0v 199.505n 1.7v 209.495n 1.7v 209.505n 1.7v 219.495n 1.7v 219.505n 1.7v 229.495n 1.7v 229.505n 0.0v 239.495n 0.0v 239.505n 0.0v 249.495n 0.0v 249.505n 0.0v 259.495n 0.0v 259.505n 0.0v 269.495n 0.0v 269.505n 0.0v 279.495n 0.0v 279.505n 0.0v 289.495n 0.0v 289.505n 1.7v 299.495n 1.7v 299.505n 1.7v 309.495n 1.7v 309.505n 1.7v 319.495n 1.7v 319.505n 0.0v 329.495n 0.0v 329.505n 0.0v 339.495n 0.0v 339.505n 0.0v 349.495n 0.0v 349.505n 0.0v 359.495n 0.0v 359.505n 0.0v 369.495n 0.0v 369.505n 1.7v 379.495n 1.7v 379.505n 1.7v 389.495n 1.7v 389.505n 0.0v 399.495n 0.0v 399.505n 0.0v 409.495n 0.0v 409.505n 0.0v 419.495n 0.0v 419.505n 0.0v 429.495n 0.0v 429.505n 0.0v 439.495n 0.0v 439.505n 0.0v 449.495n 0.0v 449.505n 0.0v 459.495n 0.0v 459.505n 1.7v 469.495n 1.7v 469.505n 1.7v 479.495n 1.7v 479.505n 0.0v 489.495n 0.0v 489.505n 1.7v 499.495n 1.7v 499.505n 0.0v 509.495n 0.0v 509.505n 0.0v 519.495n 0.0v 519.505n 0.0v 529.495n 0.0v 529.505n 0.0v 539.495n 0.0v 539.505n 0.0v 549.495n 0.0v 549.505n 0.0v 559.495n 0.0v 559.505n 0.0v 569.495n 0.0v 569.505n 0.0v 579.495n 0.0v 579.505n 0.0v 589.495n 0.0v 589.505n 0.0v 599.495n 0.0v 599.505n 0.0v 609.495n 0.0v 609.505n 0.0v 619.495n 0.0v 619.505n 0.0v 629.495n 0.0v 629.505n 1.7v 639.495n 1.7v 639.505n 1.7v 649.495n 1.7v 649.505n 1.7v 659.495n 1.7v 659.505n 1.7v 669.495n 1.7v 669.505n 0.0v 679.495n 0.0v 679.505n 1.7v 689.495n 1.7v 689.505n 0.0v 699.495n 0.0v 699.505n 1.7v 709.495n 1.7v 709.505n 1.7v 719.495n 1.7v 719.505n 1.7v 729.495n 1.7v 729.505n 1.7v 739.495n 1.7v 739.505n 1.7v 749.495n 1.7v 749.505n 0.0v 759.495n 0.0v 759.505n 0.0v 769.495n 0.0v 769.505n 0.0v 779.495n 0.0v 779.505n 0.0v 789.495n 0.0v 789.505n 0.0v 799.495n 0.0v 799.505n 1.7v 809.495n 1.7v 809.505n 1.7v 819.495n 1.7v 819.505n 0.0v 829.495n 0.0v 829.505n 0.0v 839.495n 0.0v 839.505n 0.0v 849.495n 0.0v 849.505n 0.0v 859.495n 0.0v 859.505n 1.7v 869.495n 1.7v 869.505n 1.7v 879.495n 1.7v 879.505n 1.7v 889.495n 1.7v 889.505n 1.7v 899.495n 1.7v 899.505n 0.0v 909.495n 0.0v 909.505n 0.0v 919.495n 0.0v 919.505n 1.7v 929.495n 1.7v 929.505n 1.7v 939.495n 1.7v 939.505n 1.7v 949.495n 1.7v 949.505n 0.0v 959.495n 0.0v 959.505n 0.0v 969.495n 0.0v 969.505n 0.0v 979.495n 0.0v 979.505n 1.7v 989.495n 1.7v 989.505n 0.0v 999.495n 0.0v 999.505n 0.0v 1009.495n 0.0v 1009.505n 0.0v 1019.495n 0.0v 1019.505n 0.0v 1029.495n 0.0v 1029.505n 0.0v 1039.495n 0.0v 1039.505n 1.7v 1049.495n 1.7v 1049.505n 0.0v 1059.495n 0.0v 1059.505n 0.0v 1069.495n 0.0v 1069.505n 0.0v 1079.495n 0.0v 1079.505n 0.0v 1089.495n 0.0v 1089.505n 0.0v 1099.495n 0.0v 1099.505n 0.0v 1109.495n 0.0v 1109.505n 0.0v 1119.495n 0.0v 1119.505n 0.0v 1129.495n 0.0v 1129.505n 0.0v 1139.495n 0.0v 1139.505n 0.0v 1149.495n 0.0v 1149.505n 0.0v 1159.495n 0.0v 1159.505n 1.7v 1169.495n 1.7v 1169.505n 1.7v 1179.495n 1.7v 1179.505n 0.0v 1189.495n 0.0v 1189.505n 0.0v 1199.495n 0.0v 1199.505n 0.0v 1209.495n 0.0v 1209.505n 0.0v 1219.495n 0.0v 1219.505n 0.0v 1229.495n 0.0v 1229.505n 1.7v 1239.495n 1.7v 1239.505n 1.7v 1249.495n 1.7v 1249.505n 1.7v 1259.495n 1.7v 1259.505n 1.7v 1269.495n 1.7v 1269.505n 1.7v 1279.495n 1.7v 1279.505n 0.0v 1289.495n 0.0v 1289.505n 0.0v 1299.495n 0.0v 1299.505n 0.0v 1309.495n 0.0v 1309.505n 0.0v 1319.495n 0.0v 1319.505n 0.0v 1329.495n 0.0v 1329.505n 1.7v 1339.495n 1.7v 1339.505n 1.7v 1349.495n 1.7v 1349.505n 1.7v 1359.495n 1.7v 1359.505n 1.7v 1369.495n 1.7v 1369.505n 1.7v 1379.495n 1.7v 1379.505n 1.7v 1389.495n 1.7v 1389.505n 1.7v 1399.495n 1.7v 1399.505n 0.0v 1409.495n 0.0v 1409.505n 0.0v 1419.495n 0.0v 1419.505n 0.0v 1429.495n 0.0v 1429.505n 0.0v 1439.495n 0.0v 1439.505n 0.0v 1449.495n 0.0v 1449.505n 0.0v 1459.495n 0.0v 1459.505n 0.0v 1469.495n 0.0v 1469.505n 0.0v 1479.495n 0.0v 1479.505n 0.0v 1489.495n 0.0v 1489.505n 0.0v 1499.495n 0.0v 1499.505n 0.0v 1509.495n 0.0v 1509.505n 0.0v 1519.495n 0.0v 1519.505n 1.7v 1529.495n 1.7v 1529.505n 1.7v 1539.495n 1.7v 1539.505n 0.0v 1549.495n 0.0v 1549.505n 0.0v 1559.495n 0.0v 1559.505n 0.0v 1569.495n 0.0v 1569.505n 0.0v 1579.495n 0.0v 1579.505n 0.0v 1589.495n 0.0v 1589.505n 0.0v 1599.495n 0.0v 1599.505n 0.0v 1609.495n 0.0v 1609.505n 0.0v 1619.495n 0.0v 1619.505n 0.0v 1629.495n 0.0v 1629.505n 1.7v 1639.495n 1.7v 1639.505n 1.7v 1649.495n 1.7v 1649.505n 0.0v 1659.495n 0.0v 1659.505n 1.7v 1669.495n 1.7v 1669.505n 1.7v 1679.495n 1.7v 1679.505n 1.7v 1689.495n 1.7v 1689.505n 1.7v 1699.495n 1.7v 1699.505n 0.0v 1709.495n 0.0v 1709.505n 0.0v 1719.495n 0.0v 1719.505n 0.0v 1729.495n 0.0v 1729.505n 0.0v 1739.495n 0.0v 1739.505n 0.0v 1749.495n 0.0v 1749.505n 0.0v 1759.495n 0.0v 1759.505n 1.7v 1769.495n 1.7v 1769.505n 0.0v 1779.495n 0.0v 1779.505n 1.7v 1789.495n 1.7v 1789.505n 1.7v 1799.495n 1.7v 1799.505n 0.0v 1809.495n 0.0v 1809.505n 0.0v 1819.495n 0.0v 1819.505n 1.7v 1829.495n 1.7v 1829.505n 0.0v 1839.495n 0.0v 1839.505n 0.0v 1849.495n 0.0v 1849.505n 0.0v 1859.495n 0.0v 1859.505n 0.0v 1869.495n 0.0v 1869.505n 1.7v 1879.495n 1.7v 1879.505n 1.7v 1889.495n 1.7v 1889.505n 1.7v 1899.495n 1.7v 1899.505n 0.0v 1909.495n 0.0v 1909.505n 1.7v 1919.495n 1.7v 1919.505n 0.0v 1929.495n 0.0v 1929.505n 1.7v 1939.495n 1.7v 1939.505n 1.7v 1949.495n 1.7v 1949.505n 0.0v 1959.495n 0.0v 1959.505n 0.0v 1969.495n 0.0v 1969.505n 0.0v 1979.495n 0.0v 1979.505n 0.0v 1989.495n 0.0v 1989.505n 1.7v 1999.495n 1.7v 1999.505n 1.7v 2009.495n 1.7v 2009.505n 1.7v 2019.495n 1.7v 2019.505n 0.0v 2029.495n 0.0v 2029.505n 0.0v 2039.495n 0.0v 2039.505n 1.7v 2049.495n 1.7v 2049.505n 1.7v )
* (time, data): [(0, 0), (10, 0), (20, 0), (30, 1), (40, 1), (50, 1), (60, 1), (70, 1), (80, 1), (90, 1), (100, 0), (110, 0), (120, 1), (130, 1), (140, 1), (150, 0), (160, 1), (170, 1), (180, 0), (190, 0), (200, 0), (210, 0), (220, 0), (230, 0), (240, 0), (250, 0), (260, 0), (270, 0), (280, 0), (290, 0), (300, 0), (310, 0), (320, 0), (330, 0), (340, 0), (350, 0), (360, 0), (370, 0), (380, 0), (390, 0), (400, 0), (410, 0), (420, 0), (430, 0), (440, 0), (450, 0), (460, 0), (470, 0), (480, 1), (490, 0), (500, 0), (510, 0), (520, 0), (530, 0), (540, 0), (550, 0), (560, 0), (570, 0), (580, 0), (590, 0), (600, 0), (610, 0), (620, 0), (630, 0), (640, 0), (650, 0), (660, 0), (670, 1), (680, 0), (690, 0), (700, 0), (710, 0), (720, 0), (730, 0), (740, 0), (750, 0), (760, 0), (770, 0), (780, 0), (790, 0), (800, 0), (810, 0), (820, 0), (830, 1), (840, 1), (850, 1), (860, 0), (870, 0), (880, 0), (890, 0), (900, 0), (910, 0), (920, 0), (930, 0), (940, 0), (950, 1), (960, 1), (970, 0), (980, 0), (990, 0), (1000, 1), (1010, 1), (1020, 1), (1030, 0), (1040, 0), (1050, 0), (1060, 0), (1070, 0), (1080, 0), (1090, 0), (1100, 0), (1110, 0), (1120, 0), (1130, 0), (1140, 0), (1150, 0), (1160, 0), (1170, 0), (1180, 1), (1190, 1), (1200, 1), (1210, 1), (1220, 1), (1230, 0), (1240, 0), (1250, 0), (1260, 0), (1270, 0), (1280, 0), (1290, 0), (1300, 0), (1310, 0), (1320, 0), (1330, 0), (1340, 0), (1350, 0), (1360, 0), (1370, 0), (1380, 0), (1390, 0), (1400, 0), (1410, 0), (1420, 0), (1430, 1), (1440, 0), (1450, 0), (1460, 0), (1470, 0), (1480, 0), (1490, 0), (1500, 0), (1510, 0), (1520, 0), (1530, 0), (1540, 1), (1550, 1), (1560, 1), (1570, 0), (1580, 1), (1590, 1), (1600, 1), (1610, 1), (1620, 1), (1630, 0), (1640, 0), (1650, 1), (1660, 0), (1670, 0), (1680, 0), (1690, 0), (1700, 0), (1710, 0), (1720, 0), (1730, 0), (1740, 1), (1750, 1), (1760, 0), (1770, 0), (1780, 0), (1790, 0), (1800, 1), (1810, 1), (1820, 0), (1830, 0), (1840, 0), (1850, 0), (1860, 0), (1870, 0), (1880, 0), (1890, 0), (1900, 0), (1910, 0), (1920, 0), (1930, 0), (1940, 0), (1950, 0), (1960, 0), (1970, 0), (1980, 0), (1990, 0), (2000, 0), (2010, 0), (2020, 0), (2030, 0), (2040, 0), (2050, 0)]
Va0_7  a0_7  0 PWL (0n 0.0v 9.495n 0.0v 9.505n 0.0v 19.495n 0.0v 19.505n 0.0v 29.495n 0.0v 29.505n 1.7v 39.495n 1.7v 39.505n 1.7v 49.495n 1.7v 49.505n 1.7v 59.495n 1.7v 59.505n 1.7v 69.495n 1.7v 69.505n 1.7v 79.495n 1.7v 79.505n 1.7v 89.495n 1.7v 89.505n 1.7v 99.495n 1.7v 99.505n 0.0v 109.495n 0.0v 109.505n 0.0v 119.495n 0.0v 119.505n 1.7v 129.495n 1.7v 129.505n 1.7v 139.495n 1.7v 139.505n 1.7v 149.495n 1.7v 149.505n 0.0v 159.495n 0.0v 159.505n 1.7v 169.495n 1.7v 169.505n 1.7v 179.495n 1.7v 179.505n 0.0v 189.495n 0.0v 189.505n 0.0v 199.495n 0.0v 199.505n 0.0v 209.495n 0.0v 209.505n 0.0v 219.495n 0.0v 219.505n 0.0v 229.495n 0.0v 229.505n 0.0v 239.495n 0.0v 239.505n 0.0v 249.495n 0.0v 249.505n 0.0v 259.495n 0.0v 259.505n 0.0v 269.495n 0.0v 269.505n 0.0v 279.495n 0.0v 279.505n 0.0v 289.495n 0.0v 289.505n 0.0v 299.495n 0.0v 299.505n 0.0v 309.495n 0.0v 309.505n 0.0v 319.495n 0.0v 319.505n 0.0v 329.495n 0.0v 329.505n 0.0v 339.495n 0.0v 339.505n 0.0v 349.495n 0.0v 349.505n 0.0v 359.495n 0.0v 359.505n 0.0v 369.495n 0.0v 369.505n 0.0v 379.495n 0.0v 379.505n 0.0v 389.495n 0.0v 389.505n 0.0v 399.495n 0.0v 399.505n 0.0v 409.495n 0.0v 409.505n 0.0v 419.495n 0.0v 419.505n 0.0v 429.495n 0.0v 429.505n 0.0v 439.495n 0.0v 439.505n 0.0v 449.495n 0.0v 449.505n 0.0v 459.495n 0.0v 459.505n 0.0v 469.495n 0.0v 469.505n 0.0v 479.495n 0.0v 479.505n 1.7v 489.495n 1.7v 489.505n 0.0v 499.495n 0.0v 499.505n 0.0v 509.495n 0.0v 509.505n 0.0v 519.495n 0.0v 519.505n 0.0v 529.495n 0.0v 529.505n 0.0v 539.495n 0.0v 539.505n 0.0v 549.495n 0.0v 549.505n 0.0v 559.495n 0.0v 559.505n 0.0v 569.495n 0.0v 569.505n 0.0v 579.495n 0.0v 579.505n 0.0v 589.495n 0.0v 589.505n 0.0v 599.495n 0.0v 599.505n 0.0v 609.495n 0.0v 609.505n 0.0v 619.495n 0.0v 619.505n 0.0v 629.495n 0.0v 629.505n 0.0v 639.495n 0.0v 639.505n 0.0v 649.495n 0.0v 649.505n 0.0v 659.495n 0.0v 659.505n 0.0v 669.495n 0.0v 669.505n 1.7v 679.495n 1.7v 679.505n 0.0v 689.495n 0.0v 689.505n 0.0v 699.495n 0.0v 699.505n 0.0v 709.495n 0.0v 709.505n 0.0v 719.495n 0.0v 719.505n 0.0v 729.495n 0.0v 729.505n 0.0v 739.495n 0.0v 739.505n 0.0v 749.495n 0.0v 749.505n 0.0v 759.495n 0.0v 759.505n 0.0v 769.495n 0.0v 769.505n 0.0v 779.495n 0.0v 779.505n 0.0v 789.495n 0.0v 789.505n 0.0v 799.495n 0.0v 799.505n 0.0v 809.495n 0.0v 809.505n 0.0v 819.495n 0.0v 819.505n 0.0v 829.495n 0.0v 829.505n 1.7v 839.495n 1.7v 839.505n 1.7v 849.495n 1.7v 849.505n 1.7v 859.495n 1.7v 859.505n 0.0v 869.495n 0.0v 869.505n 0.0v 879.495n 0.0v 879.505n 0.0v 889.495n 0.0v 889.505n 0.0v 899.495n 0.0v 899.505n 0.0v 909.495n 0.0v 909.505n 0.0v 919.495n 0.0v 919.505n 0.0v 929.495n 0.0v 929.505n 0.0v 939.495n 0.0v 939.505n 0.0v 949.495n 0.0v 949.505n 1.7v 959.495n 1.7v 959.505n 1.7v 969.495n 1.7v 969.505n 0.0v 979.495n 0.0v 979.505n 0.0v 989.495n 0.0v 989.505n 0.0v 999.495n 0.0v 999.505n 1.7v 1009.495n 1.7v 1009.505n 1.7v 1019.495n 1.7v 1019.505n 1.7v 1029.495n 1.7v 1029.505n 0.0v 1039.495n 0.0v 1039.505n 0.0v 1049.495n 0.0v 1049.505n 0.0v 1059.495n 0.0v 1059.505n 0.0v 1069.495n 0.0v 1069.505n 0.0v 1079.495n 0.0v 1079.505n 0.0v 1089.495n 0.0v 1089.505n 0.0v 1099.495n 0.0v 1099.505n 0.0v 1109.495n 0.0v 1109.505n 0.0v 1119.495n 0.0v 1119.505n 0.0v 1129.495n 0.0v 1129.505n 0.0v 1139.495n 0.0v 1139.505n 0.0v 1149.495n 0.0v 1149.505n 0.0v 1159.495n 0.0v 1159.505n 0.0v 1169.495n 0.0v 1169.505n 0.0v 1179.495n 0.0v 1179.505n 1.7v 1189.495n 1.7v 1189.505n 1.7v 1199.495n 1.7v 1199.505n 1.7v 1209.495n 1.7v 1209.505n 1.7v 1219.495n 1.7v 1219.505n 1.7v 1229.495n 1.7v 1229.505n 0.0v 1239.495n 0.0v 1239.505n 0.0v 1249.495n 0.0v 1249.505n 0.0v 1259.495n 0.0v 1259.505n 0.0v 1269.495n 0.0v 1269.505n 0.0v 1279.495n 0.0v 1279.505n 0.0v 1289.495n 0.0v 1289.505n 0.0v 1299.495n 0.0v 1299.505n 0.0v 1309.495n 0.0v 1309.505n 0.0v 1319.495n 0.0v 1319.505n 0.0v 1329.495n 0.0v 1329.505n 0.0v 1339.495n 0.0v 1339.505n 0.0v 1349.495n 0.0v 1349.505n 0.0v 1359.495n 0.0v 1359.505n 0.0v 1369.495n 0.0v 1369.505n 0.0v 1379.495n 0.0v 1379.505n 0.0v 1389.495n 0.0v 1389.505n 0.0v 1399.495n 0.0v 1399.505n 0.0v 1409.495n 0.0v 1409.505n 0.0v 1419.495n 0.0v 1419.505n 0.0v 1429.495n 0.0v 1429.505n 1.7v 1439.495n 1.7v 1439.505n 0.0v 1449.495n 0.0v 1449.505n 0.0v 1459.495n 0.0v 1459.505n 0.0v 1469.495n 0.0v 1469.505n 0.0v 1479.495n 0.0v 1479.505n 0.0v 1489.495n 0.0v 1489.505n 0.0v 1499.495n 0.0v 1499.505n 0.0v 1509.495n 0.0v 1509.505n 0.0v 1519.495n 0.0v 1519.505n 0.0v 1529.495n 0.0v 1529.505n 0.0v 1539.495n 0.0v 1539.505n 1.7v 1549.495n 1.7v 1549.505n 1.7v 1559.495n 1.7v 1559.505n 1.7v 1569.495n 1.7v 1569.505n 0.0v 1579.495n 0.0v 1579.505n 1.7v 1589.495n 1.7v 1589.505n 1.7v 1599.495n 1.7v 1599.505n 1.7v 1609.495n 1.7v 1609.505n 1.7v 1619.495n 1.7v 1619.505n 1.7v 1629.495n 1.7v 1629.505n 0.0v 1639.495n 0.0v 1639.505n 0.0v 1649.495n 0.0v 1649.505n 1.7v 1659.495n 1.7v 1659.505n 0.0v 1669.495n 0.0v 1669.505n 0.0v 1679.495n 0.0v 1679.505n 0.0v 1689.495n 0.0v 1689.505n 0.0v 1699.495n 0.0v 1699.505n 0.0v 1709.495n 0.0v 1709.505n 0.0v 1719.495n 0.0v 1719.505n 0.0v 1729.495n 0.0v 1729.505n 0.0v 1739.495n 0.0v 1739.505n 1.7v 1749.495n 1.7v 1749.505n 1.7v 1759.495n 1.7v 1759.505n 0.0v 1769.495n 0.0v 1769.505n 0.0v 1779.495n 0.0v 1779.505n 0.0v 1789.495n 0.0v 1789.505n 0.0v 1799.495n 0.0v 1799.505n 1.7v 1809.495n 1.7v 1809.505n 1.7v 1819.495n 1.7v 1819.505n 0.0v 1829.495n 0.0v 1829.505n 0.0v 1839.495n 0.0v 1839.505n 0.0v 1849.495n 0.0v 1849.505n 0.0v 1859.495n 0.0v 1859.505n 0.0v 1869.495n 0.0v 1869.505n 0.0v 1879.495n 0.0v 1879.505n 0.0v 1889.495n 0.0v 1889.505n 0.0v 1899.495n 0.0v 1899.505n 0.0v 1909.495n 0.0v 1909.505n 0.0v 1919.495n 0.0v 1919.505n 0.0v 1929.495n 0.0v 1929.505n 0.0v 1939.495n 0.0v 1939.505n 0.0v 1949.495n 0.0v 1949.505n 0.0v 1959.495n 0.0v 1959.505n 0.0v 1969.495n 0.0v 1969.505n 0.0v 1979.495n 0.0v 1979.505n 0.0v 1989.495n 0.0v 1989.505n 0.0v 1999.495n 0.0v 1999.505n 0.0v 2009.495n 0.0v 2009.505n 0.0v 2019.495n 0.0v 2019.505n 0.0v 2029.495n 0.0v 2029.505n 0.0v 2039.495n 0.0v 2039.505n 0.0v 2049.495n 0.0v 2049.505n 0.0v )
* (time, data): [(0, 0), (10, 0), (20, 0), (30, 0), (40, 0), (50, 0), (60, 0), (70, 0), (80, 0), (90, 0), (100, 0), (110, 1), (120, 1), (130, 1), (140, 1), (150, 1), (160, 1), (170, 1), (180, 0), (190, 0), (200, 0), (210, 0), (220, 1), (230, 1), (240, 1), (250, 1), (260, 1), (270, 0), (280, 0), (290, 0), (300, 0), (310, 0), (320, 1), (330, 1), (340, 0), (350, 1), (360, 1), (370, 0), (380, 0), (390, 0), (400, 0), (410, 0), (420, 1), (430, 1), (440, 1), (450, 1), (460, 1), (470, 1), (480, 1), (490, 1), (500, 0), (510, 0), (520, 1), (530, 1), (540, 1), (550, 0), (560, 1), (570, 0), (580, 0), (590, 0), (600, 0), (610, 0), (620, 0), (630, 0), (640, 0), (650, 0), (660, 0), (670, 0), (680, 0), (690, 0), (700, 1), (710, 1), (720, 1), (730, 1), (740, 1), (750, 1), (760, 1), (770, 0), (780, 1), (790, 1), (800, 1), (810, 0), (820, 0), (830, 0), (840, 0), (850, 1), (860, 1), (870, 0), (880, 0), (890, 0), (900, 0), (910, 0), (920, 0), (930, 0), (940, 0), (950, 0), (960, 0), (970, 0), (980, 0), (990, 0), (1000, 0), (1010, 0), (1020, 0), (1030, 0), (1040, 0), (1050, 0), (1060, 1), (1070, 1), (1080, 0), (1090, 1), (1100, 1), (1110, 0), (1120, 0), (1130, 1), (1140, 0), (1150, 0), (1160, 0), (1170, 0), (1180, 1), (1190, 1), (1200, 0), (1210, 0), (1220, 1), (1230, 0), (1240, 0), (1250, 0), (1260, 1), (1270, 1), (1280, 1), (1290, 1), (1300, 1), (1310, 1), (1320, 1), (1330, 0), (1340, 0), (1350, 0), (1360, 0), (1370, 0), (1380, 0), (1390, 1), (1400, 1), (1410, 1), (1420, 0), (1430, 0), (1440, 1), (1450, 1), (1460, 1), (1470, 1), (1480, 0), (1490, 0), (1500, 1), (1510, 0), (1520, 0), (1530, 0), (1540, 0), (1550, 0), (1560, 0), (1570, 0), (1580, 1), (1590, 1), (1600, 1), (1610, 1), (1620, 1), (1630, 1), (1640, 1), (1650, 1), (1660, 1), (1670, 1), (1680, 1), (1690, 1), (1700, 1), (1710, 1), (1720, 1), (1730, 0), (1740, 1), (1750, 1), (1760, 1), (1770, 1), (1780, 1), (1790, 0), (1800, 0), (1810, 0), (1820, 0), (1830, 0), (1840, 0), (1850, 0), (1860, 1), (1870, 1), (1880, 1), (1890, 1), (1900, 1), (1910, 1), (1920, 1), (1930, 1), (1940, 1), (1950, 1), (1960, 1), (1970, 1), (1980, 1), (1990, 1), (2000, 1), (2010, 0), (2020, 0), (2030, 0), (2040, 0), (2050, 0)]
Va1_0  a1_0  0 PWL (0n 0.0v 9.495n 0.0v 9.505n 0.0v 19.495n 0.0v 19.505n 0.0v 29.495n 0.0v 29.505n 0.0v 39.495n 0.0v 39.505n 0.0v 49.495n 0.0v 49.505n 0.0v 59.495n 0.0v 59.505n 0.0v 69.495n 0.0v 69.505n 0.0v 79.495n 0.0v 79.505n 0.0v 89.495n 0.0v 89.505n 0.0v 99.495n 0.0v 99.505n 0.0v 109.495n 0.0v 109.505n 1.7v 119.495n 1.7v 119.505n 1.7v 129.495n 1.7v 129.505n 1.7v 139.495n 1.7v 139.505n 1.7v 149.495n 1.7v 149.505n 1.7v 159.495n 1.7v 159.505n 1.7v 169.495n 1.7v 169.505n 1.7v 179.495n 1.7v 179.505n 0.0v 189.495n 0.0v 189.505n 0.0v 199.495n 0.0v 199.505n 0.0v 209.495n 0.0v 209.505n 0.0v 219.495n 0.0v 219.505n 1.7v 229.495n 1.7v 229.505n 1.7v 239.495n 1.7v 239.505n 1.7v 249.495n 1.7v 249.505n 1.7v 259.495n 1.7v 259.505n 1.7v 269.495n 1.7v 269.505n 0.0v 279.495n 0.0v 279.505n 0.0v 289.495n 0.0v 289.505n 0.0v 299.495n 0.0v 299.505n 0.0v 309.495n 0.0v 309.505n 0.0v 319.495n 0.0v 319.505n 1.7v 329.495n 1.7v 329.505n 1.7v 339.495n 1.7v 339.505n 0.0v 349.495n 0.0v 349.505n 1.7v 359.495n 1.7v 359.505n 1.7v 369.495n 1.7v 369.505n 0.0v 379.495n 0.0v 379.505n 0.0v 389.495n 0.0v 389.505n 0.0v 399.495n 0.0v 399.505n 0.0v 409.495n 0.0v 409.505n 0.0v 419.495n 0.0v 419.505n 1.7v 429.495n 1.7v 429.505n 1.7v 439.495n 1.7v 439.505n 1.7v 449.495n 1.7v 449.505n 1.7v 459.495n 1.7v 459.505n 1.7v 469.495n 1.7v 469.505n 1.7v 479.495n 1.7v 479.505n 1.7v 489.495n 1.7v 489.505n 1.7v 499.495n 1.7v 499.505n 0.0v 509.495n 0.0v 509.505n 0.0v 519.495n 0.0v 519.505n 1.7v 529.495n 1.7v 529.505n 1.7v 539.495n 1.7v 539.505n 1.7v 549.495n 1.7v 549.505n 0.0v 559.495n 0.0v 559.505n 1.7v 569.495n 1.7v 569.505n 0.0v 579.495n 0.0v 579.505n 0.0v 589.495n 0.0v 589.505n 0.0v 599.495n 0.0v 599.505n 0.0v 609.495n 0.0v 609.505n 0.0v 619.495n 0.0v 619.505n 0.0v 629.495n 0.0v 629.505n 0.0v 639.495n 0.0v 639.505n 0.0v 649.495n 0.0v 649.505n 0.0v 659.495n 0.0v 659.505n 0.0v 669.495n 0.0v 669.505n 0.0v 679.495n 0.0v 679.505n 0.0v 689.495n 0.0v 689.505n 0.0v 699.495n 0.0v 699.505n 1.7v 709.495n 1.7v 709.505n 1.7v 719.495n 1.7v 719.505n 1.7v 729.495n 1.7v 729.505n 1.7v 739.495n 1.7v 739.505n 1.7v 749.495n 1.7v 749.505n 1.7v 759.495n 1.7v 759.505n 1.7v 769.495n 1.7v 769.505n 0.0v 779.495n 0.0v 779.505n 1.7v 789.495n 1.7v 789.505n 1.7v 799.495n 1.7v 799.505n 1.7v 809.495n 1.7v 809.505n 0.0v 819.495n 0.0v 819.505n 0.0v 829.495n 0.0v 829.505n 0.0v 839.495n 0.0v 839.505n 0.0v 849.495n 0.0v 849.505n 1.7v 859.495n 1.7v 859.505n 1.7v 869.495n 1.7v 869.505n 0.0v 879.495n 0.0v 879.505n 0.0v 889.495n 0.0v 889.505n 0.0v 899.495n 0.0v 899.505n 0.0v 909.495n 0.0v 909.505n 0.0v 919.495n 0.0v 919.505n 0.0v 929.495n 0.0v 929.505n 0.0v 939.495n 0.0v 939.505n 0.0v 949.495n 0.0v 949.505n 0.0v 959.495n 0.0v 959.505n 0.0v 969.495n 0.0v 969.505n 0.0v 979.495n 0.0v 979.505n 0.0v 989.495n 0.0v 989.505n 0.0v 999.495n 0.0v 999.505n 0.0v 1009.495n 0.0v 1009.505n 0.0v 1019.495n 0.0v 1019.505n 0.0v 1029.495n 0.0v 1029.505n 0.0v 1039.495n 0.0v 1039.505n 0.0v 1049.495n 0.0v 1049.505n 0.0v 1059.495n 0.0v 1059.505n 1.7v 1069.495n 1.7v 1069.505n 1.7v 1079.495n 1.7v 1079.505n 0.0v 1089.495n 0.0v 1089.505n 1.7v 1099.495n 1.7v 1099.505n 1.7v 1109.495n 1.7v 1109.505n 0.0v 1119.495n 0.0v 1119.505n 0.0v 1129.495n 0.0v 1129.505n 1.7v 1139.495n 1.7v 1139.505n 0.0v 1149.495n 0.0v 1149.505n 0.0v 1159.495n 0.0v 1159.505n 0.0v 1169.495n 0.0v 1169.505n 0.0v 1179.495n 0.0v 1179.505n 1.7v 1189.495n 1.7v 1189.505n 1.7v 1199.495n 1.7v 1199.505n 0.0v 1209.495n 0.0v 1209.505n 0.0v 1219.495n 0.0v 1219.505n 1.7v 1229.495n 1.7v 1229.505n 0.0v 1239.495n 0.0v 1239.505n 0.0v 1249.495n 0.0v 1249.505n 0.0v 1259.495n 0.0v 1259.505n 1.7v 1269.495n 1.7v 1269.505n 1.7v 1279.495n 1.7v 1279.505n 1.7v 1289.495n 1.7v 1289.505n 1.7v 1299.495n 1.7v 1299.505n 1.7v 1309.495n 1.7v 1309.505n 1.7v 1319.495n 1.7v 1319.505n 1.7v 1329.495n 1.7v 1329.505n 0.0v 1339.495n 0.0v 1339.505n 0.0v 1349.495n 0.0v 1349.505n 0.0v 1359.495n 0.0v 1359.505n 0.0v 1369.495n 0.0v 1369.505n 0.0v 1379.495n 0.0v 1379.505n 0.0v 1389.495n 0.0v 1389.505n 1.7v 1399.495n 1.7v 1399.505n 1.7v 1409.495n 1.7v 1409.505n 1.7v 1419.495n 1.7v 1419.505n 0.0v 1429.495n 0.0v 1429.505n 0.0v 1439.495n 0.0v 1439.505n 1.7v 1449.495n 1.7v 1449.505n 1.7v 1459.495n 1.7v 1459.505n 1.7v 1469.495n 1.7v 1469.505n 1.7v 1479.495n 1.7v 1479.505n 0.0v 1489.495n 0.0v 1489.505n 0.0v 1499.495n 0.0v 1499.505n 1.7v 1509.495n 1.7v 1509.505n 0.0v 1519.495n 0.0v 1519.505n 0.0v 1529.495n 0.0v 1529.505n 0.0v 1539.495n 0.0v 1539.505n 0.0v 1549.495n 0.0v 1549.505n 0.0v 1559.495n 0.0v 1559.505n 0.0v 1569.495n 0.0v 1569.505n 0.0v 1579.495n 0.0v 1579.505n 1.7v 1589.495n 1.7v 1589.505n 1.7v 1599.495n 1.7v 1599.505n 1.7v 1609.495n 1.7v 1609.505n 1.7v 1619.495n 1.7v 1619.505n 1.7v 1629.495n 1.7v 1629.505n 1.7v 1639.495n 1.7v 1639.505n 1.7v 1649.495n 1.7v 1649.505n 1.7v 1659.495n 1.7v 1659.505n 1.7v 1669.495n 1.7v 1669.505n 1.7v 1679.495n 1.7v 1679.505n 1.7v 1689.495n 1.7v 1689.505n 1.7v 1699.495n 1.7v 1699.505n 1.7v 1709.495n 1.7v 1709.505n 1.7v 1719.495n 1.7v 1719.505n 1.7v 1729.495n 1.7v 1729.505n 0.0v 1739.495n 0.0v 1739.505n 1.7v 1749.495n 1.7v 1749.505n 1.7v 1759.495n 1.7v 1759.505n 1.7v 1769.495n 1.7v 1769.505n 1.7v 1779.495n 1.7v 1779.505n 1.7v 1789.495n 1.7v 1789.505n 0.0v 1799.495n 0.0v 1799.505n 0.0v 1809.495n 0.0v 1809.505n 0.0v 1819.495n 0.0v 1819.505n 0.0v 1829.495n 0.0v 1829.505n 0.0v 1839.495n 0.0v 1839.505n 0.0v 1849.495n 0.0v 1849.505n 0.0v 1859.495n 0.0v 1859.505n 1.7v 1869.495n 1.7v 1869.505n 1.7v 1879.495n 1.7v 1879.505n 1.7v 1889.495n 1.7v 1889.505n 1.7v 1899.495n 1.7v 1899.505n 1.7v 1909.495n 1.7v 1909.505n 1.7v 1919.495n 1.7v 1919.505n 1.7v 1929.495n 1.7v 1929.505n 1.7v 1939.495n 1.7v 1939.505n 1.7v 1949.495n 1.7v 1949.505n 1.7v 1959.495n 1.7v 1959.505n 1.7v 1969.495n 1.7v 1969.505n 1.7v 1979.495n 1.7v 1979.505n 1.7v 1989.495n 1.7v 1989.505n 1.7v 1999.495n 1.7v 1999.505n 1.7v 2009.495n 1.7v 2009.505n 0.0v 2019.495n 0.0v 2019.505n 0.0v 2029.495n 0.0v 2029.505n 0.0v 2039.495n 0.0v 2039.505n 0.0v 2049.495n 0.0v 2049.505n 0.0v )
* (time, data): [(0, 0), (10, 0), (20, 0), (30, 0), (40, 0), (50, 0), (60, 0), (70, 0), (80, 0), (90, 0), (100, 0), (110, 0), (120, 0), (130, 0), (140, 0), (150, 0), (160, 0), (170, 0), (180, 0), (190, 0), (200, 0), (210, 0), (220, 0), (230, 0), (240, 0), (250, 0), (260, 0), (270, 0), (280, 0), (290, 0), (300, 0), (310, 0), (320, 1), (330, 1), (340, 0), (350, 0), (360, 1), (370, 0), (380, 0), (390, 0), (400, 0), (410, 0), (420, 0), (430, 0), (440, 0), (450, 0), (460, 0), (470, 1), (480, 1), (490, 1), (500, 0), (510, 0), (520, 1), (530, 1), (540, 1), (550, 0), (560, 0), (570, 0), (580, 0), (590, 0), (600, 0), (610, 0), (620, 0), (630, 0), (640, 0), (650, 0), (660, 0), (670, 0), (680, 0), (690, 0), (700, 0), (710, 0), (720, 0), (730, 0), (740, 0), (750, 0), (760, 1), (770, 0), (780, 0), (790, 0), (800, 0), (810, 0), (820, 0), (830, 0), (840, 0), (850, 0), (860, 0), (870, 0), (880, 0), (890, 0), (900, 0), (910, 0), (920, 0), (930, 0), (940, 0), (950, 0), (960, 0), (970, 0), (980, 0), (990, 0), (1000, 0), (1010, 0), (1020, 0), (1030, 0), (1040, 0), (1050, 0), (1060, 1), (1070, 1), (1080, 0), (1090, 1), (1100, 0), (1110, 0), (1120, 0), (1130, 1), (1140, 0), (1150, 0), (1160, 0), (1170, 0), (1180, 1), (1190, 1), (1200, 0), (1210, 0), (1220, 0), (1230, 0), (1240, 0), (1250, 0), (1260, 0), (1270, 0), (1280, 0), (1290, 0), (1300, 0), (1310, 0), (1320, 0), (1330, 0), (1340, 0), (1350, 0), (1360, 0), (1370, 0), (1380, 0), (1390, 1), (1400, 1), (1410, 1), (1420, 0), (1430, 0), (1440, 1), (1450, 1), (1460, 1), (1470, 1), (1480, 0), (1490, 0), (1500, 1), (1510, 0), (1520, 0), (1530, 0), (1540, 0), (1550, 0), (1560, 0), (1570, 0), (1580, 1), (1590, 1), (1600, 1), (1610, 1), (1620, 0), (1630, 0), (1640, 0), (1650, 0), (1660, 0), (1670, 0), (1680, 0), (1690, 0), (1700, 0), (1710, 0), (1720, 0), (1730, 0), (1740, 0), (1750, 0), (1760, 0), (1770, 0), (1780, 0), (1790, 0), (1800, 0), (1810, 0), (1820, 0), (1830, 0), (1840, 0), (1850, 0), (1860, 1), (1870, 1), (1880, 1), (1890, 1), (1900, 1), (1910, 1), (1920, 1), (1930, 1), (1940, 1), (1950, 1), (1960, 1), (1970, 0), (1980, 0), (1990, 0), (2000, 0), (2010, 0), (2020, 0), (2030, 0), (2040, 0), (2050, 0)]
Va1_1  a1_1  0 PWL (0n 0.0v 9.495n 0.0v 9.505n 0.0v 19.495n 0.0v 19.505n 0.0v 29.495n 0.0v 29.505n 0.0v 39.495n 0.0v 39.505n 0.0v 49.495n 0.0v 49.505n 0.0v 59.495n 0.0v 59.505n 0.0v 69.495n 0.0v 69.505n 0.0v 79.495n 0.0v 79.505n 0.0v 89.495n 0.0v 89.505n 0.0v 99.495n 0.0v 99.505n 0.0v 109.495n 0.0v 109.505n 0.0v 119.495n 0.0v 119.505n 0.0v 129.495n 0.0v 129.505n 0.0v 139.495n 0.0v 139.505n 0.0v 149.495n 0.0v 149.505n 0.0v 159.495n 0.0v 159.505n 0.0v 169.495n 0.0v 169.505n 0.0v 179.495n 0.0v 179.505n 0.0v 189.495n 0.0v 189.505n 0.0v 199.495n 0.0v 199.505n 0.0v 209.495n 0.0v 209.505n 0.0v 219.495n 0.0v 219.505n 0.0v 229.495n 0.0v 229.505n 0.0v 239.495n 0.0v 239.505n 0.0v 249.495n 0.0v 249.505n 0.0v 259.495n 0.0v 259.505n 0.0v 269.495n 0.0v 269.505n 0.0v 279.495n 0.0v 279.505n 0.0v 289.495n 0.0v 289.505n 0.0v 299.495n 0.0v 299.505n 0.0v 309.495n 0.0v 309.505n 0.0v 319.495n 0.0v 319.505n 1.7v 329.495n 1.7v 329.505n 1.7v 339.495n 1.7v 339.505n 0.0v 349.495n 0.0v 349.505n 0.0v 359.495n 0.0v 359.505n 1.7v 369.495n 1.7v 369.505n 0.0v 379.495n 0.0v 379.505n 0.0v 389.495n 0.0v 389.505n 0.0v 399.495n 0.0v 399.505n 0.0v 409.495n 0.0v 409.505n 0.0v 419.495n 0.0v 419.505n 0.0v 429.495n 0.0v 429.505n 0.0v 439.495n 0.0v 439.505n 0.0v 449.495n 0.0v 449.505n 0.0v 459.495n 0.0v 459.505n 0.0v 469.495n 0.0v 469.505n 1.7v 479.495n 1.7v 479.505n 1.7v 489.495n 1.7v 489.505n 1.7v 499.495n 1.7v 499.505n 0.0v 509.495n 0.0v 509.505n 0.0v 519.495n 0.0v 519.505n 1.7v 529.495n 1.7v 529.505n 1.7v 539.495n 1.7v 539.505n 1.7v 549.495n 1.7v 549.505n 0.0v 559.495n 0.0v 559.505n 0.0v 569.495n 0.0v 569.505n 0.0v 579.495n 0.0v 579.505n 0.0v 589.495n 0.0v 589.505n 0.0v 599.495n 0.0v 599.505n 0.0v 609.495n 0.0v 609.505n 0.0v 619.495n 0.0v 619.505n 0.0v 629.495n 0.0v 629.505n 0.0v 639.495n 0.0v 639.505n 0.0v 649.495n 0.0v 649.505n 0.0v 659.495n 0.0v 659.505n 0.0v 669.495n 0.0v 669.505n 0.0v 679.495n 0.0v 679.505n 0.0v 689.495n 0.0v 689.505n 0.0v 699.495n 0.0v 699.505n 0.0v 709.495n 0.0v 709.505n 0.0v 719.495n 0.0v 719.505n 0.0v 729.495n 0.0v 729.505n 0.0v 739.495n 0.0v 739.505n 0.0v 749.495n 0.0v 749.505n 0.0v 759.495n 0.0v 759.505n 1.7v 769.495n 1.7v 769.505n 0.0v 779.495n 0.0v 779.505n 0.0v 789.495n 0.0v 789.505n 0.0v 799.495n 0.0v 799.505n 0.0v 809.495n 0.0v 809.505n 0.0v 819.495n 0.0v 819.505n 0.0v 829.495n 0.0v 829.505n 0.0v 839.495n 0.0v 839.505n 0.0v 849.495n 0.0v 849.505n 0.0v 859.495n 0.0v 859.505n 0.0v 869.495n 0.0v 869.505n 0.0v 879.495n 0.0v 879.505n 0.0v 889.495n 0.0v 889.505n 0.0v 899.495n 0.0v 899.505n 0.0v 909.495n 0.0v 909.505n 0.0v 919.495n 0.0v 919.505n 0.0v 929.495n 0.0v 929.505n 0.0v 939.495n 0.0v 939.505n 0.0v 949.495n 0.0v 949.505n 0.0v 959.495n 0.0v 959.505n 0.0v 969.495n 0.0v 969.505n 0.0v 979.495n 0.0v 979.505n 0.0v 989.495n 0.0v 989.505n 0.0v 999.495n 0.0v 999.505n 0.0v 1009.495n 0.0v 1009.505n 0.0v 1019.495n 0.0v 1019.505n 0.0v 1029.495n 0.0v 1029.505n 0.0v 1039.495n 0.0v 1039.505n 0.0v 1049.495n 0.0v 1049.505n 0.0v 1059.495n 0.0v 1059.505n 1.7v 1069.495n 1.7v 1069.505n 1.7v 1079.495n 1.7v 1079.505n 0.0v 1089.495n 0.0v 1089.505n 1.7v 1099.495n 1.7v 1099.505n 0.0v 1109.495n 0.0v 1109.505n 0.0v 1119.495n 0.0v 1119.505n 0.0v 1129.495n 0.0v 1129.505n 1.7v 1139.495n 1.7v 1139.505n 0.0v 1149.495n 0.0v 1149.505n 0.0v 1159.495n 0.0v 1159.505n 0.0v 1169.495n 0.0v 1169.505n 0.0v 1179.495n 0.0v 1179.505n 1.7v 1189.495n 1.7v 1189.505n 1.7v 1199.495n 1.7v 1199.505n 0.0v 1209.495n 0.0v 1209.505n 0.0v 1219.495n 0.0v 1219.505n 0.0v 1229.495n 0.0v 1229.505n 0.0v 1239.495n 0.0v 1239.505n 0.0v 1249.495n 0.0v 1249.505n 0.0v 1259.495n 0.0v 1259.505n 0.0v 1269.495n 0.0v 1269.505n 0.0v 1279.495n 0.0v 1279.505n 0.0v 1289.495n 0.0v 1289.505n 0.0v 1299.495n 0.0v 1299.505n 0.0v 1309.495n 0.0v 1309.505n 0.0v 1319.495n 0.0v 1319.505n 0.0v 1329.495n 0.0v 1329.505n 0.0v 1339.495n 0.0v 1339.505n 0.0v 1349.495n 0.0v 1349.505n 0.0v 1359.495n 0.0v 1359.505n 0.0v 1369.495n 0.0v 1369.505n 0.0v 1379.495n 0.0v 1379.505n 0.0v 1389.495n 0.0v 1389.505n 1.7v 1399.495n 1.7v 1399.505n 1.7v 1409.495n 1.7v 1409.505n 1.7v 1419.495n 1.7v 1419.505n 0.0v 1429.495n 0.0v 1429.505n 0.0v 1439.495n 0.0v 1439.505n 1.7v 1449.495n 1.7v 1449.505n 1.7v 1459.495n 1.7v 1459.505n 1.7v 1469.495n 1.7v 1469.505n 1.7v 1479.495n 1.7v 1479.505n 0.0v 1489.495n 0.0v 1489.505n 0.0v 1499.495n 0.0v 1499.505n 1.7v 1509.495n 1.7v 1509.505n 0.0v 1519.495n 0.0v 1519.505n 0.0v 1529.495n 0.0v 1529.505n 0.0v 1539.495n 0.0v 1539.505n 0.0v 1549.495n 0.0v 1549.505n 0.0v 1559.495n 0.0v 1559.505n 0.0v 1569.495n 0.0v 1569.505n 0.0v 1579.495n 0.0v 1579.505n 1.7v 1589.495n 1.7v 1589.505n 1.7v 1599.495n 1.7v 1599.505n 1.7v 1609.495n 1.7v 1609.505n 1.7v 1619.495n 1.7v 1619.505n 0.0v 1629.495n 0.0v 1629.505n 0.0v 1639.495n 0.0v 1639.505n 0.0v 1649.495n 0.0v 1649.505n 0.0v 1659.495n 0.0v 1659.505n 0.0v 1669.495n 0.0v 1669.505n 0.0v 1679.495n 0.0v 1679.505n 0.0v 1689.495n 0.0v 1689.505n 0.0v 1699.495n 0.0v 1699.505n 0.0v 1709.495n 0.0v 1709.505n 0.0v 1719.495n 0.0v 1719.505n 0.0v 1729.495n 0.0v 1729.505n 0.0v 1739.495n 0.0v 1739.505n 0.0v 1749.495n 0.0v 1749.505n 0.0v 1759.495n 0.0v 1759.505n 0.0v 1769.495n 0.0v 1769.505n 0.0v 1779.495n 0.0v 1779.505n 0.0v 1789.495n 0.0v 1789.505n 0.0v 1799.495n 0.0v 1799.505n 0.0v 1809.495n 0.0v 1809.505n 0.0v 1819.495n 0.0v 1819.505n 0.0v 1829.495n 0.0v 1829.505n 0.0v 1839.495n 0.0v 1839.505n 0.0v 1849.495n 0.0v 1849.505n 0.0v 1859.495n 0.0v 1859.505n 1.7v 1869.495n 1.7v 1869.505n 1.7v 1879.495n 1.7v 1879.505n 1.7v 1889.495n 1.7v 1889.505n 1.7v 1899.495n 1.7v 1899.505n 1.7v 1909.495n 1.7v 1909.505n 1.7v 1919.495n 1.7v 1919.505n 1.7v 1929.495n 1.7v 1929.505n 1.7v 1939.495n 1.7v 1939.505n 1.7v 1949.495n 1.7v 1949.505n 1.7v 1959.495n 1.7v 1959.505n 1.7v 1969.495n 1.7v 1969.505n 0.0v 1979.495n 0.0v 1979.505n 0.0v 1989.495n 0.0v 1989.505n 0.0v 1999.495n 0.0v 1999.505n 0.0v 2009.495n 0.0v 2009.505n 0.0v 2019.495n 0.0v 2019.505n 0.0v 2029.495n 0.0v 2029.505n 0.0v 2039.495n 0.0v 2039.505n 0.0v 2049.495n 0.0v 2049.505n 0.0v )
* (time, data): [(0, 0), (10, 0), (20, 0), (30, 0), (40, 0), (50, 0), (60, 0), (70, 0), (80, 0), (90, 0), (100, 0), (110, 0), (120, 0), (130, 0), (140, 0), (150, 0), (160, 0), (170, 0), (180, 0), (190, 0), (200, 0), (210, 0), (220, 0), (230, 0), (240, 0), (250, 0), (260, 0), (270, 0), (280, 0), (290, 0), (300, 0), (310, 0), (320, 1), (330, 1), (340, 0), (350, 0), (360, 1), (370, 0), (380, 0), (390, 0), (400, 0), (410, 0), (420, 0), (430, 0), (440, 0), (450, 0), (460, 0), (470, 1), (480, 1), (490, 1), (500, 0), (510, 0), (520, 1), (530, 1), (540, 1), (550, 0), (560, 0), (570, 0), (580, 0), (590, 0), (600, 0), (610, 0), (620, 0), (630, 0), (640, 0), (650, 0), (660, 0), (670, 0), (680, 0), (690, 0), (700, 0), (710, 0), (720, 0), (730, 0), (740, 0), (750, 0), (760, 1), (770, 0), (780, 0), (790, 0), (800, 0), (810, 0), (820, 0), (830, 0), (840, 0), (850, 0), (860, 0), (870, 0), (880, 0), (890, 0), (900, 0), (910, 0), (920, 0), (930, 0), (940, 0), (950, 0), (960, 0), (970, 0), (980, 0), (990, 0), (1000, 0), (1010, 0), (1020, 0), (1030, 0), (1040, 0), (1050, 0), (1060, 1), (1070, 1), (1080, 0), (1090, 1), (1100, 0), (1110, 0), (1120, 0), (1130, 1), (1140, 0), (1150, 0), (1160, 0), (1170, 0), (1180, 1), (1190, 1), (1200, 0), (1210, 0), (1220, 0), (1230, 0), (1240, 0), (1250, 0), (1260, 0), (1270, 0), (1280, 0), (1290, 0), (1300, 0), (1310, 0), (1320, 0), (1330, 0), (1340, 0), (1350, 0), (1360, 0), (1370, 0), (1380, 0), (1390, 1), (1400, 1), (1410, 1), (1420, 0), (1430, 0), (1440, 1), (1450, 1), (1460, 1), (1470, 1), (1480, 0), (1490, 0), (1500, 1), (1510, 0), (1520, 0), (1530, 0), (1540, 0), (1550, 0), (1560, 0), (1570, 0), (1580, 1), (1590, 1), (1600, 1), (1610, 1), (1620, 0), (1630, 0), (1640, 0), (1650, 0), (1660, 0), (1670, 0), (1680, 0), (1690, 0), (1700, 0), (1710, 0), (1720, 0), (1730, 0), (1740, 0), (1750, 0), (1760, 0), (1770, 0), (1780, 0), (1790, 0), (1800, 0), (1810, 0), (1820, 0), (1830, 0), (1840, 0), (1850, 0), (1860, 1), (1870, 1), (1880, 1), (1890, 1), (1900, 1), (1910, 1), (1920, 1), (1930, 1), (1940, 1), (1950, 1), (1960, 1), (1970, 0), (1980, 0), (1990, 0), (2000, 0), (2010, 0), (2020, 0), (2030, 0), (2040, 0), (2050, 0)]
Va1_2  a1_2  0 PWL (0n 0.0v 9.495n 0.0v 9.505n 0.0v 19.495n 0.0v 19.505n 0.0v 29.495n 0.0v 29.505n 0.0v 39.495n 0.0v 39.505n 0.0v 49.495n 0.0v 49.505n 0.0v 59.495n 0.0v 59.505n 0.0v 69.495n 0.0v 69.505n 0.0v 79.495n 0.0v 79.505n 0.0v 89.495n 0.0v 89.505n 0.0v 99.495n 0.0v 99.505n 0.0v 109.495n 0.0v 109.505n 0.0v 119.495n 0.0v 119.505n 0.0v 129.495n 0.0v 129.505n 0.0v 139.495n 0.0v 139.505n 0.0v 149.495n 0.0v 149.505n 0.0v 159.495n 0.0v 159.505n 0.0v 169.495n 0.0v 169.505n 0.0v 179.495n 0.0v 179.505n 0.0v 189.495n 0.0v 189.505n 0.0v 199.495n 0.0v 199.505n 0.0v 209.495n 0.0v 209.505n 0.0v 219.495n 0.0v 219.505n 0.0v 229.495n 0.0v 229.505n 0.0v 239.495n 0.0v 239.505n 0.0v 249.495n 0.0v 249.505n 0.0v 259.495n 0.0v 259.505n 0.0v 269.495n 0.0v 269.505n 0.0v 279.495n 0.0v 279.505n 0.0v 289.495n 0.0v 289.505n 0.0v 299.495n 0.0v 299.505n 0.0v 309.495n 0.0v 309.505n 0.0v 319.495n 0.0v 319.505n 1.7v 329.495n 1.7v 329.505n 1.7v 339.495n 1.7v 339.505n 0.0v 349.495n 0.0v 349.505n 0.0v 359.495n 0.0v 359.505n 1.7v 369.495n 1.7v 369.505n 0.0v 379.495n 0.0v 379.505n 0.0v 389.495n 0.0v 389.505n 0.0v 399.495n 0.0v 399.505n 0.0v 409.495n 0.0v 409.505n 0.0v 419.495n 0.0v 419.505n 0.0v 429.495n 0.0v 429.505n 0.0v 439.495n 0.0v 439.505n 0.0v 449.495n 0.0v 449.505n 0.0v 459.495n 0.0v 459.505n 0.0v 469.495n 0.0v 469.505n 1.7v 479.495n 1.7v 479.505n 1.7v 489.495n 1.7v 489.505n 1.7v 499.495n 1.7v 499.505n 0.0v 509.495n 0.0v 509.505n 0.0v 519.495n 0.0v 519.505n 1.7v 529.495n 1.7v 529.505n 1.7v 539.495n 1.7v 539.505n 1.7v 549.495n 1.7v 549.505n 0.0v 559.495n 0.0v 559.505n 0.0v 569.495n 0.0v 569.505n 0.0v 579.495n 0.0v 579.505n 0.0v 589.495n 0.0v 589.505n 0.0v 599.495n 0.0v 599.505n 0.0v 609.495n 0.0v 609.505n 0.0v 619.495n 0.0v 619.505n 0.0v 629.495n 0.0v 629.505n 0.0v 639.495n 0.0v 639.505n 0.0v 649.495n 0.0v 649.505n 0.0v 659.495n 0.0v 659.505n 0.0v 669.495n 0.0v 669.505n 0.0v 679.495n 0.0v 679.505n 0.0v 689.495n 0.0v 689.505n 0.0v 699.495n 0.0v 699.505n 0.0v 709.495n 0.0v 709.505n 0.0v 719.495n 0.0v 719.505n 0.0v 729.495n 0.0v 729.505n 0.0v 739.495n 0.0v 739.505n 0.0v 749.495n 0.0v 749.505n 0.0v 759.495n 0.0v 759.505n 1.7v 769.495n 1.7v 769.505n 0.0v 779.495n 0.0v 779.505n 0.0v 789.495n 0.0v 789.505n 0.0v 799.495n 0.0v 799.505n 0.0v 809.495n 0.0v 809.505n 0.0v 819.495n 0.0v 819.505n 0.0v 829.495n 0.0v 829.505n 0.0v 839.495n 0.0v 839.505n 0.0v 849.495n 0.0v 849.505n 0.0v 859.495n 0.0v 859.505n 0.0v 869.495n 0.0v 869.505n 0.0v 879.495n 0.0v 879.505n 0.0v 889.495n 0.0v 889.505n 0.0v 899.495n 0.0v 899.505n 0.0v 909.495n 0.0v 909.505n 0.0v 919.495n 0.0v 919.505n 0.0v 929.495n 0.0v 929.505n 0.0v 939.495n 0.0v 939.505n 0.0v 949.495n 0.0v 949.505n 0.0v 959.495n 0.0v 959.505n 0.0v 969.495n 0.0v 969.505n 0.0v 979.495n 0.0v 979.505n 0.0v 989.495n 0.0v 989.505n 0.0v 999.495n 0.0v 999.505n 0.0v 1009.495n 0.0v 1009.505n 0.0v 1019.495n 0.0v 1019.505n 0.0v 1029.495n 0.0v 1029.505n 0.0v 1039.495n 0.0v 1039.505n 0.0v 1049.495n 0.0v 1049.505n 0.0v 1059.495n 0.0v 1059.505n 1.7v 1069.495n 1.7v 1069.505n 1.7v 1079.495n 1.7v 1079.505n 0.0v 1089.495n 0.0v 1089.505n 1.7v 1099.495n 1.7v 1099.505n 0.0v 1109.495n 0.0v 1109.505n 0.0v 1119.495n 0.0v 1119.505n 0.0v 1129.495n 0.0v 1129.505n 1.7v 1139.495n 1.7v 1139.505n 0.0v 1149.495n 0.0v 1149.505n 0.0v 1159.495n 0.0v 1159.505n 0.0v 1169.495n 0.0v 1169.505n 0.0v 1179.495n 0.0v 1179.505n 1.7v 1189.495n 1.7v 1189.505n 1.7v 1199.495n 1.7v 1199.505n 0.0v 1209.495n 0.0v 1209.505n 0.0v 1219.495n 0.0v 1219.505n 0.0v 1229.495n 0.0v 1229.505n 0.0v 1239.495n 0.0v 1239.505n 0.0v 1249.495n 0.0v 1249.505n 0.0v 1259.495n 0.0v 1259.505n 0.0v 1269.495n 0.0v 1269.505n 0.0v 1279.495n 0.0v 1279.505n 0.0v 1289.495n 0.0v 1289.505n 0.0v 1299.495n 0.0v 1299.505n 0.0v 1309.495n 0.0v 1309.505n 0.0v 1319.495n 0.0v 1319.505n 0.0v 1329.495n 0.0v 1329.505n 0.0v 1339.495n 0.0v 1339.505n 0.0v 1349.495n 0.0v 1349.505n 0.0v 1359.495n 0.0v 1359.505n 0.0v 1369.495n 0.0v 1369.505n 0.0v 1379.495n 0.0v 1379.505n 0.0v 1389.495n 0.0v 1389.505n 1.7v 1399.495n 1.7v 1399.505n 1.7v 1409.495n 1.7v 1409.505n 1.7v 1419.495n 1.7v 1419.505n 0.0v 1429.495n 0.0v 1429.505n 0.0v 1439.495n 0.0v 1439.505n 1.7v 1449.495n 1.7v 1449.505n 1.7v 1459.495n 1.7v 1459.505n 1.7v 1469.495n 1.7v 1469.505n 1.7v 1479.495n 1.7v 1479.505n 0.0v 1489.495n 0.0v 1489.505n 0.0v 1499.495n 0.0v 1499.505n 1.7v 1509.495n 1.7v 1509.505n 0.0v 1519.495n 0.0v 1519.505n 0.0v 1529.495n 0.0v 1529.505n 0.0v 1539.495n 0.0v 1539.505n 0.0v 1549.495n 0.0v 1549.505n 0.0v 1559.495n 0.0v 1559.505n 0.0v 1569.495n 0.0v 1569.505n 0.0v 1579.495n 0.0v 1579.505n 1.7v 1589.495n 1.7v 1589.505n 1.7v 1599.495n 1.7v 1599.505n 1.7v 1609.495n 1.7v 1609.505n 1.7v 1619.495n 1.7v 1619.505n 0.0v 1629.495n 0.0v 1629.505n 0.0v 1639.495n 0.0v 1639.505n 0.0v 1649.495n 0.0v 1649.505n 0.0v 1659.495n 0.0v 1659.505n 0.0v 1669.495n 0.0v 1669.505n 0.0v 1679.495n 0.0v 1679.505n 0.0v 1689.495n 0.0v 1689.505n 0.0v 1699.495n 0.0v 1699.505n 0.0v 1709.495n 0.0v 1709.505n 0.0v 1719.495n 0.0v 1719.505n 0.0v 1729.495n 0.0v 1729.505n 0.0v 1739.495n 0.0v 1739.505n 0.0v 1749.495n 0.0v 1749.505n 0.0v 1759.495n 0.0v 1759.505n 0.0v 1769.495n 0.0v 1769.505n 0.0v 1779.495n 0.0v 1779.505n 0.0v 1789.495n 0.0v 1789.505n 0.0v 1799.495n 0.0v 1799.505n 0.0v 1809.495n 0.0v 1809.505n 0.0v 1819.495n 0.0v 1819.505n 0.0v 1829.495n 0.0v 1829.505n 0.0v 1839.495n 0.0v 1839.505n 0.0v 1849.495n 0.0v 1849.505n 0.0v 1859.495n 0.0v 1859.505n 1.7v 1869.495n 1.7v 1869.505n 1.7v 1879.495n 1.7v 1879.505n 1.7v 1889.495n 1.7v 1889.505n 1.7v 1899.495n 1.7v 1899.505n 1.7v 1909.495n 1.7v 1909.505n 1.7v 1919.495n 1.7v 1919.505n 1.7v 1929.495n 1.7v 1929.505n 1.7v 1939.495n 1.7v 1939.505n 1.7v 1949.495n 1.7v 1949.505n 1.7v 1959.495n 1.7v 1959.505n 1.7v 1969.495n 1.7v 1969.505n 0.0v 1979.495n 0.0v 1979.505n 0.0v 1989.495n 0.0v 1989.505n 0.0v 1999.495n 0.0v 1999.505n 0.0v 2009.495n 0.0v 2009.505n 0.0v 2019.495n 0.0v 2019.505n 0.0v 2029.495n 0.0v 2029.505n 0.0v 2039.495n 0.0v 2039.505n 0.0v 2049.495n 0.0v 2049.505n 0.0v )
* (time, data): [(0, 0), (10, 0), (20, 0), (30, 0), (40, 0), (50, 0), (60, 0), (70, 0), (80, 0), (90, 0), (100, 0), (110, 0), (120, 0), (130, 0), (140, 0), (150, 0), (160, 0), (170, 0), (180, 0), (190, 0), (200, 0), (210, 0), (220, 0), (230, 0), (240, 0), (250, 0), (260, 0), (270, 0), (280, 0), (290, 0), (300, 0), (310, 0), (320, 1), (330, 1), (340, 0), (350, 0), (360, 1), (370, 0), (380, 0), (390, 0), (400, 0), (410, 0), (420, 0), (430, 0), (440, 0), (450, 0), (460, 0), (470, 1), (480, 1), (490, 1), (500, 0), (510, 0), (520, 1), (530, 1), (540, 1), (550, 0), (560, 0), (570, 0), (580, 0), (590, 0), (600, 0), (610, 0), (620, 0), (630, 0), (640, 0), (650, 0), (660, 0), (670, 0), (680, 0), (690, 0), (700, 0), (710, 0), (720, 0), (730, 0), (740, 0), (750, 0), (760, 1), (770, 0), (780, 0), (790, 0), (800, 0), (810, 0), (820, 0), (830, 0), (840, 0), (850, 0), (860, 0), (870, 0), (880, 0), (890, 0), (900, 0), (910, 0), (920, 0), (930, 0), (940, 0), (950, 0), (960, 0), (970, 0), (980, 0), (990, 0), (1000, 0), (1010, 0), (1020, 0), (1030, 0), (1040, 0), (1050, 0), (1060, 1), (1070, 1), (1080, 0), (1090, 1), (1100, 0), (1110, 0), (1120, 0), (1130, 1), (1140, 0), (1150, 0), (1160, 0), (1170, 0), (1180, 1), (1190, 1), (1200, 0), (1210, 0), (1220, 0), (1230, 0), (1240, 0), (1250, 0), (1260, 0), (1270, 0), (1280, 0), (1290, 0), (1300, 0), (1310, 0), (1320, 0), (1330, 0), (1340, 0), (1350, 0), (1360, 0), (1370, 0), (1380, 0), (1390, 1), (1400, 1), (1410, 1), (1420, 0), (1430, 0), (1440, 1), (1450, 1), (1460, 1), (1470, 1), (1480, 0), (1490, 0), (1500, 1), (1510, 0), (1520, 0), (1530, 0), (1540, 0), (1550, 0), (1560, 0), (1570, 0), (1580, 1), (1590, 1), (1600, 1), (1610, 1), (1620, 0), (1630, 0), (1640, 0), (1650, 0), (1660, 0), (1670, 0), (1680, 0), (1690, 0), (1700, 0), (1710, 0), (1720, 0), (1730, 0), (1740, 0), (1750, 0), (1760, 0), (1770, 0), (1780, 0), (1790, 0), (1800, 0), (1810, 0), (1820, 0), (1830, 0), (1840, 0), (1850, 0), (1860, 1), (1870, 1), (1880, 1), (1890, 1), (1900, 1), (1910, 1), (1920, 1), (1930, 1), (1940, 1), (1950, 1), (1960, 1), (1970, 0), (1980, 0), (1990, 0), (2000, 0), (2010, 0), (2020, 0), (2030, 0), (2040, 0), (2050, 0)]
Va1_3  a1_3  0 PWL (0n 0.0v 9.495n 0.0v 9.505n 0.0v 19.495n 0.0v 19.505n 0.0v 29.495n 0.0v 29.505n 0.0v 39.495n 0.0v 39.505n 0.0v 49.495n 0.0v 49.505n 0.0v 59.495n 0.0v 59.505n 0.0v 69.495n 0.0v 69.505n 0.0v 79.495n 0.0v 79.505n 0.0v 89.495n 0.0v 89.505n 0.0v 99.495n 0.0v 99.505n 0.0v 109.495n 0.0v 109.505n 0.0v 119.495n 0.0v 119.505n 0.0v 129.495n 0.0v 129.505n 0.0v 139.495n 0.0v 139.505n 0.0v 149.495n 0.0v 149.505n 0.0v 159.495n 0.0v 159.505n 0.0v 169.495n 0.0v 169.505n 0.0v 179.495n 0.0v 179.505n 0.0v 189.495n 0.0v 189.505n 0.0v 199.495n 0.0v 199.505n 0.0v 209.495n 0.0v 209.505n 0.0v 219.495n 0.0v 219.505n 0.0v 229.495n 0.0v 229.505n 0.0v 239.495n 0.0v 239.505n 0.0v 249.495n 0.0v 249.505n 0.0v 259.495n 0.0v 259.505n 0.0v 269.495n 0.0v 269.505n 0.0v 279.495n 0.0v 279.505n 0.0v 289.495n 0.0v 289.505n 0.0v 299.495n 0.0v 299.505n 0.0v 309.495n 0.0v 309.505n 0.0v 319.495n 0.0v 319.505n 1.7v 329.495n 1.7v 329.505n 1.7v 339.495n 1.7v 339.505n 0.0v 349.495n 0.0v 349.505n 0.0v 359.495n 0.0v 359.505n 1.7v 369.495n 1.7v 369.505n 0.0v 379.495n 0.0v 379.505n 0.0v 389.495n 0.0v 389.505n 0.0v 399.495n 0.0v 399.505n 0.0v 409.495n 0.0v 409.505n 0.0v 419.495n 0.0v 419.505n 0.0v 429.495n 0.0v 429.505n 0.0v 439.495n 0.0v 439.505n 0.0v 449.495n 0.0v 449.505n 0.0v 459.495n 0.0v 459.505n 0.0v 469.495n 0.0v 469.505n 1.7v 479.495n 1.7v 479.505n 1.7v 489.495n 1.7v 489.505n 1.7v 499.495n 1.7v 499.505n 0.0v 509.495n 0.0v 509.505n 0.0v 519.495n 0.0v 519.505n 1.7v 529.495n 1.7v 529.505n 1.7v 539.495n 1.7v 539.505n 1.7v 549.495n 1.7v 549.505n 0.0v 559.495n 0.0v 559.505n 0.0v 569.495n 0.0v 569.505n 0.0v 579.495n 0.0v 579.505n 0.0v 589.495n 0.0v 589.505n 0.0v 599.495n 0.0v 599.505n 0.0v 609.495n 0.0v 609.505n 0.0v 619.495n 0.0v 619.505n 0.0v 629.495n 0.0v 629.505n 0.0v 639.495n 0.0v 639.505n 0.0v 649.495n 0.0v 649.505n 0.0v 659.495n 0.0v 659.505n 0.0v 669.495n 0.0v 669.505n 0.0v 679.495n 0.0v 679.505n 0.0v 689.495n 0.0v 689.505n 0.0v 699.495n 0.0v 699.505n 0.0v 709.495n 0.0v 709.505n 0.0v 719.495n 0.0v 719.505n 0.0v 729.495n 0.0v 729.505n 0.0v 739.495n 0.0v 739.505n 0.0v 749.495n 0.0v 749.505n 0.0v 759.495n 0.0v 759.505n 1.7v 769.495n 1.7v 769.505n 0.0v 779.495n 0.0v 779.505n 0.0v 789.495n 0.0v 789.505n 0.0v 799.495n 0.0v 799.505n 0.0v 809.495n 0.0v 809.505n 0.0v 819.495n 0.0v 819.505n 0.0v 829.495n 0.0v 829.505n 0.0v 839.495n 0.0v 839.505n 0.0v 849.495n 0.0v 849.505n 0.0v 859.495n 0.0v 859.505n 0.0v 869.495n 0.0v 869.505n 0.0v 879.495n 0.0v 879.505n 0.0v 889.495n 0.0v 889.505n 0.0v 899.495n 0.0v 899.505n 0.0v 909.495n 0.0v 909.505n 0.0v 919.495n 0.0v 919.505n 0.0v 929.495n 0.0v 929.505n 0.0v 939.495n 0.0v 939.505n 0.0v 949.495n 0.0v 949.505n 0.0v 959.495n 0.0v 959.505n 0.0v 969.495n 0.0v 969.505n 0.0v 979.495n 0.0v 979.505n 0.0v 989.495n 0.0v 989.505n 0.0v 999.495n 0.0v 999.505n 0.0v 1009.495n 0.0v 1009.505n 0.0v 1019.495n 0.0v 1019.505n 0.0v 1029.495n 0.0v 1029.505n 0.0v 1039.495n 0.0v 1039.505n 0.0v 1049.495n 0.0v 1049.505n 0.0v 1059.495n 0.0v 1059.505n 1.7v 1069.495n 1.7v 1069.505n 1.7v 1079.495n 1.7v 1079.505n 0.0v 1089.495n 0.0v 1089.505n 1.7v 1099.495n 1.7v 1099.505n 0.0v 1109.495n 0.0v 1109.505n 0.0v 1119.495n 0.0v 1119.505n 0.0v 1129.495n 0.0v 1129.505n 1.7v 1139.495n 1.7v 1139.505n 0.0v 1149.495n 0.0v 1149.505n 0.0v 1159.495n 0.0v 1159.505n 0.0v 1169.495n 0.0v 1169.505n 0.0v 1179.495n 0.0v 1179.505n 1.7v 1189.495n 1.7v 1189.505n 1.7v 1199.495n 1.7v 1199.505n 0.0v 1209.495n 0.0v 1209.505n 0.0v 1219.495n 0.0v 1219.505n 0.0v 1229.495n 0.0v 1229.505n 0.0v 1239.495n 0.0v 1239.505n 0.0v 1249.495n 0.0v 1249.505n 0.0v 1259.495n 0.0v 1259.505n 0.0v 1269.495n 0.0v 1269.505n 0.0v 1279.495n 0.0v 1279.505n 0.0v 1289.495n 0.0v 1289.505n 0.0v 1299.495n 0.0v 1299.505n 0.0v 1309.495n 0.0v 1309.505n 0.0v 1319.495n 0.0v 1319.505n 0.0v 1329.495n 0.0v 1329.505n 0.0v 1339.495n 0.0v 1339.505n 0.0v 1349.495n 0.0v 1349.505n 0.0v 1359.495n 0.0v 1359.505n 0.0v 1369.495n 0.0v 1369.505n 0.0v 1379.495n 0.0v 1379.505n 0.0v 1389.495n 0.0v 1389.505n 1.7v 1399.495n 1.7v 1399.505n 1.7v 1409.495n 1.7v 1409.505n 1.7v 1419.495n 1.7v 1419.505n 0.0v 1429.495n 0.0v 1429.505n 0.0v 1439.495n 0.0v 1439.505n 1.7v 1449.495n 1.7v 1449.505n 1.7v 1459.495n 1.7v 1459.505n 1.7v 1469.495n 1.7v 1469.505n 1.7v 1479.495n 1.7v 1479.505n 0.0v 1489.495n 0.0v 1489.505n 0.0v 1499.495n 0.0v 1499.505n 1.7v 1509.495n 1.7v 1509.505n 0.0v 1519.495n 0.0v 1519.505n 0.0v 1529.495n 0.0v 1529.505n 0.0v 1539.495n 0.0v 1539.505n 0.0v 1549.495n 0.0v 1549.505n 0.0v 1559.495n 0.0v 1559.505n 0.0v 1569.495n 0.0v 1569.505n 0.0v 1579.495n 0.0v 1579.505n 1.7v 1589.495n 1.7v 1589.505n 1.7v 1599.495n 1.7v 1599.505n 1.7v 1609.495n 1.7v 1609.505n 1.7v 1619.495n 1.7v 1619.505n 0.0v 1629.495n 0.0v 1629.505n 0.0v 1639.495n 0.0v 1639.505n 0.0v 1649.495n 0.0v 1649.505n 0.0v 1659.495n 0.0v 1659.505n 0.0v 1669.495n 0.0v 1669.505n 0.0v 1679.495n 0.0v 1679.505n 0.0v 1689.495n 0.0v 1689.505n 0.0v 1699.495n 0.0v 1699.505n 0.0v 1709.495n 0.0v 1709.505n 0.0v 1719.495n 0.0v 1719.505n 0.0v 1729.495n 0.0v 1729.505n 0.0v 1739.495n 0.0v 1739.505n 0.0v 1749.495n 0.0v 1749.505n 0.0v 1759.495n 0.0v 1759.505n 0.0v 1769.495n 0.0v 1769.505n 0.0v 1779.495n 0.0v 1779.505n 0.0v 1789.495n 0.0v 1789.505n 0.0v 1799.495n 0.0v 1799.505n 0.0v 1809.495n 0.0v 1809.505n 0.0v 1819.495n 0.0v 1819.505n 0.0v 1829.495n 0.0v 1829.505n 0.0v 1839.495n 0.0v 1839.505n 0.0v 1849.495n 0.0v 1849.505n 0.0v 1859.495n 0.0v 1859.505n 1.7v 1869.495n 1.7v 1869.505n 1.7v 1879.495n 1.7v 1879.505n 1.7v 1889.495n 1.7v 1889.505n 1.7v 1899.495n 1.7v 1899.505n 1.7v 1909.495n 1.7v 1909.505n 1.7v 1919.495n 1.7v 1919.505n 1.7v 1929.495n 1.7v 1929.505n 1.7v 1939.495n 1.7v 1939.505n 1.7v 1949.495n 1.7v 1949.505n 1.7v 1959.495n 1.7v 1959.505n 1.7v 1969.495n 1.7v 1969.505n 0.0v 1979.495n 0.0v 1979.505n 0.0v 1989.495n 0.0v 1989.505n 0.0v 1999.495n 0.0v 1999.505n 0.0v 2009.495n 0.0v 2009.505n 0.0v 2019.495n 0.0v 2019.505n 0.0v 2029.495n 0.0v 2029.505n 0.0v 2039.495n 0.0v 2039.505n 0.0v 2049.495n 0.0v 2049.505n 0.0v )
* (time, data): [(0, 0), (10, 0), (20, 0), (30, 0), (40, 0), (50, 0), (60, 0), (70, 0), (80, 0), (90, 0), (100, 0), (110, 0), (120, 0), (130, 0), (140, 0), (150, 0), (160, 0), (170, 0), (180, 0), (190, 0), (200, 0), (210, 0), (220, 0), (230, 0), (240, 0), (250, 0), (260, 0), (270, 0), (280, 0), (290, 0), (300, 0), (310, 0), (320, 1), (330, 1), (340, 0), (350, 0), (360, 1), (370, 0), (380, 0), (390, 0), (400, 0), (410, 0), (420, 0), (430, 0), (440, 0), (450, 0), (460, 0), (470, 1), (480, 1), (490, 1), (500, 0), (510, 0), (520, 1), (530, 1), (540, 1), (550, 0), (560, 0), (570, 0), (580, 0), (590, 0), (600, 0), (610, 0), (620, 0), (630, 0), (640, 0), (650, 0), (660, 0), (670, 0), (680, 0), (690, 0), (700, 0), (710, 0), (720, 0), (730, 0), (740, 0), (750, 0), (760, 1), (770, 0), (780, 0), (790, 0), (800, 0), (810, 0), (820, 0), (830, 0), (840, 0), (850, 0), (860, 0), (870, 0), (880, 0), (890, 0), (900, 0), (910, 0), (920, 0), (930, 0), (940, 0), (950, 0), (960, 0), (970, 0), (980, 0), (990, 0), (1000, 0), (1010, 0), (1020, 0), (1030, 0), (1040, 0), (1050, 0), (1060, 1), (1070, 1), (1080, 0), (1090, 1), (1100, 0), (1110, 0), (1120, 0), (1130, 1), (1140, 0), (1150, 0), (1160, 0), (1170, 0), (1180, 1), (1190, 1), (1200, 0), (1210, 0), (1220, 0), (1230, 0), (1240, 0), (1250, 0), (1260, 0), (1270, 0), (1280, 0), (1290, 0), (1300, 0), (1310, 0), (1320, 0), (1330, 0), (1340, 0), (1350, 0), (1360, 0), (1370, 0), (1380, 0), (1390, 1), (1400, 1), (1410, 1), (1420, 0), (1430, 0), (1440, 1), (1450, 1), (1460, 1), (1470, 1), (1480, 0), (1490, 0), (1500, 1), (1510, 0), (1520, 0), (1530, 0), (1540, 0), (1550, 0), (1560, 0), (1570, 0), (1580, 1), (1590, 1), (1600, 1), (1610, 1), (1620, 0), (1630, 0), (1640, 0), (1650, 0), (1660, 0), (1670, 0), (1680, 0), (1690, 0), (1700, 0), (1710, 0), (1720, 0), (1730, 0), (1740, 0), (1750, 0), (1760, 0), (1770, 0), (1780, 0), (1790, 0), (1800, 0), (1810, 0), (1820, 0), (1830, 0), (1840, 0), (1850, 0), (1860, 1), (1870, 1), (1880, 1), (1890, 1), (1900, 1), (1910, 1), (1920, 1), (1930, 1), (1940, 1), (1950, 1), (1960, 1), (1970, 0), (1980, 0), (1990, 0), (2000, 0), (2010, 0), (2020, 0), (2030, 0), (2040, 0), (2050, 0)]
Va1_4  a1_4  0 PWL (0n 0.0v 9.495n 0.0v 9.505n 0.0v 19.495n 0.0v 19.505n 0.0v 29.495n 0.0v 29.505n 0.0v 39.495n 0.0v 39.505n 0.0v 49.495n 0.0v 49.505n 0.0v 59.495n 0.0v 59.505n 0.0v 69.495n 0.0v 69.505n 0.0v 79.495n 0.0v 79.505n 0.0v 89.495n 0.0v 89.505n 0.0v 99.495n 0.0v 99.505n 0.0v 109.495n 0.0v 109.505n 0.0v 119.495n 0.0v 119.505n 0.0v 129.495n 0.0v 129.505n 0.0v 139.495n 0.0v 139.505n 0.0v 149.495n 0.0v 149.505n 0.0v 159.495n 0.0v 159.505n 0.0v 169.495n 0.0v 169.505n 0.0v 179.495n 0.0v 179.505n 0.0v 189.495n 0.0v 189.505n 0.0v 199.495n 0.0v 199.505n 0.0v 209.495n 0.0v 209.505n 0.0v 219.495n 0.0v 219.505n 0.0v 229.495n 0.0v 229.505n 0.0v 239.495n 0.0v 239.505n 0.0v 249.495n 0.0v 249.505n 0.0v 259.495n 0.0v 259.505n 0.0v 269.495n 0.0v 269.505n 0.0v 279.495n 0.0v 279.505n 0.0v 289.495n 0.0v 289.505n 0.0v 299.495n 0.0v 299.505n 0.0v 309.495n 0.0v 309.505n 0.0v 319.495n 0.0v 319.505n 1.7v 329.495n 1.7v 329.505n 1.7v 339.495n 1.7v 339.505n 0.0v 349.495n 0.0v 349.505n 0.0v 359.495n 0.0v 359.505n 1.7v 369.495n 1.7v 369.505n 0.0v 379.495n 0.0v 379.505n 0.0v 389.495n 0.0v 389.505n 0.0v 399.495n 0.0v 399.505n 0.0v 409.495n 0.0v 409.505n 0.0v 419.495n 0.0v 419.505n 0.0v 429.495n 0.0v 429.505n 0.0v 439.495n 0.0v 439.505n 0.0v 449.495n 0.0v 449.505n 0.0v 459.495n 0.0v 459.505n 0.0v 469.495n 0.0v 469.505n 1.7v 479.495n 1.7v 479.505n 1.7v 489.495n 1.7v 489.505n 1.7v 499.495n 1.7v 499.505n 0.0v 509.495n 0.0v 509.505n 0.0v 519.495n 0.0v 519.505n 1.7v 529.495n 1.7v 529.505n 1.7v 539.495n 1.7v 539.505n 1.7v 549.495n 1.7v 549.505n 0.0v 559.495n 0.0v 559.505n 0.0v 569.495n 0.0v 569.505n 0.0v 579.495n 0.0v 579.505n 0.0v 589.495n 0.0v 589.505n 0.0v 599.495n 0.0v 599.505n 0.0v 609.495n 0.0v 609.505n 0.0v 619.495n 0.0v 619.505n 0.0v 629.495n 0.0v 629.505n 0.0v 639.495n 0.0v 639.505n 0.0v 649.495n 0.0v 649.505n 0.0v 659.495n 0.0v 659.505n 0.0v 669.495n 0.0v 669.505n 0.0v 679.495n 0.0v 679.505n 0.0v 689.495n 0.0v 689.505n 0.0v 699.495n 0.0v 699.505n 0.0v 709.495n 0.0v 709.505n 0.0v 719.495n 0.0v 719.505n 0.0v 729.495n 0.0v 729.505n 0.0v 739.495n 0.0v 739.505n 0.0v 749.495n 0.0v 749.505n 0.0v 759.495n 0.0v 759.505n 1.7v 769.495n 1.7v 769.505n 0.0v 779.495n 0.0v 779.505n 0.0v 789.495n 0.0v 789.505n 0.0v 799.495n 0.0v 799.505n 0.0v 809.495n 0.0v 809.505n 0.0v 819.495n 0.0v 819.505n 0.0v 829.495n 0.0v 829.505n 0.0v 839.495n 0.0v 839.505n 0.0v 849.495n 0.0v 849.505n 0.0v 859.495n 0.0v 859.505n 0.0v 869.495n 0.0v 869.505n 0.0v 879.495n 0.0v 879.505n 0.0v 889.495n 0.0v 889.505n 0.0v 899.495n 0.0v 899.505n 0.0v 909.495n 0.0v 909.505n 0.0v 919.495n 0.0v 919.505n 0.0v 929.495n 0.0v 929.505n 0.0v 939.495n 0.0v 939.505n 0.0v 949.495n 0.0v 949.505n 0.0v 959.495n 0.0v 959.505n 0.0v 969.495n 0.0v 969.505n 0.0v 979.495n 0.0v 979.505n 0.0v 989.495n 0.0v 989.505n 0.0v 999.495n 0.0v 999.505n 0.0v 1009.495n 0.0v 1009.505n 0.0v 1019.495n 0.0v 1019.505n 0.0v 1029.495n 0.0v 1029.505n 0.0v 1039.495n 0.0v 1039.505n 0.0v 1049.495n 0.0v 1049.505n 0.0v 1059.495n 0.0v 1059.505n 1.7v 1069.495n 1.7v 1069.505n 1.7v 1079.495n 1.7v 1079.505n 0.0v 1089.495n 0.0v 1089.505n 1.7v 1099.495n 1.7v 1099.505n 0.0v 1109.495n 0.0v 1109.505n 0.0v 1119.495n 0.0v 1119.505n 0.0v 1129.495n 0.0v 1129.505n 1.7v 1139.495n 1.7v 1139.505n 0.0v 1149.495n 0.0v 1149.505n 0.0v 1159.495n 0.0v 1159.505n 0.0v 1169.495n 0.0v 1169.505n 0.0v 1179.495n 0.0v 1179.505n 1.7v 1189.495n 1.7v 1189.505n 1.7v 1199.495n 1.7v 1199.505n 0.0v 1209.495n 0.0v 1209.505n 0.0v 1219.495n 0.0v 1219.505n 0.0v 1229.495n 0.0v 1229.505n 0.0v 1239.495n 0.0v 1239.505n 0.0v 1249.495n 0.0v 1249.505n 0.0v 1259.495n 0.0v 1259.505n 0.0v 1269.495n 0.0v 1269.505n 0.0v 1279.495n 0.0v 1279.505n 0.0v 1289.495n 0.0v 1289.505n 0.0v 1299.495n 0.0v 1299.505n 0.0v 1309.495n 0.0v 1309.505n 0.0v 1319.495n 0.0v 1319.505n 0.0v 1329.495n 0.0v 1329.505n 0.0v 1339.495n 0.0v 1339.505n 0.0v 1349.495n 0.0v 1349.505n 0.0v 1359.495n 0.0v 1359.505n 0.0v 1369.495n 0.0v 1369.505n 0.0v 1379.495n 0.0v 1379.505n 0.0v 1389.495n 0.0v 1389.505n 1.7v 1399.495n 1.7v 1399.505n 1.7v 1409.495n 1.7v 1409.505n 1.7v 1419.495n 1.7v 1419.505n 0.0v 1429.495n 0.0v 1429.505n 0.0v 1439.495n 0.0v 1439.505n 1.7v 1449.495n 1.7v 1449.505n 1.7v 1459.495n 1.7v 1459.505n 1.7v 1469.495n 1.7v 1469.505n 1.7v 1479.495n 1.7v 1479.505n 0.0v 1489.495n 0.0v 1489.505n 0.0v 1499.495n 0.0v 1499.505n 1.7v 1509.495n 1.7v 1509.505n 0.0v 1519.495n 0.0v 1519.505n 0.0v 1529.495n 0.0v 1529.505n 0.0v 1539.495n 0.0v 1539.505n 0.0v 1549.495n 0.0v 1549.505n 0.0v 1559.495n 0.0v 1559.505n 0.0v 1569.495n 0.0v 1569.505n 0.0v 1579.495n 0.0v 1579.505n 1.7v 1589.495n 1.7v 1589.505n 1.7v 1599.495n 1.7v 1599.505n 1.7v 1609.495n 1.7v 1609.505n 1.7v 1619.495n 1.7v 1619.505n 0.0v 1629.495n 0.0v 1629.505n 0.0v 1639.495n 0.0v 1639.505n 0.0v 1649.495n 0.0v 1649.505n 0.0v 1659.495n 0.0v 1659.505n 0.0v 1669.495n 0.0v 1669.505n 0.0v 1679.495n 0.0v 1679.505n 0.0v 1689.495n 0.0v 1689.505n 0.0v 1699.495n 0.0v 1699.505n 0.0v 1709.495n 0.0v 1709.505n 0.0v 1719.495n 0.0v 1719.505n 0.0v 1729.495n 0.0v 1729.505n 0.0v 1739.495n 0.0v 1739.505n 0.0v 1749.495n 0.0v 1749.505n 0.0v 1759.495n 0.0v 1759.505n 0.0v 1769.495n 0.0v 1769.505n 0.0v 1779.495n 0.0v 1779.505n 0.0v 1789.495n 0.0v 1789.505n 0.0v 1799.495n 0.0v 1799.505n 0.0v 1809.495n 0.0v 1809.505n 0.0v 1819.495n 0.0v 1819.505n 0.0v 1829.495n 0.0v 1829.505n 0.0v 1839.495n 0.0v 1839.505n 0.0v 1849.495n 0.0v 1849.505n 0.0v 1859.495n 0.0v 1859.505n 1.7v 1869.495n 1.7v 1869.505n 1.7v 1879.495n 1.7v 1879.505n 1.7v 1889.495n 1.7v 1889.505n 1.7v 1899.495n 1.7v 1899.505n 1.7v 1909.495n 1.7v 1909.505n 1.7v 1919.495n 1.7v 1919.505n 1.7v 1929.495n 1.7v 1929.505n 1.7v 1939.495n 1.7v 1939.505n 1.7v 1949.495n 1.7v 1949.505n 1.7v 1959.495n 1.7v 1959.505n 1.7v 1969.495n 1.7v 1969.505n 0.0v 1979.495n 0.0v 1979.505n 0.0v 1989.495n 0.0v 1989.505n 0.0v 1999.495n 0.0v 1999.505n 0.0v 2009.495n 0.0v 2009.505n 0.0v 2019.495n 0.0v 2019.505n 0.0v 2029.495n 0.0v 2029.505n 0.0v 2039.495n 0.0v 2039.505n 0.0v 2049.495n 0.0v 2049.505n 0.0v )
* (time, data): [(0, 0), (10, 0), (20, 0), (30, 0), (40, 0), (50, 0), (60, 0), (70, 0), (80, 0), (90, 0), (100, 0), (110, 0), (120, 0), (130, 0), (140, 0), (150, 0), (160, 0), (170, 0), (180, 0), (190, 0), (200, 0), (210, 0), (220, 0), (230, 0), (240, 0), (250, 0), (260, 0), (270, 0), (280, 0), (290, 0), (300, 0), (310, 0), (320, 1), (330, 1), (340, 0), (350, 0), (360, 1), (370, 0), (380, 0), (390, 0), (400, 0), (410, 0), (420, 0), (430, 0), (440, 0), (450, 0), (460, 0), (470, 1), (480, 1), (490, 1), (500, 0), (510, 0), (520, 1), (530, 1), (540, 1), (550, 0), (560, 0), (570, 0), (580, 0), (590, 0), (600, 0), (610, 0), (620, 0), (630, 0), (640, 0), (650, 0), (660, 0), (670, 0), (680, 0), (690, 0), (700, 0), (710, 0), (720, 0), (730, 0), (740, 0), (750, 0), (760, 1), (770, 0), (780, 0), (790, 0), (800, 0), (810, 0), (820, 0), (830, 0), (840, 0), (850, 0), (860, 0), (870, 0), (880, 0), (890, 0), (900, 0), (910, 0), (920, 0), (930, 0), (940, 0), (950, 0), (960, 0), (970, 0), (980, 0), (990, 0), (1000, 0), (1010, 0), (1020, 0), (1030, 0), (1040, 0), (1050, 0), (1060, 1), (1070, 1), (1080, 0), (1090, 1), (1100, 0), (1110, 0), (1120, 0), (1130, 1), (1140, 0), (1150, 0), (1160, 0), (1170, 0), (1180, 1), (1190, 1), (1200, 0), (1210, 0), (1220, 0), (1230, 0), (1240, 0), (1250, 0), (1260, 0), (1270, 0), (1280, 0), (1290, 0), (1300, 0), (1310, 0), (1320, 0), (1330, 0), (1340, 0), (1350, 0), (1360, 0), (1370, 0), (1380, 0), (1390, 1), (1400, 1), (1410, 1), (1420, 0), (1430, 0), (1440, 1), (1450, 1), (1460, 1), (1470, 1), (1480, 0), (1490, 0), (1500, 1), (1510, 0), (1520, 0), (1530, 0), (1540, 0), (1550, 0), (1560, 0), (1570, 0), (1580, 1), (1590, 1), (1600, 1), (1610, 1), (1620, 0), (1630, 0), (1640, 0), (1650, 0), (1660, 0), (1670, 0), (1680, 0), (1690, 0), (1700, 0), (1710, 0), (1720, 0), (1730, 0), (1740, 0), (1750, 0), (1760, 0), (1770, 0), (1780, 0), (1790, 0), (1800, 0), (1810, 0), (1820, 0), (1830, 0), (1840, 0), (1850, 0), (1860, 1), (1870, 1), (1880, 1), (1890, 1), (1900, 1), (1910, 1), (1920, 1), (1930, 1), (1940, 1), (1950, 1), (1960, 1), (1970, 0), (1980, 0), (1990, 0), (2000, 0), (2010, 0), (2020, 0), (2030, 0), (2040, 0), (2050, 0)]
Va1_5  a1_5  0 PWL (0n 0.0v 9.495n 0.0v 9.505n 0.0v 19.495n 0.0v 19.505n 0.0v 29.495n 0.0v 29.505n 0.0v 39.495n 0.0v 39.505n 0.0v 49.495n 0.0v 49.505n 0.0v 59.495n 0.0v 59.505n 0.0v 69.495n 0.0v 69.505n 0.0v 79.495n 0.0v 79.505n 0.0v 89.495n 0.0v 89.505n 0.0v 99.495n 0.0v 99.505n 0.0v 109.495n 0.0v 109.505n 0.0v 119.495n 0.0v 119.505n 0.0v 129.495n 0.0v 129.505n 0.0v 139.495n 0.0v 139.505n 0.0v 149.495n 0.0v 149.505n 0.0v 159.495n 0.0v 159.505n 0.0v 169.495n 0.0v 169.505n 0.0v 179.495n 0.0v 179.505n 0.0v 189.495n 0.0v 189.505n 0.0v 199.495n 0.0v 199.505n 0.0v 209.495n 0.0v 209.505n 0.0v 219.495n 0.0v 219.505n 0.0v 229.495n 0.0v 229.505n 0.0v 239.495n 0.0v 239.505n 0.0v 249.495n 0.0v 249.505n 0.0v 259.495n 0.0v 259.505n 0.0v 269.495n 0.0v 269.505n 0.0v 279.495n 0.0v 279.505n 0.0v 289.495n 0.0v 289.505n 0.0v 299.495n 0.0v 299.505n 0.0v 309.495n 0.0v 309.505n 0.0v 319.495n 0.0v 319.505n 1.7v 329.495n 1.7v 329.505n 1.7v 339.495n 1.7v 339.505n 0.0v 349.495n 0.0v 349.505n 0.0v 359.495n 0.0v 359.505n 1.7v 369.495n 1.7v 369.505n 0.0v 379.495n 0.0v 379.505n 0.0v 389.495n 0.0v 389.505n 0.0v 399.495n 0.0v 399.505n 0.0v 409.495n 0.0v 409.505n 0.0v 419.495n 0.0v 419.505n 0.0v 429.495n 0.0v 429.505n 0.0v 439.495n 0.0v 439.505n 0.0v 449.495n 0.0v 449.505n 0.0v 459.495n 0.0v 459.505n 0.0v 469.495n 0.0v 469.505n 1.7v 479.495n 1.7v 479.505n 1.7v 489.495n 1.7v 489.505n 1.7v 499.495n 1.7v 499.505n 0.0v 509.495n 0.0v 509.505n 0.0v 519.495n 0.0v 519.505n 1.7v 529.495n 1.7v 529.505n 1.7v 539.495n 1.7v 539.505n 1.7v 549.495n 1.7v 549.505n 0.0v 559.495n 0.0v 559.505n 0.0v 569.495n 0.0v 569.505n 0.0v 579.495n 0.0v 579.505n 0.0v 589.495n 0.0v 589.505n 0.0v 599.495n 0.0v 599.505n 0.0v 609.495n 0.0v 609.505n 0.0v 619.495n 0.0v 619.505n 0.0v 629.495n 0.0v 629.505n 0.0v 639.495n 0.0v 639.505n 0.0v 649.495n 0.0v 649.505n 0.0v 659.495n 0.0v 659.505n 0.0v 669.495n 0.0v 669.505n 0.0v 679.495n 0.0v 679.505n 0.0v 689.495n 0.0v 689.505n 0.0v 699.495n 0.0v 699.505n 0.0v 709.495n 0.0v 709.505n 0.0v 719.495n 0.0v 719.505n 0.0v 729.495n 0.0v 729.505n 0.0v 739.495n 0.0v 739.505n 0.0v 749.495n 0.0v 749.505n 0.0v 759.495n 0.0v 759.505n 1.7v 769.495n 1.7v 769.505n 0.0v 779.495n 0.0v 779.505n 0.0v 789.495n 0.0v 789.505n 0.0v 799.495n 0.0v 799.505n 0.0v 809.495n 0.0v 809.505n 0.0v 819.495n 0.0v 819.505n 0.0v 829.495n 0.0v 829.505n 0.0v 839.495n 0.0v 839.505n 0.0v 849.495n 0.0v 849.505n 0.0v 859.495n 0.0v 859.505n 0.0v 869.495n 0.0v 869.505n 0.0v 879.495n 0.0v 879.505n 0.0v 889.495n 0.0v 889.505n 0.0v 899.495n 0.0v 899.505n 0.0v 909.495n 0.0v 909.505n 0.0v 919.495n 0.0v 919.505n 0.0v 929.495n 0.0v 929.505n 0.0v 939.495n 0.0v 939.505n 0.0v 949.495n 0.0v 949.505n 0.0v 959.495n 0.0v 959.505n 0.0v 969.495n 0.0v 969.505n 0.0v 979.495n 0.0v 979.505n 0.0v 989.495n 0.0v 989.505n 0.0v 999.495n 0.0v 999.505n 0.0v 1009.495n 0.0v 1009.505n 0.0v 1019.495n 0.0v 1019.505n 0.0v 1029.495n 0.0v 1029.505n 0.0v 1039.495n 0.0v 1039.505n 0.0v 1049.495n 0.0v 1049.505n 0.0v 1059.495n 0.0v 1059.505n 1.7v 1069.495n 1.7v 1069.505n 1.7v 1079.495n 1.7v 1079.505n 0.0v 1089.495n 0.0v 1089.505n 1.7v 1099.495n 1.7v 1099.505n 0.0v 1109.495n 0.0v 1109.505n 0.0v 1119.495n 0.0v 1119.505n 0.0v 1129.495n 0.0v 1129.505n 1.7v 1139.495n 1.7v 1139.505n 0.0v 1149.495n 0.0v 1149.505n 0.0v 1159.495n 0.0v 1159.505n 0.0v 1169.495n 0.0v 1169.505n 0.0v 1179.495n 0.0v 1179.505n 1.7v 1189.495n 1.7v 1189.505n 1.7v 1199.495n 1.7v 1199.505n 0.0v 1209.495n 0.0v 1209.505n 0.0v 1219.495n 0.0v 1219.505n 0.0v 1229.495n 0.0v 1229.505n 0.0v 1239.495n 0.0v 1239.505n 0.0v 1249.495n 0.0v 1249.505n 0.0v 1259.495n 0.0v 1259.505n 0.0v 1269.495n 0.0v 1269.505n 0.0v 1279.495n 0.0v 1279.505n 0.0v 1289.495n 0.0v 1289.505n 0.0v 1299.495n 0.0v 1299.505n 0.0v 1309.495n 0.0v 1309.505n 0.0v 1319.495n 0.0v 1319.505n 0.0v 1329.495n 0.0v 1329.505n 0.0v 1339.495n 0.0v 1339.505n 0.0v 1349.495n 0.0v 1349.505n 0.0v 1359.495n 0.0v 1359.505n 0.0v 1369.495n 0.0v 1369.505n 0.0v 1379.495n 0.0v 1379.505n 0.0v 1389.495n 0.0v 1389.505n 1.7v 1399.495n 1.7v 1399.505n 1.7v 1409.495n 1.7v 1409.505n 1.7v 1419.495n 1.7v 1419.505n 0.0v 1429.495n 0.0v 1429.505n 0.0v 1439.495n 0.0v 1439.505n 1.7v 1449.495n 1.7v 1449.505n 1.7v 1459.495n 1.7v 1459.505n 1.7v 1469.495n 1.7v 1469.505n 1.7v 1479.495n 1.7v 1479.505n 0.0v 1489.495n 0.0v 1489.505n 0.0v 1499.495n 0.0v 1499.505n 1.7v 1509.495n 1.7v 1509.505n 0.0v 1519.495n 0.0v 1519.505n 0.0v 1529.495n 0.0v 1529.505n 0.0v 1539.495n 0.0v 1539.505n 0.0v 1549.495n 0.0v 1549.505n 0.0v 1559.495n 0.0v 1559.505n 0.0v 1569.495n 0.0v 1569.505n 0.0v 1579.495n 0.0v 1579.505n 1.7v 1589.495n 1.7v 1589.505n 1.7v 1599.495n 1.7v 1599.505n 1.7v 1609.495n 1.7v 1609.505n 1.7v 1619.495n 1.7v 1619.505n 0.0v 1629.495n 0.0v 1629.505n 0.0v 1639.495n 0.0v 1639.505n 0.0v 1649.495n 0.0v 1649.505n 0.0v 1659.495n 0.0v 1659.505n 0.0v 1669.495n 0.0v 1669.505n 0.0v 1679.495n 0.0v 1679.505n 0.0v 1689.495n 0.0v 1689.505n 0.0v 1699.495n 0.0v 1699.505n 0.0v 1709.495n 0.0v 1709.505n 0.0v 1719.495n 0.0v 1719.505n 0.0v 1729.495n 0.0v 1729.505n 0.0v 1739.495n 0.0v 1739.505n 0.0v 1749.495n 0.0v 1749.505n 0.0v 1759.495n 0.0v 1759.505n 0.0v 1769.495n 0.0v 1769.505n 0.0v 1779.495n 0.0v 1779.505n 0.0v 1789.495n 0.0v 1789.505n 0.0v 1799.495n 0.0v 1799.505n 0.0v 1809.495n 0.0v 1809.505n 0.0v 1819.495n 0.0v 1819.505n 0.0v 1829.495n 0.0v 1829.505n 0.0v 1839.495n 0.0v 1839.505n 0.0v 1849.495n 0.0v 1849.505n 0.0v 1859.495n 0.0v 1859.505n 1.7v 1869.495n 1.7v 1869.505n 1.7v 1879.495n 1.7v 1879.505n 1.7v 1889.495n 1.7v 1889.505n 1.7v 1899.495n 1.7v 1899.505n 1.7v 1909.495n 1.7v 1909.505n 1.7v 1919.495n 1.7v 1919.505n 1.7v 1929.495n 1.7v 1929.505n 1.7v 1939.495n 1.7v 1939.505n 1.7v 1949.495n 1.7v 1949.505n 1.7v 1959.495n 1.7v 1959.505n 1.7v 1969.495n 1.7v 1969.505n 0.0v 1979.495n 0.0v 1979.505n 0.0v 1989.495n 0.0v 1989.505n 0.0v 1999.495n 0.0v 1999.505n 0.0v 2009.495n 0.0v 2009.505n 0.0v 2019.495n 0.0v 2019.505n 0.0v 2029.495n 0.0v 2029.505n 0.0v 2039.495n 0.0v 2039.505n 0.0v 2049.495n 0.0v 2049.505n 0.0v )
* (time, data): [(0, 0), (10, 0), (20, 0), (30, 0), (40, 0), (50, 0), (60, 0), (70, 0), (80, 0), (90, 0), (100, 0), (110, 0), (120, 0), (130, 0), (140, 0), (150, 0), (160, 0), (170, 0), (180, 0), (190, 0), (200, 0), (210, 0), (220, 0), (230, 0), (240, 0), (250, 0), (260, 0), (270, 0), (280, 0), (290, 0), (300, 0), (310, 0), (320, 1), (330, 1), (340, 0), (350, 0), (360, 1), (370, 0), (380, 0), (390, 0), (400, 0), (410, 0), (420, 0), (430, 0), (440, 0), (450, 0), (460, 0), (470, 1), (480, 1), (490, 1), (500, 0), (510, 0), (520, 1), (530, 1), (540, 1), (550, 0), (560, 0), (570, 0), (580, 0), (590, 0), (600, 0), (610, 0), (620, 0), (630, 0), (640, 0), (650, 0), (660, 0), (670, 0), (680, 0), (690, 0), (700, 0), (710, 0), (720, 0), (730, 0), (740, 0), (750, 0), (760, 1), (770, 0), (780, 0), (790, 0), (800, 0), (810, 0), (820, 0), (830, 0), (840, 0), (850, 0), (860, 0), (870, 0), (880, 0), (890, 0), (900, 0), (910, 0), (920, 0), (930, 0), (940, 0), (950, 0), (960, 0), (970, 0), (980, 0), (990, 0), (1000, 0), (1010, 0), (1020, 0), (1030, 0), (1040, 0), (1050, 0), (1060, 1), (1070, 1), (1080, 0), (1090, 1), (1100, 0), (1110, 0), (1120, 0), (1130, 1), (1140, 0), (1150, 0), (1160, 0), (1170, 0), (1180, 1), (1190, 1), (1200, 0), (1210, 0), (1220, 0), (1230, 0), (1240, 0), (1250, 0), (1260, 0), (1270, 0), (1280, 0), (1290, 0), (1300, 0), (1310, 0), (1320, 0), (1330, 0), (1340, 0), (1350, 0), (1360, 0), (1370, 0), (1380, 0), (1390, 1), (1400, 1), (1410, 1), (1420, 0), (1430, 0), (1440, 1), (1450, 1), (1460, 1), (1470, 1), (1480, 0), (1490, 0), (1500, 1), (1510, 0), (1520, 0), (1530, 0), (1540, 0), (1550, 0), (1560, 0), (1570, 0), (1580, 1), (1590, 1), (1600, 1), (1610, 1), (1620, 0), (1630, 0), (1640, 0), (1650, 0), (1660, 0), (1670, 0), (1680, 0), (1690, 0), (1700, 0), (1710, 0), (1720, 0), (1730, 0), (1740, 0), (1750, 0), (1760, 0), (1770, 0), (1780, 0), (1790, 0), (1800, 0), (1810, 0), (1820, 0), (1830, 0), (1840, 0), (1850, 0), (1860, 1), (1870, 1), (1880, 1), (1890, 1), (1900, 1), (1910, 1), (1920, 1), (1930, 1), (1940, 1), (1950, 1), (1960, 1), (1970, 0), (1980, 0), (1990, 0), (2000, 0), (2010, 0), (2020, 0), (2030, 0), (2040, 0), (2050, 0)]
Va1_6  a1_6  0 PWL (0n 0.0v 9.495n 0.0v 9.505n 0.0v 19.495n 0.0v 19.505n 0.0v 29.495n 0.0v 29.505n 0.0v 39.495n 0.0v 39.505n 0.0v 49.495n 0.0v 49.505n 0.0v 59.495n 0.0v 59.505n 0.0v 69.495n 0.0v 69.505n 0.0v 79.495n 0.0v 79.505n 0.0v 89.495n 0.0v 89.505n 0.0v 99.495n 0.0v 99.505n 0.0v 109.495n 0.0v 109.505n 0.0v 119.495n 0.0v 119.505n 0.0v 129.495n 0.0v 129.505n 0.0v 139.495n 0.0v 139.505n 0.0v 149.495n 0.0v 149.505n 0.0v 159.495n 0.0v 159.505n 0.0v 169.495n 0.0v 169.505n 0.0v 179.495n 0.0v 179.505n 0.0v 189.495n 0.0v 189.505n 0.0v 199.495n 0.0v 199.505n 0.0v 209.495n 0.0v 209.505n 0.0v 219.495n 0.0v 219.505n 0.0v 229.495n 0.0v 229.505n 0.0v 239.495n 0.0v 239.505n 0.0v 249.495n 0.0v 249.505n 0.0v 259.495n 0.0v 259.505n 0.0v 269.495n 0.0v 269.505n 0.0v 279.495n 0.0v 279.505n 0.0v 289.495n 0.0v 289.505n 0.0v 299.495n 0.0v 299.505n 0.0v 309.495n 0.0v 309.505n 0.0v 319.495n 0.0v 319.505n 1.7v 329.495n 1.7v 329.505n 1.7v 339.495n 1.7v 339.505n 0.0v 349.495n 0.0v 349.505n 0.0v 359.495n 0.0v 359.505n 1.7v 369.495n 1.7v 369.505n 0.0v 379.495n 0.0v 379.505n 0.0v 389.495n 0.0v 389.505n 0.0v 399.495n 0.0v 399.505n 0.0v 409.495n 0.0v 409.505n 0.0v 419.495n 0.0v 419.505n 0.0v 429.495n 0.0v 429.505n 0.0v 439.495n 0.0v 439.505n 0.0v 449.495n 0.0v 449.505n 0.0v 459.495n 0.0v 459.505n 0.0v 469.495n 0.0v 469.505n 1.7v 479.495n 1.7v 479.505n 1.7v 489.495n 1.7v 489.505n 1.7v 499.495n 1.7v 499.505n 0.0v 509.495n 0.0v 509.505n 0.0v 519.495n 0.0v 519.505n 1.7v 529.495n 1.7v 529.505n 1.7v 539.495n 1.7v 539.505n 1.7v 549.495n 1.7v 549.505n 0.0v 559.495n 0.0v 559.505n 0.0v 569.495n 0.0v 569.505n 0.0v 579.495n 0.0v 579.505n 0.0v 589.495n 0.0v 589.505n 0.0v 599.495n 0.0v 599.505n 0.0v 609.495n 0.0v 609.505n 0.0v 619.495n 0.0v 619.505n 0.0v 629.495n 0.0v 629.505n 0.0v 639.495n 0.0v 639.505n 0.0v 649.495n 0.0v 649.505n 0.0v 659.495n 0.0v 659.505n 0.0v 669.495n 0.0v 669.505n 0.0v 679.495n 0.0v 679.505n 0.0v 689.495n 0.0v 689.505n 0.0v 699.495n 0.0v 699.505n 0.0v 709.495n 0.0v 709.505n 0.0v 719.495n 0.0v 719.505n 0.0v 729.495n 0.0v 729.505n 0.0v 739.495n 0.0v 739.505n 0.0v 749.495n 0.0v 749.505n 0.0v 759.495n 0.0v 759.505n 1.7v 769.495n 1.7v 769.505n 0.0v 779.495n 0.0v 779.505n 0.0v 789.495n 0.0v 789.505n 0.0v 799.495n 0.0v 799.505n 0.0v 809.495n 0.0v 809.505n 0.0v 819.495n 0.0v 819.505n 0.0v 829.495n 0.0v 829.505n 0.0v 839.495n 0.0v 839.505n 0.0v 849.495n 0.0v 849.505n 0.0v 859.495n 0.0v 859.505n 0.0v 869.495n 0.0v 869.505n 0.0v 879.495n 0.0v 879.505n 0.0v 889.495n 0.0v 889.505n 0.0v 899.495n 0.0v 899.505n 0.0v 909.495n 0.0v 909.505n 0.0v 919.495n 0.0v 919.505n 0.0v 929.495n 0.0v 929.505n 0.0v 939.495n 0.0v 939.505n 0.0v 949.495n 0.0v 949.505n 0.0v 959.495n 0.0v 959.505n 0.0v 969.495n 0.0v 969.505n 0.0v 979.495n 0.0v 979.505n 0.0v 989.495n 0.0v 989.505n 0.0v 999.495n 0.0v 999.505n 0.0v 1009.495n 0.0v 1009.505n 0.0v 1019.495n 0.0v 1019.505n 0.0v 1029.495n 0.0v 1029.505n 0.0v 1039.495n 0.0v 1039.505n 0.0v 1049.495n 0.0v 1049.505n 0.0v 1059.495n 0.0v 1059.505n 1.7v 1069.495n 1.7v 1069.505n 1.7v 1079.495n 1.7v 1079.505n 0.0v 1089.495n 0.0v 1089.505n 1.7v 1099.495n 1.7v 1099.505n 0.0v 1109.495n 0.0v 1109.505n 0.0v 1119.495n 0.0v 1119.505n 0.0v 1129.495n 0.0v 1129.505n 1.7v 1139.495n 1.7v 1139.505n 0.0v 1149.495n 0.0v 1149.505n 0.0v 1159.495n 0.0v 1159.505n 0.0v 1169.495n 0.0v 1169.505n 0.0v 1179.495n 0.0v 1179.505n 1.7v 1189.495n 1.7v 1189.505n 1.7v 1199.495n 1.7v 1199.505n 0.0v 1209.495n 0.0v 1209.505n 0.0v 1219.495n 0.0v 1219.505n 0.0v 1229.495n 0.0v 1229.505n 0.0v 1239.495n 0.0v 1239.505n 0.0v 1249.495n 0.0v 1249.505n 0.0v 1259.495n 0.0v 1259.505n 0.0v 1269.495n 0.0v 1269.505n 0.0v 1279.495n 0.0v 1279.505n 0.0v 1289.495n 0.0v 1289.505n 0.0v 1299.495n 0.0v 1299.505n 0.0v 1309.495n 0.0v 1309.505n 0.0v 1319.495n 0.0v 1319.505n 0.0v 1329.495n 0.0v 1329.505n 0.0v 1339.495n 0.0v 1339.505n 0.0v 1349.495n 0.0v 1349.505n 0.0v 1359.495n 0.0v 1359.505n 0.0v 1369.495n 0.0v 1369.505n 0.0v 1379.495n 0.0v 1379.505n 0.0v 1389.495n 0.0v 1389.505n 1.7v 1399.495n 1.7v 1399.505n 1.7v 1409.495n 1.7v 1409.505n 1.7v 1419.495n 1.7v 1419.505n 0.0v 1429.495n 0.0v 1429.505n 0.0v 1439.495n 0.0v 1439.505n 1.7v 1449.495n 1.7v 1449.505n 1.7v 1459.495n 1.7v 1459.505n 1.7v 1469.495n 1.7v 1469.505n 1.7v 1479.495n 1.7v 1479.505n 0.0v 1489.495n 0.0v 1489.505n 0.0v 1499.495n 0.0v 1499.505n 1.7v 1509.495n 1.7v 1509.505n 0.0v 1519.495n 0.0v 1519.505n 0.0v 1529.495n 0.0v 1529.505n 0.0v 1539.495n 0.0v 1539.505n 0.0v 1549.495n 0.0v 1549.505n 0.0v 1559.495n 0.0v 1559.505n 0.0v 1569.495n 0.0v 1569.505n 0.0v 1579.495n 0.0v 1579.505n 1.7v 1589.495n 1.7v 1589.505n 1.7v 1599.495n 1.7v 1599.505n 1.7v 1609.495n 1.7v 1609.505n 1.7v 1619.495n 1.7v 1619.505n 0.0v 1629.495n 0.0v 1629.505n 0.0v 1639.495n 0.0v 1639.505n 0.0v 1649.495n 0.0v 1649.505n 0.0v 1659.495n 0.0v 1659.505n 0.0v 1669.495n 0.0v 1669.505n 0.0v 1679.495n 0.0v 1679.505n 0.0v 1689.495n 0.0v 1689.505n 0.0v 1699.495n 0.0v 1699.505n 0.0v 1709.495n 0.0v 1709.505n 0.0v 1719.495n 0.0v 1719.505n 0.0v 1729.495n 0.0v 1729.505n 0.0v 1739.495n 0.0v 1739.505n 0.0v 1749.495n 0.0v 1749.505n 0.0v 1759.495n 0.0v 1759.505n 0.0v 1769.495n 0.0v 1769.505n 0.0v 1779.495n 0.0v 1779.505n 0.0v 1789.495n 0.0v 1789.505n 0.0v 1799.495n 0.0v 1799.505n 0.0v 1809.495n 0.0v 1809.505n 0.0v 1819.495n 0.0v 1819.505n 0.0v 1829.495n 0.0v 1829.505n 0.0v 1839.495n 0.0v 1839.505n 0.0v 1849.495n 0.0v 1849.505n 0.0v 1859.495n 0.0v 1859.505n 1.7v 1869.495n 1.7v 1869.505n 1.7v 1879.495n 1.7v 1879.505n 1.7v 1889.495n 1.7v 1889.505n 1.7v 1899.495n 1.7v 1899.505n 1.7v 1909.495n 1.7v 1909.505n 1.7v 1919.495n 1.7v 1919.505n 1.7v 1929.495n 1.7v 1929.505n 1.7v 1939.495n 1.7v 1939.505n 1.7v 1949.495n 1.7v 1949.505n 1.7v 1959.495n 1.7v 1959.505n 1.7v 1969.495n 1.7v 1969.505n 0.0v 1979.495n 0.0v 1979.505n 0.0v 1989.495n 0.0v 1989.505n 0.0v 1999.495n 0.0v 1999.505n 0.0v 2009.495n 0.0v 2009.505n 0.0v 2019.495n 0.0v 2019.505n 0.0v 2029.495n 0.0v 2029.505n 0.0v 2039.495n 0.0v 2039.505n 0.0v 2049.495n 0.0v 2049.505n 0.0v )
* (time, data): [(0, 0), (10, 0), (20, 0), (30, 0), (40, 0), (50, 0), (60, 0), (70, 0), (80, 0), (90, 0), (100, 0), (110, 0), (120, 0), (130, 0), (140, 0), (150, 0), (160, 0), (170, 0), (180, 1), (190, 1), (200, 1), (210, 1), (220, 0), (230, 0), (240, 0), (250, 0), (260, 0), (270, 1), (280, 1), (290, 1), (300, 1), (310, 0), (320, 0), (330, 0), (340, 1), (350, 0), (360, 0), (370, 1), (380, 1), (390, 1), (400, 1), (410, 1), (420, 0), (430, 0), (440, 0), (450, 0), (460, 0), (470, 0), (480, 0), (490, 0), (500, 0), (510, 0), (520, 0), (530, 0), (540, 0), (550, 0), (560, 0), (570, 0), (580, 0), (590, 1), (600, 1), (610, 1), (620, 1), (630, 1), (640, 1), (650, 1), (660, 1), (670, 1), (680, 1), (690, 1), (700, 0), (710, 0), (720, 0), (730, 0), (740, 0), (750, 0), (760, 0), (770, 0), (780, 0), (790, 0), (800, 0), (810, 0), (820, 0), (830, 0), (840, 0), (850, 0), (860, 0), (870, 0), (880, 0), (890, 0), (900, 0), (910, 0), (920, 0), (930, 1), (940, 1), (950, 1), (960, 1), (970, 1), (980, 1), (990, 1), (1000, 1), (1010, 1), (1020, 1), (1030, 1), (1040, 1), (1050, 0), (1060, 0), (1070, 0), (1080, 1), (1090, 0), (1100, 0), (1110, 1), (1120, 1), (1130, 0), (1140, 1), (1150, 1), (1160, 1), (1170, 1), (1180, 0), (1190, 0), (1200, 0), (1210, 0), (1220, 0), (1230, 0), (1240, 0), (1250, 0), (1260, 0), (1270, 0), (1280, 0), (1290, 0), (1300, 0), (1310, 0), (1320, 0), (1330, 0), (1340, 0), (1350, 0), (1360, 0), (1370, 0), (1380, 0), (1390, 0), (1400, 0), (1410, 0), (1420, 0), (1430, 0), (1440, 0), (1450, 0), (1460, 0), (1470, 0), (1480, 1), (1490, 1), (1500, 0), (1510, 1), (1520, 1), (1530, 1), (1540, 0), (1550, 0), (1560, 1), (1570, 1), (1580, 0), (1590, 0), (1600, 0), (1610, 0), (1620, 0), (1630, 0), (1640, 0), (1650, 0), (1660, 0), (1670, 0), (1680, 0), (1690, 0), (1700, 0), (1710, 0), (1720, 0), (1730, 0), (1740, 0), (1750, 0), (1760, 0), (1770, 0), (1780, 0), (1790, 0), (1800, 0), (1810, 0), (1820, 0), (1830, 1), (1840, 1), (1850, 1), (1860, 0), (1870, 0), (1880, 0), (1890, 0), (1900, 0), (1910, 0), (1920, 0), (1930, 0), (1940, 0), (1950, 0), (1960, 0), (1970, 0), (1980, 0), (1990, 0), (2000, 0), (2010, 0), (2020, 0), (2030, 0), (2040, 0), (2050, 0)]
Va1_7  a1_7  0 PWL (0n 0.0v 9.495n 0.0v 9.505n 0.0v 19.495n 0.0v 19.505n 0.0v 29.495n 0.0v 29.505n 0.0v 39.495n 0.0v 39.505n 0.0v 49.495n 0.0v 49.505n 0.0v 59.495n 0.0v 59.505n 0.0v 69.495n 0.0v 69.505n 0.0v 79.495n 0.0v 79.505n 0.0v 89.495n 0.0v 89.505n 0.0v 99.495n 0.0v 99.505n 0.0v 109.495n 0.0v 109.505n 0.0v 119.495n 0.0v 119.505n 0.0v 129.495n 0.0v 129.505n 0.0v 139.495n 0.0v 139.505n 0.0v 149.495n 0.0v 149.505n 0.0v 159.495n 0.0v 159.505n 0.0v 169.495n 0.0v 169.505n 0.0v 179.495n 0.0v 179.505n 1.7v 189.495n 1.7v 189.505n 1.7v 199.495n 1.7v 199.505n 1.7v 209.495n 1.7v 209.505n 1.7v 219.495n 1.7v 219.505n 0.0v 229.495n 0.0v 229.505n 0.0v 239.495n 0.0v 239.505n 0.0v 249.495n 0.0v 249.505n 0.0v 259.495n 0.0v 259.505n 0.0v 269.495n 0.0v 269.505n 1.7v 279.495n 1.7v 279.505n 1.7v 289.495n 1.7v 289.505n 1.7v 299.495n 1.7v 299.505n 1.7v 309.495n 1.7v 309.505n 0.0v 319.495n 0.0v 319.505n 0.0v 329.495n 0.0v 329.505n 0.0v 339.495n 0.0v 339.505n 1.7v 349.495n 1.7v 349.505n 0.0v 359.495n 0.0v 359.505n 0.0v 369.495n 0.0v 369.505n 1.7v 379.495n 1.7v 379.505n 1.7v 389.495n 1.7v 389.505n 1.7v 399.495n 1.7v 399.505n 1.7v 409.495n 1.7v 409.505n 1.7v 419.495n 1.7v 419.505n 0.0v 429.495n 0.0v 429.505n 0.0v 439.495n 0.0v 439.505n 0.0v 449.495n 0.0v 449.505n 0.0v 459.495n 0.0v 459.505n 0.0v 469.495n 0.0v 469.505n 0.0v 479.495n 0.0v 479.505n 0.0v 489.495n 0.0v 489.505n 0.0v 499.495n 0.0v 499.505n 0.0v 509.495n 0.0v 509.505n 0.0v 519.495n 0.0v 519.505n 0.0v 529.495n 0.0v 529.505n 0.0v 539.495n 0.0v 539.505n 0.0v 549.495n 0.0v 549.505n 0.0v 559.495n 0.0v 559.505n 0.0v 569.495n 0.0v 569.505n 0.0v 579.495n 0.0v 579.505n 0.0v 589.495n 0.0v 589.505n 1.7v 599.495n 1.7v 599.505n 1.7v 609.495n 1.7v 609.505n 1.7v 619.495n 1.7v 619.505n 1.7v 629.495n 1.7v 629.505n 1.7v 639.495n 1.7v 639.505n 1.7v 649.495n 1.7v 649.505n 1.7v 659.495n 1.7v 659.505n 1.7v 669.495n 1.7v 669.505n 1.7v 679.495n 1.7v 679.505n 1.7v 689.495n 1.7v 689.505n 1.7v 699.495n 1.7v 699.505n 0.0v 709.495n 0.0v 709.505n 0.0v 719.495n 0.0v 719.505n 0.0v 729.495n 0.0v 729.505n 0.0v 739.495n 0.0v 739.505n 0.0v 749.495n 0.0v 749.505n 0.0v 759.495n 0.0v 759.505n 0.0v 769.495n 0.0v 769.505n 0.0v 779.495n 0.0v 779.505n 0.0v 789.495n 0.0v 789.505n 0.0v 799.495n 0.0v 799.505n 0.0v 809.495n 0.0v 809.505n 0.0v 819.495n 0.0v 819.505n 0.0v 829.495n 0.0v 829.505n 0.0v 839.495n 0.0v 839.505n 0.0v 849.495n 0.0v 849.505n 0.0v 859.495n 0.0v 859.505n 0.0v 869.495n 0.0v 869.505n 0.0v 879.495n 0.0v 879.505n 0.0v 889.495n 0.0v 889.505n 0.0v 899.495n 0.0v 899.505n 0.0v 909.495n 0.0v 909.505n 0.0v 919.495n 0.0v 919.505n 0.0v 929.495n 0.0v 929.505n 1.7v 939.495n 1.7v 939.505n 1.7v 949.495n 1.7v 949.505n 1.7v 959.495n 1.7v 959.505n 1.7v 969.495n 1.7v 969.505n 1.7v 979.495n 1.7v 979.505n 1.7v 989.495n 1.7v 989.505n 1.7v 999.495n 1.7v 999.505n 1.7v 1009.495n 1.7v 1009.505n 1.7v 1019.495n 1.7v 1019.505n 1.7v 1029.495n 1.7v 1029.505n 1.7v 1039.495n 1.7v 1039.505n 1.7v 1049.495n 1.7v 1049.505n 0.0v 1059.495n 0.0v 1059.505n 0.0v 1069.495n 0.0v 1069.505n 0.0v 1079.495n 0.0v 1079.505n 1.7v 1089.495n 1.7v 1089.505n 0.0v 1099.495n 0.0v 1099.505n 0.0v 1109.495n 0.0v 1109.505n 1.7v 1119.495n 1.7v 1119.505n 1.7v 1129.495n 1.7v 1129.505n 0.0v 1139.495n 0.0v 1139.505n 1.7v 1149.495n 1.7v 1149.505n 1.7v 1159.495n 1.7v 1159.505n 1.7v 1169.495n 1.7v 1169.505n 1.7v 1179.495n 1.7v 1179.505n 0.0v 1189.495n 0.0v 1189.505n 0.0v 1199.495n 0.0v 1199.505n 0.0v 1209.495n 0.0v 1209.505n 0.0v 1219.495n 0.0v 1219.505n 0.0v 1229.495n 0.0v 1229.505n 0.0v 1239.495n 0.0v 1239.505n 0.0v 1249.495n 0.0v 1249.505n 0.0v 1259.495n 0.0v 1259.505n 0.0v 1269.495n 0.0v 1269.505n 0.0v 1279.495n 0.0v 1279.505n 0.0v 1289.495n 0.0v 1289.505n 0.0v 1299.495n 0.0v 1299.505n 0.0v 1309.495n 0.0v 1309.505n 0.0v 1319.495n 0.0v 1319.505n 0.0v 1329.495n 0.0v 1329.505n 0.0v 1339.495n 0.0v 1339.505n 0.0v 1349.495n 0.0v 1349.505n 0.0v 1359.495n 0.0v 1359.505n 0.0v 1369.495n 0.0v 1369.505n 0.0v 1379.495n 0.0v 1379.505n 0.0v 1389.495n 0.0v 1389.505n 0.0v 1399.495n 0.0v 1399.505n 0.0v 1409.495n 0.0v 1409.505n 0.0v 1419.495n 0.0v 1419.505n 0.0v 1429.495n 0.0v 1429.505n 0.0v 1439.495n 0.0v 1439.505n 0.0v 1449.495n 0.0v 1449.505n 0.0v 1459.495n 0.0v 1459.505n 0.0v 1469.495n 0.0v 1469.505n 0.0v 1479.495n 0.0v 1479.505n 1.7v 1489.495n 1.7v 1489.505n 1.7v 1499.495n 1.7v 1499.505n 0.0v 1509.495n 0.0v 1509.505n 1.7v 1519.495n 1.7v 1519.505n 1.7v 1529.495n 1.7v 1529.505n 1.7v 1539.495n 1.7v 1539.505n 0.0v 1549.495n 0.0v 1549.505n 0.0v 1559.495n 0.0v 1559.505n 1.7v 1569.495n 1.7v 1569.505n 1.7v 1579.495n 1.7v 1579.505n 0.0v 1589.495n 0.0v 1589.505n 0.0v 1599.495n 0.0v 1599.505n 0.0v 1609.495n 0.0v 1609.505n 0.0v 1619.495n 0.0v 1619.505n 0.0v 1629.495n 0.0v 1629.505n 0.0v 1639.495n 0.0v 1639.505n 0.0v 1649.495n 0.0v 1649.505n 0.0v 1659.495n 0.0v 1659.505n 0.0v 1669.495n 0.0v 1669.505n 0.0v 1679.495n 0.0v 1679.505n 0.0v 1689.495n 0.0v 1689.505n 0.0v 1699.495n 0.0v 1699.505n 0.0v 1709.495n 0.0v 1709.505n 0.0v 1719.495n 0.0v 1719.505n 0.0v 1729.495n 0.0v 1729.505n 0.0v 1739.495n 0.0v 1739.505n 0.0v 1749.495n 0.0v 1749.505n 0.0v 1759.495n 0.0v 1759.505n 0.0v 1769.495n 0.0v 1769.505n 0.0v 1779.495n 0.0v 1779.505n 0.0v 1789.495n 0.0v 1789.505n 0.0v 1799.495n 0.0v 1799.505n 0.0v 1809.495n 0.0v 1809.505n 0.0v 1819.495n 0.0v 1819.505n 0.0v 1829.495n 0.0v 1829.505n 1.7v 1839.495n 1.7v 1839.505n 1.7v 1849.495n 1.7v 1849.505n 1.7v 1859.495n 1.7v 1859.505n 0.0v 1869.495n 0.0v 1869.505n 0.0v 1879.495n 0.0v 1879.505n 0.0v 1889.495n 0.0v 1889.505n 0.0v 1899.495n 0.0v 1899.505n 0.0v 1909.495n 0.0v 1909.505n 0.0v 1919.495n 0.0v 1919.505n 0.0v 1929.495n 0.0v 1929.505n 0.0v 1939.495n 0.0v 1939.505n 0.0v 1949.495n 0.0v 1949.505n 0.0v 1959.495n 0.0v 1959.505n 0.0v 1969.495n 0.0v 1969.505n 0.0v 1979.495n 0.0v 1979.505n 0.0v 1989.495n 0.0v 1989.505n 0.0v 1999.495n 0.0v 1999.505n 0.0v 2009.495n 0.0v 2009.505n 0.0v 2019.495n 0.0v 2019.505n 0.0v 2029.495n 0.0v 2029.505n 0.0v 2039.495n 0.0v 2039.505n 0.0v 2049.495n 0.0v 2049.505n 0.0v )

 * Generation of control signals
* (time, data): [(0, 1), (10, 0), (20, 0), (30, 0), (40, 1), (50, 1), (60, 1), (70, 0), (80, 0), (90, 0), (100, 0), (110, 1), (120, 0), (130, 0), (140, 1), (150, 0), (160, 0), (170, 1), (180, 0), (190, 0), (200, 0), (210, 0), (220, 0), (230, 0), (240, 1), (250, 1), (260, 1), (270, 1), (280, 1), (290, 0), (300, 1), (310, 1), (320, 0), (330, 1), (340, 1), (350, 1), (360, 1), (370, 0), (380, 0), (390, 0), (400, 0), (410, 1), (420, 1), (430, 1), (440, 1), (450, 1), (460, 0), (470, 1), (480, 0), (490, 0), (500, 0), (510, 0), (520, 1), (530, 1), (540, 1), (550, 1), (560, 1), (570, 0), (580, 1), (590, 1), (600, 1), (610, 1), (620, 0), (630, 0), (640, 1), (650, 1), (660, 1), (670, 0), (680, 0), (690, 0), (700, 0), (710, 1), (720, 0), (730, 1), (740, 1), (750, 0), (760, 0), (770, 0), (780, 1), (790, 0), (800, 0), (810, 1), (820, 0), (830, 0), (840, 1), (850, 1), (860, 0), (870, 1), (880, 1), (890, 1), (900, 0), (910, 0), (920, 0), (930, 0), (940, 0), (950, 0), (960, 1), (970, 0), (980, 0), (990, 0), (1000, 0), (1010, 1), (1020, 1), (1030, 0), (1040, 0), (1050, 0), (1060, 0), (1070, 1), (1080, 0), (1090, 1), (1100, 0), (1110, 1), (1120, 1), (1130, 1), (1140, 1), (1150, 1), (1160, 0), (1170, 0), (1180, 0), (1190, 1), (1200, 1), (1210, 1), (1220, 1), (1230, 0), (1240, 0), (1250, 0), (1260, 0), (1270, 1), (1280, 0), (1290, 1), (1300, 0), (1310, 1), (1320, 1), (1330, 0), (1340, 0), (1350, 1), (1360, 1), (1370, 1), (1380, 1), (1390, 1), (1400, 0), (1410, 1), (1420, 1), (1430, 0), (1440, 0), (1450, 1), (1460, 1), (1470, 1), (1480, 0), (1490, 1), (1500, 1), (1510, 0), (1520, 0), (1530, 1), (1540, 0), (1550, 1), (1560, 1), (1570, 0), (1580, 0), (1590, 1), (1600, 1), (1610, 1), (1620, 1), (1630, 0), (1640, 1), (1650, 0), (1660, 0), (1670, 1), (1680, 1), (1690, 0), (1700, 0), (1710, 0), (1720, 1), (1730, 1), (1740, 0), (1750, 0), (1760, 0), (1770, 0), (1780, 0), (1790, 0), (1800, 0), (1810, 1), (1820, 0), (1830, 0), (1840, 1), (1850, 1), (1860, 1), (1870, 0), (1880, 1), (1890, 1), (1900, 0), (1910, 0), (1920, 0), (1930, 0), (1940, 1), (1950, 0), (1960, 0), (1970, 0), (1980, 1), (1990, 0), (2000, 1), (2010, 1), (2020, 0), (2030, 1), (2040, 0), (2050, 1)]
VCSB0 CSB0 0 PWL (0n 1.7v 9.495n 1.7v 9.505n 0.0v 19.495n 0.0v 19.505n 0.0v 29.495n 0.0v 29.505n 0.0v 39.495n 0.0v 39.505n 1.7v 49.495n 1.7v 49.505n 1.7v 59.495n 1.7v 59.505n 1.7v 69.495n 1.7v 69.505n 0.0v 79.495n 0.0v 79.505n 0.0v 89.495n 0.0v 89.505n 0.0v 99.495n 0.0v 99.505n 0.0v 109.495n 0.0v 109.505n 1.7v 119.495n 1.7v 119.505n 0.0v 129.495n 0.0v 129.505n 0.0v 139.495n 0.0v 139.505n 1.7v 149.495n 1.7v 149.505n 0.0v 159.495n 0.0v 159.505n 0.0v 169.495n 0.0v 169.505n 1.7v 179.495n 1.7v 179.505n 0.0v 189.495n 0.0v 189.505n 0.0v 199.495n 0.0v 199.505n 0.0v 209.495n 0.0v 209.505n 0.0v 219.495n 0.0v 219.505n 0.0v 229.495n 0.0v 229.505n 0.0v 239.495n 0.0v 239.505n 1.7v 249.495n 1.7v 249.505n 1.7v 259.495n 1.7v 259.505n 1.7v 269.495n 1.7v 269.505n 1.7v 279.495n 1.7v 279.505n 1.7v 289.495n 1.7v 289.505n 0.0v 299.495n 0.0v 299.505n 1.7v 309.495n 1.7v 309.505n 1.7v 319.495n 1.7v 319.505n 0.0v 329.495n 0.0v 329.505n 1.7v 339.495n 1.7v 339.505n 1.7v 349.495n 1.7v 349.505n 1.7v 359.495n 1.7v 359.505n 1.7v 369.495n 1.7v 369.505n 0.0v 379.495n 0.0v 379.505n 0.0v 389.495n 0.0v 389.505n 0.0v 399.495n 0.0v 399.505n 0.0v 409.495n 0.0v 409.505n 1.7v 419.495n 1.7v 419.505n 1.7v 429.495n 1.7v 429.505n 1.7v 439.495n 1.7v 439.505n 1.7v 449.495n 1.7v 449.505n 1.7v 459.495n 1.7v 459.505n 0.0v 469.495n 0.0v 469.505n 1.7v 479.495n 1.7v 479.505n 0.0v 489.495n 0.0v 489.505n 0.0v 499.495n 0.0v 499.505n 0.0v 509.495n 0.0v 509.505n 0.0v 519.495n 0.0v 519.505n 1.7v 529.495n 1.7v 529.505n 1.7v 539.495n 1.7v 539.505n 1.7v 549.495n 1.7v 549.505n 1.7v 559.495n 1.7v 559.505n 1.7v 569.495n 1.7v 569.505n 0.0v 579.495n 0.0v 579.505n 1.7v 589.495n 1.7v 589.505n 1.7v 599.495n 1.7v 599.505n 1.7v 609.495n 1.7v 609.505n 1.7v 619.495n 1.7v 619.505n 0.0v 629.495n 0.0v 629.505n 0.0v 639.495n 0.0v 639.505n 1.7v 649.495n 1.7v 649.505n 1.7v 659.495n 1.7v 659.505n 1.7v 669.495n 1.7v 669.505n 0.0v 679.495n 0.0v 679.505n 0.0v 689.495n 0.0v 689.505n 0.0v 699.495n 0.0v 699.505n 0.0v 709.495n 0.0v 709.505n 1.7v 719.495n 1.7v 719.505n 0.0v 729.495n 0.0v 729.505n 1.7v 739.495n 1.7v 739.505n 1.7v 749.495n 1.7v 749.505n 0.0v 759.495n 0.0v 759.505n 0.0v 769.495n 0.0v 769.505n 0.0v 779.495n 0.0v 779.505n 1.7v 789.495n 1.7v 789.505n 0.0v 799.495n 0.0v 799.505n 0.0v 809.495n 0.0v 809.505n 1.7v 819.495n 1.7v 819.505n 0.0v 829.495n 0.0v 829.505n 0.0v 839.495n 0.0v 839.505n 1.7v 849.495n 1.7v 849.505n 1.7v 859.495n 1.7v 859.505n 0.0v 869.495n 0.0v 869.505n 1.7v 879.495n 1.7v 879.505n 1.7v 889.495n 1.7v 889.505n 1.7v 899.495n 1.7v 899.505n 0.0v 909.495n 0.0v 909.505n 0.0v 919.495n 0.0v 919.505n 0.0v 929.495n 0.0v 929.505n 0.0v 939.495n 0.0v 939.505n 0.0v 949.495n 0.0v 949.505n 0.0v 959.495n 0.0v 959.505n 1.7v 969.495n 1.7v 969.505n 0.0v 979.495n 0.0v 979.505n 0.0v 989.495n 0.0v 989.505n 0.0v 999.495n 0.0v 999.505n 0.0v 1009.495n 0.0v 1009.505n 1.7v 1019.495n 1.7v 1019.505n 1.7v 1029.495n 1.7v 1029.505n 0.0v 1039.495n 0.0v 1039.505n 0.0v 1049.495n 0.0v 1049.505n 0.0v 1059.495n 0.0v 1059.505n 0.0v 1069.495n 0.0v 1069.505n 1.7v 1079.495n 1.7v 1079.505n 0.0v 1089.495n 0.0v 1089.505n 1.7v 1099.495n 1.7v 1099.505n 0.0v 1109.495n 0.0v 1109.505n 1.7v 1119.495n 1.7v 1119.505n 1.7v 1129.495n 1.7v 1129.505n 1.7v 1139.495n 1.7v 1139.505n 1.7v 1149.495n 1.7v 1149.505n 1.7v 1159.495n 1.7v 1159.505n 0.0v 1169.495n 0.0v 1169.505n 0.0v 1179.495n 0.0v 1179.505n 0.0v 1189.495n 0.0v 1189.505n 1.7v 1199.495n 1.7v 1199.505n 1.7v 1209.495n 1.7v 1209.505n 1.7v 1219.495n 1.7v 1219.505n 1.7v 1229.495n 1.7v 1229.505n 0.0v 1239.495n 0.0v 1239.505n 0.0v 1249.495n 0.0v 1249.505n 0.0v 1259.495n 0.0v 1259.505n 0.0v 1269.495n 0.0v 1269.505n 1.7v 1279.495n 1.7v 1279.505n 0.0v 1289.495n 0.0v 1289.505n 1.7v 1299.495n 1.7v 1299.505n 0.0v 1309.495n 0.0v 1309.505n 1.7v 1319.495n 1.7v 1319.505n 1.7v 1329.495n 1.7v 1329.505n 0.0v 1339.495n 0.0v 1339.505n 0.0v 1349.495n 0.0v 1349.505n 1.7v 1359.495n 1.7v 1359.505n 1.7v 1369.495n 1.7v 1369.505n 1.7v 1379.495n 1.7v 1379.505n 1.7v 1389.495n 1.7v 1389.505n 1.7v 1399.495n 1.7v 1399.505n 0.0v 1409.495n 0.0v 1409.505n 1.7v 1419.495n 1.7v 1419.505n 1.7v 1429.495n 1.7v 1429.505n 0.0v 1439.495n 0.0v 1439.505n 0.0v 1449.495n 0.0v 1449.505n 1.7v 1459.495n 1.7v 1459.505n 1.7v 1469.495n 1.7v 1469.505n 1.7v 1479.495n 1.7v 1479.505n 0.0v 1489.495n 0.0v 1489.505n 1.7v 1499.495n 1.7v 1499.505n 1.7v 1509.495n 1.7v 1509.505n 0.0v 1519.495n 0.0v 1519.505n 0.0v 1529.495n 0.0v 1529.505n 1.7v 1539.495n 1.7v 1539.505n 0.0v 1549.495n 0.0v 1549.505n 1.7v 1559.495n 1.7v 1559.505n 1.7v 1569.495n 1.7v 1569.505n 0.0v 1579.495n 0.0v 1579.505n 0.0v 1589.495n 0.0v 1589.505n 1.7v 1599.495n 1.7v 1599.505n 1.7v 1609.495n 1.7v 1609.505n 1.7v 1619.495n 1.7v 1619.505n 1.7v 1629.495n 1.7v 1629.505n 0.0v 1639.495n 0.0v 1639.505n 1.7v 1649.495n 1.7v 1649.505n 0.0v 1659.495n 0.0v 1659.505n 0.0v 1669.495n 0.0v 1669.505n 1.7v 1679.495n 1.7v 1679.505n 1.7v 1689.495n 1.7v 1689.505n 0.0v 1699.495n 0.0v 1699.505n 0.0v 1709.495n 0.0v 1709.505n 0.0v 1719.495n 0.0v 1719.505n 1.7v 1729.495n 1.7v 1729.505n 1.7v 1739.495n 1.7v 1739.505n 0.0v 1749.495n 0.0v 1749.505n 0.0v 1759.495n 0.0v 1759.505n 0.0v 1769.495n 0.0v 1769.505n 0.0v 1779.495n 0.0v 1779.505n 0.0v 1789.495n 0.0v 1789.505n 0.0v 1799.495n 0.0v 1799.505n 0.0v 1809.495n 0.0v 1809.505n 1.7v 1819.495n 1.7v 1819.505n 0.0v 1829.495n 0.0v 1829.505n 0.0v 1839.495n 0.0v 1839.505n 1.7v 1849.495n 1.7v 1849.505n 1.7v 1859.495n 1.7v 1859.505n 1.7v 1869.495n 1.7v 1869.505n 0.0v 1879.495n 0.0v 1879.505n 1.7v 1889.495n 1.7v 1889.505n 1.7v 1899.495n 1.7v 1899.505n 0.0v 1909.495n 0.0v 1909.505n 0.0v 1919.495n 0.0v 1919.505n 0.0v 1929.495n 0.0v 1929.505n 0.0v 1939.495n 0.0v 1939.505n 1.7v 1949.495n 1.7v 1949.505n 0.0v 1959.495n 0.0v 1959.505n 0.0v 1969.495n 0.0v 1969.505n 0.0v 1979.495n 0.0v 1979.505n 1.7v 1989.495n 1.7v 1989.505n 0.0v 1999.495n 0.0v 1999.505n 1.7v 2009.495n 1.7v 2009.505n 1.7v 2019.495n 1.7v 2019.505n 0.0v 2029.495n 0.0v 2029.505n 1.7v 2039.495n 1.7v 2039.505n 0.0v 2049.495n 0.0v 2049.505n 1.7v )
* (time, data): [(0, 1), (10, 1), (20, 1), (30, 1), (40, 0), (50, 1), (60, 0), (70, 1), (80, 1), (90, 1), (100, 1), (110, 0), (120, 1), (130, 0), (140, 1), (150, 1), (160, 0), (170, 1), (180, 0), (190, 0), (200, 1), (210, 1), (220, 0), (230, 1), (240, 0), (250, 1), (260, 1), (270, 0), (280, 0), (290, 0), (300, 1), (310, 0), (320, 0), (330, 1), (340, 0), (350, 0), (360, 0), (370, 0), (380, 1), (390, 1), (400, 1), (410, 1), (420, 0), (430, 1), (440, 1), (450, 0), (460, 1), (470, 0), (480, 1), (490, 1), (500, 0), (510, 1), (520, 0), (530, 1), (540, 1), (550, 0), (560, 0), (570, 0), (580, 0), (590, 0), (600, 0), (610, 1), (620, 1), (630, 1), (640, 1), (650, 0), (660, 0), (670, 1), (680, 0), (690, 1), (700, 0), (710, 0), (720, 1), (730, 1), (740, 1), (750, 1), (760, 0), (770, 0), (780, 0), (790, 0), (800, 1), (810, 0), (820, 1), (830, 1), (840, 1), (850, 0), (860, 1), (870, 0), (880, 1), (890, 0), (900, 1), (910, 1), (920, 1), (930, 0), (940, 1), (950, 1), (960, 1), (970, 0), (980, 1), (990, 1), (1000, 1), (1010, 1), (1020, 1), (1030, 1), (1040, 1), (1050, 0), (1060, 0), (1070, 1), (1080, 0), (1090, 0), (1100, 0), (1110, 0), (1120, 1), (1130, 0), (1140, 0), (1150, 1), (1160, 1), (1170, 1), (1180, 0), (1190, 0), (1200, 0), (1210, 1), (1220, 0), (1230, 0), (1240, 1), (1250, 1), (1260, 0), (1270, 1), (1280, 1), (1290, 1), (1300, 1), (1310, 1), (1320, 1), (1330, 0), (1340, 1), (1350, 1), (1360, 1), (1370, 1), (1380, 1), (1390, 0), (1400, 1), (1410, 1), (1420, 0), (1430, 1), (1440, 0), (1450, 0), (1460, 1), (1470, 1), (1480, 0), (1490, 1), (1500, 0), (1510, 0), (1520, 1), (1530, 1), (1540, 0), (1550, 1), (1560, 0), (1570, 1), (1580, 0), (1590, 1), (1600, 1), (1610, 1), (1620, 0), (1630, 1), (1640, 1), (1650, 1), (1660, 0), (1670, 1), (1680, 0), (1690, 1), (1700, 1), (1710, 1), (1720, 1), (1730, 0), (1740, 0), (1750, 1), (1760, 1), (1770, 1), (1780, 1), (1790, 0), (1800, 1), (1810, 1), (1820, 1), (1830, 0), (1840, 1), (1850, 1), (1860, 0), (1870, 1), (1880, 1), (1890, 1), (1900, 1), (1910, 1), (1920, 1), (1930, 1), (1940, 1), (1950, 0), (1960, 1), (1970, 0), (1980, 1), (1990, 1), (2000, 1), (2010, 0), (2020, 1), (2030, 1), (2040, 0), (2050, 1)]
VCSB1 CSB1 0 PWL (0n 1.7v 9.495n 1.7v 9.505n 1.7v 19.495n 1.7v 19.505n 1.7v 29.495n 1.7v 29.505n 1.7v 39.495n 1.7v 39.505n 0.0v 49.495n 0.0v 49.505n 1.7v 59.495n 1.7v 59.505n 0.0v 69.495n 0.0v 69.505n 1.7v 79.495n 1.7v 79.505n 1.7v 89.495n 1.7v 89.505n 1.7v 99.495n 1.7v 99.505n 1.7v 109.495n 1.7v 109.505n 0.0v 119.495n 0.0v 119.505n 1.7v 129.495n 1.7v 129.505n 0.0v 139.495n 0.0v 139.505n 1.7v 149.495n 1.7v 149.505n 1.7v 159.495n 1.7v 159.505n 0.0v 169.495n 0.0v 169.505n 1.7v 179.495n 1.7v 179.505n 0.0v 189.495n 0.0v 189.505n 0.0v 199.495n 0.0v 199.505n 1.7v 209.495n 1.7v 209.505n 1.7v 219.495n 1.7v 219.505n 0.0v 229.495n 0.0v 229.505n 1.7v 239.495n 1.7v 239.505n 0.0v 249.495n 0.0v 249.505n 1.7v 259.495n 1.7v 259.505n 1.7v 269.495n 1.7v 269.505n 0.0v 279.495n 0.0v 279.505n 0.0v 289.495n 0.0v 289.505n 0.0v 299.495n 0.0v 299.505n 1.7v 309.495n 1.7v 309.505n 0.0v 319.495n 0.0v 319.505n 0.0v 329.495n 0.0v 329.505n 1.7v 339.495n 1.7v 339.505n 0.0v 349.495n 0.0v 349.505n 0.0v 359.495n 0.0v 359.505n 0.0v 369.495n 0.0v 369.505n 0.0v 379.495n 0.0v 379.505n 1.7v 389.495n 1.7v 389.505n 1.7v 399.495n 1.7v 399.505n 1.7v 409.495n 1.7v 409.505n 1.7v 419.495n 1.7v 419.505n 0.0v 429.495n 0.0v 429.505n 1.7v 439.495n 1.7v 439.505n 1.7v 449.495n 1.7v 449.505n 0.0v 459.495n 0.0v 459.505n 1.7v 469.495n 1.7v 469.505n 0.0v 479.495n 0.0v 479.505n 1.7v 489.495n 1.7v 489.505n 1.7v 499.495n 1.7v 499.505n 0.0v 509.495n 0.0v 509.505n 1.7v 519.495n 1.7v 519.505n 0.0v 529.495n 0.0v 529.505n 1.7v 539.495n 1.7v 539.505n 1.7v 549.495n 1.7v 549.505n 0.0v 559.495n 0.0v 559.505n 0.0v 569.495n 0.0v 569.505n 0.0v 579.495n 0.0v 579.505n 0.0v 589.495n 0.0v 589.505n 0.0v 599.495n 0.0v 599.505n 0.0v 609.495n 0.0v 609.505n 1.7v 619.495n 1.7v 619.505n 1.7v 629.495n 1.7v 629.505n 1.7v 639.495n 1.7v 639.505n 1.7v 649.495n 1.7v 649.505n 0.0v 659.495n 0.0v 659.505n 0.0v 669.495n 0.0v 669.505n 1.7v 679.495n 1.7v 679.505n 0.0v 689.495n 0.0v 689.505n 1.7v 699.495n 1.7v 699.505n 0.0v 709.495n 0.0v 709.505n 0.0v 719.495n 0.0v 719.505n 1.7v 729.495n 1.7v 729.505n 1.7v 739.495n 1.7v 739.505n 1.7v 749.495n 1.7v 749.505n 1.7v 759.495n 1.7v 759.505n 0.0v 769.495n 0.0v 769.505n 0.0v 779.495n 0.0v 779.505n 0.0v 789.495n 0.0v 789.505n 0.0v 799.495n 0.0v 799.505n 1.7v 809.495n 1.7v 809.505n 0.0v 819.495n 0.0v 819.505n 1.7v 829.495n 1.7v 829.505n 1.7v 839.495n 1.7v 839.505n 1.7v 849.495n 1.7v 849.505n 0.0v 859.495n 0.0v 859.505n 1.7v 869.495n 1.7v 869.505n 0.0v 879.495n 0.0v 879.505n 1.7v 889.495n 1.7v 889.505n 0.0v 899.495n 0.0v 899.505n 1.7v 909.495n 1.7v 909.505n 1.7v 919.495n 1.7v 919.505n 1.7v 929.495n 1.7v 929.505n 0.0v 939.495n 0.0v 939.505n 1.7v 949.495n 1.7v 949.505n 1.7v 959.495n 1.7v 959.505n 1.7v 969.495n 1.7v 969.505n 0.0v 979.495n 0.0v 979.505n 1.7v 989.495n 1.7v 989.505n 1.7v 999.495n 1.7v 999.505n 1.7v 1009.495n 1.7v 1009.505n 1.7v 1019.495n 1.7v 1019.505n 1.7v 1029.495n 1.7v 1029.505n 1.7v 1039.495n 1.7v 1039.505n 1.7v 1049.495n 1.7v 1049.505n 0.0v 1059.495n 0.0v 1059.505n 0.0v 1069.495n 0.0v 1069.505n 1.7v 1079.495n 1.7v 1079.505n 0.0v 1089.495n 0.0v 1089.505n 0.0v 1099.495n 0.0v 1099.505n 0.0v 1109.495n 0.0v 1109.505n 0.0v 1119.495n 0.0v 1119.505n 1.7v 1129.495n 1.7v 1129.505n 0.0v 1139.495n 0.0v 1139.505n 0.0v 1149.495n 0.0v 1149.505n 1.7v 1159.495n 1.7v 1159.505n 1.7v 1169.495n 1.7v 1169.505n 1.7v 1179.495n 1.7v 1179.505n 0.0v 1189.495n 0.0v 1189.505n 0.0v 1199.495n 0.0v 1199.505n 0.0v 1209.495n 0.0v 1209.505n 1.7v 1219.495n 1.7v 1219.505n 0.0v 1229.495n 0.0v 1229.505n 0.0v 1239.495n 0.0v 1239.505n 1.7v 1249.495n 1.7v 1249.505n 1.7v 1259.495n 1.7v 1259.505n 0.0v 1269.495n 0.0v 1269.505n 1.7v 1279.495n 1.7v 1279.505n 1.7v 1289.495n 1.7v 1289.505n 1.7v 1299.495n 1.7v 1299.505n 1.7v 1309.495n 1.7v 1309.505n 1.7v 1319.495n 1.7v 1319.505n 1.7v 1329.495n 1.7v 1329.505n 0.0v 1339.495n 0.0v 1339.505n 1.7v 1349.495n 1.7v 1349.505n 1.7v 1359.495n 1.7v 1359.505n 1.7v 1369.495n 1.7v 1369.505n 1.7v 1379.495n 1.7v 1379.505n 1.7v 1389.495n 1.7v 1389.505n 0.0v 1399.495n 0.0v 1399.505n 1.7v 1409.495n 1.7v 1409.505n 1.7v 1419.495n 1.7v 1419.505n 0.0v 1429.495n 0.0v 1429.505n 1.7v 1439.495n 1.7v 1439.505n 0.0v 1449.495n 0.0v 1449.505n 0.0v 1459.495n 0.0v 1459.505n 1.7v 1469.495n 1.7v 1469.505n 1.7v 1479.495n 1.7v 1479.505n 0.0v 1489.495n 0.0v 1489.505n 1.7v 1499.495n 1.7v 1499.505n 0.0v 1509.495n 0.0v 1509.505n 0.0v 1519.495n 0.0v 1519.505n 1.7v 1529.495n 1.7v 1529.505n 1.7v 1539.495n 1.7v 1539.505n 0.0v 1549.495n 0.0v 1549.505n 1.7v 1559.495n 1.7v 1559.505n 0.0v 1569.495n 0.0v 1569.505n 1.7v 1579.495n 1.7v 1579.505n 0.0v 1589.495n 0.0v 1589.505n 1.7v 1599.495n 1.7v 1599.505n 1.7v 1609.495n 1.7v 1609.505n 1.7v 1619.495n 1.7v 1619.505n 0.0v 1629.495n 0.0v 1629.505n 1.7v 1639.495n 1.7v 1639.505n 1.7v 1649.495n 1.7v 1649.505n 1.7v 1659.495n 1.7v 1659.505n 0.0v 1669.495n 0.0v 1669.505n 1.7v 1679.495n 1.7v 1679.505n 0.0v 1689.495n 0.0v 1689.505n 1.7v 1699.495n 1.7v 1699.505n 1.7v 1709.495n 1.7v 1709.505n 1.7v 1719.495n 1.7v 1719.505n 1.7v 1729.495n 1.7v 1729.505n 0.0v 1739.495n 0.0v 1739.505n 0.0v 1749.495n 0.0v 1749.505n 1.7v 1759.495n 1.7v 1759.505n 1.7v 1769.495n 1.7v 1769.505n 1.7v 1779.495n 1.7v 1779.505n 1.7v 1789.495n 1.7v 1789.505n 0.0v 1799.495n 0.0v 1799.505n 1.7v 1809.495n 1.7v 1809.505n 1.7v 1819.495n 1.7v 1819.505n 1.7v 1829.495n 1.7v 1829.505n 0.0v 1839.495n 0.0v 1839.505n 1.7v 1849.495n 1.7v 1849.505n 1.7v 1859.495n 1.7v 1859.505n 0.0v 1869.495n 0.0v 1869.505n 1.7v 1879.495n 1.7v 1879.505n 1.7v 1889.495n 1.7v 1889.505n 1.7v 1899.495n 1.7v 1899.505n 1.7v 1909.495n 1.7v 1909.505n 1.7v 1919.495n 1.7v 1919.505n 1.7v 1929.495n 1.7v 1929.505n 1.7v 1939.495n 1.7v 1939.505n 1.7v 1949.495n 1.7v 1949.505n 0.0v 1959.495n 0.0v 1959.505n 1.7v 1969.495n 1.7v 1969.505n 0.0v 1979.495n 0.0v 1979.505n 1.7v 1989.495n 1.7v 1989.505n 1.7v 1999.495n 1.7v 1999.505n 1.7v 2009.495n 1.7v 2009.505n 0.0v 2019.495n 0.0v 2019.505n 1.7v 2029.495n 1.7v 2029.505n 1.7v 2039.495n 1.7v 2039.505n 0.0v 2049.495n 0.0v 2049.505n 1.7v )

* Generation of spare enable signals
* (time, data): [(0, 0), (10, 0), (20, 0), (30, 0), (40, 0), (50, 0), (60, 0), (70, 0), (80, 0), (90, 0), (100, 0), (110, 0), (120, 0), (130, 0), (140, 0), (150, 0), (160, 0), (170, 0), (180, 0), (190, 0), (200, 0), (210, 0), (220, 0), (230, 0), (240, 0), (250, 0), (260, 0), (270, 0), (280, 0), (290, 0), (300, 0), (310, 0), (320, 0), (330, 0), (340, 0), (350, 0), (360, 0), (370, 0), (380, 0), (390, 0), (400, 0), (410, 0), (420, 0), (430, 0), (440, 0), (450, 0), (460, 0), (470, 0), (480, 0), (490, 0), (500, 0), (510, 0), (520, 0), (530, 0), (540, 0), (550, 0), (560, 0), (570, 0), (580, 0), (590, 0), (600, 0), (610, 0), (620, 0), (630, 0), (640, 0), (650, 0), (660, 0), (670, 0), (680, 0), (690, 0), (700, 0), (710, 0), (720, 0), (730, 0), (740, 0), (750, 0), (760, 0), (770, 0), (780, 0), (790, 0), (800, 0), (810, 0), (820, 0), (830, 0), (840, 0), (850, 0), (860, 0), (870, 0), (880, 0), (890, 0), (900, 0), (910, 0), (920, 0), (930, 0), (940, 0), (950, 0), (960, 0), (970, 0), (980, 0), (990, 0), (1000, 0), (1010, 0), (1020, 0), (1030, 0), (1040, 0), (1050, 0), (1060, 0), (1070, 0), (1080, 0), (1090, 0), (1100, 0), (1110, 0), (1120, 0), (1130, 0), (1140, 0), (1150, 0), (1160, 0), (1170, 0), (1180, 0), (1190, 0), (1200, 0), (1210, 0), (1220, 0), (1230, 0), (1240, 0), (1250, 0), (1260, 0), (1270, 0), (1280, 0), (1290, 0), (1300, 0), (1310, 0), (1320, 0), (1330, 0), (1340, 0), (1350, 0), (1360, 0), (1370, 0), (1380, 0), (1390, 0), (1400, 0), (1410, 0), (1420, 0), (1430, 0), (1440, 0), (1450, 0), (1460, 0), (1470, 0), (1480, 0), (1490, 0), (1500, 0), (1510, 0), (1520, 0), (1530, 0), (1540, 0), (1550, 0), (1560, 0), (1570, 0), (1580, 0), (1590, 0), (1600, 0), (1610, 0), (1620, 0), (1630, 0), (1640, 0), (1650, 0), (1660, 0), (1670, 0), (1680, 0), (1690, 0), (1700, 0), (1710, 0), (1720, 0), (1730, 0), (1740, 0), (1750, 0), (1760, 0), (1770, 0), (1780, 0), (1790, 0), (1800, 0), (1810, 0), (1820, 0), (1830, 0), (1840, 0), (1850, 0), (1860, 0), (1870, 0), (1880, 0), (1890, 0), (1900, 0), (1910, 0), (1920, 0), (1930, 0), (1940, 0), (1950, 0), (1960, 0), (1970, 0), (1980, 0), (1990, 0), (2000, 0), (2010, 0), (2020, 0), (2030, 0), (2040, 0), (2050, 0)]
VSPARE_WEN0_0  SPARE_WEN0_0  0 PWL (0n 0.0v 9.495n 0.0v 9.505n 0.0v 19.495n 0.0v 19.505n 0.0v 29.495n 0.0v 29.505n 0.0v 39.495n 0.0v 39.505n 0.0v 49.495n 0.0v 49.505n 0.0v 59.495n 0.0v 59.505n 0.0v 69.495n 0.0v 69.505n 0.0v 79.495n 0.0v 79.505n 0.0v 89.495n 0.0v 89.505n 0.0v 99.495n 0.0v 99.505n 0.0v 109.495n 0.0v 109.505n 0.0v 119.495n 0.0v 119.505n 0.0v 129.495n 0.0v 129.505n 0.0v 139.495n 0.0v 139.505n 0.0v 149.495n 0.0v 149.505n 0.0v 159.495n 0.0v 159.505n 0.0v 169.495n 0.0v 169.505n 0.0v 179.495n 0.0v 179.505n 0.0v 189.495n 0.0v 189.505n 0.0v 199.495n 0.0v 199.505n 0.0v 209.495n 0.0v 209.505n 0.0v 219.495n 0.0v 219.505n 0.0v 229.495n 0.0v 229.505n 0.0v 239.495n 0.0v 239.505n 0.0v 249.495n 0.0v 249.505n 0.0v 259.495n 0.0v 259.505n 0.0v 269.495n 0.0v 269.505n 0.0v 279.495n 0.0v 279.505n 0.0v 289.495n 0.0v 289.505n 0.0v 299.495n 0.0v 299.505n 0.0v 309.495n 0.0v 309.505n 0.0v 319.495n 0.0v 319.505n 0.0v 329.495n 0.0v 329.505n 0.0v 339.495n 0.0v 339.505n 0.0v 349.495n 0.0v 349.505n 0.0v 359.495n 0.0v 359.505n 0.0v 369.495n 0.0v 369.505n 0.0v 379.495n 0.0v 379.505n 0.0v 389.495n 0.0v 389.505n 0.0v 399.495n 0.0v 399.505n 0.0v 409.495n 0.0v 409.505n 0.0v 419.495n 0.0v 419.505n 0.0v 429.495n 0.0v 429.505n 0.0v 439.495n 0.0v 439.505n 0.0v 449.495n 0.0v 449.505n 0.0v 459.495n 0.0v 459.505n 0.0v 469.495n 0.0v 469.505n 0.0v 479.495n 0.0v 479.505n 0.0v 489.495n 0.0v 489.505n 0.0v 499.495n 0.0v 499.505n 0.0v 509.495n 0.0v 509.505n 0.0v 519.495n 0.0v 519.505n 0.0v 529.495n 0.0v 529.505n 0.0v 539.495n 0.0v 539.505n 0.0v 549.495n 0.0v 549.505n 0.0v 559.495n 0.0v 559.505n 0.0v 569.495n 0.0v 569.505n 0.0v 579.495n 0.0v 579.505n 0.0v 589.495n 0.0v 589.505n 0.0v 599.495n 0.0v 599.505n 0.0v 609.495n 0.0v 609.505n 0.0v 619.495n 0.0v 619.505n 0.0v 629.495n 0.0v 629.505n 0.0v 639.495n 0.0v 639.505n 0.0v 649.495n 0.0v 649.505n 0.0v 659.495n 0.0v 659.505n 0.0v 669.495n 0.0v 669.505n 0.0v 679.495n 0.0v 679.505n 0.0v 689.495n 0.0v 689.505n 0.0v 699.495n 0.0v 699.505n 0.0v 709.495n 0.0v 709.505n 0.0v 719.495n 0.0v 719.505n 0.0v 729.495n 0.0v 729.505n 0.0v 739.495n 0.0v 739.505n 0.0v 749.495n 0.0v 749.505n 0.0v 759.495n 0.0v 759.505n 0.0v 769.495n 0.0v 769.505n 0.0v 779.495n 0.0v 779.505n 0.0v 789.495n 0.0v 789.505n 0.0v 799.495n 0.0v 799.505n 0.0v 809.495n 0.0v 809.505n 0.0v 819.495n 0.0v 819.505n 0.0v 829.495n 0.0v 829.505n 0.0v 839.495n 0.0v 839.505n 0.0v 849.495n 0.0v 849.505n 0.0v 859.495n 0.0v 859.505n 0.0v 869.495n 0.0v 869.505n 0.0v 879.495n 0.0v 879.505n 0.0v 889.495n 0.0v 889.505n 0.0v 899.495n 0.0v 899.505n 0.0v 909.495n 0.0v 909.505n 0.0v 919.495n 0.0v 919.505n 0.0v 929.495n 0.0v 929.505n 0.0v 939.495n 0.0v 939.505n 0.0v 949.495n 0.0v 949.505n 0.0v 959.495n 0.0v 959.505n 0.0v 969.495n 0.0v 969.505n 0.0v 979.495n 0.0v 979.505n 0.0v 989.495n 0.0v 989.505n 0.0v 999.495n 0.0v 999.505n 0.0v 1009.495n 0.0v 1009.505n 0.0v 1019.495n 0.0v 1019.505n 0.0v 1029.495n 0.0v 1029.505n 0.0v 1039.495n 0.0v 1039.505n 0.0v 1049.495n 0.0v 1049.505n 0.0v 1059.495n 0.0v 1059.505n 0.0v 1069.495n 0.0v 1069.505n 0.0v 1079.495n 0.0v 1079.505n 0.0v 1089.495n 0.0v 1089.505n 0.0v 1099.495n 0.0v 1099.505n 0.0v 1109.495n 0.0v 1109.505n 0.0v 1119.495n 0.0v 1119.505n 0.0v 1129.495n 0.0v 1129.505n 0.0v 1139.495n 0.0v 1139.505n 0.0v 1149.495n 0.0v 1149.505n 0.0v 1159.495n 0.0v 1159.505n 0.0v 1169.495n 0.0v 1169.505n 0.0v 1179.495n 0.0v 1179.505n 0.0v 1189.495n 0.0v 1189.505n 0.0v 1199.495n 0.0v 1199.505n 0.0v 1209.495n 0.0v 1209.505n 0.0v 1219.495n 0.0v 1219.505n 0.0v 1229.495n 0.0v 1229.505n 0.0v 1239.495n 0.0v 1239.505n 0.0v 1249.495n 0.0v 1249.505n 0.0v 1259.495n 0.0v 1259.505n 0.0v 1269.495n 0.0v 1269.505n 0.0v 1279.495n 0.0v 1279.505n 0.0v 1289.495n 0.0v 1289.505n 0.0v 1299.495n 0.0v 1299.505n 0.0v 1309.495n 0.0v 1309.505n 0.0v 1319.495n 0.0v 1319.505n 0.0v 1329.495n 0.0v 1329.505n 0.0v 1339.495n 0.0v 1339.505n 0.0v 1349.495n 0.0v 1349.505n 0.0v 1359.495n 0.0v 1359.505n 0.0v 1369.495n 0.0v 1369.505n 0.0v 1379.495n 0.0v 1379.505n 0.0v 1389.495n 0.0v 1389.505n 0.0v 1399.495n 0.0v 1399.505n 0.0v 1409.495n 0.0v 1409.505n 0.0v 1419.495n 0.0v 1419.505n 0.0v 1429.495n 0.0v 1429.505n 0.0v 1439.495n 0.0v 1439.505n 0.0v 1449.495n 0.0v 1449.505n 0.0v 1459.495n 0.0v 1459.505n 0.0v 1469.495n 0.0v 1469.505n 0.0v 1479.495n 0.0v 1479.505n 0.0v 1489.495n 0.0v 1489.505n 0.0v 1499.495n 0.0v 1499.505n 0.0v 1509.495n 0.0v 1509.505n 0.0v 1519.495n 0.0v 1519.505n 0.0v 1529.495n 0.0v 1529.505n 0.0v 1539.495n 0.0v 1539.505n 0.0v 1549.495n 0.0v 1549.505n 0.0v 1559.495n 0.0v 1559.505n 0.0v 1569.495n 0.0v 1569.505n 0.0v 1579.495n 0.0v 1579.505n 0.0v 1589.495n 0.0v 1589.505n 0.0v 1599.495n 0.0v 1599.505n 0.0v 1609.495n 0.0v 1609.505n 0.0v 1619.495n 0.0v 1619.505n 0.0v 1629.495n 0.0v 1629.505n 0.0v 1639.495n 0.0v 1639.505n 0.0v 1649.495n 0.0v 1649.505n 0.0v 1659.495n 0.0v 1659.505n 0.0v 1669.495n 0.0v 1669.505n 0.0v 1679.495n 0.0v 1679.505n 0.0v 1689.495n 0.0v 1689.505n 0.0v 1699.495n 0.0v 1699.505n 0.0v 1709.495n 0.0v 1709.505n 0.0v 1719.495n 0.0v 1719.505n 0.0v 1729.495n 0.0v 1729.505n 0.0v 1739.495n 0.0v 1739.505n 0.0v 1749.495n 0.0v 1749.505n 0.0v 1759.495n 0.0v 1759.505n 0.0v 1769.495n 0.0v 1769.505n 0.0v 1779.495n 0.0v 1779.505n 0.0v 1789.495n 0.0v 1789.505n 0.0v 1799.495n 0.0v 1799.505n 0.0v 1809.495n 0.0v 1809.505n 0.0v 1819.495n 0.0v 1819.505n 0.0v 1829.495n 0.0v 1829.505n 0.0v 1839.495n 0.0v 1839.505n 0.0v 1849.495n 0.0v 1849.505n 0.0v 1859.495n 0.0v 1859.505n 0.0v 1869.495n 0.0v 1869.505n 0.0v 1879.495n 0.0v 1879.505n 0.0v 1889.495n 0.0v 1889.505n 0.0v 1899.495n 0.0v 1899.505n 0.0v 1909.495n 0.0v 1909.505n 0.0v 1919.495n 0.0v 1919.505n 0.0v 1929.495n 0.0v 1929.505n 0.0v 1939.495n 0.0v 1939.505n 0.0v 1949.495n 0.0v 1949.505n 0.0v 1959.495n 0.0v 1959.505n 0.0v 1969.495n 0.0v 1969.505n 0.0v 1979.495n 0.0v 1979.505n 0.0v 1989.495n 0.0v 1989.505n 0.0v 1999.495n 0.0v 1999.505n 0.0v 2009.495n 0.0v 2009.505n 0.0v 2019.495n 0.0v 2019.505n 0.0v 2029.495n 0.0v 2029.505n 0.0v 2039.495n 0.0v 2039.505n 0.0v 2049.495n 0.0v 2049.505n 0.0v )
* PULSE: period=10
Vclk0 clk0 0 PULSE (0 1.7 9.995n 0.01n 0.01n 4.99n 10n)
* PULSE: period=10
Vclk1 clk1 0 PULSE (0 1.7 9.995n 0.01n 0.01n 4.99n 10n)

 * Generation of dout measurements
* CHECK dout1_0 vdout1_0ck4 = 0 time = 50
* CHECK dout1_1 vdout1_1ck4 = 0 time = 50
* CHECK dout1_2 vdout1_2ck4 = 1.7 time = 50
* CHECK dout1_3 vdout1_3ck4 = 0 time = 50
* CHECK dout1_4 vdout1_4ck4 = 0 time = 50
* CHECK dout1_5 vdout1_5ck4 = 0 time = 50
* CHECK dout1_6 vdout1_6ck4 = 1.7 time = 50
* CHECK dout1_7 vdout1_7ck4 = 1.7 time = 50
* CHECK dout1_8 vdout1_8ck4 = 1.7 time = 50
* CHECK dout1_9 vdout1_9ck4 = 1.7 time = 50
* CHECK dout1_10 vdout1_10ck4 = 1.7 time = 50
* CHECK dout1_11 vdout1_11ck4 = 0 time = 50
* CHECK dout1_12 vdout1_12ck4 = 0 time = 50
* CHECK dout1_13 vdout1_13ck4 = 1.7 time = 50
* CHECK dout1_14 vdout1_14ck4 = 0 time = 50
* CHECK dout1_15 vdout1_15ck4 = 1.7 time = 50
* CHECK dout1_16 vdout1_16ck4 = 0 time = 50
* CHECK dout1_0 vdout1_0ck6 = 0 time = 70
* CHECK dout1_1 vdout1_1ck6 = 0 time = 70
* CHECK dout1_2 vdout1_2ck6 = 1.7 time = 70
* CHECK dout1_3 vdout1_3ck6 = 0 time = 70
* CHECK dout1_4 vdout1_4ck6 = 0 time = 70
* CHECK dout1_5 vdout1_5ck6 = 0 time = 70
* CHECK dout1_6 vdout1_6ck6 = 1.7 time = 70
* CHECK dout1_7 vdout1_7ck6 = 1.7 time = 70
* CHECK dout1_8 vdout1_8ck6 = 1.7 time = 70
* CHECK dout1_9 vdout1_9ck6 = 1.7 time = 70
* CHECK dout1_10 vdout1_10ck6 = 1.7 time = 70
* CHECK dout1_11 vdout1_11ck6 = 0 time = 70
* CHECK dout1_12 vdout1_12ck6 = 0 time = 70
* CHECK dout1_13 vdout1_13ck6 = 1.7 time = 70
* CHECK dout1_14 vdout1_14ck6 = 0 time = 70
* CHECK dout1_15 vdout1_15ck6 = 1.7 time = 70
* CHECK dout1_16 vdout1_16ck6 = 0 time = 70
* CHECK dout1_0 vdout1_0ck11 = 0 time = 120
* CHECK dout1_1 vdout1_1ck11 = 1.7 time = 120
* CHECK dout1_2 vdout1_2ck11 = 1.7 time = 120
* CHECK dout1_3 vdout1_3ck11 = 1.7 time = 120
* CHECK dout1_4 vdout1_4ck11 = 1.7 time = 120
* CHECK dout1_5 vdout1_5ck11 = 1.7 time = 120
* CHECK dout1_6 vdout1_6ck11 = 0 time = 120
* CHECK dout1_7 vdout1_7ck11 = 1.7 time = 120
* CHECK dout1_8 vdout1_8ck11 = 1.7 time = 120
* CHECK dout1_9 vdout1_9ck11 = 1.7 time = 120
* CHECK dout1_10 vdout1_10ck11 = 1.7 time = 120
* CHECK dout1_11 vdout1_11ck11 = 1.7 time = 120
* CHECK dout1_12 vdout1_12ck11 = 0 time = 120
* CHECK dout1_13 vdout1_13ck11 = 1.7 time = 120
* CHECK dout1_14 vdout1_14ck11 = 1.7 time = 120
* CHECK dout1_15 vdout1_15ck11 = 0 time = 120
* CHECK dout1_16 vdout1_16ck11 = 0 time = 120
* CHECK dout1_0 vdout1_0ck13 = 0 time = 140
* CHECK dout1_1 vdout1_1ck13 = 1.7 time = 140
* CHECK dout1_2 vdout1_2ck13 = 1.7 time = 140
* CHECK dout1_3 vdout1_3ck13 = 1.7 time = 140
* CHECK dout1_4 vdout1_4ck13 = 1.7 time = 140
* CHECK dout1_5 vdout1_5ck13 = 1.7 time = 140
* CHECK dout1_6 vdout1_6ck13 = 0 time = 140
* CHECK dout1_7 vdout1_7ck13 = 1.7 time = 140
* CHECK dout1_8 vdout1_8ck13 = 1.7 time = 140
* CHECK dout1_9 vdout1_9ck13 = 1.7 time = 140
* CHECK dout1_10 vdout1_10ck13 = 1.7 time = 140
* CHECK dout1_11 vdout1_11ck13 = 1.7 time = 140
* CHECK dout1_12 vdout1_12ck13 = 0 time = 140
* CHECK dout1_13 vdout1_13ck13 = 1.7 time = 140
* CHECK dout1_14 vdout1_14ck13 = 1.7 time = 140
* CHECK dout1_15 vdout1_15ck13 = 0 time = 140
* CHECK dout1_16 vdout1_16ck13 = 0 time = 140
* CHECK dout1_0 vdout1_0ck16 = 0 time = 170
* CHECK dout1_1 vdout1_1ck16 = 1.7 time = 170
* CHECK dout1_2 vdout1_2ck16 = 0 time = 170
* CHECK dout1_3 vdout1_3ck16 = 1.7 time = 170
* CHECK dout1_4 vdout1_4ck16 = 0 time = 170
* CHECK dout1_5 vdout1_5ck16 = 0 time = 170
* CHECK dout1_6 vdout1_6ck16 = 0 time = 170
* CHECK dout1_7 vdout1_7ck16 = 0 time = 170
* CHECK dout1_8 vdout1_8ck16 = 0 time = 170
* CHECK dout1_9 vdout1_9ck16 = 0 time = 170
* CHECK dout1_10 vdout1_10ck16 = 0 time = 170
* CHECK dout1_11 vdout1_11ck16 = 0 time = 170
* CHECK dout1_12 vdout1_12ck16 = 1.7 time = 170
* CHECK dout1_13 vdout1_13ck16 = 0 time = 170
* CHECK dout1_14 vdout1_14ck16 = 1.7 time = 170
* CHECK dout1_15 vdout1_15ck16 = 0 time = 170
* CHECK dout1_16 vdout1_16ck16 = 0 time = 170
* CHECK dout1_0 vdout1_0ck18 = 0 time = 190
* CHECK dout1_1 vdout1_1ck18 = 1.7 time = 190
* CHECK dout1_2 vdout1_2ck18 = 1.7 time = 190
* CHECK dout1_3 vdout1_3ck18 = 1.7 time = 190
* CHECK dout1_4 vdout1_4ck18 = 0 time = 190
* CHECK dout1_5 vdout1_5ck18 = 1.7 time = 190
* CHECK dout1_6 vdout1_6ck18 = 0 time = 190
* CHECK dout1_7 vdout1_7ck18 = 1.7 time = 190
* CHECK dout1_8 vdout1_8ck18 = 1.7 time = 190
* CHECK dout1_9 vdout1_9ck18 = 1.7 time = 190
* CHECK dout1_10 vdout1_10ck18 = 0 time = 190
* CHECK dout1_11 vdout1_11ck18 = 1.7 time = 190
* CHECK dout1_12 vdout1_12ck18 = 0 time = 190
* CHECK dout1_13 vdout1_13ck18 = 1.7 time = 190
* CHECK dout1_14 vdout1_14ck18 = 1.7 time = 190
* CHECK dout1_15 vdout1_15ck18 = 1.7 time = 190
* CHECK dout1_16 vdout1_16ck18 = 0 time = 190
* CHECK dout1_0 vdout1_0ck19 = 0 time = 200
* CHECK dout1_1 vdout1_1ck19 = 1.7 time = 200
* CHECK dout1_2 vdout1_2ck19 = 1.7 time = 200
* CHECK dout1_3 vdout1_3ck19 = 1.7 time = 200
* CHECK dout1_4 vdout1_4ck19 = 0 time = 200
* CHECK dout1_5 vdout1_5ck19 = 1.7 time = 200
* CHECK dout1_6 vdout1_6ck19 = 0 time = 200
* CHECK dout1_7 vdout1_7ck19 = 1.7 time = 200
* CHECK dout1_8 vdout1_8ck19 = 1.7 time = 200
* CHECK dout1_9 vdout1_9ck19 = 1.7 time = 200
* CHECK dout1_10 vdout1_10ck19 = 0 time = 200
* CHECK dout1_11 vdout1_11ck19 = 1.7 time = 200
* CHECK dout1_12 vdout1_12ck19 = 0 time = 200
* CHECK dout1_13 vdout1_13ck19 = 1.7 time = 200
* CHECK dout1_14 vdout1_14ck19 = 1.7 time = 200
* CHECK dout1_15 vdout1_15ck19 = 1.7 time = 200
* CHECK dout1_16 vdout1_16ck19 = 0 time = 200
* CHECK dout1_0 vdout1_0ck22 = 1.7 time = 230
* CHECK dout1_1 vdout1_1ck22 = 1.7 time = 230
* CHECK dout1_2 vdout1_2ck22 = 1.7 time = 230
* CHECK dout1_3 vdout1_3ck22 = 0 time = 230
* CHECK dout1_4 vdout1_4ck22 = 0 time = 230
* CHECK dout1_5 vdout1_5ck22 = 1.7 time = 230
* CHECK dout1_6 vdout1_6ck22 = 0 time = 230
* CHECK dout1_7 vdout1_7ck22 = 1.7 time = 230
* CHECK dout1_8 vdout1_8ck22 = 0 time = 230
* CHECK dout1_9 vdout1_9ck22 = 0 time = 230
* CHECK dout1_10 vdout1_10ck22 = 1.7 time = 230
* CHECK dout1_11 vdout1_11ck22 = 0 time = 230
* CHECK dout1_12 vdout1_12ck22 = 0 time = 230
* CHECK dout1_13 vdout1_13ck22 = 1.7 time = 230
* CHECK dout1_14 vdout1_14ck22 = 0 time = 230
* CHECK dout1_15 vdout1_15ck22 = 1.7 time = 230
* CHECK dout1_16 vdout1_16ck22 = 0 time = 230
* CHECK dout1_0 vdout1_0ck24 = 1.7 time = 250
* CHECK dout1_1 vdout1_1ck24 = 1.7 time = 250
* CHECK dout1_2 vdout1_2ck24 = 1.7 time = 250
* CHECK dout1_3 vdout1_3ck24 = 0 time = 250
* CHECK dout1_4 vdout1_4ck24 = 0 time = 250
* CHECK dout1_5 vdout1_5ck24 = 1.7 time = 250
* CHECK dout1_6 vdout1_6ck24 = 0 time = 250
* CHECK dout1_7 vdout1_7ck24 = 1.7 time = 250
* CHECK dout1_8 vdout1_8ck24 = 0 time = 250
* CHECK dout1_9 vdout1_9ck24 = 0 time = 250
* CHECK dout1_10 vdout1_10ck24 = 1.7 time = 250
* CHECK dout1_11 vdout1_11ck24 = 0 time = 250
* CHECK dout1_12 vdout1_12ck24 = 0 time = 250
* CHECK dout1_13 vdout1_13ck24 = 1.7 time = 250
* CHECK dout1_14 vdout1_14ck24 = 0 time = 250
* CHECK dout1_15 vdout1_15ck24 = 1.7 time = 250
* CHECK dout1_16 vdout1_16ck24 = 0 time = 250
* CHECK dout1_0 vdout1_0ck27 = 0 time = 280
* CHECK dout1_1 vdout1_1ck27 = 1.7 time = 280
* CHECK dout1_2 vdout1_2ck27 = 1.7 time = 280
* CHECK dout1_3 vdout1_3ck27 = 1.7 time = 280
* CHECK dout1_4 vdout1_4ck27 = 0 time = 280
* CHECK dout1_5 vdout1_5ck27 = 1.7 time = 280
* CHECK dout1_6 vdout1_6ck27 = 0 time = 280
* CHECK dout1_7 vdout1_7ck27 = 1.7 time = 280
* CHECK dout1_8 vdout1_8ck27 = 1.7 time = 280
* CHECK dout1_9 vdout1_9ck27 = 1.7 time = 280
* CHECK dout1_10 vdout1_10ck27 = 0 time = 280
* CHECK dout1_11 vdout1_11ck27 = 1.7 time = 280
* CHECK dout1_12 vdout1_12ck27 = 0 time = 280
* CHECK dout1_13 vdout1_13ck27 = 1.7 time = 280
* CHECK dout1_14 vdout1_14ck27 = 1.7 time = 280
* CHECK dout1_15 vdout1_15ck27 = 1.7 time = 280
* CHECK dout1_16 vdout1_16ck27 = 0 time = 280
* CHECK dout1_0 vdout1_0ck28 = 0 time = 290
* CHECK dout1_1 vdout1_1ck28 = 1.7 time = 290
* CHECK dout1_2 vdout1_2ck28 = 1.7 time = 290
* CHECK dout1_3 vdout1_3ck28 = 1.7 time = 290
* CHECK dout1_4 vdout1_4ck28 = 0 time = 290
* CHECK dout1_5 vdout1_5ck28 = 1.7 time = 290
* CHECK dout1_6 vdout1_6ck28 = 0 time = 290
* CHECK dout1_7 vdout1_7ck28 = 1.7 time = 290
* CHECK dout1_8 vdout1_8ck28 = 1.7 time = 290
* CHECK dout1_9 vdout1_9ck28 = 1.7 time = 290
* CHECK dout1_10 vdout1_10ck28 = 0 time = 290
* CHECK dout1_11 vdout1_11ck28 = 1.7 time = 290
* CHECK dout1_12 vdout1_12ck28 = 0 time = 290
* CHECK dout1_13 vdout1_13ck28 = 1.7 time = 290
* CHECK dout1_14 vdout1_14ck28 = 1.7 time = 290
* CHECK dout1_15 vdout1_15ck28 = 1.7 time = 290
* CHECK dout1_16 vdout1_16ck28 = 0 time = 290
* CHECK dout1_0 vdout1_0ck29 = 0 time = 300
* CHECK dout1_1 vdout1_1ck29 = 1.7 time = 300
* CHECK dout1_2 vdout1_2ck29 = 1.7 time = 300
* CHECK dout1_3 vdout1_3ck29 = 1.7 time = 300
* CHECK dout1_4 vdout1_4ck29 = 0 time = 300
* CHECK dout1_5 vdout1_5ck29 = 1.7 time = 300
* CHECK dout1_6 vdout1_6ck29 = 0 time = 300
* CHECK dout1_7 vdout1_7ck29 = 1.7 time = 300
* CHECK dout1_8 vdout1_8ck29 = 1.7 time = 300
* CHECK dout1_9 vdout1_9ck29 = 1.7 time = 300
* CHECK dout1_10 vdout1_10ck29 = 0 time = 300
* CHECK dout1_11 vdout1_11ck29 = 1.7 time = 300
* CHECK dout1_12 vdout1_12ck29 = 0 time = 300
* CHECK dout1_13 vdout1_13ck29 = 1.7 time = 300
* CHECK dout1_14 vdout1_14ck29 = 1.7 time = 300
* CHECK dout1_15 vdout1_15ck29 = 1.7 time = 300
* CHECK dout1_16 vdout1_16ck29 = 0 time = 300
* CHECK dout1_0 vdout1_0ck31 = 1.7 time = 320
* CHECK dout1_1 vdout1_1ck31 = 0 time = 320
* CHECK dout1_2 vdout1_2ck31 = 0 time = 320
* CHECK dout1_3 vdout1_3ck31 = 1.7 time = 320
* CHECK dout1_4 vdout1_4ck31 = 1.7 time = 320
* CHECK dout1_5 vdout1_5ck31 = 1.7 time = 320
* CHECK dout1_6 vdout1_6ck31 = 0 time = 320
* CHECK dout1_7 vdout1_7ck31 = 0 time = 320
* CHECK dout1_8 vdout1_8ck31 = 0 time = 320
* CHECK dout1_9 vdout1_9ck31 = 0 time = 320
* CHECK dout1_10 vdout1_10ck31 = 1.7 time = 320
* CHECK dout1_11 vdout1_11ck31 = 0 time = 320
* CHECK dout1_12 vdout1_12ck31 = 1.7 time = 320
* CHECK dout1_13 vdout1_13ck31 = 0 time = 320
* CHECK dout1_14 vdout1_14ck31 = 1.7 time = 320
* CHECK dout1_15 vdout1_15ck31 = 0 time = 320
* CHECK dout1_16 vdout1_16ck31 = 0 time = 320
* CHECK dout1_0 vdout1_0ck32 = 1.7 time = 330
* CHECK dout1_1 vdout1_1ck32 = 1.7 time = 330
* CHECK dout1_2 vdout1_2ck32 = 0 time = 330
* CHECK dout1_3 vdout1_3ck32 = 1.7 time = 330
* CHECK dout1_4 vdout1_4ck32 = 1.7 time = 330
* CHECK dout1_5 vdout1_5ck32 = 0 time = 330
* CHECK dout1_6 vdout1_6ck32 = 1.7 time = 330
* CHECK dout1_7 vdout1_7ck32 = 1.7 time = 330
* CHECK dout1_8 vdout1_8ck32 = 1.7 time = 330
* CHECK dout1_9 vdout1_9ck32 = 0 time = 330
* CHECK dout1_10 vdout1_10ck32 = 0 time = 330
* CHECK dout1_11 vdout1_11ck32 = 1.7 time = 330
* CHECK dout1_12 vdout1_12ck32 = 1.7 time = 330
* CHECK dout1_13 vdout1_13ck32 = 0 time = 330
* CHECK dout1_14 vdout1_14ck32 = 1.7 time = 330
* CHECK dout1_15 vdout1_15ck32 = 0 time = 330
* CHECK dout1_16 vdout1_16ck32 = 0 time = 330
* CHECK dout1_0 vdout1_0ck34 = 0 time = 350
* CHECK dout1_1 vdout1_1ck34 = 1.7 time = 350
* CHECK dout1_2 vdout1_2ck34 = 1.7 time = 350
* CHECK dout1_3 vdout1_3ck34 = 1.7 time = 350
* CHECK dout1_4 vdout1_4ck34 = 0 time = 350
* CHECK dout1_5 vdout1_5ck34 = 1.7 time = 350
* CHECK dout1_6 vdout1_6ck34 = 0 time = 350
* CHECK dout1_7 vdout1_7ck34 = 1.7 time = 350
* CHECK dout1_8 vdout1_8ck34 = 1.7 time = 350
* CHECK dout1_9 vdout1_9ck34 = 1.7 time = 350
* CHECK dout1_10 vdout1_10ck34 = 0 time = 350
* CHECK dout1_11 vdout1_11ck34 = 1.7 time = 350
* CHECK dout1_12 vdout1_12ck34 = 0 time = 350
* CHECK dout1_13 vdout1_13ck34 = 1.7 time = 350
* CHECK dout1_14 vdout1_14ck34 = 1.7 time = 350
* CHECK dout1_15 vdout1_15ck34 = 1.7 time = 350
* CHECK dout1_16 vdout1_16ck34 = 0 time = 350
* CHECK dout1_0 vdout1_0ck35 = 1.7 time = 360
* CHECK dout1_1 vdout1_1ck35 = 1.7 time = 360
* CHECK dout1_2 vdout1_2ck35 = 1.7 time = 360
* CHECK dout1_3 vdout1_3ck35 = 0 time = 360
* CHECK dout1_4 vdout1_4ck35 = 0 time = 360
* CHECK dout1_5 vdout1_5ck35 = 1.7 time = 360
* CHECK dout1_6 vdout1_6ck35 = 0 time = 360
* CHECK dout1_7 vdout1_7ck35 = 1.7 time = 360
* CHECK dout1_8 vdout1_8ck35 = 0 time = 360
* CHECK dout1_9 vdout1_9ck35 = 0 time = 360
* CHECK dout1_10 vdout1_10ck35 = 1.7 time = 360
* CHECK dout1_11 vdout1_11ck35 = 0 time = 360
* CHECK dout1_12 vdout1_12ck35 = 0 time = 360
* CHECK dout1_13 vdout1_13ck35 = 1.7 time = 360
* CHECK dout1_14 vdout1_14ck35 = 0 time = 360
* CHECK dout1_15 vdout1_15ck35 = 1.7 time = 360
* CHECK dout1_16 vdout1_16ck35 = 0 time = 360
* CHECK dout1_0 vdout1_0ck36 = 1.7 time = 370
* CHECK dout1_1 vdout1_1ck36 = 1.7 time = 370
* CHECK dout1_2 vdout1_2ck36 = 0 time = 370
* CHECK dout1_3 vdout1_3ck36 = 1.7 time = 370
* CHECK dout1_4 vdout1_4ck36 = 1.7 time = 370
* CHECK dout1_5 vdout1_5ck36 = 0 time = 370
* CHECK dout1_6 vdout1_6ck36 = 1.7 time = 370
* CHECK dout1_7 vdout1_7ck36 = 1.7 time = 370
* CHECK dout1_8 vdout1_8ck36 = 1.7 time = 370
* CHECK dout1_9 vdout1_9ck36 = 0 time = 370
* CHECK dout1_10 vdout1_10ck36 = 0 time = 370
* CHECK dout1_11 vdout1_11ck36 = 1.7 time = 370
* CHECK dout1_12 vdout1_12ck36 = 1.7 time = 370
* CHECK dout1_13 vdout1_13ck36 = 0 time = 370
* CHECK dout1_14 vdout1_14ck36 = 1.7 time = 370
* CHECK dout1_15 vdout1_15ck36 = 0 time = 370
* CHECK dout1_16 vdout1_16ck36 = 0 time = 370
* CHECK dout1_0 vdout1_0ck37 = 0 time = 380
* CHECK dout1_1 vdout1_1ck37 = 1.7 time = 380
* CHECK dout1_2 vdout1_2ck37 = 1.7 time = 380
* CHECK dout1_3 vdout1_3ck37 = 1.7 time = 380
* CHECK dout1_4 vdout1_4ck37 = 0 time = 380
* CHECK dout1_5 vdout1_5ck37 = 1.7 time = 380
* CHECK dout1_6 vdout1_6ck37 = 0 time = 380
* CHECK dout1_7 vdout1_7ck37 = 1.7 time = 380
* CHECK dout1_8 vdout1_8ck37 = 1.7 time = 380
* CHECK dout1_9 vdout1_9ck37 = 1.7 time = 380
* CHECK dout1_10 vdout1_10ck37 = 0 time = 380
* CHECK dout1_11 vdout1_11ck37 = 1.7 time = 380
* CHECK dout1_12 vdout1_12ck37 = 0 time = 380
* CHECK dout1_13 vdout1_13ck37 = 1.7 time = 380
* CHECK dout1_14 vdout1_14ck37 = 1.7 time = 380
* CHECK dout1_15 vdout1_15ck37 = 1.7 time = 380
* CHECK dout1_16 vdout1_16ck37 = 0 time = 380
* CHECK dout1_0 vdout1_0ck42 = 1.7 time = 430
* CHECK dout1_1 vdout1_1ck42 = 0 time = 430
* CHECK dout1_2 vdout1_2ck42 = 0 time = 430
* CHECK dout1_3 vdout1_3ck42 = 1.7 time = 430
* CHECK dout1_4 vdout1_4ck42 = 0 time = 430
* CHECK dout1_5 vdout1_5ck42 = 0 time = 430
* CHECK dout1_6 vdout1_6ck42 = 0 time = 430
* CHECK dout1_7 vdout1_7ck42 = 0 time = 430
* CHECK dout1_8 vdout1_8ck42 = 1.7 time = 430
* CHECK dout1_9 vdout1_9ck42 = 1.7 time = 430
* CHECK dout1_10 vdout1_10ck42 = 0 time = 430
* CHECK dout1_11 vdout1_11ck42 = 1.7 time = 430
* CHECK dout1_12 vdout1_12ck42 = 0 time = 430
* CHECK dout1_13 vdout1_13ck42 = 0 time = 430
* CHECK dout1_14 vdout1_14ck42 = 1.7 time = 430
* CHECK dout1_15 vdout1_15ck42 = 1.7 time = 430
* CHECK dout1_16 vdout1_16ck42 = 0 time = 430
* CHECK dout1_0 vdout1_0ck45 = 1.7 time = 460
* CHECK dout1_1 vdout1_1ck45 = 0 time = 460
* CHECK dout1_2 vdout1_2ck45 = 0 time = 460
* CHECK dout1_3 vdout1_3ck45 = 1.7 time = 460
* CHECK dout1_4 vdout1_4ck45 = 0 time = 460
* CHECK dout1_5 vdout1_5ck45 = 0 time = 460
* CHECK dout1_6 vdout1_6ck45 = 0 time = 460
* CHECK dout1_7 vdout1_7ck45 = 0 time = 460
* CHECK dout1_8 vdout1_8ck45 = 1.7 time = 460
* CHECK dout1_9 vdout1_9ck45 = 1.7 time = 460
* CHECK dout1_10 vdout1_10ck45 = 0 time = 460
* CHECK dout1_11 vdout1_11ck45 = 1.7 time = 460
* CHECK dout1_12 vdout1_12ck45 = 0 time = 460
* CHECK dout1_13 vdout1_13ck45 = 0 time = 460
* CHECK dout1_14 vdout1_14ck45 = 1.7 time = 460
* CHECK dout1_15 vdout1_15ck45 = 1.7 time = 460
* CHECK dout1_16 vdout1_16ck45 = 0 time = 460
* CHECK dout1_0 vdout1_0ck47 = 0 time = 480
* CHECK dout1_1 vdout1_1ck47 = 1.7 time = 480
* CHECK dout1_2 vdout1_2ck47 = 0 time = 480
* CHECK dout1_3 vdout1_3ck47 = 0 time = 480
* CHECK dout1_4 vdout1_4ck47 = 1.7 time = 480
* CHECK dout1_5 vdout1_5ck47 = 1.7 time = 480
* CHECK dout1_6 vdout1_6ck47 = 1.7 time = 480
* CHECK dout1_7 vdout1_7ck47 = 0 time = 480
* CHECK dout1_8 vdout1_8ck47 = 1.7 time = 480
* CHECK dout1_9 vdout1_9ck47 = 0 time = 480
* CHECK dout1_10 vdout1_10ck47 = 1.7 time = 480
* CHECK dout1_11 vdout1_11ck47 = 1.7 time = 480
* CHECK dout1_12 vdout1_12ck47 = 0 time = 480
* CHECK dout1_13 vdout1_13ck47 = 0 time = 480
* CHECK dout1_14 vdout1_14ck47 = 0 time = 480
* CHECK dout1_15 vdout1_15ck47 = 1.7 time = 480
* CHECK dout1_16 vdout1_16ck47 = 0 time = 480
* CHECK dout1_0 vdout1_0ck50 = 1.7 time = 510
* CHECK dout1_1 vdout1_1ck50 = 1.7 time = 510
* CHECK dout1_2 vdout1_2ck50 = 0 time = 510
* CHECK dout1_3 vdout1_3ck50 = 1.7 time = 510
* CHECK dout1_4 vdout1_4ck50 = 0 time = 510
* CHECK dout1_5 vdout1_5ck50 = 0 time = 510
* CHECK dout1_6 vdout1_6ck50 = 1.7 time = 510
* CHECK dout1_7 vdout1_7ck50 = 1.7 time = 510
* CHECK dout1_8 vdout1_8ck50 = 0 time = 510
* CHECK dout1_9 vdout1_9ck50 = 1.7 time = 510
* CHECK dout1_10 vdout1_10ck50 = 1.7 time = 510
* CHECK dout1_11 vdout1_11ck50 = 1.7 time = 510
* CHECK dout1_12 vdout1_12ck50 = 1.7 time = 510
* CHECK dout1_13 vdout1_13ck50 = 1.7 time = 510
* CHECK dout1_14 vdout1_14ck50 = 1.7 time = 510
* CHECK dout1_15 vdout1_15ck50 = 0 time = 510
* CHECK dout1_16 vdout1_16ck50 = 0 time = 510
* CHECK dout1_0 vdout1_0ck52 = 1.7 time = 530
* CHECK dout1_1 vdout1_1ck52 = 0 time = 530
* CHECK dout1_2 vdout1_2ck52 = 0 time = 530
* CHECK dout1_3 vdout1_3ck52 = 0 time = 530
* CHECK dout1_4 vdout1_4ck52 = 0 time = 530
* CHECK dout1_5 vdout1_5ck52 = 0 time = 530
* CHECK dout1_6 vdout1_6ck52 = 1.7 time = 530
* CHECK dout1_7 vdout1_7ck52 = 1.7 time = 530
* CHECK dout1_8 vdout1_8ck52 = 1.7 time = 530
* CHECK dout1_9 vdout1_9ck52 = 1.7 time = 530
* CHECK dout1_10 vdout1_10ck52 = 0 time = 530
* CHECK dout1_11 vdout1_11ck52 = 1.7 time = 530
* CHECK dout1_12 vdout1_12ck52 = 0 time = 530
* CHECK dout1_13 vdout1_13ck52 = 1.7 time = 530
* CHECK dout1_14 vdout1_14ck52 = 0 time = 530
* CHECK dout1_15 vdout1_15ck52 = 1.7 time = 530
* CHECK dout1_16 vdout1_16ck52 = 0 time = 530
* CHECK dout1_0 vdout1_0ck55 = 1.7 time = 560
* CHECK dout1_1 vdout1_1ck55 = 1.7 time = 560
* CHECK dout1_2 vdout1_2ck55 = 1.7 time = 560
* CHECK dout1_3 vdout1_3ck55 = 1.7 time = 560
* CHECK dout1_4 vdout1_4ck55 = 1.7 time = 560
* CHECK dout1_5 vdout1_5ck55 = 1.7 time = 560
* CHECK dout1_6 vdout1_6ck55 = 0 time = 560
* CHECK dout1_7 vdout1_7ck55 = 1.7 time = 560
* CHECK dout1_8 vdout1_8ck55 = 1.7 time = 560
* CHECK dout1_9 vdout1_9ck55 = 0 time = 560
* CHECK dout1_10 vdout1_10ck55 = 0 time = 560
* CHECK dout1_11 vdout1_11ck55 = 1.7 time = 560
* CHECK dout1_12 vdout1_12ck55 = 0 time = 560
* CHECK dout1_13 vdout1_13ck55 = 0 time = 560
* CHECK dout1_14 vdout1_14ck55 = 1.7 time = 560
* CHECK dout1_15 vdout1_15ck55 = 1.7 time = 560
* CHECK dout1_16 vdout1_16ck55 = 0 time = 560
* CHECK dout1_0 vdout1_0ck56 = 1.7 time = 570
* CHECK dout1_1 vdout1_1ck56 = 0 time = 570
* CHECK dout1_2 vdout1_2ck56 = 0 time = 570
* CHECK dout1_3 vdout1_3ck56 = 1.7 time = 570
* CHECK dout1_4 vdout1_4ck56 = 0 time = 570
* CHECK dout1_5 vdout1_5ck56 = 1.7 time = 570
* CHECK dout1_6 vdout1_6ck56 = 0 time = 570
* CHECK dout1_7 vdout1_7ck56 = 1.7 time = 570
* CHECK dout1_8 vdout1_8ck56 = 1.7 time = 570
* CHECK dout1_9 vdout1_9ck56 = 1.7 time = 570
* CHECK dout1_10 vdout1_10ck56 = 0 time = 570
* CHECK dout1_11 vdout1_11ck56 = 1.7 time = 570
* CHECK dout1_12 vdout1_12ck56 = 0 time = 570
* CHECK dout1_13 vdout1_13ck56 = 1.7 time = 570
* CHECK dout1_14 vdout1_14ck56 = 1.7 time = 570
* CHECK dout1_15 vdout1_15ck56 = 0 time = 570
* CHECK dout1_16 vdout1_16ck56 = 0 time = 570
* CHECK dout1_0 vdout1_0ck57 = 1.7 time = 580
* CHECK dout1_1 vdout1_1ck57 = 1.7 time = 580
* CHECK dout1_2 vdout1_2ck57 = 1.7 time = 580
* CHECK dout1_3 vdout1_3ck57 = 1.7 time = 580
* CHECK dout1_4 vdout1_4ck57 = 1.7 time = 580
* CHECK dout1_5 vdout1_5ck57 = 1.7 time = 580
* CHECK dout1_6 vdout1_6ck57 = 0 time = 580
* CHECK dout1_7 vdout1_7ck57 = 1.7 time = 580
* CHECK dout1_8 vdout1_8ck57 = 1.7 time = 580
* CHECK dout1_9 vdout1_9ck57 = 0 time = 580
* CHECK dout1_10 vdout1_10ck57 = 0 time = 580
* CHECK dout1_11 vdout1_11ck57 = 1.7 time = 580
* CHECK dout1_12 vdout1_12ck57 = 0 time = 580
* CHECK dout1_13 vdout1_13ck57 = 0 time = 580
* CHECK dout1_14 vdout1_14ck57 = 1.7 time = 580
* CHECK dout1_15 vdout1_15ck57 = 1.7 time = 580
* CHECK dout1_16 vdout1_16ck57 = 0 time = 580
* CHECK dout1_0 vdout1_0ck58 = 1.7 time = 590
* CHECK dout1_1 vdout1_1ck58 = 1.7 time = 590
* CHECK dout1_2 vdout1_2ck58 = 1.7 time = 590
* CHECK dout1_3 vdout1_3ck58 = 1.7 time = 590
* CHECK dout1_4 vdout1_4ck58 = 1.7 time = 590
* CHECK dout1_5 vdout1_5ck58 = 1.7 time = 590
* CHECK dout1_6 vdout1_6ck58 = 0 time = 590
* CHECK dout1_7 vdout1_7ck58 = 1.7 time = 590
* CHECK dout1_8 vdout1_8ck58 = 1.7 time = 590
* CHECK dout1_9 vdout1_9ck58 = 0 time = 590
* CHECK dout1_10 vdout1_10ck58 = 0 time = 590
* CHECK dout1_11 vdout1_11ck58 = 1.7 time = 590
* CHECK dout1_12 vdout1_12ck58 = 0 time = 590
* CHECK dout1_13 vdout1_13ck58 = 0 time = 590
* CHECK dout1_14 vdout1_14ck58 = 1.7 time = 590
* CHECK dout1_15 vdout1_15ck58 = 1.7 time = 590
* CHECK dout1_16 vdout1_16ck58 = 0 time = 590
* CHECK dout1_0 vdout1_0ck59 = 1.7 time = 600
* CHECK dout1_1 vdout1_1ck59 = 0 time = 600
* CHECK dout1_2 vdout1_2ck59 = 1.7 time = 600
* CHECK dout1_3 vdout1_3ck59 = 1.7 time = 600
* CHECK dout1_4 vdout1_4ck59 = 0 time = 600
* CHECK dout1_5 vdout1_5ck59 = 0 time = 600
* CHECK dout1_6 vdout1_6ck59 = 1.7 time = 600
* CHECK dout1_7 vdout1_7ck59 = 1.7 time = 600
* CHECK dout1_8 vdout1_8ck59 = 1.7 time = 600
* CHECK dout1_9 vdout1_9ck59 = 0 time = 600
* CHECK dout1_10 vdout1_10ck59 = 0 time = 600
* CHECK dout1_11 vdout1_11ck59 = 1.7 time = 600
* CHECK dout1_12 vdout1_12ck59 = 0 time = 600
* CHECK dout1_13 vdout1_13ck59 = 0 time = 600
* CHECK dout1_14 vdout1_14ck59 = 0 time = 600
* CHECK dout1_15 vdout1_15ck59 = 1.7 time = 600
* CHECK dout1_16 vdout1_16ck59 = 0 time = 600
* CHECK dout1_0 vdout1_0ck60 = 1.7 time = 610
* CHECK dout1_1 vdout1_1ck60 = 0 time = 610
* CHECK dout1_2 vdout1_2ck60 = 1.7 time = 610
* CHECK dout1_3 vdout1_3ck60 = 1.7 time = 610
* CHECK dout1_4 vdout1_4ck60 = 0 time = 610
* CHECK dout1_5 vdout1_5ck60 = 0 time = 610
* CHECK dout1_6 vdout1_6ck60 = 1.7 time = 610
* CHECK dout1_7 vdout1_7ck60 = 1.7 time = 610
* CHECK dout1_8 vdout1_8ck60 = 1.7 time = 610
* CHECK dout1_9 vdout1_9ck60 = 0 time = 610
* CHECK dout1_10 vdout1_10ck60 = 0 time = 610
* CHECK dout1_11 vdout1_11ck60 = 1.7 time = 610
* CHECK dout1_12 vdout1_12ck60 = 0 time = 610
* CHECK dout1_13 vdout1_13ck60 = 0 time = 610
* CHECK dout1_14 vdout1_14ck60 = 0 time = 610
* CHECK dout1_15 vdout1_15ck60 = 1.7 time = 610
* CHECK dout1_16 vdout1_16ck60 = 0 time = 610
* CHECK dout1_0 vdout1_0ck65 = 1.7 time = 660
* CHECK dout1_1 vdout1_1ck65 = 0 time = 660
* CHECK dout1_2 vdout1_2ck65 = 1.7 time = 660
* CHECK dout1_3 vdout1_3ck65 = 1.7 time = 660
* CHECK dout1_4 vdout1_4ck65 = 0 time = 660
* CHECK dout1_5 vdout1_5ck65 = 0 time = 660
* CHECK dout1_6 vdout1_6ck65 = 1.7 time = 660
* CHECK dout1_7 vdout1_7ck65 = 1.7 time = 660
* CHECK dout1_8 vdout1_8ck65 = 1.7 time = 660
* CHECK dout1_9 vdout1_9ck65 = 0 time = 660
* CHECK dout1_10 vdout1_10ck65 = 0 time = 660
* CHECK dout1_11 vdout1_11ck65 = 1.7 time = 660
* CHECK dout1_12 vdout1_12ck65 = 0 time = 660
* CHECK dout1_13 vdout1_13ck65 = 0 time = 660
* CHECK dout1_14 vdout1_14ck65 = 0 time = 660
* CHECK dout1_15 vdout1_15ck65 = 1.7 time = 660
* CHECK dout1_16 vdout1_16ck65 = 0 time = 660
* CHECK dout1_0 vdout1_0ck66 = 1.7 time = 670
* CHECK dout1_1 vdout1_1ck66 = 0 time = 670
* CHECK dout1_2 vdout1_2ck66 = 1.7 time = 670
* CHECK dout1_3 vdout1_3ck66 = 1.7 time = 670
* CHECK dout1_4 vdout1_4ck66 = 0 time = 670
* CHECK dout1_5 vdout1_5ck66 = 0 time = 670
* CHECK dout1_6 vdout1_6ck66 = 1.7 time = 670
* CHECK dout1_7 vdout1_7ck66 = 1.7 time = 670
* CHECK dout1_8 vdout1_8ck66 = 1.7 time = 670
* CHECK dout1_9 vdout1_9ck66 = 0 time = 670
* CHECK dout1_10 vdout1_10ck66 = 0 time = 670
* CHECK dout1_11 vdout1_11ck66 = 1.7 time = 670
* CHECK dout1_12 vdout1_12ck66 = 0 time = 670
* CHECK dout1_13 vdout1_13ck66 = 0 time = 670
* CHECK dout1_14 vdout1_14ck66 = 0 time = 670
* CHECK dout1_15 vdout1_15ck66 = 1.7 time = 670
* CHECK dout1_16 vdout1_16ck66 = 0 time = 670
* CHECK dout1_0 vdout1_0ck68 = 0 time = 690
* CHECK dout1_1 vdout1_1ck68 = 0 time = 690
* CHECK dout1_2 vdout1_2ck68 = 0 time = 690
* CHECK dout1_3 vdout1_3ck68 = 0 time = 690
* CHECK dout1_4 vdout1_4ck68 = 0 time = 690
* CHECK dout1_5 vdout1_5ck68 = 0 time = 690
* CHECK dout1_6 vdout1_6ck68 = 1.7 time = 690
* CHECK dout1_7 vdout1_7ck68 = 1.7 time = 690
* CHECK dout1_8 vdout1_8ck68 = 1.7 time = 690
* CHECK dout1_9 vdout1_9ck68 = 1.7 time = 690
* CHECK dout1_10 vdout1_10ck68 = 0 time = 690
* CHECK dout1_11 vdout1_11ck68 = 1.7 time = 690
* CHECK dout1_12 vdout1_12ck68 = 0 time = 690
* CHECK dout1_13 vdout1_13ck68 = 1.7 time = 690
* CHECK dout1_14 vdout1_14ck68 = 1.7 time = 690
* CHECK dout1_15 vdout1_15ck68 = 0 time = 690
* CHECK dout1_16 vdout1_16ck68 = 0 time = 690
* CHECK dout1_0 vdout1_0ck70 = 0 time = 710
* CHECK dout1_1 vdout1_1ck70 = 1.7 time = 710
* CHECK dout1_2 vdout1_2ck70 = 0 time = 710
* CHECK dout1_3 vdout1_3ck70 = 0 time = 710
* CHECK dout1_4 vdout1_4ck70 = 0 time = 710
* CHECK dout1_5 vdout1_5ck70 = 1.7 time = 710
* CHECK dout1_6 vdout1_6ck70 = 0 time = 710
* CHECK dout1_7 vdout1_7ck70 = 1.7 time = 710
* CHECK dout1_8 vdout1_8ck70 = 1.7 time = 710
* CHECK dout1_9 vdout1_9ck70 = 0 time = 710
* CHECK dout1_10 vdout1_10ck70 = 1.7 time = 710
* CHECK dout1_11 vdout1_11ck70 = 1.7 time = 710
* CHECK dout1_12 vdout1_12ck70 = 1.7 time = 710
* CHECK dout1_13 vdout1_13ck70 = 1.7 time = 710
* CHECK dout1_14 vdout1_14ck70 = 0 time = 710
* CHECK dout1_15 vdout1_15ck70 = 0 time = 710
* CHECK dout1_16 vdout1_16ck70 = 0 time = 710
* CHECK dout1_0 vdout1_0ck71 = 0 time = 720
* CHECK dout1_1 vdout1_1ck71 = 1.7 time = 720
* CHECK dout1_2 vdout1_2ck71 = 0 time = 720
* CHECK dout1_3 vdout1_3ck71 = 0 time = 720
* CHECK dout1_4 vdout1_4ck71 = 0 time = 720
* CHECK dout1_5 vdout1_5ck71 = 1.7 time = 720
* CHECK dout1_6 vdout1_6ck71 = 0 time = 720
* CHECK dout1_7 vdout1_7ck71 = 1.7 time = 720
* CHECK dout1_8 vdout1_8ck71 = 1.7 time = 720
* CHECK dout1_9 vdout1_9ck71 = 0 time = 720
* CHECK dout1_10 vdout1_10ck71 = 1.7 time = 720
* CHECK dout1_11 vdout1_11ck71 = 1.7 time = 720
* CHECK dout1_12 vdout1_12ck71 = 1.7 time = 720
* CHECK dout1_13 vdout1_13ck71 = 1.7 time = 720
* CHECK dout1_14 vdout1_14ck71 = 0 time = 720
* CHECK dout1_15 vdout1_15ck71 = 0 time = 720
* CHECK dout1_16 vdout1_16ck71 = 0 time = 720
* CHECK dout1_0 vdout1_0ck76 = 1.7 time = 770
* CHECK dout1_1 vdout1_1ck76 = 1.7 time = 770
* CHECK dout1_2 vdout1_2ck76 = 1.7 time = 770
* CHECK dout1_3 vdout1_3ck76 = 1.7 time = 770
* CHECK dout1_4 vdout1_4ck76 = 1.7 time = 770
* CHECK dout1_5 vdout1_5ck76 = 0 time = 770
* CHECK dout1_6 vdout1_6ck76 = 0 time = 770
* CHECK dout1_7 vdout1_7ck76 = 0 time = 770
* CHECK dout1_8 vdout1_8ck76 = 1.7 time = 770
* CHECK dout1_9 vdout1_9ck76 = 1.7 time = 770
* CHECK dout1_10 vdout1_10ck76 = 0 time = 770
* CHECK dout1_11 vdout1_11ck76 = 0 time = 770
* CHECK dout1_12 vdout1_12ck76 = 1.7 time = 770
* CHECK dout1_13 vdout1_13ck76 = 0 time = 770
* CHECK dout1_14 vdout1_14ck76 = 1.7 time = 770
* CHECK dout1_15 vdout1_15ck76 = 0 time = 770
* CHECK dout1_16 vdout1_16ck76 = 0 time = 770
* CHECK dout1_0 vdout1_0ck77 = 0 time = 780
* CHECK dout1_1 vdout1_1ck77 = 0 time = 780
* CHECK dout1_2 vdout1_2ck77 = 0 time = 780
* CHECK dout1_3 vdout1_3ck77 = 1.7 time = 780
* CHECK dout1_4 vdout1_4ck77 = 0 time = 780
* CHECK dout1_5 vdout1_5ck77 = 0 time = 780
* CHECK dout1_6 vdout1_6ck77 = 0 time = 780
* CHECK dout1_7 vdout1_7ck77 = 1.7 time = 780
* CHECK dout1_8 vdout1_8ck77 = 1.7 time = 780
* CHECK dout1_9 vdout1_9ck77 = 0 time = 780
* CHECK dout1_10 vdout1_10ck77 = 1.7 time = 780
* CHECK dout1_11 vdout1_11ck77 = 0 time = 780
* CHECK dout1_12 vdout1_12ck77 = 1.7 time = 780
* CHECK dout1_13 vdout1_13ck77 = 1.7 time = 780
* CHECK dout1_14 vdout1_14ck77 = 0 time = 780
* CHECK dout1_15 vdout1_15ck77 = 1.7 time = 780
* CHECK dout1_16 vdout1_16ck77 = 0 time = 780
* CHECK dout1_0 vdout1_0ck78 = 1.7 time = 790
* CHECK dout1_1 vdout1_1ck78 = 0 time = 790
* CHECK dout1_2 vdout1_2ck78 = 0 time = 790
* CHECK dout1_3 vdout1_3ck78 = 0 time = 790
* CHECK dout1_4 vdout1_4ck78 = 0 time = 790
* CHECK dout1_5 vdout1_5ck78 = 1.7 time = 790
* CHECK dout1_6 vdout1_6ck78 = 0 time = 790
* CHECK dout1_7 vdout1_7ck78 = 0 time = 790
* CHECK dout1_8 vdout1_8ck78 = 1.7 time = 790
* CHECK dout1_9 vdout1_9ck78 = 1.7 time = 790
* CHECK dout1_10 vdout1_10ck78 = 0 time = 790
* CHECK dout1_11 vdout1_11ck78 = 1.7 time = 790
* CHECK dout1_12 vdout1_12ck78 = 1.7 time = 790
* CHECK dout1_13 vdout1_13ck78 = 1.7 time = 790
* CHECK dout1_14 vdout1_14ck78 = 0 time = 790
* CHECK dout1_15 vdout1_15ck78 = 1.7 time = 790
* CHECK dout1_16 vdout1_16ck78 = 0 time = 790
* CHECK dout1_0 vdout1_0ck79 = 1.7 time = 800
* CHECK dout1_1 vdout1_1ck79 = 0 time = 800
* CHECK dout1_2 vdout1_2ck79 = 0 time = 800
* CHECK dout1_3 vdout1_3ck79 = 0 time = 800
* CHECK dout1_4 vdout1_4ck79 = 0 time = 800
* CHECK dout1_5 vdout1_5ck79 = 1.7 time = 800
* CHECK dout1_6 vdout1_6ck79 = 0 time = 800
* CHECK dout1_7 vdout1_7ck79 = 0 time = 800
* CHECK dout1_8 vdout1_8ck79 = 1.7 time = 800
* CHECK dout1_9 vdout1_9ck79 = 1.7 time = 800
* CHECK dout1_10 vdout1_10ck79 = 0 time = 800
* CHECK dout1_11 vdout1_11ck79 = 1.7 time = 800
* CHECK dout1_12 vdout1_12ck79 = 1.7 time = 800
* CHECK dout1_13 vdout1_13ck79 = 1.7 time = 800
* CHECK dout1_14 vdout1_14ck79 = 0 time = 800
* CHECK dout1_15 vdout1_15ck79 = 1.7 time = 800
* CHECK dout1_16 vdout1_16ck79 = 0 time = 800
* CHECK dout1_0 vdout1_0ck81 = 0 time = 820
* CHECK dout1_1 vdout1_1ck81 = 1.7 time = 820
* CHECK dout1_2 vdout1_2ck81 = 0 time = 820
* CHECK dout1_3 vdout1_3ck81 = 1.7 time = 820
* CHECK dout1_4 vdout1_4ck81 = 1.7 time = 820
* CHECK dout1_5 vdout1_5ck81 = 0 time = 820
* CHECK dout1_6 vdout1_6ck81 = 0 time = 820
* CHECK dout1_7 vdout1_7ck81 = 1.7 time = 820
* CHECK dout1_8 vdout1_8ck81 = 1.7 time = 820
* CHECK dout1_9 vdout1_9ck81 = 1.7 time = 820
* CHECK dout1_10 vdout1_10ck81 = 1.7 time = 820
* CHECK dout1_11 vdout1_11ck81 = 0 time = 820
* CHECK dout1_12 vdout1_12ck81 = 1.7 time = 820
* CHECK dout1_13 vdout1_13ck81 = 1.7 time = 820
* CHECK dout1_14 vdout1_14ck81 = 0 time = 820
* CHECK dout1_15 vdout1_15ck81 = 1.7 time = 820
* CHECK dout1_16 vdout1_16ck81 = 0 time = 820
* CHECK dout1_0 vdout1_0ck85 = 1.7 time = 860
* CHECK dout1_1 vdout1_1ck85 = 0 time = 860
* CHECK dout1_2 vdout1_2ck85 = 0 time = 860
* CHECK dout1_3 vdout1_3ck85 = 0 time = 860
* CHECK dout1_4 vdout1_4ck85 = 0 time = 860
* CHECK dout1_5 vdout1_5ck85 = 1.7 time = 860
* CHECK dout1_6 vdout1_6ck85 = 0 time = 860
* CHECK dout1_7 vdout1_7ck85 = 0 time = 860
* CHECK dout1_8 vdout1_8ck85 = 1.7 time = 860
* CHECK dout1_9 vdout1_9ck85 = 1.7 time = 860
* CHECK dout1_10 vdout1_10ck85 = 0 time = 860
* CHECK dout1_11 vdout1_11ck85 = 1.7 time = 860
* CHECK dout1_12 vdout1_12ck85 = 1.7 time = 860
* CHECK dout1_13 vdout1_13ck85 = 1.7 time = 860
* CHECK dout1_14 vdout1_14ck85 = 0 time = 860
* CHECK dout1_15 vdout1_15ck85 = 1.7 time = 860
* CHECK dout1_16 vdout1_16ck85 = 0 time = 860
* CHECK dout1_0 vdout1_0ck87 = 1.7 time = 880
* CHECK dout1_1 vdout1_1ck87 = 0 time = 880
* CHECK dout1_2 vdout1_2ck87 = 0 time = 880
* CHECK dout1_3 vdout1_3ck87 = 1.7 time = 880
* CHECK dout1_4 vdout1_4ck87 = 1.7 time = 880
* CHECK dout1_5 vdout1_5ck87 = 1.7 time = 880
* CHECK dout1_6 vdout1_6ck87 = 0 time = 880
* CHECK dout1_7 vdout1_7ck87 = 0 time = 880
* CHECK dout1_8 vdout1_8ck87 = 1.7 time = 880
* CHECK dout1_9 vdout1_9ck87 = 0 time = 880
* CHECK dout1_10 vdout1_10ck87 = 1.7 time = 880
* CHECK dout1_11 vdout1_11ck87 = 0 time = 880
* CHECK dout1_12 vdout1_12ck87 = 0 time = 880
* CHECK dout1_13 vdout1_13ck87 = 1.7 time = 880
* CHECK dout1_14 vdout1_14ck87 = 0 time = 880
* CHECK dout1_15 vdout1_15ck87 = 0 time = 880
* CHECK dout1_16 vdout1_16ck87 = 0 time = 880
* CHECK dout1_0 vdout1_0ck89 = 1.7 time = 900
* CHECK dout1_1 vdout1_1ck89 = 0 time = 900
* CHECK dout1_2 vdout1_2ck89 = 0 time = 900
* CHECK dout1_3 vdout1_3ck89 = 1.7 time = 900
* CHECK dout1_4 vdout1_4ck89 = 1.7 time = 900
* CHECK dout1_5 vdout1_5ck89 = 1.7 time = 900
* CHECK dout1_6 vdout1_6ck89 = 0 time = 900
* CHECK dout1_7 vdout1_7ck89 = 0 time = 900
* CHECK dout1_8 vdout1_8ck89 = 1.7 time = 900
* CHECK dout1_9 vdout1_9ck89 = 0 time = 900
* CHECK dout1_10 vdout1_10ck89 = 1.7 time = 900
* CHECK dout1_11 vdout1_11ck89 = 0 time = 900
* CHECK dout1_12 vdout1_12ck89 = 0 time = 900
* CHECK dout1_13 vdout1_13ck89 = 1.7 time = 900
* CHECK dout1_14 vdout1_14ck89 = 0 time = 900
* CHECK dout1_15 vdout1_15ck89 = 0 time = 900
* CHECK dout1_16 vdout1_16ck89 = 0 time = 900
* CHECK dout1_0 vdout1_0ck93 = 0 time = 940
* CHECK dout1_1 vdout1_1ck93 = 0 time = 940
* CHECK dout1_2 vdout1_2ck93 = 1.7 time = 940
* CHECK dout1_3 vdout1_3ck93 = 1.7 time = 940
* CHECK dout1_4 vdout1_4ck93 = 0 time = 940
* CHECK dout1_5 vdout1_5ck93 = 1.7 time = 940
* CHECK dout1_6 vdout1_6ck93 = 0 time = 940
* CHECK dout1_7 vdout1_7ck93 = 0 time = 940
* CHECK dout1_8 vdout1_8ck93 = 1.7 time = 940
* CHECK dout1_9 vdout1_9ck93 = 1.7 time = 940
* CHECK dout1_10 vdout1_10ck93 = 1.7 time = 940
* CHECK dout1_11 vdout1_11ck93 = 0 time = 940
* CHECK dout1_12 vdout1_12ck93 = 0 time = 940
* CHECK dout1_13 vdout1_13ck93 = 1.7 time = 940
* CHECK dout1_14 vdout1_14ck93 = 1.7 time = 940
* CHECK dout1_15 vdout1_15ck93 = 0 time = 940
* CHECK dout1_16 vdout1_16ck93 = 0 time = 940
* CHECK dout1_0 vdout1_0ck97 = 1.7 time = 980
* CHECK dout1_1 vdout1_1ck97 = 0 time = 980
* CHECK dout1_2 vdout1_2ck97 = 0 time = 980
* CHECK dout1_3 vdout1_3ck97 = 1.7 time = 980
* CHECK dout1_4 vdout1_4ck97 = 1.7 time = 980
* CHECK dout1_5 vdout1_5ck97 = 0 time = 980
* CHECK dout1_6 vdout1_6ck97 = 1.7 time = 980
* CHECK dout1_7 vdout1_7ck97 = 1.7 time = 980
* CHECK dout1_8 vdout1_8ck97 = 1.7 time = 980
* CHECK dout1_9 vdout1_9ck97 = 1.7 time = 980
* CHECK dout1_10 vdout1_10ck97 = 0 time = 980
* CHECK dout1_11 vdout1_11ck97 = 1.7 time = 980
* CHECK dout1_12 vdout1_12ck97 = 1.7 time = 980
* CHECK dout1_13 vdout1_13ck97 = 0 time = 980
* CHECK dout1_14 vdout1_14ck97 = 0 time = 980
* CHECK dout1_15 vdout1_15ck97 = 1.7 time = 980
* CHECK dout1_16 vdout1_16ck97 = 0 time = 980
* CHECK dout1_0 vdout1_0ck105 = 0 time = 1060
* CHECK dout1_1 vdout1_1ck105 = 1.7 time = 1060
* CHECK dout1_2 vdout1_2ck105 = 0 time = 1060
* CHECK dout1_3 vdout1_3ck105 = 1.7 time = 1060
* CHECK dout1_4 vdout1_4ck105 = 0 time = 1060
* CHECK dout1_5 vdout1_5ck105 = 0 time = 1060
* CHECK dout1_6 vdout1_6ck105 = 0 time = 1060
* CHECK dout1_7 vdout1_7ck105 = 1.7 time = 1060
* CHECK dout1_8 vdout1_8ck105 = 0 time = 1060
* CHECK dout1_9 vdout1_9ck105 = 1.7 time = 1060
* CHECK dout1_10 vdout1_10ck105 = 0 time = 1060
* CHECK dout1_11 vdout1_11ck105 = 0 time = 1060
* CHECK dout1_12 vdout1_12ck105 = 0 time = 1060
* CHECK dout1_13 vdout1_13ck105 = 0 time = 1060
* CHECK dout1_14 vdout1_14ck105 = 0 time = 1060
* CHECK dout1_15 vdout1_15ck105 = 1.7 time = 1060
* CHECK dout1_16 vdout1_16ck105 = 0 time = 1060
* CHECK dout1_0 vdout1_0ck106 = 0 time = 1070
* CHECK dout1_1 vdout1_1ck106 = 0 time = 1070
* CHECK dout1_2 vdout1_2ck106 = 0 time = 1070
* CHECK dout1_3 vdout1_3ck106 = 0 time = 1070
* CHECK dout1_4 vdout1_4ck106 = 0 time = 1070
* CHECK dout1_5 vdout1_5ck106 = 0 time = 1070
* CHECK dout1_6 vdout1_6ck106 = 1.7 time = 1070
* CHECK dout1_7 vdout1_7ck106 = 0 time = 1070
* CHECK dout1_8 vdout1_8ck106 = 1.7 time = 1070
* CHECK dout1_9 vdout1_9ck106 = 0 time = 1070
* CHECK dout1_10 vdout1_10ck106 = 0 time = 1070
* CHECK dout1_11 vdout1_11ck106 = 0 time = 1070
* CHECK dout1_12 vdout1_12ck106 = 1.7 time = 1070
* CHECK dout1_13 vdout1_13ck106 = 0 time = 1070
* CHECK dout1_14 vdout1_14ck106 = 0 time = 1070
* CHECK dout1_15 vdout1_15ck106 = 1.7 time = 1070
* CHECK dout1_16 vdout1_16ck106 = 0 time = 1070
* CHECK dout1_0 vdout1_0ck108 = 0 time = 1090
* CHECK dout1_1 vdout1_1ck108 = 1.7 time = 1090
* CHECK dout1_2 vdout1_2ck108 = 0 time = 1090
* CHECK dout1_3 vdout1_3ck108 = 1.7 time = 1090
* CHECK dout1_4 vdout1_4ck108 = 1.7 time = 1090
* CHECK dout1_5 vdout1_5ck108 = 0 time = 1090
* CHECK dout1_6 vdout1_6ck108 = 0 time = 1090
* CHECK dout1_7 vdout1_7ck108 = 1.7 time = 1090
* CHECK dout1_8 vdout1_8ck108 = 0 time = 1090
* CHECK dout1_9 vdout1_9ck108 = 0 time = 1090
* CHECK dout1_10 vdout1_10ck108 = 1.7 time = 1090
* CHECK dout1_11 vdout1_11ck108 = 0 time = 1090
* CHECK dout1_12 vdout1_12ck108 = 1.7 time = 1090
* CHECK dout1_13 vdout1_13ck108 = 0 time = 1090
* CHECK dout1_14 vdout1_14ck108 = 1.7 time = 1090
* CHECK dout1_15 vdout1_15ck108 = 1.7 time = 1090
* CHECK dout1_16 vdout1_16ck108 = 0 time = 1090
* CHECK dout1_0 vdout1_0ck109 = 0 time = 1100
* CHECK dout1_1 vdout1_1ck109 = 0 time = 1100
* CHECK dout1_2 vdout1_2ck109 = 0 time = 1100
* CHECK dout1_3 vdout1_3ck109 = 0 time = 1100
* CHECK dout1_4 vdout1_4ck109 = 0 time = 1100
* CHECK dout1_5 vdout1_5ck109 = 0 time = 1100
* CHECK dout1_6 vdout1_6ck109 = 1.7 time = 1100
* CHECK dout1_7 vdout1_7ck109 = 0 time = 1100
* CHECK dout1_8 vdout1_8ck109 = 1.7 time = 1100
* CHECK dout1_9 vdout1_9ck109 = 0 time = 1100
* CHECK dout1_10 vdout1_10ck109 = 0 time = 1100
* CHECK dout1_11 vdout1_11ck109 = 0 time = 1100
* CHECK dout1_12 vdout1_12ck109 = 1.7 time = 1100
* CHECK dout1_13 vdout1_13ck109 = 0 time = 1100
* CHECK dout1_14 vdout1_14ck109 = 0 time = 1100
* CHECK dout1_15 vdout1_15ck109 = 1.7 time = 1100
* CHECK dout1_16 vdout1_16ck109 = 0 time = 1100
* CHECK dout1_0 vdout1_0ck110 = 0 time = 1110
* CHECK dout1_1 vdout1_1ck110 = 1.7 time = 1110
* CHECK dout1_2 vdout1_2ck110 = 1.7 time = 1110
* CHECK dout1_3 vdout1_3ck110 = 0 time = 1110
* CHECK dout1_4 vdout1_4ck110 = 0 time = 1110
* CHECK dout1_5 vdout1_5ck110 = 0 time = 1110
* CHECK dout1_6 vdout1_6ck110 = 0 time = 1110
* CHECK dout1_7 vdout1_7ck110 = 1.7 time = 1110
* CHECK dout1_8 vdout1_8ck110 = 1.7 time = 1110
* CHECK dout1_9 vdout1_9ck110 = 0 time = 1110
* CHECK dout1_10 vdout1_10ck110 = 1.7 time = 1110
* CHECK dout1_11 vdout1_11ck110 = 0 time = 1110
* CHECK dout1_12 vdout1_12ck110 = 1.7 time = 1110
* CHECK dout1_13 vdout1_13ck110 = 0 time = 1110
* CHECK dout1_14 vdout1_14ck110 = 1.7 time = 1110
* CHECK dout1_15 vdout1_15ck110 = 0 time = 1110
* CHECK dout1_16 vdout1_16ck110 = 0 time = 1110
* CHECK dout1_0 vdout1_0ck111 = 0 time = 1120
* CHECK dout1_1 vdout1_1ck111 = 1.7 time = 1120
* CHECK dout1_2 vdout1_2ck111 = 0 time = 1120
* CHECK dout1_3 vdout1_3ck111 = 1.7 time = 1120
* CHECK dout1_4 vdout1_4ck111 = 1.7 time = 1120
* CHECK dout1_5 vdout1_5ck111 = 0 time = 1120
* CHECK dout1_6 vdout1_6ck111 = 0 time = 1120
* CHECK dout1_7 vdout1_7ck111 = 1.7 time = 1120
* CHECK dout1_8 vdout1_8ck111 = 0 time = 1120
* CHECK dout1_9 vdout1_9ck111 = 0 time = 1120
* CHECK dout1_10 vdout1_10ck111 = 1.7 time = 1120
* CHECK dout1_11 vdout1_11ck111 = 0 time = 1120
* CHECK dout1_12 vdout1_12ck111 = 1.7 time = 1120
* CHECK dout1_13 vdout1_13ck111 = 0 time = 1120
* CHECK dout1_14 vdout1_14ck111 = 1.7 time = 1120
* CHECK dout1_15 vdout1_15ck111 = 1.7 time = 1120
* CHECK dout1_16 vdout1_16ck111 = 0 time = 1120
* CHECK dout1_0 vdout1_0ck113 = 0 time = 1140
* CHECK dout1_1 vdout1_1ck113 = 0 time = 1140
* CHECK dout1_2 vdout1_2ck113 = 0 time = 1140
* CHECK dout1_3 vdout1_3ck113 = 0 time = 1140
* CHECK dout1_4 vdout1_4ck113 = 0 time = 1140
* CHECK dout1_5 vdout1_5ck113 = 0 time = 1140
* CHECK dout1_6 vdout1_6ck113 = 1.7 time = 1140
* CHECK dout1_7 vdout1_7ck113 = 0 time = 1140
* CHECK dout1_8 vdout1_8ck113 = 1.7 time = 1140
* CHECK dout1_9 vdout1_9ck113 = 0 time = 1140
* CHECK dout1_10 vdout1_10ck113 = 0 time = 1140
* CHECK dout1_11 vdout1_11ck113 = 0 time = 1140
* CHECK dout1_12 vdout1_12ck113 = 1.7 time = 1140
* CHECK dout1_13 vdout1_13ck113 = 0 time = 1140
* CHECK dout1_14 vdout1_14ck113 = 0 time = 1140
* CHECK dout1_15 vdout1_15ck113 = 1.7 time = 1140
* CHECK dout1_16 vdout1_16ck113 = 0 time = 1140
* CHECK dout1_0 vdout1_0ck114 = 0 time = 1150
* CHECK dout1_1 vdout1_1ck114 = 1.7 time = 1150
* CHECK dout1_2 vdout1_2ck114 = 0 time = 1150
* CHECK dout1_3 vdout1_3ck114 = 1.7 time = 1150
* CHECK dout1_4 vdout1_4ck114 = 1.7 time = 1150
* CHECK dout1_5 vdout1_5ck114 = 0 time = 1150
* CHECK dout1_6 vdout1_6ck114 = 0 time = 1150
* CHECK dout1_7 vdout1_7ck114 = 1.7 time = 1150
* CHECK dout1_8 vdout1_8ck114 = 0 time = 1150
* CHECK dout1_9 vdout1_9ck114 = 0 time = 1150
* CHECK dout1_10 vdout1_10ck114 = 1.7 time = 1150
* CHECK dout1_11 vdout1_11ck114 = 0 time = 1150
* CHECK dout1_12 vdout1_12ck114 = 1.7 time = 1150
* CHECK dout1_13 vdout1_13ck114 = 0 time = 1150
* CHECK dout1_14 vdout1_14ck114 = 1.7 time = 1150
* CHECK dout1_15 vdout1_15ck114 = 1.7 time = 1150
* CHECK dout1_16 vdout1_16ck114 = 0 time = 1150
* CHECK dout1_0 vdout1_0ck118 = 0 time = 1190
* CHECK dout1_1 vdout1_1ck118 = 0 time = 1190
* CHECK dout1_2 vdout1_2ck118 = 1.7 time = 1190
* CHECK dout1_3 vdout1_3ck118 = 1.7 time = 1190
* CHECK dout1_4 vdout1_4ck118 = 0 time = 1190
* CHECK dout1_5 vdout1_5ck118 = 1.7 time = 1190
* CHECK dout1_6 vdout1_6ck118 = 0 time = 1190
* CHECK dout1_7 vdout1_7ck118 = 0 time = 1190
* CHECK dout1_8 vdout1_8ck118 = 1.7 time = 1190
* CHECK dout1_9 vdout1_9ck118 = 1.7 time = 1190
* CHECK dout1_10 vdout1_10ck118 = 1.7 time = 1190
* CHECK dout1_11 vdout1_11ck118 = 1.7 time = 1190
* CHECK dout1_12 vdout1_12ck118 = 1.7 time = 1190
* CHECK dout1_13 vdout1_13ck118 = 0 time = 1190
* CHECK dout1_14 vdout1_14ck118 = 1.7 time = 1190
* CHECK dout1_15 vdout1_15ck118 = 0 time = 1190
* CHECK dout1_16 vdout1_16ck118 = 0 time = 1190
* CHECK dout1_0 vdout1_0ck119 = 0 time = 1200
* CHECK dout1_1 vdout1_1ck119 = 0 time = 1200
* CHECK dout1_2 vdout1_2ck119 = 1.7 time = 1200
* CHECK dout1_3 vdout1_3ck119 = 1.7 time = 1200
* CHECK dout1_4 vdout1_4ck119 = 0 time = 1200
* CHECK dout1_5 vdout1_5ck119 = 1.7 time = 1200
* CHECK dout1_6 vdout1_6ck119 = 0 time = 1200
* CHECK dout1_7 vdout1_7ck119 = 0 time = 1200
* CHECK dout1_8 vdout1_8ck119 = 1.7 time = 1200
* CHECK dout1_9 vdout1_9ck119 = 1.7 time = 1200
* CHECK dout1_10 vdout1_10ck119 = 1.7 time = 1200
* CHECK dout1_11 vdout1_11ck119 = 1.7 time = 1200
* CHECK dout1_12 vdout1_12ck119 = 1.7 time = 1200
* CHECK dout1_13 vdout1_13ck119 = 0 time = 1200
* CHECK dout1_14 vdout1_14ck119 = 1.7 time = 1200
* CHECK dout1_15 vdout1_15ck119 = 0 time = 1200
* CHECK dout1_16 vdout1_16ck119 = 0 time = 1200
* CHECK dout1_0 vdout1_0ck120 = 0 time = 1210
* CHECK dout1_1 vdout1_1ck120 = 1.7 time = 1210
* CHECK dout1_2 vdout1_2ck120 = 0 time = 1210
* CHECK dout1_3 vdout1_3ck120 = 1.7 time = 1210
* CHECK dout1_4 vdout1_4ck120 = 0 time = 1210
* CHECK dout1_5 vdout1_5ck120 = 0 time = 1210
* CHECK dout1_6 vdout1_6ck120 = 0 time = 1210
* CHECK dout1_7 vdout1_7ck120 = 1.7 time = 1210
* CHECK dout1_8 vdout1_8ck120 = 1.7 time = 1210
* CHECK dout1_9 vdout1_9ck120 = 0 time = 1210
* CHECK dout1_10 vdout1_10ck120 = 1.7 time = 1210
* CHECK dout1_11 vdout1_11ck120 = 1.7 time = 1210
* CHECK dout1_12 vdout1_12ck120 = 0 time = 1210
* CHECK dout1_13 vdout1_13ck120 = 1.7 time = 1210
* CHECK dout1_14 vdout1_14ck120 = 1.7 time = 1210
* CHECK dout1_15 vdout1_15ck120 = 1.7 time = 1210
* CHECK dout1_16 vdout1_16ck120 = 0 time = 1210
* CHECK dout1_0 vdout1_0ck122 = 0 time = 1230
* CHECK dout1_1 vdout1_1ck122 = 1.7 time = 1230
* CHECK dout1_2 vdout1_2ck122 = 1.7 time = 1230
* CHECK dout1_3 vdout1_3ck122 = 0 time = 1230
* CHECK dout1_4 vdout1_4ck122 = 0 time = 1230
* CHECK dout1_5 vdout1_5ck122 = 0 time = 1230
* CHECK dout1_6 vdout1_6ck122 = 0 time = 1230
* CHECK dout1_7 vdout1_7ck122 = 1.7 time = 1230
* CHECK dout1_8 vdout1_8ck122 = 1.7 time = 1230
* CHECK dout1_9 vdout1_9ck122 = 0 time = 1230
* CHECK dout1_10 vdout1_10ck122 = 1.7 time = 1230
* CHECK dout1_11 vdout1_11ck122 = 0 time = 1230
* CHECK dout1_12 vdout1_12ck122 = 1.7 time = 1230
* CHECK dout1_13 vdout1_13ck122 = 0 time = 1230
* CHECK dout1_14 vdout1_14ck122 = 1.7 time = 1230
* CHECK dout1_15 vdout1_15ck122 = 0 time = 1230
* CHECK dout1_16 vdout1_16ck122 = 0 time = 1230
* CHECK dout1_0 vdout1_0ck123 = 0 time = 1240
* CHECK dout1_1 vdout1_1ck123 = 1.7 time = 1240
* CHECK dout1_2 vdout1_2ck123 = 0 time = 1240
* CHECK dout1_3 vdout1_3ck123 = 1.7 time = 1240
* CHECK dout1_4 vdout1_4ck123 = 0 time = 1240
* CHECK dout1_5 vdout1_5ck123 = 0 time = 1240
* CHECK dout1_6 vdout1_6ck123 = 0 time = 1240
* CHECK dout1_7 vdout1_7ck123 = 1.7 time = 1240
* CHECK dout1_8 vdout1_8ck123 = 1.7 time = 1240
* CHECK dout1_9 vdout1_9ck123 = 0 time = 1240
* CHECK dout1_10 vdout1_10ck123 = 1.7 time = 1240
* CHECK dout1_11 vdout1_11ck123 = 1.7 time = 1240
* CHECK dout1_12 vdout1_12ck123 = 0 time = 1240
* CHECK dout1_13 vdout1_13ck123 = 1.7 time = 1240
* CHECK dout1_14 vdout1_14ck123 = 1.7 time = 1240
* CHECK dout1_15 vdout1_15ck123 = 1.7 time = 1240
* CHECK dout1_16 vdout1_16ck123 = 0 time = 1240
* CHECK dout1_0 vdout1_0ck126 = 0 time = 1270
* CHECK dout1_1 vdout1_1ck126 = 1.7 time = 1270
* CHECK dout1_2 vdout1_2ck126 = 1.7 time = 1270
* CHECK dout1_3 vdout1_3ck126 = 0 time = 1270
* CHECK dout1_4 vdout1_4ck126 = 0 time = 1270
* CHECK dout1_5 vdout1_5ck126 = 0 time = 1270
* CHECK dout1_6 vdout1_6ck126 = 0 time = 1270
* CHECK dout1_7 vdout1_7ck126 = 1.7 time = 1270
* CHECK dout1_8 vdout1_8ck126 = 1.7 time = 1270
* CHECK dout1_9 vdout1_9ck126 = 0 time = 1270
* CHECK dout1_10 vdout1_10ck126 = 1.7 time = 1270
* CHECK dout1_11 vdout1_11ck126 = 0 time = 1270
* CHECK dout1_12 vdout1_12ck126 = 1.7 time = 1270
* CHECK dout1_13 vdout1_13ck126 = 0 time = 1270
* CHECK dout1_14 vdout1_14ck126 = 1.7 time = 1270
* CHECK dout1_15 vdout1_15ck126 = 0 time = 1270
* CHECK dout1_16 vdout1_16ck126 = 0 time = 1270
* CHECK dout1_0 vdout1_0ck133 = 0 time = 1340
* CHECK dout1_1 vdout1_1ck133 = 1.7 time = 1340
* CHECK dout1_2 vdout1_2ck133 = 0 time = 1340
* CHECK dout1_3 vdout1_3ck133 = 1.7 time = 1340
* CHECK dout1_4 vdout1_4ck133 = 0 time = 1340
* CHECK dout1_5 vdout1_5ck133 = 0 time = 1340
* CHECK dout1_6 vdout1_6ck133 = 0 time = 1340
* CHECK dout1_7 vdout1_7ck133 = 1.7 time = 1340
* CHECK dout1_8 vdout1_8ck133 = 1.7 time = 1340
* CHECK dout1_9 vdout1_9ck133 = 0 time = 1340
* CHECK dout1_10 vdout1_10ck133 = 1.7 time = 1340
* CHECK dout1_11 vdout1_11ck133 = 1.7 time = 1340
* CHECK dout1_12 vdout1_12ck133 = 0 time = 1340
* CHECK dout1_13 vdout1_13ck133 = 1.7 time = 1340
* CHECK dout1_14 vdout1_14ck133 = 1.7 time = 1340
* CHECK dout1_15 vdout1_15ck133 = 1.7 time = 1340
* CHECK dout1_16 vdout1_16ck133 = 0 time = 1340
* CHECK dout1_0 vdout1_0ck139 = 1.7 time = 1400
* CHECK dout1_1 vdout1_1ck139 = 1.7 time = 1400
* CHECK dout1_2 vdout1_2ck139 = 1.7 time = 1400
* CHECK dout1_3 vdout1_3ck139 = 1.7 time = 1400
* CHECK dout1_4 vdout1_4ck139 = 1.7 time = 1400
* CHECK dout1_5 vdout1_5ck139 = 1.7 time = 1400
* CHECK dout1_6 vdout1_6ck139 = 1.7 time = 1400
* CHECK dout1_7 vdout1_7ck139 = 1.7 time = 1400
* CHECK dout1_8 vdout1_8ck139 = 0 time = 1400
* CHECK dout1_9 vdout1_9ck139 = 1.7 time = 1400
* CHECK dout1_10 vdout1_10ck139 = 1.7 time = 1400
* CHECK dout1_11 vdout1_11ck139 = 1.7 time = 1400
* CHECK dout1_12 vdout1_12ck139 = 1.7 time = 1400
* CHECK dout1_13 vdout1_13ck139 = 0 time = 1400
* CHECK dout1_14 vdout1_14ck139 = 1.7 time = 1400
* CHECK dout1_15 vdout1_15ck139 = 0 time = 1400
* CHECK dout1_16 vdout1_16ck139 = 0 time = 1400
* CHECK dout1_0 vdout1_0ck142 = 1.7 time = 1430
* CHECK dout1_1 vdout1_1ck142 = 1.7 time = 1430
* CHECK dout1_2 vdout1_2ck142 = 0 time = 1430
* CHECK dout1_3 vdout1_3ck142 = 0 time = 1430
* CHECK dout1_4 vdout1_4ck142 = 1.7 time = 1430
* CHECK dout1_5 vdout1_5ck142 = 1.7 time = 1430
* CHECK dout1_6 vdout1_6ck142 = 0 time = 1430
* CHECK dout1_7 vdout1_7ck142 = 1.7 time = 1430
* CHECK dout1_8 vdout1_8ck142 = 0 time = 1430
* CHECK dout1_9 vdout1_9ck142 = 0 time = 1430
* CHECK dout1_10 vdout1_10ck142 = 0 time = 1430
* CHECK dout1_11 vdout1_11ck142 = 0 time = 1430
* CHECK dout1_12 vdout1_12ck142 = 1.7 time = 1430
* CHECK dout1_13 vdout1_13ck142 = 0 time = 1430
* CHECK dout1_14 vdout1_14ck142 = 0 time = 1430
* CHECK dout1_15 vdout1_15ck142 = 0 time = 1430
* CHECK dout1_16 vdout1_16ck142 = 0 time = 1430
* CHECK dout1_0 vdout1_0ck144 = 1.7 time = 1450
* CHECK dout1_1 vdout1_1ck144 = 1.7 time = 1450
* CHECK dout1_2 vdout1_2ck144 = 1.7 time = 1450
* CHECK dout1_3 vdout1_3ck144 = 1.7 time = 1450
* CHECK dout1_4 vdout1_4ck144 = 1.7 time = 1450
* CHECK dout1_5 vdout1_5ck144 = 1.7 time = 1450
* CHECK dout1_6 vdout1_6ck144 = 1.7 time = 1450
* CHECK dout1_7 vdout1_7ck144 = 1.7 time = 1450
* CHECK dout1_8 vdout1_8ck144 = 0 time = 1450
* CHECK dout1_9 vdout1_9ck144 = 1.7 time = 1450
* CHECK dout1_10 vdout1_10ck144 = 1.7 time = 1450
* CHECK dout1_11 vdout1_11ck144 = 1.7 time = 1450
* CHECK dout1_12 vdout1_12ck144 = 1.7 time = 1450
* CHECK dout1_13 vdout1_13ck144 = 0 time = 1450
* CHECK dout1_14 vdout1_14ck144 = 1.7 time = 1450
* CHECK dout1_15 vdout1_15ck144 = 0 time = 1450
* CHECK dout1_16 vdout1_16ck144 = 0 time = 1450
* CHECK dout1_0 vdout1_0ck145 = 1.7 time = 1460
* CHECK dout1_1 vdout1_1ck145 = 1.7 time = 1460
* CHECK dout1_2 vdout1_2ck145 = 1.7 time = 1460
* CHECK dout1_3 vdout1_3ck145 = 1.7 time = 1460
* CHECK dout1_4 vdout1_4ck145 = 1.7 time = 1460
* CHECK dout1_5 vdout1_5ck145 = 1.7 time = 1460
* CHECK dout1_6 vdout1_6ck145 = 1.7 time = 1460
* CHECK dout1_7 vdout1_7ck145 = 1.7 time = 1460
* CHECK dout1_8 vdout1_8ck145 = 0 time = 1460
* CHECK dout1_9 vdout1_9ck145 = 1.7 time = 1460
* CHECK dout1_10 vdout1_10ck145 = 1.7 time = 1460
* CHECK dout1_11 vdout1_11ck145 = 1.7 time = 1460
* CHECK dout1_12 vdout1_12ck145 = 1.7 time = 1460
* CHECK dout1_13 vdout1_13ck145 = 0 time = 1460
* CHECK dout1_14 vdout1_14ck145 = 1.7 time = 1460
* CHECK dout1_15 vdout1_15ck145 = 0 time = 1460
* CHECK dout1_16 vdout1_16ck145 = 0 time = 1460
* CHECK dout1_0 vdout1_0ck148 = 0 time = 1490
* CHECK dout1_1 vdout1_1ck148 = 1.7 time = 1490
* CHECK dout1_2 vdout1_2ck148 = 0 time = 1490
* CHECK dout1_3 vdout1_3ck148 = 1.7 time = 1490
* CHECK dout1_4 vdout1_4ck148 = 0 time = 1490
* CHECK dout1_5 vdout1_5ck148 = 1.7 time = 1490
* CHECK dout1_6 vdout1_6ck148 = 1.7 time = 1490
* CHECK dout1_7 vdout1_7ck148 = 0 time = 1490
* CHECK dout1_8 vdout1_8ck148 = 1.7 time = 1490
* CHECK dout1_9 vdout1_9ck148 = 1.7 time = 1490
* CHECK dout1_10 vdout1_10ck148 = 1.7 time = 1490
* CHECK dout1_11 vdout1_11ck148 = 0 time = 1490
* CHECK dout1_12 vdout1_12ck148 = 1.7 time = 1490
* CHECK dout1_13 vdout1_13ck148 = 1.7 time = 1490
* CHECK dout1_14 vdout1_14ck148 = 0 time = 1490
* CHECK dout1_15 vdout1_15ck148 = 0 time = 1490
* CHECK dout1_16 vdout1_16ck148 = 0 time = 1490
* CHECK dout1_0 vdout1_0ck150 = 1.7 time = 1510
* CHECK dout1_1 vdout1_1ck150 = 1.7 time = 1510
* CHECK dout1_2 vdout1_2ck150 = 1.7 time = 1510
* CHECK dout1_3 vdout1_3ck150 = 1.7 time = 1510
* CHECK dout1_4 vdout1_4ck150 = 1.7 time = 1510
* CHECK dout1_5 vdout1_5ck150 = 1.7 time = 1510
* CHECK dout1_6 vdout1_6ck150 = 1.7 time = 1510
* CHECK dout1_7 vdout1_7ck150 = 1.7 time = 1510
* CHECK dout1_8 vdout1_8ck150 = 0 time = 1510
* CHECK dout1_9 vdout1_9ck150 = 1.7 time = 1510
* CHECK dout1_10 vdout1_10ck150 = 1.7 time = 1510
* CHECK dout1_11 vdout1_11ck150 = 1.7 time = 1510
* CHECK dout1_12 vdout1_12ck150 = 1.7 time = 1510
* CHECK dout1_13 vdout1_13ck150 = 0 time = 1510
* CHECK dout1_14 vdout1_14ck150 = 1.7 time = 1510
* CHECK dout1_15 vdout1_15ck150 = 0 time = 1510
* CHECK dout1_16 vdout1_16ck150 = 0 time = 1510
* CHECK dout1_0 vdout1_0ck151 = 0 time = 1520
* CHECK dout1_1 vdout1_1ck151 = 1.7 time = 1520
* CHECK dout1_2 vdout1_2ck151 = 0 time = 1520
* CHECK dout1_3 vdout1_3ck151 = 1.7 time = 1520
* CHECK dout1_4 vdout1_4ck151 = 0 time = 1520
* CHECK dout1_5 vdout1_5ck151 = 1.7 time = 1520
* CHECK dout1_6 vdout1_6ck151 = 1.7 time = 1520
* CHECK dout1_7 vdout1_7ck151 = 0 time = 1520
* CHECK dout1_8 vdout1_8ck151 = 1.7 time = 1520
* CHECK dout1_9 vdout1_9ck151 = 1.7 time = 1520
* CHECK dout1_10 vdout1_10ck151 = 1.7 time = 1520
* CHECK dout1_11 vdout1_11ck151 = 0 time = 1520
* CHECK dout1_12 vdout1_12ck151 = 1.7 time = 1520
* CHECK dout1_13 vdout1_13ck151 = 1.7 time = 1520
* CHECK dout1_14 vdout1_14ck151 = 0 time = 1520
* CHECK dout1_15 vdout1_15ck151 = 0 time = 1520
* CHECK dout1_16 vdout1_16ck151 = 0 time = 1520
* CHECK dout1_0 vdout1_0ck154 = 0 time = 1550
* CHECK dout1_1 vdout1_1ck154 = 0 time = 1550
* CHECK dout1_2 vdout1_2ck154 = 1.7 time = 1550
* CHECK dout1_3 vdout1_3ck154 = 0 time = 1550
* CHECK dout1_4 vdout1_4ck154 = 1.7 time = 1550
* CHECK dout1_5 vdout1_5ck154 = 1.7 time = 1550
* CHECK dout1_6 vdout1_6ck154 = 1.7 time = 1550
* CHECK dout1_7 vdout1_7ck154 = 0 time = 1550
* CHECK dout1_8 vdout1_8ck154 = 0 time = 1550
* CHECK dout1_9 vdout1_9ck154 = 1.7 time = 1550
* CHECK dout1_10 vdout1_10ck154 = 1.7 time = 1550
* CHECK dout1_11 vdout1_11ck154 = 0 time = 1550
* CHECK dout1_12 vdout1_12ck154 = 1.7 time = 1550
* CHECK dout1_13 vdout1_13ck154 = 1.7 time = 1550
* CHECK dout1_14 vdout1_14ck154 = 0 time = 1550
* CHECK dout1_15 vdout1_15ck154 = 1.7 time = 1550
* CHECK dout1_16 vdout1_16ck154 = 0 time = 1550
* CHECK dout1_0 vdout1_0ck156 = 0 time = 1570
* CHECK dout1_1 vdout1_1ck156 = 0 time = 1570
* CHECK dout1_2 vdout1_2ck156 = 1.7 time = 1570
* CHECK dout1_3 vdout1_3ck156 = 1.7 time = 1570
* CHECK dout1_4 vdout1_4ck156 = 0 time = 1570
* CHECK dout1_5 vdout1_5ck156 = 1.7 time = 1570
* CHECK dout1_6 vdout1_6ck156 = 1.7 time = 1570
* CHECK dout1_7 vdout1_7ck156 = 1.7 time = 1570
* CHECK dout1_8 vdout1_8ck156 = 0 time = 1570
* CHECK dout1_9 vdout1_9ck156 = 1.7 time = 1570
* CHECK dout1_10 vdout1_10ck156 = 1.7 time = 1570
* CHECK dout1_11 vdout1_11ck156 = 0 time = 1570
* CHECK dout1_12 vdout1_12ck156 = 1.7 time = 1570
* CHECK dout1_13 vdout1_13ck156 = 0 time = 1570
* CHECK dout1_14 vdout1_14ck156 = 1.7 time = 1570
* CHECK dout1_15 vdout1_15ck156 = 0 time = 1570
* CHECK dout1_16 vdout1_16ck156 = 0 time = 1570
* CHECK dout1_0 vdout1_0ck158 = 0 time = 1590
* CHECK dout1_1 vdout1_1ck158 = 1.7 time = 1590
* CHECK dout1_2 vdout1_2ck158 = 1.7 time = 1590
* CHECK dout1_3 vdout1_3ck158 = 1.7 time = 1590
* CHECK dout1_4 vdout1_4ck158 = 1.7 time = 1590
* CHECK dout1_5 vdout1_5ck158 = 0 time = 1590
* CHECK dout1_6 vdout1_6ck158 = 1.7 time = 1590
* CHECK dout1_7 vdout1_7ck158 = 0 time = 1590
* CHECK dout1_8 vdout1_8ck158 = 0 time = 1590
* CHECK dout1_9 vdout1_9ck158 = 0 time = 1590
* CHECK dout1_10 vdout1_10ck158 = 1.7 time = 1590
* CHECK dout1_11 vdout1_11ck158 = 0 time = 1590
* CHECK dout1_12 vdout1_12ck158 = 1.7 time = 1590
* CHECK dout1_13 vdout1_13ck158 = 0 time = 1590
* CHECK dout1_14 vdout1_14ck158 = 1.7 time = 1590
* CHECK dout1_15 vdout1_15ck158 = 0 time = 1590
* CHECK dout1_16 vdout1_16ck158 = 0 time = 1590
* CHECK dout1_0 vdout1_0ck162 = 1.7 time = 1630
* CHECK dout1_1 vdout1_1ck162 = 0 time = 1630
* CHECK dout1_2 vdout1_2ck162 = 0 time = 1630
* CHECK dout1_3 vdout1_3ck162 = 1.7 time = 1630
* CHECK dout1_4 vdout1_4ck162 = 0 time = 1630
* CHECK dout1_5 vdout1_5ck162 = 0 time = 1630
* CHECK dout1_6 vdout1_6ck162 = 1.7 time = 1630
* CHECK dout1_7 vdout1_7ck162 = 0 time = 1630
* CHECK dout1_8 vdout1_8ck162 = 0 time = 1630
* CHECK dout1_9 vdout1_9ck162 = 0 time = 1630
* CHECK dout1_10 vdout1_10ck162 = 0 time = 1630
* CHECK dout1_11 vdout1_11ck162 = 1.7 time = 1630
* CHECK dout1_12 vdout1_12ck162 = 0 time = 1630
* CHECK dout1_13 vdout1_13ck162 = 1.7 time = 1630
* CHECK dout1_14 vdout1_14ck162 = 1.7 time = 1630
* CHECK dout1_15 vdout1_15ck162 = 0 time = 1630
* CHECK dout1_16 vdout1_16ck162 = 0 time = 1630
* CHECK dout1_0 vdout1_0ck166 = 1.7 time = 1670
* CHECK dout1_1 vdout1_1ck166 = 0 time = 1670
* CHECK dout1_2 vdout1_2ck166 = 0 time = 1670
* CHECK dout1_3 vdout1_3ck166 = 1.7 time = 1670
* CHECK dout1_4 vdout1_4ck166 = 0 time = 1670
* CHECK dout1_5 vdout1_5ck166 = 0 time = 1670
* CHECK dout1_6 vdout1_6ck166 = 1.7 time = 1670
* CHECK dout1_7 vdout1_7ck166 = 0 time = 1670
* CHECK dout1_8 vdout1_8ck166 = 0 time = 1670
* CHECK dout1_9 vdout1_9ck166 = 0 time = 1670
* CHECK dout1_10 vdout1_10ck166 = 0 time = 1670
* CHECK dout1_11 vdout1_11ck166 = 1.7 time = 1670
* CHECK dout1_12 vdout1_12ck166 = 0 time = 1670
* CHECK dout1_13 vdout1_13ck166 = 1.7 time = 1670
* CHECK dout1_14 vdout1_14ck166 = 1.7 time = 1670
* CHECK dout1_15 vdout1_15ck166 = 0 time = 1670
* CHECK dout1_16 vdout1_16ck166 = 0 time = 1670
* CHECK dout1_0 vdout1_0ck168 = 1.7 time = 1690
* CHECK dout1_1 vdout1_1ck168 = 0 time = 1690
* CHECK dout1_2 vdout1_2ck168 = 0 time = 1690
* CHECK dout1_3 vdout1_3ck168 = 1.7 time = 1690
* CHECK dout1_4 vdout1_4ck168 = 0 time = 1690
* CHECK dout1_5 vdout1_5ck168 = 0 time = 1690
* CHECK dout1_6 vdout1_6ck168 = 1.7 time = 1690
* CHECK dout1_7 vdout1_7ck168 = 0 time = 1690
* CHECK dout1_8 vdout1_8ck168 = 0 time = 1690
* CHECK dout1_9 vdout1_9ck168 = 0 time = 1690
* CHECK dout1_10 vdout1_10ck168 = 0 time = 1690
* CHECK dout1_11 vdout1_11ck168 = 1.7 time = 1690
* CHECK dout1_12 vdout1_12ck168 = 0 time = 1690
* CHECK dout1_13 vdout1_13ck168 = 1.7 time = 1690
* CHECK dout1_14 vdout1_14ck168 = 1.7 time = 1690
* CHECK dout1_15 vdout1_15ck168 = 0 time = 1690
* CHECK dout1_16 vdout1_16ck168 = 0 time = 1690
* CHECK dout1_0 vdout1_0ck173 = 0 time = 1740
* CHECK dout1_1 vdout1_1ck173 = 1.7 time = 1740
* CHECK dout1_2 vdout1_2ck173 = 0 time = 1740
* CHECK dout1_3 vdout1_3ck173 = 1.7 time = 1740
* CHECK dout1_4 vdout1_4ck173 = 1.7 time = 1740
* CHECK dout1_5 vdout1_5ck173 = 1.7 time = 1740
* CHECK dout1_6 vdout1_6ck173 = 0 time = 1740
* CHECK dout1_7 vdout1_7ck173 = 0 time = 1740
* CHECK dout1_8 vdout1_8ck173 = 0 time = 1740
* CHECK dout1_9 vdout1_9ck173 = 1.7 time = 1740
* CHECK dout1_10 vdout1_10ck173 = 0 time = 1740
* CHECK dout1_11 vdout1_11ck173 = 1.7 time = 1740
* CHECK dout1_12 vdout1_12ck173 = 1.7 time = 1740
* CHECK dout1_13 vdout1_13ck173 = 1.7 time = 1740
* CHECK dout1_14 vdout1_14ck173 = 0 time = 1740
* CHECK dout1_15 vdout1_15ck173 = 1.7 time = 1740
* CHECK dout1_16 vdout1_16ck173 = 0 time = 1740
* CHECK dout1_0 vdout1_0ck174 = 0 time = 1750
* CHECK dout1_1 vdout1_1ck174 = 0 time = 1750
* CHECK dout1_2 vdout1_2ck174 = 1.7 time = 1750
* CHECK dout1_3 vdout1_3ck174 = 1.7 time = 1750
* CHECK dout1_4 vdout1_4ck174 = 1.7 time = 1750
* CHECK dout1_5 vdout1_5ck174 = 0 time = 1750
* CHECK dout1_6 vdout1_6ck174 = 1.7 time = 1750
* CHECK dout1_7 vdout1_7ck174 = 0 time = 1750
* CHECK dout1_8 vdout1_8ck174 = 0 time = 1750
* CHECK dout1_9 vdout1_9ck174 = 0 time = 1750
* CHECK dout1_10 vdout1_10ck174 = 1.7 time = 1750
* CHECK dout1_11 vdout1_11ck174 = 0 time = 1750
* CHECK dout1_12 vdout1_12ck174 = 1.7 time = 1750
* CHECK dout1_13 vdout1_13ck174 = 0 time = 1750
* CHECK dout1_14 vdout1_14ck174 = 1.7 time = 1750
* CHECK dout1_15 vdout1_15ck174 = 0 time = 1750
* CHECK dout1_16 vdout1_16ck174 = 0 time = 1750
* CHECK dout1_0 vdout1_0ck179 = 0 time = 1800
* CHECK dout1_1 vdout1_1ck179 = 1.7 time = 1800
* CHECK dout1_2 vdout1_2ck179 = 1.7 time = 1800
* CHECK dout1_3 vdout1_3ck179 = 1.7 time = 1800
* CHECK dout1_4 vdout1_4ck179 = 1.7 time = 1800
* CHECK dout1_5 vdout1_5ck179 = 0 time = 1800
* CHECK dout1_6 vdout1_6ck179 = 0 time = 1800
* CHECK dout1_7 vdout1_7ck179 = 1.7 time = 1800
* CHECK dout1_8 vdout1_8ck179 = 0 time = 1800
* CHECK dout1_9 vdout1_9ck179 = 1.7 time = 1800
* CHECK dout1_10 vdout1_10ck179 = 0 time = 1800
* CHECK dout1_11 vdout1_11ck179 = 1.7 time = 1800
* CHECK dout1_12 vdout1_12ck179 = 1.7 time = 1800
* CHECK dout1_13 vdout1_13ck179 = 0 time = 1800
* CHECK dout1_14 vdout1_14ck179 = 1.7 time = 1800
* CHECK dout1_15 vdout1_15ck179 = 0 time = 1800
* CHECK dout1_16 vdout1_16ck179 = 0 time = 1800
* CHECK dout1_0 vdout1_0ck183 = 1.7 time = 1840
* CHECK dout1_1 vdout1_1ck183 = 1.7 time = 1840
* CHECK dout1_2 vdout1_2ck183 = 1.7 time = 1840
* CHECK dout1_3 vdout1_3ck183 = 0 time = 1840
* CHECK dout1_4 vdout1_4ck183 = 0 time = 1840
* CHECK dout1_5 vdout1_5ck183 = 0 time = 1840
* CHECK dout1_6 vdout1_6ck183 = 0 time = 1840
* CHECK dout1_7 vdout1_7ck183 = 0 time = 1840
* CHECK dout1_8 vdout1_8ck183 = 1.7 time = 1840
* CHECK dout1_9 vdout1_9ck183 = 1.7 time = 1840
* CHECK dout1_10 vdout1_10ck183 = 0 time = 1840
* CHECK dout1_11 vdout1_11ck183 = 0 time = 1840
* CHECK dout1_12 vdout1_12ck183 = 0 time = 1840
* CHECK dout1_13 vdout1_13ck183 = 1.7 time = 1840
* CHECK dout1_14 vdout1_14ck183 = 1.7 time = 1840
* CHECK dout1_15 vdout1_15ck183 = 0 time = 1840
* CHECK dout1_16 vdout1_16ck183 = 0 time = 1840
* CHECK dout1_0 vdout1_0ck186 = 0 time = 1870
* CHECK dout1_1 vdout1_1ck186 = 1.7 time = 1870
* CHECK dout1_2 vdout1_2ck186 = 1.7 time = 1870
* CHECK dout1_3 vdout1_3ck186 = 1.7 time = 1870
* CHECK dout1_4 vdout1_4ck186 = 0 time = 1870
* CHECK dout1_5 vdout1_5ck186 = 0 time = 1870
* CHECK dout1_6 vdout1_6ck186 = 1.7 time = 1870
* CHECK dout1_7 vdout1_7ck186 = 1.7 time = 1870
* CHECK dout1_8 vdout1_8ck186 = 1.7 time = 1870
* CHECK dout1_9 vdout1_9ck186 = 1.7 time = 1870
* CHECK dout1_10 vdout1_10ck186 = 1.7 time = 1870
* CHECK dout1_11 vdout1_11ck186 = 1.7 time = 1870
* CHECK dout1_12 vdout1_12ck186 = 0 time = 1870
* CHECK dout1_13 vdout1_13ck186 = 0 time = 1870
* CHECK dout1_14 vdout1_14ck186 = 1.7 time = 1870
* CHECK dout1_15 vdout1_15ck186 = 1.7 time = 1870
* CHECK dout1_16 vdout1_16ck186 = 0 time = 1870
* CHECK dout1_0 vdout1_0ck195 = 0 time = 1960
* CHECK dout1_1 vdout1_1ck195 = 0 time = 1960
* CHECK dout1_2 vdout1_2ck195 = 1.7 time = 1960
* CHECK dout1_3 vdout1_3ck195 = 0 time = 1960
* CHECK dout1_4 vdout1_4ck195 = 0 time = 1960
* CHECK dout1_5 vdout1_5ck195 = 1.7 time = 1960
* CHECK dout1_6 vdout1_6ck195 = 1.7 time = 1960
* CHECK dout1_7 vdout1_7ck195 = 0 time = 1960
* CHECK dout1_8 vdout1_8ck195 = 1.7 time = 1960
* CHECK dout1_9 vdout1_9ck195 = 1.7 time = 1960
* CHECK dout1_10 vdout1_10ck195 = 1.7 time = 1960
* CHECK dout1_11 vdout1_11ck195 = 0 time = 1960
* CHECK dout1_12 vdout1_12ck195 = 0 time = 1960
* CHECK dout1_13 vdout1_13ck195 = 0 time = 1960
* CHECK dout1_14 vdout1_14ck195 = 0 time = 1960
* CHECK dout1_15 vdout1_15ck195 = 0 time = 1960
* CHECK dout1_16 vdout1_16ck195 = 0 time = 1960
* CHECK dout1_0 vdout1_0ck197 = 1.7 time = 1980
* CHECK dout1_1 vdout1_1ck197 = 0 time = 1980
* CHECK dout1_2 vdout1_2ck197 = 0 time = 1980
* CHECK dout1_3 vdout1_3ck197 = 0 time = 1980
* CHECK dout1_4 vdout1_4ck197 = 1.7 time = 1980
* CHECK dout1_5 vdout1_5ck197 = 1.7 time = 1980
* CHECK dout1_6 vdout1_6ck197 = 0 time = 1980
* CHECK dout1_7 vdout1_7ck197 = 0 time = 1980
* CHECK dout1_8 vdout1_8ck197 = 1.7 time = 1980
* CHECK dout1_9 vdout1_9ck197 = 1.7 time = 1980
* CHECK dout1_10 vdout1_10ck197 = 0 time = 1980
* CHECK dout1_11 vdout1_11ck197 = 1.7 time = 1980
* CHECK dout1_12 vdout1_12ck197 = 0 time = 1980
* CHECK dout1_13 vdout1_13ck197 = 0 time = 1980
* CHECK dout1_14 vdout1_14ck197 = 0 time = 1980
* CHECK dout1_15 vdout1_15ck197 = 1.7 time = 1980
* CHECK dout1_16 vdout1_16ck197 = 0 time = 1980
* CHECK dout1_0 vdout1_0ck201 = 0 time = 2020
* CHECK dout1_1 vdout1_1ck201 = 0 time = 2020
* CHECK dout1_2 vdout1_2ck201 = 0 time = 2020
* CHECK dout1_3 vdout1_3ck201 = 0 time = 2020
* CHECK dout1_4 vdout1_4ck201 = 0 time = 2020
* CHECK dout1_5 vdout1_5ck201 = 1.7 time = 2020
* CHECK dout1_6 vdout1_6ck201 = 1.7 time = 2020
* CHECK dout1_7 vdout1_7ck201 = 1.7 time = 2020
* CHECK dout1_8 vdout1_8ck201 = 1.7 time = 2020
* CHECK dout1_9 vdout1_9ck201 = 1.7 time = 2020
* CHECK dout1_10 vdout1_10ck201 = 1.7 time = 2020
* CHECK dout1_11 vdout1_11ck201 = 0 time = 2020
* CHECK dout1_12 vdout1_12ck201 = 0 time = 2020
* CHECK dout1_13 vdout1_13ck201 = 1.7 time = 2020
* CHECK dout1_14 vdout1_14ck201 = 0 time = 2020
* CHECK dout1_15 vdout1_15ck201 = 0 time = 2020
* CHECK dout1_16 vdout1_16ck201 = 0 time = 2020
* CHECK dout1_0 vdout1_0ck204 = 0 time = 2050
* CHECK dout1_1 vdout1_1ck204 = 0 time = 2050
* CHECK dout1_2 vdout1_2ck204 = 0 time = 2050
* CHECK dout1_3 vdout1_3ck204 = 0 time = 2050
* CHECK dout1_4 vdout1_4ck204 = 0 time = 2050
* CHECK dout1_5 vdout1_5ck204 = 1.7 time = 2050
* CHECK dout1_6 vdout1_6ck204 = 1.7 time = 2050
* CHECK dout1_7 vdout1_7ck204 = 1.7 time = 2050
* CHECK dout1_8 vdout1_8ck204 = 1.7 time = 2050
* CHECK dout1_9 vdout1_9ck204 = 1.7 time = 2050
* CHECK dout1_10 vdout1_10ck204 = 1.7 time = 2050
* CHECK dout1_11 vdout1_11ck204 = 0 time = 2050
* CHECK dout1_12 vdout1_12ck204 = 0 time = 2050
* CHECK dout1_13 vdout1_13ck204 = 1.7 time = 2050
* CHECK dout1_14 vdout1_14ck204 = 0 time = 2050
* CHECK dout1_15 vdout1_15ck204 = 0 time = 2050
* CHECK dout1_16 vdout1_16ck204 = 0 time = 2050
.include /Sky130_memory/work/openram_builds/v20260612_1r1w_full/sky130_sram_256bytes_1r1w_16x128/functional_meas.sp
.TEMP 0
.TRAN 10p 2060n 0n 10p UIC
.OPTIONS POST=1 RELTOL=0.001 PROBE method=gear ACCT
* probe is used for hspice/xa, while plot is used in ngspice
*.probe V(*)
*.plot V(*)
.end
