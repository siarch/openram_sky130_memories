* Functional test stimulus file for 10ns period

* SS process corner
.lib "/Sky130_memory/pdk/sky130A/libs.tech/ngspice/sky130.lib.spice" ss
.include "/tmp/openram_ryan_47039_temp/sram.sp"

* Global Power Supplies
Vvdd vdd 0 1.7

*Nodes gnd and 0 are the same global ground node in ngspice/hspice/xa. Otherwise, this source may be needed.
*Vgnd gnd 0 0.0

* Instantiation of the SRAM
Xsky130_sram_128bytes_1r1w_32x32 din0_0 din0_1 din0_2 din0_3 din0_4 din0_5 din0_6 din0_7 din0_8 din0_9 din0_10 din0_11 din0_12 din0_13 din0_14 din0_15 din0_16 din0_17 din0_18 din0_19 din0_20 din0_21 din0_22 din0_23 din0_24 din0_25 din0_26 din0_27 din0_28 din0_29 din0_30 din0_31 din0_32 a0_0 a0_1 a0_2 a0_3 a0_4 a0_5 a1_0 a1_1 a1_2 a1_3 a1_4 a1_5 CSB0 CSB1 clk0 clk1 SPARE_WEN0_0 dout1_0 dout1_1 dout1_2 dout1_3 dout1_4 dout1_5 dout1_6 dout1_7 dout1_8 dout1_9 dout1_10 dout1_11 dout1_12 dout1_13 dout1_14 dout1_15 dout1_16 dout1_17 dout1_18 dout1_19 dout1_20 dout1_21 dout1_22 dout1_23 dout1_24 dout1_25 dout1_26 dout1_27 dout1_28 dout1_29 dout1_30 dout1_31 dout1_32 vdd gnd sky130_sram_128bytes_1r1w_32x32

* SRAM output loads
CD10 dout1_0  0 27.56f
CD11 dout1_1  0 27.56f
CD12 dout1_2  0 27.56f
CD13 dout1_3  0 27.56f
CD14 dout1_4  0 27.56f
CD15 dout1_5  0 27.56f
CD16 dout1_6  0 27.56f
CD17 dout1_7  0 27.56f
CD18 dout1_8  0 27.56f
CD19 dout1_9  0 27.56f
CD110 dout1_10  0 27.56f
CD111 dout1_11  0 27.56f
CD112 dout1_12  0 27.56f
CD113 dout1_13  0 27.56f
CD114 dout1_14  0 27.56f
CD115 dout1_15  0 27.56f
CD116 dout1_16  0 27.56f
CD117 dout1_17  0 27.56f
CD118 dout1_18  0 27.56f
CD119 dout1_19  0 27.56f
CD120 dout1_20  0 27.56f
CD121 dout1_21  0 27.56f
CD122 dout1_22  0 27.56f
CD123 dout1_23  0 27.56f
CD124 dout1_24  0 27.56f
CD125 dout1_25  0 27.56f
CD126 dout1_26  0 27.56f
CD127 dout1_27  0 27.56f
CD128 dout1_28  0 27.56f
CD129 dout1_29  0 27.56f
CD130 dout1_30  0 27.56f
CD131 dout1_31  0 27.56f
CD132 dout1_32  0 27.56f

* Important signals for debug
* bl:	xsram:xbank0:bl_0_1
* br:	xsram:xbank0:br_0_1
* s_en:	xsram:s_en
* q:	xsram:xbank0:xbitcell_array:xbitcell_array:xbit_r0_c0.Q
* qbar:	xsram:xbank0:xbitcell_array:xbitcell_array:xbit_r0_c0.Q_bar

* Sequence of operations
*	Idle during cycle 0 (0ns - 10ns)
*	Writing 0+00010001111110010000101001110000  to  address 000000 (from port 0) during cycle 1 (10ns - 20ns)
*	Writing 0+00010100111011000100100111000110  to  address 000000 (from port 0) during cycle 2 (20ns - 30ns)
*	Writing 0+00110110010010111110101111011111  to  address 000000 (from port 0) during cycle 3 (30ns - 40ns)
*	Reading 0+00110110010010111110101111011111 from address 000000 (from port 1) during cycle 4 (40ns - 50ns)
*	Writing 0+01010101000001000011110011100011  to  address 011111 (from port 0) during cycle 5 (50ns - 60ns)
*	Writing 0+10110111110011010101011011010011  to  address 011111 (from port 0) during cycle 6 (60ns - 70ns)
*	Reading 0+00110110010010111110101111011111 from address 000000 (from port 1) during cycle 6 (60ns - 70ns)
*	Writing 0+00110111111010111101011000101100  to  address 000000 (from port 0) during cycle 7 (70ns - 80ns)
*	Writing 0+01001100111100000010000001001110  to  address 011111 (from port 0) during cycle 8 (80ns - 90ns)
*	Reading 0+00110111111010111101011000101100 from address 000000 (from port 1) during cycle 8 (80ns - 90ns)
*	Reading 0+00110111111010111101011000101100 from address 000000 (from port 1) during cycle 9 (90ns - 100ns)
*	Reading 0+00110111111010111101011000101100 from address 000000 (from port 1) during cycle 10 (100ns - 110ns)
*	Reading 0+00110111111010111101011000101100 from address 000000 (from port 1) during cycle 11 (110ns - 120ns)
*	Writing 0+11101000001111111111101001001100  to  address 011111 (from port 0) during cycle 12 (120ns - 130ns)
*	Reading 0+00110111111010111101011000101100 from address 000000 (from port 1) during cycle 12 (120ns - 130ns)
*	Writing 0+11011011001011010100101001100000  to  address 011111 (from port 0) during cycle 13 (130ns - 140ns)
*	Writing 0+01100111101011100101000010010001  to  address 011111 (from port 0) during cycle 14 (140ns - 150ns)
*	Reading 0+01100111101011100101000010010001 from address 011111 (from port 1) during cycle 15 (150ns - 160ns)
*	Writing 0+00101011010110000101010110101010  to  address 011111 (from port 0) during cycle 18 (180ns - 190ns)
*	Reading 0+00101011010110000101010110101010 from address 011111 (from port 1) during cycle 20 (200ns - 210ns)
*	Writing 0+10111100110010000100001111001000  to  address 011111 (from port 0) during cycle 21 (210ns - 220ns)
*	Writing 0+10010101001010111101110010110111  to  address 000000 (from port 0) during cycle 24 (240ns - 250ns)
*	Reading 0+10010101001010111101110010110111 from address 000000 (from port 1) during cycle 25 (250ns - 260ns)
*	Reading 0+10111100110010000100001111001000 from address 011111 (from port 1) during cycle 26 (260ns - 270ns)
*	Writing 0+00010000101111001010110110011011  to  address 011111 (from port 0) during cycle 27 (270ns - 280ns)
*	Reading 0+00010000101111001010110110011011 from address 011111 (from port 1) during cycle 28 (280ns - 290ns)
*	Reading 0+10010101001010111101110010110111 from address 000000 (from port 1) during cycle 29 (290ns - 300ns)
*	Writing 0+01001011010001010001011111011101  to  address 000000 (from port 0) during cycle 30 (300ns - 310ns)
*	Reading 0+00010000101111001010110110011011 from address 011111 (from port 1) during cycle 30 (300ns - 310ns)
*	Writing 0+11110100010100001001100101000001  to  address 000000 (from port 0) during cycle 31 (310ns - 320ns)
*	Writing 0+11111011000111101111100110001101  to  address 000000 (from port 0) during cycle 32 (320ns - 330ns)
*	Writing 0+11110101000011100011110111100001  to  address 011111 (from port 0) during cycle 33 (330ns - 340ns)
*	Reading 0+11110101000011100011110111100001 from address 011111 (from port 1) during cycle 34 (340ns - 350ns)
*	Reading 0+11110101000011100011110111100001 from address 011111 (from port 1) during cycle 37 (370ns - 380ns)
*	Writing 0+11110011111001111110100001010000  to  address 000000 (from port 0) during cycle 38 (380ns - 390ns)
*	Reading 0+11110011111001111110100001010000 from address 000000 (from port 1) during cycle 39 (390ns - 400ns)
*	Reading 0+11110011111001111110100001010000 from address 000000 (from port 1) during cycle 41 (410ns - 420ns)
*	Reading 0+11110011111001111110100001010000 from address 000000 (from port 1) during cycle 42 (420ns - 430ns)
*	Writing 0+11100011101000110010111001101110  to  address 011111 (from port 0) during cycle 43 (430ns - 440ns)
*	Reading 0+11110011111001111110100001010000 from address 000000 (from port 1) during cycle 43 (430ns - 440ns)
*	Writing 0+01110101001110001101110011111101  to  address 011111 (from port 0) during cycle 44 (440ns - 450ns)
*	Reading 0+11110011111001111110100001010000 from address 000000 (from port 1) during cycle 44 (440ns - 450ns)
*	Writing 0+11101011000100100110000010101101  to  address 000000 (from port 0) during cycle 46 (460ns - 470ns)
*	Writing 0+01000111110110111110110111011011  to  address 000000 (from port 0) during cycle 47 (470ns - 480ns)
*	Reading 0+01000111110110111110110111011011 from address 000000 (from port 1) during cycle 48 (480ns - 490ns)
*	Writing 0+00110111011100011010010101011000  to  address 000000 (from port 0) during cycle 51 (510ns - 520ns)
*	Writing 0+01010101110000001010011000111101  to  address 011111 (from port 0) during cycle 52 (520ns - 530ns)
*	Writing 0+01000100010011011011101010001010  to  address 011111 (from port 0) during cycle 53 (530ns - 540ns)
*	Reading 0+00110111011100011010010101011000 from address 000000 (from port 1) during cycle 53 (530ns - 540ns)
*	Writing 0+10111101111001110001010100110011  to  address 011111 (from port 0) during cycle 54 (540ns - 550ns)
*	Writing 0+01010101000001010100110110111011  to  address 011111 (from port 0) during cycle 55 (550ns - 560ns)
*	Reading 0+00110111011100011010010101011000 from address 000000 (from port 1) during cycle 55 (550ns - 560ns)
*	Reading 0+00110111011100011010010101011000 from address 000000 (from port 1) during cycle 57 (570ns - 580ns)
*	Reading 0+01010101000001010100110110111011 from address 011111 (from port 1) during cycle 58 (580ns - 590ns)
*	Writing 0+10111100100101001001001101110011  to  address 011111 (from port 0) during cycle 59 (590ns - 600ns)
*	Reading 0+00110111011100011010010101011000 from address 000000 (from port 1) during cycle 61 (610ns - 620ns)
*	Reading 0+00110111011100011010010101011000 from address 000000 (from port 1) during cycle 62 (620ns - 630ns)
*	Writing 0+10000110011000000110010101111010  to  address 011111 (from port 0) during cycle 63 (630ns - 640ns)
*	Writing 0+10101110111010010010111110000001  to  address 011111 (from port 0) during cycle 64 (640ns - 650ns)
*	Reading 0+00110111011100011010010101011000 from address 000000 (from port 1) during cycle 64 (640ns - 650ns)
*	Writing 0+11011111111000001011011101011100  to  address 011111 (from port 0) during cycle 66 (660ns - 670ns)
*	Reading 0+00110111011100011010010101011000 from address 000000 (from port 1) during cycle 66 (660ns - 670ns)
*	Writing 0+10011001100111001011011000010100  to  address 000000 (from port 0) during cycle 67 (670ns - 680ns)
*	Writing 0+01011010111001100000011011110000  to  address 011111 (from port 0) during cycle 69 (690ns - 700ns)
*	Reading 0+10011001100111001011011000010100 from address 000000 (from port 1) during cycle 69 (690ns - 700ns)
*	Writing 0+00100001010111111000000110100110  to  address 000000 (from port 0) during cycle 70 (700ns - 710ns)
*	Reading 0+01011010111001100000011011110000 from address 011111 (from port 1) during cycle 70 (700ns - 710ns)
*	Writing 0+10010100000110000111000100011011  to  address 011111 (from port 0) during cycle 71 (710ns - 720ns)
*	Writing 0+00010010101110001101100110011100  to  address 011111 (from port 0) during cycle 72 (720ns - 730ns)
*	Reading 0+00100001010111111000000110100110 from address 000000 (from port 1) during cycle 73 (730ns - 740ns)
*	Writing 0+01011110111111000100001111100011  to  address 011111 (from port 0) during cycle 74 (740ns - 750ns)
*	Writing 0+01101100100100101110100010010010  to  address 011111 (from port 0) during cycle 75 (750ns - 760ns)
*	Writing 0+01001001010101111000011111101101  to  address 011111 (from port 0) during cycle 76 (760ns - 770ns)
*	Writing 0+01011001111001010101110010100010  to  address 000000 (from port 0) during cycle 77 (770ns - 780ns)
*	Writing 0+11011001101101010101100001101101  to  address 011111 (from port 0) during cycle 79 (790ns - 800ns)
*	Writing 0+00110100011001001110110110010011  to  address 000000 (from port 0) during cycle 81 (810ns - 820ns)
*	Reading 0+11011001101101010101100001101101 from address 011111 (from port 1) during cycle 81 (810ns - 820ns)
*	Writing 0+11101101101110110010010101000010  to  address 011111 (from port 0) during cycle 82 (820ns - 830ns)
*	Reading 0+00110100011001001110110110010011 from address 000000 (from port 1) during cycle 82 (820ns - 830ns)
*	Reading 0+11101101101110110010010101000010 from address 011111 (from port 1) during cycle 84 (840ns - 850ns)
*	Writing 0+00110101100001110110100111010110  to  address 011111 (from port 0) during cycle 85 (850ns - 860ns)
*	Writing 0+00110110010001110100111011100101  to  address 011111 (from port 0) during cycle 86 (860ns - 870ns)
*	Writing 0+01111001010010110001101111010111  to  address 000000 (from port 0) during cycle 87 (870ns - 880ns)
*	Reading 0+00110110010001110100111011100101 from address 011111 (from port 1) during cycle 89 (890ns - 900ns)
*	Reading 0+00110110010001110100111011100101 from address 011111 (from port 1) during cycle 90 (900ns - 910ns)
*	Reading 0+00110110010001110100111011100101 from address 011111 (from port 1) during cycle 91 (910ns - 920ns)
*	Writing 0+11111101101100010111111110000110  to  address 000000 (from port 0) during cycle 92 (920ns - 930ns)
*	Writing 0+00010010010010010111011111110100  to  address 011111 (from port 0) during cycle 93 (930ns - 940ns)
*	Writing 0+01100101111010000000111000011100  to  address 011111 (from port 0) during cycle 94 (940ns - 950ns)
*	Writing 0+00011100110110111111111001101100  to  address 011111 (from port 0) during cycle 95 (950ns - 960ns)
*	Writing 0+00111001111000001011111100011110  to  address 000000 (from port 0) during cycle 97 (970ns - 980ns)
*	Reading 0+00011100110110111111111001101100 from address 011111 (from port 1) during cycle 97 (970ns - 980ns)
*	Writing 0+11101111000100000000010000001101  to  address 011111 (from port 0) during cycle 98 (980ns - 990ns)
*	Reading 0+11101111000100000000010000001101 from address 011111 (from port 1) during cycle 100 (1000ns - 1010ns)
*	Reading 0+11101111000100000000010000001101 from address 011111 (from port 1) during cycle 102 (1020ns - 1030ns)
*	Reading 0+11101111000100000000010000001101 from address 011111 (from port 1) during cycle 103 (1030ns - 1040ns)
*	Writing 0+01101101000100011000101101100000  to  address 011111 (from port 0) during cycle 104 (1040ns - 1050ns)
*	Reading 0+01101101000100011000101101100000 from address 011111 (from port 1) during cycle 105 (1050ns - 1060ns)
*	Reading 0+00111001111000001011111100011110 from address 000000 (from port 1) during cycle 108 (1080ns - 1090ns)
*	Writing 0+11111111100011011101111011010110  to  address 011111 (from port 0) during cycle 109 (1090ns - 1100ns)
*	Writing 0+00000011011110110111110101101100  to  address 011111 (from port 0) during cycle 110 (1100ns - 1110ns)
*	Writing 0+10010011000100010101001001000110  to  address 011111 (from port 0) during cycle 111 (1110ns - 1120ns)
*	Reading 0+00111001111000001011111100011110 from address 000000 (from port 1) during cycle 111 (1110ns - 1120ns)
*	Reading 0+00111001111000001011111100011110 from address 000000 (from port 1) during cycle 112 (1120ns - 1130ns)
*	Writing 0+11110000100110000101000101000011  to  address 011111 (from port 0) during cycle 114 (1140ns - 1150ns)
*	Reading 0+00111001111000001011111100011110 from address 000000 (from port 1) during cycle 114 (1140ns - 1150ns)
*	Writing 0+10011111101110110001001101100001  to  address 000000 (from port 0) during cycle 115 (1150ns - 1160ns)
*	Writing 0+10011011000001110010001101101000  to  address 000000 (from port 0) during cycle 116 (1160ns - 1170ns)
*	Writing 0+01001000101001110001010011001100  to  address 011111 (from port 0) during cycle 117 (1170ns - 1180ns)
*	Writing 0+00100101011100111111101011000111  to  address 011111 (from port 0) during cycle 118 (1180ns - 1190ns)
*	Writing 0+10110100011110100000000101011101  to  address 000000 (from port 0) during cycle 120 (1200ns - 1210ns)
*	Reading 0+00100101011100111111101011000111 from address 011111 (from port 1) during cycle 120 (1200ns - 1210ns)
*	Writing 0+01010110101100011010111010010111  to  address 000000 (from port 0) during cycle 121 (1210ns - 1220ns)
*	Reading 0+00100101011100111111101011000111 from address 011111 (from port 1) during cycle 121 (1210ns - 1220ns)
*	Writing 0+10111100011010001000101100101100  to  address 011111 (from port 0) during cycle 122 (1220ns - 1230ns)
*	Writing 0+10110000000110010001100010100100  to  address 000000 (from port 0) during cycle 123 (1230ns - 1240ns)
*	Reading 0+10111100011010001000101100101100 from address 011111 (from port 1) during cycle 123 (1230ns - 1240ns)
*	Writing 0+01011011010111100110101010001110  to  address 011111 (from port 0) during cycle 124 (1240ns - 1250ns)
*	Reading 0+01011011010111100110101010001110 from address 011111 (from port 1) during cycle 125 (1250ns - 1260ns)
*	Writing 0+00111010011000010010001111100100  to  address 011111 (from port 0) during cycle 127 (1270ns - 1280ns)
*	Reading 0+00111010011000010010001111100100 from address 011111 (from port 1) during cycle 128 (1280ns - 1290ns)
*	Writing 0+01001000010001111011111010000000  to  address 000000 (from port 0) during cycle 129 (1290ns - 1300ns)
*	Writing 0+10110110000101000011001000101111  to  address 000000 (from port 0) during cycle 132 (1320ns - 1330ns)
*	Writing 0+01110001010000100110001110100011  to  address 011111 (from port 0) during cycle 134 (1340ns - 1350ns)
*	Writing 0+00000001110100110010001111110110  to  address 011111 (from port 0) during cycle 135 (1350ns - 1360ns)
*	Writing 0+00100000011010001100100001000111  to  address 011111 (from port 0) during cycle 137 (1370ns - 1380ns)
*	Writing 0+10111111101100110010011011111010  to  address 000000 (from port 0) during cycle 138 (1380ns - 1390ns)
*	Reading 0+00100000011010001100100001000111 from address 011111 (from port 1) during cycle 139 (1390ns - 1400ns)
*	Writing 0+00010000111011011100010110100111  to  address 011111 (from port 0) during cycle 140 (1400ns - 1410ns)
*	Writing 0+10001100111001100110010000111011  to  address 011111 (from port 0) during cycle 141 (1410ns - 1420ns)
*	Reading 0+10111111101100110010011011111010 from address 000000 (from port 1) during cycle 143 (1430ns - 1440ns)
*	Writing 0+10011110001101111011111001000000  to  address 011111 (from port 0) during cycle 144 (1440ns - 1450ns)
*	Writing 0+10011110101100100101010011000100  to  address 000000 (from port 0) during cycle 145 (1450ns - 1460ns)
*	Writing 0+11110110110111100101010000010000  to  address 000000 (from port 0) during cycle 146 (1460ns - 1470ns)
*	Writing 0+11110000000001110111100110101110  to  address 000000 (from port 0) during cycle 147 (1470ns - 1480ns)
*	Writing 0+00100110100010100000101111001110  to  address 011111 (from port 0) during cycle 149 (1490ns - 1500ns)
*	Reading 0+00100110100010100000101111001110 from address 011111 (from port 1) during cycle 150 (1500ns - 1510ns)
*	Writing 0+00101110111101100011011010111100  to  address 011111 (from port 0) during cycle 151 (1510ns - 1520ns)
*	Reading 0+00101110111101100011011010111100 from address 011111 (from port 1) during cycle 152 (1520ns - 1530ns)
*	Writing 0+11011100010011100001101101000111  to  address 000000 (from port 0) during cycle 153 (1530ns - 1540ns)
*	Reading 0+00101110111101100011011010111100 from address 011111 (from port 1) during cycle 153 (1530ns - 1540ns)
*	Writing 0+10100101111010011011011001010110  to  address 000000 (from port 0) during cycle 154 (1540ns - 1550ns)
*	Writing 0+00011010100010001110100010100000  to  address 000000 (from port 0) during cycle 155 (1550ns - 1560ns)
*	Reading 0+00011010100010001110100010100000 from address 000000 (from port 1) during cycle 156 (1560ns - 1570ns)
*	Writing 0+00011111111011111001001001110110  to  address 011111 (from port 0) during cycle 157 (1570ns - 1580ns)
*	Writing 0+01110010011000101011010011100000  to  address 011111 (from port 0) during cycle 158 (1580ns - 1590ns)
*	Writing 0+01011011000010100010101010100001  to  address 000000 (from port 0) during cycle 159 (1590ns - 1600ns)
*	Writing 0+00011111010001001110101010000000  to  address 000000 (from port 0) during cycle 160 (1600ns - 1610ns)
*	Reading 0+01110010011000101011010011100000 from address 011111 (from port 1) during cycle 160 (1600ns - 1610ns)
*	Writing 0+01110000010001100000101111100011  to  address 011111 (from port 0) during cycle 161 (1610ns - 1620ns)
*	Reading 0+01110000010001100000101111100011 from address 011111 (from port 1) during cycle 162 (1620ns - 1630ns)
*	Writing 0+01101000100100110111010000010010  to  address 011111 (from port 0) during cycle 164 (1640ns - 1650ns)
*	Writing 0+10010110000011100100010101110001  to  address 000000 (from port 0) during cycle 167 (1670ns - 1680ns)
*	Writing 0+01000101101110100100011101111000  to  address 011111 (from port 0) during cycle 168 (1680ns - 1690ns)
*	Writing 0+10001100000001110111000110100111  to  address 011111 (from port 0) during cycle 169 (1690ns - 1700ns)
*	Writing 0+01111101111111110010111100010100  to  address 011111 (from port 0) during cycle 170 (1700ns - 1710ns)
*	Reading 0+10010110000011100100010101110001 from address 000000 (from port 1) during cycle 170 (1700ns - 1710ns)
*	Writing 0+01110001010011100011010011111100  to  address 000000 (from port 0) during cycle 171 (1710ns - 1720ns)
*	Writing 0+11000000000101001100111110010000  to  address 011111 (from port 0) during cycle 172 (1720ns - 1730ns)
*	Reading 0+11000000000101001100111110010000 from address 011111 (from port 1) during cycle 173 (1730ns - 1740ns)
*	Writing 0+10010101001101100101101101101101  to  address 011111 (from port 0) during cycle 174 (1740ns - 1750ns)
*	Writing 0+01101000110111010000110101011100  to  address 011111 (from port 0) during cycle 176 (1760ns - 1770ns)
*	Reading 0+01110001010011100011010011111100 from address 000000 (from port 1) during cycle 176 (1760ns - 1770ns)
*	Writing 0+01111011001101010100001100110010  to  address 000000 (from port 0) during cycle 177 (1770ns - 1780ns)
*	Writing 0+00110111000110001101110000110100  to  address 000000 (from port 0) during cycle 178 (1780ns - 1790ns)
*	Writing 0+11111111100110111000100010011011  to  address 011111 (from port 0) during cycle 179 (1790ns - 1800ns)
*	Writing 0+10110100100101101010010000110000  to  address 011111 (from port 0) during cycle 180 (1800ns - 1810ns)
*	Reading 0+00110111000110001101110000110100 from address 000000 (from port 1) during cycle 180 (1800ns - 1810ns)
*	Writing 0+01101011110000000111111001100101  to  address 011111 (from port 0) during cycle 181 (1810ns - 1820ns)
*	Writing 0+11111000101001111011100101010000  to  address 000000 (from port 0) during cycle 182 (1820ns - 1830ns)
*	Writing 0+01000101010000000101011101001110  to  address 000000 (from port 0) during cycle 183 (1830ns - 1840ns)
*	Writing 0+01001100010001101001100110110010  to  address 011111 (from port 0) during cycle 184 (1840ns - 1850ns)
*	Writing 0+10100100111101110101100101000100  to  address 011111 (from port 0) during cycle 186 (1860ns - 1870ns)
*	Reading 0+01000101010000000101011101001110 from address 000000 (from port 1) during cycle 186 (1860ns - 1870ns)
*	Reading 0+10100100111101110101100101000100 from address 011111 (from port 1) during cycle 187 (1870ns - 1880ns)
*	Writing 0+01110101101000110100010110101000  to  address 011111 (from port 0) during cycle 188 (1880ns - 1890ns)
*	Writing 0+01100011000101011111110011000100  to  address 000000 (from port 0) during cycle 190 (1900ns - 1910ns)
*	Writing 0+01100010011001100100010001000000  to  address 000000 (from port 0) during cycle 191 (1910ns - 1920ns)
*	Reading 0+01110101101000110100010110101000 from address 011111 (from port 1) during cycle 191 (1910ns - 1920ns)
*	Writing 0+11010000010111111000111011010011  to  address 000000 (from port 0) during cycle 192 (1920ns - 1930ns)
*	Writing 0+10110101011000100011111000010011  to  address 011111 (from port 0) during cycle 193 (1930ns - 1940ns)
*	Writing 0+11111110011010011111011000100100  to  address 000000 (from port 0) during cycle 194 (1940ns - 1950ns)
*	Writing 0+00110001100011100011111000011010  to  address 011111 (from port 0) during cycle 195 (1950ns - 1960ns)
*	Reading 0+00110001100011100011111000011010 from address 011111 (from port 1) during cycle 196 (1960ns - 1970ns)
*	Writing 0+11110000010000011010000001101010  to  address 000000 (from port 0) during cycle 197 (1970ns - 1980ns)
*	Writing 0+01101001111000100010011001100001  to  address 011111 (from port 0) during cycle 199 (1990ns - 2000ns)
*	Reading 0+11110000010000011010000001101010 from address 000000 (from port 1) during cycle 199 (1990ns - 2000ns)
*	Writing 0+00110111110001111110000001010001  to  address 011111 (from port 0) during cycle 202 (2020ns - 2030ns)
*	Writing 0+11001011110011110011111010110101  to  address 000000 (from port 0) during cycle 203 (2030ns - 2040ns)
*	Idle during cycle 205 (2050ns - 2060ns)

* Generation of data and address signals
* (time, data): [(0, 0), (10, 0), (20, 0), (30, 1), (40, 1), (50, 1), (60, 1), (70, 0), (80, 0), (90, 0), (100, 0), (110, 0), (120, 0), (130, 0), (140, 1), (150, 1), (160, 1), (170, 1), (180, 0), (190, 0), (200, 0), (210, 0), (220, 0), (230, 0), (240, 1), (250, 1), (260, 1), (270, 1), (280, 1), (290, 1), (300, 1), (310, 1), (320, 1), (330, 1), (340, 1), (350, 1), (360, 1), (370, 1), (380, 0), (390, 0), (400, 0), (410, 0), (420, 0), (430, 0), (440, 1), (450, 1), (460, 1), (470, 1), (480, 1), (490, 1), (500, 1), (510, 0), (520, 1), (530, 0), (540, 1), (550, 1), (560, 1), (570, 1), (580, 1), (590, 1), (600, 1), (610, 1), (620, 1), (630, 0), (640, 1), (650, 1), (660, 0), (670, 0), (680, 0), (690, 0), (700, 0), (710, 1), (720, 0), (730, 0), (740, 1), (750, 0), (760, 1), (770, 0), (780, 0), (790, 1), (800, 1), (810, 1), (820, 0), (830, 0), (840, 0), (850, 0), (860, 1), (870, 1), (880, 1), (890, 1), (900, 1), (910, 1), (920, 0), (930, 0), (940, 0), (950, 0), (960, 0), (970, 0), (980, 1), (990, 1), (1000, 1), (1010, 1), (1020, 1), (1030, 1), (1040, 0), (1050, 0), (1060, 0), (1070, 0), (1080, 0), (1090, 0), (1100, 0), (1110, 0), (1120, 0), (1130, 0), (1140, 1), (1150, 1), (1160, 0), (1170, 0), (1180, 1), (1190, 1), (1200, 1), (1210, 1), (1220, 0), (1230, 0), (1240, 0), (1250, 0), (1260, 0), (1270, 0), (1280, 0), (1290, 0), (1300, 0), (1310, 0), (1320, 1), (1330, 1), (1340, 1), (1350, 0), (1360, 0), (1370, 1), (1380, 0), (1390, 0), (1400, 1), (1410, 1), (1420, 1), (1430, 1), (1440, 0), (1450, 0), (1460, 0), (1470, 0), (1480, 0), (1490, 0), (1500, 0), (1510, 0), (1520, 0), (1530, 1), (1540, 0), (1550, 0), (1560, 0), (1570, 0), (1580, 0), (1590, 1), (1600, 0), (1610, 1), (1620, 1), (1630, 1), (1640, 0), (1650, 0), (1660, 0), (1670, 1), (1680, 0), (1690, 1), (1700, 0), (1710, 0), (1720, 0), (1730, 0), (1740, 1), (1750, 1), (1760, 0), (1770, 0), (1780, 0), (1790, 1), (1800, 0), (1810, 1), (1820, 0), (1830, 0), (1840, 0), (1850, 0), (1860, 0), (1870, 0), (1880, 0), (1890, 0), (1900, 0), (1910, 0), (1920, 1), (1930, 1), (1940, 0), (1950, 0), (1960, 0), (1970, 0), (1980, 0), (1990, 1), (2000, 1), (2010, 1), (2020, 1), (2030, 1), (2040, 1), (2050, 1)]
Vdin0_0  din0_0  0 PWL (0n 0.0v 9.495n 0.0v 9.505n 0.0v 19.495n 0.0v 19.505n 0.0v 29.495n 0.0v 29.505n 1.7v 39.495n 1.7v 39.505n 1.7v 49.495n 1.7v 49.505n 1.7v 59.495n 1.7v 59.505n 1.7v 69.495n 1.7v 69.505n 0.0v 79.495n 0.0v 79.505n 0.0v 89.495n 0.0v 89.505n 0.0v 99.495n 0.0v 99.505n 0.0v 109.495n 0.0v 109.505n 0.0v 119.495n 0.0v 119.505n 0.0v 129.495n 0.0v 129.505n 0.0v 139.495n 0.0v 139.505n 1.7v 149.495n 1.7v 149.505n 1.7v 159.495n 1.7v 159.505n 1.7v 169.495n 1.7v 169.505n 1.7v 179.495n 1.7v 179.505n 0.0v 189.495n 0.0v 189.505n 0.0v 199.495n 0.0v 199.505n 0.0v 209.495n 0.0v 209.505n 0.0v 219.495n 0.0v 219.505n 0.0v 229.495n 0.0v 229.505n 0.0v 239.495n 0.0v 239.505n 1.7v 249.495n 1.7v 249.505n 1.7v 259.495n 1.7v 259.505n 1.7v 269.495n 1.7v 269.505n 1.7v 279.495n 1.7v 279.505n 1.7v 289.495n 1.7v 289.505n 1.7v 299.495n 1.7v 299.505n 1.7v 309.495n 1.7v 309.505n 1.7v 319.495n 1.7v 319.505n 1.7v 329.495n 1.7v 329.505n 1.7v 339.495n 1.7v 339.505n 1.7v 349.495n 1.7v 349.505n 1.7v 359.495n 1.7v 359.505n 1.7v 369.495n 1.7v 369.505n 1.7v 379.495n 1.7v 379.505n 0.0v 389.495n 0.0v 389.505n 0.0v 399.495n 0.0v 399.505n 0.0v 409.495n 0.0v 409.505n 0.0v 419.495n 0.0v 419.505n 0.0v 429.495n 0.0v 429.505n 0.0v 439.495n 0.0v 439.505n 1.7v 449.495n 1.7v 449.505n 1.7v 459.495n 1.7v 459.505n 1.7v 469.495n 1.7v 469.505n 1.7v 479.495n 1.7v 479.505n 1.7v 489.495n 1.7v 489.505n 1.7v 499.495n 1.7v 499.505n 1.7v 509.495n 1.7v 509.505n 0.0v 519.495n 0.0v 519.505n 1.7v 529.495n 1.7v 529.505n 0.0v 539.495n 0.0v 539.505n 1.7v 549.495n 1.7v 549.505n 1.7v 559.495n 1.7v 559.505n 1.7v 569.495n 1.7v 569.505n 1.7v 579.495n 1.7v 579.505n 1.7v 589.495n 1.7v 589.505n 1.7v 599.495n 1.7v 599.505n 1.7v 609.495n 1.7v 609.505n 1.7v 619.495n 1.7v 619.505n 1.7v 629.495n 1.7v 629.505n 0.0v 639.495n 0.0v 639.505n 1.7v 649.495n 1.7v 649.505n 1.7v 659.495n 1.7v 659.505n 0.0v 669.495n 0.0v 669.505n 0.0v 679.495n 0.0v 679.505n 0.0v 689.495n 0.0v 689.505n 0.0v 699.495n 0.0v 699.505n 0.0v 709.495n 0.0v 709.505n 1.7v 719.495n 1.7v 719.505n 0.0v 729.495n 0.0v 729.505n 0.0v 739.495n 0.0v 739.505n 1.7v 749.495n 1.7v 749.505n 0.0v 759.495n 0.0v 759.505n 1.7v 769.495n 1.7v 769.505n 0.0v 779.495n 0.0v 779.505n 0.0v 789.495n 0.0v 789.505n 1.7v 799.495n 1.7v 799.505n 1.7v 809.495n 1.7v 809.505n 1.7v 819.495n 1.7v 819.505n 0.0v 829.495n 0.0v 829.505n 0.0v 839.495n 0.0v 839.505n 0.0v 849.495n 0.0v 849.505n 0.0v 859.495n 0.0v 859.505n 1.7v 869.495n 1.7v 869.505n 1.7v 879.495n 1.7v 879.505n 1.7v 889.495n 1.7v 889.505n 1.7v 899.495n 1.7v 899.505n 1.7v 909.495n 1.7v 909.505n 1.7v 919.495n 1.7v 919.505n 0.0v 929.495n 0.0v 929.505n 0.0v 939.495n 0.0v 939.505n 0.0v 949.495n 0.0v 949.505n 0.0v 959.495n 0.0v 959.505n 0.0v 969.495n 0.0v 969.505n 0.0v 979.495n 0.0v 979.505n 1.7v 989.495n 1.7v 989.505n 1.7v 999.495n 1.7v 999.505n 1.7v 1009.495n 1.7v 1009.505n 1.7v 1019.495n 1.7v 1019.505n 1.7v 1029.495n 1.7v 1029.505n 1.7v 1039.495n 1.7v 1039.505n 0.0v 1049.495n 0.0v 1049.505n 0.0v 1059.495n 0.0v 1059.505n 0.0v 1069.495n 0.0v 1069.505n 0.0v 1079.495n 0.0v 1079.505n 0.0v 1089.495n 0.0v 1089.505n 0.0v 1099.495n 0.0v 1099.505n 0.0v 1109.495n 0.0v 1109.505n 0.0v 1119.495n 0.0v 1119.505n 0.0v 1129.495n 0.0v 1129.505n 0.0v 1139.495n 0.0v 1139.505n 1.7v 1149.495n 1.7v 1149.505n 1.7v 1159.495n 1.7v 1159.505n 0.0v 1169.495n 0.0v 1169.505n 0.0v 1179.495n 0.0v 1179.505n 1.7v 1189.495n 1.7v 1189.505n 1.7v 1199.495n 1.7v 1199.505n 1.7v 1209.495n 1.7v 1209.505n 1.7v 1219.495n 1.7v 1219.505n 0.0v 1229.495n 0.0v 1229.505n 0.0v 1239.495n 0.0v 1239.505n 0.0v 1249.495n 0.0v 1249.505n 0.0v 1259.495n 0.0v 1259.505n 0.0v 1269.495n 0.0v 1269.505n 0.0v 1279.495n 0.0v 1279.505n 0.0v 1289.495n 0.0v 1289.505n 0.0v 1299.495n 0.0v 1299.505n 0.0v 1309.495n 0.0v 1309.505n 0.0v 1319.495n 0.0v 1319.505n 1.7v 1329.495n 1.7v 1329.505n 1.7v 1339.495n 1.7v 1339.505n 1.7v 1349.495n 1.7v 1349.505n 0.0v 1359.495n 0.0v 1359.505n 0.0v 1369.495n 0.0v 1369.505n 1.7v 1379.495n 1.7v 1379.505n 0.0v 1389.495n 0.0v 1389.505n 0.0v 1399.495n 0.0v 1399.505n 1.7v 1409.495n 1.7v 1409.505n 1.7v 1419.495n 1.7v 1419.505n 1.7v 1429.495n 1.7v 1429.505n 1.7v 1439.495n 1.7v 1439.505n 0.0v 1449.495n 0.0v 1449.505n 0.0v 1459.495n 0.0v 1459.505n 0.0v 1469.495n 0.0v 1469.505n 0.0v 1479.495n 0.0v 1479.505n 0.0v 1489.495n 0.0v 1489.505n 0.0v 1499.495n 0.0v 1499.505n 0.0v 1509.495n 0.0v 1509.505n 0.0v 1519.495n 0.0v 1519.505n 0.0v 1529.495n 0.0v 1529.505n 1.7v 1539.495n 1.7v 1539.505n 0.0v 1549.495n 0.0v 1549.505n 0.0v 1559.495n 0.0v 1559.505n 0.0v 1569.495n 0.0v 1569.505n 0.0v 1579.495n 0.0v 1579.505n 0.0v 1589.495n 0.0v 1589.505n 1.7v 1599.495n 1.7v 1599.505n 0.0v 1609.495n 0.0v 1609.505n 1.7v 1619.495n 1.7v 1619.505n 1.7v 1629.495n 1.7v 1629.505n 1.7v 1639.495n 1.7v 1639.505n 0.0v 1649.495n 0.0v 1649.505n 0.0v 1659.495n 0.0v 1659.505n 0.0v 1669.495n 0.0v 1669.505n 1.7v 1679.495n 1.7v 1679.505n 0.0v 1689.495n 0.0v 1689.505n 1.7v 1699.495n 1.7v 1699.505n 0.0v 1709.495n 0.0v 1709.505n 0.0v 1719.495n 0.0v 1719.505n 0.0v 1729.495n 0.0v 1729.505n 0.0v 1739.495n 0.0v 1739.505n 1.7v 1749.495n 1.7v 1749.505n 1.7v 1759.495n 1.7v 1759.505n 0.0v 1769.495n 0.0v 1769.505n 0.0v 1779.495n 0.0v 1779.505n 0.0v 1789.495n 0.0v 1789.505n 1.7v 1799.495n 1.7v 1799.505n 0.0v 1809.495n 0.0v 1809.505n 1.7v 1819.495n 1.7v 1819.505n 0.0v 1829.495n 0.0v 1829.505n 0.0v 1839.495n 0.0v 1839.505n 0.0v 1849.495n 0.0v 1849.505n 0.0v 1859.495n 0.0v 1859.505n 0.0v 1869.495n 0.0v 1869.505n 0.0v 1879.495n 0.0v 1879.505n 0.0v 1889.495n 0.0v 1889.505n 0.0v 1899.495n 0.0v 1899.505n 0.0v 1909.495n 0.0v 1909.505n 0.0v 1919.495n 0.0v 1919.505n 1.7v 1929.495n 1.7v 1929.505n 1.7v 1939.495n 1.7v 1939.505n 0.0v 1949.495n 0.0v 1949.505n 0.0v 1959.495n 0.0v 1959.505n 0.0v 1969.495n 0.0v 1969.505n 0.0v 1979.495n 0.0v 1979.505n 0.0v 1989.495n 0.0v 1989.505n 1.7v 1999.495n 1.7v 1999.505n 1.7v 2009.495n 1.7v 2009.505n 1.7v 2019.495n 1.7v 2019.505n 1.7v 2029.495n 1.7v 2029.505n 1.7v 2039.495n 1.7v 2039.505n 1.7v 2049.495n 1.7v 2049.505n 1.7v )
* (time, data): [(0, 0), (10, 0), (20, 1), (30, 1), (40, 1), (50, 1), (60, 1), (70, 0), (80, 1), (90, 1), (100, 1), (110, 1), (120, 0), (130, 0), (140, 0), (150, 0), (160, 0), (170, 0), (180, 1), (190, 1), (200, 1), (210, 0), (220, 0), (230, 0), (240, 1), (250, 1), (260, 1), (270, 1), (280, 1), (290, 1), (300, 0), (310, 0), (320, 0), (330, 0), (340, 0), (350, 0), (360, 0), (370, 0), (380, 0), (390, 0), (400, 0), (410, 0), (420, 0), (430, 1), (440, 0), (450, 0), (460, 0), (470, 1), (480, 1), (490, 1), (500, 1), (510, 0), (520, 0), (530, 1), (540, 1), (550, 1), (560, 1), (570, 1), (580, 1), (590, 1), (600, 1), (610, 1), (620, 1), (630, 1), (640, 0), (650, 0), (660, 0), (670, 0), (680, 0), (690, 0), (700, 1), (710, 1), (720, 0), (730, 0), (740, 1), (750, 1), (760, 0), (770, 1), (780, 1), (790, 0), (800, 0), (810, 1), (820, 1), (830, 1), (840, 1), (850, 1), (860, 0), (870, 1), (880, 1), (890, 1), (900, 1), (910, 1), (920, 1), (930, 0), (940, 0), (950, 0), (960, 0), (970, 1), (980, 0), (990, 0), (1000, 0), (1010, 0), (1020, 0), (1030, 0), (1040, 0), (1050, 0), (1060, 0), (1070, 0), (1080, 0), (1090, 1), (1100, 0), (1110, 1), (1120, 1), (1130, 1), (1140, 1), (1150, 0), (1160, 0), (1170, 0), (1180, 1), (1190, 1), (1200, 0), (1210, 1), (1220, 0), (1230, 0), (1240, 1), (1250, 1), (1260, 1), (1270, 0), (1280, 0), (1290, 0), (1300, 0), (1310, 0), (1320, 1), (1330, 1), (1340, 1), (1350, 1), (1360, 1), (1370, 1), (1380, 1), (1390, 1), (1400, 1), (1410, 1), (1420, 1), (1430, 1), (1440, 0), (1450, 0), (1460, 0), (1470, 1), (1480, 1), (1490, 1), (1500, 1), (1510, 0), (1520, 0), (1530, 1), (1540, 1), (1550, 0), (1560, 0), (1570, 1), (1580, 0), (1590, 0), (1600, 0), (1610, 1), (1620, 1), (1630, 1), (1640, 1), (1650, 1), (1660, 1), (1670, 0), (1680, 0), (1690, 1), (1700, 0), (1710, 0), (1720, 0), (1730, 0), (1740, 0), (1750, 0), (1760, 0), (1770, 1), (1780, 0), (1790, 1), (1800, 0), (1810, 0), (1820, 0), (1830, 1), (1840, 1), (1850, 1), (1860, 0), (1870, 0), (1880, 0), (1890, 0), (1900, 0), (1910, 0), (1920, 1), (1930, 1), (1940, 0), (1950, 1), (1960, 1), (1970, 1), (1980, 1), (1990, 0), (2000, 0), (2010, 0), (2020, 0), (2030, 0), (2040, 0), (2050, 0)]
Vdin0_1  din0_1  0 PWL (0n 0.0v 9.495n 0.0v 9.505n 0.0v 19.495n 0.0v 19.505n 1.7v 29.495n 1.7v 29.505n 1.7v 39.495n 1.7v 39.505n 1.7v 49.495n 1.7v 49.505n 1.7v 59.495n 1.7v 59.505n 1.7v 69.495n 1.7v 69.505n 0.0v 79.495n 0.0v 79.505n 1.7v 89.495n 1.7v 89.505n 1.7v 99.495n 1.7v 99.505n 1.7v 109.495n 1.7v 109.505n 1.7v 119.495n 1.7v 119.505n 0.0v 129.495n 0.0v 129.505n 0.0v 139.495n 0.0v 139.505n 0.0v 149.495n 0.0v 149.505n 0.0v 159.495n 0.0v 159.505n 0.0v 169.495n 0.0v 169.505n 0.0v 179.495n 0.0v 179.505n 1.7v 189.495n 1.7v 189.505n 1.7v 199.495n 1.7v 199.505n 1.7v 209.495n 1.7v 209.505n 0.0v 219.495n 0.0v 219.505n 0.0v 229.495n 0.0v 229.505n 0.0v 239.495n 0.0v 239.505n 1.7v 249.495n 1.7v 249.505n 1.7v 259.495n 1.7v 259.505n 1.7v 269.495n 1.7v 269.505n 1.7v 279.495n 1.7v 279.505n 1.7v 289.495n 1.7v 289.505n 1.7v 299.495n 1.7v 299.505n 0.0v 309.495n 0.0v 309.505n 0.0v 319.495n 0.0v 319.505n 0.0v 329.495n 0.0v 329.505n 0.0v 339.495n 0.0v 339.505n 0.0v 349.495n 0.0v 349.505n 0.0v 359.495n 0.0v 359.505n 0.0v 369.495n 0.0v 369.505n 0.0v 379.495n 0.0v 379.505n 0.0v 389.495n 0.0v 389.505n 0.0v 399.495n 0.0v 399.505n 0.0v 409.495n 0.0v 409.505n 0.0v 419.495n 0.0v 419.505n 0.0v 429.495n 0.0v 429.505n 1.7v 439.495n 1.7v 439.505n 0.0v 449.495n 0.0v 449.505n 0.0v 459.495n 0.0v 459.505n 0.0v 469.495n 0.0v 469.505n 1.7v 479.495n 1.7v 479.505n 1.7v 489.495n 1.7v 489.505n 1.7v 499.495n 1.7v 499.505n 1.7v 509.495n 1.7v 509.505n 0.0v 519.495n 0.0v 519.505n 0.0v 529.495n 0.0v 529.505n 1.7v 539.495n 1.7v 539.505n 1.7v 549.495n 1.7v 549.505n 1.7v 559.495n 1.7v 559.505n 1.7v 569.495n 1.7v 569.505n 1.7v 579.495n 1.7v 579.505n 1.7v 589.495n 1.7v 589.505n 1.7v 599.495n 1.7v 599.505n 1.7v 609.495n 1.7v 609.505n 1.7v 619.495n 1.7v 619.505n 1.7v 629.495n 1.7v 629.505n 1.7v 639.495n 1.7v 639.505n 0.0v 649.495n 0.0v 649.505n 0.0v 659.495n 0.0v 659.505n 0.0v 669.495n 0.0v 669.505n 0.0v 679.495n 0.0v 679.505n 0.0v 689.495n 0.0v 689.505n 0.0v 699.495n 0.0v 699.505n 1.7v 709.495n 1.7v 709.505n 1.7v 719.495n 1.7v 719.505n 0.0v 729.495n 0.0v 729.505n 0.0v 739.495n 0.0v 739.505n 1.7v 749.495n 1.7v 749.505n 1.7v 759.495n 1.7v 759.505n 0.0v 769.495n 0.0v 769.505n 1.7v 779.495n 1.7v 779.505n 1.7v 789.495n 1.7v 789.505n 0.0v 799.495n 0.0v 799.505n 0.0v 809.495n 0.0v 809.505n 1.7v 819.495n 1.7v 819.505n 1.7v 829.495n 1.7v 829.505n 1.7v 839.495n 1.7v 839.505n 1.7v 849.495n 1.7v 849.505n 1.7v 859.495n 1.7v 859.505n 0.0v 869.495n 0.0v 869.505n 1.7v 879.495n 1.7v 879.505n 1.7v 889.495n 1.7v 889.505n 1.7v 899.495n 1.7v 899.505n 1.7v 909.495n 1.7v 909.505n 1.7v 919.495n 1.7v 919.505n 1.7v 929.495n 1.7v 929.505n 0.0v 939.495n 0.0v 939.505n 0.0v 949.495n 0.0v 949.505n 0.0v 959.495n 0.0v 959.505n 0.0v 969.495n 0.0v 969.505n 1.7v 979.495n 1.7v 979.505n 0.0v 989.495n 0.0v 989.505n 0.0v 999.495n 0.0v 999.505n 0.0v 1009.495n 0.0v 1009.505n 0.0v 1019.495n 0.0v 1019.505n 0.0v 1029.495n 0.0v 1029.505n 0.0v 1039.495n 0.0v 1039.505n 0.0v 1049.495n 0.0v 1049.505n 0.0v 1059.495n 0.0v 1059.505n 0.0v 1069.495n 0.0v 1069.505n 0.0v 1079.495n 0.0v 1079.505n 0.0v 1089.495n 0.0v 1089.505n 1.7v 1099.495n 1.7v 1099.505n 0.0v 1109.495n 0.0v 1109.505n 1.7v 1119.495n 1.7v 1119.505n 1.7v 1129.495n 1.7v 1129.505n 1.7v 1139.495n 1.7v 1139.505n 1.7v 1149.495n 1.7v 1149.505n 0.0v 1159.495n 0.0v 1159.505n 0.0v 1169.495n 0.0v 1169.505n 0.0v 1179.495n 0.0v 1179.505n 1.7v 1189.495n 1.7v 1189.505n 1.7v 1199.495n 1.7v 1199.505n 0.0v 1209.495n 0.0v 1209.505n 1.7v 1219.495n 1.7v 1219.505n 0.0v 1229.495n 0.0v 1229.505n 0.0v 1239.495n 0.0v 1239.505n 1.7v 1249.495n 1.7v 1249.505n 1.7v 1259.495n 1.7v 1259.505n 1.7v 1269.495n 1.7v 1269.505n 0.0v 1279.495n 0.0v 1279.505n 0.0v 1289.495n 0.0v 1289.505n 0.0v 1299.495n 0.0v 1299.505n 0.0v 1309.495n 0.0v 1309.505n 0.0v 1319.495n 0.0v 1319.505n 1.7v 1329.495n 1.7v 1329.505n 1.7v 1339.495n 1.7v 1339.505n 1.7v 1349.495n 1.7v 1349.505n 1.7v 1359.495n 1.7v 1359.505n 1.7v 1369.495n 1.7v 1369.505n 1.7v 1379.495n 1.7v 1379.505n 1.7v 1389.495n 1.7v 1389.505n 1.7v 1399.495n 1.7v 1399.505n 1.7v 1409.495n 1.7v 1409.505n 1.7v 1419.495n 1.7v 1419.505n 1.7v 1429.495n 1.7v 1429.505n 1.7v 1439.495n 1.7v 1439.505n 0.0v 1449.495n 0.0v 1449.505n 0.0v 1459.495n 0.0v 1459.505n 0.0v 1469.495n 0.0v 1469.505n 1.7v 1479.495n 1.7v 1479.505n 1.7v 1489.495n 1.7v 1489.505n 1.7v 1499.495n 1.7v 1499.505n 1.7v 1509.495n 1.7v 1509.505n 0.0v 1519.495n 0.0v 1519.505n 0.0v 1529.495n 0.0v 1529.505n 1.7v 1539.495n 1.7v 1539.505n 1.7v 1549.495n 1.7v 1549.505n 0.0v 1559.495n 0.0v 1559.505n 0.0v 1569.495n 0.0v 1569.505n 1.7v 1579.495n 1.7v 1579.505n 0.0v 1589.495n 0.0v 1589.505n 0.0v 1599.495n 0.0v 1599.505n 0.0v 1609.495n 0.0v 1609.505n 1.7v 1619.495n 1.7v 1619.505n 1.7v 1629.495n 1.7v 1629.505n 1.7v 1639.495n 1.7v 1639.505n 1.7v 1649.495n 1.7v 1649.505n 1.7v 1659.495n 1.7v 1659.505n 1.7v 1669.495n 1.7v 1669.505n 0.0v 1679.495n 0.0v 1679.505n 0.0v 1689.495n 0.0v 1689.505n 1.7v 1699.495n 1.7v 1699.505n 0.0v 1709.495n 0.0v 1709.505n 0.0v 1719.495n 0.0v 1719.505n 0.0v 1729.495n 0.0v 1729.505n 0.0v 1739.495n 0.0v 1739.505n 0.0v 1749.495n 0.0v 1749.505n 0.0v 1759.495n 0.0v 1759.505n 0.0v 1769.495n 0.0v 1769.505n 1.7v 1779.495n 1.7v 1779.505n 0.0v 1789.495n 0.0v 1789.505n 1.7v 1799.495n 1.7v 1799.505n 0.0v 1809.495n 0.0v 1809.505n 0.0v 1819.495n 0.0v 1819.505n 0.0v 1829.495n 0.0v 1829.505n 1.7v 1839.495n 1.7v 1839.505n 1.7v 1849.495n 1.7v 1849.505n 1.7v 1859.495n 1.7v 1859.505n 0.0v 1869.495n 0.0v 1869.505n 0.0v 1879.495n 0.0v 1879.505n 0.0v 1889.495n 0.0v 1889.505n 0.0v 1899.495n 0.0v 1899.505n 0.0v 1909.495n 0.0v 1909.505n 0.0v 1919.495n 0.0v 1919.505n 1.7v 1929.495n 1.7v 1929.505n 1.7v 1939.495n 1.7v 1939.505n 0.0v 1949.495n 0.0v 1949.505n 1.7v 1959.495n 1.7v 1959.505n 1.7v 1969.495n 1.7v 1969.505n 1.7v 1979.495n 1.7v 1979.505n 1.7v 1989.495n 1.7v 1989.505n 0.0v 1999.495n 0.0v 1999.505n 0.0v 2009.495n 0.0v 2009.505n 0.0v 2019.495n 0.0v 2019.505n 0.0v 2029.495n 0.0v 2029.505n 0.0v 2039.495n 0.0v 2039.505n 0.0v 2049.495n 0.0v 2049.505n 0.0v )
* (time, data): [(0, 0), (10, 0), (20, 1), (30, 1), (40, 1), (50, 0), (60, 0), (70, 1), (80, 1), (90, 1), (100, 1), (110, 1), (120, 1), (130, 0), (140, 0), (150, 0), (160, 0), (170, 0), (180, 0), (190, 0), (200, 0), (210, 0), (220, 0), (230, 0), (240, 1), (250, 1), (260, 1), (270, 0), (280, 0), (290, 0), (300, 1), (310, 0), (320, 1), (330, 0), (340, 0), (350, 0), (360, 0), (370, 0), (380, 0), (390, 0), (400, 0), (410, 0), (420, 0), (430, 1), (440, 1), (450, 1), (460, 1), (470, 0), (480, 0), (490, 0), (500, 0), (510, 0), (520, 1), (530, 0), (540, 0), (550, 0), (560, 0), (570, 0), (580, 0), (590, 0), (600, 0), (610, 0), (620, 0), (630, 0), (640, 0), (650, 0), (660, 1), (670, 1), (680, 1), (690, 0), (700, 1), (710, 0), (720, 1), (730, 1), (740, 0), (750, 0), (760, 1), (770, 0), (780, 0), (790, 1), (800, 1), (810, 0), (820, 0), (830, 0), (840, 0), (850, 1), (860, 1), (870, 1), (880, 1), (890, 1), (900, 1), (910, 1), (920, 1), (930, 1), (940, 1), (950, 1), (960, 1), (970, 1), (980, 1), (990, 1), (1000, 1), (1010, 1), (1020, 1), (1030, 1), (1040, 0), (1050, 0), (1060, 0), (1070, 0), (1080, 0), (1090, 1), (1100, 1), (1110, 1), (1120, 1), (1130, 1), (1140, 0), (1150, 0), (1160, 0), (1170, 1), (1180, 1), (1190, 1), (1200, 1), (1210, 1), (1220, 1), (1230, 1), (1240, 1), (1250, 1), (1260, 1), (1270, 1), (1280, 1), (1290, 0), (1300, 0), (1310, 0), (1320, 1), (1330, 1), (1340, 0), (1350, 1), (1360, 1), (1370, 1), (1380, 0), (1390, 0), (1400, 1), (1410, 0), (1420, 0), (1430, 0), (1440, 0), (1450, 1), (1460, 0), (1470, 1), (1480, 1), (1490, 1), (1500, 1), (1510, 1), (1520, 1), (1530, 1), (1540, 1), (1550, 0), (1560, 0), (1570, 1), (1580, 0), (1590, 0), (1600, 0), (1610, 0), (1620, 0), (1630, 0), (1640, 0), (1650, 0), (1660, 0), (1670, 0), (1680, 0), (1690, 1), (1700, 1), (1710, 1), (1720, 0), (1730, 0), (1740, 1), (1750, 1), (1760, 1), (1770, 0), (1780, 1), (1790, 0), (1800, 0), (1810, 1), (1820, 0), (1830, 1), (1840, 0), (1850, 0), (1860, 1), (1870, 1), (1880, 0), (1890, 0), (1900, 1), (1910, 0), (1920, 0), (1930, 0), (1940, 1), (1950, 0), (1960, 0), (1970, 0), (1980, 0), (1990, 0), (2000, 0), (2010, 0), (2020, 0), (2030, 1), (2040, 1), (2050, 1)]
Vdin0_2  din0_2  0 PWL (0n 0.0v 9.495n 0.0v 9.505n 0.0v 19.495n 0.0v 19.505n 1.7v 29.495n 1.7v 29.505n 1.7v 39.495n 1.7v 39.505n 1.7v 49.495n 1.7v 49.505n 0.0v 59.495n 0.0v 59.505n 0.0v 69.495n 0.0v 69.505n 1.7v 79.495n 1.7v 79.505n 1.7v 89.495n 1.7v 89.505n 1.7v 99.495n 1.7v 99.505n 1.7v 109.495n 1.7v 109.505n 1.7v 119.495n 1.7v 119.505n 1.7v 129.495n 1.7v 129.505n 0.0v 139.495n 0.0v 139.505n 0.0v 149.495n 0.0v 149.505n 0.0v 159.495n 0.0v 159.505n 0.0v 169.495n 0.0v 169.505n 0.0v 179.495n 0.0v 179.505n 0.0v 189.495n 0.0v 189.505n 0.0v 199.495n 0.0v 199.505n 0.0v 209.495n 0.0v 209.505n 0.0v 219.495n 0.0v 219.505n 0.0v 229.495n 0.0v 229.505n 0.0v 239.495n 0.0v 239.505n 1.7v 249.495n 1.7v 249.505n 1.7v 259.495n 1.7v 259.505n 1.7v 269.495n 1.7v 269.505n 0.0v 279.495n 0.0v 279.505n 0.0v 289.495n 0.0v 289.505n 0.0v 299.495n 0.0v 299.505n 1.7v 309.495n 1.7v 309.505n 0.0v 319.495n 0.0v 319.505n 1.7v 329.495n 1.7v 329.505n 0.0v 339.495n 0.0v 339.505n 0.0v 349.495n 0.0v 349.505n 0.0v 359.495n 0.0v 359.505n 0.0v 369.495n 0.0v 369.505n 0.0v 379.495n 0.0v 379.505n 0.0v 389.495n 0.0v 389.505n 0.0v 399.495n 0.0v 399.505n 0.0v 409.495n 0.0v 409.505n 0.0v 419.495n 0.0v 419.505n 0.0v 429.495n 0.0v 429.505n 1.7v 439.495n 1.7v 439.505n 1.7v 449.495n 1.7v 449.505n 1.7v 459.495n 1.7v 459.505n 1.7v 469.495n 1.7v 469.505n 0.0v 479.495n 0.0v 479.505n 0.0v 489.495n 0.0v 489.505n 0.0v 499.495n 0.0v 499.505n 0.0v 509.495n 0.0v 509.505n 0.0v 519.495n 0.0v 519.505n 1.7v 529.495n 1.7v 529.505n 0.0v 539.495n 0.0v 539.505n 0.0v 549.495n 0.0v 549.505n 0.0v 559.495n 0.0v 559.505n 0.0v 569.495n 0.0v 569.505n 0.0v 579.495n 0.0v 579.505n 0.0v 589.495n 0.0v 589.505n 0.0v 599.495n 0.0v 599.505n 0.0v 609.495n 0.0v 609.505n 0.0v 619.495n 0.0v 619.505n 0.0v 629.495n 0.0v 629.505n 0.0v 639.495n 0.0v 639.505n 0.0v 649.495n 0.0v 649.505n 0.0v 659.495n 0.0v 659.505n 1.7v 669.495n 1.7v 669.505n 1.7v 679.495n 1.7v 679.505n 1.7v 689.495n 1.7v 689.505n 0.0v 699.495n 0.0v 699.505n 1.7v 709.495n 1.7v 709.505n 0.0v 719.495n 0.0v 719.505n 1.7v 729.495n 1.7v 729.505n 1.7v 739.495n 1.7v 739.505n 0.0v 749.495n 0.0v 749.505n 0.0v 759.495n 0.0v 759.505n 1.7v 769.495n 1.7v 769.505n 0.0v 779.495n 0.0v 779.505n 0.0v 789.495n 0.0v 789.505n 1.7v 799.495n 1.7v 799.505n 1.7v 809.495n 1.7v 809.505n 0.0v 819.495n 0.0v 819.505n 0.0v 829.495n 0.0v 829.505n 0.0v 839.495n 0.0v 839.505n 0.0v 849.495n 0.0v 849.505n 1.7v 859.495n 1.7v 859.505n 1.7v 869.495n 1.7v 869.505n 1.7v 879.495n 1.7v 879.505n 1.7v 889.495n 1.7v 889.505n 1.7v 899.495n 1.7v 899.505n 1.7v 909.495n 1.7v 909.505n 1.7v 919.495n 1.7v 919.505n 1.7v 929.495n 1.7v 929.505n 1.7v 939.495n 1.7v 939.505n 1.7v 949.495n 1.7v 949.505n 1.7v 959.495n 1.7v 959.505n 1.7v 969.495n 1.7v 969.505n 1.7v 979.495n 1.7v 979.505n 1.7v 989.495n 1.7v 989.505n 1.7v 999.495n 1.7v 999.505n 1.7v 1009.495n 1.7v 1009.505n 1.7v 1019.495n 1.7v 1019.505n 1.7v 1029.495n 1.7v 1029.505n 1.7v 1039.495n 1.7v 1039.505n 0.0v 1049.495n 0.0v 1049.505n 0.0v 1059.495n 0.0v 1059.505n 0.0v 1069.495n 0.0v 1069.505n 0.0v 1079.495n 0.0v 1079.505n 0.0v 1089.495n 0.0v 1089.505n 1.7v 1099.495n 1.7v 1099.505n 1.7v 1109.495n 1.7v 1109.505n 1.7v 1119.495n 1.7v 1119.505n 1.7v 1129.495n 1.7v 1129.505n 1.7v 1139.495n 1.7v 1139.505n 0.0v 1149.495n 0.0v 1149.505n 0.0v 1159.495n 0.0v 1159.505n 0.0v 1169.495n 0.0v 1169.505n 1.7v 1179.495n 1.7v 1179.505n 1.7v 1189.495n 1.7v 1189.505n 1.7v 1199.495n 1.7v 1199.505n 1.7v 1209.495n 1.7v 1209.505n 1.7v 1219.495n 1.7v 1219.505n 1.7v 1229.495n 1.7v 1229.505n 1.7v 1239.495n 1.7v 1239.505n 1.7v 1249.495n 1.7v 1249.505n 1.7v 1259.495n 1.7v 1259.505n 1.7v 1269.495n 1.7v 1269.505n 1.7v 1279.495n 1.7v 1279.505n 1.7v 1289.495n 1.7v 1289.505n 0.0v 1299.495n 0.0v 1299.505n 0.0v 1309.495n 0.0v 1309.505n 0.0v 1319.495n 0.0v 1319.505n 1.7v 1329.495n 1.7v 1329.505n 1.7v 1339.495n 1.7v 1339.505n 0.0v 1349.495n 0.0v 1349.505n 1.7v 1359.495n 1.7v 1359.505n 1.7v 1369.495n 1.7v 1369.505n 1.7v 1379.495n 1.7v 1379.505n 0.0v 1389.495n 0.0v 1389.505n 0.0v 1399.495n 0.0v 1399.505n 1.7v 1409.495n 1.7v 1409.505n 0.0v 1419.495n 0.0v 1419.505n 0.0v 1429.495n 0.0v 1429.505n 0.0v 1439.495n 0.0v 1439.505n 0.0v 1449.495n 0.0v 1449.505n 1.7v 1459.495n 1.7v 1459.505n 0.0v 1469.495n 0.0v 1469.505n 1.7v 1479.495n 1.7v 1479.505n 1.7v 1489.495n 1.7v 1489.505n 1.7v 1499.495n 1.7v 1499.505n 1.7v 1509.495n 1.7v 1509.505n 1.7v 1519.495n 1.7v 1519.505n 1.7v 1529.495n 1.7v 1529.505n 1.7v 1539.495n 1.7v 1539.505n 1.7v 1549.495n 1.7v 1549.505n 0.0v 1559.495n 0.0v 1559.505n 0.0v 1569.495n 0.0v 1569.505n 1.7v 1579.495n 1.7v 1579.505n 0.0v 1589.495n 0.0v 1589.505n 0.0v 1599.495n 0.0v 1599.505n 0.0v 1609.495n 0.0v 1609.505n 0.0v 1619.495n 0.0v 1619.505n 0.0v 1629.495n 0.0v 1629.505n 0.0v 1639.495n 0.0v 1639.505n 0.0v 1649.495n 0.0v 1649.505n 0.0v 1659.495n 0.0v 1659.505n 0.0v 1669.495n 0.0v 1669.505n 0.0v 1679.495n 0.0v 1679.505n 0.0v 1689.495n 0.0v 1689.505n 1.7v 1699.495n 1.7v 1699.505n 1.7v 1709.495n 1.7v 1709.505n 1.7v 1719.495n 1.7v 1719.505n 0.0v 1729.495n 0.0v 1729.505n 0.0v 1739.495n 0.0v 1739.505n 1.7v 1749.495n 1.7v 1749.505n 1.7v 1759.495n 1.7v 1759.505n 1.7v 1769.495n 1.7v 1769.505n 0.0v 1779.495n 0.0v 1779.505n 1.7v 1789.495n 1.7v 1789.505n 0.0v 1799.495n 0.0v 1799.505n 0.0v 1809.495n 0.0v 1809.505n 1.7v 1819.495n 1.7v 1819.505n 0.0v 1829.495n 0.0v 1829.505n 1.7v 1839.495n 1.7v 1839.505n 0.0v 1849.495n 0.0v 1849.505n 0.0v 1859.495n 0.0v 1859.505n 1.7v 1869.495n 1.7v 1869.505n 1.7v 1879.495n 1.7v 1879.505n 0.0v 1889.495n 0.0v 1889.505n 0.0v 1899.495n 0.0v 1899.505n 1.7v 1909.495n 1.7v 1909.505n 0.0v 1919.495n 0.0v 1919.505n 0.0v 1929.495n 0.0v 1929.505n 0.0v 1939.495n 0.0v 1939.505n 1.7v 1949.495n 1.7v 1949.505n 0.0v 1959.495n 0.0v 1959.505n 0.0v 1969.495n 0.0v 1969.505n 0.0v 1979.495n 0.0v 1979.505n 0.0v 1989.495n 0.0v 1989.505n 0.0v 1999.495n 0.0v 1999.505n 0.0v 2009.495n 0.0v 2009.505n 0.0v 2019.495n 0.0v 2019.505n 0.0v 2029.495n 0.0v 2029.505n 1.7v 2039.495n 1.7v 2039.505n 1.7v 2049.495n 1.7v 2049.505n 1.7v )
* (time, data): [(0, 0), (10, 0), (20, 0), (30, 1), (40, 1), (50, 0), (60, 0), (70, 1), (80, 1), (90, 1), (100, 1), (110, 1), (120, 1), (130, 0), (140, 0), (150, 0), (160, 0), (170, 0), (180, 1), (190, 1), (200, 1), (210, 1), (220, 1), (230, 1), (240, 0), (250, 0), (260, 0), (270, 1), (280, 1), (290, 1), (300, 1), (310, 0), (320, 1), (330, 0), (340, 0), (350, 0), (360, 0), (370, 0), (380, 0), (390, 0), (400, 0), (410, 0), (420, 0), (430, 1), (440, 1), (450, 1), (460, 1), (470, 1), (480, 1), (490, 1), (500, 1), (510, 1), (520, 1), (530, 1), (540, 0), (550, 1), (560, 1), (570, 1), (580, 1), (590, 0), (600, 0), (610, 0), (620, 0), (630, 1), (640, 0), (650, 0), (660, 1), (670, 0), (680, 0), (690, 0), (700, 0), (710, 1), (720, 1), (730, 1), (740, 0), (750, 0), (760, 1), (770, 0), (780, 0), (790, 1), (800, 1), (810, 0), (820, 0), (830, 0), (840, 0), (850, 0), (860, 0), (870, 0), (880, 0), (890, 0), (900, 0), (910, 0), (920, 0), (930, 0), (940, 1), (950, 1), (960, 1), (970, 1), (980, 1), (990, 1), (1000, 1), (1010, 1), (1020, 1), (1030, 1), (1040, 0), (1050, 0), (1060, 0), (1070, 0), (1080, 0), (1090, 0), (1100, 1), (1110, 0), (1120, 0), (1130, 0), (1140, 0), (1150, 0), (1160, 1), (1170, 1), (1180, 0), (1190, 0), (1200, 1), (1210, 0), (1220, 1), (1230, 0), (1240, 1), (1250, 1), (1260, 1), (1270, 0), (1280, 0), (1290, 0), (1300, 0), (1310, 0), (1320, 1), (1330, 1), (1340, 0), (1350, 0), (1360, 0), (1370, 0), (1380, 1), (1390, 1), (1400, 0), (1410, 1), (1420, 1), (1430, 1), (1440, 0), (1450, 0), (1460, 0), (1470, 1), (1480, 1), (1490, 1), (1500, 1), (1510, 1), (1520, 1), (1530, 0), (1540, 0), (1550, 0), (1560, 0), (1570, 0), (1580, 0), (1590, 0), (1600, 0), (1610, 0), (1620, 0), (1630, 0), (1640, 0), (1650, 0), (1660, 0), (1670, 0), (1680, 1), (1690, 0), (1700, 0), (1710, 1), (1720, 0), (1730, 0), (1740, 1), (1750, 1), (1760, 1), (1770, 0), (1780, 0), (1790, 1), (1800, 0), (1810, 0), (1820, 0), (1830, 1), (1840, 0), (1850, 0), (1860, 0), (1870, 0), (1880, 1), (1890, 1), (1900, 0), (1910, 0), (1920, 0), (1930, 0), (1940, 0), (1950, 1), (1960, 1), (1970, 1), (1980, 1), (1990, 0), (2000, 0), (2010, 0), (2020, 0), (2030, 0), (2040, 0), (2050, 0)]
Vdin0_3  din0_3  0 PWL (0n 0.0v 9.495n 0.0v 9.505n 0.0v 19.495n 0.0v 19.505n 0.0v 29.495n 0.0v 29.505n 1.7v 39.495n 1.7v 39.505n 1.7v 49.495n 1.7v 49.505n 0.0v 59.495n 0.0v 59.505n 0.0v 69.495n 0.0v 69.505n 1.7v 79.495n 1.7v 79.505n 1.7v 89.495n 1.7v 89.505n 1.7v 99.495n 1.7v 99.505n 1.7v 109.495n 1.7v 109.505n 1.7v 119.495n 1.7v 119.505n 1.7v 129.495n 1.7v 129.505n 0.0v 139.495n 0.0v 139.505n 0.0v 149.495n 0.0v 149.505n 0.0v 159.495n 0.0v 159.505n 0.0v 169.495n 0.0v 169.505n 0.0v 179.495n 0.0v 179.505n 1.7v 189.495n 1.7v 189.505n 1.7v 199.495n 1.7v 199.505n 1.7v 209.495n 1.7v 209.505n 1.7v 219.495n 1.7v 219.505n 1.7v 229.495n 1.7v 229.505n 1.7v 239.495n 1.7v 239.505n 0.0v 249.495n 0.0v 249.505n 0.0v 259.495n 0.0v 259.505n 0.0v 269.495n 0.0v 269.505n 1.7v 279.495n 1.7v 279.505n 1.7v 289.495n 1.7v 289.505n 1.7v 299.495n 1.7v 299.505n 1.7v 309.495n 1.7v 309.505n 0.0v 319.495n 0.0v 319.505n 1.7v 329.495n 1.7v 329.505n 0.0v 339.495n 0.0v 339.505n 0.0v 349.495n 0.0v 349.505n 0.0v 359.495n 0.0v 359.505n 0.0v 369.495n 0.0v 369.505n 0.0v 379.495n 0.0v 379.505n 0.0v 389.495n 0.0v 389.505n 0.0v 399.495n 0.0v 399.505n 0.0v 409.495n 0.0v 409.505n 0.0v 419.495n 0.0v 419.505n 0.0v 429.495n 0.0v 429.505n 1.7v 439.495n 1.7v 439.505n 1.7v 449.495n 1.7v 449.505n 1.7v 459.495n 1.7v 459.505n 1.7v 469.495n 1.7v 469.505n 1.7v 479.495n 1.7v 479.505n 1.7v 489.495n 1.7v 489.505n 1.7v 499.495n 1.7v 499.505n 1.7v 509.495n 1.7v 509.505n 1.7v 519.495n 1.7v 519.505n 1.7v 529.495n 1.7v 529.505n 1.7v 539.495n 1.7v 539.505n 0.0v 549.495n 0.0v 549.505n 1.7v 559.495n 1.7v 559.505n 1.7v 569.495n 1.7v 569.505n 1.7v 579.495n 1.7v 579.505n 1.7v 589.495n 1.7v 589.505n 0.0v 599.495n 0.0v 599.505n 0.0v 609.495n 0.0v 609.505n 0.0v 619.495n 0.0v 619.505n 0.0v 629.495n 0.0v 629.505n 1.7v 639.495n 1.7v 639.505n 0.0v 649.495n 0.0v 649.505n 0.0v 659.495n 0.0v 659.505n 1.7v 669.495n 1.7v 669.505n 0.0v 679.495n 0.0v 679.505n 0.0v 689.495n 0.0v 689.505n 0.0v 699.495n 0.0v 699.505n 0.0v 709.495n 0.0v 709.505n 1.7v 719.495n 1.7v 719.505n 1.7v 729.495n 1.7v 729.505n 1.7v 739.495n 1.7v 739.505n 0.0v 749.495n 0.0v 749.505n 0.0v 759.495n 0.0v 759.505n 1.7v 769.495n 1.7v 769.505n 0.0v 779.495n 0.0v 779.505n 0.0v 789.495n 0.0v 789.505n 1.7v 799.495n 1.7v 799.505n 1.7v 809.495n 1.7v 809.505n 0.0v 819.495n 0.0v 819.505n 0.0v 829.495n 0.0v 829.505n 0.0v 839.495n 0.0v 839.505n 0.0v 849.495n 0.0v 849.505n 0.0v 859.495n 0.0v 859.505n 0.0v 869.495n 0.0v 869.505n 0.0v 879.495n 0.0v 879.505n 0.0v 889.495n 0.0v 889.505n 0.0v 899.495n 0.0v 899.505n 0.0v 909.495n 0.0v 909.505n 0.0v 919.495n 0.0v 919.505n 0.0v 929.495n 0.0v 929.505n 0.0v 939.495n 0.0v 939.505n 1.7v 949.495n 1.7v 949.505n 1.7v 959.495n 1.7v 959.505n 1.7v 969.495n 1.7v 969.505n 1.7v 979.495n 1.7v 979.505n 1.7v 989.495n 1.7v 989.505n 1.7v 999.495n 1.7v 999.505n 1.7v 1009.495n 1.7v 1009.505n 1.7v 1019.495n 1.7v 1019.505n 1.7v 1029.495n 1.7v 1029.505n 1.7v 1039.495n 1.7v 1039.505n 0.0v 1049.495n 0.0v 1049.505n 0.0v 1059.495n 0.0v 1059.505n 0.0v 1069.495n 0.0v 1069.505n 0.0v 1079.495n 0.0v 1079.505n 0.0v 1089.495n 0.0v 1089.505n 0.0v 1099.495n 0.0v 1099.505n 1.7v 1109.495n 1.7v 1109.505n 0.0v 1119.495n 0.0v 1119.505n 0.0v 1129.495n 0.0v 1129.505n 0.0v 1139.495n 0.0v 1139.505n 0.0v 1149.495n 0.0v 1149.505n 0.0v 1159.495n 0.0v 1159.505n 1.7v 1169.495n 1.7v 1169.505n 1.7v 1179.495n 1.7v 1179.505n 0.0v 1189.495n 0.0v 1189.505n 0.0v 1199.495n 0.0v 1199.505n 1.7v 1209.495n 1.7v 1209.505n 0.0v 1219.495n 0.0v 1219.505n 1.7v 1229.495n 1.7v 1229.505n 0.0v 1239.495n 0.0v 1239.505n 1.7v 1249.495n 1.7v 1249.505n 1.7v 1259.495n 1.7v 1259.505n 1.7v 1269.495n 1.7v 1269.505n 0.0v 1279.495n 0.0v 1279.505n 0.0v 1289.495n 0.0v 1289.505n 0.0v 1299.495n 0.0v 1299.505n 0.0v 1309.495n 0.0v 1309.505n 0.0v 1319.495n 0.0v 1319.505n 1.7v 1329.495n 1.7v 1329.505n 1.7v 1339.495n 1.7v 1339.505n 0.0v 1349.495n 0.0v 1349.505n 0.0v 1359.495n 0.0v 1359.505n 0.0v 1369.495n 0.0v 1369.505n 0.0v 1379.495n 0.0v 1379.505n 1.7v 1389.495n 1.7v 1389.505n 1.7v 1399.495n 1.7v 1399.505n 0.0v 1409.495n 0.0v 1409.505n 1.7v 1419.495n 1.7v 1419.505n 1.7v 1429.495n 1.7v 1429.505n 1.7v 1439.495n 1.7v 1439.505n 0.0v 1449.495n 0.0v 1449.505n 0.0v 1459.495n 0.0v 1459.505n 0.0v 1469.495n 0.0v 1469.505n 1.7v 1479.495n 1.7v 1479.505n 1.7v 1489.495n 1.7v 1489.505n 1.7v 1499.495n 1.7v 1499.505n 1.7v 1509.495n 1.7v 1509.505n 1.7v 1519.495n 1.7v 1519.505n 1.7v 1529.495n 1.7v 1529.505n 0.0v 1539.495n 0.0v 1539.505n 0.0v 1549.495n 0.0v 1549.505n 0.0v 1559.495n 0.0v 1559.505n 0.0v 1569.495n 0.0v 1569.505n 0.0v 1579.495n 0.0v 1579.505n 0.0v 1589.495n 0.0v 1589.505n 0.0v 1599.495n 0.0v 1599.505n 0.0v 1609.495n 0.0v 1609.505n 0.0v 1619.495n 0.0v 1619.505n 0.0v 1629.495n 0.0v 1629.505n 0.0v 1639.495n 0.0v 1639.505n 0.0v 1649.495n 0.0v 1649.505n 0.0v 1659.495n 0.0v 1659.505n 0.0v 1669.495n 0.0v 1669.505n 0.0v 1679.495n 0.0v 1679.505n 1.7v 1689.495n 1.7v 1689.505n 0.0v 1699.495n 0.0v 1699.505n 0.0v 1709.495n 0.0v 1709.505n 1.7v 1719.495n 1.7v 1719.505n 0.0v 1729.495n 0.0v 1729.505n 0.0v 1739.495n 0.0v 1739.505n 1.7v 1749.495n 1.7v 1749.505n 1.7v 1759.495n 1.7v 1759.505n 1.7v 1769.495n 1.7v 1769.505n 0.0v 1779.495n 0.0v 1779.505n 0.0v 1789.495n 0.0v 1789.505n 1.7v 1799.495n 1.7v 1799.505n 0.0v 1809.495n 0.0v 1809.505n 0.0v 1819.495n 0.0v 1819.505n 0.0v 1829.495n 0.0v 1829.505n 1.7v 1839.495n 1.7v 1839.505n 0.0v 1849.495n 0.0v 1849.505n 0.0v 1859.495n 0.0v 1859.505n 0.0v 1869.495n 0.0v 1869.505n 0.0v 1879.495n 0.0v 1879.505n 1.7v 1889.495n 1.7v 1889.505n 1.7v 1899.495n 1.7v 1899.505n 0.0v 1909.495n 0.0v 1909.505n 0.0v 1919.495n 0.0v 1919.505n 0.0v 1929.495n 0.0v 1929.505n 0.0v 1939.495n 0.0v 1939.505n 0.0v 1949.495n 0.0v 1949.505n 1.7v 1959.495n 1.7v 1959.505n 1.7v 1969.495n 1.7v 1969.505n 1.7v 1979.495n 1.7v 1979.505n 1.7v 1989.495n 1.7v 1989.505n 0.0v 1999.495n 0.0v 1999.505n 0.0v 2009.495n 0.0v 2009.505n 0.0v 2019.495n 0.0v 2019.505n 0.0v 2029.495n 0.0v 2029.505n 0.0v 2039.495n 0.0v 2039.505n 0.0v 2049.495n 0.0v 2049.505n 0.0v )
* (time, data): [(0, 0), (10, 1), (20, 0), (30, 1), (40, 1), (50, 0), (60, 1), (70, 0), (80, 0), (90, 0), (100, 0), (110, 0), (120, 0), (130, 0), (140, 1), (150, 1), (160, 1), (170, 1), (180, 0), (190, 0), (200, 0), (210, 0), (220, 0), (230, 0), (240, 1), (250, 1), (260, 1), (270, 1), (280, 1), (290, 1), (300, 1), (310, 0), (320, 0), (330, 0), (340, 0), (350, 0), (360, 0), (370, 0), (380, 1), (390, 1), (400, 1), (410, 1), (420, 1), (430, 0), (440, 1), (450, 1), (460, 0), (470, 1), (480, 1), (490, 1), (500, 1), (510, 1), (520, 1), (530, 0), (540, 1), (550, 1), (560, 1), (570, 1), (580, 1), (590, 1), (600, 1), (610, 1), (620, 1), (630, 1), (640, 0), (650, 0), (660, 1), (670, 1), (680, 1), (690, 1), (700, 0), (710, 1), (720, 1), (730, 1), (740, 0), (750, 1), (760, 0), (770, 0), (780, 0), (790, 0), (800, 0), (810, 1), (820, 0), (830, 0), (840, 0), (850, 1), (860, 0), (870, 1), (880, 1), (890, 1), (900, 1), (910, 1), (920, 0), (930, 1), (940, 1), (950, 0), (960, 0), (970, 1), (980, 0), (990, 0), (1000, 0), (1010, 0), (1020, 0), (1030, 0), (1040, 0), (1050, 0), (1060, 0), (1070, 0), (1080, 0), (1090, 1), (1100, 0), (1110, 0), (1120, 0), (1130, 0), (1140, 0), (1150, 0), (1160, 0), (1170, 0), (1180, 0), (1190, 0), (1200, 1), (1210, 1), (1220, 0), (1230, 0), (1240, 0), (1250, 0), (1260, 0), (1270, 0), (1280, 0), (1290, 0), (1300, 0), (1310, 0), (1320, 0), (1330, 0), (1340, 0), (1350, 1), (1360, 1), (1370, 0), (1380, 1), (1390, 1), (1400, 0), (1410, 1), (1420, 1), (1430, 1), (1440, 0), (1450, 0), (1460, 1), (1470, 0), (1480, 0), (1490, 0), (1500, 0), (1510, 1), (1520, 1), (1530, 0), (1540, 1), (1550, 0), (1560, 0), (1570, 1), (1580, 0), (1590, 0), (1600, 0), (1610, 0), (1620, 0), (1630, 0), (1640, 1), (1650, 1), (1660, 1), (1670, 1), (1680, 1), (1690, 0), (1700, 1), (1710, 1), (1720, 1), (1730, 1), (1740, 0), (1750, 0), (1760, 1), (1770, 1), (1780, 1), (1790, 1), (1800, 1), (1810, 0), (1820, 1), (1830, 0), (1840, 1), (1850, 1), (1860, 0), (1870, 0), (1880, 0), (1890, 0), (1900, 0), (1910, 0), (1920, 1), (1930, 1), (1940, 0), (1950, 1), (1960, 1), (1970, 0), (1980, 0), (1990, 0), (2000, 0), (2010, 0), (2020, 1), (2030, 1), (2040, 1), (2050, 1)]
Vdin0_4  din0_4  0 PWL (0n 0.0v 9.495n 0.0v 9.505n 1.7v 19.495n 1.7v 19.505n 0.0v 29.495n 0.0v 29.505n 1.7v 39.495n 1.7v 39.505n 1.7v 49.495n 1.7v 49.505n 0.0v 59.495n 0.0v 59.505n 1.7v 69.495n 1.7v 69.505n 0.0v 79.495n 0.0v 79.505n 0.0v 89.495n 0.0v 89.505n 0.0v 99.495n 0.0v 99.505n 0.0v 109.495n 0.0v 109.505n 0.0v 119.495n 0.0v 119.505n 0.0v 129.495n 0.0v 129.505n 0.0v 139.495n 0.0v 139.505n 1.7v 149.495n 1.7v 149.505n 1.7v 159.495n 1.7v 159.505n 1.7v 169.495n 1.7v 169.505n 1.7v 179.495n 1.7v 179.505n 0.0v 189.495n 0.0v 189.505n 0.0v 199.495n 0.0v 199.505n 0.0v 209.495n 0.0v 209.505n 0.0v 219.495n 0.0v 219.505n 0.0v 229.495n 0.0v 229.505n 0.0v 239.495n 0.0v 239.505n 1.7v 249.495n 1.7v 249.505n 1.7v 259.495n 1.7v 259.505n 1.7v 269.495n 1.7v 269.505n 1.7v 279.495n 1.7v 279.505n 1.7v 289.495n 1.7v 289.505n 1.7v 299.495n 1.7v 299.505n 1.7v 309.495n 1.7v 309.505n 0.0v 319.495n 0.0v 319.505n 0.0v 329.495n 0.0v 329.505n 0.0v 339.495n 0.0v 339.505n 0.0v 349.495n 0.0v 349.505n 0.0v 359.495n 0.0v 359.505n 0.0v 369.495n 0.0v 369.505n 0.0v 379.495n 0.0v 379.505n 1.7v 389.495n 1.7v 389.505n 1.7v 399.495n 1.7v 399.505n 1.7v 409.495n 1.7v 409.505n 1.7v 419.495n 1.7v 419.505n 1.7v 429.495n 1.7v 429.505n 0.0v 439.495n 0.0v 439.505n 1.7v 449.495n 1.7v 449.505n 1.7v 459.495n 1.7v 459.505n 0.0v 469.495n 0.0v 469.505n 1.7v 479.495n 1.7v 479.505n 1.7v 489.495n 1.7v 489.505n 1.7v 499.495n 1.7v 499.505n 1.7v 509.495n 1.7v 509.505n 1.7v 519.495n 1.7v 519.505n 1.7v 529.495n 1.7v 529.505n 0.0v 539.495n 0.0v 539.505n 1.7v 549.495n 1.7v 549.505n 1.7v 559.495n 1.7v 559.505n 1.7v 569.495n 1.7v 569.505n 1.7v 579.495n 1.7v 579.505n 1.7v 589.495n 1.7v 589.505n 1.7v 599.495n 1.7v 599.505n 1.7v 609.495n 1.7v 609.505n 1.7v 619.495n 1.7v 619.505n 1.7v 629.495n 1.7v 629.505n 1.7v 639.495n 1.7v 639.505n 0.0v 649.495n 0.0v 649.505n 0.0v 659.495n 0.0v 659.505n 1.7v 669.495n 1.7v 669.505n 1.7v 679.495n 1.7v 679.505n 1.7v 689.495n 1.7v 689.505n 1.7v 699.495n 1.7v 699.505n 0.0v 709.495n 0.0v 709.505n 1.7v 719.495n 1.7v 719.505n 1.7v 729.495n 1.7v 729.505n 1.7v 739.495n 1.7v 739.505n 0.0v 749.495n 0.0v 749.505n 1.7v 759.495n 1.7v 759.505n 0.0v 769.495n 0.0v 769.505n 0.0v 779.495n 0.0v 779.505n 0.0v 789.495n 0.0v 789.505n 0.0v 799.495n 0.0v 799.505n 0.0v 809.495n 0.0v 809.505n 1.7v 819.495n 1.7v 819.505n 0.0v 829.495n 0.0v 829.505n 0.0v 839.495n 0.0v 839.505n 0.0v 849.495n 0.0v 849.505n 1.7v 859.495n 1.7v 859.505n 0.0v 869.495n 0.0v 869.505n 1.7v 879.495n 1.7v 879.505n 1.7v 889.495n 1.7v 889.505n 1.7v 899.495n 1.7v 899.505n 1.7v 909.495n 1.7v 909.505n 1.7v 919.495n 1.7v 919.505n 0.0v 929.495n 0.0v 929.505n 1.7v 939.495n 1.7v 939.505n 1.7v 949.495n 1.7v 949.505n 0.0v 959.495n 0.0v 959.505n 0.0v 969.495n 0.0v 969.505n 1.7v 979.495n 1.7v 979.505n 0.0v 989.495n 0.0v 989.505n 0.0v 999.495n 0.0v 999.505n 0.0v 1009.495n 0.0v 1009.505n 0.0v 1019.495n 0.0v 1019.505n 0.0v 1029.495n 0.0v 1029.505n 0.0v 1039.495n 0.0v 1039.505n 0.0v 1049.495n 0.0v 1049.505n 0.0v 1059.495n 0.0v 1059.505n 0.0v 1069.495n 0.0v 1069.505n 0.0v 1079.495n 0.0v 1079.505n 0.0v 1089.495n 0.0v 1089.505n 1.7v 1099.495n 1.7v 1099.505n 0.0v 1109.495n 0.0v 1109.505n 0.0v 1119.495n 0.0v 1119.505n 0.0v 1129.495n 0.0v 1129.505n 0.0v 1139.495n 0.0v 1139.505n 0.0v 1149.495n 0.0v 1149.505n 0.0v 1159.495n 0.0v 1159.505n 0.0v 1169.495n 0.0v 1169.505n 0.0v 1179.495n 0.0v 1179.505n 0.0v 1189.495n 0.0v 1189.505n 0.0v 1199.495n 0.0v 1199.505n 1.7v 1209.495n 1.7v 1209.505n 1.7v 1219.495n 1.7v 1219.505n 0.0v 1229.495n 0.0v 1229.505n 0.0v 1239.495n 0.0v 1239.505n 0.0v 1249.495n 0.0v 1249.505n 0.0v 1259.495n 0.0v 1259.505n 0.0v 1269.495n 0.0v 1269.505n 0.0v 1279.495n 0.0v 1279.505n 0.0v 1289.495n 0.0v 1289.505n 0.0v 1299.495n 0.0v 1299.505n 0.0v 1309.495n 0.0v 1309.505n 0.0v 1319.495n 0.0v 1319.505n 0.0v 1329.495n 0.0v 1329.505n 0.0v 1339.495n 0.0v 1339.505n 0.0v 1349.495n 0.0v 1349.505n 1.7v 1359.495n 1.7v 1359.505n 1.7v 1369.495n 1.7v 1369.505n 0.0v 1379.495n 0.0v 1379.505n 1.7v 1389.495n 1.7v 1389.505n 1.7v 1399.495n 1.7v 1399.505n 0.0v 1409.495n 0.0v 1409.505n 1.7v 1419.495n 1.7v 1419.505n 1.7v 1429.495n 1.7v 1429.505n 1.7v 1439.495n 1.7v 1439.505n 0.0v 1449.495n 0.0v 1449.505n 0.0v 1459.495n 0.0v 1459.505n 1.7v 1469.495n 1.7v 1469.505n 0.0v 1479.495n 0.0v 1479.505n 0.0v 1489.495n 0.0v 1489.505n 0.0v 1499.495n 0.0v 1499.505n 0.0v 1509.495n 0.0v 1509.505n 1.7v 1519.495n 1.7v 1519.505n 1.7v 1529.495n 1.7v 1529.505n 0.0v 1539.495n 0.0v 1539.505n 1.7v 1549.495n 1.7v 1549.505n 0.0v 1559.495n 0.0v 1559.505n 0.0v 1569.495n 0.0v 1569.505n 1.7v 1579.495n 1.7v 1579.505n 0.0v 1589.495n 0.0v 1589.505n 0.0v 1599.495n 0.0v 1599.505n 0.0v 1609.495n 0.0v 1609.505n 0.0v 1619.495n 0.0v 1619.505n 0.0v 1629.495n 0.0v 1629.505n 0.0v 1639.495n 0.0v 1639.505n 1.7v 1649.495n 1.7v 1649.505n 1.7v 1659.495n 1.7v 1659.505n 1.7v 1669.495n 1.7v 1669.505n 1.7v 1679.495n 1.7v 1679.505n 1.7v 1689.495n 1.7v 1689.505n 0.0v 1699.495n 0.0v 1699.505n 1.7v 1709.495n 1.7v 1709.505n 1.7v 1719.495n 1.7v 1719.505n 1.7v 1729.495n 1.7v 1729.505n 1.7v 1739.495n 1.7v 1739.505n 0.0v 1749.495n 0.0v 1749.505n 0.0v 1759.495n 0.0v 1759.505n 1.7v 1769.495n 1.7v 1769.505n 1.7v 1779.495n 1.7v 1779.505n 1.7v 1789.495n 1.7v 1789.505n 1.7v 1799.495n 1.7v 1799.505n 1.7v 1809.495n 1.7v 1809.505n 0.0v 1819.495n 0.0v 1819.505n 1.7v 1829.495n 1.7v 1829.505n 0.0v 1839.495n 0.0v 1839.505n 1.7v 1849.495n 1.7v 1849.505n 1.7v 1859.495n 1.7v 1859.505n 0.0v 1869.495n 0.0v 1869.505n 0.0v 1879.495n 0.0v 1879.505n 0.0v 1889.495n 0.0v 1889.505n 0.0v 1899.495n 0.0v 1899.505n 0.0v 1909.495n 0.0v 1909.505n 0.0v 1919.495n 0.0v 1919.505n 1.7v 1929.495n 1.7v 1929.505n 1.7v 1939.495n 1.7v 1939.505n 0.0v 1949.495n 0.0v 1949.505n 1.7v 1959.495n 1.7v 1959.505n 1.7v 1969.495n 1.7v 1969.505n 0.0v 1979.495n 0.0v 1979.505n 0.0v 1989.495n 0.0v 1989.505n 0.0v 1999.495n 0.0v 1999.505n 0.0v 2009.495n 0.0v 2009.505n 0.0v 2019.495n 0.0v 2019.505n 1.7v 2029.495n 1.7v 2029.505n 1.7v 2039.495n 1.7v 2039.505n 1.7v 2049.495n 1.7v 2049.505n 1.7v )
* (time, data): [(0, 0), (10, 1), (20, 0), (30, 0), (40, 0), (50, 1), (60, 0), (70, 1), (80, 0), (90, 0), (100, 0), (110, 0), (120, 0), (130, 1), (140, 0), (150, 0), (160, 0), (170, 0), (180, 1), (190, 1), (200, 1), (210, 0), (220, 0), (230, 0), (240, 1), (250, 1), (260, 1), (270, 0), (280, 0), (290, 0), (300, 0), (310, 0), (320, 0), (330, 1), (340, 1), (350, 1), (360, 1), (370, 1), (380, 0), (390, 0), (400, 0), (410, 0), (420, 0), (430, 1), (440, 1), (450, 1), (460, 1), (470, 0), (480, 0), (490, 0), (500, 0), (510, 0), (520, 1), (530, 0), (540, 1), (550, 1), (560, 1), (570, 1), (580, 1), (590, 1), (600, 1), (610, 1), (620, 1), (630, 1), (640, 0), (650, 0), (660, 0), (670, 0), (680, 0), (690, 1), (700, 1), (710, 0), (720, 0), (730, 0), (740, 1), (750, 0), (760, 1), (770, 1), (780, 1), (790, 1), (800, 1), (810, 0), (820, 0), (830, 0), (840, 0), (850, 0), (860, 1), (870, 0), (880, 0), (890, 0), (900, 0), (910, 0), (920, 0), (930, 1), (940, 0), (950, 1), (960, 1), (970, 0), (980, 0), (990, 0), (1000, 0), (1010, 0), (1020, 0), (1030, 0), (1040, 1), (1050, 1), (1060, 1), (1070, 1), (1080, 1), (1090, 0), (1100, 1), (1110, 0), (1120, 0), (1130, 0), (1140, 0), (1150, 1), (1160, 1), (1170, 0), (1180, 0), (1190, 0), (1200, 0), (1210, 0), (1220, 1), (1230, 1), (1240, 0), (1250, 0), (1260, 0), (1270, 1), (1280, 1), (1290, 0), (1300, 0), (1310, 0), (1320, 1), (1330, 1), (1340, 1), (1350, 1), (1360, 1), (1370, 0), (1380, 1), (1390, 1), (1400, 1), (1410, 1), (1420, 1), (1430, 1), (1440, 0), (1450, 0), (1460, 0), (1470, 1), (1480, 1), (1490, 0), (1500, 0), (1510, 1), (1520, 1), (1530, 0), (1540, 0), (1550, 1), (1560, 1), (1570, 1), (1580, 1), (1590, 1), (1600, 0), (1610, 1), (1620, 1), (1630, 1), (1640, 0), (1650, 0), (1660, 0), (1670, 1), (1680, 1), (1690, 1), (1700, 0), (1710, 1), (1720, 0), (1730, 0), (1740, 1), (1750, 1), (1760, 0), (1770, 1), (1780, 1), (1790, 0), (1800, 1), (1810, 1), (1820, 0), (1830, 0), (1840, 1), (1850, 1), (1860, 0), (1870, 0), (1880, 1), (1890, 1), (1900, 0), (1910, 0), (1920, 0), (1930, 0), (1940, 1), (1950, 0), (1960, 0), (1970, 1), (1980, 1), (1990, 1), (2000, 1), (2010, 1), (2020, 0), (2030, 1), (2040, 1), (2050, 1)]
Vdin0_5  din0_5  0 PWL (0n 0.0v 9.495n 0.0v 9.505n 1.7v 19.495n 1.7v 19.505n 0.0v 29.495n 0.0v 29.505n 0.0v 39.495n 0.0v 39.505n 0.0v 49.495n 0.0v 49.505n 1.7v 59.495n 1.7v 59.505n 0.0v 69.495n 0.0v 69.505n 1.7v 79.495n 1.7v 79.505n 0.0v 89.495n 0.0v 89.505n 0.0v 99.495n 0.0v 99.505n 0.0v 109.495n 0.0v 109.505n 0.0v 119.495n 0.0v 119.505n 0.0v 129.495n 0.0v 129.505n 1.7v 139.495n 1.7v 139.505n 0.0v 149.495n 0.0v 149.505n 0.0v 159.495n 0.0v 159.505n 0.0v 169.495n 0.0v 169.505n 0.0v 179.495n 0.0v 179.505n 1.7v 189.495n 1.7v 189.505n 1.7v 199.495n 1.7v 199.505n 1.7v 209.495n 1.7v 209.505n 0.0v 219.495n 0.0v 219.505n 0.0v 229.495n 0.0v 229.505n 0.0v 239.495n 0.0v 239.505n 1.7v 249.495n 1.7v 249.505n 1.7v 259.495n 1.7v 259.505n 1.7v 269.495n 1.7v 269.505n 0.0v 279.495n 0.0v 279.505n 0.0v 289.495n 0.0v 289.505n 0.0v 299.495n 0.0v 299.505n 0.0v 309.495n 0.0v 309.505n 0.0v 319.495n 0.0v 319.505n 0.0v 329.495n 0.0v 329.505n 1.7v 339.495n 1.7v 339.505n 1.7v 349.495n 1.7v 349.505n 1.7v 359.495n 1.7v 359.505n 1.7v 369.495n 1.7v 369.505n 1.7v 379.495n 1.7v 379.505n 0.0v 389.495n 0.0v 389.505n 0.0v 399.495n 0.0v 399.505n 0.0v 409.495n 0.0v 409.505n 0.0v 419.495n 0.0v 419.505n 0.0v 429.495n 0.0v 429.505n 1.7v 439.495n 1.7v 439.505n 1.7v 449.495n 1.7v 449.505n 1.7v 459.495n 1.7v 459.505n 1.7v 469.495n 1.7v 469.505n 0.0v 479.495n 0.0v 479.505n 0.0v 489.495n 0.0v 489.505n 0.0v 499.495n 0.0v 499.505n 0.0v 509.495n 0.0v 509.505n 0.0v 519.495n 0.0v 519.505n 1.7v 529.495n 1.7v 529.505n 0.0v 539.495n 0.0v 539.505n 1.7v 549.495n 1.7v 549.505n 1.7v 559.495n 1.7v 559.505n 1.7v 569.495n 1.7v 569.505n 1.7v 579.495n 1.7v 579.505n 1.7v 589.495n 1.7v 589.505n 1.7v 599.495n 1.7v 599.505n 1.7v 609.495n 1.7v 609.505n 1.7v 619.495n 1.7v 619.505n 1.7v 629.495n 1.7v 629.505n 1.7v 639.495n 1.7v 639.505n 0.0v 649.495n 0.0v 649.505n 0.0v 659.495n 0.0v 659.505n 0.0v 669.495n 0.0v 669.505n 0.0v 679.495n 0.0v 679.505n 0.0v 689.495n 0.0v 689.505n 1.7v 699.495n 1.7v 699.505n 1.7v 709.495n 1.7v 709.505n 0.0v 719.495n 0.0v 719.505n 0.0v 729.495n 0.0v 729.505n 0.0v 739.495n 0.0v 739.505n 1.7v 749.495n 1.7v 749.505n 0.0v 759.495n 0.0v 759.505n 1.7v 769.495n 1.7v 769.505n 1.7v 779.495n 1.7v 779.505n 1.7v 789.495n 1.7v 789.505n 1.7v 799.495n 1.7v 799.505n 1.7v 809.495n 1.7v 809.505n 0.0v 819.495n 0.0v 819.505n 0.0v 829.495n 0.0v 829.505n 0.0v 839.495n 0.0v 839.505n 0.0v 849.495n 0.0v 849.505n 0.0v 859.495n 0.0v 859.505n 1.7v 869.495n 1.7v 869.505n 0.0v 879.495n 0.0v 879.505n 0.0v 889.495n 0.0v 889.505n 0.0v 899.495n 0.0v 899.505n 0.0v 909.495n 0.0v 909.505n 0.0v 919.495n 0.0v 919.505n 0.0v 929.495n 0.0v 929.505n 1.7v 939.495n 1.7v 939.505n 0.0v 949.495n 0.0v 949.505n 1.7v 959.495n 1.7v 959.505n 1.7v 969.495n 1.7v 969.505n 0.0v 979.495n 0.0v 979.505n 0.0v 989.495n 0.0v 989.505n 0.0v 999.495n 0.0v 999.505n 0.0v 1009.495n 0.0v 1009.505n 0.0v 1019.495n 0.0v 1019.505n 0.0v 1029.495n 0.0v 1029.505n 0.0v 1039.495n 0.0v 1039.505n 1.7v 1049.495n 1.7v 1049.505n 1.7v 1059.495n 1.7v 1059.505n 1.7v 1069.495n 1.7v 1069.505n 1.7v 1079.495n 1.7v 1079.505n 1.7v 1089.495n 1.7v 1089.505n 0.0v 1099.495n 0.0v 1099.505n 1.7v 1109.495n 1.7v 1109.505n 0.0v 1119.495n 0.0v 1119.505n 0.0v 1129.495n 0.0v 1129.505n 0.0v 1139.495n 0.0v 1139.505n 0.0v 1149.495n 0.0v 1149.505n 1.7v 1159.495n 1.7v 1159.505n 1.7v 1169.495n 1.7v 1169.505n 0.0v 1179.495n 0.0v 1179.505n 0.0v 1189.495n 0.0v 1189.505n 0.0v 1199.495n 0.0v 1199.505n 0.0v 1209.495n 0.0v 1209.505n 0.0v 1219.495n 0.0v 1219.505n 1.7v 1229.495n 1.7v 1229.505n 1.7v 1239.495n 1.7v 1239.505n 0.0v 1249.495n 0.0v 1249.505n 0.0v 1259.495n 0.0v 1259.505n 0.0v 1269.495n 0.0v 1269.505n 1.7v 1279.495n 1.7v 1279.505n 1.7v 1289.495n 1.7v 1289.505n 0.0v 1299.495n 0.0v 1299.505n 0.0v 1309.495n 0.0v 1309.505n 0.0v 1319.495n 0.0v 1319.505n 1.7v 1329.495n 1.7v 1329.505n 1.7v 1339.495n 1.7v 1339.505n 1.7v 1349.495n 1.7v 1349.505n 1.7v 1359.495n 1.7v 1359.505n 1.7v 1369.495n 1.7v 1369.505n 0.0v 1379.495n 0.0v 1379.505n 1.7v 1389.495n 1.7v 1389.505n 1.7v 1399.495n 1.7v 1399.505n 1.7v 1409.495n 1.7v 1409.505n 1.7v 1419.495n 1.7v 1419.505n 1.7v 1429.495n 1.7v 1429.505n 1.7v 1439.495n 1.7v 1439.505n 0.0v 1449.495n 0.0v 1449.505n 0.0v 1459.495n 0.0v 1459.505n 0.0v 1469.495n 0.0v 1469.505n 1.7v 1479.495n 1.7v 1479.505n 1.7v 1489.495n 1.7v 1489.505n 0.0v 1499.495n 0.0v 1499.505n 0.0v 1509.495n 0.0v 1509.505n 1.7v 1519.495n 1.7v 1519.505n 1.7v 1529.495n 1.7v 1529.505n 0.0v 1539.495n 0.0v 1539.505n 0.0v 1549.495n 0.0v 1549.505n 1.7v 1559.495n 1.7v 1559.505n 1.7v 1569.495n 1.7v 1569.505n 1.7v 1579.495n 1.7v 1579.505n 1.7v 1589.495n 1.7v 1589.505n 1.7v 1599.495n 1.7v 1599.505n 0.0v 1609.495n 0.0v 1609.505n 1.7v 1619.495n 1.7v 1619.505n 1.7v 1629.495n 1.7v 1629.505n 1.7v 1639.495n 1.7v 1639.505n 0.0v 1649.495n 0.0v 1649.505n 0.0v 1659.495n 0.0v 1659.505n 0.0v 1669.495n 0.0v 1669.505n 1.7v 1679.495n 1.7v 1679.505n 1.7v 1689.495n 1.7v 1689.505n 1.7v 1699.495n 1.7v 1699.505n 0.0v 1709.495n 0.0v 1709.505n 1.7v 1719.495n 1.7v 1719.505n 0.0v 1729.495n 0.0v 1729.505n 0.0v 1739.495n 0.0v 1739.505n 1.7v 1749.495n 1.7v 1749.505n 1.7v 1759.495n 1.7v 1759.505n 0.0v 1769.495n 0.0v 1769.505n 1.7v 1779.495n 1.7v 1779.505n 1.7v 1789.495n 1.7v 1789.505n 0.0v 1799.495n 0.0v 1799.505n 1.7v 1809.495n 1.7v 1809.505n 1.7v 1819.495n 1.7v 1819.505n 0.0v 1829.495n 0.0v 1829.505n 0.0v 1839.495n 0.0v 1839.505n 1.7v 1849.495n 1.7v 1849.505n 1.7v 1859.495n 1.7v 1859.505n 0.0v 1869.495n 0.0v 1869.505n 0.0v 1879.495n 0.0v 1879.505n 1.7v 1889.495n 1.7v 1889.505n 1.7v 1899.495n 1.7v 1899.505n 0.0v 1909.495n 0.0v 1909.505n 0.0v 1919.495n 0.0v 1919.505n 0.0v 1929.495n 0.0v 1929.505n 0.0v 1939.495n 0.0v 1939.505n 1.7v 1949.495n 1.7v 1949.505n 0.0v 1959.495n 0.0v 1959.505n 0.0v 1969.495n 0.0v 1969.505n 1.7v 1979.495n 1.7v 1979.505n 1.7v 1989.495n 1.7v 1989.505n 1.7v 1999.495n 1.7v 1999.505n 1.7v 2009.495n 1.7v 2009.505n 1.7v 2019.495n 1.7v 2019.505n 0.0v 2029.495n 0.0v 2029.505n 1.7v 2039.495n 1.7v 2039.505n 1.7v 2049.495n 1.7v 2049.505n 1.7v )
* (time, data): [(0, 0), (10, 1), (20, 1), (30, 1), (40, 1), (50, 1), (60, 1), (70, 0), (80, 1), (90, 1), (100, 1), (110, 1), (120, 1), (130, 1), (140, 0), (150, 0), (160, 0), (170, 0), (180, 0), (190, 0), (200, 0), (210, 1), (220, 1), (230, 1), (240, 0), (250, 0), (260, 0), (270, 0), (280, 0), (290, 0), (300, 1), (310, 1), (320, 0), (330, 1), (340, 1), (350, 1), (360, 1), (370, 1), (380, 1), (390, 1), (400, 1), (410, 1), (420, 1), (430, 1), (440, 1), (450, 1), (460, 0), (470, 1), (480, 1), (490, 1), (500, 1), (510, 1), (520, 0), (530, 0), (540, 0), (550, 0), (560, 0), (570, 0), (580, 0), (590, 1), (600, 1), (610, 1), (620, 1), (630, 1), (640, 0), (650, 0), (660, 1), (670, 0), (680, 0), (690, 1), (700, 0), (710, 0), (720, 0), (730, 0), (740, 1), (750, 0), (760, 1), (770, 0), (780, 0), (790, 1), (800, 1), (810, 0), (820, 1), (830, 1), (840, 1), (850, 1), (860, 1), (870, 1), (880, 1), (890, 1), (900, 1), (910, 1), (920, 0), (930, 1), (940, 0), (950, 1), (960, 1), (970, 0), (980, 0), (990, 0), (1000, 0), (1010, 0), (1020, 0), (1030, 0), (1040, 1), (1050, 1), (1060, 1), (1070, 1), (1080, 1), (1090, 1), (1100, 1), (1110, 1), (1120, 1), (1130, 1), (1140, 1), (1150, 1), (1160, 1), (1170, 1), (1180, 1), (1190, 1), (1200, 1), (1210, 0), (1220, 0), (1230, 0), (1240, 0), (1250, 0), (1260, 0), (1270, 1), (1280, 1), (1290, 0), (1300, 0), (1310, 0), (1320, 0), (1330, 0), (1340, 0), (1350, 1), (1360, 1), (1370, 1), (1380, 1), (1390, 1), (1400, 0), (1410, 0), (1420, 0), (1430, 0), (1440, 1), (1450, 1), (1460, 0), (1470, 0), (1480, 0), (1490, 1), (1500, 1), (1510, 0), (1520, 0), (1530, 1), (1540, 1), (1550, 0), (1560, 0), (1570, 1), (1580, 1), (1590, 0), (1600, 0), (1610, 1), (1620, 1), (1630, 1), (1640, 0), (1650, 0), (1660, 0), (1670, 1), (1680, 1), (1690, 0), (1700, 0), (1710, 1), (1720, 0), (1730, 0), (1740, 1), (1750, 1), (1760, 1), (1770, 0), (1780, 0), (1790, 0), (1800, 0), (1810, 1), (1820, 1), (1830, 1), (1840, 0), (1850, 0), (1860, 1), (1870, 1), (1880, 0), (1890, 0), (1900, 1), (1910, 1), (1920, 1), (1930, 0), (1940, 0), (1950, 0), (1960, 0), (1970, 1), (1980, 1), (1990, 1), (2000, 1), (2010, 1), (2020, 1), (2030, 0), (2040, 0), (2050, 0)]
Vdin0_6  din0_6  0 PWL (0n 0.0v 9.495n 0.0v 9.505n 1.7v 19.495n 1.7v 19.505n 1.7v 29.495n 1.7v 29.505n 1.7v 39.495n 1.7v 39.505n 1.7v 49.495n 1.7v 49.505n 1.7v 59.495n 1.7v 59.505n 1.7v 69.495n 1.7v 69.505n 0.0v 79.495n 0.0v 79.505n 1.7v 89.495n 1.7v 89.505n 1.7v 99.495n 1.7v 99.505n 1.7v 109.495n 1.7v 109.505n 1.7v 119.495n 1.7v 119.505n 1.7v 129.495n 1.7v 129.505n 1.7v 139.495n 1.7v 139.505n 0.0v 149.495n 0.0v 149.505n 0.0v 159.495n 0.0v 159.505n 0.0v 169.495n 0.0v 169.505n 0.0v 179.495n 0.0v 179.505n 0.0v 189.495n 0.0v 189.505n 0.0v 199.495n 0.0v 199.505n 0.0v 209.495n 0.0v 209.505n 1.7v 219.495n 1.7v 219.505n 1.7v 229.495n 1.7v 229.505n 1.7v 239.495n 1.7v 239.505n 0.0v 249.495n 0.0v 249.505n 0.0v 259.495n 0.0v 259.505n 0.0v 269.495n 0.0v 269.505n 0.0v 279.495n 0.0v 279.505n 0.0v 289.495n 0.0v 289.505n 0.0v 299.495n 0.0v 299.505n 1.7v 309.495n 1.7v 309.505n 1.7v 319.495n 1.7v 319.505n 0.0v 329.495n 0.0v 329.505n 1.7v 339.495n 1.7v 339.505n 1.7v 349.495n 1.7v 349.505n 1.7v 359.495n 1.7v 359.505n 1.7v 369.495n 1.7v 369.505n 1.7v 379.495n 1.7v 379.505n 1.7v 389.495n 1.7v 389.505n 1.7v 399.495n 1.7v 399.505n 1.7v 409.495n 1.7v 409.505n 1.7v 419.495n 1.7v 419.505n 1.7v 429.495n 1.7v 429.505n 1.7v 439.495n 1.7v 439.505n 1.7v 449.495n 1.7v 449.505n 1.7v 459.495n 1.7v 459.505n 0.0v 469.495n 0.0v 469.505n 1.7v 479.495n 1.7v 479.505n 1.7v 489.495n 1.7v 489.505n 1.7v 499.495n 1.7v 499.505n 1.7v 509.495n 1.7v 509.505n 1.7v 519.495n 1.7v 519.505n 0.0v 529.495n 0.0v 529.505n 0.0v 539.495n 0.0v 539.505n 0.0v 549.495n 0.0v 549.505n 0.0v 559.495n 0.0v 559.505n 0.0v 569.495n 0.0v 569.505n 0.0v 579.495n 0.0v 579.505n 0.0v 589.495n 0.0v 589.505n 1.7v 599.495n 1.7v 599.505n 1.7v 609.495n 1.7v 609.505n 1.7v 619.495n 1.7v 619.505n 1.7v 629.495n 1.7v 629.505n 1.7v 639.495n 1.7v 639.505n 0.0v 649.495n 0.0v 649.505n 0.0v 659.495n 0.0v 659.505n 1.7v 669.495n 1.7v 669.505n 0.0v 679.495n 0.0v 679.505n 0.0v 689.495n 0.0v 689.505n 1.7v 699.495n 1.7v 699.505n 0.0v 709.495n 0.0v 709.505n 0.0v 719.495n 0.0v 719.505n 0.0v 729.495n 0.0v 729.505n 0.0v 739.495n 0.0v 739.505n 1.7v 749.495n 1.7v 749.505n 0.0v 759.495n 0.0v 759.505n 1.7v 769.495n 1.7v 769.505n 0.0v 779.495n 0.0v 779.505n 0.0v 789.495n 0.0v 789.505n 1.7v 799.495n 1.7v 799.505n 1.7v 809.495n 1.7v 809.505n 0.0v 819.495n 0.0v 819.505n 1.7v 829.495n 1.7v 829.505n 1.7v 839.495n 1.7v 839.505n 1.7v 849.495n 1.7v 849.505n 1.7v 859.495n 1.7v 859.505n 1.7v 869.495n 1.7v 869.505n 1.7v 879.495n 1.7v 879.505n 1.7v 889.495n 1.7v 889.505n 1.7v 899.495n 1.7v 899.505n 1.7v 909.495n 1.7v 909.505n 1.7v 919.495n 1.7v 919.505n 0.0v 929.495n 0.0v 929.505n 1.7v 939.495n 1.7v 939.505n 0.0v 949.495n 0.0v 949.505n 1.7v 959.495n 1.7v 959.505n 1.7v 969.495n 1.7v 969.505n 0.0v 979.495n 0.0v 979.505n 0.0v 989.495n 0.0v 989.505n 0.0v 999.495n 0.0v 999.505n 0.0v 1009.495n 0.0v 1009.505n 0.0v 1019.495n 0.0v 1019.505n 0.0v 1029.495n 0.0v 1029.505n 0.0v 1039.495n 0.0v 1039.505n 1.7v 1049.495n 1.7v 1049.505n 1.7v 1059.495n 1.7v 1059.505n 1.7v 1069.495n 1.7v 1069.505n 1.7v 1079.495n 1.7v 1079.505n 1.7v 1089.495n 1.7v 1089.505n 1.7v 1099.495n 1.7v 1099.505n 1.7v 1109.495n 1.7v 1109.505n 1.7v 1119.495n 1.7v 1119.505n 1.7v 1129.495n 1.7v 1129.505n 1.7v 1139.495n 1.7v 1139.505n 1.7v 1149.495n 1.7v 1149.505n 1.7v 1159.495n 1.7v 1159.505n 1.7v 1169.495n 1.7v 1169.505n 1.7v 1179.495n 1.7v 1179.505n 1.7v 1189.495n 1.7v 1189.505n 1.7v 1199.495n 1.7v 1199.505n 1.7v 1209.495n 1.7v 1209.505n 0.0v 1219.495n 0.0v 1219.505n 0.0v 1229.495n 0.0v 1229.505n 0.0v 1239.495n 0.0v 1239.505n 0.0v 1249.495n 0.0v 1249.505n 0.0v 1259.495n 0.0v 1259.505n 0.0v 1269.495n 0.0v 1269.505n 1.7v 1279.495n 1.7v 1279.505n 1.7v 1289.495n 1.7v 1289.505n 0.0v 1299.495n 0.0v 1299.505n 0.0v 1309.495n 0.0v 1309.505n 0.0v 1319.495n 0.0v 1319.505n 0.0v 1329.495n 0.0v 1329.505n 0.0v 1339.495n 0.0v 1339.505n 0.0v 1349.495n 0.0v 1349.505n 1.7v 1359.495n 1.7v 1359.505n 1.7v 1369.495n 1.7v 1369.505n 1.7v 1379.495n 1.7v 1379.505n 1.7v 1389.495n 1.7v 1389.505n 1.7v 1399.495n 1.7v 1399.505n 0.0v 1409.495n 0.0v 1409.505n 0.0v 1419.495n 0.0v 1419.505n 0.0v 1429.495n 0.0v 1429.505n 0.0v 1439.495n 0.0v 1439.505n 1.7v 1449.495n 1.7v 1449.505n 1.7v 1459.495n 1.7v 1459.505n 0.0v 1469.495n 0.0v 1469.505n 0.0v 1479.495n 0.0v 1479.505n 0.0v 1489.495n 0.0v 1489.505n 1.7v 1499.495n 1.7v 1499.505n 1.7v 1509.495n 1.7v 1509.505n 0.0v 1519.495n 0.0v 1519.505n 0.0v 1529.495n 0.0v 1529.505n 1.7v 1539.495n 1.7v 1539.505n 1.7v 1549.495n 1.7v 1549.505n 0.0v 1559.495n 0.0v 1559.505n 0.0v 1569.495n 0.0v 1569.505n 1.7v 1579.495n 1.7v 1579.505n 1.7v 1589.495n 1.7v 1589.505n 0.0v 1599.495n 0.0v 1599.505n 0.0v 1609.495n 0.0v 1609.505n 1.7v 1619.495n 1.7v 1619.505n 1.7v 1629.495n 1.7v 1629.505n 1.7v 1639.495n 1.7v 1639.505n 0.0v 1649.495n 0.0v 1649.505n 0.0v 1659.495n 0.0v 1659.505n 0.0v 1669.495n 0.0v 1669.505n 1.7v 1679.495n 1.7v 1679.505n 1.7v 1689.495n 1.7v 1689.505n 0.0v 1699.495n 0.0v 1699.505n 0.0v 1709.495n 0.0v 1709.505n 1.7v 1719.495n 1.7v 1719.505n 0.0v 1729.495n 0.0v 1729.505n 0.0v 1739.495n 0.0v 1739.505n 1.7v 1749.495n 1.7v 1749.505n 1.7v 1759.495n 1.7v 1759.505n 1.7v 1769.495n 1.7v 1769.505n 0.0v 1779.495n 0.0v 1779.505n 0.0v 1789.495n 0.0v 1789.505n 0.0v 1799.495n 0.0v 1799.505n 0.0v 1809.495n 0.0v 1809.505n 1.7v 1819.495n 1.7v 1819.505n 1.7v 1829.495n 1.7v 1829.505n 1.7v 1839.495n 1.7v 1839.505n 0.0v 1849.495n 0.0v 1849.505n 0.0v 1859.495n 0.0v 1859.505n 1.7v 1869.495n 1.7v 1869.505n 1.7v 1879.495n 1.7v 1879.505n 0.0v 1889.495n 0.0v 1889.505n 0.0v 1899.495n 0.0v 1899.505n 1.7v 1909.495n 1.7v 1909.505n 1.7v 1919.495n 1.7v 1919.505n 1.7v 1929.495n 1.7v 1929.505n 0.0v 1939.495n 0.0v 1939.505n 0.0v 1949.495n 0.0v 1949.505n 0.0v 1959.495n 0.0v 1959.505n 0.0v 1969.495n 0.0v 1969.505n 1.7v 1979.495n 1.7v 1979.505n 1.7v 1989.495n 1.7v 1989.505n 1.7v 1999.495n 1.7v 1999.505n 1.7v 2009.495n 1.7v 2009.505n 1.7v 2019.495n 1.7v 2019.505n 1.7v 2029.495n 1.7v 2029.505n 0.0v 2039.495n 0.0v 2039.505n 0.0v 2049.495n 0.0v 2049.505n 0.0v )
* (time, data): [(0, 0), (10, 0), (20, 1), (30, 1), (40, 1), (50, 1), (60, 1), (70, 0), (80, 0), (90, 0), (100, 0), (110, 0), (120, 0), (130, 0), (140, 1), (150, 1), (160, 1), (170, 1), (180, 1), (190, 1), (200, 1), (210, 1), (220, 1), (230, 1), (240, 1), (250, 1), (260, 1), (270, 1), (280, 1), (290, 1), (300, 1), (310, 0), (320, 1), (330, 1), (340, 1), (350, 1), (360, 1), (370, 1), (380, 0), (390, 0), (400, 0), (410, 0), (420, 0), (430, 0), (440, 1), (450, 1), (460, 1), (470, 1), (480, 1), (490, 1), (500, 1), (510, 0), (520, 0), (530, 1), (540, 0), (550, 1), (560, 1), (570, 1), (580, 1), (590, 0), (600, 0), (610, 0), (620, 0), (630, 0), (640, 1), (650, 1), (660, 0), (670, 0), (680, 0), (690, 1), (700, 1), (710, 0), (720, 1), (730, 1), (740, 1), (750, 1), (760, 1), (770, 1), (780, 1), (790, 0), (800, 0), (810, 1), (820, 0), (830, 0), (840, 0), (850, 1), (860, 1), (870, 1), (880, 1), (890, 1), (900, 1), (910, 1), (920, 1), (930, 1), (940, 0), (950, 0), (960, 0), (970, 0), (980, 0), (990, 0), (1000, 0), (1010, 0), (1020, 0), (1030, 0), (1040, 0), (1050, 0), (1060, 0), (1070, 0), (1080, 0), (1090, 1), (1100, 0), (1110, 0), (1120, 0), (1130, 0), (1140, 0), (1150, 0), (1160, 0), (1170, 1), (1180, 1), (1190, 1), (1200, 0), (1210, 1), (1220, 0), (1230, 1), (1240, 1), (1250, 1), (1260, 1), (1270, 1), (1280, 1), (1290, 1), (1300, 1), (1310, 1), (1320, 0), (1330, 0), (1340, 1), (1350, 1), (1360, 1), (1370, 0), (1380, 1), (1390, 1), (1400, 1), (1410, 0), (1420, 0), (1430, 0), (1440, 0), (1450, 1), (1460, 0), (1470, 1), (1480, 1), (1490, 1), (1500, 1), (1510, 1), (1520, 1), (1530, 0), (1540, 0), (1550, 1), (1560, 1), (1570, 0), (1580, 1), (1590, 1), (1600, 1), (1610, 1), (1620, 1), (1630, 1), (1640, 0), (1650, 0), (1660, 0), (1670, 0), (1680, 0), (1690, 1), (1700, 0), (1710, 1), (1720, 1), (1730, 1), (1740, 0), (1750, 0), (1760, 0), (1770, 0), (1780, 0), (1790, 1), (1800, 0), (1810, 0), (1820, 0), (1830, 0), (1840, 1), (1850, 1), (1860, 0), (1870, 0), (1880, 1), (1890, 1), (1900, 1), (1910, 0), (1920, 1), (1930, 0), (1940, 0), (1950, 0), (1960, 0), (1970, 0), (1980, 0), (1990, 0), (2000, 0), (2010, 0), (2020, 0), (2030, 1), (2040, 1), (2050, 1)]
Vdin0_7  din0_7  0 PWL (0n 0.0v 9.495n 0.0v 9.505n 0.0v 19.495n 0.0v 19.505n 1.7v 29.495n 1.7v 29.505n 1.7v 39.495n 1.7v 39.505n 1.7v 49.495n 1.7v 49.505n 1.7v 59.495n 1.7v 59.505n 1.7v 69.495n 1.7v 69.505n 0.0v 79.495n 0.0v 79.505n 0.0v 89.495n 0.0v 89.505n 0.0v 99.495n 0.0v 99.505n 0.0v 109.495n 0.0v 109.505n 0.0v 119.495n 0.0v 119.505n 0.0v 129.495n 0.0v 129.505n 0.0v 139.495n 0.0v 139.505n 1.7v 149.495n 1.7v 149.505n 1.7v 159.495n 1.7v 159.505n 1.7v 169.495n 1.7v 169.505n 1.7v 179.495n 1.7v 179.505n 1.7v 189.495n 1.7v 189.505n 1.7v 199.495n 1.7v 199.505n 1.7v 209.495n 1.7v 209.505n 1.7v 219.495n 1.7v 219.505n 1.7v 229.495n 1.7v 229.505n 1.7v 239.495n 1.7v 239.505n 1.7v 249.495n 1.7v 249.505n 1.7v 259.495n 1.7v 259.505n 1.7v 269.495n 1.7v 269.505n 1.7v 279.495n 1.7v 279.505n 1.7v 289.495n 1.7v 289.505n 1.7v 299.495n 1.7v 299.505n 1.7v 309.495n 1.7v 309.505n 0.0v 319.495n 0.0v 319.505n 1.7v 329.495n 1.7v 329.505n 1.7v 339.495n 1.7v 339.505n 1.7v 349.495n 1.7v 349.505n 1.7v 359.495n 1.7v 359.505n 1.7v 369.495n 1.7v 369.505n 1.7v 379.495n 1.7v 379.505n 0.0v 389.495n 0.0v 389.505n 0.0v 399.495n 0.0v 399.505n 0.0v 409.495n 0.0v 409.505n 0.0v 419.495n 0.0v 419.505n 0.0v 429.495n 0.0v 429.505n 0.0v 439.495n 0.0v 439.505n 1.7v 449.495n 1.7v 449.505n 1.7v 459.495n 1.7v 459.505n 1.7v 469.495n 1.7v 469.505n 1.7v 479.495n 1.7v 479.505n 1.7v 489.495n 1.7v 489.505n 1.7v 499.495n 1.7v 499.505n 1.7v 509.495n 1.7v 509.505n 0.0v 519.495n 0.0v 519.505n 0.0v 529.495n 0.0v 529.505n 1.7v 539.495n 1.7v 539.505n 0.0v 549.495n 0.0v 549.505n 1.7v 559.495n 1.7v 559.505n 1.7v 569.495n 1.7v 569.505n 1.7v 579.495n 1.7v 579.505n 1.7v 589.495n 1.7v 589.505n 0.0v 599.495n 0.0v 599.505n 0.0v 609.495n 0.0v 609.505n 0.0v 619.495n 0.0v 619.505n 0.0v 629.495n 0.0v 629.505n 0.0v 639.495n 0.0v 639.505n 1.7v 649.495n 1.7v 649.505n 1.7v 659.495n 1.7v 659.505n 0.0v 669.495n 0.0v 669.505n 0.0v 679.495n 0.0v 679.505n 0.0v 689.495n 0.0v 689.505n 1.7v 699.495n 1.7v 699.505n 1.7v 709.495n 1.7v 709.505n 0.0v 719.495n 0.0v 719.505n 1.7v 729.495n 1.7v 729.505n 1.7v 739.495n 1.7v 739.505n 1.7v 749.495n 1.7v 749.505n 1.7v 759.495n 1.7v 759.505n 1.7v 769.495n 1.7v 769.505n 1.7v 779.495n 1.7v 779.505n 1.7v 789.495n 1.7v 789.505n 0.0v 799.495n 0.0v 799.505n 0.0v 809.495n 0.0v 809.505n 1.7v 819.495n 1.7v 819.505n 0.0v 829.495n 0.0v 829.505n 0.0v 839.495n 0.0v 839.505n 0.0v 849.495n 0.0v 849.505n 1.7v 859.495n 1.7v 859.505n 1.7v 869.495n 1.7v 869.505n 1.7v 879.495n 1.7v 879.505n 1.7v 889.495n 1.7v 889.505n 1.7v 899.495n 1.7v 899.505n 1.7v 909.495n 1.7v 909.505n 1.7v 919.495n 1.7v 919.505n 1.7v 929.495n 1.7v 929.505n 1.7v 939.495n 1.7v 939.505n 0.0v 949.495n 0.0v 949.505n 0.0v 959.495n 0.0v 959.505n 0.0v 969.495n 0.0v 969.505n 0.0v 979.495n 0.0v 979.505n 0.0v 989.495n 0.0v 989.505n 0.0v 999.495n 0.0v 999.505n 0.0v 1009.495n 0.0v 1009.505n 0.0v 1019.495n 0.0v 1019.505n 0.0v 1029.495n 0.0v 1029.505n 0.0v 1039.495n 0.0v 1039.505n 0.0v 1049.495n 0.0v 1049.505n 0.0v 1059.495n 0.0v 1059.505n 0.0v 1069.495n 0.0v 1069.505n 0.0v 1079.495n 0.0v 1079.505n 0.0v 1089.495n 0.0v 1089.505n 1.7v 1099.495n 1.7v 1099.505n 0.0v 1109.495n 0.0v 1109.505n 0.0v 1119.495n 0.0v 1119.505n 0.0v 1129.495n 0.0v 1129.505n 0.0v 1139.495n 0.0v 1139.505n 0.0v 1149.495n 0.0v 1149.505n 0.0v 1159.495n 0.0v 1159.505n 0.0v 1169.495n 0.0v 1169.505n 1.7v 1179.495n 1.7v 1179.505n 1.7v 1189.495n 1.7v 1189.505n 1.7v 1199.495n 1.7v 1199.505n 0.0v 1209.495n 0.0v 1209.505n 1.7v 1219.495n 1.7v 1219.505n 0.0v 1229.495n 0.0v 1229.505n 1.7v 1239.495n 1.7v 1239.505n 1.7v 1249.495n 1.7v 1249.505n 1.7v 1259.495n 1.7v 1259.505n 1.7v 1269.495n 1.7v 1269.505n 1.7v 1279.495n 1.7v 1279.505n 1.7v 1289.495n 1.7v 1289.505n 1.7v 1299.495n 1.7v 1299.505n 1.7v 1309.495n 1.7v 1309.505n 1.7v 1319.495n 1.7v 1319.505n 0.0v 1329.495n 0.0v 1329.505n 0.0v 1339.495n 0.0v 1339.505n 1.7v 1349.495n 1.7v 1349.505n 1.7v 1359.495n 1.7v 1359.505n 1.7v 1369.495n 1.7v 1369.505n 0.0v 1379.495n 0.0v 1379.505n 1.7v 1389.495n 1.7v 1389.505n 1.7v 1399.495n 1.7v 1399.505n 1.7v 1409.495n 1.7v 1409.505n 0.0v 1419.495n 0.0v 1419.505n 0.0v 1429.495n 0.0v 1429.505n 0.0v 1439.495n 0.0v 1439.505n 0.0v 1449.495n 0.0v 1449.505n 1.7v 1459.495n 1.7v 1459.505n 0.0v 1469.495n 0.0v 1469.505n 1.7v 1479.495n 1.7v 1479.505n 1.7v 1489.495n 1.7v 1489.505n 1.7v 1499.495n 1.7v 1499.505n 1.7v 1509.495n 1.7v 1509.505n 1.7v 1519.495n 1.7v 1519.505n 1.7v 1529.495n 1.7v 1529.505n 0.0v 1539.495n 0.0v 1539.505n 0.0v 1549.495n 0.0v 1549.505n 1.7v 1559.495n 1.7v 1559.505n 1.7v 1569.495n 1.7v 1569.505n 0.0v 1579.495n 0.0v 1579.505n 1.7v 1589.495n 1.7v 1589.505n 1.7v 1599.495n 1.7v 1599.505n 1.7v 1609.495n 1.7v 1609.505n 1.7v 1619.495n 1.7v 1619.505n 1.7v 1629.495n 1.7v 1629.505n 1.7v 1639.495n 1.7v 1639.505n 0.0v 1649.495n 0.0v 1649.505n 0.0v 1659.495n 0.0v 1659.505n 0.0v 1669.495n 0.0v 1669.505n 0.0v 1679.495n 0.0v 1679.505n 0.0v 1689.495n 0.0v 1689.505n 1.7v 1699.495n 1.7v 1699.505n 0.0v 1709.495n 0.0v 1709.505n 1.7v 1719.495n 1.7v 1719.505n 1.7v 1729.495n 1.7v 1729.505n 1.7v 1739.495n 1.7v 1739.505n 0.0v 1749.495n 0.0v 1749.505n 0.0v 1759.495n 0.0v 1759.505n 0.0v 1769.495n 0.0v 1769.505n 0.0v 1779.495n 0.0v 1779.505n 0.0v 1789.495n 0.0v 1789.505n 1.7v 1799.495n 1.7v 1799.505n 0.0v 1809.495n 0.0v 1809.505n 0.0v 1819.495n 0.0v 1819.505n 0.0v 1829.495n 0.0v 1829.505n 0.0v 1839.495n 0.0v 1839.505n 1.7v 1849.495n 1.7v 1849.505n 1.7v 1859.495n 1.7v 1859.505n 0.0v 1869.495n 0.0v 1869.505n 0.0v 1879.495n 0.0v 1879.505n 1.7v 1889.495n 1.7v 1889.505n 1.7v 1899.495n 1.7v 1899.505n 1.7v 1909.495n 1.7v 1909.505n 0.0v 1919.495n 0.0v 1919.505n 1.7v 1929.495n 1.7v 1929.505n 0.0v 1939.495n 0.0v 1939.505n 0.0v 1949.495n 0.0v 1949.505n 0.0v 1959.495n 0.0v 1959.505n 0.0v 1969.495n 0.0v 1969.505n 0.0v 1979.495n 0.0v 1979.505n 0.0v 1989.495n 0.0v 1989.505n 0.0v 1999.495n 0.0v 1999.505n 0.0v 2009.495n 0.0v 2009.505n 0.0v 2019.495n 0.0v 2019.505n 0.0v 2029.495n 0.0v 2029.505n 1.7v 2039.495n 1.7v 2039.505n 1.7v 2049.495n 1.7v 2049.505n 1.7v )
* (time, data): [(0, 0), (10, 0), (20, 1), (30, 1), (40, 1), (50, 0), (60, 0), (70, 0), (80, 0), (90, 0), (100, 0), (110, 0), (120, 0), (130, 0), (140, 0), (150, 0), (160, 0), (170, 0), (180, 1), (190, 1), (200, 1), (210, 1), (220, 1), (230, 1), (240, 0), (250, 0), (260, 0), (270, 1), (280, 1), (290, 1), (300, 1), (310, 1), (320, 1), (330, 1), (340, 1), (350, 1), (360, 1), (370, 1), (380, 0), (390, 0), (400, 0), (410, 0), (420, 0), (430, 0), (440, 0), (450, 0), (460, 0), (470, 1), (480, 1), (490, 1), (500, 1), (510, 1), (520, 0), (530, 0), (540, 1), (550, 1), (560, 1), (570, 1), (580, 1), (590, 1), (600, 1), (610, 1), (620, 1), (630, 1), (640, 1), (650, 1), (660, 1), (670, 0), (680, 0), (690, 0), (700, 1), (710, 1), (720, 1), (730, 1), (740, 1), (750, 0), (760, 1), (770, 0), (780, 0), (790, 0), (800, 0), (810, 1), (820, 1), (830, 1), (840, 1), (850, 1), (860, 0), (870, 1), (880, 1), (890, 1), (900, 1), (910, 1), (920, 1), (930, 1), (940, 0), (950, 0), (960, 0), (970, 1), (980, 0), (990, 0), (1000, 0), (1010, 0), (1020, 0), (1030, 0), (1040, 1), (1050, 1), (1060, 1), (1070, 1), (1080, 1), (1090, 0), (1100, 1), (1110, 0), (1120, 0), (1130, 0), (1140, 1), (1150, 1), (1160, 1), (1170, 0), (1180, 0), (1190, 0), (1200, 1), (1210, 0), (1220, 1), (1230, 0), (1240, 0), (1250, 0), (1260, 0), (1270, 1), (1280, 1), (1290, 0), (1300, 0), (1310, 0), (1320, 0), (1330, 0), (1340, 1), (1350, 1), (1360, 1), (1370, 0), (1380, 0), (1390, 0), (1400, 1), (1410, 0), (1420, 0), (1430, 0), (1440, 0), (1450, 0), (1460, 0), (1470, 1), (1480, 1), (1490, 1), (1500, 1), (1510, 0), (1520, 0), (1530, 1), (1540, 0), (1550, 0), (1560, 0), (1570, 0), (1580, 0), (1590, 0), (1600, 0), (1610, 1), (1620, 1), (1630, 1), (1640, 0), (1650, 0), (1660, 0), (1670, 1), (1680, 1), (1690, 1), (1700, 1), (1710, 0), (1720, 1), (1730, 1), (1740, 1), (1750, 1), (1760, 1), (1770, 1), (1780, 0), (1790, 0), (1800, 0), (1810, 0), (1820, 1), (1830, 1), (1840, 1), (1850, 1), (1860, 1), (1870, 1), (1880, 1), (1890, 1), (1900, 0), (1910, 0), (1920, 0), (1930, 0), (1940, 0), (1950, 0), (1960, 0), (1970, 0), (1980, 0), (1990, 0), (2000, 0), (2010, 0), (2020, 0), (2030, 0), (2040, 0), (2050, 0)]
Vdin0_8  din0_8  0 PWL (0n 0.0v 9.495n 0.0v 9.505n 0.0v 19.495n 0.0v 19.505n 1.7v 29.495n 1.7v 29.505n 1.7v 39.495n 1.7v 39.505n 1.7v 49.495n 1.7v 49.505n 0.0v 59.495n 0.0v 59.505n 0.0v 69.495n 0.0v 69.505n 0.0v 79.495n 0.0v 79.505n 0.0v 89.495n 0.0v 89.505n 0.0v 99.495n 0.0v 99.505n 0.0v 109.495n 0.0v 109.505n 0.0v 119.495n 0.0v 119.505n 0.0v 129.495n 0.0v 129.505n 0.0v 139.495n 0.0v 139.505n 0.0v 149.495n 0.0v 149.505n 0.0v 159.495n 0.0v 159.505n 0.0v 169.495n 0.0v 169.505n 0.0v 179.495n 0.0v 179.505n 1.7v 189.495n 1.7v 189.505n 1.7v 199.495n 1.7v 199.505n 1.7v 209.495n 1.7v 209.505n 1.7v 219.495n 1.7v 219.505n 1.7v 229.495n 1.7v 229.505n 1.7v 239.495n 1.7v 239.505n 0.0v 249.495n 0.0v 249.505n 0.0v 259.495n 0.0v 259.505n 0.0v 269.495n 0.0v 269.505n 1.7v 279.495n 1.7v 279.505n 1.7v 289.495n 1.7v 289.505n 1.7v 299.495n 1.7v 299.505n 1.7v 309.495n 1.7v 309.505n 1.7v 319.495n 1.7v 319.505n 1.7v 329.495n 1.7v 329.505n 1.7v 339.495n 1.7v 339.505n 1.7v 349.495n 1.7v 349.505n 1.7v 359.495n 1.7v 359.505n 1.7v 369.495n 1.7v 369.505n 1.7v 379.495n 1.7v 379.505n 0.0v 389.495n 0.0v 389.505n 0.0v 399.495n 0.0v 399.505n 0.0v 409.495n 0.0v 409.505n 0.0v 419.495n 0.0v 419.505n 0.0v 429.495n 0.0v 429.505n 0.0v 439.495n 0.0v 439.505n 0.0v 449.495n 0.0v 449.505n 0.0v 459.495n 0.0v 459.505n 0.0v 469.495n 0.0v 469.505n 1.7v 479.495n 1.7v 479.505n 1.7v 489.495n 1.7v 489.505n 1.7v 499.495n 1.7v 499.505n 1.7v 509.495n 1.7v 509.505n 1.7v 519.495n 1.7v 519.505n 0.0v 529.495n 0.0v 529.505n 0.0v 539.495n 0.0v 539.505n 1.7v 549.495n 1.7v 549.505n 1.7v 559.495n 1.7v 559.505n 1.7v 569.495n 1.7v 569.505n 1.7v 579.495n 1.7v 579.505n 1.7v 589.495n 1.7v 589.505n 1.7v 599.495n 1.7v 599.505n 1.7v 609.495n 1.7v 609.505n 1.7v 619.495n 1.7v 619.505n 1.7v 629.495n 1.7v 629.505n 1.7v 639.495n 1.7v 639.505n 1.7v 649.495n 1.7v 649.505n 1.7v 659.495n 1.7v 659.505n 1.7v 669.495n 1.7v 669.505n 0.0v 679.495n 0.0v 679.505n 0.0v 689.495n 0.0v 689.505n 0.0v 699.495n 0.0v 699.505n 1.7v 709.495n 1.7v 709.505n 1.7v 719.495n 1.7v 719.505n 1.7v 729.495n 1.7v 729.505n 1.7v 739.495n 1.7v 739.505n 1.7v 749.495n 1.7v 749.505n 0.0v 759.495n 0.0v 759.505n 1.7v 769.495n 1.7v 769.505n 0.0v 779.495n 0.0v 779.505n 0.0v 789.495n 0.0v 789.505n 0.0v 799.495n 0.0v 799.505n 0.0v 809.495n 0.0v 809.505n 1.7v 819.495n 1.7v 819.505n 1.7v 829.495n 1.7v 829.505n 1.7v 839.495n 1.7v 839.505n 1.7v 849.495n 1.7v 849.505n 1.7v 859.495n 1.7v 859.505n 0.0v 869.495n 0.0v 869.505n 1.7v 879.495n 1.7v 879.505n 1.7v 889.495n 1.7v 889.505n 1.7v 899.495n 1.7v 899.505n 1.7v 909.495n 1.7v 909.505n 1.7v 919.495n 1.7v 919.505n 1.7v 929.495n 1.7v 929.505n 1.7v 939.495n 1.7v 939.505n 0.0v 949.495n 0.0v 949.505n 0.0v 959.495n 0.0v 959.505n 0.0v 969.495n 0.0v 969.505n 1.7v 979.495n 1.7v 979.505n 0.0v 989.495n 0.0v 989.505n 0.0v 999.495n 0.0v 999.505n 0.0v 1009.495n 0.0v 1009.505n 0.0v 1019.495n 0.0v 1019.505n 0.0v 1029.495n 0.0v 1029.505n 0.0v 1039.495n 0.0v 1039.505n 1.7v 1049.495n 1.7v 1049.505n 1.7v 1059.495n 1.7v 1059.505n 1.7v 1069.495n 1.7v 1069.505n 1.7v 1079.495n 1.7v 1079.505n 1.7v 1089.495n 1.7v 1089.505n 0.0v 1099.495n 0.0v 1099.505n 1.7v 1109.495n 1.7v 1109.505n 0.0v 1119.495n 0.0v 1119.505n 0.0v 1129.495n 0.0v 1129.505n 0.0v 1139.495n 0.0v 1139.505n 1.7v 1149.495n 1.7v 1149.505n 1.7v 1159.495n 1.7v 1159.505n 1.7v 1169.495n 1.7v 1169.505n 0.0v 1179.495n 0.0v 1179.505n 0.0v 1189.495n 0.0v 1189.505n 0.0v 1199.495n 0.0v 1199.505n 1.7v 1209.495n 1.7v 1209.505n 0.0v 1219.495n 0.0v 1219.505n 1.7v 1229.495n 1.7v 1229.505n 0.0v 1239.495n 0.0v 1239.505n 0.0v 1249.495n 0.0v 1249.505n 0.0v 1259.495n 0.0v 1259.505n 0.0v 1269.495n 0.0v 1269.505n 1.7v 1279.495n 1.7v 1279.505n 1.7v 1289.495n 1.7v 1289.505n 0.0v 1299.495n 0.0v 1299.505n 0.0v 1309.495n 0.0v 1309.505n 0.0v 1319.495n 0.0v 1319.505n 0.0v 1329.495n 0.0v 1329.505n 0.0v 1339.495n 0.0v 1339.505n 1.7v 1349.495n 1.7v 1349.505n 1.7v 1359.495n 1.7v 1359.505n 1.7v 1369.495n 1.7v 1369.505n 0.0v 1379.495n 0.0v 1379.505n 0.0v 1389.495n 0.0v 1389.505n 0.0v 1399.495n 0.0v 1399.505n 1.7v 1409.495n 1.7v 1409.505n 0.0v 1419.495n 0.0v 1419.505n 0.0v 1429.495n 0.0v 1429.505n 0.0v 1439.495n 0.0v 1439.505n 0.0v 1449.495n 0.0v 1449.505n 0.0v 1459.495n 0.0v 1459.505n 0.0v 1469.495n 0.0v 1469.505n 1.7v 1479.495n 1.7v 1479.505n 1.7v 1489.495n 1.7v 1489.505n 1.7v 1499.495n 1.7v 1499.505n 1.7v 1509.495n 1.7v 1509.505n 0.0v 1519.495n 0.0v 1519.505n 0.0v 1529.495n 0.0v 1529.505n 1.7v 1539.495n 1.7v 1539.505n 0.0v 1549.495n 0.0v 1549.505n 0.0v 1559.495n 0.0v 1559.505n 0.0v 1569.495n 0.0v 1569.505n 0.0v 1579.495n 0.0v 1579.505n 0.0v 1589.495n 0.0v 1589.505n 0.0v 1599.495n 0.0v 1599.505n 0.0v 1609.495n 0.0v 1609.505n 1.7v 1619.495n 1.7v 1619.505n 1.7v 1629.495n 1.7v 1629.505n 1.7v 1639.495n 1.7v 1639.505n 0.0v 1649.495n 0.0v 1649.505n 0.0v 1659.495n 0.0v 1659.505n 0.0v 1669.495n 0.0v 1669.505n 1.7v 1679.495n 1.7v 1679.505n 1.7v 1689.495n 1.7v 1689.505n 1.7v 1699.495n 1.7v 1699.505n 1.7v 1709.495n 1.7v 1709.505n 0.0v 1719.495n 0.0v 1719.505n 1.7v 1729.495n 1.7v 1729.505n 1.7v 1739.495n 1.7v 1739.505n 1.7v 1749.495n 1.7v 1749.505n 1.7v 1759.495n 1.7v 1759.505n 1.7v 1769.495n 1.7v 1769.505n 1.7v 1779.495n 1.7v 1779.505n 0.0v 1789.495n 0.0v 1789.505n 0.0v 1799.495n 0.0v 1799.505n 0.0v 1809.495n 0.0v 1809.505n 0.0v 1819.495n 0.0v 1819.505n 1.7v 1829.495n 1.7v 1829.505n 1.7v 1839.495n 1.7v 1839.505n 1.7v 1849.495n 1.7v 1849.505n 1.7v 1859.495n 1.7v 1859.505n 1.7v 1869.495n 1.7v 1869.505n 1.7v 1879.495n 1.7v 1879.505n 1.7v 1889.495n 1.7v 1889.505n 1.7v 1899.495n 1.7v 1899.505n 0.0v 1909.495n 0.0v 1909.505n 0.0v 1919.495n 0.0v 1919.505n 0.0v 1929.495n 0.0v 1929.505n 0.0v 1939.495n 0.0v 1939.505n 0.0v 1949.495n 0.0v 1949.505n 0.0v 1959.495n 0.0v 1959.505n 0.0v 1969.495n 0.0v 1969.505n 0.0v 1979.495n 0.0v 1979.505n 0.0v 1989.495n 0.0v 1989.505n 0.0v 1999.495n 0.0v 1999.505n 0.0v 2009.495n 0.0v 2009.505n 0.0v 2019.495n 0.0v 2019.505n 0.0v 2029.495n 0.0v 2029.505n 0.0v 2039.495n 0.0v 2039.505n 0.0v 2049.495n 0.0v 2049.505n 0.0v )
* (time, data): [(0, 0), (10, 1), (20, 0), (30, 1), (40, 1), (50, 0), (60, 1), (70, 1), (80, 0), (90, 0), (100, 0), (110, 0), (120, 1), (130, 1), (140, 0), (150, 0), (160, 0), (170, 0), (180, 0), (190, 0), (200, 0), (210, 1), (220, 1), (230, 1), (240, 0), (250, 0), (260, 0), (270, 0), (280, 0), (290, 0), (300, 1), (310, 0), (320, 0), (330, 0), (340, 0), (350, 0), (360, 0), (370, 0), (380, 0), (390, 0), (400, 0), (410, 0), (420, 0), (430, 1), (440, 0), (450, 0), (460, 0), (470, 0), (480, 0), (490, 0), (500, 0), (510, 0), (520, 1), (530, 1), (540, 0), (550, 0), (560, 0), (570, 0), (580, 0), (590, 1), (600, 1), (610, 1), (620, 1), (630, 0), (640, 1), (650, 1), (660, 1), (670, 1), (680, 1), (690, 1), (700, 0), (710, 0), (720, 0), (730, 0), (740, 1), (750, 0), (760, 1), (770, 0), (780, 0), (790, 0), (800, 0), (810, 0), (820, 0), (830, 0), (840, 0), (850, 0), (860, 1), (870, 1), (880, 1), (890, 1), (900, 1), (910, 1), (920, 1), (930, 1), (940, 1), (950, 1), (960, 1), (970, 1), (980, 0), (990, 0), (1000, 0), (1010, 0), (1020, 0), (1030, 0), (1040, 1), (1050, 1), (1060, 1), (1070, 1), (1080, 1), (1090, 1), (1100, 0), (1110, 1), (1120, 1), (1130, 1), (1140, 0), (1150, 1), (1160, 1), (1170, 0), (1180, 1), (1190, 1), (1200, 0), (1210, 1), (1220, 1), (1230, 0), (1240, 1), (1250, 1), (1260, 1), (1270, 1), (1280, 1), (1290, 1), (1300, 1), (1310, 1), (1320, 1), (1330, 1), (1340, 1), (1350, 1), (1360, 1), (1370, 0), (1380, 1), (1390, 1), (1400, 0), (1410, 0), (1420, 0), (1430, 0), (1440, 1), (1450, 0), (1460, 0), (1470, 0), (1480, 0), (1490, 1), (1500, 1), (1510, 1), (1520, 1), (1530, 1), (1540, 1), (1550, 0), (1560, 0), (1570, 1), (1580, 0), (1590, 1), (1600, 1), (1610, 1), (1620, 1), (1630, 1), (1640, 0), (1650, 0), (1660, 0), (1670, 0), (1680, 1), (1690, 0), (1700, 1), (1710, 0), (1720, 1), (1730, 1), (1740, 1), (1750, 1), (1760, 0), (1770, 1), (1780, 0), (1790, 0), (1800, 0), (1810, 1), (1820, 0), (1830, 1), (1840, 0), (1850, 0), (1860, 0), (1870, 0), (1880, 0), (1890, 0), (1900, 0), (1910, 0), (1920, 1), (1930, 1), (1940, 1), (1950, 1), (1960, 1), (1970, 0), (1980, 0), (1990, 1), (2000, 1), (2010, 1), (2020, 0), (2030, 1), (2040, 1), (2050, 1)]
Vdin0_9  din0_9  0 PWL (0n 0.0v 9.495n 0.0v 9.505n 1.7v 19.495n 1.7v 19.505n 0.0v 29.495n 0.0v 29.505n 1.7v 39.495n 1.7v 39.505n 1.7v 49.495n 1.7v 49.505n 0.0v 59.495n 0.0v 59.505n 1.7v 69.495n 1.7v 69.505n 1.7v 79.495n 1.7v 79.505n 0.0v 89.495n 0.0v 89.505n 0.0v 99.495n 0.0v 99.505n 0.0v 109.495n 0.0v 109.505n 0.0v 119.495n 0.0v 119.505n 1.7v 129.495n 1.7v 129.505n 1.7v 139.495n 1.7v 139.505n 0.0v 149.495n 0.0v 149.505n 0.0v 159.495n 0.0v 159.505n 0.0v 169.495n 0.0v 169.505n 0.0v 179.495n 0.0v 179.505n 0.0v 189.495n 0.0v 189.505n 0.0v 199.495n 0.0v 199.505n 0.0v 209.495n 0.0v 209.505n 1.7v 219.495n 1.7v 219.505n 1.7v 229.495n 1.7v 229.505n 1.7v 239.495n 1.7v 239.505n 0.0v 249.495n 0.0v 249.505n 0.0v 259.495n 0.0v 259.505n 0.0v 269.495n 0.0v 269.505n 0.0v 279.495n 0.0v 279.505n 0.0v 289.495n 0.0v 289.505n 0.0v 299.495n 0.0v 299.505n 1.7v 309.495n 1.7v 309.505n 0.0v 319.495n 0.0v 319.505n 0.0v 329.495n 0.0v 329.505n 0.0v 339.495n 0.0v 339.505n 0.0v 349.495n 0.0v 349.505n 0.0v 359.495n 0.0v 359.505n 0.0v 369.495n 0.0v 369.505n 0.0v 379.495n 0.0v 379.505n 0.0v 389.495n 0.0v 389.505n 0.0v 399.495n 0.0v 399.505n 0.0v 409.495n 0.0v 409.505n 0.0v 419.495n 0.0v 419.505n 0.0v 429.495n 0.0v 429.505n 1.7v 439.495n 1.7v 439.505n 0.0v 449.495n 0.0v 449.505n 0.0v 459.495n 0.0v 459.505n 0.0v 469.495n 0.0v 469.505n 0.0v 479.495n 0.0v 479.505n 0.0v 489.495n 0.0v 489.505n 0.0v 499.495n 0.0v 499.505n 0.0v 509.495n 0.0v 509.505n 0.0v 519.495n 0.0v 519.505n 1.7v 529.495n 1.7v 529.505n 1.7v 539.495n 1.7v 539.505n 0.0v 549.495n 0.0v 549.505n 0.0v 559.495n 0.0v 559.505n 0.0v 569.495n 0.0v 569.505n 0.0v 579.495n 0.0v 579.505n 0.0v 589.495n 0.0v 589.505n 1.7v 599.495n 1.7v 599.505n 1.7v 609.495n 1.7v 609.505n 1.7v 619.495n 1.7v 619.505n 1.7v 629.495n 1.7v 629.505n 0.0v 639.495n 0.0v 639.505n 1.7v 649.495n 1.7v 649.505n 1.7v 659.495n 1.7v 659.505n 1.7v 669.495n 1.7v 669.505n 1.7v 679.495n 1.7v 679.505n 1.7v 689.495n 1.7v 689.505n 1.7v 699.495n 1.7v 699.505n 0.0v 709.495n 0.0v 709.505n 0.0v 719.495n 0.0v 719.505n 0.0v 729.495n 0.0v 729.505n 0.0v 739.495n 0.0v 739.505n 1.7v 749.495n 1.7v 749.505n 0.0v 759.495n 0.0v 759.505n 1.7v 769.495n 1.7v 769.505n 0.0v 779.495n 0.0v 779.505n 0.0v 789.495n 0.0v 789.505n 0.0v 799.495n 0.0v 799.505n 0.0v 809.495n 0.0v 809.505n 0.0v 819.495n 0.0v 819.505n 0.0v 829.495n 0.0v 829.505n 0.0v 839.495n 0.0v 839.505n 0.0v 849.495n 0.0v 849.505n 0.0v 859.495n 0.0v 859.505n 1.7v 869.495n 1.7v 869.505n 1.7v 879.495n 1.7v 879.505n 1.7v 889.495n 1.7v 889.505n 1.7v 899.495n 1.7v 899.505n 1.7v 909.495n 1.7v 909.505n 1.7v 919.495n 1.7v 919.505n 1.7v 929.495n 1.7v 929.505n 1.7v 939.495n 1.7v 939.505n 1.7v 949.495n 1.7v 949.505n 1.7v 959.495n 1.7v 959.505n 1.7v 969.495n 1.7v 969.505n 1.7v 979.495n 1.7v 979.505n 0.0v 989.495n 0.0v 989.505n 0.0v 999.495n 0.0v 999.505n 0.0v 1009.495n 0.0v 1009.505n 0.0v 1019.495n 0.0v 1019.505n 0.0v 1029.495n 0.0v 1029.505n 0.0v 1039.495n 0.0v 1039.505n 1.7v 1049.495n 1.7v 1049.505n 1.7v 1059.495n 1.7v 1059.505n 1.7v 1069.495n 1.7v 1069.505n 1.7v 1079.495n 1.7v 1079.505n 1.7v 1089.495n 1.7v 1089.505n 1.7v 1099.495n 1.7v 1099.505n 0.0v 1109.495n 0.0v 1109.505n 1.7v 1119.495n 1.7v 1119.505n 1.7v 1129.495n 1.7v 1129.505n 1.7v 1139.495n 1.7v 1139.505n 0.0v 1149.495n 0.0v 1149.505n 1.7v 1159.495n 1.7v 1159.505n 1.7v 1169.495n 1.7v 1169.505n 0.0v 1179.495n 0.0v 1179.505n 1.7v 1189.495n 1.7v 1189.505n 1.7v 1199.495n 1.7v 1199.505n 0.0v 1209.495n 0.0v 1209.505n 1.7v 1219.495n 1.7v 1219.505n 1.7v 1229.495n 1.7v 1229.505n 0.0v 1239.495n 0.0v 1239.505n 1.7v 1249.495n 1.7v 1249.505n 1.7v 1259.495n 1.7v 1259.505n 1.7v 1269.495n 1.7v 1269.505n 1.7v 1279.495n 1.7v 1279.505n 1.7v 1289.495n 1.7v 1289.505n 1.7v 1299.495n 1.7v 1299.505n 1.7v 1309.495n 1.7v 1309.505n 1.7v 1319.495n 1.7v 1319.505n 1.7v 1329.495n 1.7v 1329.505n 1.7v 1339.495n 1.7v 1339.505n 1.7v 1349.495n 1.7v 1349.505n 1.7v 1359.495n 1.7v 1359.505n 1.7v 1369.495n 1.7v 1369.505n 0.0v 1379.495n 0.0v 1379.505n 1.7v 1389.495n 1.7v 1389.505n 1.7v 1399.495n 1.7v 1399.505n 0.0v 1409.495n 0.0v 1409.505n 0.0v 1419.495n 0.0v 1419.505n 0.0v 1429.495n 0.0v 1429.505n 0.0v 1439.495n 0.0v 1439.505n 1.7v 1449.495n 1.7v 1449.505n 0.0v 1459.495n 0.0v 1459.505n 0.0v 1469.495n 0.0v 1469.505n 0.0v 1479.495n 0.0v 1479.505n 0.0v 1489.495n 0.0v 1489.505n 1.7v 1499.495n 1.7v 1499.505n 1.7v 1509.495n 1.7v 1509.505n 1.7v 1519.495n 1.7v 1519.505n 1.7v 1529.495n 1.7v 1529.505n 1.7v 1539.495n 1.7v 1539.505n 1.7v 1549.495n 1.7v 1549.505n 0.0v 1559.495n 0.0v 1559.505n 0.0v 1569.495n 0.0v 1569.505n 1.7v 1579.495n 1.7v 1579.505n 0.0v 1589.495n 0.0v 1589.505n 1.7v 1599.495n 1.7v 1599.505n 1.7v 1609.495n 1.7v 1609.505n 1.7v 1619.495n 1.7v 1619.505n 1.7v 1629.495n 1.7v 1629.505n 1.7v 1639.495n 1.7v 1639.505n 0.0v 1649.495n 0.0v 1649.505n 0.0v 1659.495n 0.0v 1659.505n 0.0v 1669.495n 0.0v 1669.505n 0.0v 1679.495n 0.0v 1679.505n 1.7v 1689.495n 1.7v 1689.505n 0.0v 1699.495n 0.0v 1699.505n 1.7v 1709.495n 1.7v 1709.505n 0.0v 1719.495n 0.0v 1719.505n 1.7v 1729.495n 1.7v 1729.505n 1.7v 1739.495n 1.7v 1739.505n 1.7v 1749.495n 1.7v 1749.505n 1.7v 1759.495n 1.7v 1759.505n 0.0v 1769.495n 0.0v 1769.505n 1.7v 1779.495n 1.7v 1779.505n 0.0v 1789.495n 0.0v 1789.505n 0.0v 1799.495n 0.0v 1799.505n 0.0v 1809.495n 0.0v 1809.505n 1.7v 1819.495n 1.7v 1819.505n 0.0v 1829.495n 0.0v 1829.505n 1.7v 1839.495n 1.7v 1839.505n 0.0v 1849.495n 0.0v 1849.505n 0.0v 1859.495n 0.0v 1859.505n 0.0v 1869.495n 0.0v 1869.505n 0.0v 1879.495n 0.0v 1879.505n 0.0v 1889.495n 0.0v 1889.505n 0.0v 1899.495n 0.0v 1899.505n 0.0v 1909.495n 0.0v 1909.505n 0.0v 1919.495n 0.0v 1919.505n 1.7v 1929.495n 1.7v 1929.505n 1.7v 1939.495n 1.7v 1939.505n 1.7v 1949.495n 1.7v 1949.505n 1.7v 1959.495n 1.7v 1959.505n 1.7v 1969.495n 1.7v 1969.505n 0.0v 1979.495n 0.0v 1979.505n 0.0v 1989.495n 0.0v 1989.505n 1.7v 1999.495n 1.7v 1999.505n 1.7v 2009.495n 1.7v 2009.505n 1.7v 2019.495n 1.7v 2019.505n 0.0v 2029.495n 0.0v 2029.505n 1.7v 2039.495n 1.7v 2039.505n 1.7v 2049.495n 1.7v 2049.505n 1.7v )
* (time, data): [(0, 0), (10, 0), (20, 0), (30, 0), (40, 0), (50, 1), (60, 1), (70, 1), (80, 0), (90, 0), (100, 0), (110, 0), (120, 0), (130, 0), (140, 0), (150, 0), (160, 0), (170, 0), (180, 1), (190, 1), (200, 1), (210, 0), (220, 0), (230, 0), (240, 1), (250, 1), (260, 1), (270, 1), (280, 1), (290, 1), (300, 1), (310, 0), (320, 0), (330, 1), (340, 1), (350, 1), (360, 1), (370, 1), (380, 0), (390, 0), (400, 0), (410, 0), (420, 0), (430, 1), (440, 1), (450, 1), (460, 0), (470, 1), (480, 1), (490, 1), (500, 1), (510, 1), (520, 1), (530, 0), (540, 1), (550, 1), (560, 1), (570, 1), (580, 1), (590, 0), (600, 0), (610, 0), (620, 0), (630, 1), (640, 1), (650, 1), (660, 1), (670, 1), (680, 1), (690, 1), (700, 0), (710, 0), (720, 0), (730, 0), (740, 0), (750, 0), (760, 1), (770, 1), (780, 1), (790, 0), (800, 0), (810, 1), (820, 1), (830, 1), (840, 1), (850, 0), (860, 1), (870, 0), (880, 0), (890, 0), (900, 0), (910, 0), (920, 1), (930, 1), (940, 1), (950, 1), (960, 1), (970, 1), (980, 1), (990, 1), (1000, 1), (1010, 1), (1020, 1), (1030, 1), (1040, 0), (1050, 0), (1060, 0), (1070, 0), (1080, 0), (1090, 1), (1100, 1), (1110, 0), (1120, 0), (1130, 0), (1140, 0), (1150, 0), (1160, 0), (1170, 1), (1180, 0), (1190, 0), (1200, 0), (1210, 1), (1220, 0), (1230, 0), (1240, 0), (1250, 0), (1260, 0), (1270, 0), (1280, 0), (1290, 1), (1300, 1), (1310, 1), (1320, 0), (1330, 0), (1340, 0), (1350, 0), (1360, 0), (1370, 0), (1380, 1), (1390, 1), (1400, 1), (1410, 1), (1420, 1), (1430, 1), (1440, 1), (1450, 1), (1460, 1), (1470, 0), (1480, 0), (1490, 0), (1500, 0), (1510, 1), (1520, 1), (1530, 0), (1540, 1), (1550, 0), (1560, 0), (1570, 0), (1580, 1), (1590, 0), (1600, 0), (1610, 0), (1620, 0), (1630, 0), (1640, 1), (1650, 1), (1660, 1), (1670, 1), (1680, 1), (1690, 0), (1700, 1), (1710, 1), (1720, 1), (1730, 1), (1740, 0), (1750, 0), (1760, 1), (1770, 0), (1780, 1), (1790, 0), (1800, 1), (1810, 1), (1820, 0), (1830, 1), (1840, 0), (1850, 0), (1860, 0), (1870, 0), (1880, 1), (1890, 1), (1900, 1), (1910, 1), (1920, 1), (1930, 1), (1940, 1), (1950, 1), (1960, 1), (1970, 0), (1980, 0), (1990, 1), (2000, 1), (2010, 1), (2020, 0), (2030, 1), (2040, 1), (2050, 1)]
Vdin0_10  din0_10  0 PWL (0n 0.0v 9.495n 0.0v 9.505n 0.0v 19.495n 0.0v 19.505n 0.0v 29.495n 0.0v 29.505n 0.0v 39.495n 0.0v 39.505n 0.0v 49.495n 0.0v 49.505n 1.7v 59.495n 1.7v 59.505n 1.7v 69.495n 1.7v 69.505n 1.7v 79.495n 1.7v 79.505n 0.0v 89.495n 0.0v 89.505n 0.0v 99.495n 0.0v 99.505n 0.0v 109.495n 0.0v 109.505n 0.0v 119.495n 0.0v 119.505n 0.0v 129.495n 0.0v 129.505n 0.0v 139.495n 0.0v 139.505n 0.0v 149.495n 0.0v 149.505n 0.0v 159.495n 0.0v 159.505n 0.0v 169.495n 0.0v 169.505n 0.0v 179.495n 0.0v 179.505n 1.7v 189.495n 1.7v 189.505n 1.7v 199.495n 1.7v 199.505n 1.7v 209.495n 1.7v 209.505n 0.0v 219.495n 0.0v 219.505n 0.0v 229.495n 0.0v 229.505n 0.0v 239.495n 0.0v 239.505n 1.7v 249.495n 1.7v 249.505n 1.7v 259.495n 1.7v 259.505n 1.7v 269.495n 1.7v 269.505n 1.7v 279.495n 1.7v 279.505n 1.7v 289.495n 1.7v 289.505n 1.7v 299.495n 1.7v 299.505n 1.7v 309.495n 1.7v 309.505n 0.0v 319.495n 0.0v 319.505n 0.0v 329.495n 0.0v 329.505n 1.7v 339.495n 1.7v 339.505n 1.7v 349.495n 1.7v 349.505n 1.7v 359.495n 1.7v 359.505n 1.7v 369.495n 1.7v 369.505n 1.7v 379.495n 1.7v 379.505n 0.0v 389.495n 0.0v 389.505n 0.0v 399.495n 0.0v 399.505n 0.0v 409.495n 0.0v 409.505n 0.0v 419.495n 0.0v 419.505n 0.0v 429.495n 0.0v 429.505n 1.7v 439.495n 1.7v 439.505n 1.7v 449.495n 1.7v 449.505n 1.7v 459.495n 1.7v 459.505n 0.0v 469.495n 0.0v 469.505n 1.7v 479.495n 1.7v 479.505n 1.7v 489.495n 1.7v 489.505n 1.7v 499.495n 1.7v 499.505n 1.7v 509.495n 1.7v 509.505n 1.7v 519.495n 1.7v 519.505n 1.7v 529.495n 1.7v 529.505n 0.0v 539.495n 0.0v 539.505n 1.7v 549.495n 1.7v 549.505n 1.7v 559.495n 1.7v 559.505n 1.7v 569.495n 1.7v 569.505n 1.7v 579.495n 1.7v 579.505n 1.7v 589.495n 1.7v 589.505n 0.0v 599.495n 0.0v 599.505n 0.0v 609.495n 0.0v 609.505n 0.0v 619.495n 0.0v 619.505n 0.0v 629.495n 0.0v 629.505n 1.7v 639.495n 1.7v 639.505n 1.7v 649.495n 1.7v 649.505n 1.7v 659.495n 1.7v 659.505n 1.7v 669.495n 1.7v 669.505n 1.7v 679.495n 1.7v 679.505n 1.7v 689.495n 1.7v 689.505n 1.7v 699.495n 1.7v 699.505n 0.0v 709.495n 0.0v 709.505n 0.0v 719.495n 0.0v 719.505n 0.0v 729.495n 0.0v 729.505n 0.0v 739.495n 0.0v 739.505n 0.0v 749.495n 0.0v 749.505n 0.0v 759.495n 0.0v 759.505n 1.7v 769.495n 1.7v 769.505n 1.7v 779.495n 1.7v 779.505n 1.7v 789.495n 1.7v 789.505n 0.0v 799.495n 0.0v 799.505n 0.0v 809.495n 0.0v 809.505n 1.7v 819.495n 1.7v 819.505n 1.7v 829.495n 1.7v 829.505n 1.7v 839.495n 1.7v 839.505n 1.7v 849.495n 1.7v 849.505n 0.0v 859.495n 0.0v 859.505n 1.7v 869.495n 1.7v 869.505n 0.0v 879.495n 0.0v 879.505n 0.0v 889.495n 0.0v 889.505n 0.0v 899.495n 0.0v 899.505n 0.0v 909.495n 0.0v 909.505n 0.0v 919.495n 0.0v 919.505n 1.7v 929.495n 1.7v 929.505n 1.7v 939.495n 1.7v 939.505n 1.7v 949.495n 1.7v 949.505n 1.7v 959.495n 1.7v 959.505n 1.7v 969.495n 1.7v 969.505n 1.7v 979.495n 1.7v 979.505n 1.7v 989.495n 1.7v 989.505n 1.7v 999.495n 1.7v 999.505n 1.7v 1009.495n 1.7v 1009.505n 1.7v 1019.495n 1.7v 1019.505n 1.7v 1029.495n 1.7v 1029.505n 1.7v 1039.495n 1.7v 1039.505n 0.0v 1049.495n 0.0v 1049.505n 0.0v 1059.495n 0.0v 1059.505n 0.0v 1069.495n 0.0v 1069.505n 0.0v 1079.495n 0.0v 1079.505n 0.0v 1089.495n 0.0v 1089.505n 1.7v 1099.495n 1.7v 1099.505n 1.7v 1109.495n 1.7v 1109.505n 0.0v 1119.495n 0.0v 1119.505n 0.0v 1129.495n 0.0v 1129.505n 0.0v 1139.495n 0.0v 1139.505n 0.0v 1149.495n 0.0v 1149.505n 0.0v 1159.495n 0.0v 1159.505n 0.0v 1169.495n 0.0v 1169.505n 1.7v 1179.495n 1.7v 1179.505n 0.0v 1189.495n 0.0v 1189.505n 0.0v 1199.495n 0.0v 1199.505n 0.0v 1209.495n 0.0v 1209.505n 1.7v 1219.495n 1.7v 1219.505n 0.0v 1229.495n 0.0v 1229.505n 0.0v 1239.495n 0.0v 1239.505n 0.0v 1249.495n 0.0v 1249.505n 0.0v 1259.495n 0.0v 1259.505n 0.0v 1269.495n 0.0v 1269.505n 0.0v 1279.495n 0.0v 1279.505n 0.0v 1289.495n 0.0v 1289.505n 1.7v 1299.495n 1.7v 1299.505n 1.7v 1309.495n 1.7v 1309.505n 1.7v 1319.495n 1.7v 1319.505n 0.0v 1329.495n 0.0v 1329.505n 0.0v 1339.495n 0.0v 1339.505n 0.0v 1349.495n 0.0v 1349.505n 0.0v 1359.495n 0.0v 1359.505n 0.0v 1369.495n 0.0v 1369.505n 0.0v 1379.495n 0.0v 1379.505n 1.7v 1389.495n 1.7v 1389.505n 1.7v 1399.495n 1.7v 1399.505n 1.7v 1409.495n 1.7v 1409.505n 1.7v 1419.495n 1.7v 1419.505n 1.7v 1429.495n 1.7v 1429.505n 1.7v 1439.495n 1.7v 1439.505n 1.7v 1449.495n 1.7v 1449.505n 1.7v 1459.495n 1.7v 1459.505n 1.7v 1469.495n 1.7v 1469.505n 0.0v 1479.495n 0.0v 1479.505n 0.0v 1489.495n 0.0v 1489.505n 0.0v 1499.495n 0.0v 1499.505n 0.0v 1509.495n 0.0v 1509.505n 1.7v 1519.495n 1.7v 1519.505n 1.7v 1529.495n 1.7v 1529.505n 0.0v 1539.495n 0.0v 1539.505n 1.7v 1549.495n 1.7v 1549.505n 0.0v 1559.495n 0.0v 1559.505n 0.0v 1569.495n 0.0v 1569.505n 0.0v 1579.495n 0.0v 1579.505n 1.7v 1589.495n 1.7v 1589.505n 0.0v 1599.495n 0.0v 1599.505n 0.0v 1609.495n 0.0v 1609.505n 0.0v 1619.495n 0.0v 1619.505n 0.0v 1629.495n 0.0v 1629.505n 0.0v 1639.495n 0.0v 1639.505n 1.7v 1649.495n 1.7v 1649.505n 1.7v 1659.495n 1.7v 1659.505n 1.7v 1669.495n 1.7v 1669.505n 1.7v 1679.495n 1.7v 1679.505n 1.7v 1689.495n 1.7v 1689.505n 0.0v 1699.495n 0.0v 1699.505n 1.7v 1709.495n 1.7v 1709.505n 1.7v 1719.495n 1.7v 1719.505n 1.7v 1729.495n 1.7v 1729.505n 1.7v 1739.495n 1.7v 1739.505n 0.0v 1749.495n 0.0v 1749.505n 0.0v 1759.495n 0.0v 1759.505n 1.7v 1769.495n 1.7v 1769.505n 0.0v 1779.495n 0.0v 1779.505n 1.7v 1789.495n 1.7v 1789.505n 0.0v 1799.495n 0.0v 1799.505n 1.7v 1809.495n 1.7v 1809.505n 1.7v 1819.495n 1.7v 1819.505n 0.0v 1829.495n 0.0v 1829.505n 1.7v 1839.495n 1.7v 1839.505n 0.0v 1849.495n 0.0v 1849.505n 0.0v 1859.495n 0.0v 1859.505n 0.0v 1869.495n 0.0v 1869.505n 0.0v 1879.495n 0.0v 1879.505n 1.7v 1889.495n 1.7v 1889.505n 1.7v 1899.495n 1.7v 1899.505n 1.7v 1909.495n 1.7v 1909.505n 1.7v 1919.495n 1.7v 1919.505n 1.7v 1929.495n 1.7v 1929.505n 1.7v 1939.495n 1.7v 1939.505n 1.7v 1949.495n 1.7v 1949.505n 1.7v 1959.495n 1.7v 1959.505n 1.7v 1969.495n 1.7v 1969.505n 0.0v 1979.495n 0.0v 1979.505n 0.0v 1989.495n 0.0v 1989.505n 1.7v 1999.495n 1.7v 1999.505n 1.7v 2009.495n 1.7v 2009.505n 1.7v 2019.495n 1.7v 2019.505n 0.0v 2029.495n 0.0v 2029.505n 1.7v 2039.495n 1.7v 2039.505n 1.7v 2049.495n 1.7v 2049.505n 1.7v )
* (time, data): [(0, 0), (10, 1), (20, 1), (30, 1), (40, 1), (50, 1), (60, 0), (70, 0), (80, 0), (90, 0), (100, 0), (110, 0), (120, 1), (130, 1), (140, 0), (150, 0), (160, 0), (170, 0), (180, 0), (190, 0), (200, 0), (210, 0), (220, 0), (230, 0), (240, 1), (250, 1), (260, 1), (270, 1), (280, 1), (290, 1), (300, 0), (310, 1), (320, 1), (330, 1), (340, 1), (350, 1), (360, 1), (370, 1), (380, 1), (390, 1), (400, 1), (410, 1), (420, 1), (430, 1), (440, 1), (450, 1), (460, 0), (470, 1), (480, 1), (490, 1), (500, 1), (510, 0), (520, 0), (530, 1), (540, 0), (550, 1), (560, 1), (570, 1), (580, 1), (590, 0), (600, 0), (610, 0), (620, 0), (630, 0), (640, 1), (650, 1), (660, 0), (670, 0), (680, 0), (690, 0), (700, 0), (710, 0), (720, 1), (730, 1), (740, 0), (750, 1), (760, 0), (770, 1), (780, 1), (790, 1), (800, 1), (810, 1), (820, 0), (830, 0), (840, 0), (850, 1), (860, 1), (870, 1), (880, 1), (890, 1), (900, 1), (910, 1), (920, 1), (930, 0), (940, 1), (950, 1), (960, 1), (970, 1), (980, 0), (990, 0), (1000, 0), (1010, 0), (1020, 0), (1030, 0), (1040, 1), (1050, 1), (1060, 1), (1070, 1), (1080, 1), (1090, 1), (1100, 1), (1110, 0), (1120, 0), (1130, 0), (1140, 0), (1150, 0), (1160, 0), (1170, 0), (1180, 1), (1190, 1), (1200, 0), (1210, 1), (1220, 1), (1230, 1), (1240, 1), (1250, 1), (1260, 1), (1270, 0), (1280, 0), (1290, 1), (1300, 1), (1310, 1), (1320, 0), (1330, 0), (1340, 0), (1350, 0), (1360, 0), (1370, 1), (1380, 0), (1390, 0), (1400, 0), (1410, 0), (1420, 0), (1430, 0), (1440, 1), (1450, 0), (1460, 0), (1470, 1), (1480, 1), (1490, 1), (1500, 1), (1510, 0), (1520, 0), (1530, 1), (1540, 0), (1550, 1), (1560, 1), (1570, 0), (1580, 0), (1590, 1), (1600, 1), (1610, 1), (1620, 1), (1630, 1), (1640, 0), (1650, 0), (1660, 0), (1670, 0), (1680, 0), (1690, 0), (1700, 1), (1710, 0), (1720, 1), (1730, 1), (1740, 1), (1750, 1), (1760, 1), (1770, 0), (1780, 1), (1790, 1), (1800, 0), (1810, 1), (1820, 1), (1830, 0), (1840, 1), (1850, 1), (1860, 1), (1870, 1), (1880, 0), (1890, 0), (1900, 1), (1910, 0), (1920, 1), (1930, 1), (1940, 0), (1950, 1), (1960, 1), (1970, 0), (1980, 0), (1990, 0), (2000, 0), (2010, 0), (2020, 0), (2030, 1), (2040, 1), (2050, 1)]
Vdin0_11  din0_11  0 PWL (0n 0.0v 9.495n 0.0v 9.505n 1.7v 19.495n 1.7v 19.505n 1.7v 29.495n 1.7v 29.505n 1.7v 39.495n 1.7v 39.505n 1.7v 49.495n 1.7v 49.505n 1.7v 59.495n 1.7v 59.505n 0.0v 69.495n 0.0v 69.505n 0.0v 79.495n 0.0v 79.505n 0.0v 89.495n 0.0v 89.505n 0.0v 99.495n 0.0v 99.505n 0.0v 109.495n 0.0v 109.505n 0.0v 119.495n 0.0v 119.505n 1.7v 129.495n 1.7v 129.505n 1.7v 139.495n 1.7v 139.505n 0.0v 149.495n 0.0v 149.505n 0.0v 159.495n 0.0v 159.505n 0.0v 169.495n 0.0v 169.505n 0.0v 179.495n 0.0v 179.505n 0.0v 189.495n 0.0v 189.505n 0.0v 199.495n 0.0v 199.505n 0.0v 209.495n 0.0v 209.505n 0.0v 219.495n 0.0v 219.505n 0.0v 229.495n 0.0v 229.505n 0.0v 239.495n 0.0v 239.505n 1.7v 249.495n 1.7v 249.505n 1.7v 259.495n 1.7v 259.505n 1.7v 269.495n 1.7v 269.505n 1.7v 279.495n 1.7v 279.505n 1.7v 289.495n 1.7v 289.505n 1.7v 299.495n 1.7v 299.505n 0.0v 309.495n 0.0v 309.505n 1.7v 319.495n 1.7v 319.505n 1.7v 329.495n 1.7v 329.505n 1.7v 339.495n 1.7v 339.505n 1.7v 349.495n 1.7v 349.505n 1.7v 359.495n 1.7v 359.505n 1.7v 369.495n 1.7v 369.505n 1.7v 379.495n 1.7v 379.505n 1.7v 389.495n 1.7v 389.505n 1.7v 399.495n 1.7v 399.505n 1.7v 409.495n 1.7v 409.505n 1.7v 419.495n 1.7v 419.505n 1.7v 429.495n 1.7v 429.505n 1.7v 439.495n 1.7v 439.505n 1.7v 449.495n 1.7v 449.505n 1.7v 459.495n 1.7v 459.505n 0.0v 469.495n 0.0v 469.505n 1.7v 479.495n 1.7v 479.505n 1.7v 489.495n 1.7v 489.505n 1.7v 499.495n 1.7v 499.505n 1.7v 509.495n 1.7v 509.505n 0.0v 519.495n 0.0v 519.505n 0.0v 529.495n 0.0v 529.505n 1.7v 539.495n 1.7v 539.505n 0.0v 549.495n 0.0v 549.505n 1.7v 559.495n 1.7v 559.505n 1.7v 569.495n 1.7v 569.505n 1.7v 579.495n 1.7v 579.505n 1.7v 589.495n 1.7v 589.505n 0.0v 599.495n 0.0v 599.505n 0.0v 609.495n 0.0v 609.505n 0.0v 619.495n 0.0v 619.505n 0.0v 629.495n 0.0v 629.505n 0.0v 639.495n 0.0v 639.505n 1.7v 649.495n 1.7v 649.505n 1.7v 659.495n 1.7v 659.505n 0.0v 669.495n 0.0v 669.505n 0.0v 679.495n 0.0v 679.505n 0.0v 689.495n 0.0v 689.505n 0.0v 699.495n 0.0v 699.505n 0.0v 709.495n 0.0v 709.505n 0.0v 719.495n 0.0v 719.505n 1.7v 729.495n 1.7v 729.505n 1.7v 739.495n 1.7v 739.505n 0.0v 749.495n 0.0v 749.505n 1.7v 759.495n 1.7v 759.505n 0.0v 769.495n 0.0v 769.505n 1.7v 779.495n 1.7v 779.505n 1.7v 789.495n 1.7v 789.505n 1.7v 799.495n 1.7v 799.505n 1.7v 809.495n 1.7v 809.505n 1.7v 819.495n 1.7v 819.505n 0.0v 829.495n 0.0v 829.505n 0.0v 839.495n 0.0v 839.505n 0.0v 849.495n 0.0v 849.505n 1.7v 859.495n 1.7v 859.505n 1.7v 869.495n 1.7v 869.505n 1.7v 879.495n 1.7v 879.505n 1.7v 889.495n 1.7v 889.505n 1.7v 899.495n 1.7v 899.505n 1.7v 909.495n 1.7v 909.505n 1.7v 919.495n 1.7v 919.505n 1.7v 929.495n 1.7v 929.505n 0.0v 939.495n 0.0v 939.505n 1.7v 949.495n 1.7v 949.505n 1.7v 959.495n 1.7v 959.505n 1.7v 969.495n 1.7v 969.505n 1.7v 979.495n 1.7v 979.505n 0.0v 989.495n 0.0v 989.505n 0.0v 999.495n 0.0v 999.505n 0.0v 1009.495n 0.0v 1009.505n 0.0v 1019.495n 0.0v 1019.505n 0.0v 1029.495n 0.0v 1029.505n 0.0v 1039.495n 0.0v 1039.505n 1.7v 1049.495n 1.7v 1049.505n 1.7v 1059.495n 1.7v 1059.505n 1.7v 1069.495n 1.7v 1069.505n 1.7v 1079.495n 1.7v 1079.505n 1.7v 1089.495n 1.7v 1089.505n 1.7v 1099.495n 1.7v 1099.505n 1.7v 1109.495n 1.7v 1109.505n 0.0v 1119.495n 0.0v 1119.505n 0.0v 1129.495n 0.0v 1129.505n 0.0v 1139.495n 0.0v 1139.505n 0.0v 1149.495n 0.0v 1149.505n 0.0v 1159.495n 0.0v 1159.505n 0.0v 1169.495n 0.0v 1169.505n 0.0v 1179.495n 0.0v 1179.505n 1.7v 1189.495n 1.7v 1189.505n 1.7v 1199.495n 1.7v 1199.505n 0.0v 1209.495n 0.0v 1209.505n 1.7v 1219.495n 1.7v 1219.505n 1.7v 1229.495n 1.7v 1229.505n 1.7v 1239.495n 1.7v 1239.505n 1.7v 1249.495n 1.7v 1249.505n 1.7v 1259.495n 1.7v 1259.505n 1.7v 1269.495n 1.7v 1269.505n 0.0v 1279.495n 0.0v 1279.505n 0.0v 1289.495n 0.0v 1289.505n 1.7v 1299.495n 1.7v 1299.505n 1.7v 1309.495n 1.7v 1309.505n 1.7v 1319.495n 1.7v 1319.505n 0.0v 1329.495n 0.0v 1329.505n 0.0v 1339.495n 0.0v 1339.505n 0.0v 1349.495n 0.0v 1349.505n 0.0v 1359.495n 0.0v 1359.505n 0.0v 1369.495n 0.0v 1369.505n 1.7v 1379.495n 1.7v 1379.505n 0.0v 1389.495n 0.0v 1389.505n 0.0v 1399.495n 0.0v 1399.505n 0.0v 1409.495n 0.0v 1409.505n 0.0v 1419.495n 0.0v 1419.505n 0.0v 1429.495n 0.0v 1429.505n 0.0v 1439.495n 0.0v 1439.505n 1.7v 1449.495n 1.7v 1449.505n 0.0v 1459.495n 0.0v 1459.505n 0.0v 1469.495n 0.0v 1469.505n 1.7v 1479.495n 1.7v 1479.505n 1.7v 1489.495n 1.7v 1489.505n 1.7v 1499.495n 1.7v 1499.505n 1.7v 1509.495n 1.7v 1509.505n 0.0v 1519.495n 0.0v 1519.505n 0.0v 1529.495n 0.0v 1529.505n 1.7v 1539.495n 1.7v 1539.505n 0.0v 1549.495n 0.0v 1549.505n 1.7v 1559.495n 1.7v 1559.505n 1.7v 1569.495n 1.7v 1569.505n 0.0v 1579.495n 0.0v 1579.505n 0.0v 1589.495n 0.0v 1589.505n 1.7v 1599.495n 1.7v 1599.505n 1.7v 1609.495n 1.7v 1609.505n 1.7v 1619.495n 1.7v 1619.505n 1.7v 1629.495n 1.7v 1629.505n 1.7v 1639.495n 1.7v 1639.505n 0.0v 1649.495n 0.0v 1649.505n 0.0v 1659.495n 0.0v 1659.505n 0.0v 1669.495n 0.0v 1669.505n 0.0v 1679.495n 0.0v 1679.505n 0.0v 1689.495n 0.0v 1689.505n 0.0v 1699.495n 0.0v 1699.505n 1.7v 1709.495n 1.7v 1709.505n 0.0v 1719.495n 0.0v 1719.505n 1.7v 1729.495n 1.7v 1729.505n 1.7v 1739.495n 1.7v 1739.505n 1.7v 1749.495n 1.7v 1749.505n 1.7v 1759.495n 1.7v 1759.505n 1.7v 1769.495n 1.7v 1769.505n 0.0v 1779.495n 0.0v 1779.505n 1.7v 1789.495n 1.7v 1789.505n 1.7v 1799.495n 1.7v 1799.505n 0.0v 1809.495n 0.0v 1809.505n 1.7v 1819.495n 1.7v 1819.505n 1.7v 1829.495n 1.7v 1829.505n 0.0v 1839.495n 0.0v 1839.505n 1.7v 1849.495n 1.7v 1849.505n 1.7v 1859.495n 1.7v 1859.505n 1.7v 1869.495n 1.7v 1869.505n 1.7v 1879.495n 1.7v 1879.505n 0.0v 1889.495n 0.0v 1889.505n 0.0v 1899.495n 0.0v 1899.505n 1.7v 1909.495n 1.7v 1909.505n 0.0v 1919.495n 0.0v 1919.505n 1.7v 1929.495n 1.7v 1929.505n 1.7v 1939.495n 1.7v 1939.505n 0.0v 1949.495n 0.0v 1949.505n 1.7v 1959.495n 1.7v 1959.505n 1.7v 1969.495n 1.7v 1969.505n 0.0v 1979.495n 0.0v 1979.505n 0.0v 1989.495n 0.0v 1989.505n 0.0v 1999.495n 0.0v 1999.505n 0.0v 2009.495n 0.0v 2009.505n 0.0v 2019.495n 0.0v 2019.505n 0.0v 2029.495n 0.0v 2029.505n 1.7v 2039.495n 1.7v 2039.505n 1.7v 2049.495n 1.7v 2049.505n 1.7v )
* (time, data): [(0, 0), (10, 0), (20, 0), (30, 0), (40, 0), (50, 1), (60, 1), (70, 1), (80, 0), (90, 0), (100, 0), (110, 0), (120, 1), (130, 0), (140, 1), (150, 1), (160, 1), (170, 1), (180, 1), (190, 1), (200, 1), (210, 0), (220, 0), (230, 0), (240, 1), (250, 1), (260, 1), (270, 0), (280, 0), (290, 0), (300, 1), (310, 1), (320, 1), (330, 1), (340, 1), (350, 1), (360, 1), (370, 1), (380, 0), (390, 0), (400, 0), (410, 0), (420, 0), (430, 0), (440, 1), (450, 1), (460, 0), (470, 0), (480, 0), (490, 0), (500, 0), (510, 0), (520, 0), (530, 1), (540, 1), (550, 0), (560, 0), (570, 0), (580, 0), (590, 1), (600, 1), (610, 1), (620, 1), (630, 0), (640, 0), (650, 0), (660, 1), (670, 1), (680, 1), (690, 0), (700, 0), (710, 1), (720, 1), (730, 1), (740, 0), (750, 0), (760, 0), (770, 1), (780, 1), (790, 1), (800, 1), (810, 0), (820, 0), (830, 0), (840, 0), (850, 0), (860, 0), (870, 1), (880, 1), (890, 1), (900, 1), (910, 1), (920, 1), (930, 1), (940, 0), (950, 1), (960, 1), (970, 1), (980, 0), (990, 0), (1000, 0), (1010, 0), (1020, 0), (1030, 0), (1040, 0), (1050, 0), (1060, 0), (1070, 0), (1080, 0), (1090, 1), (1100, 1), (1110, 1), (1120, 1), (1130, 1), (1140, 1), (1150, 1), (1160, 0), (1170, 1), (1180, 1), (1190, 1), (1200, 0), (1210, 0), (1220, 0), (1230, 1), (1240, 0), (1250, 0), (1260, 0), (1270, 0), (1280, 0), (1290, 1), (1300, 1), (1310, 1), (1320, 1), (1330, 1), (1340, 0), (1350, 0), (1360, 0), (1370, 0), (1380, 0), (1390, 0), (1400, 0), (1410, 0), (1420, 0), (1430, 0), (1440, 1), (1450, 1), (1460, 1), (1470, 1), (1480, 1), (1490, 0), (1500, 0), (1510, 1), (1520, 1), (1530, 1), (1540, 1), (1550, 0), (1560, 0), (1570, 1), (1580, 1), (1590, 0), (1600, 0), (1610, 0), (1620, 0), (1630, 0), (1640, 1), (1650, 1), (1660, 1), (1670, 0), (1680, 0), (1690, 1), (1700, 0), (1710, 1), (1720, 0), (1730, 0), (1740, 1), (1750, 1), (1760, 0), (1770, 0), (1780, 1), (1790, 0), (1800, 0), (1810, 1), (1820, 1), (1830, 1), (1840, 1), (1850, 1), (1860, 1), (1870, 1), (1880, 0), (1890, 0), (1900, 1), (1910, 0), (1920, 0), (1930, 1), (1940, 1), (1950, 1), (1960, 1), (1970, 0), (1980, 0), (1990, 0), (2000, 0), (2010, 0), (2020, 0), (2030, 1), (2040, 1), (2050, 1)]
Vdin0_12  din0_12  0 PWL (0n 0.0v 9.495n 0.0v 9.505n 0.0v 19.495n 0.0v 19.505n 0.0v 29.495n 0.0v 29.505n 0.0v 39.495n 0.0v 39.505n 0.0v 49.495n 0.0v 49.505n 1.7v 59.495n 1.7v 59.505n 1.7v 69.495n 1.7v 69.505n 1.7v 79.495n 1.7v 79.505n 0.0v 89.495n 0.0v 89.505n 0.0v 99.495n 0.0v 99.505n 0.0v 109.495n 0.0v 109.505n 0.0v 119.495n 0.0v 119.505n 1.7v 129.495n 1.7v 129.505n 0.0v 139.495n 0.0v 139.505n 1.7v 149.495n 1.7v 149.505n 1.7v 159.495n 1.7v 159.505n 1.7v 169.495n 1.7v 169.505n 1.7v 179.495n 1.7v 179.505n 1.7v 189.495n 1.7v 189.505n 1.7v 199.495n 1.7v 199.505n 1.7v 209.495n 1.7v 209.505n 0.0v 219.495n 0.0v 219.505n 0.0v 229.495n 0.0v 229.505n 0.0v 239.495n 0.0v 239.505n 1.7v 249.495n 1.7v 249.505n 1.7v 259.495n 1.7v 259.505n 1.7v 269.495n 1.7v 269.505n 0.0v 279.495n 0.0v 279.505n 0.0v 289.495n 0.0v 289.505n 0.0v 299.495n 0.0v 299.505n 1.7v 309.495n 1.7v 309.505n 1.7v 319.495n 1.7v 319.505n 1.7v 329.495n 1.7v 329.505n 1.7v 339.495n 1.7v 339.505n 1.7v 349.495n 1.7v 349.505n 1.7v 359.495n 1.7v 359.505n 1.7v 369.495n 1.7v 369.505n 1.7v 379.495n 1.7v 379.505n 0.0v 389.495n 0.0v 389.505n 0.0v 399.495n 0.0v 399.505n 0.0v 409.495n 0.0v 409.505n 0.0v 419.495n 0.0v 419.505n 0.0v 429.495n 0.0v 429.505n 0.0v 439.495n 0.0v 439.505n 1.7v 449.495n 1.7v 449.505n 1.7v 459.495n 1.7v 459.505n 0.0v 469.495n 0.0v 469.505n 0.0v 479.495n 0.0v 479.505n 0.0v 489.495n 0.0v 489.505n 0.0v 499.495n 0.0v 499.505n 0.0v 509.495n 0.0v 509.505n 0.0v 519.495n 0.0v 519.505n 0.0v 529.495n 0.0v 529.505n 1.7v 539.495n 1.7v 539.505n 1.7v 549.495n 1.7v 549.505n 0.0v 559.495n 0.0v 559.505n 0.0v 569.495n 0.0v 569.505n 0.0v 579.495n 0.0v 579.505n 0.0v 589.495n 0.0v 589.505n 1.7v 599.495n 1.7v 599.505n 1.7v 609.495n 1.7v 609.505n 1.7v 619.495n 1.7v 619.505n 1.7v 629.495n 1.7v 629.505n 0.0v 639.495n 0.0v 639.505n 0.0v 649.495n 0.0v 649.505n 0.0v 659.495n 0.0v 659.505n 1.7v 669.495n 1.7v 669.505n 1.7v 679.495n 1.7v 679.505n 1.7v 689.495n 1.7v 689.505n 0.0v 699.495n 0.0v 699.505n 0.0v 709.495n 0.0v 709.505n 1.7v 719.495n 1.7v 719.505n 1.7v 729.495n 1.7v 729.505n 1.7v 739.495n 1.7v 739.505n 0.0v 749.495n 0.0v 749.505n 0.0v 759.495n 0.0v 759.505n 0.0v 769.495n 0.0v 769.505n 1.7v 779.495n 1.7v 779.505n 1.7v 789.495n 1.7v 789.505n 1.7v 799.495n 1.7v 799.505n 1.7v 809.495n 1.7v 809.505n 0.0v 819.495n 0.0v 819.505n 0.0v 829.495n 0.0v 829.505n 0.0v 839.495n 0.0v 839.505n 0.0v 849.495n 0.0v 849.505n 0.0v 859.495n 0.0v 859.505n 0.0v 869.495n 0.0v 869.505n 1.7v 879.495n 1.7v 879.505n 1.7v 889.495n 1.7v 889.505n 1.7v 899.495n 1.7v 899.505n 1.7v 909.495n 1.7v 909.505n 1.7v 919.495n 1.7v 919.505n 1.7v 929.495n 1.7v 929.505n 1.7v 939.495n 1.7v 939.505n 0.0v 949.495n 0.0v 949.505n 1.7v 959.495n 1.7v 959.505n 1.7v 969.495n 1.7v 969.505n 1.7v 979.495n 1.7v 979.505n 0.0v 989.495n 0.0v 989.505n 0.0v 999.495n 0.0v 999.505n 0.0v 1009.495n 0.0v 1009.505n 0.0v 1019.495n 0.0v 1019.505n 0.0v 1029.495n 0.0v 1029.505n 0.0v 1039.495n 0.0v 1039.505n 0.0v 1049.495n 0.0v 1049.505n 0.0v 1059.495n 0.0v 1059.505n 0.0v 1069.495n 0.0v 1069.505n 0.0v 1079.495n 0.0v 1079.505n 0.0v 1089.495n 0.0v 1089.505n 1.7v 1099.495n 1.7v 1099.505n 1.7v 1109.495n 1.7v 1109.505n 1.7v 1119.495n 1.7v 1119.505n 1.7v 1129.495n 1.7v 1129.505n 1.7v 1139.495n 1.7v 1139.505n 1.7v 1149.495n 1.7v 1149.505n 1.7v 1159.495n 1.7v 1159.505n 0.0v 1169.495n 0.0v 1169.505n 1.7v 1179.495n 1.7v 1179.505n 1.7v 1189.495n 1.7v 1189.505n 1.7v 1199.495n 1.7v 1199.505n 0.0v 1209.495n 0.0v 1209.505n 0.0v 1219.495n 0.0v 1219.505n 0.0v 1229.495n 0.0v 1229.505n 1.7v 1239.495n 1.7v 1239.505n 0.0v 1249.495n 0.0v 1249.505n 0.0v 1259.495n 0.0v 1259.505n 0.0v 1269.495n 0.0v 1269.505n 0.0v 1279.495n 0.0v 1279.505n 0.0v 1289.495n 0.0v 1289.505n 1.7v 1299.495n 1.7v 1299.505n 1.7v 1309.495n 1.7v 1309.505n 1.7v 1319.495n 1.7v 1319.505n 1.7v 1329.495n 1.7v 1329.505n 1.7v 1339.495n 1.7v 1339.505n 0.0v 1349.495n 0.0v 1349.505n 0.0v 1359.495n 0.0v 1359.505n 0.0v 1369.495n 0.0v 1369.505n 0.0v 1379.495n 0.0v 1379.505n 0.0v 1389.495n 0.0v 1389.505n 0.0v 1399.495n 0.0v 1399.505n 0.0v 1409.495n 0.0v 1409.505n 0.0v 1419.495n 0.0v 1419.505n 0.0v 1429.495n 0.0v 1429.505n 0.0v 1439.495n 0.0v 1439.505n 1.7v 1449.495n 1.7v 1449.505n 1.7v 1459.495n 1.7v 1459.505n 1.7v 1469.495n 1.7v 1469.505n 1.7v 1479.495n 1.7v 1479.505n 1.7v 1489.495n 1.7v 1489.505n 0.0v 1499.495n 0.0v 1499.505n 0.0v 1509.495n 0.0v 1509.505n 1.7v 1519.495n 1.7v 1519.505n 1.7v 1529.495n 1.7v 1529.505n 1.7v 1539.495n 1.7v 1539.505n 1.7v 1549.495n 1.7v 1549.505n 0.0v 1559.495n 0.0v 1559.505n 0.0v 1569.495n 0.0v 1569.505n 1.7v 1579.495n 1.7v 1579.505n 1.7v 1589.495n 1.7v 1589.505n 0.0v 1599.495n 0.0v 1599.505n 0.0v 1609.495n 0.0v 1609.505n 0.0v 1619.495n 0.0v 1619.505n 0.0v 1629.495n 0.0v 1629.505n 0.0v 1639.495n 0.0v 1639.505n 1.7v 1649.495n 1.7v 1649.505n 1.7v 1659.495n 1.7v 1659.505n 1.7v 1669.495n 1.7v 1669.505n 0.0v 1679.495n 0.0v 1679.505n 0.0v 1689.495n 0.0v 1689.505n 1.7v 1699.495n 1.7v 1699.505n 0.0v 1709.495n 0.0v 1709.505n 1.7v 1719.495n 1.7v 1719.505n 0.0v 1729.495n 0.0v 1729.505n 0.0v 1739.495n 0.0v 1739.505n 1.7v 1749.495n 1.7v 1749.505n 1.7v 1759.495n 1.7v 1759.505n 0.0v 1769.495n 0.0v 1769.505n 0.0v 1779.495n 0.0v 1779.505n 1.7v 1789.495n 1.7v 1789.505n 0.0v 1799.495n 0.0v 1799.505n 0.0v 1809.495n 0.0v 1809.505n 1.7v 1819.495n 1.7v 1819.505n 1.7v 1829.495n 1.7v 1829.505n 1.7v 1839.495n 1.7v 1839.505n 1.7v 1849.495n 1.7v 1849.505n 1.7v 1859.495n 1.7v 1859.505n 1.7v 1869.495n 1.7v 1869.505n 1.7v 1879.495n 1.7v 1879.505n 0.0v 1889.495n 0.0v 1889.505n 0.0v 1899.495n 0.0v 1899.505n 1.7v 1909.495n 1.7v 1909.505n 0.0v 1919.495n 0.0v 1919.505n 0.0v 1929.495n 0.0v 1929.505n 1.7v 1939.495n 1.7v 1939.505n 1.7v 1949.495n 1.7v 1949.505n 1.7v 1959.495n 1.7v 1959.505n 1.7v 1969.495n 1.7v 1969.505n 0.0v 1979.495n 0.0v 1979.505n 0.0v 1989.495n 0.0v 1989.505n 0.0v 1999.495n 0.0v 1999.505n 0.0v 2009.495n 0.0v 2009.505n 0.0v 2019.495n 0.0v 2019.505n 0.0v 2029.495n 0.0v 2029.505n 1.7v 2039.495n 1.7v 2039.505n 1.7v 2049.495n 1.7v 2049.505n 1.7v )
* (time, data): [(0, 0), (10, 0), (20, 0), (30, 1), (40, 1), (50, 1), (60, 0), (70, 0), (80, 1), (90, 1), (100, 1), (110, 1), (120, 1), (130, 0), (140, 0), (150, 0), (160, 0), (170, 0), (180, 0), (190, 0), (200, 0), (210, 0), (220, 0), (230, 0), (240, 0), (250, 0), (260, 0), (270, 1), (280, 1), (290, 1), (300, 0), (310, 0), (320, 1), (330, 1), (340, 1), (350, 1), (360, 1), (370, 1), (380, 1), (390, 1), (400, 1), (410, 1), (420, 1), (430, 1), (440, 0), (450, 0), (460, 1), (470, 1), (480, 1), (490, 1), (500, 1), (510, 1), (520, 1), (530, 1), (540, 0), (550, 0), (560, 0), (570, 0), (580, 0), (590, 0), (600, 0), (610, 0), (620, 0), (630, 1), (640, 1), (650, 1), (660, 1), (670, 1), (680, 1), (690, 0), (700, 0), (710, 1), (720, 0), (730, 0), (740, 0), (750, 1), (760, 0), (770, 0), (780, 0), (790, 0), (800, 0), (810, 1), (820, 1), (830, 1), (840, 1), (850, 1), (860, 0), (870, 0), (880, 0), (890, 0), (900, 0), (910, 0), (920, 1), (930, 1), (940, 0), (950, 1), (960, 1), (970, 1), (980, 0), (990, 0), (1000, 0), (1010, 0), (1020, 0), (1030, 0), (1040, 0), (1050, 0), (1060, 0), (1070, 0), (1080, 0), (1090, 0), (1100, 1), (1110, 0), (1120, 0), (1130, 0), (1140, 0), (1150, 0), (1160, 1), (1170, 0), (1180, 1), (1190, 1), (1200, 0), (1210, 1), (1220, 0), (1230, 0), (1240, 1), (1250, 1), (1260, 1), (1270, 1), (1280, 1), (1290, 1), (1300, 1), (1310, 1), (1320, 1), (1330, 1), (1340, 1), (1350, 1), (1360, 1), (1370, 0), (1380, 1), (1390, 1), (1400, 0), (1410, 1), (1420, 1), (1430, 1), (1440, 1), (1450, 0), (1460, 0), (1470, 1), (1480, 1), (1490, 0), (1500, 0), (1510, 1), (1520, 1), (1530, 0), (1540, 1), (1550, 1), (1560, 1), (1570, 0), (1580, 1), (1590, 1), (1600, 1), (1610, 0), (1620, 0), (1630, 0), (1640, 1), (1650, 1), (1660, 1), (1670, 0), (1680, 0), (1690, 1), (1700, 1), (1710, 1), (1720, 0), (1730, 0), (1740, 0), (1750, 0), (1760, 0), (1770, 0), (1780, 0), (1790, 0), (1800, 1), (1810, 1), (1820, 1), (1830, 0), (1840, 0), (1850, 0), (1860, 0), (1870, 0), (1880, 0), (1890, 0), (1900, 1), (1910, 0), (1920, 0), (1930, 1), (1940, 1), (1950, 1), (1960, 1), (1970, 1), (1980, 1), (1990, 1), (2000, 1), (2010, 1), (2020, 1), (2030, 1), (2040, 1), (2050, 1)]
Vdin0_13  din0_13  0 PWL (0n 0.0v 9.495n 0.0v 9.505n 0.0v 19.495n 0.0v 19.505n 0.0v 29.495n 0.0v 29.505n 1.7v 39.495n 1.7v 39.505n 1.7v 49.495n 1.7v 49.505n 1.7v 59.495n 1.7v 59.505n 0.0v 69.495n 0.0v 69.505n 0.0v 79.495n 0.0v 79.505n 1.7v 89.495n 1.7v 89.505n 1.7v 99.495n 1.7v 99.505n 1.7v 109.495n 1.7v 109.505n 1.7v 119.495n 1.7v 119.505n 1.7v 129.495n 1.7v 129.505n 0.0v 139.495n 0.0v 139.505n 0.0v 149.495n 0.0v 149.505n 0.0v 159.495n 0.0v 159.505n 0.0v 169.495n 0.0v 169.505n 0.0v 179.495n 0.0v 179.505n 0.0v 189.495n 0.0v 189.505n 0.0v 199.495n 0.0v 199.505n 0.0v 209.495n 0.0v 209.505n 0.0v 219.495n 0.0v 219.505n 0.0v 229.495n 0.0v 229.505n 0.0v 239.495n 0.0v 239.505n 0.0v 249.495n 0.0v 249.505n 0.0v 259.495n 0.0v 259.505n 0.0v 269.495n 0.0v 269.505n 1.7v 279.495n 1.7v 279.505n 1.7v 289.495n 1.7v 289.505n 1.7v 299.495n 1.7v 299.505n 0.0v 309.495n 0.0v 309.505n 0.0v 319.495n 0.0v 319.505n 1.7v 329.495n 1.7v 329.505n 1.7v 339.495n 1.7v 339.505n 1.7v 349.495n 1.7v 349.505n 1.7v 359.495n 1.7v 359.505n 1.7v 369.495n 1.7v 369.505n 1.7v 379.495n 1.7v 379.505n 1.7v 389.495n 1.7v 389.505n 1.7v 399.495n 1.7v 399.505n 1.7v 409.495n 1.7v 409.505n 1.7v 419.495n 1.7v 419.505n 1.7v 429.495n 1.7v 429.505n 1.7v 439.495n 1.7v 439.505n 0.0v 449.495n 0.0v 449.505n 0.0v 459.495n 0.0v 459.505n 1.7v 469.495n 1.7v 469.505n 1.7v 479.495n 1.7v 479.505n 1.7v 489.495n 1.7v 489.505n 1.7v 499.495n 1.7v 499.505n 1.7v 509.495n 1.7v 509.505n 1.7v 519.495n 1.7v 519.505n 1.7v 529.495n 1.7v 529.505n 1.7v 539.495n 1.7v 539.505n 0.0v 549.495n 0.0v 549.505n 0.0v 559.495n 0.0v 559.505n 0.0v 569.495n 0.0v 569.505n 0.0v 579.495n 0.0v 579.505n 0.0v 589.495n 0.0v 589.505n 0.0v 599.495n 0.0v 599.505n 0.0v 609.495n 0.0v 609.505n 0.0v 619.495n 0.0v 619.505n 0.0v 629.495n 0.0v 629.505n 1.7v 639.495n 1.7v 639.505n 1.7v 649.495n 1.7v 649.505n 1.7v 659.495n 1.7v 659.505n 1.7v 669.495n 1.7v 669.505n 1.7v 679.495n 1.7v 679.505n 1.7v 689.495n 1.7v 689.505n 0.0v 699.495n 0.0v 699.505n 0.0v 709.495n 0.0v 709.505n 1.7v 719.495n 1.7v 719.505n 0.0v 729.495n 0.0v 729.505n 0.0v 739.495n 0.0v 739.505n 0.0v 749.495n 0.0v 749.505n 1.7v 759.495n 1.7v 759.505n 0.0v 769.495n 0.0v 769.505n 0.0v 779.495n 0.0v 779.505n 0.0v 789.495n 0.0v 789.505n 0.0v 799.495n 0.0v 799.505n 0.0v 809.495n 0.0v 809.505n 1.7v 819.495n 1.7v 819.505n 1.7v 829.495n 1.7v 829.505n 1.7v 839.495n 1.7v 839.505n 1.7v 849.495n 1.7v 849.505n 1.7v 859.495n 1.7v 859.505n 0.0v 869.495n 0.0v 869.505n 0.0v 879.495n 0.0v 879.505n 0.0v 889.495n 0.0v 889.505n 0.0v 899.495n 0.0v 899.505n 0.0v 909.495n 0.0v 909.505n 0.0v 919.495n 0.0v 919.505n 1.7v 929.495n 1.7v 929.505n 1.7v 939.495n 1.7v 939.505n 0.0v 949.495n 0.0v 949.505n 1.7v 959.495n 1.7v 959.505n 1.7v 969.495n 1.7v 969.505n 1.7v 979.495n 1.7v 979.505n 0.0v 989.495n 0.0v 989.505n 0.0v 999.495n 0.0v 999.505n 0.0v 1009.495n 0.0v 1009.505n 0.0v 1019.495n 0.0v 1019.505n 0.0v 1029.495n 0.0v 1029.505n 0.0v 1039.495n 0.0v 1039.505n 0.0v 1049.495n 0.0v 1049.505n 0.0v 1059.495n 0.0v 1059.505n 0.0v 1069.495n 0.0v 1069.505n 0.0v 1079.495n 0.0v 1079.505n 0.0v 1089.495n 0.0v 1089.505n 0.0v 1099.495n 0.0v 1099.505n 1.7v 1109.495n 1.7v 1109.505n 0.0v 1119.495n 0.0v 1119.505n 0.0v 1129.495n 0.0v 1129.505n 0.0v 1139.495n 0.0v 1139.505n 0.0v 1149.495n 0.0v 1149.505n 0.0v 1159.495n 0.0v 1159.505n 1.7v 1169.495n 1.7v 1169.505n 0.0v 1179.495n 0.0v 1179.505n 1.7v 1189.495n 1.7v 1189.505n 1.7v 1199.495n 1.7v 1199.505n 0.0v 1209.495n 0.0v 1209.505n 1.7v 1219.495n 1.7v 1219.505n 0.0v 1229.495n 0.0v 1229.505n 0.0v 1239.495n 0.0v 1239.505n 1.7v 1249.495n 1.7v 1249.505n 1.7v 1259.495n 1.7v 1259.505n 1.7v 1269.495n 1.7v 1269.505n 1.7v 1279.495n 1.7v 1279.505n 1.7v 1289.495n 1.7v 1289.505n 1.7v 1299.495n 1.7v 1299.505n 1.7v 1309.495n 1.7v 1309.505n 1.7v 1319.495n 1.7v 1319.505n 1.7v 1329.495n 1.7v 1329.505n 1.7v 1339.495n 1.7v 1339.505n 1.7v 1349.495n 1.7v 1349.505n 1.7v 1359.495n 1.7v 1359.505n 1.7v 1369.495n 1.7v 1369.505n 0.0v 1379.495n 0.0v 1379.505n 1.7v 1389.495n 1.7v 1389.505n 1.7v 1399.495n 1.7v 1399.505n 0.0v 1409.495n 0.0v 1409.505n 1.7v 1419.495n 1.7v 1419.505n 1.7v 1429.495n 1.7v 1429.505n 1.7v 1439.495n 1.7v 1439.505n 1.7v 1449.495n 1.7v 1449.505n 0.0v 1459.495n 0.0v 1459.505n 0.0v 1469.495n 0.0v 1469.505n 1.7v 1479.495n 1.7v 1479.505n 1.7v 1489.495n 1.7v 1489.505n 0.0v 1499.495n 0.0v 1499.505n 0.0v 1509.495n 0.0v 1509.505n 1.7v 1519.495n 1.7v 1519.505n 1.7v 1529.495n 1.7v 1529.505n 0.0v 1539.495n 0.0v 1539.505n 1.7v 1549.495n 1.7v 1549.505n 1.7v 1559.495n 1.7v 1559.505n 1.7v 1569.495n 1.7v 1569.505n 0.0v 1579.495n 0.0v 1579.505n 1.7v 1589.495n 1.7v 1589.505n 1.7v 1599.495n 1.7v 1599.505n 1.7v 1609.495n 1.7v 1609.505n 0.0v 1619.495n 0.0v 1619.505n 0.0v 1629.495n 0.0v 1629.505n 0.0v 1639.495n 0.0v 1639.505n 1.7v 1649.495n 1.7v 1649.505n 1.7v 1659.495n 1.7v 1659.505n 1.7v 1669.495n 1.7v 1669.505n 0.0v 1679.495n 0.0v 1679.505n 0.0v 1689.495n 0.0v 1689.505n 1.7v 1699.495n 1.7v 1699.505n 1.7v 1709.495n 1.7v 1709.505n 1.7v 1719.495n 1.7v 1719.505n 0.0v 1729.495n 0.0v 1729.505n 0.0v 1739.495n 0.0v 1739.505n 0.0v 1749.495n 0.0v 1749.505n 0.0v 1759.495n 0.0v 1759.505n 0.0v 1769.495n 0.0v 1769.505n 0.0v 1779.495n 0.0v 1779.505n 0.0v 1789.495n 0.0v 1789.505n 0.0v 1799.495n 0.0v 1799.505n 1.7v 1809.495n 1.7v 1809.505n 1.7v 1819.495n 1.7v 1819.505n 1.7v 1829.495n 1.7v 1829.505n 0.0v 1839.495n 0.0v 1839.505n 0.0v 1849.495n 0.0v 1849.505n 0.0v 1859.495n 0.0v 1859.505n 0.0v 1869.495n 0.0v 1869.505n 0.0v 1879.495n 0.0v 1879.505n 0.0v 1889.495n 0.0v 1889.505n 0.0v 1899.495n 0.0v 1899.505n 1.7v 1909.495n 1.7v 1909.505n 0.0v 1919.495n 0.0v 1919.505n 0.0v 1929.495n 0.0v 1929.505n 1.7v 1939.495n 1.7v 1939.505n 1.7v 1949.495n 1.7v 1949.505n 1.7v 1959.495n 1.7v 1959.505n 1.7v 1969.495n 1.7v 1969.505n 1.7v 1979.495n 1.7v 1979.505n 1.7v 1989.495n 1.7v 1989.505n 1.7v 1999.495n 1.7v 1999.505n 1.7v 2009.495n 1.7v 2009.505n 1.7v 2019.495n 1.7v 2019.505n 1.7v 2029.495n 1.7v 2029.505n 1.7v 2039.495n 1.7v 2039.505n 1.7v 2049.495n 1.7v 2049.505n 1.7v )
* (time, data): [(0, 0), (10, 0), (20, 1), (30, 1), (40, 1), (50, 0), (60, 1), (70, 1), (80, 0), (90, 0), (100, 0), (110, 0), (120, 1), (130, 1), (140, 1), (150, 1), (160, 1), (170, 1), (180, 1), (190, 1), (200, 1), (210, 1), (220, 1), (230, 1), (240, 1), (250, 1), (260, 1), (270, 0), (280, 0), (290, 0), (300, 0), (310, 0), (320, 1), (330, 0), (340, 0), (350, 0), (360, 0), (370, 0), (380, 1), (390, 1), (400, 1), (410, 1), (420, 1), (430, 0), (440, 1), (450, 1), (460, 1), (470, 1), (480, 1), (490, 1), (500, 1), (510, 0), (520, 0), (530, 0), (540, 0), (550, 1), (560, 1), (570, 1), (580, 1), (590, 0), (600, 0), (610, 0), (620, 0), (630, 1), (640, 0), (650, 0), (660, 0), (670, 0), (680, 0), (690, 0), (700, 0), (710, 1), (720, 1), (730, 1), (740, 1), (750, 1), (760, 0), (770, 1), (780, 1), (790, 1), (800, 1), (810, 1), (820, 0), (830, 0), (840, 0), (850, 1), (860, 1), (870, 0), (880, 0), (890, 0), (900, 0), (910, 0), (920, 1), (930, 1), (940, 0), (950, 1), (960, 1), (970, 0), (980, 0), (990, 0), (1000, 0), (1010, 0), (1020, 0), (1030, 0), (1040, 0), (1050, 0), (1060, 0), (1070, 0), (1080, 0), (1090, 1), (1100, 1), (1110, 1), (1120, 1), (1130, 1), (1140, 1), (1150, 0), (1160, 0), (1170, 0), (1180, 1), (1190, 1), (1200, 0), (1210, 0), (1220, 0), (1230, 0), (1240, 1), (1250, 1), (1260, 1), (1270, 0), (1280, 0), (1290, 0), (1300, 0), (1310, 0), (1320, 0), (1330, 0), (1340, 1), (1350, 0), (1360, 0), (1370, 1), (1380, 0), (1390, 0), (1400, 1), (1410, 1), (1420, 1), (1430, 1), (1440, 0), (1450, 1), (1460, 1), (1470, 1), (1480, 1), (1490, 0), (1500, 0), (1510, 0), (1520, 0), (1530, 0), (1540, 0), (1550, 1), (1560, 1), (1570, 0), (1580, 0), (1590, 0), (1600, 1), (1610, 0), (1620, 0), (1630, 0), (1640, 1), (1650, 1), (1660, 1), (1670, 1), (1680, 1), (1690, 1), (1700, 0), (1710, 0), (1720, 1), (1730, 1), (1740, 1), (1750, 1), (1760, 0), (1770, 1), (1780, 1), (1790, 0), (1800, 0), (1810, 1), (1820, 0), (1830, 1), (1840, 0), (1850, 0), (1860, 1), (1870, 1), (1880, 1), (1890, 1), (1900, 1), (1910, 1), (1920, 0), (1930, 0), (1940, 1), (1950, 0), (1960, 0), (1970, 0), (1980, 0), (1990, 0), (2000, 0), (2010, 0), (2020, 1), (2030, 0), (2040, 0), (2050, 0)]
Vdin0_14  din0_14  0 PWL (0n 0.0v 9.495n 0.0v 9.505n 0.0v 19.495n 0.0v 19.505n 1.7v 29.495n 1.7v 29.505n 1.7v 39.495n 1.7v 39.505n 1.7v 49.495n 1.7v 49.505n 0.0v 59.495n 0.0v 59.505n 1.7v 69.495n 1.7v 69.505n 1.7v 79.495n 1.7v 79.505n 0.0v 89.495n 0.0v 89.505n 0.0v 99.495n 0.0v 99.505n 0.0v 109.495n 0.0v 109.505n 0.0v 119.495n 0.0v 119.505n 1.7v 129.495n 1.7v 129.505n 1.7v 139.495n 1.7v 139.505n 1.7v 149.495n 1.7v 149.505n 1.7v 159.495n 1.7v 159.505n 1.7v 169.495n 1.7v 169.505n 1.7v 179.495n 1.7v 179.505n 1.7v 189.495n 1.7v 189.505n 1.7v 199.495n 1.7v 199.505n 1.7v 209.495n 1.7v 209.505n 1.7v 219.495n 1.7v 219.505n 1.7v 229.495n 1.7v 229.505n 1.7v 239.495n 1.7v 239.505n 1.7v 249.495n 1.7v 249.505n 1.7v 259.495n 1.7v 259.505n 1.7v 269.495n 1.7v 269.505n 0.0v 279.495n 0.0v 279.505n 0.0v 289.495n 0.0v 289.505n 0.0v 299.495n 0.0v 299.505n 0.0v 309.495n 0.0v 309.505n 0.0v 319.495n 0.0v 319.505n 1.7v 329.495n 1.7v 329.505n 0.0v 339.495n 0.0v 339.505n 0.0v 349.495n 0.0v 349.505n 0.0v 359.495n 0.0v 359.505n 0.0v 369.495n 0.0v 369.505n 0.0v 379.495n 0.0v 379.505n 1.7v 389.495n 1.7v 389.505n 1.7v 399.495n 1.7v 399.505n 1.7v 409.495n 1.7v 409.505n 1.7v 419.495n 1.7v 419.505n 1.7v 429.495n 1.7v 429.505n 0.0v 439.495n 0.0v 439.505n 1.7v 449.495n 1.7v 449.505n 1.7v 459.495n 1.7v 459.505n 1.7v 469.495n 1.7v 469.505n 1.7v 479.495n 1.7v 479.505n 1.7v 489.495n 1.7v 489.505n 1.7v 499.495n 1.7v 499.505n 1.7v 509.495n 1.7v 509.505n 0.0v 519.495n 0.0v 519.505n 0.0v 529.495n 0.0v 529.505n 0.0v 539.495n 0.0v 539.505n 0.0v 549.495n 0.0v 549.505n 1.7v 559.495n 1.7v 559.505n 1.7v 569.495n 1.7v 569.505n 1.7v 579.495n 1.7v 579.505n 1.7v 589.495n 1.7v 589.505n 0.0v 599.495n 0.0v 599.505n 0.0v 609.495n 0.0v 609.505n 0.0v 619.495n 0.0v 619.505n 0.0v 629.495n 0.0v 629.505n 1.7v 639.495n 1.7v 639.505n 0.0v 649.495n 0.0v 649.505n 0.0v 659.495n 0.0v 659.505n 0.0v 669.495n 0.0v 669.505n 0.0v 679.495n 0.0v 679.505n 0.0v 689.495n 0.0v 689.505n 0.0v 699.495n 0.0v 699.505n 0.0v 709.495n 0.0v 709.505n 1.7v 719.495n 1.7v 719.505n 1.7v 729.495n 1.7v 729.505n 1.7v 739.495n 1.7v 739.505n 1.7v 749.495n 1.7v 749.505n 1.7v 759.495n 1.7v 759.505n 0.0v 769.495n 0.0v 769.505n 1.7v 779.495n 1.7v 779.505n 1.7v 789.495n 1.7v 789.505n 1.7v 799.495n 1.7v 799.505n 1.7v 809.495n 1.7v 809.505n 1.7v 819.495n 1.7v 819.505n 0.0v 829.495n 0.0v 829.505n 0.0v 839.495n 0.0v 839.505n 0.0v 849.495n 0.0v 849.505n 1.7v 859.495n 1.7v 859.505n 1.7v 869.495n 1.7v 869.505n 0.0v 879.495n 0.0v 879.505n 0.0v 889.495n 0.0v 889.505n 0.0v 899.495n 0.0v 899.505n 0.0v 909.495n 0.0v 909.505n 0.0v 919.495n 0.0v 919.505n 1.7v 929.495n 1.7v 929.505n 1.7v 939.495n 1.7v 939.505n 0.0v 949.495n 0.0v 949.505n 1.7v 959.495n 1.7v 959.505n 1.7v 969.495n 1.7v 969.505n 0.0v 979.495n 0.0v 979.505n 0.0v 989.495n 0.0v 989.505n 0.0v 999.495n 0.0v 999.505n 0.0v 1009.495n 0.0v 1009.505n 0.0v 1019.495n 0.0v 1019.505n 0.0v 1029.495n 0.0v 1029.505n 0.0v 1039.495n 0.0v 1039.505n 0.0v 1049.495n 0.0v 1049.505n 0.0v 1059.495n 0.0v 1059.505n 0.0v 1069.495n 0.0v 1069.505n 0.0v 1079.495n 0.0v 1079.505n 0.0v 1089.495n 0.0v 1089.505n 1.7v 1099.495n 1.7v 1099.505n 1.7v 1109.495n 1.7v 1109.505n 1.7v 1119.495n 1.7v 1119.505n 1.7v 1129.495n 1.7v 1129.505n 1.7v 1139.495n 1.7v 1139.505n 1.7v 1149.495n 1.7v 1149.505n 0.0v 1159.495n 0.0v 1159.505n 0.0v 1169.495n 0.0v 1169.505n 0.0v 1179.495n 0.0v 1179.505n 1.7v 1189.495n 1.7v 1189.505n 1.7v 1199.495n 1.7v 1199.505n 0.0v 1209.495n 0.0v 1209.505n 0.0v 1219.495n 0.0v 1219.505n 0.0v 1229.495n 0.0v 1229.505n 0.0v 1239.495n 0.0v 1239.505n 1.7v 1249.495n 1.7v 1249.505n 1.7v 1259.495n 1.7v 1259.505n 1.7v 1269.495n 1.7v 1269.505n 0.0v 1279.495n 0.0v 1279.505n 0.0v 1289.495n 0.0v 1289.505n 0.0v 1299.495n 0.0v 1299.505n 0.0v 1309.495n 0.0v 1309.505n 0.0v 1319.495n 0.0v 1319.505n 0.0v 1329.495n 0.0v 1329.505n 0.0v 1339.495n 0.0v 1339.505n 1.7v 1349.495n 1.7v 1349.505n 0.0v 1359.495n 0.0v 1359.505n 0.0v 1369.495n 0.0v 1369.505n 1.7v 1379.495n 1.7v 1379.505n 0.0v 1389.495n 0.0v 1389.505n 0.0v 1399.495n 0.0v 1399.505n 1.7v 1409.495n 1.7v 1409.505n 1.7v 1419.495n 1.7v 1419.505n 1.7v 1429.495n 1.7v 1429.505n 1.7v 1439.495n 1.7v 1439.505n 0.0v 1449.495n 0.0v 1449.505n 1.7v 1459.495n 1.7v 1459.505n 1.7v 1469.495n 1.7v 1469.505n 1.7v 1479.495n 1.7v 1479.505n 1.7v 1489.495n 1.7v 1489.505n 0.0v 1499.495n 0.0v 1499.505n 0.0v 1509.495n 0.0v 1509.505n 0.0v 1519.495n 0.0v 1519.505n 0.0v 1529.495n 0.0v 1529.505n 0.0v 1539.495n 0.0v 1539.505n 0.0v 1549.495n 0.0v 1549.505n 1.7v 1559.495n 1.7v 1559.505n 1.7v 1569.495n 1.7v 1569.505n 0.0v 1579.495n 0.0v 1579.505n 0.0v 1589.495n 0.0v 1589.505n 0.0v 1599.495n 0.0v 1599.505n 1.7v 1609.495n 1.7v 1609.505n 0.0v 1619.495n 0.0v 1619.505n 0.0v 1629.495n 0.0v 1629.505n 0.0v 1639.495n 0.0v 1639.505n 1.7v 1649.495n 1.7v 1649.505n 1.7v 1659.495n 1.7v 1659.505n 1.7v 1669.495n 1.7v 1669.505n 1.7v 1679.495n 1.7v 1679.505n 1.7v 1689.495n 1.7v 1689.505n 1.7v 1699.495n 1.7v 1699.505n 0.0v 1709.495n 0.0v 1709.505n 0.0v 1719.495n 0.0v 1719.505n 1.7v 1729.495n 1.7v 1729.505n 1.7v 1739.495n 1.7v 1739.505n 1.7v 1749.495n 1.7v 1749.505n 1.7v 1759.495n 1.7v 1759.505n 0.0v 1769.495n 0.0v 1769.505n 1.7v 1779.495n 1.7v 1779.505n 1.7v 1789.495n 1.7v 1789.505n 0.0v 1799.495n 0.0v 1799.505n 0.0v 1809.495n 0.0v 1809.505n 1.7v 1819.495n 1.7v 1819.505n 0.0v 1829.495n 0.0v 1829.505n 1.7v 1839.495n 1.7v 1839.505n 0.0v 1849.495n 0.0v 1849.505n 0.0v 1859.495n 0.0v 1859.505n 1.7v 1869.495n 1.7v 1869.505n 1.7v 1879.495n 1.7v 1879.505n 1.7v 1889.495n 1.7v 1889.505n 1.7v 1899.495n 1.7v 1899.505n 1.7v 1909.495n 1.7v 1909.505n 1.7v 1919.495n 1.7v 1919.505n 0.0v 1929.495n 0.0v 1929.505n 0.0v 1939.495n 0.0v 1939.505n 1.7v 1949.495n 1.7v 1949.505n 0.0v 1959.495n 0.0v 1959.505n 0.0v 1969.495n 0.0v 1969.505n 0.0v 1979.495n 0.0v 1979.505n 0.0v 1989.495n 0.0v 1989.505n 0.0v 1999.495n 0.0v 1999.505n 0.0v 2009.495n 0.0v 2009.505n 0.0v 2019.495n 0.0v 2019.505n 1.7v 2029.495n 1.7v 2029.505n 0.0v 2039.495n 0.0v 2039.505n 0.0v 2049.495n 0.0v 2049.505n 0.0v )
* (time, data): [(0, 0), (10, 0), (20, 0), (30, 1), (40, 1), (50, 0), (60, 0), (70, 1), (80, 0), (90, 0), (100, 0), (110, 0), (120, 1), (130, 0), (140, 0), (150, 0), (160, 0), (170, 0), (180, 0), (190, 0), (200, 0), (210, 0), (220, 0), (230, 0), (240, 1), (250, 1), (260, 1), (270, 1), (280, 1), (290, 1), (300, 0), (310, 1), (320, 1), (330, 0), (340, 0), (350, 0), (360, 0), (370, 0), (380, 1), (390, 1), (400, 1), (410, 1), (420, 1), (430, 0), (440, 1), (450, 1), (460, 0), (470, 1), (480, 1), (490, 1), (500, 1), (510, 1), (520, 1), (530, 1), (540, 0), (550, 0), (560, 0), (570, 0), (580, 0), (590, 1), (600, 1), (610, 1), (620, 1), (630, 0), (640, 0), (650, 0), (660, 1), (670, 1), (680, 1), (690, 0), (700, 1), (710, 0), (720, 1), (730, 1), (740, 0), (750, 1), (760, 1), (770, 0), (780, 0), (790, 0), (800, 0), (810, 1), (820, 0), (830, 0), (840, 0), (850, 0), (860, 0), (870, 0), (880, 0), (890, 0), (900, 0), (910, 0), (920, 0), (930, 0), (940, 0), (950, 1), (960, 1), (970, 1), (980, 0), (990, 0), (1000, 0), (1010, 0), (1020, 0), (1030, 0), (1040, 1), (1050, 1), (1060, 1), (1070, 1), (1080, 1), (1090, 1), (1100, 0), (1110, 0), (1120, 0), (1130, 0), (1140, 0), (1150, 0), (1160, 0), (1170, 0), (1180, 1), (1190, 1), (1200, 0), (1210, 1), (1220, 1), (1230, 0), (1240, 0), (1250, 0), (1260, 0), (1270, 0), (1280, 0), (1290, 1), (1300, 1), (1310, 1), (1320, 0), (1330, 0), (1340, 0), (1350, 0), (1360, 0), (1370, 1), (1380, 0), (1390, 0), (1400, 1), (1410, 0), (1420, 0), (1430, 0), (1440, 1), (1450, 0), (1460, 0), (1470, 0), (1480, 0), (1490, 0), (1500, 0), (1510, 0), (1520, 0), (1530, 0), (1540, 1), (1550, 1), (1560, 1), (1570, 1), (1580, 1), (1590, 0), (1600, 1), (1610, 0), (1620, 0), (1630, 0), (1640, 0), (1650, 0), (1660, 0), (1670, 0), (1680, 0), (1690, 0), (1700, 0), (1710, 0), (1720, 1), (1730, 1), (1740, 0), (1750, 0), (1760, 0), (1770, 0), (1780, 1), (1790, 1), (1800, 1), (1810, 0), (1820, 1), (1830, 0), (1840, 1), (1850, 1), (1860, 0), (1870, 0), (1880, 0), (1890, 0), (1900, 1), (1910, 0), (1920, 1), (1930, 0), (1940, 1), (1950, 0), (1960, 0), (1970, 1), (1980, 1), (1990, 0), (2000, 0), (2010, 0), (2020, 1), (2030, 0), (2040, 0), (2050, 0)]
Vdin0_15  din0_15  0 PWL (0n 0.0v 9.495n 0.0v 9.505n 0.0v 19.495n 0.0v 19.505n 0.0v 29.495n 0.0v 29.505n 1.7v 39.495n 1.7v 39.505n 1.7v 49.495n 1.7v 49.505n 0.0v 59.495n 0.0v 59.505n 0.0v 69.495n 0.0v 69.505n 1.7v 79.495n 1.7v 79.505n 0.0v 89.495n 0.0v 89.505n 0.0v 99.495n 0.0v 99.505n 0.0v 109.495n 0.0v 109.505n 0.0v 119.495n 0.0v 119.505n 1.7v 129.495n 1.7v 129.505n 0.0v 139.495n 0.0v 139.505n 0.0v 149.495n 0.0v 149.505n 0.0v 159.495n 0.0v 159.505n 0.0v 169.495n 0.0v 169.505n 0.0v 179.495n 0.0v 179.505n 0.0v 189.495n 0.0v 189.505n 0.0v 199.495n 0.0v 199.505n 0.0v 209.495n 0.0v 209.505n 0.0v 219.495n 0.0v 219.505n 0.0v 229.495n 0.0v 229.505n 0.0v 239.495n 0.0v 239.505n 1.7v 249.495n 1.7v 249.505n 1.7v 259.495n 1.7v 259.505n 1.7v 269.495n 1.7v 269.505n 1.7v 279.495n 1.7v 279.505n 1.7v 289.495n 1.7v 289.505n 1.7v 299.495n 1.7v 299.505n 0.0v 309.495n 0.0v 309.505n 1.7v 319.495n 1.7v 319.505n 1.7v 329.495n 1.7v 329.505n 0.0v 339.495n 0.0v 339.505n 0.0v 349.495n 0.0v 349.505n 0.0v 359.495n 0.0v 359.505n 0.0v 369.495n 0.0v 369.505n 0.0v 379.495n 0.0v 379.505n 1.7v 389.495n 1.7v 389.505n 1.7v 399.495n 1.7v 399.505n 1.7v 409.495n 1.7v 409.505n 1.7v 419.495n 1.7v 419.505n 1.7v 429.495n 1.7v 429.505n 0.0v 439.495n 0.0v 439.505n 1.7v 449.495n 1.7v 449.505n 1.7v 459.495n 1.7v 459.505n 0.0v 469.495n 0.0v 469.505n 1.7v 479.495n 1.7v 479.505n 1.7v 489.495n 1.7v 489.505n 1.7v 499.495n 1.7v 499.505n 1.7v 509.495n 1.7v 509.505n 1.7v 519.495n 1.7v 519.505n 1.7v 529.495n 1.7v 529.505n 1.7v 539.495n 1.7v 539.505n 0.0v 549.495n 0.0v 549.505n 0.0v 559.495n 0.0v 559.505n 0.0v 569.495n 0.0v 569.505n 0.0v 579.495n 0.0v 579.505n 0.0v 589.495n 0.0v 589.505n 1.7v 599.495n 1.7v 599.505n 1.7v 609.495n 1.7v 609.505n 1.7v 619.495n 1.7v 619.505n 1.7v 629.495n 1.7v 629.505n 0.0v 639.495n 0.0v 639.505n 0.0v 649.495n 0.0v 649.505n 0.0v 659.495n 0.0v 659.505n 1.7v 669.495n 1.7v 669.505n 1.7v 679.495n 1.7v 679.505n 1.7v 689.495n 1.7v 689.505n 0.0v 699.495n 0.0v 699.505n 1.7v 709.495n 1.7v 709.505n 0.0v 719.495n 0.0v 719.505n 1.7v 729.495n 1.7v 729.505n 1.7v 739.495n 1.7v 739.505n 0.0v 749.495n 0.0v 749.505n 1.7v 759.495n 1.7v 759.505n 1.7v 769.495n 1.7v 769.505n 0.0v 779.495n 0.0v 779.505n 0.0v 789.495n 0.0v 789.505n 0.0v 799.495n 0.0v 799.505n 0.0v 809.495n 0.0v 809.505n 1.7v 819.495n 1.7v 819.505n 0.0v 829.495n 0.0v 829.505n 0.0v 839.495n 0.0v 839.505n 0.0v 849.495n 0.0v 849.505n 0.0v 859.495n 0.0v 859.505n 0.0v 869.495n 0.0v 869.505n 0.0v 879.495n 0.0v 879.505n 0.0v 889.495n 0.0v 889.505n 0.0v 899.495n 0.0v 899.505n 0.0v 909.495n 0.0v 909.505n 0.0v 919.495n 0.0v 919.505n 0.0v 929.495n 0.0v 929.505n 0.0v 939.495n 0.0v 939.505n 0.0v 949.495n 0.0v 949.505n 1.7v 959.495n 1.7v 959.505n 1.7v 969.495n 1.7v 969.505n 1.7v 979.495n 1.7v 979.505n 0.0v 989.495n 0.0v 989.505n 0.0v 999.495n 0.0v 999.505n 0.0v 1009.495n 0.0v 1009.505n 0.0v 1019.495n 0.0v 1019.505n 0.0v 1029.495n 0.0v 1029.505n 0.0v 1039.495n 0.0v 1039.505n 1.7v 1049.495n 1.7v 1049.505n 1.7v 1059.495n 1.7v 1059.505n 1.7v 1069.495n 1.7v 1069.505n 1.7v 1079.495n 1.7v 1079.505n 1.7v 1089.495n 1.7v 1089.505n 1.7v 1099.495n 1.7v 1099.505n 0.0v 1109.495n 0.0v 1109.505n 0.0v 1119.495n 0.0v 1119.505n 0.0v 1129.495n 0.0v 1129.505n 0.0v 1139.495n 0.0v 1139.505n 0.0v 1149.495n 0.0v 1149.505n 0.0v 1159.495n 0.0v 1159.505n 0.0v 1169.495n 0.0v 1169.505n 0.0v 1179.495n 0.0v 1179.505n 1.7v 1189.495n 1.7v 1189.505n 1.7v 1199.495n 1.7v 1199.505n 0.0v 1209.495n 0.0v 1209.505n 1.7v 1219.495n 1.7v 1219.505n 1.7v 1229.495n 1.7v 1229.505n 0.0v 1239.495n 0.0v 1239.505n 0.0v 1249.495n 0.0v 1249.505n 0.0v 1259.495n 0.0v 1259.505n 0.0v 1269.495n 0.0v 1269.505n 0.0v 1279.495n 0.0v 1279.505n 0.0v 1289.495n 0.0v 1289.505n 1.7v 1299.495n 1.7v 1299.505n 1.7v 1309.495n 1.7v 1309.505n 1.7v 1319.495n 1.7v 1319.505n 0.0v 1329.495n 0.0v 1329.505n 0.0v 1339.495n 0.0v 1339.505n 0.0v 1349.495n 0.0v 1349.505n 0.0v 1359.495n 0.0v 1359.505n 0.0v 1369.495n 0.0v 1369.505n 1.7v 1379.495n 1.7v 1379.505n 0.0v 1389.495n 0.0v 1389.505n 0.0v 1399.495n 0.0v 1399.505n 1.7v 1409.495n 1.7v 1409.505n 0.0v 1419.495n 0.0v 1419.505n 0.0v 1429.495n 0.0v 1429.505n 0.0v 1439.495n 0.0v 1439.505n 1.7v 1449.495n 1.7v 1449.505n 0.0v 1459.495n 0.0v 1459.505n 0.0v 1469.495n 0.0v 1469.505n 0.0v 1479.495n 0.0v 1479.505n 0.0v 1489.495n 0.0v 1489.505n 0.0v 1499.495n 0.0v 1499.505n 0.0v 1509.495n 0.0v 1509.505n 0.0v 1519.495n 0.0v 1519.505n 0.0v 1529.495n 0.0v 1529.505n 0.0v 1539.495n 0.0v 1539.505n 1.7v 1549.495n 1.7v 1549.505n 1.7v 1559.495n 1.7v 1559.505n 1.7v 1569.495n 1.7v 1569.505n 1.7v 1579.495n 1.7v 1579.505n 1.7v 1589.495n 1.7v 1589.505n 0.0v 1599.495n 0.0v 1599.505n 1.7v 1609.495n 1.7v 1609.505n 0.0v 1619.495n 0.0v 1619.505n 0.0v 1629.495n 0.0v 1629.505n 0.0v 1639.495n 0.0v 1639.505n 0.0v 1649.495n 0.0v 1649.505n 0.0v 1659.495n 0.0v 1659.505n 0.0v 1669.495n 0.0v 1669.505n 0.0v 1679.495n 0.0v 1679.505n 0.0v 1689.495n 0.0v 1689.505n 0.0v 1699.495n 0.0v 1699.505n 0.0v 1709.495n 0.0v 1709.505n 0.0v 1719.495n 0.0v 1719.505n 1.7v 1729.495n 1.7v 1729.505n 1.7v 1739.495n 1.7v 1739.505n 0.0v 1749.495n 0.0v 1749.505n 0.0v 1759.495n 0.0v 1759.505n 0.0v 1769.495n 0.0v 1769.505n 0.0v 1779.495n 0.0v 1779.505n 1.7v 1789.495n 1.7v 1789.505n 1.7v 1799.495n 1.7v 1799.505n 1.7v 1809.495n 1.7v 1809.505n 0.0v 1819.495n 0.0v 1819.505n 1.7v 1829.495n 1.7v 1829.505n 0.0v 1839.495n 0.0v 1839.505n 1.7v 1849.495n 1.7v 1849.505n 1.7v 1859.495n 1.7v 1859.505n 0.0v 1869.495n 0.0v 1869.505n 0.0v 1879.495n 0.0v 1879.505n 0.0v 1889.495n 0.0v 1889.505n 0.0v 1899.495n 0.0v 1899.505n 1.7v 1909.495n 1.7v 1909.505n 0.0v 1919.495n 0.0v 1919.505n 1.7v 1929.495n 1.7v 1929.505n 0.0v 1939.495n 0.0v 1939.505n 1.7v 1949.495n 1.7v 1949.505n 0.0v 1959.495n 0.0v 1959.505n 0.0v 1969.495n 0.0v 1969.505n 1.7v 1979.495n 1.7v 1979.505n 1.7v 1989.495n 1.7v 1989.505n 0.0v 1999.495n 0.0v 1999.505n 0.0v 2009.495n 0.0v 2009.505n 0.0v 2019.495n 0.0v 2019.505n 1.7v 2029.495n 1.7v 2029.505n 0.0v 2039.495n 0.0v 2039.505n 0.0v 2049.495n 0.0v 2049.505n 0.0v )
* (time, data): [(0, 0), (10, 1), (20, 0), (30, 1), (40, 1), (50, 0), (60, 1), (70, 1), (80, 0), (90, 0), (100, 0), (110, 0), (120, 1), (130, 1), (140, 0), (150, 0), (160, 0), (170, 0), (180, 0), (190, 0), (200, 0), (210, 0), (220, 0), (230, 0), (240, 1), (250, 1), (260, 1), (270, 0), (280, 0), (290, 0), (300, 1), (310, 0), (320, 0), (330, 0), (340, 0), (350, 0), (360, 0), (370, 0), (380, 1), (390, 1), (400, 1), (410, 1), (420, 1), (430, 1), (440, 0), (450, 0), (460, 0), (470, 1), (480, 1), (490, 1), (500, 1), (510, 1), (520, 0), (530, 1), (540, 1), (550, 1), (560, 1), (570, 1), (580, 1), (590, 0), (600, 0), (610, 0), (620, 0), (630, 0), (640, 1), (650, 1), (660, 0), (670, 0), (680, 0), (690, 0), (700, 1), (710, 0), (720, 0), (730, 0), (740, 0), (750, 0), (760, 1), (770, 1), (780, 1), (790, 1), (800, 1), (810, 0), (820, 1), (830, 1), (840, 1), (850, 1), (860, 1), (870, 1), (880, 1), (890, 1), (900, 1), (910, 1), (920, 1), (930, 1), (940, 0), (950, 1), (960, 1), (970, 0), (980, 0), (990, 0), (1000, 0), (1010, 0), (1020, 0), (1030, 0), (1040, 1), (1050, 1), (1060, 1), (1070, 1), (1080, 1), (1090, 1), (1100, 1), (1110, 1), (1120, 1), (1130, 1), (1140, 0), (1150, 1), (1160, 1), (1170, 1), (1180, 1), (1190, 1), (1200, 0), (1210, 1), (1220, 0), (1230, 1), (1240, 0), (1250, 0), (1260, 0), (1270, 1), (1280, 1), (1290, 1), (1300, 1), (1310, 1), (1320, 0), (1330, 0), (1340, 0), (1350, 1), (1360, 1), (1370, 0), (1380, 1), (1390, 1), (1400, 1), (1410, 0), (1420, 0), (1430, 0), (1440, 1), (1450, 0), (1460, 0), (1470, 1), (1480, 1), (1490, 0), (1500, 0), (1510, 0), (1520, 0), (1530, 0), (1540, 1), (1550, 0), (1560, 0), (1570, 1), (1580, 0), (1590, 0), (1600, 0), (1610, 0), (1620, 0), (1630, 0), (1640, 1), (1650, 1), (1660, 1), (1670, 0), (1680, 0), (1690, 1), (1700, 1), (1710, 0), (1720, 0), (1730, 0), (1740, 0), (1750, 0), (1760, 1), (1770, 1), (1780, 0), (1790, 1), (1800, 0), (1810, 0), (1820, 1), (1830, 0), (1840, 0), (1850, 0), (1860, 1), (1870, 1), (1880, 1), (1890, 1), (1900, 1), (1910, 0), (1920, 1), (1930, 0), (1940, 1), (1950, 0), (1960, 0), (1970, 1), (1980, 1), (1990, 0), (2000, 0), (2010, 0), (2020, 1), (2030, 1), (2040, 1), (2050, 1)]
Vdin0_16  din0_16  0 PWL (0n 0.0v 9.495n 0.0v 9.505n 1.7v 19.495n 1.7v 19.505n 0.0v 29.495n 0.0v 29.505n 1.7v 39.495n 1.7v 39.505n 1.7v 49.495n 1.7v 49.505n 0.0v 59.495n 0.0v 59.505n 1.7v 69.495n 1.7v 69.505n 1.7v 79.495n 1.7v 79.505n 0.0v 89.495n 0.0v 89.505n 0.0v 99.495n 0.0v 99.505n 0.0v 109.495n 0.0v 109.505n 0.0v 119.495n 0.0v 119.505n 1.7v 129.495n 1.7v 129.505n 1.7v 139.495n 1.7v 139.505n 0.0v 149.495n 0.0v 149.505n 0.0v 159.495n 0.0v 159.505n 0.0v 169.495n 0.0v 169.505n 0.0v 179.495n 0.0v 179.505n 0.0v 189.495n 0.0v 189.505n 0.0v 199.495n 0.0v 199.505n 0.0v 209.495n 0.0v 209.505n 0.0v 219.495n 0.0v 219.505n 0.0v 229.495n 0.0v 229.505n 0.0v 239.495n 0.0v 239.505n 1.7v 249.495n 1.7v 249.505n 1.7v 259.495n 1.7v 259.505n 1.7v 269.495n 1.7v 269.505n 0.0v 279.495n 0.0v 279.505n 0.0v 289.495n 0.0v 289.505n 0.0v 299.495n 0.0v 299.505n 1.7v 309.495n 1.7v 309.505n 0.0v 319.495n 0.0v 319.505n 0.0v 329.495n 0.0v 329.505n 0.0v 339.495n 0.0v 339.505n 0.0v 349.495n 0.0v 349.505n 0.0v 359.495n 0.0v 359.505n 0.0v 369.495n 0.0v 369.505n 0.0v 379.495n 0.0v 379.505n 1.7v 389.495n 1.7v 389.505n 1.7v 399.495n 1.7v 399.505n 1.7v 409.495n 1.7v 409.505n 1.7v 419.495n 1.7v 419.505n 1.7v 429.495n 1.7v 429.505n 1.7v 439.495n 1.7v 439.505n 0.0v 449.495n 0.0v 449.505n 0.0v 459.495n 0.0v 459.505n 0.0v 469.495n 0.0v 469.505n 1.7v 479.495n 1.7v 479.505n 1.7v 489.495n 1.7v 489.505n 1.7v 499.495n 1.7v 499.505n 1.7v 509.495n 1.7v 509.505n 1.7v 519.495n 1.7v 519.505n 0.0v 529.495n 0.0v 529.505n 1.7v 539.495n 1.7v 539.505n 1.7v 549.495n 1.7v 549.505n 1.7v 559.495n 1.7v 559.505n 1.7v 569.495n 1.7v 569.505n 1.7v 579.495n 1.7v 579.505n 1.7v 589.495n 1.7v 589.505n 0.0v 599.495n 0.0v 599.505n 0.0v 609.495n 0.0v 609.505n 0.0v 619.495n 0.0v 619.505n 0.0v 629.495n 0.0v 629.505n 0.0v 639.495n 0.0v 639.505n 1.7v 649.495n 1.7v 649.505n 1.7v 659.495n 1.7v 659.505n 0.0v 669.495n 0.0v 669.505n 0.0v 679.495n 0.0v 679.505n 0.0v 689.495n 0.0v 689.505n 0.0v 699.495n 0.0v 699.505n 1.7v 709.495n 1.7v 709.505n 0.0v 719.495n 0.0v 719.505n 0.0v 729.495n 0.0v 729.505n 0.0v 739.495n 0.0v 739.505n 0.0v 749.495n 0.0v 749.505n 0.0v 759.495n 0.0v 759.505n 1.7v 769.495n 1.7v 769.505n 1.7v 779.495n 1.7v 779.505n 1.7v 789.495n 1.7v 789.505n 1.7v 799.495n 1.7v 799.505n 1.7v 809.495n 1.7v 809.505n 0.0v 819.495n 0.0v 819.505n 1.7v 829.495n 1.7v 829.505n 1.7v 839.495n 1.7v 839.505n 1.7v 849.495n 1.7v 849.505n 1.7v 859.495n 1.7v 859.505n 1.7v 869.495n 1.7v 869.505n 1.7v 879.495n 1.7v 879.505n 1.7v 889.495n 1.7v 889.505n 1.7v 899.495n 1.7v 899.505n 1.7v 909.495n 1.7v 909.505n 1.7v 919.495n 1.7v 919.505n 1.7v 929.495n 1.7v 929.505n 1.7v 939.495n 1.7v 939.505n 0.0v 949.495n 0.0v 949.505n 1.7v 959.495n 1.7v 959.505n 1.7v 969.495n 1.7v 969.505n 0.0v 979.495n 0.0v 979.505n 0.0v 989.495n 0.0v 989.505n 0.0v 999.495n 0.0v 999.505n 0.0v 1009.495n 0.0v 1009.505n 0.0v 1019.495n 0.0v 1019.505n 0.0v 1029.495n 0.0v 1029.505n 0.0v 1039.495n 0.0v 1039.505n 1.7v 1049.495n 1.7v 1049.505n 1.7v 1059.495n 1.7v 1059.505n 1.7v 1069.495n 1.7v 1069.505n 1.7v 1079.495n 1.7v 1079.505n 1.7v 1089.495n 1.7v 1089.505n 1.7v 1099.495n 1.7v 1099.505n 1.7v 1109.495n 1.7v 1109.505n 1.7v 1119.495n 1.7v 1119.505n 1.7v 1129.495n 1.7v 1129.505n 1.7v 1139.495n 1.7v 1139.505n 0.0v 1149.495n 0.0v 1149.505n 1.7v 1159.495n 1.7v 1159.505n 1.7v 1169.495n 1.7v 1169.505n 1.7v 1179.495n 1.7v 1179.505n 1.7v 1189.495n 1.7v 1189.505n 1.7v 1199.495n 1.7v 1199.505n 0.0v 1209.495n 0.0v 1209.505n 1.7v 1219.495n 1.7v 1219.505n 0.0v 1229.495n 0.0v 1229.505n 1.7v 1239.495n 1.7v 1239.505n 0.0v 1249.495n 0.0v 1249.505n 0.0v 1259.495n 0.0v 1259.505n 0.0v 1269.495n 0.0v 1269.505n 1.7v 1279.495n 1.7v 1279.505n 1.7v 1289.495n 1.7v 1289.505n 1.7v 1299.495n 1.7v 1299.505n 1.7v 1309.495n 1.7v 1309.505n 1.7v 1319.495n 1.7v 1319.505n 0.0v 1329.495n 0.0v 1329.505n 0.0v 1339.495n 0.0v 1339.505n 0.0v 1349.495n 0.0v 1349.505n 1.7v 1359.495n 1.7v 1359.505n 1.7v 1369.495n 1.7v 1369.505n 0.0v 1379.495n 0.0v 1379.505n 1.7v 1389.495n 1.7v 1389.505n 1.7v 1399.495n 1.7v 1399.505n 1.7v 1409.495n 1.7v 1409.505n 0.0v 1419.495n 0.0v 1419.505n 0.0v 1429.495n 0.0v 1429.505n 0.0v 1439.495n 0.0v 1439.505n 1.7v 1449.495n 1.7v 1449.505n 0.0v 1459.495n 0.0v 1459.505n 0.0v 1469.495n 0.0v 1469.505n 1.7v 1479.495n 1.7v 1479.505n 1.7v 1489.495n 1.7v 1489.505n 0.0v 1499.495n 0.0v 1499.505n 0.0v 1509.495n 0.0v 1509.505n 0.0v 1519.495n 0.0v 1519.505n 0.0v 1529.495n 0.0v 1529.505n 0.0v 1539.495n 0.0v 1539.505n 1.7v 1549.495n 1.7v 1549.505n 0.0v 1559.495n 0.0v 1559.505n 0.0v 1569.495n 0.0v 1569.505n 1.7v 1579.495n 1.7v 1579.505n 0.0v 1589.495n 0.0v 1589.505n 0.0v 1599.495n 0.0v 1599.505n 0.0v 1609.495n 0.0v 1609.505n 0.0v 1619.495n 0.0v 1619.505n 0.0v 1629.495n 0.0v 1629.505n 0.0v 1639.495n 0.0v 1639.505n 1.7v 1649.495n 1.7v 1649.505n 1.7v 1659.495n 1.7v 1659.505n 1.7v 1669.495n 1.7v 1669.505n 0.0v 1679.495n 0.0v 1679.505n 0.0v 1689.495n 0.0v 1689.505n 1.7v 1699.495n 1.7v 1699.505n 1.7v 1709.495n 1.7v 1709.505n 0.0v 1719.495n 0.0v 1719.505n 0.0v 1729.495n 0.0v 1729.505n 0.0v 1739.495n 0.0v 1739.505n 0.0v 1749.495n 0.0v 1749.505n 0.0v 1759.495n 0.0v 1759.505n 1.7v 1769.495n 1.7v 1769.505n 1.7v 1779.495n 1.7v 1779.505n 0.0v 1789.495n 0.0v 1789.505n 1.7v 1799.495n 1.7v 1799.505n 0.0v 1809.495n 0.0v 1809.505n 0.0v 1819.495n 0.0v 1819.505n 1.7v 1829.495n 1.7v 1829.505n 0.0v 1839.495n 0.0v 1839.505n 0.0v 1849.495n 0.0v 1849.505n 0.0v 1859.495n 0.0v 1859.505n 1.7v 1869.495n 1.7v 1869.505n 1.7v 1879.495n 1.7v 1879.505n 1.7v 1889.495n 1.7v 1889.505n 1.7v 1899.495n 1.7v 1899.505n 1.7v 1909.495n 1.7v 1909.505n 0.0v 1919.495n 0.0v 1919.505n 1.7v 1929.495n 1.7v 1929.505n 0.0v 1939.495n 0.0v 1939.505n 1.7v 1949.495n 1.7v 1949.505n 0.0v 1959.495n 0.0v 1959.505n 0.0v 1969.495n 0.0v 1969.505n 1.7v 1979.495n 1.7v 1979.505n 1.7v 1989.495n 1.7v 1989.505n 0.0v 1999.495n 0.0v 1999.505n 0.0v 2009.495n 0.0v 2009.505n 0.0v 2019.495n 0.0v 2019.505n 1.7v 2029.495n 1.7v 2029.505n 1.7v 2039.495n 1.7v 2039.505n 1.7v 2049.495n 1.7v 2049.505n 1.7v )
* (time, data): [(0, 0), (10, 0), (20, 0), (30, 1), (40, 1), (50, 0), (60, 0), (70, 1), (80, 0), (90, 0), (100, 0), (110, 0), (120, 1), (130, 0), (140, 1), (150, 1), (160, 1), (170, 1), (180, 0), (190, 0), (200, 0), (210, 0), (220, 0), (230, 0), (240, 1), (250, 1), (260, 1), (270, 0), (280, 0), (290, 0), (300, 0), (310, 0), (320, 1), (330, 1), (340, 1), (350, 1), (360, 1), (370, 1), (380, 1), (390, 1), (400, 1), (410, 1), (420, 1), (430, 1), (440, 0), (450, 0), (460, 1), (470, 1), (480, 1), (490, 1), (500, 1), (510, 0), (520, 0), (530, 0), (540, 1), (550, 0), (560, 0), (570, 0), (580, 0), (590, 0), (600, 0), (610, 0), (620, 0), (630, 0), (640, 0), (650, 0), (660, 0), (670, 0), (680, 0), (690, 1), (700, 1), (710, 0), (720, 0), (730, 0), (740, 0), (750, 1), (760, 1), (770, 0), (780, 0), (790, 0), (800, 0), (810, 0), (820, 1), (830, 1), (840, 1), (850, 1), (860, 1), (870, 1), (880, 1), (890, 1), (900, 1), (910, 1), (920, 0), (930, 0), (940, 0), (950, 1), (960, 1), (970, 0), (980, 0), (990, 0), (1000, 0), (1010, 0), (1020, 0), (1030, 0), (1040, 0), (1050, 0), (1060, 0), (1070, 0), (1080, 0), (1090, 0), (1100, 1), (1110, 0), (1120, 0), (1130, 0), (1140, 0), (1150, 1), (1160, 1), (1170, 1), (1180, 1), (1190, 1), (1200, 1), (1210, 0), (1220, 0), (1230, 0), (1240, 1), (1250, 1), (1260, 1), (1270, 0), (1280, 0), (1290, 1), (1300, 1), (1310, 1), (1320, 0), (1330, 0), (1340, 1), (1350, 1), (1360, 1), (1370, 0), (1380, 1), (1390, 1), (1400, 0), (1410, 1), (1420, 1), (1430, 1), (1440, 1), (1450, 1), (1460, 1), (1470, 1), (1480, 1), (1490, 1), (1500, 1), (1510, 1), (1520, 1), (1530, 1), (1540, 0), (1550, 0), (1560, 0), (1570, 1), (1580, 1), (1590, 1), (1600, 0), (1610, 1), (1620, 1), (1630, 1), (1640, 1), (1650, 1), (1660, 1), (1670, 1), (1680, 1), (1690, 1), (1700, 1), (1710, 1), (1720, 0), (1730, 0), (1740, 1), (1750, 1), (1760, 0), (1770, 0), (1780, 0), (1790, 1), (1800, 1), (1810, 0), (1820, 1), (1830, 0), (1840, 1), (1850, 1), (1860, 1), (1870, 1), (1880, 1), (1890, 1), (1900, 0), (1910, 1), (1920, 1), (1930, 1), (1940, 0), (1950, 1), (1960, 1), (1970, 0), (1980, 0), (1990, 1), (2000, 1), (2010, 1), (2020, 1), (2030, 1), (2040, 1), (2050, 1)]
Vdin0_17  din0_17  0 PWL (0n 0.0v 9.495n 0.0v 9.505n 0.0v 19.495n 0.0v 19.505n 0.0v 29.495n 0.0v 29.505n 1.7v 39.495n 1.7v 39.505n 1.7v 49.495n 1.7v 49.505n 0.0v 59.495n 0.0v 59.505n 0.0v 69.495n 0.0v 69.505n 1.7v 79.495n 1.7v 79.505n 0.0v 89.495n 0.0v 89.505n 0.0v 99.495n 0.0v 99.505n 0.0v 109.495n 0.0v 109.505n 0.0v 119.495n 0.0v 119.505n 1.7v 129.495n 1.7v 129.505n 0.0v 139.495n 0.0v 139.505n 1.7v 149.495n 1.7v 149.505n 1.7v 159.495n 1.7v 159.505n 1.7v 169.495n 1.7v 169.505n 1.7v 179.495n 1.7v 179.505n 0.0v 189.495n 0.0v 189.505n 0.0v 199.495n 0.0v 199.505n 0.0v 209.495n 0.0v 209.505n 0.0v 219.495n 0.0v 219.505n 0.0v 229.495n 0.0v 229.505n 0.0v 239.495n 0.0v 239.505n 1.7v 249.495n 1.7v 249.505n 1.7v 259.495n 1.7v 259.505n 1.7v 269.495n 1.7v 269.505n 0.0v 279.495n 0.0v 279.505n 0.0v 289.495n 0.0v 289.505n 0.0v 299.495n 0.0v 299.505n 0.0v 309.495n 0.0v 309.505n 0.0v 319.495n 0.0v 319.505n 1.7v 329.495n 1.7v 329.505n 1.7v 339.495n 1.7v 339.505n 1.7v 349.495n 1.7v 349.505n 1.7v 359.495n 1.7v 359.505n 1.7v 369.495n 1.7v 369.505n 1.7v 379.495n 1.7v 379.505n 1.7v 389.495n 1.7v 389.505n 1.7v 399.495n 1.7v 399.505n 1.7v 409.495n 1.7v 409.505n 1.7v 419.495n 1.7v 419.505n 1.7v 429.495n 1.7v 429.505n 1.7v 439.495n 1.7v 439.505n 0.0v 449.495n 0.0v 449.505n 0.0v 459.495n 0.0v 459.505n 1.7v 469.495n 1.7v 469.505n 1.7v 479.495n 1.7v 479.505n 1.7v 489.495n 1.7v 489.505n 1.7v 499.495n 1.7v 499.505n 1.7v 509.495n 1.7v 509.505n 0.0v 519.495n 0.0v 519.505n 0.0v 529.495n 0.0v 529.505n 0.0v 539.495n 0.0v 539.505n 1.7v 549.495n 1.7v 549.505n 0.0v 559.495n 0.0v 559.505n 0.0v 569.495n 0.0v 569.505n 0.0v 579.495n 0.0v 579.505n 0.0v 589.495n 0.0v 589.505n 0.0v 599.495n 0.0v 599.505n 0.0v 609.495n 0.0v 609.505n 0.0v 619.495n 0.0v 619.505n 0.0v 629.495n 0.0v 629.505n 0.0v 639.495n 0.0v 639.505n 0.0v 649.495n 0.0v 649.505n 0.0v 659.495n 0.0v 659.505n 0.0v 669.495n 0.0v 669.505n 0.0v 679.495n 0.0v 679.505n 0.0v 689.495n 0.0v 689.505n 1.7v 699.495n 1.7v 699.505n 1.7v 709.495n 1.7v 709.505n 0.0v 719.495n 0.0v 719.505n 0.0v 729.495n 0.0v 729.505n 0.0v 739.495n 0.0v 739.505n 0.0v 749.495n 0.0v 749.505n 1.7v 759.495n 1.7v 759.505n 1.7v 769.495n 1.7v 769.505n 0.0v 779.495n 0.0v 779.505n 0.0v 789.495n 0.0v 789.505n 0.0v 799.495n 0.0v 799.505n 0.0v 809.495n 0.0v 809.505n 0.0v 819.495n 0.0v 819.505n 1.7v 829.495n 1.7v 829.505n 1.7v 839.495n 1.7v 839.505n 1.7v 849.495n 1.7v 849.505n 1.7v 859.495n 1.7v 859.505n 1.7v 869.495n 1.7v 869.505n 1.7v 879.495n 1.7v 879.505n 1.7v 889.495n 1.7v 889.505n 1.7v 899.495n 1.7v 899.505n 1.7v 909.495n 1.7v 909.505n 1.7v 919.495n 1.7v 919.505n 0.0v 929.495n 0.0v 929.505n 0.0v 939.495n 0.0v 939.505n 0.0v 949.495n 0.0v 949.505n 1.7v 959.495n 1.7v 959.505n 1.7v 969.495n 1.7v 969.505n 0.0v 979.495n 0.0v 979.505n 0.0v 989.495n 0.0v 989.505n 0.0v 999.495n 0.0v 999.505n 0.0v 1009.495n 0.0v 1009.505n 0.0v 1019.495n 0.0v 1019.505n 0.0v 1029.495n 0.0v 1029.505n 0.0v 1039.495n 0.0v 1039.505n 0.0v 1049.495n 0.0v 1049.505n 0.0v 1059.495n 0.0v 1059.505n 0.0v 1069.495n 0.0v 1069.505n 0.0v 1079.495n 0.0v 1079.505n 0.0v 1089.495n 0.0v 1089.505n 0.0v 1099.495n 0.0v 1099.505n 1.7v 1109.495n 1.7v 1109.505n 0.0v 1119.495n 0.0v 1119.505n 0.0v 1129.495n 0.0v 1129.505n 0.0v 1139.495n 0.0v 1139.505n 0.0v 1149.495n 0.0v 1149.505n 1.7v 1159.495n 1.7v 1159.505n 1.7v 1169.495n 1.7v 1169.505n 1.7v 1179.495n 1.7v 1179.505n 1.7v 1189.495n 1.7v 1189.505n 1.7v 1199.495n 1.7v 1199.505n 1.7v 1209.495n 1.7v 1209.505n 0.0v 1219.495n 0.0v 1219.505n 0.0v 1229.495n 0.0v 1229.505n 0.0v 1239.495n 0.0v 1239.505n 1.7v 1249.495n 1.7v 1249.505n 1.7v 1259.495n 1.7v 1259.505n 1.7v 1269.495n 1.7v 1269.505n 0.0v 1279.495n 0.0v 1279.505n 0.0v 1289.495n 0.0v 1289.505n 1.7v 1299.495n 1.7v 1299.505n 1.7v 1309.495n 1.7v 1309.505n 1.7v 1319.495n 1.7v 1319.505n 0.0v 1329.495n 0.0v 1329.505n 0.0v 1339.495n 0.0v 1339.505n 1.7v 1349.495n 1.7v 1349.505n 1.7v 1359.495n 1.7v 1359.505n 1.7v 1369.495n 1.7v 1369.505n 0.0v 1379.495n 0.0v 1379.505n 1.7v 1389.495n 1.7v 1389.505n 1.7v 1399.495n 1.7v 1399.505n 0.0v 1409.495n 0.0v 1409.505n 1.7v 1419.495n 1.7v 1419.505n 1.7v 1429.495n 1.7v 1429.505n 1.7v 1439.495n 1.7v 1439.505n 1.7v 1449.495n 1.7v 1449.505n 1.7v 1459.495n 1.7v 1459.505n 1.7v 1469.495n 1.7v 1469.505n 1.7v 1479.495n 1.7v 1479.505n 1.7v 1489.495n 1.7v 1489.505n 1.7v 1499.495n 1.7v 1499.505n 1.7v 1509.495n 1.7v 1509.505n 1.7v 1519.495n 1.7v 1519.505n 1.7v 1529.495n 1.7v 1529.505n 1.7v 1539.495n 1.7v 1539.505n 0.0v 1549.495n 0.0v 1549.505n 0.0v 1559.495n 0.0v 1559.505n 0.0v 1569.495n 0.0v 1569.505n 1.7v 1579.495n 1.7v 1579.505n 1.7v 1589.495n 1.7v 1589.505n 1.7v 1599.495n 1.7v 1599.505n 0.0v 1609.495n 0.0v 1609.505n 1.7v 1619.495n 1.7v 1619.505n 1.7v 1629.495n 1.7v 1629.505n 1.7v 1639.495n 1.7v 1639.505n 1.7v 1649.495n 1.7v 1649.505n 1.7v 1659.495n 1.7v 1659.505n 1.7v 1669.495n 1.7v 1669.505n 1.7v 1679.495n 1.7v 1679.505n 1.7v 1689.495n 1.7v 1689.505n 1.7v 1699.495n 1.7v 1699.505n 1.7v 1709.495n 1.7v 1709.505n 1.7v 1719.495n 1.7v 1719.505n 0.0v 1729.495n 0.0v 1729.505n 0.0v 1739.495n 0.0v 1739.505n 1.7v 1749.495n 1.7v 1749.505n 1.7v 1759.495n 1.7v 1759.505n 0.0v 1769.495n 0.0v 1769.505n 0.0v 1779.495n 0.0v 1779.505n 0.0v 1789.495n 0.0v 1789.505n 1.7v 1799.495n 1.7v 1799.505n 1.7v 1809.495n 1.7v 1809.505n 0.0v 1819.495n 0.0v 1819.505n 1.7v 1829.495n 1.7v 1829.505n 0.0v 1839.495n 0.0v 1839.505n 1.7v 1849.495n 1.7v 1849.505n 1.7v 1859.495n 1.7v 1859.505n 1.7v 1869.495n 1.7v 1869.505n 1.7v 1879.495n 1.7v 1879.505n 1.7v 1889.495n 1.7v 1889.505n 1.7v 1899.495n 1.7v 1899.505n 0.0v 1909.495n 0.0v 1909.505n 1.7v 1919.495n 1.7v 1919.505n 1.7v 1929.495n 1.7v 1929.505n 1.7v 1939.495n 1.7v 1939.505n 0.0v 1949.495n 0.0v 1949.505n 1.7v 1959.495n 1.7v 1959.505n 1.7v 1969.495n 1.7v 1969.505n 0.0v 1979.495n 0.0v 1979.505n 0.0v 1989.495n 0.0v 1989.505n 1.7v 1999.495n 1.7v 1999.505n 1.7v 2009.495n 1.7v 2009.505n 1.7v 2019.495n 1.7v 2019.505n 1.7v 2029.495n 1.7v 2029.505n 1.7v 2039.495n 1.7v 2039.505n 1.7v 2049.495n 1.7v 2049.505n 1.7v )
* (time, data): [(0, 0), (10, 0), (20, 1), (30, 0), (40, 0), (50, 1), (60, 1), (70, 0), (80, 0), (90, 0), (100, 0), (110, 0), (120, 1), (130, 1), (140, 1), (150, 1), (160, 1), (170, 1), (180, 0), (190, 0), (200, 0), (210, 0), (220, 0), (230, 0), (240, 0), (250, 0), (260, 0), (270, 1), (280, 1), (290, 1), (300, 1), (310, 0), (320, 1), (330, 1), (340, 1), (350, 1), (360, 1), (370, 1), (380, 1), (390, 1), (400, 1), (410, 1), (420, 1), (430, 0), (440, 0), (450, 0), (460, 0), (470, 0), (480, 0), (490, 0), (500, 0), (510, 0), (520, 0), (530, 1), (540, 1), (550, 1), (560, 1), (570, 1), (580, 1), (590, 1), (600, 1), (610, 1), (620, 1), (630, 0), (640, 0), (650, 0), (660, 0), (670, 1), (680, 1), (690, 1), (700, 1), (710, 0), (720, 0), (730, 0), (740, 1), (750, 0), (760, 1), (770, 1), (780, 1), (790, 1), (800, 1), (810, 1), (820, 0), (830, 0), (840, 0), (850, 1), (860, 1), (870, 0), (880, 0), (890, 0), (900, 0), (910, 0), (920, 0), (930, 0), (940, 0), (950, 0), (960, 0), (970, 0), (980, 0), (990, 0), (1000, 0), (1010, 0), (1020, 0), (1030, 0), (1040, 0), (1050, 0), (1060, 0), (1070, 0), (1080, 0), (1090, 1), (1100, 0), (1110, 0), (1120, 0), (1130, 0), (1140, 0), (1150, 0), (1160, 1), (1170, 1), (1180, 0), (1190, 0), (1200, 0), (1210, 0), (1220, 0), (1230, 0), (1240, 1), (1250, 1), (1260, 1), (1270, 0), (1280, 0), (1290, 1), (1300, 1), (1310, 1), (1320, 1), (1330, 1), (1340, 0), (1350, 0), (1360, 0), (1370, 0), (1380, 0), (1390, 0), (1400, 1), (1410, 1), (1420, 1), (1430, 1), (1440, 1), (1450, 0), (1460, 1), (1470, 1), (1480, 1), (1490, 0), (1500, 0), (1510, 1), (1520, 1), (1530, 1), (1540, 0), (1550, 0), (1560, 0), (1570, 1), (1580, 0), (1590, 0), (1600, 1), (1610, 1), (1620, 1), (1630, 1), (1640, 0), (1650, 0), (1660, 0), (1670, 1), (1680, 0), (1690, 1), (1700, 1), (1710, 1), (1720, 1), (1730, 1), (1740, 1), (1750, 1), (1760, 1), (1770, 1), (1780, 0), (1790, 0), (1800, 1), (1810, 0), (1820, 1), (1830, 0), (1840, 1), (1850, 1), (1860, 1), (1870, 1), (1880, 0), (1890, 0), (1900, 1), (1910, 1), (1920, 1), (1930, 0), (1940, 0), (1950, 1), (1960, 1), (1970, 0), (1980, 0), (1990, 0), (2000, 0), (2010, 0), (2020, 1), (2030, 1), (2040, 1), (2050, 1)]
Vdin0_18  din0_18  0 PWL (0n 0.0v 9.495n 0.0v 9.505n 0.0v 19.495n 0.0v 19.505n 1.7v 29.495n 1.7v 29.505n 0.0v 39.495n 0.0v 39.505n 0.0v 49.495n 0.0v 49.505n 1.7v 59.495n 1.7v 59.505n 1.7v 69.495n 1.7v 69.505n 0.0v 79.495n 0.0v 79.505n 0.0v 89.495n 0.0v 89.505n 0.0v 99.495n 0.0v 99.505n 0.0v 109.495n 0.0v 109.505n 0.0v 119.495n 0.0v 119.505n 1.7v 129.495n 1.7v 129.505n 1.7v 139.495n 1.7v 139.505n 1.7v 149.495n 1.7v 149.505n 1.7v 159.495n 1.7v 159.505n 1.7v 169.495n 1.7v 169.505n 1.7v 179.495n 1.7v 179.505n 0.0v 189.495n 0.0v 189.505n 0.0v 199.495n 0.0v 199.505n 0.0v 209.495n 0.0v 209.505n 0.0v 219.495n 0.0v 219.505n 0.0v 229.495n 0.0v 229.505n 0.0v 239.495n 0.0v 239.505n 0.0v 249.495n 0.0v 249.505n 0.0v 259.495n 0.0v 259.505n 0.0v 269.495n 0.0v 269.505n 1.7v 279.495n 1.7v 279.505n 1.7v 289.495n 1.7v 289.505n 1.7v 299.495n 1.7v 299.505n 1.7v 309.495n 1.7v 309.505n 0.0v 319.495n 0.0v 319.505n 1.7v 329.495n 1.7v 329.505n 1.7v 339.495n 1.7v 339.505n 1.7v 349.495n 1.7v 349.505n 1.7v 359.495n 1.7v 359.505n 1.7v 369.495n 1.7v 369.505n 1.7v 379.495n 1.7v 379.505n 1.7v 389.495n 1.7v 389.505n 1.7v 399.495n 1.7v 399.505n 1.7v 409.495n 1.7v 409.505n 1.7v 419.495n 1.7v 419.505n 1.7v 429.495n 1.7v 429.505n 0.0v 439.495n 0.0v 439.505n 0.0v 449.495n 0.0v 449.505n 0.0v 459.495n 0.0v 459.505n 0.0v 469.495n 0.0v 469.505n 0.0v 479.495n 0.0v 479.505n 0.0v 489.495n 0.0v 489.505n 0.0v 499.495n 0.0v 499.505n 0.0v 509.495n 0.0v 509.505n 0.0v 519.495n 0.0v 519.505n 0.0v 529.495n 0.0v 529.505n 1.7v 539.495n 1.7v 539.505n 1.7v 549.495n 1.7v 549.505n 1.7v 559.495n 1.7v 559.505n 1.7v 569.495n 1.7v 569.505n 1.7v 579.495n 1.7v 579.505n 1.7v 589.495n 1.7v 589.505n 1.7v 599.495n 1.7v 599.505n 1.7v 609.495n 1.7v 609.505n 1.7v 619.495n 1.7v 619.505n 1.7v 629.495n 1.7v 629.505n 0.0v 639.495n 0.0v 639.505n 0.0v 649.495n 0.0v 649.505n 0.0v 659.495n 0.0v 659.505n 0.0v 669.495n 0.0v 669.505n 1.7v 679.495n 1.7v 679.505n 1.7v 689.495n 1.7v 689.505n 1.7v 699.495n 1.7v 699.505n 1.7v 709.495n 1.7v 709.505n 0.0v 719.495n 0.0v 719.505n 0.0v 729.495n 0.0v 729.505n 0.0v 739.495n 0.0v 739.505n 1.7v 749.495n 1.7v 749.505n 0.0v 759.495n 0.0v 759.505n 1.7v 769.495n 1.7v 769.505n 1.7v 779.495n 1.7v 779.505n 1.7v 789.495n 1.7v 789.505n 1.7v 799.495n 1.7v 799.505n 1.7v 809.495n 1.7v 809.505n 1.7v 819.495n 1.7v 819.505n 0.0v 829.495n 0.0v 829.505n 0.0v 839.495n 0.0v 839.505n 0.0v 849.495n 0.0v 849.505n 1.7v 859.495n 1.7v 859.505n 1.7v 869.495n 1.7v 869.505n 0.0v 879.495n 0.0v 879.505n 0.0v 889.495n 0.0v 889.505n 0.0v 899.495n 0.0v 899.505n 0.0v 909.495n 0.0v 909.505n 0.0v 919.495n 0.0v 919.505n 0.0v 929.495n 0.0v 929.505n 0.0v 939.495n 0.0v 939.505n 0.0v 949.495n 0.0v 949.505n 0.0v 959.495n 0.0v 959.505n 0.0v 969.495n 0.0v 969.505n 0.0v 979.495n 0.0v 979.505n 0.0v 989.495n 0.0v 989.505n 0.0v 999.495n 0.0v 999.505n 0.0v 1009.495n 0.0v 1009.505n 0.0v 1019.495n 0.0v 1019.505n 0.0v 1029.495n 0.0v 1029.505n 0.0v 1039.495n 0.0v 1039.505n 0.0v 1049.495n 0.0v 1049.505n 0.0v 1059.495n 0.0v 1059.505n 0.0v 1069.495n 0.0v 1069.505n 0.0v 1079.495n 0.0v 1079.505n 0.0v 1089.495n 0.0v 1089.505n 1.7v 1099.495n 1.7v 1099.505n 0.0v 1109.495n 0.0v 1109.505n 0.0v 1119.495n 0.0v 1119.505n 0.0v 1129.495n 0.0v 1129.505n 0.0v 1139.495n 0.0v 1139.505n 0.0v 1149.495n 0.0v 1149.505n 0.0v 1159.495n 0.0v 1159.505n 1.7v 1169.495n 1.7v 1169.505n 1.7v 1179.495n 1.7v 1179.505n 0.0v 1189.495n 0.0v 1189.505n 0.0v 1199.495n 0.0v 1199.505n 0.0v 1209.495n 0.0v 1209.505n 0.0v 1219.495n 0.0v 1219.505n 0.0v 1229.495n 0.0v 1229.505n 0.0v 1239.495n 0.0v 1239.505n 1.7v 1249.495n 1.7v 1249.505n 1.7v 1259.495n 1.7v 1259.505n 1.7v 1269.495n 1.7v 1269.505n 0.0v 1279.495n 0.0v 1279.505n 0.0v 1289.495n 0.0v 1289.505n 1.7v 1299.495n 1.7v 1299.505n 1.7v 1309.495n 1.7v 1309.505n 1.7v 1319.495n 1.7v 1319.505n 1.7v 1329.495n 1.7v 1329.505n 1.7v 1339.495n 1.7v 1339.505n 0.0v 1349.495n 0.0v 1349.505n 0.0v 1359.495n 0.0v 1359.505n 0.0v 1369.495n 0.0v 1369.505n 0.0v 1379.495n 0.0v 1379.505n 0.0v 1389.495n 0.0v 1389.505n 0.0v 1399.495n 0.0v 1399.505n 1.7v 1409.495n 1.7v 1409.505n 1.7v 1419.495n 1.7v 1419.505n 1.7v 1429.495n 1.7v 1429.505n 1.7v 1439.495n 1.7v 1439.505n 1.7v 1449.495n 1.7v 1449.505n 0.0v 1459.495n 0.0v 1459.505n 1.7v 1469.495n 1.7v 1469.505n 1.7v 1479.495n 1.7v 1479.505n 1.7v 1489.495n 1.7v 1489.505n 0.0v 1499.495n 0.0v 1499.505n 0.0v 1509.495n 0.0v 1509.505n 1.7v 1519.495n 1.7v 1519.505n 1.7v 1529.495n 1.7v 1529.505n 1.7v 1539.495n 1.7v 1539.505n 0.0v 1549.495n 0.0v 1549.505n 0.0v 1559.495n 0.0v 1559.505n 0.0v 1569.495n 0.0v 1569.505n 1.7v 1579.495n 1.7v 1579.505n 0.0v 1589.495n 0.0v 1589.505n 0.0v 1599.495n 0.0v 1599.505n 1.7v 1609.495n 1.7v 1609.505n 1.7v 1619.495n 1.7v 1619.505n 1.7v 1629.495n 1.7v 1629.505n 1.7v 1639.495n 1.7v 1639.505n 0.0v 1649.495n 0.0v 1649.505n 0.0v 1659.495n 0.0v 1659.505n 0.0v 1669.495n 0.0v 1669.505n 1.7v 1679.495n 1.7v 1679.505n 0.0v 1689.495n 0.0v 1689.505n 1.7v 1699.495n 1.7v 1699.505n 1.7v 1709.495n 1.7v 1709.505n 1.7v 1719.495n 1.7v 1719.505n 1.7v 1729.495n 1.7v 1729.505n 1.7v 1739.495n 1.7v 1739.505n 1.7v 1749.495n 1.7v 1749.505n 1.7v 1759.495n 1.7v 1759.505n 1.7v 1769.495n 1.7v 1769.505n 1.7v 1779.495n 1.7v 1779.505n 0.0v 1789.495n 0.0v 1789.505n 0.0v 1799.495n 0.0v 1799.505n 1.7v 1809.495n 1.7v 1809.505n 0.0v 1819.495n 0.0v 1819.505n 1.7v 1829.495n 1.7v 1829.505n 0.0v 1839.495n 0.0v 1839.505n 1.7v 1849.495n 1.7v 1849.505n 1.7v 1859.495n 1.7v 1859.505n 1.7v 1869.495n 1.7v 1869.505n 1.7v 1879.495n 1.7v 1879.505n 0.0v 1889.495n 0.0v 1889.505n 0.0v 1899.495n 0.0v 1899.505n 1.7v 1909.495n 1.7v 1909.505n 1.7v 1919.495n 1.7v 1919.505n 1.7v 1929.495n 1.7v 1929.505n 0.0v 1939.495n 0.0v 1939.505n 0.0v 1949.495n 0.0v 1949.505n 1.7v 1959.495n 1.7v 1959.505n 1.7v 1969.495n 1.7v 1969.505n 0.0v 1979.495n 0.0v 1979.505n 0.0v 1989.495n 0.0v 1989.505n 0.0v 1999.495n 0.0v 1999.505n 0.0v 2009.495n 0.0v 2009.505n 0.0v 2019.495n 0.0v 2019.505n 1.7v 2029.495n 1.7v 2029.505n 1.7v 2039.495n 1.7v 2039.505n 1.7v 2049.495n 1.7v 2049.505n 1.7v )
* (time, data): [(0, 0), (10, 1), (20, 1), (30, 1), (40, 1), (50, 0), (60, 1), (70, 1), (80, 0), (90, 0), (100, 0), (110, 0), (120, 1), (130, 1), (140, 1), (150, 1), (160, 1), (170, 1), (180, 1), (190, 1), (200, 1), (210, 1), (220, 1), (230, 1), (240, 1), (250, 1), (260, 1), (270, 1), (280, 1), (290, 1), (300, 0), (310, 0), (320, 1), (330, 1), (340, 1), (350, 1), (360, 1), (370, 1), (380, 0), (390, 0), (400, 0), (410, 0), (420, 0), (430, 0), (440, 1), (450, 1), (460, 0), (470, 1), (480, 1), (490, 1), (500, 1), (510, 0), (520, 0), (530, 1), (540, 0), (550, 0), (560, 0), (570, 0), (580, 0), (590, 0), (600, 0), (610, 0), (620, 0), (630, 0), (640, 1), (650, 1), (660, 0), (670, 1), (680, 1), (690, 0), (700, 1), (710, 1), (720, 1), (730, 1), (740, 1), (750, 0), (760, 0), (770, 0), (780, 0), (790, 0), (800, 0), (810, 0), (820, 1), (830, 1), (840, 1), (850, 0), (860, 0), (870, 1), (880, 1), (890, 1), (900, 1), (910, 1), (920, 0), (930, 1), (940, 1), (950, 1), (960, 1), (970, 0), (980, 0), (990, 0), (1000, 0), (1010, 0), (1020, 0), (1030, 0), (1040, 0), (1050, 0), (1060, 0), (1070, 0), (1080, 0), (1090, 1), (1100, 1), (1110, 0), (1120, 0), (1130, 0), (1140, 1), (1150, 1), (1160, 0), (1170, 0), (1180, 0), (1190, 0), (1200, 1), (1210, 0), (1220, 1), (1230, 1), (1240, 1), (1250, 1), (1260, 1), (1270, 0), (1280, 0), (1290, 0), (1300, 0), (1310, 0), (1320, 0), (1330, 0), (1340, 0), (1350, 0), (1360, 0), (1370, 1), (1380, 0), (1390, 0), (1400, 1), (1410, 0), (1420, 0), (1430, 0), (1440, 0), (1450, 0), (1460, 1), (1470, 0), (1480, 0), (1490, 1), (1500, 1), (1510, 0), (1520, 0), (1530, 1), (1540, 1), (1550, 1), (1560, 1), (1570, 1), (1580, 0), (1590, 1), (1600, 0), (1610, 0), (1620, 0), (1630, 0), (1640, 0), (1650, 0), (1660, 0), (1670, 1), (1680, 1), (1690, 0), (1700, 1), (1710, 1), (1720, 0), (1730, 0), (1740, 0), (1750, 0), (1760, 1), (1770, 0), (1780, 1), (1790, 1), (1800, 0), (1810, 0), (1820, 0), (1830, 0), (1840, 0), (1850, 0), (1860, 0), (1870, 0), (1880, 0), (1890, 0), (1900, 0), (1910, 0), (1920, 1), (1930, 0), (1940, 1), (1950, 1), (1960, 1), (1970, 0), (1980, 0), (1990, 0), (2000, 0), (2010, 0), (2020, 0), (2030, 1), (2040, 1), (2050, 1)]
Vdin0_19  din0_19  0 PWL (0n 0.0v 9.495n 0.0v 9.505n 1.7v 19.495n 1.7v 19.505n 1.7v 29.495n 1.7v 29.505n 1.7v 39.495n 1.7v 39.505n 1.7v 49.495n 1.7v 49.505n 0.0v 59.495n 0.0v 59.505n 1.7v 69.495n 1.7v 69.505n 1.7v 79.495n 1.7v 79.505n 0.0v 89.495n 0.0v 89.505n 0.0v 99.495n 0.0v 99.505n 0.0v 109.495n 0.0v 109.505n 0.0v 119.495n 0.0v 119.505n 1.7v 129.495n 1.7v 129.505n 1.7v 139.495n 1.7v 139.505n 1.7v 149.495n 1.7v 149.505n 1.7v 159.495n 1.7v 159.505n 1.7v 169.495n 1.7v 169.505n 1.7v 179.495n 1.7v 179.505n 1.7v 189.495n 1.7v 189.505n 1.7v 199.495n 1.7v 199.505n 1.7v 209.495n 1.7v 209.505n 1.7v 219.495n 1.7v 219.505n 1.7v 229.495n 1.7v 229.505n 1.7v 239.495n 1.7v 239.505n 1.7v 249.495n 1.7v 249.505n 1.7v 259.495n 1.7v 259.505n 1.7v 269.495n 1.7v 269.505n 1.7v 279.495n 1.7v 279.505n 1.7v 289.495n 1.7v 289.505n 1.7v 299.495n 1.7v 299.505n 0.0v 309.495n 0.0v 309.505n 0.0v 319.495n 0.0v 319.505n 1.7v 329.495n 1.7v 329.505n 1.7v 339.495n 1.7v 339.505n 1.7v 349.495n 1.7v 349.505n 1.7v 359.495n 1.7v 359.505n 1.7v 369.495n 1.7v 369.505n 1.7v 379.495n 1.7v 379.505n 0.0v 389.495n 0.0v 389.505n 0.0v 399.495n 0.0v 399.505n 0.0v 409.495n 0.0v 409.505n 0.0v 419.495n 0.0v 419.505n 0.0v 429.495n 0.0v 429.505n 0.0v 439.495n 0.0v 439.505n 1.7v 449.495n 1.7v 449.505n 1.7v 459.495n 1.7v 459.505n 0.0v 469.495n 0.0v 469.505n 1.7v 479.495n 1.7v 479.505n 1.7v 489.495n 1.7v 489.505n 1.7v 499.495n 1.7v 499.505n 1.7v 509.495n 1.7v 509.505n 0.0v 519.495n 0.0v 519.505n 0.0v 529.495n 0.0v 529.505n 1.7v 539.495n 1.7v 539.505n 0.0v 549.495n 0.0v 549.505n 0.0v 559.495n 0.0v 559.505n 0.0v 569.495n 0.0v 569.505n 0.0v 579.495n 0.0v 579.505n 0.0v 589.495n 0.0v 589.505n 0.0v 599.495n 0.0v 599.505n 0.0v 609.495n 0.0v 609.505n 0.0v 619.495n 0.0v 619.505n 0.0v 629.495n 0.0v 629.505n 0.0v 639.495n 0.0v 639.505n 1.7v 649.495n 1.7v 649.505n 1.7v 659.495n 1.7v 659.505n 0.0v 669.495n 0.0v 669.505n 1.7v 679.495n 1.7v 679.505n 1.7v 689.495n 1.7v 689.505n 0.0v 699.495n 0.0v 699.505n 1.7v 709.495n 1.7v 709.505n 1.7v 719.495n 1.7v 719.505n 1.7v 729.495n 1.7v 729.505n 1.7v 739.495n 1.7v 739.505n 1.7v 749.495n 1.7v 749.505n 0.0v 759.495n 0.0v 759.505n 0.0v 769.495n 0.0v 769.505n 0.0v 779.495n 0.0v 779.505n 0.0v 789.495n 0.0v 789.505n 0.0v 799.495n 0.0v 799.505n 0.0v 809.495n 0.0v 809.505n 0.0v 819.495n 0.0v 819.505n 1.7v 829.495n 1.7v 829.505n 1.7v 839.495n 1.7v 839.505n 1.7v 849.495n 1.7v 849.505n 0.0v 859.495n 0.0v 859.505n 0.0v 869.495n 0.0v 869.505n 1.7v 879.495n 1.7v 879.505n 1.7v 889.495n 1.7v 889.505n 1.7v 899.495n 1.7v 899.505n 1.7v 909.495n 1.7v 909.505n 1.7v 919.495n 1.7v 919.505n 0.0v 929.495n 0.0v 929.505n 1.7v 939.495n 1.7v 939.505n 1.7v 949.495n 1.7v 949.505n 1.7v 959.495n 1.7v 959.505n 1.7v 969.495n 1.7v 969.505n 0.0v 979.495n 0.0v 979.505n 0.0v 989.495n 0.0v 989.505n 0.0v 999.495n 0.0v 999.505n 0.0v 1009.495n 0.0v 1009.505n 0.0v 1019.495n 0.0v 1019.505n 0.0v 1029.495n 0.0v 1029.505n 0.0v 1039.495n 0.0v 1039.505n 0.0v 1049.495n 0.0v 1049.505n 0.0v 1059.495n 0.0v 1059.505n 0.0v 1069.495n 0.0v 1069.505n 0.0v 1079.495n 0.0v 1079.505n 0.0v 1089.495n 0.0v 1089.505n 1.7v 1099.495n 1.7v 1099.505n 1.7v 1109.495n 1.7v 1109.505n 0.0v 1119.495n 0.0v 1119.505n 0.0v 1129.495n 0.0v 1129.505n 0.0v 1139.495n 0.0v 1139.505n 1.7v 1149.495n 1.7v 1149.505n 1.7v 1159.495n 1.7v 1159.505n 0.0v 1169.495n 0.0v 1169.505n 0.0v 1179.495n 0.0v 1179.505n 0.0v 1189.495n 0.0v 1189.505n 0.0v 1199.495n 0.0v 1199.505n 1.7v 1209.495n 1.7v 1209.505n 0.0v 1219.495n 0.0v 1219.505n 1.7v 1229.495n 1.7v 1229.505n 1.7v 1239.495n 1.7v 1239.505n 1.7v 1249.495n 1.7v 1249.505n 1.7v 1259.495n 1.7v 1259.505n 1.7v 1269.495n 1.7v 1269.505n 0.0v 1279.495n 0.0v 1279.505n 0.0v 1289.495n 0.0v 1289.505n 0.0v 1299.495n 0.0v 1299.505n 0.0v 1309.495n 0.0v 1309.505n 0.0v 1319.495n 0.0v 1319.505n 0.0v 1329.495n 0.0v 1329.505n 0.0v 1339.495n 0.0v 1339.505n 0.0v 1349.495n 0.0v 1349.505n 0.0v 1359.495n 0.0v 1359.505n 0.0v 1369.495n 0.0v 1369.505n 1.7v 1379.495n 1.7v 1379.505n 0.0v 1389.495n 0.0v 1389.505n 0.0v 1399.495n 0.0v 1399.505n 1.7v 1409.495n 1.7v 1409.505n 0.0v 1419.495n 0.0v 1419.505n 0.0v 1429.495n 0.0v 1429.505n 0.0v 1439.495n 0.0v 1439.505n 0.0v 1449.495n 0.0v 1449.505n 0.0v 1459.495n 0.0v 1459.505n 1.7v 1469.495n 1.7v 1469.505n 0.0v 1479.495n 0.0v 1479.505n 0.0v 1489.495n 0.0v 1489.505n 1.7v 1499.495n 1.7v 1499.505n 1.7v 1509.495n 1.7v 1509.505n 0.0v 1519.495n 0.0v 1519.505n 0.0v 1529.495n 0.0v 1529.505n 1.7v 1539.495n 1.7v 1539.505n 1.7v 1549.495n 1.7v 1549.505n 1.7v 1559.495n 1.7v 1559.505n 1.7v 1569.495n 1.7v 1569.505n 1.7v 1579.495n 1.7v 1579.505n 0.0v 1589.495n 0.0v 1589.505n 1.7v 1599.495n 1.7v 1599.505n 0.0v 1609.495n 0.0v 1609.505n 0.0v 1619.495n 0.0v 1619.505n 0.0v 1629.495n 0.0v 1629.505n 0.0v 1639.495n 0.0v 1639.505n 0.0v 1649.495n 0.0v 1649.505n 0.0v 1659.495n 0.0v 1659.505n 0.0v 1669.495n 0.0v 1669.505n 1.7v 1679.495n 1.7v 1679.505n 1.7v 1689.495n 1.7v 1689.505n 0.0v 1699.495n 0.0v 1699.505n 1.7v 1709.495n 1.7v 1709.505n 1.7v 1719.495n 1.7v 1719.505n 0.0v 1729.495n 0.0v 1729.505n 0.0v 1739.495n 0.0v 1739.505n 0.0v 1749.495n 0.0v 1749.505n 0.0v 1759.495n 0.0v 1759.505n 1.7v 1769.495n 1.7v 1769.505n 0.0v 1779.495n 0.0v 1779.505n 1.7v 1789.495n 1.7v 1789.505n 1.7v 1799.495n 1.7v 1799.505n 0.0v 1809.495n 0.0v 1809.505n 0.0v 1819.495n 0.0v 1819.505n 0.0v 1829.495n 0.0v 1829.505n 0.0v 1839.495n 0.0v 1839.505n 0.0v 1849.495n 0.0v 1849.505n 0.0v 1859.495n 0.0v 1859.505n 0.0v 1869.495n 0.0v 1869.505n 0.0v 1879.495n 0.0v 1879.505n 0.0v 1889.495n 0.0v 1889.505n 0.0v 1899.495n 0.0v 1899.505n 0.0v 1909.495n 0.0v 1909.505n 0.0v 1919.495n 0.0v 1919.505n 1.7v 1929.495n 1.7v 1929.505n 0.0v 1939.495n 0.0v 1939.505n 1.7v 1949.495n 1.7v 1949.505n 1.7v 1959.495n 1.7v 1959.505n 1.7v 1969.495n 1.7v 1969.505n 0.0v 1979.495n 0.0v 1979.505n 0.0v 1989.495n 0.0v 1989.505n 0.0v 1999.495n 0.0v 1999.505n 0.0v 2009.495n 0.0v 2009.505n 0.0v 2019.495n 0.0v 2019.505n 0.0v 2029.495n 0.0v 2029.505n 1.7v 2039.495n 1.7v 2039.505n 1.7v 2049.495n 1.7v 2049.505n 1.7v )
* (time, data): [(0, 0), (10, 1), (20, 0), (30, 0), (40, 0), (50, 0), (60, 0), (70, 0), (80, 1), (90, 1), (100, 1), (110, 1), (120, 1), (130, 0), (140, 0), (150, 0), (160, 0), (170, 0), (180, 1), (190, 1), (200, 1), (210, 0), (220, 0), (230, 0), (240, 0), (250, 0), (260, 0), (270, 1), (280, 1), (290, 1), (300, 0), (310, 1), (320, 1), (330, 0), (340, 0), (350, 0), (360, 0), (370, 0), (380, 0), (390, 0), (400, 0), (410, 0), (420, 0), (430, 0), (440, 1), (450, 1), (460, 1), (470, 1), (480, 1), (490, 1), (500, 1), (510, 1), (520, 0), (530, 0), (540, 0), (550, 0), (560, 0), (570, 0), (580, 0), (590, 1), (600, 1), (610, 1), (620, 1), (630, 0), (640, 0), (650, 0), (660, 0), (670, 1), (680, 1), (690, 0), (700, 1), (710, 1), (720, 1), (730, 1), (740, 1), (750, 1), (760, 1), (770, 0), (780, 0), (790, 1), (800, 1), (810, 0), (820, 1), (830, 1), (840, 1), (850, 0), (860, 0), (870, 0), (880, 0), (890, 0), (900, 0), (910, 0), (920, 1), (930, 0), (940, 0), (950, 1), (960, 1), (970, 0), (980, 1), (990, 1), (1000, 1), (1010, 1), (1020, 1), (1030, 1), (1040, 1), (1050, 1), (1060, 1), (1070, 1), (1080, 1), (1090, 0), (1100, 1), (1110, 1), (1120, 1), (1130, 1), (1140, 1), (1150, 1), (1160, 0), (1170, 0), (1180, 1), (1190, 1), (1200, 1), (1210, 1), (1220, 0), (1230, 1), (1240, 1), (1250, 1), (1260, 1), (1270, 0), (1280, 0), (1290, 0), (1300, 0), (1310, 0), (1320, 1), (1330, 1), (1340, 0), (1350, 1), (1360, 1), (1370, 0), (1380, 1), (1390, 1), (1400, 0), (1410, 0), (1420, 0), (1430, 0), (1440, 1), (1450, 1), (1460, 1), (1470, 0), (1480, 0), (1490, 0), (1500, 0), (1510, 1), (1520, 1), (1530, 0), (1540, 0), (1550, 0), (1560, 0), (1570, 0), (1580, 0), (1590, 0), (1600, 0), (1610, 0), (1620, 0), (1630, 0), (1640, 1), (1650, 1), (1660, 1), (1670, 0), (1680, 1), (1690, 0), (1700, 1), (1710, 0), (1720, 1), (1730, 1), (1740, 1), (1750, 1), (1760, 1), (1770, 1), (1780, 1), (1790, 1), (1800, 1), (1810, 0), (1820, 0), (1830, 0), (1840, 0), (1850, 0), (1860, 1), (1870, 1), (1880, 0), (1890, 0), (1900, 1), (1910, 0), (1920, 1), (1930, 0), (1940, 0), (1950, 0), (1960, 0), (1970, 0), (1980, 0), (1990, 0), (2000, 0), (2010, 0), (2020, 0), (2030, 0), (2040, 0), (2050, 0)]
Vdin0_20  din0_20  0 PWL (0n 0.0v 9.495n 0.0v 9.505n 1.7v 19.495n 1.7v 19.505n 0.0v 29.495n 0.0v 29.505n 0.0v 39.495n 0.0v 39.505n 0.0v 49.495n 0.0v 49.505n 0.0v 59.495n 0.0v 59.505n 0.0v 69.495n 0.0v 69.505n 0.0v 79.495n 0.0v 79.505n 1.7v 89.495n 1.7v 89.505n 1.7v 99.495n 1.7v 99.505n 1.7v 109.495n 1.7v 109.505n 1.7v 119.495n 1.7v 119.505n 1.7v 129.495n 1.7v 129.505n 0.0v 139.495n 0.0v 139.505n 0.0v 149.495n 0.0v 149.505n 0.0v 159.495n 0.0v 159.505n 0.0v 169.495n 0.0v 169.505n 0.0v 179.495n 0.0v 179.505n 1.7v 189.495n 1.7v 189.505n 1.7v 199.495n 1.7v 199.505n 1.7v 209.495n 1.7v 209.505n 0.0v 219.495n 0.0v 219.505n 0.0v 229.495n 0.0v 229.505n 0.0v 239.495n 0.0v 239.505n 0.0v 249.495n 0.0v 249.505n 0.0v 259.495n 0.0v 259.505n 0.0v 269.495n 0.0v 269.505n 1.7v 279.495n 1.7v 279.505n 1.7v 289.495n 1.7v 289.505n 1.7v 299.495n 1.7v 299.505n 0.0v 309.495n 0.0v 309.505n 1.7v 319.495n 1.7v 319.505n 1.7v 329.495n 1.7v 329.505n 0.0v 339.495n 0.0v 339.505n 0.0v 349.495n 0.0v 349.505n 0.0v 359.495n 0.0v 359.505n 0.0v 369.495n 0.0v 369.505n 0.0v 379.495n 0.0v 379.505n 0.0v 389.495n 0.0v 389.505n 0.0v 399.495n 0.0v 399.505n 0.0v 409.495n 0.0v 409.505n 0.0v 419.495n 0.0v 419.505n 0.0v 429.495n 0.0v 429.505n 0.0v 439.495n 0.0v 439.505n 1.7v 449.495n 1.7v 449.505n 1.7v 459.495n 1.7v 459.505n 1.7v 469.495n 1.7v 469.505n 1.7v 479.495n 1.7v 479.505n 1.7v 489.495n 1.7v 489.505n 1.7v 499.495n 1.7v 499.505n 1.7v 509.495n 1.7v 509.505n 1.7v 519.495n 1.7v 519.505n 0.0v 529.495n 0.0v 529.505n 0.0v 539.495n 0.0v 539.505n 0.0v 549.495n 0.0v 549.505n 0.0v 559.495n 0.0v 559.505n 0.0v 569.495n 0.0v 569.505n 0.0v 579.495n 0.0v 579.505n 0.0v 589.495n 0.0v 589.505n 1.7v 599.495n 1.7v 599.505n 1.7v 609.495n 1.7v 609.505n 1.7v 619.495n 1.7v 619.505n 1.7v 629.495n 1.7v 629.505n 0.0v 639.495n 0.0v 639.505n 0.0v 649.495n 0.0v 649.505n 0.0v 659.495n 0.0v 659.505n 0.0v 669.495n 0.0v 669.505n 1.7v 679.495n 1.7v 679.505n 1.7v 689.495n 1.7v 689.505n 0.0v 699.495n 0.0v 699.505n 1.7v 709.495n 1.7v 709.505n 1.7v 719.495n 1.7v 719.505n 1.7v 729.495n 1.7v 729.505n 1.7v 739.495n 1.7v 739.505n 1.7v 749.495n 1.7v 749.505n 1.7v 759.495n 1.7v 759.505n 1.7v 769.495n 1.7v 769.505n 0.0v 779.495n 0.0v 779.505n 0.0v 789.495n 0.0v 789.505n 1.7v 799.495n 1.7v 799.505n 1.7v 809.495n 1.7v 809.505n 0.0v 819.495n 0.0v 819.505n 1.7v 829.495n 1.7v 829.505n 1.7v 839.495n 1.7v 839.505n 1.7v 849.495n 1.7v 849.505n 0.0v 859.495n 0.0v 859.505n 0.0v 869.495n 0.0v 869.505n 0.0v 879.495n 0.0v 879.505n 0.0v 889.495n 0.0v 889.505n 0.0v 899.495n 0.0v 899.505n 0.0v 909.495n 0.0v 909.505n 0.0v 919.495n 0.0v 919.505n 1.7v 929.495n 1.7v 929.505n 0.0v 939.495n 0.0v 939.505n 0.0v 949.495n 0.0v 949.505n 1.7v 959.495n 1.7v 959.505n 1.7v 969.495n 1.7v 969.505n 0.0v 979.495n 0.0v 979.505n 1.7v 989.495n 1.7v 989.505n 1.7v 999.495n 1.7v 999.505n 1.7v 1009.495n 1.7v 1009.505n 1.7v 1019.495n 1.7v 1019.505n 1.7v 1029.495n 1.7v 1029.505n 1.7v 1039.495n 1.7v 1039.505n 1.7v 1049.495n 1.7v 1049.505n 1.7v 1059.495n 1.7v 1059.505n 1.7v 1069.495n 1.7v 1069.505n 1.7v 1079.495n 1.7v 1079.505n 1.7v 1089.495n 1.7v 1089.505n 0.0v 1099.495n 0.0v 1099.505n 1.7v 1109.495n 1.7v 1109.505n 1.7v 1119.495n 1.7v 1119.505n 1.7v 1129.495n 1.7v 1129.505n 1.7v 1139.495n 1.7v 1139.505n 1.7v 1149.495n 1.7v 1149.505n 1.7v 1159.495n 1.7v 1159.505n 0.0v 1169.495n 0.0v 1169.505n 0.0v 1179.495n 0.0v 1179.505n 1.7v 1189.495n 1.7v 1189.505n 1.7v 1199.495n 1.7v 1199.505n 1.7v 1209.495n 1.7v 1209.505n 1.7v 1219.495n 1.7v 1219.505n 0.0v 1229.495n 0.0v 1229.505n 1.7v 1239.495n 1.7v 1239.505n 1.7v 1249.495n 1.7v 1249.505n 1.7v 1259.495n 1.7v 1259.505n 1.7v 1269.495n 1.7v 1269.505n 0.0v 1279.495n 0.0v 1279.505n 0.0v 1289.495n 0.0v 1289.505n 0.0v 1299.495n 0.0v 1299.505n 0.0v 1309.495n 0.0v 1309.505n 0.0v 1319.495n 0.0v 1319.505n 1.7v 1329.495n 1.7v 1329.505n 1.7v 1339.495n 1.7v 1339.505n 0.0v 1349.495n 0.0v 1349.505n 1.7v 1359.495n 1.7v 1359.505n 1.7v 1369.495n 1.7v 1369.505n 0.0v 1379.495n 0.0v 1379.505n 1.7v 1389.495n 1.7v 1389.505n 1.7v 1399.495n 1.7v 1399.505n 0.0v 1409.495n 0.0v 1409.505n 0.0v 1419.495n 0.0v 1419.505n 0.0v 1429.495n 0.0v 1429.505n 0.0v 1439.495n 0.0v 1439.505n 1.7v 1449.495n 1.7v 1449.505n 1.7v 1459.495n 1.7v 1459.505n 1.7v 1469.495n 1.7v 1469.505n 0.0v 1479.495n 0.0v 1479.505n 0.0v 1489.495n 0.0v 1489.505n 0.0v 1499.495n 0.0v 1499.505n 0.0v 1509.495n 0.0v 1509.505n 1.7v 1519.495n 1.7v 1519.505n 1.7v 1529.495n 1.7v 1529.505n 0.0v 1539.495n 0.0v 1539.505n 0.0v 1549.495n 0.0v 1549.505n 0.0v 1559.495n 0.0v 1559.505n 0.0v 1569.495n 0.0v 1569.505n 0.0v 1579.495n 0.0v 1579.505n 0.0v 1589.495n 0.0v 1589.505n 0.0v 1599.495n 0.0v 1599.505n 0.0v 1609.495n 0.0v 1609.505n 0.0v 1619.495n 0.0v 1619.505n 0.0v 1629.495n 0.0v 1629.505n 0.0v 1639.495n 0.0v 1639.505n 1.7v 1649.495n 1.7v 1649.505n 1.7v 1659.495n 1.7v 1659.505n 1.7v 1669.495n 1.7v 1669.505n 0.0v 1679.495n 0.0v 1679.505n 1.7v 1689.495n 1.7v 1689.505n 0.0v 1699.495n 0.0v 1699.505n 1.7v 1709.495n 1.7v 1709.505n 0.0v 1719.495n 0.0v 1719.505n 1.7v 1729.495n 1.7v 1729.505n 1.7v 1739.495n 1.7v 1739.505n 1.7v 1749.495n 1.7v 1749.505n 1.7v 1759.495n 1.7v 1759.505n 1.7v 1769.495n 1.7v 1769.505n 1.7v 1779.495n 1.7v 1779.505n 1.7v 1789.495n 1.7v 1789.505n 1.7v 1799.495n 1.7v 1799.505n 1.7v 1809.495n 1.7v 1809.505n 0.0v 1819.495n 0.0v 1819.505n 0.0v 1829.495n 0.0v 1829.505n 0.0v 1839.495n 0.0v 1839.505n 0.0v 1849.495n 0.0v 1849.505n 0.0v 1859.495n 0.0v 1859.505n 1.7v 1869.495n 1.7v 1869.505n 1.7v 1879.495n 1.7v 1879.505n 0.0v 1889.495n 0.0v 1889.505n 0.0v 1899.495n 0.0v 1899.505n 1.7v 1909.495n 1.7v 1909.505n 0.0v 1919.495n 0.0v 1919.505n 1.7v 1929.495n 1.7v 1929.505n 0.0v 1939.495n 0.0v 1939.505n 0.0v 1949.495n 0.0v 1949.505n 0.0v 1959.495n 0.0v 1959.505n 0.0v 1969.495n 0.0v 1969.505n 0.0v 1979.495n 0.0v 1979.505n 0.0v 1989.495n 0.0v 1989.505n 0.0v 1999.495n 0.0v 1999.505n 0.0v 2009.495n 0.0v 2009.505n 0.0v 2019.495n 0.0v 2019.505n 0.0v 2029.495n 0.0v 2029.505n 0.0v 2039.495n 0.0v 2039.505n 0.0v 2049.495n 0.0v 2049.505n 0.0v )
* (time, data): [(0, 0), (10, 1), (20, 1), (30, 0), (40, 0), (50, 0), (60, 0), (70, 1), (80, 1), (90, 1), (100, 1), (110, 1), (120, 1), (130, 1), (140, 1), (150, 1), (160, 1), (170, 1), (180, 0), (190, 0), (200, 0), (210, 0), (220, 0), (230, 0), (240, 1), (250, 1), (260, 1), (270, 1), (280, 1), (290, 1), (300, 0), (310, 0), (320, 0), (330, 0), (340, 0), (350, 0), (360, 0), (370, 0), (380, 1), (390, 1), (400, 1), (410, 1), (420, 1), (430, 1), (440, 1), (450, 1), (460, 0), (470, 0), (480, 0), (490, 0), (500, 0), (510, 1), (520, 0), (530, 0), (540, 1), (550, 0), (560, 0), (570, 0), (580, 0), (590, 0), (600, 0), (610, 0), (620, 0), (630, 1), (640, 1), (650, 1), (660, 1), (670, 0), (680, 0), (690, 1), (700, 0), (710, 0), (720, 1), (730, 1), (740, 1), (750, 0), (760, 0), (770, 1), (780, 1), (790, 1), (800, 1), (810, 1), (820, 1), (830, 1), (840, 1), (850, 0), (860, 0), (870, 0), (880, 0), (890, 0), (900, 0), (910, 0), (920, 1), (930, 0), (940, 1), (950, 0), (960, 0), (970, 1), (980, 0), (990, 0), (1000, 0), (1010, 0), (1020, 0), (1030, 0), (1040, 0), (1050, 0), (1060, 0), (1070, 0), (1080, 0), (1090, 0), (1100, 1), (1110, 0), (1120, 0), (1130, 0), (1140, 0), (1150, 1), (1160, 0), (1170, 1), (1180, 1), (1190, 1), (1200, 1), (1210, 1), (1220, 1), (1230, 0), (1240, 0), (1250, 0), (1260, 0), (1270, 1), (1280, 1), (1290, 0), (1300, 0), (1310, 0), (1320, 0), (1330, 0), (1340, 0), (1350, 0), (1360, 0), (1370, 1), (1380, 1), (1390, 1), (1400, 1), (1410, 1), (1420, 1), (1430, 1), (1440, 1), (1450, 1), (1460, 0), (1470, 0), (1480, 0), (1490, 0), (1500, 0), (1510, 1), (1520, 1), (1530, 0), (1540, 1), (1550, 0), (1560, 0), (1570, 1), (1580, 1), (1590, 0), (1600, 0), (1610, 0), (1620, 0), (1630, 0), (1640, 0), (1650, 0), (1660, 0), (1670, 0), (1680, 1), (1690, 0), (1700, 1), (1710, 0), (1720, 0), (1730, 0), (1740, 1), (1750, 1), (1760, 0), (1770, 1), (1780, 0), (1790, 0), (1800, 0), (1810, 0), (1820, 1), (1830, 0), (1840, 0), (1850, 0), (1860, 1), (1870, 1), (1880, 1), (1890, 1), (1900, 0), (1910, 1), (1920, 0), (1930, 1), (1940, 1), (1950, 0), (1960, 0), (1970, 0), (1980, 0), (1990, 1), (2000, 1), (2010, 1), (2020, 0), (2030, 0), (2040, 0), (2050, 0)]
Vdin0_21  din0_21  0 PWL (0n 0.0v 9.495n 0.0v 9.505n 1.7v 19.495n 1.7v 19.505n 1.7v 29.495n 1.7v 29.505n 0.0v 39.495n 0.0v 39.505n 0.0v 49.495n 0.0v 49.505n 0.0v 59.495n 0.0v 59.505n 0.0v 69.495n 0.0v 69.505n 1.7v 79.495n 1.7v 79.505n 1.7v 89.495n 1.7v 89.505n 1.7v 99.495n 1.7v 99.505n 1.7v 109.495n 1.7v 109.505n 1.7v 119.495n 1.7v 119.505n 1.7v 129.495n 1.7v 129.505n 1.7v 139.495n 1.7v 139.505n 1.7v 149.495n 1.7v 149.505n 1.7v 159.495n 1.7v 159.505n 1.7v 169.495n 1.7v 169.505n 1.7v 179.495n 1.7v 179.505n 0.0v 189.495n 0.0v 189.505n 0.0v 199.495n 0.0v 199.505n 0.0v 209.495n 0.0v 209.505n 0.0v 219.495n 0.0v 219.505n 0.0v 229.495n 0.0v 229.505n 0.0v 239.495n 0.0v 239.505n 1.7v 249.495n 1.7v 249.505n 1.7v 259.495n 1.7v 259.505n 1.7v 269.495n 1.7v 269.505n 1.7v 279.495n 1.7v 279.505n 1.7v 289.495n 1.7v 289.505n 1.7v 299.495n 1.7v 299.505n 0.0v 309.495n 0.0v 309.505n 0.0v 319.495n 0.0v 319.505n 0.0v 329.495n 0.0v 329.505n 0.0v 339.495n 0.0v 339.505n 0.0v 349.495n 0.0v 349.505n 0.0v 359.495n 0.0v 359.505n 0.0v 369.495n 0.0v 369.505n 0.0v 379.495n 0.0v 379.505n 1.7v 389.495n 1.7v 389.505n 1.7v 399.495n 1.7v 399.505n 1.7v 409.495n 1.7v 409.505n 1.7v 419.495n 1.7v 419.505n 1.7v 429.495n 1.7v 429.505n 1.7v 439.495n 1.7v 439.505n 1.7v 449.495n 1.7v 449.505n 1.7v 459.495n 1.7v 459.505n 0.0v 469.495n 0.0v 469.505n 0.0v 479.495n 0.0v 479.505n 0.0v 489.495n 0.0v 489.505n 0.0v 499.495n 0.0v 499.505n 0.0v 509.495n 0.0v 509.505n 1.7v 519.495n 1.7v 519.505n 0.0v 529.495n 0.0v 529.505n 0.0v 539.495n 0.0v 539.505n 1.7v 549.495n 1.7v 549.505n 0.0v 559.495n 0.0v 559.505n 0.0v 569.495n 0.0v 569.505n 0.0v 579.495n 0.0v 579.505n 0.0v 589.495n 0.0v 589.505n 0.0v 599.495n 0.0v 599.505n 0.0v 609.495n 0.0v 609.505n 0.0v 619.495n 0.0v 619.505n 0.0v 629.495n 0.0v 629.505n 1.7v 639.495n 1.7v 639.505n 1.7v 649.495n 1.7v 649.505n 1.7v 659.495n 1.7v 659.505n 1.7v 669.495n 1.7v 669.505n 0.0v 679.495n 0.0v 679.505n 0.0v 689.495n 0.0v 689.505n 1.7v 699.495n 1.7v 699.505n 0.0v 709.495n 0.0v 709.505n 0.0v 719.495n 0.0v 719.505n 1.7v 729.495n 1.7v 729.505n 1.7v 739.495n 1.7v 739.505n 1.7v 749.495n 1.7v 749.505n 0.0v 759.495n 0.0v 759.505n 0.0v 769.495n 0.0v 769.505n 1.7v 779.495n 1.7v 779.505n 1.7v 789.495n 1.7v 789.505n 1.7v 799.495n 1.7v 799.505n 1.7v 809.495n 1.7v 809.505n 1.7v 819.495n 1.7v 819.505n 1.7v 829.495n 1.7v 829.505n 1.7v 839.495n 1.7v 839.505n 1.7v 849.495n 1.7v 849.505n 0.0v 859.495n 0.0v 859.505n 0.0v 869.495n 0.0v 869.505n 0.0v 879.495n 0.0v 879.505n 0.0v 889.495n 0.0v 889.505n 0.0v 899.495n 0.0v 899.505n 0.0v 909.495n 0.0v 909.505n 0.0v 919.495n 0.0v 919.505n 1.7v 929.495n 1.7v 929.505n 0.0v 939.495n 0.0v 939.505n 1.7v 949.495n 1.7v 949.505n 0.0v 959.495n 0.0v 959.505n 0.0v 969.495n 0.0v 969.505n 1.7v 979.495n 1.7v 979.505n 0.0v 989.495n 0.0v 989.505n 0.0v 999.495n 0.0v 999.505n 0.0v 1009.495n 0.0v 1009.505n 0.0v 1019.495n 0.0v 1019.505n 0.0v 1029.495n 0.0v 1029.505n 0.0v 1039.495n 0.0v 1039.505n 0.0v 1049.495n 0.0v 1049.505n 0.0v 1059.495n 0.0v 1059.505n 0.0v 1069.495n 0.0v 1069.505n 0.0v 1079.495n 0.0v 1079.505n 0.0v 1089.495n 0.0v 1089.505n 0.0v 1099.495n 0.0v 1099.505n 1.7v 1109.495n 1.7v 1109.505n 0.0v 1119.495n 0.0v 1119.505n 0.0v 1129.495n 0.0v 1129.505n 0.0v 1139.495n 0.0v 1139.505n 0.0v 1149.495n 0.0v 1149.505n 1.7v 1159.495n 1.7v 1159.505n 0.0v 1169.495n 0.0v 1169.505n 1.7v 1179.495n 1.7v 1179.505n 1.7v 1189.495n 1.7v 1189.505n 1.7v 1199.495n 1.7v 1199.505n 1.7v 1209.495n 1.7v 1209.505n 1.7v 1219.495n 1.7v 1219.505n 1.7v 1229.495n 1.7v 1229.505n 0.0v 1239.495n 0.0v 1239.505n 0.0v 1249.495n 0.0v 1249.505n 0.0v 1259.495n 0.0v 1259.505n 0.0v 1269.495n 0.0v 1269.505n 1.7v 1279.495n 1.7v 1279.505n 1.7v 1289.495n 1.7v 1289.505n 0.0v 1299.495n 0.0v 1299.505n 0.0v 1309.495n 0.0v 1309.505n 0.0v 1319.495n 0.0v 1319.505n 0.0v 1329.495n 0.0v 1329.505n 0.0v 1339.495n 0.0v 1339.505n 0.0v 1349.495n 0.0v 1349.505n 0.0v 1359.495n 0.0v 1359.505n 0.0v 1369.495n 0.0v 1369.505n 1.7v 1379.495n 1.7v 1379.505n 1.7v 1389.495n 1.7v 1389.505n 1.7v 1399.495n 1.7v 1399.505n 1.7v 1409.495n 1.7v 1409.505n 1.7v 1419.495n 1.7v 1419.505n 1.7v 1429.495n 1.7v 1429.505n 1.7v 1439.495n 1.7v 1439.505n 1.7v 1449.495n 1.7v 1449.505n 1.7v 1459.495n 1.7v 1459.505n 0.0v 1469.495n 0.0v 1469.505n 0.0v 1479.495n 0.0v 1479.505n 0.0v 1489.495n 0.0v 1489.505n 0.0v 1499.495n 0.0v 1499.505n 0.0v 1509.495n 0.0v 1509.505n 1.7v 1519.495n 1.7v 1519.505n 1.7v 1529.495n 1.7v 1529.505n 0.0v 1539.495n 0.0v 1539.505n 1.7v 1549.495n 1.7v 1549.505n 0.0v 1559.495n 0.0v 1559.505n 0.0v 1569.495n 0.0v 1569.505n 1.7v 1579.495n 1.7v 1579.505n 1.7v 1589.495n 1.7v 1589.505n 0.0v 1599.495n 0.0v 1599.505n 0.0v 1609.495n 0.0v 1609.505n 0.0v 1619.495n 0.0v 1619.505n 0.0v 1629.495n 0.0v 1629.505n 0.0v 1639.495n 0.0v 1639.505n 0.0v 1649.495n 0.0v 1649.505n 0.0v 1659.495n 0.0v 1659.505n 0.0v 1669.495n 0.0v 1669.505n 0.0v 1679.495n 0.0v 1679.505n 1.7v 1689.495n 1.7v 1689.505n 0.0v 1699.495n 0.0v 1699.505n 1.7v 1709.495n 1.7v 1709.505n 0.0v 1719.495n 0.0v 1719.505n 0.0v 1729.495n 0.0v 1729.505n 0.0v 1739.495n 0.0v 1739.505n 1.7v 1749.495n 1.7v 1749.505n 1.7v 1759.495n 1.7v 1759.505n 0.0v 1769.495n 0.0v 1769.505n 1.7v 1779.495n 1.7v 1779.505n 0.0v 1789.495n 0.0v 1789.505n 0.0v 1799.495n 0.0v 1799.505n 0.0v 1809.495n 0.0v 1809.505n 0.0v 1819.495n 0.0v 1819.505n 1.7v 1829.495n 1.7v 1829.505n 0.0v 1839.495n 0.0v 1839.505n 0.0v 1849.495n 0.0v 1849.505n 0.0v 1859.495n 0.0v 1859.505n 1.7v 1869.495n 1.7v 1869.505n 1.7v 1879.495n 1.7v 1879.505n 1.7v 1889.495n 1.7v 1889.505n 1.7v 1899.495n 1.7v 1899.505n 0.0v 1909.495n 0.0v 1909.505n 1.7v 1919.495n 1.7v 1919.505n 0.0v 1929.495n 0.0v 1929.505n 1.7v 1939.495n 1.7v 1939.505n 1.7v 1949.495n 1.7v 1949.505n 0.0v 1959.495n 0.0v 1959.505n 0.0v 1969.495n 0.0v 1969.505n 0.0v 1979.495n 0.0v 1979.505n 0.0v 1989.495n 0.0v 1989.505n 1.7v 1999.495n 1.7v 1999.505n 1.7v 2009.495n 1.7v 2009.505n 1.7v 2019.495n 1.7v 2019.505n 0.0v 2029.495n 0.0v 2029.505n 0.0v 2039.495n 0.0v 2039.505n 0.0v 2049.495n 0.0v 2049.505n 0.0v )
* (time, data): [(0, 0), (10, 1), (20, 1), (30, 1), (40, 1), (50, 0), (60, 1), (70, 1), (80, 1), (90, 1), (100, 1), (110, 1), (120, 0), (130, 0), (140, 0), (150, 0), (160, 0), (170, 0), (180, 1), (190, 1), (200, 1), (210, 1), (220, 1), (230, 1), (240, 0), (250, 0), (260, 0), (270, 0), (280, 0), (290, 0), (300, 1), (310, 1), (320, 0), (330, 0), (340, 0), (350, 0), (360, 0), (370, 0), (380, 1), (390, 1), (400, 1), (410, 1), (420, 1), (430, 0), (440, 0), (450, 0), (460, 0), (470, 1), (480, 1), (490, 1), (500, 1), (510, 1), (520, 1), (530, 1), (540, 1), (550, 0), (560, 0), (570, 0), (580, 0), (590, 0), (600, 0), (610, 0), (620, 0), (630, 1), (640, 1), (650, 1), (660, 1), (670, 0), (680, 0), (690, 1), (700, 1), (710, 0), (720, 0), (730, 0), (740, 1), (750, 0), (760, 1), (770, 1), (780, 1), (790, 0), (800, 0), (810, 1), (820, 0), (830, 0), (840, 0), (850, 0), (860, 1), (870, 1), (880, 1), (890, 1), (900, 1), (910, 1), (920, 0), (930, 1), (940, 1), (950, 1), (960, 1), (970, 1), (980, 0), (990, 0), (1000, 0), (1010, 0), (1020, 0), (1030, 0), (1040, 0), (1050, 0), (1060, 0), (1070, 0), (1080, 0), (1090, 0), (1100, 1), (1110, 0), (1120, 0), (1130, 0), (1140, 0), (1150, 0), (1160, 0), (1170, 0), (1180, 1), (1190, 1), (1200, 1), (1210, 0), (1220, 1), (1230, 0), (1240, 1), (1250, 1), (1260, 1), (1270, 1), (1280, 1), (1290, 1), (1300, 1), (1310, 1), (1320, 0), (1330, 0), (1340, 1), (1350, 1), (1360, 1), (1370, 1), (1380, 0), (1390, 0), (1400, 1), (1410, 1), (1420, 1), (1430, 1), (1440, 0), (1450, 0), (1460, 1), (1470, 0), (1480, 0), (1490, 0), (1500, 0), (1510, 1), (1520, 1), (1530, 1), (1540, 1), (1550, 0), (1560, 0), (1570, 1), (1580, 1), (1590, 0), (1600, 1), (1610, 1), (1620, 1), (1630, 1), (1640, 0), (1650, 0), (1660, 0), (1670, 0), (1680, 0), (1690, 0), (1700, 1), (1710, 1), (1720, 0), (1730, 0), (1740, 0), (1750, 0), (1760, 1), (1770, 0), (1780, 0), (1790, 0), (1800, 0), (1810, 1), (1820, 0), (1830, 1), (1840, 1), (1850, 1), (1860, 1), (1870, 1), (1880, 0), (1890, 0), (1900, 0), (1910, 1), (1920, 1), (1930, 1), (1940, 1), (1950, 0), (1960, 0), (1970, 1), (1980, 1), (1990, 1), (2000, 1), (2010, 1), (2020, 1), (2030, 1), (2040, 1), (2050, 1)]
Vdin0_22  din0_22  0 PWL (0n 0.0v 9.495n 0.0v 9.505n 1.7v 19.495n 1.7v 19.505n 1.7v 29.495n 1.7v 29.505n 1.7v 39.495n 1.7v 39.505n 1.7v 49.495n 1.7v 49.505n 0.0v 59.495n 0.0v 59.505n 1.7v 69.495n 1.7v 69.505n 1.7v 79.495n 1.7v 79.505n 1.7v 89.495n 1.7v 89.505n 1.7v 99.495n 1.7v 99.505n 1.7v 109.495n 1.7v 109.505n 1.7v 119.495n 1.7v 119.505n 0.0v 129.495n 0.0v 129.505n 0.0v 139.495n 0.0v 139.505n 0.0v 149.495n 0.0v 149.505n 0.0v 159.495n 0.0v 159.505n 0.0v 169.495n 0.0v 169.505n 0.0v 179.495n 0.0v 179.505n 1.7v 189.495n 1.7v 189.505n 1.7v 199.495n 1.7v 199.505n 1.7v 209.495n 1.7v 209.505n 1.7v 219.495n 1.7v 219.505n 1.7v 229.495n 1.7v 229.505n 1.7v 239.495n 1.7v 239.505n 0.0v 249.495n 0.0v 249.505n 0.0v 259.495n 0.0v 259.505n 0.0v 269.495n 0.0v 269.505n 0.0v 279.495n 0.0v 279.505n 0.0v 289.495n 0.0v 289.505n 0.0v 299.495n 0.0v 299.505n 1.7v 309.495n 1.7v 309.505n 1.7v 319.495n 1.7v 319.505n 0.0v 329.495n 0.0v 329.505n 0.0v 339.495n 0.0v 339.505n 0.0v 349.495n 0.0v 349.505n 0.0v 359.495n 0.0v 359.505n 0.0v 369.495n 0.0v 369.505n 0.0v 379.495n 0.0v 379.505n 1.7v 389.495n 1.7v 389.505n 1.7v 399.495n 1.7v 399.505n 1.7v 409.495n 1.7v 409.505n 1.7v 419.495n 1.7v 419.505n 1.7v 429.495n 1.7v 429.505n 0.0v 439.495n 0.0v 439.505n 0.0v 449.495n 0.0v 449.505n 0.0v 459.495n 0.0v 459.505n 0.0v 469.495n 0.0v 469.505n 1.7v 479.495n 1.7v 479.505n 1.7v 489.495n 1.7v 489.505n 1.7v 499.495n 1.7v 499.505n 1.7v 509.495n 1.7v 509.505n 1.7v 519.495n 1.7v 519.505n 1.7v 529.495n 1.7v 529.505n 1.7v 539.495n 1.7v 539.505n 1.7v 549.495n 1.7v 549.505n 0.0v 559.495n 0.0v 559.505n 0.0v 569.495n 0.0v 569.505n 0.0v 579.495n 0.0v 579.505n 0.0v 589.495n 0.0v 589.505n 0.0v 599.495n 0.0v 599.505n 0.0v 609.495n 0.0v 609.505n 0.0v 619.495n 0.0v 619.505n 0.0v 629.495n 0.0v 629.505n 1.7v 639.495n 1.7v 639.505n 1.7v 649.495n 1.7v 649.505n 1.7v 659.495n 1.7v 659.505n 1.7v 669.495n 1.7v 669.505n 0.0v 679.495n 0.0v 679.505n 0.0v 689.495n 0.0v 689.505n 1.7v 699.495n 1.7v 699.505n 1.7v 709.495n 1.7v 709.505n 0.0v 719.495n 0.0v 719.505n 0.0v 729.495n 0.0v 729.505n 0.0v 739.495n 0.0v 739.505n 1.7v 749.495n 1.7v 749.505n 0.0v 759.495n 0.0v 759.505n 1.7v 769.495n 1.7v 769.505n 1.7v 779.495n 1.7v 779.505n 1.7v 789.495n 1.7v 789.505n 0.0v 799.495n 0.0v 799.505n 0.0v 809.495n 0.0v 809.505n 1.7v 819.495n 1.7v 819.505n 0.0v 829.495n 0.0v 829.505n 0.0v 839.495n 0.0v 839.505n 0.0v 849.495n 0.0v 849.505n 0.0v 859.495n 0.0v 859.505n 1.7v 869.495n 1.7v 869.505n 1.7v 879.495n 1.7v 879.505n 1.7v 889.495n 1.7v 889.505n 1.7v 899.495n 1.7v 899.505n 1.7v 909.495n 1.7v 909.505n 1.7v 919.495n 1.7v 919.505n 0.0v 929.495n 0.0v 929.505n 1.7v 939.495n 1.7v 939.505n 1.7v 949.495n 1.7v 949.505n 1.7v 959.495n 1.7v 959.505n 1.7v 969.495n 1.7v 969.505n 1.7v 979.495n 1.7v 979.505n 0.0v 989.495n 0.0v 989.505n 0.0v 999.495n 0.0v 999.505n 0.0v 1009.495n 0.0v 1009.505n 0.0v 1019.495n 0.0v 1019.505n 0.0v 1029.495n 0.0v 1029.505n 0.0v 1039.495n 0.0v 1039.505n 0.0v 1049.495n 0.0v 1049.505n 0.0v 1059.495n 0.0v 1059.505n 0.0v 1069.495n 0.0v 1069.505n 0.0v 1079.495n 0.0v 1079.505n 0.0v 1089.495n 0.0v 1089.505n 0.0v 1099.495n 0.0v 1099.505n 1.7v 1109.495n 1.7v 1109.505n 0.0v 1119.495n 0.0v 1119.505n 0.0v 1129.495n 0.0v 1129.505n 0.0v 1139.495n 0.0v 1139.505n 0.0v 1149.495n 0.0v 1149.505n 0.0v 1159.495n 0.0v 1159.505n 0.0v 1169.495n 0.0v 1169.505n 0.0v 1179.495n 0.0v 1179.505n 1.7v 1189.495n 1.7v 1189.505n 1.7v 1199.495n 1.7v 1199.505n 1.7v 1209.495n 1.7v 1209.505n 0.0v 1219.495n 0.0v 1219.505n 1.7v 1229.495n 1.7v 1229.505n 0.0v 1239.495n 0.0v 1239.505n 1.7v 1249.495n 1.7v 1249.505n 1.7v 1259.495n 1.7v 1259.505n 1.7v 1269.495n 1.7v 1269.505n 1.7v 1279.495n 1.7v 1279.505n 1.7v 1289.495n 1.7v 1289.505n 1.7v 1299.495n 1.7v 1299.505n 1.7v 1309.495n 1.7v 1309.505n 1.7v 1319.495n 1.7v 1319.505n 0.0v 1329.495n 0.0v 1329.505n 0.0v 1339.495n 0.0v 1339.505n 1.7v 1349.495n 1.7v 1349.505n 1.7v 1359.495n 1.7v 1359.505n 1.7v 1369.495n 1.7v 1369.505n 1.7v 1379.495n 1.7v 1379.505n 0.0v 1389.495n 0.0v 1389.505n 0.0v 1399.495n 0.0v 1399.505n 1.7v 1409.495n 1.7v 1409.505n 1.7v 1419.495n 1.7v 1419.505n 1.7v 1429.495n 1.7v 1429.505n 1.7v 1439.495n 1.7v 1439.505n 0.0v 1449.495n 0.0v 1449.505n 0.0v 1459.495n 0.0v 1459.505n 1.7v 1469.495n 1.7v 1469.505n 0.0v 1479.495n 0.0v 1479.505n 0.0v 1489.495n 0.0v 1489.505n 0.0v 1499.495n 0.0v 1499.505n 0.0v 1509.495n 0.0v 1509.505n 1.7v 1519.495n 1.7v 1519.505n 1.7v 1529.495n 1.7v 1529.505n 1.7v 1539.495n 1.7v 1539.505n 1.7v 1549.495n 1.7v 1549.505n 0.0v 1559.495n 0.0v 1559.505n 0.0v 1569.495n 0.0v 1569.505n 1.7v 1579.495n 1.7v 1579.505n 1.7v 1589.495n 1.7v 1589.505n 0.0v 1599.495n 0.0v 1599.505n 1.7v 1609.495n 1.7v 1609.505n 1.7v 1619.495n 1.7v 1619.505n 1.7v 1629.495n 1.7v 1629.505n 1.7v 1639.495n 1.7v 1639.505n 0.0v 1649.495n 0.0v 1649.505n 0.0v 1659.495n 0.0v 1659.505n 0.0v 1669.495n 0.0v 1669.505n 0.0v 1679.495n 0.0v 1679.505n 0.0v 1689.495n 0.0v 1689.505n 0.0v 1699.495n 0.0v 1699.505n 1.7v 1709.495n 1.7v 1709.505n 1.7v 1719.495n 1.7v 1719.505n 0.0v 1729.495n 0.0v 1729.505n 0.0v 1739.495n 0.0v 1739.505n 0.0v 1749.495n 0.0v 1749.505n 0.0v 1759.495n 0.0v 1759.505n 1.7v 1769.495n 1.7v 1769.505n 0.0v 1779.495n 0.0v 1779.505n 0.0v 1789.495n 0.0v 1789.505n 0.0v 1799.495n 0.0v 1799.505n 0.0v 1809.495n 0.0v 1809.505n 1.7v 1819.495n 1.7v 1819.505n 0.0v 1829.495n 0.0v 1829.505n 1.7v 1839.495n 1.7v 1839.505n 1.7v 1849.495n 1.7v 1849.505n 1.7v 1859.495n 1.7v 1859.505n 1.7v 1869.495n 1.7v 1869.505n 1.7v 1879.495n 1.7v 1879.505n 0.0v 1889.495n 0.0v 1889.505n 0.0v 1899.495n 0.0v 1899.505n 0.0v 1909.495n 0.0v 1909.505n 1.7v 1919.495n 1.7v 1919.505n 1.7v 1929.495n 1.7v 1929.505n 1.7v 1939.495n 1.7v 1939.505n 1.7v 1949.495n 1.7v 1949.505n 0.0v 1959.495n 0.0v 1959.505n 0.0v 1969.495n 0.0v 1969.505n 1.7v 1979.495n 1.7v 1979.505n 1.7v 1989.495n 1.7v 1989.505n 1.7v 1999.495n 1.7v 1999.505n 1.7v 2009.495n 1.7v 2009.505n 1.7v 2019.495n 1.7v 2019.505n 1.7v 2029.495n 1.7v 2029.505n 1.7v 2039.495n 1.7v 2039.505n 1.7v 2049.495n 1.7v 2049.505n 1.7v )
* (time, data): [(0, 0), (10, 1), (20, 1), (30, 0), (40, 0), (50, 0), (60, 1), (70, 1), (80, 1), (90, 1), (100, 1), (110, 1), (120, 0), (130, 0), (140, 1), (150, 1), (160, 1), (170, 1), (180, 0), (190, 0), (200, 0), (210, 1), (220, 1), (230, 1), (240, 0), (250, 0), (260, 0), (270, 1), (280, 1), (290, 1), (300, 0), (310, 0), (320, 0), (330, 0), (340, 0), (350, 0), (360, 0), (370, 0), (380, 1), (390, 1), (400, 1), (410, 1), (420, 1), (430, 1), (440, 0), (450, 0), (460, 0), (470, 1), (480, 1), (490, 1), (500, 1), (510, 0), (520, 1), (530, 0), (540, 1), (550, 0), (560, 0), (570, 0), (580, 0), (590, 1), (600, 1), (610, 1), (620, 1), (630, 0), (640, 1), (650, 1), (660, 1), (670, 1), (680, 1), (690, 1), (700, 0), (710, 0), (720, 1), (730, 1), (740, 1), (750, 1), (760, 0), (770, 1), (780, 1), (790, 1), (800, 1), (810, 0), (820, 1), (830, 1), (840, 1), (850, 1), (860, 0), (870, 0), (880, 0), (890, 0), (900, 0), (910, 0), (920, 1), (930, 0), (940, 1), (950, 1), (960, 1), (970, 1), (980, 0), (990, 0), (1000, 0), (1010, 0), (1020, 0), (1030, 0), (1040, 0), (1050, 0), (1060, 0), (1070, 0), (1080, 0), (1090, 1), (1100, 0), (1110, 0), (1120, 0), (1130, 0), (1140, 1), (1150, 1), (1160, 0), (1170, 1), (1180, 0), (1190, 0), (1200, 0), (1210, 1), (1220, 0), (1230, 0), (1240, 0), (1250, 0), (1260, 0), (1270, 0), (1280, 0), (1290, 0), (1300, 0), (1310, 0), (1320, 0), (1330, 0), (1340, 0), (1350, 1), (1360, 1), (1370, 0), (1380, 1), (1390, 1), (1400, 1), (1410, 1), (1420, 1), (1430, 1), (1440, 0), (1450, 1), (1460, 1), (1470, 0), (1480, 0), (1490, 1), (1500, 1), (1510, 1), (1520, 1), (1530, 0), (1540, 1), (1550, 1), (1560, 1), (1570, 1), (1580, 0), (1590, 0), (1600, 0), (1610, 0), (1620, 0), (1630, 0), (1640, 1), (1650, 1), (1660, 1), (1670, 0), (1680, 1), (1690, 0), (1700, 1), (1710, 0), (1720, 0), (1730, 0), (1740, 0), (1750, 0), (1760, 1), (1770, 0), (1780, 0), (1790, 1), (1800, 1), (1810, 1), (1820, 1), (1830, 0), (1840, 0), (1850, 0), (1860, 1), (1870, 1), (1880, 1), (1890, 1), (1900, 0), (1910, 0), (1920, 0), (1930, 0), (1940, 0), (1950, 1), (1960, 1), (1970, 0), (1980, 0), (1990, 1), (2000, 1), (2010, 1), (2020, 1), (2030, 1), (2040, 1), (2050, 1)]
Vdin0_23  din0_23  0 PWL (0n 0.0v 9.495n 0.0v 9.505n 1.7v 19.495n 1.7v 19.505n 1.7v 29.495n 1.7v 29.505n 0.0v 39.495n 0.0v 39.505n 0.0v 49.495n 0.0v 49.505n 0.0v 59.495n 0.0v 59.505n 1.7v 69.495n 1.7v 69.505n 1.7v 79.495n 1.7v 79.505n 1.7v 89.495n 1.7v 89.505n 1.7v 99.495n 1.7v 99.505n 1.7v 109.495n 1.7v 109.505n 1.7v 119.495n 1.7v 119.505n 0.0v 129.495n 0.0v 129.505n 0.0v 139.495n 0.0v 139.505n 1.7v 149.495n 1.7v 149.505n 1.7v 159.495n 1.7v 159.505n 1.7v 169.495n 1.7v 169.505n 1.7v 179.495n 1.7v 179.505n 0.0v 189.495n 0.0v 189.505n 0.0v 199.495n 0.0v 199.505n 0.0v 209.495n 0.0v 209.505n 1.7v 219.495n 1.7v 219.505n 1.7v 229.495n 1.7v 229.505n 1.7v 239.495n 1.7v 239.505n 0.0v 249.495n 0.0v 249.505n 0.0v 259.495n 0.0v 259.505n 0.0v 269.495n 0.0v 269.505n 1.7v 279.495n 1.7v 279.505n 1.7v 289.495n 1.7v 289.505n 1.7v 299.495n 1.7v 299.505n 0.0v 309.495n 0.0v 309.505n 0.0v 319.495n 0.0v 319.505n 0.0v 329.495n 0.0v 329.505n 0.0v 339.495n 0.0v 339.505n 0.0v 349.495n 0.0v 349.505n 0.0v 359.495n 0.0v 359.505n 0.0v 369.495n 0.0v 369.505n 0.0v 379.495n 0.0v 379.505n 1.7v 389.495n 1.7v 389.505n 1.7v 399.495n 1.7v 399.505n 1.7v 409.495n 1.7v 409.505n 1.7v 419.495n 1.7v 419.505n 1.7v 429.495n 1.7v 429.505n 1.7v 439.495n 1.7v 439.505n 0.0v 449.495n 0.0v 449.505n 0.0v 459.495n 0.0v 459.505n 0.0v 469.495n 0.0v 469.505n 1.7v 479.495n 1.7v 479.505n 1.7v 489.495n 1.7v 489.505n 1.7v 499.495n 1.7v 499.505n 1.7v 509.495n 1.7v 509.505n 0.0v 519.495n 0.0v 519.505n 1.7v 529.495n 1.7v 529.505n 0.0v 539.495n 0.0v 539.505n 1.7v 549.495n 1.7v 549.505n 0.0v 559.495n 0.0v 559.505n 0.0v 569.495n 0.0v 569.505n 0.0v 579.495n 0.0v 579.505n 0.0v 589.495n 0.0v 589.505n 1.7v 599.495n 1.7v 599.505n 1.7v 609.495n 1.7v 609.505n 1.7v 619.495n 1.7v 619.505n 1.7v 629.495n 1.7v 629.505n 0.0v 639.495n 0.0v 639.505n 1.7v 649.495n 1.7v 649.505n 1.7v 659.495n 1.7v 659.505n 1.7v 669.495n 1.7v 669.505n 1.7v 679.495n 1.7v 679.505n 1.7v 689.495n 1.7v 689.505n 1.7v 699.495n 1.7v 699.505n 0.0v 709.495n 0.0v 709.505n 0.0v 719.495n 0.0v 719.505n 1.7v 729.495n 1.7v 729.505n 1.7v 739.495n 1.7v 739.505n 1.7v 749.495n 1.7v 749.505n 1.7v 759.495n 1.7v 759.505n 0.0v 769.495n 0.0v 769.505n 1.7v 779.495n 1.7v 779.505n 1.7v 789.495n 1.7v 789.505n 1.7v 799.495n 1.7v 799.505n 1.7v 809.495n 1.7v 809.505n 0.0v 819.495n 0.0v 819.505n 1.7v 829.495n 1.7v 829.505n 1.7v 839.495n 1.7v 839.505n 1.7v 849.495n 1.7v 849.505n 1.7v 859.495n 1.7v 859.505n 0.0v 869.495n 0.0v 869.505n 0.0v 879.495n 0.0v 879.505n 0.0v 889.495n 0.0v 889.505n 0.0v 899.495n 0.0v 899.505n 0.0v 909.495n 0.0v 909.505n 0.0v 919.495n 0.0v 919.505n 1.7v 929.495n 1.7v 929.505n 0.0v 939.495n 0.0v 939.505n 1.7v 949.495n 1.7v 949.505n 1.7v 959.495n 1.7v 959.505n 1.7v 969.495n 1.7v 969.505n 1.7v 979.495n 1.7v 979.505n 0.0v 989.495n 0.0v 989.505n 0.0v 999.495n 0.0v 999.505n 0.0v 1009.495n 0.0v 1009.505n 0.0v 1019.495n 0.0v 1019.505n 0.0v 1029.495n 0.0v 1029.505n 0.0v 1039.495n 0.0v 1039.505n 0.0v 1049.495n 0.0v 1049.505n 0.0v 1059.495n 0.0v 1059.505n 0.0v 1069.495n 0.0v 1069.505n 0.0v 1079.495n 0.0v 1079.505n 0.0v 1089.495n 0.0v 1089.505n 1.7v 1099.495n 1.7v 1099.505n 0.0v 1109.495n 0.0v 1109.505n 0.0v 1119.495n 0.0v 1119.505n 0.0v 1129.495n 0.0v 1129.505n 0.0v 1139.495n 0.0v 1139.505n 1.7v 1149.495n 1.7v 1149.505n 1.7v 1159.495n 1.7v 1159.505n 0.0v 1169.495n 0.0v 1169.505n 1.7v 1179.495n 1.7v 1179.505n 0.0v 1189.495n 0.0v 1189.505n 0.0v 1199.495n 0.0v 1199.505n 0.0v 1209.495n 0.0v 1209.505n 1.7v 1219.495n 1.7v 1219.505n 0.0v 1229.495n 0.0v 1229.505n 0.0v 1239.495n 0.0v 1239.505n 0.0v 1249.495n 0.0v 1249.505n 0.0v 1259.495n 0.0v 1259.505n 0.0v 1269.495n 0.0v 1269.505n 0.0v 1279.495n 0.0v 1279.505n 0.0v 1289.495n 0.0v 1289.505n 0.0v 1299.495n 0.0v 1299.505n 0.0v 1309.495n 0.0v 1309.505n 0.0v 1319.495n 0.0v 1319.505n 0.0v 1329.495n 0.0v 1329.505n 0.0v 1339.495n 0.0v 1339.505n 0.0v 1349.495n 0.0v 1349.505n 1.7v 1359.495n 1.7v 1359.505n 1.7v 1369.495n 1.7v 1369.505n 0.0v 1379.495n 0.0v 1379.505n 1.7v 1389.495n 1.7v 1389.505n 1.7v 1399.495n 1.7v 1399.505n 1.7v 1409.495n 1.7v 1409.505n 1.7v 1419.495n 1.7v 1419.505n 1.7v 1429.495n 1.7v 1429.505n 1.7v 1439.495n 1.7v 1439.505n 0.0v 1449.495n 0.0v 1449.505n 1.7v 1459.495n 1.7v 1459.505n 1.7v 1469.495n 1.7v 1469.505n 0.0v 1479.495n 0.0v 1479.505n 0.0v 1489.495n 0.0v 1489.505n 1.7v 1499.495n 1.7v 1499.505n 1.7v 1509.495n 1.7v 1509.505n 1.7v 1519.495n 1.7v 1519.505n 1.7v 1529.495n 1.7v 1529.505n 0.0v 1539.495n 0.0v 1539.505n 1.7v 1549.495n 1.7v 1549.505n 1.7v 1559.495n 1.7v 1559.505n 1.7v 1569.495n 1.7v 1569.505n 1.7v 1579.495n 1.7v 1579.505n 0.0v 1589.495n 0.0v 1589.505n 0.0v 1599.495n 0.0v 1599.505n 0.0v 1609.495n 0.0v 1609.505n 0.0v 1619.495n 0.0v 1619.505n 0.0v 1629.495n 0.0v 1629.505n 0.0v 1639.495n 0.0v 1639.505n 1.7v 1649.495n 1.7v 1649.505n 1.7v 1659.495n 1.7v 1659.505n 1.7v 1669.495n 1.7v 1669.505n 0.0v 1679.495n 0.0v 1679.505n 1.7v 1689.495n 1.7v 1689.505n 0.0v 1699.495n 0.0v 1699.505n 1.7v 1709.495n 1.7v 1709.505n 0.0v 1719.495n 0.0v 1719.505n 0.0v 1729.495n 0.0v 1729.505n 0.0v 1739.495n 0.0v 1739.505n 0.0v 1749.495n 0.0v 1749.505n 0.0v 1759.495n 0.0v 1759.505n 1.7v 1769.495n 1.7v 1769.505n 0.0v 1779.495n 0.0v 1779.505n 0.0v 1789.495n 0.0v 1789.505n 1.7v 1799.495n 1.7v 1799.505n 1.7v 1809.495n 1.7v 1809.505n 1.7v 1819.495n 1.7v 1819.505n 1.7v 1829.495n 1.7v 1829.505n 0.0v 1839.495n 0.0v 1839.505n 0.0v 1849.495n 0.0v 1849.505n 0.0v 1859.495n 0.0v 1859.505n 1.7v 1869.495n 1.7v 1869.505n 1.7v 1879.495n 1.7v 1879.505n 1.7v 1889.495n 1.7v 1889.505n 1.7v 1899.495n 1.7v 1899.505n 0.0v 1909.495n 0.0v 1909.505n 0.0v 1919.495n 0.0v 1919.505n 0.0v 1929.495n 0.0v 1929.505n 0.0v 1939.495n 0.0v 1939.505n 0.0v 1949.495n 0.0v 1949.505n 1.7v 1959.495n 1.7v 1959.505n 1.7v 1969.495n 1.7v 1969.505n 0.0v 1979.495n 0.0v 1979.505n 0.0v 1989.495n 0.0v 1989.505n 1.7v 1999.495n 1.7v 1999.505n 1.7v 2009.495n 1.7v 2009.505n 1.7v 2019.495n 1.7v 2019.505n 1.7v 2029.495n 1.7v 2029.505n 1.7v 2039.495n 1.7v 2039.505n 1.7v 2049.495n 1.7v 2049.505n 1.7v )
* (time, data): [(0, 0), (10, 1), (20, 0), (30, 0), (40, 0), (50, 1), (60, 1), (70, 1), (80, 0), (90, 0), (100, 0), (110, 0), (120, 0), (130, 1), (140, 1), (150, 1), (160, 1), (170, 1), (180, 1), (190, 1), (200, 1), (210, 0), (220, 0), (230, 0), (240, 1), (250, 1), (260, 1), (270, 0), (280, 0), (290, 0), (300, 1), (310, 0), (320, 1), (330, 1), (340, 1), (350, 1), (360, 1), (370, 1), (380, 1), (390, 1), (400, 1), (410, 1), (420, 1), (430, 1), (440, 1), (450, 1), (460, 1), (470, 1), (480, 1), (490, 1), (500, 1), (510, 1), (520, 1), (530, 0), (540, 1), (550, 1), (560, 1), (570, 1), (580, 1), (590, 0), (600, 0), (610, 0), (620, 0), (630, 0), (640, 0), (650, 0), (660, 1), (670, 1), (680, 1), (690, 0), (700, 1), (710, 0), (720, 0), (730, 0), (740, 0), (750, 0), (760, 1), (770, 1), (780, 1), (790, 1), (800, 1), (810, 0), (820, 1), (830, 1), (840, 1), (850, 1), (860, 0), (870, 1), (880, 1), (890, 1), (900, 1), (910, 1), (920, 1), (930, 0), (940, 1), (950, 0), (960, 0), (970, 1), (980, 1), (990, 1), (1000, 1), (1010, 1), (1020, 1), (1030, 1), (1040, 1), (1050, 1), (1060, 1), (1070, 1), (1080, 1), (1090, 1), (1100, 1), (1110, 1), (1120, 1), (1130, 1), (1140, 0), (1150, 1), (1160, 1), (1170, 0), (1180, 1), (1190, 1), (1200, 0), (1210, 0), (1220, 0), (1230, 0), (1240, 1), (1250, 1), (1260, 1), (1270, 0), (1280, 0), (1290, 0), (1300, 0), (1310, 0), (1320, 0), (1330, 0), (1340, 1), (1350, 1), (1360, 1), (1370, 0), (1380, 1), (1390, 1), (1400, 0), (1410, 0), (1420, 0), (1430, 0), (1440, 0), (1450, 0), (1460, 0), (1470, 0), (1480, 0), (1490, 0), (1500, 0), (1510, 0), (1520, 0), (1530, 0), (1540, 1), (1550, 0), (1560, 0), (1570, 1), (1580, 0), (1590, 1), (1600, 1), (1610, 0), (1620, 0), (1630, 0), (1640, 0), (1650, 0), (1660, 0), (1670, 0), (1680, 1), (1690, 0), (1700, 1), (1710, 1), (1720, 0), (1730, 0), (1740, 1), (1750, 1), (1760, 0), (1770, 1), (1780, 1), (1790, 1), (1800, 0), (1810, 1), (1820, 0), (1830, 1), (1840, 0), (1850, 0), (1860, 0), (1870, 0), (1880, 1), (1890, 1), (1900, 1), (1910, 0), (1920, 0), (1930, 1), (1940, 0), (1950, 1), (1960, 1), (1970, 0), (1980, 0), (1990, 1), (2000, 1), (2010, 1), (2020, 1), (2030, 1), (2040, 1), (2050, 1)]
Vdin0_24  din0_24  0 PWL (0n 0.0v 9.495n 0.0v 9.505n 1.7v 19.495n 1.7v 19.505n 0.0v 29.495n 0.0v 29.505n 0.0v 39.495n 0.0v 39.505n 0.0v 49.495n 0.0v 49.505n 1.7v 59.495n 1.7v 59.505n 1.7v 69.495n 1.7v 69.505n 1.7v 79.495n 1.7v 79.505n 0.0v 89.495n 0.0v 89.505n 0.0v 99.495n 0.0v 99.505n 0.0v 109.495n 0.0v 109.505n 0.0v 119.495n 0.0v 119.505n 0.0v 129.495n 0.0v 129.505n 1.7v 139.495n 1.7v 139.505n 1.7v 149.495n 1.7v 149.505n 1.7v 159.495n 1.7v 159.505n 1.7v 169.495n 1.7v 169.505n 1.7v 179.495n 1.7v 179.505n 1.7v 189.495n 1.7v 189.505n 1.7v 199.495n 1.7v 199.505n 1.7v 209.495n 1.7v 209.505n 0.0v 219.495n 0.0v 219.505n 0.0v 229.495n 0.0v 229.505n 0.0v 239.495n 0.0v 239.505n 1.7v 249.495n 1.7v 249.505n 1.7v 259.495n 1.7v 259.505n 1.7v 269.495n 1.7v 269.505n 0.0v 279.495n 0.0v 279.505n 0.0v 289.495n 0.0v 289.505n 0.0v 299.495n 0.0v 299.505n 1.7v 309.495n 1.7v 309.505n 0.0v 319.495n 0.0v 319.505n 1.7v 329.495n 1.7v 329.505n 1.7v 339.495n 1.7v 339.505n 1.7v 349.495n 1.7v 349.505n 1.7v 359.495n 1.7v 359.505n 1.7v 369.495n 1.7v 369.505n 1.7v 379.495n 1.7v 379.505n 1.7v 389.495n 1.7v 389.505n 1.7v 399.495n 1.7v 399.505n 1.7v 409.495n 1.7v 409.505n 1.7v 419.495n 1.7v 419.505n 1.7v 429.495n 1.7v 429.505n 1.7v 439.495n 1.7v 439.505n 1.7v 449.495n 1.7v 449.505n 1.7v 459.495n 1.7v 459.505n 1.7v 469.495n 1.7v 469.505n 1.7v 479.495n 1.7v 479.505n 1.7v 489.495n 1.7v 489.505n 1.7v 499.495n 1.7v 499.505n 1.7v 509.495n 1.7v 509.505n 1.7v 519.495n 1.7v 519.505n 1.7v 529.495n 1.7v 529.505n 0.0v 539.495n 0.0v 539.505n 1.7v 549.495n 1.7v 549.505n 1.7v 559.495n 1.7v 559.505n 1.7v 569.495n 1.7v 569.505n 1.7v 579.495n 1.7v 579.505n 1.7v 589.495n 1.7v 589.505n 0.0v 599.495n 0.0v 599.505n 0.0v 609.495n 0.0v 609.505n 0.0v 619.495n 0.0v 619.505n 0.0v 629.495n 0.0v 629.505n 0.0v 639.495n 0.0v 639.505n 0.0v 649.495n 0.0v 649.505n 0.0v 659.495n 0.0v 659.505n 1.7v 669.495n 1.7v 669.505n 1.7v 679.495n 1.7v 679.505n 1.7v 689.495n 1.7v 689.505n 0.0v 699.495n 0.0v 699.505n 1.7v 709.495n 1.7v 709.505n 0.0v 719.495n 0.0v 719.505n 0.0v 729.495n 0.0v 729.505n 0.0v 739.495n 0.0v 739.505n 0.0v 749.495n 0.0v 749.505n 0.0v 759.495n 0.0v 759.505n 1.7v 769.495n 1.7v 769.505n 1.7v 779.495n 1.7v 779.505n 1.7v 789.495n 1.7v 789.505n 1.7v 799.495n 1.7v 799.505n 1.7v 809.495n 1.7v 809.505n 0.0v 819.495n 0.0v 819.505n 1.7v 829.495n 1.7v 829.505n 1.7v 839.495n 1.7v 839.505n 1.7v 849.495n 1.7v 849.505n 1.7v 859.495n 1.7v 859.505n 0.0v 869.495n 0.0v 869.505n 1.7v 879.495n 1.7v 879.505n 1.7v 889.495n 1.7v 889.505n 1.7v 899.495n 1.7v 899.505n 1.7v 909.495n 1.7v 909.505n 1.7v 919.495n 1.7v 919.505n 1.7v 929.495n 1.7v 929.505n 0.0v 939.495n 0.0v 939.505n 1.7v 949.495n 1.7v 949.505n 0.0v 959.495n 0.0v 959.505n 0.0v 969.495n 0.0v 969.505n 1.7v 979.495n 1.7v 979.505n 1.7v 989.495n 1.7v 989.505n 1.7v 999.495n 1.7v 999.505n 1.7v 1009.495n 1.7v 1009.505n 1.7v 1019.495n 1.7v 1019.505n 1.7v 1029.495n 1.7v 1029.505n 1.7v 1039.495n 1.7v 1039.505n 1.7v 1049.495n 1.7v 1049.505n 1.7v 1059.495n 1.7v 1059.505n 1.7v 1069.495n 1.7v 1069.505n 1.7v 1079.495n 1.7v 1079.505n 1.7v 1089.495n 1.7v 1089.505n 1.7v 1099.495n 1.7v 1099.505n 1.7v 1109.495n 1.7v 1109.505n 1.7v 1119.495n 1.7v 1119.505n 1.7v 1129.495n 1.7v 1129.505n 1.7v 1139.495n 1.7v 1139.505n 0.0v 1149.495n 0.0v 1149.505n 1.7v 1159.495n 1.7v 1159.505n 1.7v 1169.495n 1.7v 1169.505n 0.0v 1179.495n 0.0v 1179.505n 1.7v 1189.495n 1.7v 1189.505n 1.7v 1199.495n 1.7v 1199.505n 0.0v 1209.495n 0.0v 1209.505n 0.0v 1219.495n 0.0v 1219.505n 0.0v 1229.495n 0.0v 1229.505n 0.0v 1239.495n 0.0v 1239.505n 1.7v 1249.495n 1.7v 1249.505n 1.7v 1259.495n 1.7v 1259.505n 1.7v 1269.495n 1.7v 1269.505n 0.0v 1279.495n 0.0v 1279.505n 0.0v 1289.495n 0.0v 1289.505n 0.0v 1299.495n 0.0v 1299.505n 0.0v 1309.495n 0.0v 1309.505n 0.0v 1319.495n 0.0v 1319.505n 0.0v 1329.495n 0.0v 1329.505n 0.0v 1339.495n 0.0v 1339.505n 1.7v 1349.495n 1.7v 1349.505n 1.7v 1359.495n 1.7v 1359.505n 1.7v 1369.495n 1.7v 1369.505n 0.0v 1379.495n 0.0v 1379.505n 1.7v 1389.495n 1.7v 1389.505n 1.7v 1399.495n 1.7v 1399.505n 0.0v 1409.495n 0.0v 1409.505n 0.0v 1419.495n 0.0v 1419.505n 0.0v 1429.495n 0.0v 1429.505n 0.0v 1439.495n 0.0v 1439.505n 0.0v 1449.495n 0.0v 1449.505n 0.0v 1459.495n 0.0v 1459.505n 0.0v 1469.495n 0.0v 1469.505n 0.0v 1479.495n 0.0v 1479.505n 0.0v 1489.495n 0.0v 1489.505n 0.0v 1499.495n 0.0v 1499.505n 0.0v 1509.495n 0.0v 1509.505n 0.0v 1519.495n 0.0v 1519.505n 0.0v 1529.495n 0.0v 1529.505n 0.0v 1539.495n 0.0v 1539.505n 1.7v 1549.495n 1.7v 1549.505n 0.0v 1559.495n 0.0v 1559.505n 0.0v 1569.495n 0.0v 1569.505n 1.7v 1579.495n 1.7v 1579.505n 0.0v 1589.495n 0.0v 1589.505n 1.7v 1599.495n 1.7v 1599.505n 1.7v 1609.495n 1.7v 1609.505n 0.0v 1619.495n 0.0v 1619.505n 0.0v 1629.495n 0.0v 1629.505n 0.0v 1639.495n 0.0v 1639.505n 0.0v 1649.495n 0.0v 1649.505n 0.0v 1659.495n 0.0v 1659.505n 0.0v 1669.495n 0.0v 1669.505n 0.0v 1679.495n 0.0v 1679.505n 1.7v 1689.495n 1.7v 1689.505n 0.0v 1699.495n 0.0v 1699.505n 1.7v 1709.495n 1.7v 1709.505n 1.7v 1719.495n 1.7v 1719.505n 0.0v 1729.495n 0.0v 1729.505n 0.0v 1739.495n 0.0v 1739.505n 1.7v 1749.495n 1.7v 1749.505n 1.7v 1759.495n 1.7v 1759.505n 0.0v 1769.495n 0.0v 1769.505n 1.7v 1779.495n 1.7v 1779.505n 1.7v 1789.495n 1.7v 1789.505n 1.7v 1799.495n 1.7v 1799.505n 0.0v 1809.495n 0.0v 1809.505n 1.7v 1819.495n 1.7v 1819.505n 0.0v 1829.495n 0.0v 1829.505n 1.7v 1839.495n 1.7v 1839.505n 0.0v 1849.495n 0.0v 1849.505n 0.0v 1859.495n 0.0v 1859.505n 0.0v 1869.495n 0.0v 1869.505n 0.0v 1879.495n 0.0v 1879.505n 1.7v 1889.495n 1.7v 1889.505n 1.7v 1899.495n 1.7v 1899.505n 1.7v 1909.495n 1.7v 1909.505n 0.0v 1919.495n 0.0v 1919.505n 0.0v 1929.495n 0.0v 1929.505n 1.7v 1939.495n 1.7v 1939.505n 0.0v 1949.495n 0.0v 1949.505n 1.7v 1959.495n 1.7v 1959.505n 1.7v 1969.495n 1.7v 1969.505n 0.0v 1979.495n 0.0v 1979.505n 0.0v 1989.495n 0.0v 1989.505n 1.7v 1999.495n 1.7v 1999.505n 1.7v 2009.495n 1.7v 2009.505n 1.7v 2019.495n 1.7v 2019.505n 1.7v 2029.495n 1.7v 2029.505n 1.7v 2039.495n 1.7v 2039.505n 1.7v 2049.495n 1.7v 2049.505n 1.7v )
* (time, data): [(0, 0), (10, 0), (20, 0), (30, 1), (40, 1), (50, 0), (60, 1), (70, 1), (80, 0), (90, 0), (100, 0), (110, 0), (120, 0), (130, 1), (140, 1), (150, 1), (160, 1), (170, 1), (180, 1), (190, 1), (200, 1), (210, 0), (220, 0), (230, 0), (240, 0), (250, 0), (260, 0), (270, 0), (280, 0), (290, 0), (300, 1), (310, 0), (320, 1), (330, 0), (340, 0), (350, 0), (360, 0), (370, 0), (380, 1), (390, 1), (400, 1), (410, 1), (420, 1), (430, 1), (440, 0), (450, 0), (460, 1), (470, 1), (480, 1), (490, 1), (500, 1), (510, 1), (520, 0), (530, 0), (540, 0), (550, 0), (560, 0), (570, 0), (580, 0), (590, 0), (600, 0), (610, 0), (620, 0), (630, 1), (640, 1), (650, 1), (660, 1), (670, 0), (680, 0), (690, 1), (700, 0), (710, 0), (720, 1), (730, 1), (740, 1), (750, 0), (760, 0), (770, 0), (780, 0), (790, 0), (800, 0), (810, 0), (820, 0), (830, 0), (840, 0), (850, 0), (860, 1), (870, 0), (880, 0), (890, 0), (900, 0), (910, 0), (920, 0), (930, 1), (940, 0), (950, 0), (960, 0), (970, 0), (980, 1), (990, 1), (1000, 1), (1010, 1), (1020, 1), (1030, 1), (1040, 0), (1050, 0), (1060, 0), (1070, 0), (1080, 0), (1090, 1), (1100, 1), (1110, 1), (1120, 1), (1130, 1), (1140, 0), (1150, 1), (1160, 1), (1170, 0), (1180, 0), (1190, 0), (1200, 0), (1210, 1), (1220, 0), (1230, 0), (1240, 1), (1250, 1), (1260, 1), (1270, 1), (1280, 1), (1290, 0), (1300, 0), (1310, 0), (1320, 1), (1330, 1), (1340, 0), (1350, 0), (1360, 0), (1370, 0), (1380, 1), (1390, 1), (1400, 0), (1410, 0), (1420, 0), (1430, 0), (1440, 1), (1450, 1), (1460, 1), (1470, 0), (1480, 0), (1490, 1), (1500, 1), (1510, 1), (1520, 1), (1530, 0), (1540, 0), (1550, 1), (1560, 1), (1570, 1), (1580, 1), (1590, 1), (1600, 1), (1610, 0), (1620, 0), (1630, 0), (1640, 0), (1650, 0), (1660, 0), (1670, 1), (1680, 0), (1690, 0), (1700, 0), (1710, 0), (1720, 0), (1730, 0), (1740, 0), (1750, 0), (1760, 0), (1770, 1), (1780, 1), (1790, 1), (1800, 0), (1810, 1), (1820, 0), (1830, 0), (1840, 0), (1850, 0), (1860, 0), (1870, 0), (1880, 0), (1890, 0), (1900, 1), (1910, 1), (1920, 0), (1930, 0), (1940, 1), (1950, 0), (1960, 0), (1970, 0), (1980, 0), (1990, 0), (2000, 0), (2010, 0), (2020, 1), (2030, 1), (2040, 1), (2050, 1)]
Vdin0_25  din0_25  0 PWL (0n 0.0v 9.495n 0.0v 9.505n 0.0v 19.495n 0.0v 19.505n 0.0v 29.495n 0.0v 29.505n 1.7v 39.495n 1.7v 39.505n 1.7v 49.495n 1.7v 49.505n 0.0v 59.495n 0.0v 59.505n 1.7v 69.495n 1.7v 69.505n 1.7v 79.495n 1.7v 79.505n 0.0v 89.495n 0.0v 89.505n 0.0v 99.495n 0.0v 99.505n 0.0v 109.495n 0.0v 109.505n 0.0v 119.495n 0.0v 119.505n 0.0v 129.495n 0.0v 129.505n 1.7v 139.495n 1.7v 139.505n 1.7v 149.495n 1.7v 149.505n 1.7v 159.495n 1.7v 159.505n 1.7v 169.495n 1.7v 169.505n 1.7v 179.495n 1.7v 179.505n 1.7v 189.495n 1.7v 189.505n 1.7v 199.495n 1.7v 199.505n 1.7v 209.495n 1.7v 209.505n 0.0v 219.495n 0.0v 219.505n 0.0v 229.495n 0.0v 229.505n 0.0v 239.495n 0.0v 239.505n 0.0v 249.495n 0.0v 249.505n 0.0v 259.495n 0.0v 259.505n 0.0v 269.495n 0.0v 269.505n 0.0v 279.495n 0.0v 279.505n 0.0v 289.495n 0.0v 289.505n 0.0v 299.495n 0.0v 299.505n 1.7v 309.495n 1.7v 309.505n 0.0v 319.495n 0.0v 319.505n 1.7v 329.495n 1.7v 329.505n 0.0v 339.495n 0.0v 339.505n 0.0v 349.495n 0.0v 349.505n 0.0v 359.495n 0.0v 359.505n 0.0v 369.495n 0.0v 369.505n 0.0v 379.495n 0.0v 379.505n 1.7v 389.495n 1.7v 389.505n 1.7v 399.495n 1.7v 399.505n 1.7v 409.495n 1.7v 409.505n 1.7v 419.495n 1.7v 419.505n 1.7v 429.495n 1.7v 429.505n 1.7v 439.495n 1.7v 439.505n 0.0v 449.495n 0.0v 449.505n 0.0v 459.495n 0.0v 459.505n 1.7v 469.495n 1.7v 469.505n 1.7v 479.495n 1.7v 479.505n 1.7v 489.495n 1.7v 489.505n 1.7v 499.495n 1.7v 499.505n 1.7v 509.495n 1.7v 509.505n 1.7v 519.495n 1.7v 519.505n 0.0v 529.495n 0.0v 529.505n 0.0v 539.495n 0.0v 539.505n 0.0v 549.495n 0.0v 549.505n 0.0v 559.495n 0.0v 559.505n 0.0v 569.495n 0.0v 569.505n 0.0v 579.495n 0.0v 579.505n 0.0v 589.495n 0.0v 589.505n 0.0v 599.495n 0.0v 599.505n 0.0v 609.495n 0.0v 609.505n 0.0v 619.495n 0.0v 619.505n 0.0v 629.495n 0.0v 629.505n 1.7v 639.495n 1.7v 639.505n 1.7v 649.495n 1.7v 649.505n 1.7v 659.495n 1.7v 659.505n 1.7v 669.495n 1.7v 669.505n 0.0v 679.495n 0.0v 679.505n 0.0v 689.495n 0.0v 689.505n 1.7v 699.495n 1.7v 699.505n 0.0v 709.495n 0.0v 709.505n 0.0v 719.495n 0.0v 719.505n 1.7v 729.495n 1.7v 729.505n 1.7v 739.495n 1.7v 739.505n 1.7v 749.495n 1.7v 749.505n 0.0v 759.495n 0.0v 759.505n 0.0v 769.495n 0.0v 769.505n 0.0v 779.495n 0.0v 779.505n 0.0v 789.495n 0.0v 789.505n 0.0v 799.495n 0.0v 799.505n 0.0v 809.495n 0.0v 809.505n 0.0v 819.495n 0.0v 819.505n 0.0v 829.495n 0.0v 829.505n 0.0v 839.495n 0.0v 839.505n 0.0v 849.495n 0.0v 849.505n 0.0v 859.495n 0.0v 859.505n 1.7v 869.495n 1.7v 869.505n 0.0v 879.495n 0.0v 879.505n 0.0v 889.495n 0.0v 889.505n 0.0v 899.495n 0.0v 899.505n 0.0v 909.495n 0.0v 909.505n 0.0v 919.495n 0.0v 919.505n 0.0v 929.495n 0.0v 929.505n 1.7v 939.495n 1.7v 939.505n 0.0v 949.495n 0.0v 949.505n 0.0v 959.495n 0.0v 959.505n 0.0v 969.495n 0.0v 969.505n 0.0v 979.495n 0.0v 979.505n 1.7v 989.495n 1.7v 989.505n 1.7v 999.495n 1.7v 999.505n 1.7v 1009.495n 1.7v 1009.505n 1.7v 1019.495n 1.7v 1019.505n 1.7v 1029.495n 1.7v 1029.505n 1.7v 1039.495n 1.7v 1039.505n 0.0v 1049.495n 0.0v 1049.505n 0.0v 1059.495n 0.0v 1059.505n 0.0v 1069.495n 0.0v 1069.505n 0.0v 1079.495n 0.0v 1079.505n 0.0v 1089.495n 0.0v 1089.505n 1.7v 1099.495n 1.7v 1099.505n 1.7v 1109.495n 1.7v 1109.505n 1.7v 1119.495n 1.7v 1119.505n 1.7v 1129.495n 1.7v 1129.505n 1.7v 1139.495n 1.7v 1139.505n 0.0v 1149.495n 0.0v 1149.505n 1.7v 1159.495n 1.7v 1159.505n 1.7v 1169.495n 1.7v 1169.505n 0.0v 1179.495n 0.0v 1179.505n 0.0v 1189.495n 0.0v 1189.505n 0.0v 1199.495n 0.0v 1199.505n 0.0v 1209.495n 0.0v 1209.505n 1.7v 1219.495n 1.7v 1219.505n 0.0v 1229.495n 0.0v 1229.505n 0.0v 1239.495n 0.0v 1239.505n 1.7v 1249.495n 1.7v 1249.505n 1.7v 1259.495n 1.7v 1259.505n 1.7v 1269.495n 1.7v 1269.505n 1.7v 1279.495n 1.7v 1279.505n 1.7v 1289.495n 1.7v 1289.505n 0.0v 1299.495n 0.0v 1299.505n 0.0v 1309.495n 0.0v 1309.505n 0.0v 1319.495n 0.0v 1319.505n 1.7v 1329.495n 1.7v 1329.505n 1.7v 1339.495n 1.7v 1339.505n 0.0v 1349.495n 0.0v 1349.505n 0.0v 1359.495n 0.0v 1359.505n 0.0v 1369.495n 0.0v 1369.505n 0.0v 1379.495n 0.0v 1379.505n 1.7v 1389.495n 1.7v 1389.505n 1.7v 1399.495n 1.7v 1399.505n 0.0v 1409.495n 0.0v 1409.505n 0.0v 1419.495n 0.0v 1419.505n 0.0v 1429.495n 0.0v 1429.505n 0.0v 1439.495n 0.0v 1439.505n 1.7v 1449.495n 1.7v 1449.505n 1.7v 1459.495n 1.7v 1459.505n 1.7v 1469.495n 1.7v 1469.505n 0.0v 1479.495n 0.0v 1479.505n 0.0v 1489.495n 0.0v 1489.505n 1.7v 1499.495n 1.7v 1499.505n 1.7v 1509.495n 1.7v 1509.505n 1.7v 1519.495n 1.7v 1519.505n 1.7v 1529.495n 1.7v 1529.505n 0.0v 1539.495n 0.0v 1539.505n 0.0v 1549.495n 0.0v 1549.505n 1.7v 1559.495n 1.7v 1559.505n 1.7v 1569.495n 1.7v 1569.505n 1.7v 1579.495n 1.7v 1579.505n 1.7v 1589.495n 1.7v 1589.505n 1.7v 1599.495n 1.7v 1599.505n 1.7v 1609.495n 1.7v 1609.505n 0.0v 1619.495n 0.0v 1619.505n 0.0v 1629.495n 0.0v 1629.505n 0.0v 1639.495n 0.0v 1639.505n 0.0v 1649.495n 0.0v 1649.505n 0.0v 1659.495n 0.0v 1659.505n 0.0v 1669.495n 0.0v 1669.505n 1.7v 1679.495n 1.7v 1679.505n 0.0v 1689.495n 0.0v 1689.505n 0.0v 1699.495n 0.0v 1699.505n 0.0v 1709.495n 0.0v 1709.505n 0.0v 1719.495n 0.0v 1719.505n 0.0v 1729.495n 0.0v 1729.505n 0.0v 1739.495n 0.0v 1739.505n 0.0v 1749.495n 0.0v 1749.505n 0.0v 1759.495n 0.0v 1759.505n 0.0v 1769.495n 0.0v 1769.505n 1.7v 1779.495n 1.7v 1779.505n 1.7v 1789.495n 1.7v 1789.505n 1.7v 1799.495n 1.7v 1799.505n 0.0v 1809.495n 0.0v 1809.505n 1.7v 1819.495n 1.7v 1819.505n 0.0v 1829.495n 0.0v 1829.505n 0.0v 1839.495n 0.0v 1839.505n 0.0v 1849.495n 0.0v 1849.505n 0.0v 1859.495n 0.0v 1859.505n 0.0v 1869.495n 0.0v 1869.505n 0.0v 1879.495n 0.0v 1879.505n 0.0v 1889.495n 0.0v 1889.505n 0.0v 1899.495n 0.0v 1899.505n 1.7v 1909.495n 1.7v 1909.505n 1.7v 1919.495n 1.7v 1919.505n 0.0v 1929.495n 0.0v 1929.505n 0.0v 1939.495n 0.0v 1939.505n 1.7v 1949.495n 1.7v 1949.505n 0.0v 1959.495n 0.0v 1959.505n 0.0v 1969.495n 0.0v 1969.505n 0.0v 1979.495n 0.0v 1979.505n 0.0v 1989.495n 0.0v 1989.505n 0.0v 1999.495n 0.0v 1999.505n 0.0v 2009.495n 0.0v 2009.505n 0.0v 2019.495n 0.0v 2019.505n 1.7v 2029.495n 1.7v 2029.505n 1.7v 2039.495n 1.7v 2039.505n 1.7v 2049.495n 1.7v 2049.505n 1.7v )
* (time, data): [(0, 0), (10, 0), (20, 1), (30, 1), (40, 1), (50, 1), (60, 1), (70, 1), (80, 1), (90, 1), (100, 1), (110, 1), (120, 0), (130, 0), (140, 1), (150, 1), (160, 1), (170, 1), (180, 0), (190, 0), (200, 0), (210, 1), (220, 1), (230, 1), (240, 1), (250, 1), (260, 1), (270, 0), (280, 0), (290, 0), (300, 0), (310, 1), (320, 0), (330, 1), (340, 1), (350, 1), (360, 1), (370, 1), (380, 0), (390, 0), (400, 0), (410, 0), (420, 0), (430, 0), (440, 1), (450, 1), (460, 0), (470, 1), (480, 1), (490, 1), (500, 1), (510, 1), (520, 1), (530, 1), (540, 1), (550, 1), (560, 1), (570, 1), (580, 1), (590, 1), (600, 1), (610, 1), (620, 1), (630, 1), (640, 1), (650, 1), (660, 1), (670, 0), (680, 0), (690, 0), (700, 0), (710, 1), (720, 0), (730, 0), (740, 1), (750, 1), (760, 0), (770, 0), (780, 0), (790, 0), (800, 0), (810, 1), (820, 1), (830, 1), (840, 1), (850, 1), (860, 1), (870, 0), (880, 0), (890, 0), (900, 0), (910, 0), (920, 1), (930, 0), (940, 1), (950, 1), (960, 1), (970, 0), (980, 1), (990, 1), (1000, 1), (1010, 1), (1020, 1), (1030, 1), (1040, 1), (1050, 1), (1060, 1), (1070, 1), (1080, 1), (1090, 1), (1100, 0), (1110, 0), (1120, 0), (1130, 0), (1140, 0), (1150, 1), (1160, 0), (1170, 0), (1180, 1), (1190, 1), (1200, 1), (1210, 1), (1220, 1), (1230, 0), (1240, 0), (1250, 0), (1260, 0), (1270, 0), (1280, 0), (1290, 0), (1300, 0), (1310, 0), (1320, 1), (1330, 1), (1340, 0), (1350, 0), (1360, 0), (1370, 0), (1380, 1), (1390, 1), (1400, 0), (1410, 1), (1420, 1), (1430, 1), (1440, 1), (1450, 1), (1460, 1), (1470, 0), (1480, 0), (1490, 1), (1500, 1), (1510, 1), (1520, 1), (1530, 1), (1540, 1), (1550, 0), (1560, 0), (1570, 1), (1580, 0), (1590, 0), (1600, 1), (1610, 0), (1620, 0), (1630, 0), (1640, 0), (1650, 0), (1660, 0), (1670, 1), (1680, 1), (1690, 1), (1700, 1), (1710, 0), (1720, 0), (1730, 0), (1740, 1), (1750, 1), (1760, 0), (1770, 0), (1780, 1), (1790, 1), (1800, 1), (1810, 0), (1820, 0), (1830, 1), (1840, 1), (1850, 1), (1860, 1), (1870, 1), (1880, 1), (1890, 1), (1900, 0), (1910, 0), (1920, 0), (1930, 1), (1940, 1), (1950, 0), (1960, 0), (1970, 0), (1980, 0), (1990, 0), (2000, 0), (2010, 0), (2020, 1), (2030, 0), (2040, 0), (2050, 0)]
Vdin0_26  din0_26  0 PWL (0n 0.0v 9.495n 0.0v 9.505n 0.0v 19.495n 0.0v 19.505n 1.7v 29.495n 1.7v 29.505n 1.7v 39.495n 1.7v 39.505n 1.7v 49.495n 1.7v 49.505n 1.7v 59.495n 1.7v 59.505n 1.7v 69.495n 1.7v 69.505n 1.7v 79.495n 1.7v 79.505n 1.7v 89.495n 1.7v 89.505n 1.7v 99.495n 1.7v 99.505n 1.7v 109.495n 1.7v 109.505n 1.7v 119.495n 1.7v 119.505n 0.0v 129.495n 0.0v 129.505n 0.0v 139.495n 0.0v 139.505n 1.7v 149.495n 1.7v 149.505n 1.7v 159.495n 1.7v 159.505n 1.7v 169.495n 1.7v 169.505n 1.7v 179.495n 1.7v 179.505n 0.0v 189.495n 0.0v 189.505n 0.0v 199.495n 0.0v 199.505n 0.0v 209.495n 0.0v 209.505n 1.7v 219.495n 1.7v 219.505n 1.7v 229.495n 1.7v 229.505n 1.7v 239.495n 1.7v 239.505n 1.7v 249.495n 1.7v 249.505n 1.7v 259.495n 1.7v 259.505n 1.7v 269.495n 1.7v 269.505n 0.0v 279.495n 0.0v 279.505n 0.0v 289.495n 0.0v 289.505n 0.0v 299.495n 0.0v 299.505n 0.0v 309.495n 0.0v 309.505n 1.7v 319.495n 1.7v 319.505n 0.0v 329.495n 0.0v 329.505n 1.7v 339.495n 1.7v 339.505n 1.7v 349.495n 1.7v 349.505n 1.7v 359.495n 1.7v 359.505n 1.7v 369.495n 1.7v 369.505n 1.7v 379.495n 1.7v 379.505n 0.0v 389.495n 0.0v 389.505n 0.0v 399.495n 0.0v 399.505n 0.0v 409.495n 0.0v 409.505n 0.0v 419.495n 0.0v 419.505n 0.0v 429.495n 0.0v 429.505n 0.0v 439.495n 0.0v 439.505n 1.7v 449.495n 1.7v 449.505n 1.7v 459.495n 1.7v 459.505n 0.0v 469.495n 0.0v 469.505n 1.7v 479.495n 1.7v 479.505n 1.7v 489.495n 1.7v 489.505n 1.7v 499.495n 1.7v 499.505n 1.7v 509.495n 1.7v 509.505n 1.7v 519.495n 1.7v 519.505n 1.7v 529.495n 1.7v 529.505n 1.7v 539.495n 1.7v 539.505n 1.7v 549.495n 1.7v 549.505n 1.7v 559.495n 1.7v 559.505n 1.7v 569.495n 1.7v 569.505n 1.7v 579.495n 1.7v 579.505n 1.7v 589.495n 1.7v 589.505n 1.7v 599.495n 1.7v 599.505n 1.7v 609.495n 1.7v 609.505n 1.7v 619.495n 1.7v 619.505n 1.7v 629.495n 1.7v 629.505n 1.7v 639.495n 1.7v 639.505n 1.7v 649.495n 1.7v 649.505n 1.7v 659.495n 1.7v 659.505n 1.7v 669.495n 1.7v 669.505n 0.0v 679.495n 0.0v 679.505n 0.0v 689.495n 0.0v 689.505n 0.0v 699.495n 0.0v 699.505n 0.0v 709.495n 0.0v 709.505n 1.7v 719.495n 1.7v 719.505n 0.0v 729.495n 0.0v 729.505n 0.0v 739.495n 0.0v 739.505n 1.7v 749.495n 1.7v 749.505n 1.7v 759.495n 1.7v 759.505n 0.0v 769.495n 0.0v 769.505n 0.0v 779.495n 0.0v 779.505n 0.0v 789.495n 0.0v 789.505n 0.0v 799.495n 0.0v 799.505n 0.0v 809.495n 0.0v 809.505n 1.7v 819.495n 1.7v 819.505n 1.7v 829.495n 1.7v 829.505n 1.7v 839.495n 1.7v 839.505n 1.7v 849.495n 1.7v 849.505n 1.7v 859.495n 1.7v 859.505n 1.7v 869.495n 1.7v 869.505n 0.0v 879.495n 0.0v 879.505n 0.0v 889.495n 0.0v 889.505n 0.0v 899.495n 0.0v 899.505n 0.0v 909.495n 0.0v 909.505n 0.0v 919.495n 0.0v 919.505n 1.7v 929.495n 1.7v 929.505n 0.0v 939.495n 0.0v 939.505n 1.7v 949.495n 1.7v 949.505n 1.7v 959.495n 1.7v 959.505n 1.7v 969.495n 1.7v 969.505n 0.0v 979.495n 0.0v 979.505n 1.7v 989.495n 1.7v 989.505n 1.7v 999.495n 1.7v 999.505n 1.7v 1009.495n 1.7v 1009.505n 1.7v 1019.495n 1.7v 1019.505n 1.7v 1029.495n 1.7v 1029.505n 1.7v 1039.495n 1.7v 1039.505n 1.7v 1049.495n 1.7v 1049.505n 1.7v 1059.495n 1.7v 1059.505n 1.7v 1069.495n 1.7v 1069.505n 1.7v 1079.495n 1.7v 1079.505n 1.7v 1089.495n 1.7v 1089.505n 1.7v 1099.495n 1.7v 1099.505n 0.0v 1109.495n 0.0v 1109.505n 0.0v 1119.495n 0.0v 1119.505n 0.0v 1129.495n 0.0v 1129.505n 0.0v 1139.495n 0.0v 1139.505n 0.0v 1149.495n 0.0v 1149.505n 1.7v 1159.495n 1.7v 1159.505n 0.0v 1169.495n 0.0v 1169.505n 0.0v 1179.495n 0.0v 1179.505n 1.7v 1189.495n 1.7v 1189.505n 1.7v 1199.495n 1.7v 1199.505n 1.7v 1209.495n 1.7v 1209.505n 1.7v 1219.495n 1.7v 1219.505n 1.7v 1229.495n 1.7v 1229.505n 0.0v 1239.495n 0.0v 1239.505n 0.0v 1249.495n 0.0v 1249.505n 0.0v 1259.495n 0.0v 1259.505n 0.0v 1269.495n 0.0v 1269.505n 0.0v 1279.495n 0.0v 1279.505n 0.0v 1289.495n 0.0v 1289.505n 0.0v 1299.495n 0.0v 1299.505n 0.0v 1309.495n 0.0v 1309.505n 0.0v 1319.495n 0.0v 1319.505n 1.7v 1329.495n 1.7v 1329.505n 1.7v 1339.495n 1.7v 1339.505n 0.0v 1349.495n 0.0v 1349.505n 0.0v 1359.495n 0.0v 1359.505n 0.0v 1369.495n 0.0v 1369.505n 0.0v 1379.495n 0.0v 1379.505n 1.7v 1389.495n 1.7v 1389.505n 1.7v 1399.495n 1.7v 1399.505n 0.0v 1409.495n 0.0v 1409.505n 1.7v 1419.495n 1.7v 1419.505n 1.7v 1429.495n 1.7v 1429.505n 1.7v 1439.495n 1.7v 1439.505n 1.7v 1449.495n 1.7v 1449.505n 1.7v 1459.495n 1.7v 1459.505n 1.7v 1469.495n 1.7v 1469.505n 0.0v 1479.495n 0.0v 1479.505n 0.0v 1489.495n 0.0v 1489.505n 1.7v 1499.495n 1.7v 1499.505n 1.7v 1509.495n 1.7v 1509.505n 1.7v 1519.495n 1.7v 1519.505n 1.7v 1529.495n 1.7v 1529.505n 1.7v 1539.495n 1.7v 1539.505n 1.7v 1549.495n 1.7v 1549.505n 0.0v 1559.495n 0.0v 1559.505n 0.0v 1569.495n 0.0v 1569.505n 1.7v 1579.495n 1.7v 1579.505n 0.0v 1589.495n 0.0v 1589.505n 0.0v 1599.495n 0.0v 1599.505n 1.7v 1609.495n 1.7v 1609.505n 0.0v 1619.495n 0.0v 1619.505n 0.0v 1629.495n 0.0v 1629.505n 0.0v 1639.495n 0.0v 1639.505n 0.0v 1649.495n 0.0v 1649.505n 0.0v 1659.495n 0.0v 1659.505n 0.0v 1669.495n 0.0v 1669.505n 1.7v 1679.495n 1.7v 1679.505n 1.7v 1689.495n 1.7v 1689.505n 1.7v 1699.495n 1.7v 1699.505n 1.7v 1709.495n 1.7v 1709.505n 0.0v 1719.495n 0.0v 1719.505n 0.0v 1729.495n 0.0v 1729.505n 0.0v 1739.495n 0.0v 1739.505n 1.7v 1749.495n 1.7v 1749.505n 1.7v 1759.495n 1.7v 1759.505n 0.0v 1769.495n 0.0v 1769.505n 0.0v 1779.495n 0.0v 1779.505n 1.7v 1789.495n 1.7v 1789.505n 1.7v 1799.495n 1.7v 1799.505n 1.7v 1809.495n 1.7v 1809.505n 0.0v 1819.495n 0.0v 1819.505n 0.0v 1829.495n 0.0v 1829.505n 1.7v 1839.495n 1.7v 1839.505n 1.7v 1849.495n 1.7v 1849.505n 1.7v 1859.495n 1.7v 1859.505n 1.7v 1869.495n 1.7v 1869.505n 1.7v 1879.495n 1.7v 1879.505n 1.7v 1889.495n 1.7v 1889.505n 1.7v 1899.495n 1.7v 1899.505n 0.0v 1909.495n 0.0v 1909.505n 0.0v 1919.495n 0.0v 1919.505n 0.0v 1929.495n 0.0v 1929.505n 1.7v 1939.495n 1.7v 1939.505n 1.7v 1949.495n 1.7v 1949.505n 0.0v 1959.495n 0.0v 1959.505n 0.0v 1969.495n 0.0v 1969.505n 0.0v 1979.495n 0.0v 1979.505n 0.0v 1989.495n 0.0v 1989.505n 0.0v 1999.495n 0.0v 1999.505n 0.0v 2009.495n 0.0v 2009.505n 0.0v 2019.495n 0.0v 2019.505n 1.7v 2029.495n 1.7v 2029.505n 0.0v 2039.495n 0.0v 2039.505n 0.0v 2049.495n 0.0v 2049.505n 0.0v )
* (time, data): [(0, 0), (10, 0), (20, 0), (30, 0), (40, 0), (50, 0), (60, 0), (70, 0), (80, 1), (90, 1), (100, 1), (110, 1), (120, 1), (130, 1), (140, 0), (150, 0), (160, 0), (170, 0), (180, 1), (190, 1), (200, 1), (210, 1), (220, 1), (230, 1), (240, 0), (250, 0), (260, 0), (270, 0), (280, 0), (290, 0), (300, 1), (310, 0), (320, 1), (330, 0), (340, 0), (350, 0), (360, 0), (370, 0), (380, 0), (390, 0), (400, 0), (410, 0), (420, 0), (430, 0), (440, 0), (450, 0), (460, 1), (470, 0), (480, 0), (490, 0), (500, 0), (510, 0), (520, 0), (530, 0), (540, 1), (550, 0), (560, 0), (570, 0), (580, 0), (590, 1), (600, 1), (610, 1), (620, 1), (630, 0), (640, 1), (650, 1), (660, 1), (670, 1), (680, 1), (690, 1), (700, 0), (710, 0), (720, 0), (730, 0), (740, 1), (750, 1), (760, 1), (770, 1), (780, 1), (790, 1), (800, 1), (810, 0), (820, 1), (830, 1), (840, 1), (850, 0), (860, 0), (870, 1), (880, 1), (890, 1), (900, 1), (910, 1), (920, 1), (930, 0), (940, 0), (950, 1), (960, 1), (970, 1), (980, 1), (990, 1), (1000, 1), (1010, 1), (1020, 1), (1030, 1), (1040, 1), (1050, 1), (1060, 1), (1070, 1), (1080, 1), (1090, 1), (1100, 0), (1110, 0), (1120, 0), (1130, 0), (1140, 0), (1150, 1), (1160, 1), (1170, 1), (1180, 0), (1190, 0), (1200, 0), (1210, 0), (1220, 1), (1230, 0), (1240, 1), (1250, 1), (1260, 1), (1270, 1), (1280, 1), (1290, 1), (1300, 1), (1310, 1), (1320, 0), (1330, 0), (1340, 0), (1350, 0), (1360, 0), (1370, 0), (1380, 1), (1390, 1), (1400, 0), (1410, 1), (1420, 1), (1430, 1), (1440, 1), (1450, 1), (1460, 0), (1470, 0), (1480, 0), (1490, 0), (1500, 0), (1510, 1), (1520, 1), (1530, 1), (1540, 0), (1550, 1), (1560, 1), (1570, 1), (1580, 0), (1590, 1), (1600, 1), (1610, 0), (1620, 0), (1630, 0), (1640, 1), (1650, 1), (1660, 1), (1670, 0), (1680, 0), (1690, 1), (1700, 1), (1710, 0), (1720, 0), (1730, 0), (1740, 0), (1750, 0), (1760, 1), (1770, 1), (1780, 0), (1790, 1), (1800, 0), (1810, 1), (1820, 1), (1830, 0), (1840, 1), (1850, 1), (1860, 0), (1870, 0), (1880, 0), (1890, 0), (1900, 0), (1910, 0), (1920, 0), (1930, 0), (1940, 1), (1950, 0), (1960, 0), (1970, 0), (1980, 0), (1990, 1), (2000, 1), (2010, 1), (2020, 0), (2030, 1), (2040, 1), (2050, 1)]
Vdin0_27  din0_27  0 PWL (0n 0.0v 9.495n 0.0v 9.505n 0.0v 19.495n 0.0v 19.505n 0.0v 29.495n 0.0v 29.505n 0.0v 39.495n 0.0v 39.505n 0.0v 49.495n 0.0v 49.505n 0.0v 59.495n 0.0v 59.505n 0.0v 69.495n 0.0v 69.505n 0.0v 79.495n 0.0v 79.505n 1.7v 89.495n 1.7v 89.505n 1.7v 99.495n 1.7v 99.505n 1.7v 109.495n 1.7v 109.505n 1.7v 119.495n 1.7v 119.505n 1.7v 129.495n 1.7v 129.505n 1.7v 139.495n 1.7v 139.505n 0.0v 149.495n 0.0v 149.505n 0.0v 159.495n 0.0v 159.505n 0.0v 169.495n 0.0v 169.505n 0.0v 179.495n 0.0v 179.505n 1.7v 189.495n 1.7v 189.505n 1.7v 199.495n 1.7v 199.505n 1.7v 209.495n 1.7v 209.505n 1.7v 219.495n 1.7v 219.505n 1.7v 229.495n 1.7v 229.505n 1.7v 239.495n 1.7v 239.505n 0.0v 249.495n 0.0v 249.505n 0.0v 259.495n 0.0v 259.505n 0.0v 269.495n 0.0v 269.505n 0.0v 279.495n 0.0v 279.505n 0.0v 289.495n 0.0v 289.505n 0.0v 299.495n 0.0v 299.505n 1.7v 309.495n 1.7v 309.505n 0.0v 319.495n 0.0v 319.505n 1.7v 329.495n 1.7v 329.505n 0.0v 339.495n 0.0v 339.505n 0.0v 349.495n 0.0v 349.505n 0.0v 359.495n 0.0v 359.505n 0.0v 369.495n 0.0v 369.505n 0.0v 379.495n 0.0v 379.505n 0.0v 389.495n 0.0v 389.505n 0.0v 399.495n 0.0v 399.505n 0.0v 409.495n 0.0v 409.505n 0.0v 419.495n 0.0v 419.505n 0.0v 429.495n 0.0v 429.505n 0.0v 439.495n 0.0v 439.505n 0.0v 449.495n 0.0v 449.505n 0.0v 459.495n 0.0v 459.505n 1.7v 469.495n 1.7v 469.505n 0.0v 479.495n 0.0v 479.505n 0.0v 489.495n 0.0v 489.505n 0.0v 499.495n 0.0v 499.505n 0.0v 509.495n 0.0v 509.505n 0.0v 519.495n 0.0v 519.505n 0.0v 529.495n 0.0v 529.505n 0.0v 539.495n 0.0v 539.505n 1.7v 549.495n 1.7v 549.505n 0.0v 559.495n 0.0v 559.505n 0.0v 569.495n 0.0v 569.505n 0.0v 579.495n 0.0v 579.505n 0.0v 589.495n 0.0v 589.505n 1.7v 599.495n 1.7v 599.505n 1.7v 609.495n 1.7v 609.505n 1.7v 619.495n 1.7v 619.505n 1.7v 629.495n 1.7v 629.505n 0.0v 639.495n 0.0v 639.505n 1.7v 649.495n 1.7v 649.505n 1.7v 659.495n 1.7v 659.505n 1.7v 669.495n 1.7v 669.505n 1.7v 679.495n 1.7v 679.505n 1.7v 689.495n 1.7v 689.505n 1.7v 699.495n 1.7v 699.505n 0.0v 709.495n 0.0v 709.505n 0.0v 719.495n 0.0v 719.505n 0.0v 729.495n 0.0v 729.505n 0.0v 739.495n 0.0v 739.505n 1.7v 749.495n 1.7v 749.505n 1.7v 759.495n 1.7v 759.505n 1.7v 769.495n 1.7v 769.505n 1.7v 779.495n 1.7v 779.505n 1.7v 789.495n 1.7v 789.505n 1.7v 799.495n 1.7v 799.505n 1.7v 809.495n 1.7v 809.505n 0.0v 819.495n 0.0v 819.505n 1.7v 829.495n 1.7v 829.505n 1.7v 839.495n 1.7v 839.505n 1.7v 849.495n 1.7v 849.505n 0.0v 859.495n 0.0v 859.505n 0.0v 869.495n 0.0v 869.505n 1.7v 879.495n 1.7v 879.505n 1.7v 889.495n 1.7v 889.505n 1.7v 899.495n 1.7v 899.505n 1.7v 909.495n 1.7v 909.505n 1.7v 919.495n 1.7v 919.505n 1.7v 929.495n 1.7v 929.505n 0.0v 939.495n 0.0v 939.505n 0.0v 949.495n 0.0v 949.505n 1.7v 959.495n 1.7v 959.505n 1.7v 969.495n 1.7v 969.505n 1.7v 979.495n 1.7v 979.505n 1.7v 989.495n 1.7v 989.505n 1.7v 999.495n 1.7v 999.505n 1.7v 1009.495n 1.7v 1009.505n 1.7v 1019.495n 1.7v 1019.505n 1.7v 1029.495n 1.7v 1029.505n 1.7v 1039.495n 1.7v 1039.505n 1.7v 1049.495n 1.7v 1049.505n 1.7v 1059.495n 1.7v 1059.505n 1.7v 1069.495n 1.7v 1069.505n 1.7v 1079.495n 1.7v 1079.505n 1.7v 1089.495n 1.7v 1089.505n 1.7v 1099.495n 1.7v 1099.505n 0.0v 1109.495n 0.0v 1109.505n 0.0v 1119.495n 0.0v 1119.505n 0.0v 1129.495n 0.0v 1129.505n 0.0v 1139.495n 0.0v 1139.505n 0.0v 1149.495n 0.0v 1149.505n 1.7v 1159.495n 1.7v 1159.505n 1.7v 1169.495n 1.7v 1169.505n 1.7v 1179.495n 1.7v 1179.505n 0.0v 1189.495n 0.0v 1189.505n 0.0v 1199.495n 0.0v 1199.505n 0.0v 1209.495n 0.0v 1209.505n 0.0v 1219.495n 0.0v 1219.505n 1.7v 1229.495n 1.7v 1229.505n 0.0v 1239.495n 0.0v 1239.505n 1.7v 1249.495n 1.7v 1249.505n 1.7v 1259.495n 1.7v 1259.505n 1.7v 1269.495n 1.7v 1269.505n 1.7v 1279.495n 1.7v 1279.505n 1.7v 1289.495n 1.7v 1289.505n 1.7v 1299.495n 1.7v 1299.505n 1.7v 1309.495n 1.7v 1309.505n 1.7v 1319.495n 1.7v 1319.505n 0.0v 1329.495n 0.0v 1329.505n 0.0v 1339.495n 0.0v 1339.505n 0.0v 1349.495n 0.0v 1349.505n 0.0v 1359.495n 0.0v 1359.505n 0.0v 1369.495n 0.0v 1369.505n 0.0v 1379.495n 0.0v 1379.505n 1.7v 1389.495n 1.7v 1389.505n 1.7v 1399.495n 1.7v 1399.505n 0.0v 1409.495n 0.0v 1409.505n 1.7v 1419.495n 1.7v 1419.505n 1.7v 1429.495n 1.7v 1429.505n 1.7v 1439.495n 1.7v 1439.505n 1.7v 1449.495n 1.7v 1449.505n 1.7v 1459.495n 1.7v 1459.505n 0.0v 1469.495n 0.0v 1469.505n 0.0v 1479.495n 0.0v 1479.505n 0.0v 1489.495n 0.0v 1489.505n 0.0v 1499.495n 0.0v 1499.505n 0.0v 1509.495n 0.0v 1509.505n 1.7v 1519.495n 1.7v 1519.505n 1.7v 1529.495n 1.7v 1529.505n 1.7v 1539.495n 1.7v 1539.505n 0.0v 1549.495n 0.0v 1549.505n 1.7v 1559.495n 1.7v 1559.505n 1.7v 1569.495n 1.7v 1569.505n 1.7v 1579.495n 1.7v 1579.505n 0.0v 1589.495n 0.0v 1589.505n 1.7v 1599.495n 1.7v 1599.505n 1.7v 1609.495n 1.7v 1609.505n 0.0v 1619.495n 0.0v 1619.505n 0.0v 1629.495n 0.0v 1629.505n 0.0v 1639.495n 0.0v 1639.505n 1.7v 1649.495n 1.7v 1649.505n 1.7v 1659.495n 1.7v 1659.505n 1.7v 1669.495n 1.7v 1669.505n 0.0v 1679.495n 0.0v 1679.505n 0.0v 1689.495n 0.0v 1689.505n 1.7v 1699.495n 1.7v 1699.505n 1.7v 1709.495n 1.7v 1709.505n 0.0v 1719.495n 0.0v 1719.505n 0.0v 1729.495n 0.0v 1729.505n 0.0v 1739.495n 0.0v 1739.505n 0.0v 1749.495n 0.0v 1749.505n 0.0v 1759.495n 0.0v 1759.505n 1.7v 1769.495n 1.7v 1769.505n 1.7v 1779.495n 1.7v 1779.505n 0.0v 1789.495n 0.0v 1789.505n 1.7v 1799.495n 1.7v 1799.505n 0.0v 1809.495n 0.0v 1809.505n 1.7v 1819.495n 1.7v 1819.505n 1.7v 1829.495n 1.7v 1829.505n 0.0v 1839.495n 0.0v 1839.505n 1.7v 1849.495n 1.7v 1849.505n 1.7v 1859.495n 1.7v 1859.505n 0.0v 1869.495n 0.0v 1869.505n 0.0v 1879.495n 0.0v 1879.505n 0.0v 1889.495n 0.0v 1889.505n 0.0v 1899.495n 0.0v 1899.505n 0.0v 1909.495n 0.0v 1909.505n 0.0v 1919.495n 0.0v 1919.505n 0.0v 1929.495n 0.0v 1929.505n 0.0v 1939.495n 0.0v 1939.505n 1.7v 1949.495n 1.7v 1949.505n 0.0v 1959.495n 0.0v 1959.505n 0.0v 1969.495n 0.0v 1969.505n 0.0v 1979.495n 0.0v 1979.505n 0.0v 1989.495n 0.0v 1989.505n 1.7v 1999.495n 1.7v 1999.505n 1.7v 2009.495n 1.7v 2009.505n 1.7v 2019.495n 1.7v 2019.505n 0.0v 2029.495n 0.0v 2029.505n 1.7v 2039.495n 1.7v 2039.505n 1.7v 2049.495n 1.7v 2049.505n 1.7v )
* (time, data): [(0, 0), (10, 1), (20, 1), (30, 1), (40, 1), (50, 1), (60, 1), (70, 1), (80, 0), (90, 0), (100, 0), (110, 0), (120, 0), (130, 1), (140, 0), (150, 0), (160, 0), (170, 0), (180, 0), (190, 0), (200, 0), (210, 1), (220, 1), (230, 1), (240, 1), (250, 1), (260, 1), (270, 1), (280, 1), (290, 1), (300, 0), (310, 1), (320, 1), (330, 1), (340, 1), (350, 1), (360, 1), (370, 1), (380, 1), (390, 1), (400, 1), (410, 1), (420, 1), (430, 0), (440, 1), (450, 1), (460, 0), (470, 0), (480, 0), (490, 0), (500, 0), (510, 1), (520, 1), (530, 0), (540, 1), (550, 1), (560, 1), (570, 1), (580, 1), (590, 1), (600, 1), (610, 1), (620, 1), (630, 0), (640, 0), (650, 0), (660, 1), (670, 1), (680, 1), (690, 1), (700, 0), (710, 1), (720, 1), (730, 1), (740, 1), (750, 0), (760, 0), (770, 1), (780, 1), (790, 1), (800, 1), (810, 1), (820, 0), (830, 0), (840, 0), (850, 1), (860, 1), (870, 1), (880, 1), (890, 1), (900, 1), (910, 1), (920, 1), (930, 1), (940, 0), (950, 1), (960, 1), (970, 1), (980, 0), (990, 0), (1000, 0), (1010, 0), (1020, 0), (1030, 0), (1040, 0), (1050, 0), (1060, 0), (1070, 0), (1080, 0), (1090, 1), (1100, 0), (1110, 1), (1120, 1), (1130, 1), (1140, 1), (1150, 1), (1160, 1), (1170, 0), (1180, 0), (1190, 0), (1200, 1), (1210, 1), (1220, 1), (1230, 1), (1240, 1), (1250, 1), (1260, 1), (1270, 1), (1280, 1), (1290, 0), (1300, 0), (1310, 0), (1320, 1), (1330, 1), (1340, 1), (1350, 0), (1360, 0), (1370, 0), (1380, 1), (1390, 1), (1400, 1), (1410, 0), (1420, 0), (1430, 0), (1440, 1), (1450, 1), (1460, 1), (1470, 1), (1480, 1), (1490, 0), (1500, 0), (1510, 0), (1520, 0), (1530, 1), (1540, 0), (1550, 1), (1560, 1), (1570, 1), (1580, 1), (1590, 1), (1600, 1), (1610, 1), (1620, 1), (1630, 1), (1640, 0), (1650, 0), (1660, 0), (1670, 1), (1680, 0), (1690, 0), (1700, 1), (1710, 1), (1720, 0), (1730, 0), (1740, 1), (1750, 1), (1760, 0), (1770, 1), (1780, 1), (1790, 1), (1800, 1), (1810, 0), (1820, 1), (1830, 0), (1840, 0), (1850, 0), (1860, 0), (1870, 0), (1880, 1), (1890, 1), (1900, 0), (1910, 0), (1920, 1), (1930, 1), (1940, 1), (1950, 1), (1960, 1), (1970, 1), (1980, 1), (1990, 0), (2000, 0), (2010, 0), (2020, 1), (2030, 0), (2040, 0), (2050, 0)]
Vdin0_28  din0_28  0 PWL (0n 0.0v 9.495n 0.0v 9.505n 1.7v 19.495n 1.7v 19.505n 1.7v 29.495n 1.7v 29.505n 1.7v 39.495n 1.7v 39.505n 1.7v 49.495n 1.7v 49.505n 1.7v 59.495n 1.7v 59.505n 1.7v 69.495n 1.7v 69.505n 1.7v 79.495n 1.7v 79.505n 0.0v 89.495n 0.0v 89.505n 0.0v 99.495n 0.0v 99.505n 0.0v 109.495n 0.0v 109.505n 0.0v 119.495n 0.0v 119.505n 0.0v 129.495n 0.0v 129.505n 1.7v 139.495n 1.7v 139.505n 0.0v 149.495n 0.0v 149.505n 0.0v 159.495n 0.0v 159.505n 0.0v 169.495n 0.0v 169.505n 0.0v 179.495n 0.0v 179.505n 0.0v 189.495n 0.0v 189.505n 0.0v 199.495n 0.0v 199.505n 0.0v 209.495n 0.0v 209.505n 1.7v 219.495n 1.7v 219.505n 1.7v 229.495n 1.7v 229.505n 1.7v 239.495n 1.7v 239.505n 1.7v 249.495n 1.7v 249.505n 1.7v 259.495n 1.7v 259.505n 1.7v 269.495n 1.7v 269.505n 1.7v 279.495n 1.7v 279.505n 1.7v 289.495n 1.7v 289.505n 1.7v 299.495n 1.7v 299.505n 0.0v 309.495n 0.0v 309.505n 1.7v 319.495n 1.7v 319.505n 1.7v 329.495n 1.7v 329.505n 1.7v 339.495n 1.7v 339.505n 1.7v 349.495n 1.7v 349.505n 1.7v 359.495n 1.7v 359.505n 1.7v 369.495n 1.7v 369.505n 1.7v 379.495n 1.7v 379.505n 1.7v 389.495n 1.7v 389.505n 1.7v 399.495n 1.7v 399.505n 1.7v 409.495n 1.7v 409.505n 1.7v 419.495n 1.7v 419.505n 1.7v 429.495n 1.7v 429.505n 0.0v 439.495n 0.0v 439.505n 1.7v 449.495n 1.7v 449.505n 1.7v 459.495n 1.7v 459.505n 0.0v 469.495n 0.0v 469.505n 0.0v 479.495n 0.0v 479.505n 0.0v 489.495n 0.0v 489.505n 0.0v 499.495n 0.0v 499.505n 0.0v 509.495n 0.0v 509.505n 1.7v 519.495n 1.7v 519.505n 1.7v 529.495n 1.7v 529.505n 0.0v 539.495n 0.0v 539.505n 1.7v 549.495n 1.7v 549.505n 1.7v 559.495n 1.7v 559.505n 1.7v 569.495n 1.7v 569.505n 1.7v 579.495n 1.7v 579.505n 1.7v 589.495n 1.7v 589.505n 1.7v 599.495n 1.7v 599.505n 1.7v 609.495n 1.7v 609.505n 1.7v 619.495n 1.7v 619.505n 1.7v 629.495n 1.7v 629.505n 0.0v 639.495n 0.0v 639.505n 0.0v 649.495n 0.0v 649.505n 0.0v 659.495n 0.0v 659.505n 1.7v 669.495n 1.7v 669.505n 1.7v 679.495n 1.7v 679.505n 1.7v 689.495n 1.7v 689.505n 1.7v 699.495n 1.7v 699.505n 0.0v 709.495n 0.0v 709.505n 1.7v 719.495n 1.7v 719.505n 1.7v 729.495n 1.7v 729.505n 1.7v 739.495n 1.7v 739.505n 1.7v 749.495n 1.7v 749.505n 0.0v 759.495n 0.0v 759.505n 0.0v 769.495n 0.0v 769.505n 1.7v 779.495n 1.7v 779.505n 1.7v 789.495n 1.7v 789.505n 1.7v 799.495n 1.7v 799.505n 1.7v 809.495n 1.7v 809.505n 1.7v 819.495n 1.7v 819.505n 0.0v 829.495n 0.0v 829.505n 0.0v 839.495n 0.0v 839.505n 0.0v 849.495n 0.0v 849.505n 1.7v 859.495n 1.7v 859.505n 1.7v 869.495n 1.7v 869.505n 1.7v 879.495n 1.7v 879.505n 1.7v 889.495n 1.7v 889.505n 1.7v 899.495n 1.7v 899.505n 1.7v 909.495n 1.7v 909.505n 1.7v 919.495n 1.7v 919.505n 1.7v 929.495n 1.7v 929.505n 1.7v 939.495n 1.7v 939.505n 0.0v 949.495n 0.0v 949.505n 1.7v 959.495n 1.7v 959.505n 1.7v 969.495n 1.7v 969.505n 1.7v 979.495n 1.7v 979.505n 0.0v 989.495n 0.0v 989.505n 0.0v 999.495n 0.0v 999.505n 0.0v 1009.495n 0.0v 1009.505n 0.0v 1019.495n 0.0v 1019.505n 0.0v 1029.495n 0.0v 1029.505n 0.0v 1039.495n 0.0v 1039.505n 0.0v 1049.495n 0.0v 1049.505n 0.0v 1059.495n 0.0v 1059.505n 0.0v 1069.495n 0.0v 1069.505n 0.0v 1079.495n 0.0v 1079.505n 0.0v 1089.495n 0.0v 1089.505n 1.7v 1099.495n 1.7v 1099.505n 0.0v 1109.495n 0.0v 1109.505n 1.7v 1119.495n 1.7v 1119.505n 1.7v 1129.495n 1.7v 1129.505n 1.7v 1139.495n 1.7v 1139.505n 1.7v 1149.495n 1.7v 1149.505n 1.7v 1159.495n 1.7v 1159.505n 1.7v 1169.495n 1.7v 1169.505n 0.0v 1179.495n 0.0v 1179.505n 0.0v 1189.495n 0.0v 1189.505n 0.0v 1199.495n 0.0v 1199.505n 1.7v 1209.495n 1.7v 1209.505n 1.7v 1219.495n 1.7v 1219.505n 1.7v 1229.495n 1.7v 1229.505n 1.7v 1239.495n 1.7v 1239.505n 1.7v 1249.495n 1.7v 1249.505n 1.7v 1259.495n 1.7v 1259.505n 1.7v 1269.495n 1.7v 1269.505n 1.7v 1279.495n 1.7v 1279.505n 1.7v 1289.495n 1.7v 1289.505n 0.0v 1299.495n 0.0v 1299.505n 0.0v 1309.495n 0.0v 1309.505n 0.0v 1319.495n 0.0v 1319.505n 1.7v 1329.495n 1.7v 1329.505n 1.7v 1339.495n 1.7v 1339.505n 1.7v 1349.495n 1.7v 1349.505n 0.0v 1359.495n 0.0v 1359.505n 0.0v 1369.495n 0.0v 1369.505n 0.0v 1379.495n 0.0v 1379.505n 1.7v 1389.495n 1.7v 1389.505n 1.7v 1399.495n 1.7v 1399.505n 1.7v 1409.495n 1.7v 1409.505n 0.0v 1419.495n 0.0v 1419.505n 0.0v 1429.495n 0.0v 1429.505n 0.0v 1439.495n 0.0v 1439.505n 1.7v 1449.495n 1.7v 1449.505n 1.7v 1459.495n 1.7v 1459.505n 1.7v 1469.495n 1.7v 1469.505n 1.7v 1479.495n 1.7v 1479.505n 1.7v 1489.495n 1.7v 1489.505n 0.0v 1499.495n 0.0v 1499.505n 0.0v 1509.495n 0.0v 1509.505n 0.0v 1519.495n 0.0v 1519.505n 0.0v 1529.495n 0.0v 1529.505n 1.7v 1539.495n 1.7v 1539.505n 0.0v 1549.495n 0.0v 1549.505n 1.7v 1559.495n 1.7v 1559.505n 1.7v 1569.495n 1.7v 1569.505n 1.7v 1579.495n 1.7v 1579.505n 1.7v 1589.495n 1.7v 1589.505n 1.7v 1599.495n 1.7v 1599.505n 1.7v 1609.495n 1.7v 1609.505n 1.7v 1619.495n 1.7v 1619.505n 1.7v 1629.495n 1.7v 1629.505n 1.7v 1639.495n 1.7v 1639.505n 0.0v 1649.495n 0.0v 1649.505n 0.0v 1659.495n 0.0v 1659.505n 0.0v 1669.495n 0.0v 1669.505n 1.7v 1679.495n 1.7v 1679.505n 0.0v 1689.495n 0.0v 1689.505n 0.0v 1699.495n 0.0v 1699.505n 1.7v 1709.495n 1.7v 1709.505n 1.7v 1719.495n 1.7v 1719.505n 0.0v 1729.495n 0.0v 1729.505n 0.0v 1739.495n 0.0v 1739.505n 1.7v 1749.495n 1.7v 1749.505n 1.7v 1759.495n 1.7v 1759.505n 0.0v 1769.495n 0.0v 1769.505n 1.7v 1779.495n 1.7v 1779.505n 1.7v 1789.495n 1.7v 1789.505n 1.7v 1799.495n 1.7v 1799.505n 1.7v 1809.495n 1.7v 1809.505n 0.0v 1819.495n 0.0v 1819.505n 1.7v 1829.495n 1.7v 1829.505n 0.0v 1839.495n 0.0v 1839.505n 0.0v 1849.495n 0.0v 1849.505n 0.0v 1859.495n 0.0v 1859.505n 0.0v 1869.495n 0.0v 1869.505n 0.0v 1879.495n 0.0v 1879.505n 1.7v 1889.495n 1.7v 1889.505n 1.7v 1899.495n 1.7v 1899.505n 0.0v 1909.495n 0.0v 1909.505n 0.0v 1919.495n 0.0v 1919.505n 1.7v 1929.495n 1.7v 1929.505n 1.7v 1939.495n 1.7v 1939.505n 1.7v 1949.495n 1.7v 1949.505n 1.7v 1959.495n 1.7v 1959.505n 1.7v 1969.495n 1.7v 1969.505n 1.7v 1979.495n 1.7v 1979.505n 1.7v 1989.495n 1.7v 1989.505n 0.0v 1999.495n 0.0v 1999.505n 0.0v 2009.495n 0.0v 2009.505n 0.0v 2019.495n 0.0v 2019.505n 1.7v 2029.495n 1.7v 2029.505n 0.0v 2039.495n 0.0v 2039.505n 0.0v 2049.495n 0.0v 2049.505n 0.0v )
* (time, data): [(0, 0), (10, 0), (20, 0), (30, 1), (40, 1), (50, 0), (60, 1), (70, 1), (80, 0), (90, 0), (100, 0), (110, 0), (120, 1), (130, 0), (140, 1), (150, 1), (160, 1), (170, 1), (180, 1), (190, 1), (200, 1), (210, 1), (220, 1), (230, 1), (240, 0), (250, 0), (260, 0), (270, 0), (280, 0), (290, 0), (300, 0), (310, 1), (320, 1), (330, 1), (340, 1), (350, 1), (360, 1), (370, 1), (380, 1), (390, 1), (400, 1), (410, 1), (420, 1), (430, 1), (440, 1), (450, 1), (460, 1), (470, 0), (480, 0), (490, 0), (500, 0), (510, 1), (520, 0), (530, 0), (540, 1), (550, 0), (560, 0), (570, 0), (580, 0), (590, 1), (600, 1), (610, 1), (620, 1), (630, 0), (640, 1), (650, 1), (660, 0), (670, 0), (680, 0), (690, 0), (700, 1), (710, 0), (720, 0), (730, 0), (740, 0), (750, 1), (760, 0), (770, 0), (780, 0), (790, 0), (800, 0), (810, 1), (820, 1), (830, 1), (840, 1), (850, 1), (860, 1), (870, 1), (880, 1), (890, 1), (900, 1), (910, 1), (920, 1), (930, 0), (940, 1), (950, 0), (960, 0), (970, 1), (980, 1), (990, 1), (1000, 1), (1010, 1), (1020, 1), (1030, 1), (1040, 1), (1050, 1), (1060, 1), (1070, 1), (1080, 1), (1090, 1), (1100, 0), (1110, 0), (1120, 0), (1130, 0), (1140, 1), (1150, 0), (1160, 0), (1170, 0), (1180, 1), (1190, 1), (1200, 1), (1210, 0), (1220, 1), (1230, 1), (1240, 0), (1250, 0), (1260, 0), (1270, 1), (1280, 1), (1290, 0), (1300, 0), (1310, 0), (1320, 1), (1330, 1), (1340, 1), (1350, 0), (1360, 0), (1370, 1), (1380, 1), (1390, 1), (1400, 0), (1410, 0), (1420, 0), (1430, 0), (1440, 0), (1450, 0), (1460, 1), (1470, 1), (1480, 1), (1490, 1), (1500, 1), (1510, 1), (1520, 1), (1530, 0), (1540, 1), (1550, 0), (1560, 0), (1570, 0), (1580, 1), (1590, 0), (1600, 0), (1610, 1), (1620, 1), (1630, 1), (1640, 1), (1650, 1), (1660, 1), (1670, 0), (1680, 0), (1690, 0), (1700, 1), (1710, 1), (1720, 0), (1730, 0), (1740, 0), (1750, 0), (1760, 1), (1770, 1), (1780, 1), (1790, 1), (1800, 1), (1810, 1), (1820, 1), (1830, 0), (1840, 0), (1850, 0), (1860, 1), (1870, 1), (1880, 1), (1890, 1), (1900, 1), (1910, 1), (1920, 0), (1930, 1), (1940, 1), (1950, 1), (1960, 1), (1970, 1), (1980, 1), (1990, 1), (2000, 1), (2010, 1), (2020, 1), (2030, 0), (2040, 0), (2050, 0)]
Vdin0_29  din0_29  0 PWL (0n 0.0v 9.495n 0.0v 9.505n 0.0v 19.495n 0.0v 19.505n 0.0v 29.495n 0.0v 29.505n 1.7v 39.495n 1.7v 39.505n 1.7v 49.495n 1.7v 49.505n 0.0v 59.495n 0.0v 59.505n 1.7v 69.495n 1.7v 69.505n 1.7v 79.495n 1.7v 79.505n 0.0v 89.495n 0.0v 89.505n 0.0v 99.495n 0.0v 99.505n 0.0v 109.495n 0.0v 109.505n 0.0v 119.495n 0.0v 119.505n 1.7v 129.495n 1.7v 129.505n 0.0v 139.495n 0.0v 139.505n 1.7v 149.495n 1.7v 149.505n 1.7v 159.495n 1.7v 159.505n 1.7v 169.495n 1.7v 169.505n 1.7v 179.495n 1.7v 179.505n 1.7v 189.495n 1.7v 189.505n 1.7v 199.495n 1.7v 199.505n 1.7v 209.495n 1.7v 209.505n 1.7v 219.495n 1.7v 219.505n 1.7v 229.495n 1.7v 229.505n 1.7v 239.495n 1.7v 239.505n 0.0v 249.495n 0.0v 249.505n 0.0v 259.495n 0.0v 259.505n 0.0v 269.495n 0.0v 269.505n 0.0v 279.495n 0.0v 279.505n 0.0v 289.495n 0.0v 289.505n 0.0v 299.495n 0.0v 299.505n 0.0v 309.495n 0.0v 309.505n 1.7v 319.495n 1.7v 319.505n 1.7v 329.495n 1.7v 329.505n 1.7v 339.495n 1.7v 339.505n 1.7v 349.495n 1.7v 349.505n 1.7v 359.495n 1.7v 359.505n 1.7v 369.495n 1.7v 369.505n 1.7v 379.495n 1.7v 379.505n 1.7v 389.495n 1.7v 389.505n 1.7v 399.495n 1.7v 399.505n 1.7v 409.495n 1.7v 409.505n 1.7v 419.495n 1.7v 419.505n 1.7v 429.495n 1.7v 429.505n 1.7v 439.495n 1.7v 439.505n 1.7v 449.495n 1.7v 449.505n 1.7v 459.495n 1.7v 459.505n 1.7v 469.495n 1.7v 469.505n 0.0v 479.495n 0.0v 479.505n 0.0v 489.495n 0.0v 489.505n 0.0v 499.495n 0.0v 499.505n 0.0v 509.495n 0.0v 509.505n 1.7v 519.495n 1.7v 519.505n 0.0v 529.495n 0.0v 529.505n 0.0v 539.495n 0.0v 539.505n 1.7v 549.495n 1.7v 549.505n 0.0v 559.495n 0.0v 559.505n 0.0v 569.495n 0.0v 569.505n 0.0v 579.495n 0.0v 579.505n 0.0v 589.495n 0.0v 589.505n 1.7v 599.495n 1.7v 599.505n 1.7v 609.495n 1.7v 609.505n 1.7v 619.495n 1.7v 619.505n 1.7v 629.495n 1.7v 629.505n 0.0v 639.495n 0.0v 639.505n 1.7v 649.495n 1.7v 649.505n 1.7v 659.495n 1.7v 659.505n 0.0v 669.495n 0.0v 669.505n 0.0v 679.495n 0.0v 679.505n 0.0v 689.495n 0.0v 689.505n 0.0v 699.495n 0.0v 699.505n 1.7v 709.495n 1.7v 709.505n 0.0v 719.495n 0.0v 719.505n 0.0v 729.495n 0.0v 729.505n 0.0v 739.495n 0.0v 739.505n 0.0v 749.495n 0.0v 749.505n 1.7v 759.495n 1.7v 759.505n 0.0v 769.495n 0.0v 769.505n 0.0v 779.495n 0.0v 779.505n 0.0v 789.495n 0.0v 789.505n 0.0v 799.495n 0.0v 799.505n 0.0v 809.495n 0.0v 809.505n 1.7v 819.495n 1.7v 819.505n 1.7v 829.495n 1.7v 829.505n 1.7v 839.495n 1.7v 839.505n 1.7v 849.495n 1.7v 849.505n 1.7v 859.495n 1.7v 859.505n 1.7v 869.495n 1.7v 869.505n 1.7v 879.495n 1.7v 879.505n 1.7v 889.495n 1.7v 889.505n 1.7v 899.495n 1.7v 899.505n 1.7v 909.495n 1.7v 909.505n 1.7v 919.495n 1.7v 919.505n 1.7v 929.495n 1.7v 929.505n 0.0v 939.495n 0.0v 939.505n 1.7v 949.495n 1.7v 949.505n 0.0v 959.495n 0.0v 959.505n 0.0v 969.495n 0.0v 969.505n 1.7v 979.495n 1.7v 979.505n 1.7v 989.495n 1.7v 989.505n 1.7v 999.495n 1.7v 999.505n 1.7v 1009.495n 1.7v 1009.505n 1.7v 1019.495n 1.7v 1019.505n 1.7v 1029.495n 1.7v 1029.505n 1.7v 1039.495n 1.7v 1039.505n 1.7v 1049.495n 1.7v 1049.505n 1.7v 1059.495n 1.7v 1059.505n 1.7v 1069.495n 1.7v 1069.505n 1.7v 1079.495n 1.7v 1079.505n 1.7v 1089.495n 1.7v 1089.505n 1.7v 1099.495n 1.7v 1099.505n 0.0v 1109.495n 0.0v 1109.505n 0.0v 1119.495n 0.0v 1119.505n 0.0v 1129.495n 0.0v 1129.505n 0.0v 1139.495n 0.0v 1139.505n 1.7v 1149.495n 1.7v 1149.505n 0.0v 1159.495n 0.0v 1159.505n 0.0v 1169.495n 0.0v 1169.505n 0.0v 1179.495n 0.0v 1179.505n 1.7v 1189.495n 1.7v 1189.505n 1.7v 1199.495n 1.7v 1199.505n 1.7v 1209.495n 1.7v 1209.505n 0.0v 1219.495n 0.0v 1219.505n 1.7v 1229.495n 1.7v 1229.505n 1.7v 1239.495n 1.7v 1239.505n 0.0v 1249.495n 0.0v 1249.505n 0.0v 1259.495n 0.0v 1259.505n 0.0v 1269.495n 0.0v 1269.505n 1.7v 1279.495n 1.7v 1279.505n 1.7v 1289.495n 1.7v 1289.505n 0.0v 1299.495n 0.0v 1299.505n 0.0v 1309.495n 0.0v 1309.505n 0.0v 1319.495n 0.0v 1319.505n 1.7v 1329.495n 1.7v 1329.505n 1.7v 1339.495n 1.7v 1339.505n 1.7v 1349.495n 1.7v 1349.505n 0.0v 1359.495n 0.0v 1359.505n 0.0v 1369.495n 0.0v 1369.505n 1.7v 1379.495n 1.7v 1379.505n 1.7v 1389.495n 1.7v 1389.505n 1.7v 1399.495n 1.7v 1399.505n 0.0v 1409.495n 0.0v 1409.505n 0.0v 1419.495n 0.0v 1419.505n 0.0v 1429.495n 0.0v 1429.505n 0.0v 1439.495n 0.0v 1439.505n 0.0v 1449.495n 0.0v 1449.505n 0.0v 1459.495n 0.0v 1459.505n 1.7v 1469.495n 1.7v 1469.505n 1.7v 1479.495n 1.7v 1479.505n 1.7v 1489.495n 1.7v 1489.505n 1.7v 1499.495n 1.7v 1499.505n 1.7v 1509.495n 1.7v 1509.505n 1.7v 1519.495n 1.7v 1519.505n 1.7v 1529.495n 1.7v 1529.505n 0.0v 1539.495n 0.0v 1539.505n 1.7v 1549.495n 1.7v 1549.505n 0.0v 1559.495n 0.0v 1559.505n 0.0v 1569.495n 0.0v 1569.505n 0.0v 1579.495n 0.0v 1579.505n 1.7v 1589.495n 1.7v 1589.505n 0.0v 1599.495n 0.0v 1599.505n 0.0v 1609.495n 0.0v 1609.505n 1.7v 1619.495n 1.7v 1619.505n 1.7v 1629.495n 1.7v 1629.505n 1.7v 1639.495n 1.7v 1639.505n 1.7v 1649.495n 1.7v 1649.505n 1.7v 1659.495n 1.7v 1659.505n 1.7v 1669.495n 1.7v 1669.505n 0.0v 1679.495n 0.0v 1679.505n 0.0v 1689.495n 0.0v 1689.505n 0.0v 1699.495n 0.0v 1699.505n 1.7v 1709.495n 1.7v 1709.505n 1.7v 1719.495n 1.7v 1719.505n 0.0v 1729.495n 0.0v 1729.505n 0.0v 1739.495n 0.0v 1739.505n 0.0v 1749.495n 0.0v 1749.505n 0.0v 1759.495n 0.0v 1759.505n 1.7v 1769.495n 1.7v 1769.505n 1.7v 1779.495n 1.7v 1779.505n 1.7v 1789.495n 1.7v 1789.505n 1.7v 1799.495n 1.7v 1799.505n 1.7v 1809.495n 1.7v 1809.505n 1.7v 1819.495n 1.7v 1819.505n 1.7v 1829.495n 1.7v 1829.505n 0.0v 1839.495n 0.0v 1839.505n 0.0v 1849.495n 0.0v 1849.505n 0.0v 1859.495n 0.0v 1859.505n 1.7v 1869.495n 1.7v 1869.505n 1.7v 1879.495n 1.7v 1879.505n 1.7v 1889.495n 1.7v 1889.505n 1.7v 1899.495n 1.7v 1899.505n 1.7v 1909.495n 1.7v 1909.505n 1.7v 1919.495n 1.7v 1919.505n 0.0v 1929.495n 0.0v 1929.505n 1.7v 1939.495n 1.7v 1939.505n 1.7v 1949.495n 1.7v 1949.505n 1.7v 1959.495n 1.7v 1959.505n 1.7v 1969.495n 1.7v 1969.505n 1.7v 1979.495n 1.7v 1979.505n 1.7v 1989.495n 1.7v 1989.505n 1.7v 1999.495n 1.7v 1999.505n 1.7v 2009.495n 1.7v 2009.505n 1.7v 2019.495n 1.7v 2019.505n 1.7v 2029.495n 1.7v 2029.505n 0.0v 2039.495n 0.0v 2039.505n 0.0v 2049.495n 0.0v 2049.505n 0.0v )
* (time, data): [(0, 0), (10, 0), (20, 0), (30, 0), (40, 0), (50, 1), (60, 0), (70, 0), (80, 1), (90, 1), (100, 1), (110, 1), (120, 1), (130, 1), (140, 1), (150, 1), (160, 1), (170, 1), (180, 0), (190, 0), (200, 0), (210, 0), (220, 0), (230, 0), (240, 0), (250, 0), (260, 0), (270, 0), (280, 0), (290, 0), (300, 1), (310, 1), (320, 1), (330, 1), (340, 1), (350, 1), (360, 1), (370, 1), (380, 1), (390, 1), (400, 1), (410, 1), (420, 1), (430, 1), (440, 1), (450, 1), (460, 1), (470, 1), (480, 1), (490, 1), (500, 1), (510, 0), (520, 1), (530, 1), (540, 0), (550, 1), (560, 1), (570, 1), (580, 1), (590, 0), (600, 0), (610, 0), (620, 0), (630, 0), (640, 0), (650, 0), (660, 1), (670, 0), (680, 0), (690, 1), (700, 0), (710, 0), (720, 0), (730, 0), (740, 1), (750, 1), (760, 1), (770, 1), (780, 1), (790, 1), (800, 1), (810, 0), (820, 1), (830, 1), (840, 1), (850, 0), (860, 0), (870, 1), (880, 1), (890, 1), (900, 1), (910, 1), (920, 1), (930, 0), (940, 1), (950, 0), (960, 0), (970, 0), (980, 1), (990, 1), (1000, 1), (1010, 1), (1020, 1), (1030, 1), (1040, 1), (1050, 1), (1060, 1), (1070, 1), (1080, 1), (1090, 1), (1100, 0), (1110, 0), (1120, 0), (1130, 0), (1140, 1), (1150, 0), (1160, 0), (1170, 1), (1180, 0), (1190, 0), (1200, 0), (1210, 1), (1220, 0), (1230, 0), (1240, 1), (1250, 1), (1260, 1), (1270, 0), (1280, 0), (1290, 1), (1300, 1), (1310, 1), (1320, 0), (1330, 0), (1340, 1), (1350, 0), (1360, 0), (1370, 0), (1380, 0), (1390, 0), (1400, 0), (1410, 0), (1420, 0), (1430, 0), (1440, 0), (1450, 0), (1460, 1), (1470, 1), (1480, 1), (1490, 0), (1500, 0), (1510, 0), (1520, 0), (1530, 1), (1540, 0), (1550, 0), (1560, 0), (1570, 0), (1580, 1), (1590, 1), (1600, 0), (1610, 1), (1620, 1), (1630, 1), (1640, 1), (1650, 1), (1660, 1), (1670, 0), (1680, 1), (1690, 0), (1700, 1), (1710, 1), (1720, 1), (1730, 1), (1740, 0), (1750, 0), (1760, 1), (1770, 1), (1780, 0), (1790, 1), (1800, 0), (1810, 1), (1820, 1), (1830, 1), (1840, 1), (1850, 1), (1860, 0), (1870, 0), (1880, 1), (1890, 1), (1900, 1), (1910, 1), (1920, 1), (1930, 0), (1940, 1), (1950, 0), (1960, 0), (1970, 1), (1980, 1), (1990, 1), (2000, 1), (2010, 1), (2020, 0), (2030, 1), (2040, 1), (2050, 1)]
Vdin0_30  din0_30  0 PWL (0n 0.0v 9.495n 0.0v 9.505n 0.0v 19.495n 0.0v 19.505n 0.0v 29.495n 0.0v 29.505n 0.0v 39.495n 0.0v 39.505n 0.0v 49.495n 0.0v 49.505n 1.7v 59.495n 1.7v 59.505n 0.0v 69.495n 0.0v 69.505n 0.0v 79.495n 0.0v 79.505n 1.7v 89.495n 1.7v 89.505n 1.7v 99.495n 1.7v 99.505n 1.7v 109.495n 1.7v 109.505n 1.7v 119.495n 1.7v 119.505n 1.7v 129.495n 1.7v 129.505n 1.7v 139.495n 1.7v 139.505n 1.7v 149.495n 1.7v 149.505n 1.7v 159.495n 1.7v 159.505n 1.7v 169.495n 1.7v 169.505n 1.7v 179.495n 1.7v 179.505n 0.0v 189.495n 0.0v 189.505n 0.0v 199.495n 0.0v 199.505n 0.0v 209.495n 0.0v 209.505n 0.0v 219.495n 0.0v 219.505n 0.0v 229.495n 0.0v 229.505n 0.0v 239.495n 0.0v 239.505n 0.0v 249.495n 0.0v 249.505n 0.0v 259.495n 0.0v 259.505n 0.0v 269.495n 0.0v 269.505n 0.0v 279.495n 0.0v 279.505n 0.0v 289.495n 0.0v 289.505n 0.0v 299.495n 0.0v 299.505n 1.7v 309.495n 1.7v 309.505n 1.7v 319.495n 1.7v 319.505n 1.7v 329.495n 1.7v 329.505n 1.7v 339.495n 1.7v 339.505n 1.7v 349.495n 1.7v 349.505n 1.7v 359.495n 1.7v 359.505n 1.7v 369.495n 1.7v 369.505n 1.7v 379.495n 1.7v 379.505n 1.7v 389.495n 1.7v 389.505n 1.7v 399.495n 1.7v 399.505n 1.7v 409.495n 1.7v 409.505n 1.7v 419.495n 1.7v 419.505n 1.7v 429.495n 1.7v 429.505n 1.7v 439.495n 1.7v 439.505n 1.7v 449.495n 1.7v 449.505n 1.7v 459.495n 1.7v 459.505n 1.7v 469.495n 1.7v 469.505n 1.7v 479.495n 1.7v 479.505n 1.7v 489.495n 1.7v 489.505n 1.7v 499.495n 1.7v 499.505n 1.7v 509.495n 1.7v 509.505n 0.0v 519.495n 0.0v 519.505n 1.7v 529.495n 1.7v 529.505n 1.7v 539.495n 1.7v 539.505n 0.0v 549.495n 0.0v 549.505n 1.7v 559.495n 1.7v 559.505n 1.7v 569.495n 1.7v 569.505n 1.7v 579.495n 1.7v 579.505n 1.7v 589.495n 1.7v 589.505n 0.0v 599.495n 0.0v 599.505n 0.0v 609.495n 0.0v 609.505n 0.0v 619.495n 0.0v 619.505n 0.0v 629.495n 0.0v 629.505n 0.0v 639.495n 0.0v 639.505n 0.0v 649.495n 0.0v 649.505n 0.0v 659.495n 0.0v 659.505n 1.7v 669.495n 1.7v 669.505n 0.0v 679.495n 0.0v 679.505n 0.0v 689.495n 0.0v 689.505n 1.7v 699.495n 1.7v 699.505n 0.0v 709.495n 0.0v 709.505n 0.0v 719.495n 0.0v 719.505n 0.0v 729.495n 0.0v 729.505n 0.0v 739.495n 0.0v 739.505n 1.7v 749.495n 1.7v 749.505n 1.7v 759.495n 1.7v 759.505n 1.7v 769.495n 1.7v 769.505n 1.7v 779.495n 1.7v 779.505n 1.7v 789.495n 1.7v 789.505n 1.7v 799.495n 1.7v 799.505n 1.7v 809.495n 1.7v 809.505n 0.0v 819.495n 0.0v 819.505n 1.7v 829.495n 1.7v 829.505n 1.7v 839.495n 1.7v 839.505n 1.7v 849.495n 1.7v 849.505n 0.0v 859.495n 0.0v 859.505n 0.0v 869.495n 0.0v 869.505n 1.7v 879.495n 1.7v 879.505n 1.7v 889.495n 1.7v 889.505n 1.7v 899.495n 1.7v 899.505n 1.7v 909.495n 1.7v 909.505n 1.7v 919.495n 1.7v 919.505n 1.7v 929.495n 1.7v 929.505n 0.0v 939.495n 0.0v 939.505n 1.7v 949.495n 1.7v 949.505n 0.0v 959.495n 0.0v 959.505n 0.0v 969.495n 0.0v 969.505n 0.0v 979.495n 0.0v 979.505n 1.7v 989.495n 1.7v 989.505n 1.7v 999.495n 1.7v 999.505n 1.7v 1009.495n 1.7v 1009.505n 1.7v 1019.495n 1.7v 1019.505n 1.7v 1029.495n 1.7v 1029.505n 1.7v 1039.495n 1.7v 1039.505n 1.7v 1049.495n 1.7v 1049.505n 1.7v 1059.495n 1.7v 1059.505n 1.7v 1069.495n 1.7v 1069.505n 1.7v 1079.495n 1.7v 1079.505n 1.7v 1089.495n 1.7v 1089.505n 1.7v 1099.495n 1.7v 1099.505n 0.0v 1109.495n 0.0v 1109.505n 0.0v 1119.495n 0.0v 1119.505n 0.0v 1129.495n 0.0v 1129.505n 0.0v 1139.495n 0.0v 1139.505n 1.7v 1149.495n 1.7v 1149.505n 0.0v 1159.495n 0.0v 1159.505n 0.0v 1169.495n 0.0v 1169.505n 1.7v 1179.495n 1.7v 1179.505n 0.0v 1189.495n 0.0v 1189.505n 0.0v 1199.495n 0.0v 1199.505n 0.0v 1209.495n 0.0v 1209.505n 1.7v 1219.495n 1.7v 1219.505n 0.0v 1229.495n 0.0v 1229.505n 0.0v 1239.495n 0.0v 1239.505n 1.7v 1249.495n 1.7v 1249.505n 1.7v 1259.495n 1.7v 1259.505n 1.7v 1269.495n 1.7v 1269.505n 0.0v 1279.495n 0.0v 1279.505n 0.0v 1289.495n 0.0v 1289.505n 1.7v 1299.495n 1.7v 1299.505n 1.7v 1309.495n 1.7v 1309.505n 1.7v 1319.495n 1.7v 1319.505n 0.0v 1329.495n 0.0v 1329.505n 0.0v 1339.495n 0.0v 1339.505n 1.7v 1349.495n 1.7v 1349.505n 0.0v 1359.495n 0.0v 1359.505n 0.0v 1369.495n 0.0v 1369.505n 0.0v 1379.495n 0.0v 1379.505n 0.0v 1389.495n 0.0v 1389.505n 0.0v 1399.495n 0.0v 1399.505n 0.0v 1409.495n 0.0v 1409.505n 0.0v 1419.495n 0.0v 1419.505n 0.0v 1429.495n 0.0v 1429.505n 0.0v 1439.495n 0.0v 1439.505n 0.0v 1449.495n 0.0v 1449.505n 0.0v 1459.495n 0.0v 1459.505n 1.7v 1469.495n 1.7v 1469.505n 1.7v 1479.495n 1.7v 1479.505n 1.7v 1489.495n 1.7v 1489.505n 0.0v 1499.495n 0.0v 1499.505n 0.0v 1509.495n 0.0v 1509.505n 0.0v 1519.495n 0.0v 1519.505n 0.0v 1529.495n 0.0v 1529.505n 1.7v 1539.495n 1.7v 1539.505n 0.0v 1549.495n 0.0v 1549.505n 0.0v 1559.495n 0.0v 1559.505n 0.0v 1569.495n 0.0v 1569.505n 0.0v 1579.495n 0.0v 1579.505n 1.7v 1589.495n 1.7v 1589.505n 1.7v 1599.495n 1.7v 1599.505n 0.0v 1609.495n 0.0v 1609.505n 1.7v 1619.495n 1.7v 1619.505n 1.7v 1629.495n 1.7v 1629.505n 1.7v 1639.495n 1.7v 1639.505n 1.7v 1649.495n 1.7v 1649.505n 1.7v 1659.495n 1.7v 1659.505n 1.7v 1669.495n 1.7v 1669.505n 0.0v 1679.495n 0.0v 1679.505n 1.7v 1689.495n 1.7v 1689.505n 0.0v 1699.495n 0.0v 1699.505n 1.7v 1709.495n 1.7v 1709.505n 1.7v 1719.495n 1.7v 1719.505n 1.7v 1729.495n 1.7v 1729.505n 1.7v 1739.495n 1.7v 1739.505n 0.0v 1749.495n 0.0v 1749.505n 0.0v 1759.495n 0.0v 1759.505n 1.7v 1769.495n 1.7v 1769.505n 1.7v 1779.495n 1.7v 1779.505n 0.0v 1789.495n 0.0v 1789.505n 1.7v 1799.495n 1.7v 1799.505n 0.0v 1809.495n 0.0v 1809.505n 1.7v 1819.495n 1.7v 1819.505n 1.7v 1829.495n 1.7v 1829.505n 1.7v 1839.495n 1.7v 1839.505n 1.7v 1849.495n 1.7v 1849.505n 1.7v 1859.495n 1.7v 1859.505n 0.0v 1869.495n 0.0v 1869.505n 0.0v 1879.495n 0.0v 1879.505n 1.7v 1889.495n 1.7v 1889.505n 1.7v 1899.495n 1.7v 1899.505n 1.7v 1909.495n 1.7v 1909.505n 1.7v 1919.495n 1.7v 1919.505n 1.7v 1929.495n 1.7v 1929.505n 0.0v 1939.495n 0.0v 1939.505n 1.7v 1949.495n 1.7v 1949.505n 0.0v 1959.495n 0.0v 1959.505n 0.0v 1969.495n 0.0v 1969.505n 1.7v 1979.495n 1.7v 1979.505n 1.7v 1989.495n 1.7v 1989.505n 1.7v 1999.495n 1.7v 1999.505n 1.7v 2009.495n 1.7v 2009.505n 1.7v 2019.495n 1.7v 2019.505n 0.0v 2029.495n 0.0v 2029.505n 1.7v 2039.495n 1.7v 2039.505n 1.7v 2049.495n 1.7v 2049.505n 1.7v )
* (time, data): [(0, 0), (10, 0), (20, 0), (30, 0), (40, 0), (50, 0), (60, 1), (70, 0), (80, 0), (90, 0), (100, 0), (110, 0), (120, 1), (130, 1), (140, 0), (150, 0), (160, 0), (170, 0), (180, 0), (190, 0), (200, 0), (210, 1), (220, 1), (230, 1), (240, 1), (250, 1), (260, 1), (270, 0), (280, 0), (290, 0), (300, 0), (310, 1), (320, 1), (330, 1), (340, 1), (350, 1), (360, 1), (370, 1), (380, 1), (390, 1), (400, 1), (410, 1), (420, 1), (430, 1), (440, 0), (450, 0), (460, 1), (470, 0), (480, 0), (490, 0), (500, 0), (510, 0), (520, 0), (530, 0), (540, 1), (550, 0), (560, 0), (570, 0), (580, 0), (590, 1), (600, 1), (610, 1), (620, 1), (630, 1), (640, 1), (650, 1), (660, 1), (670, 1), (680, 1), (690, 0), (700, 0), (710, 1), (720, 0), (730, 0), (740, 0), (750, 0), (760, 0), (770, 0), (780, 0), (790, 1), (800, 1), (810, 0), (820, 1), (830, 1), (840, 1), (850, 0), (860, 0), (870, 0), (880, 0), (890, 0), (900, 0), (910, 0), (920, 1), (930, 0), (940, 0), (950, 0), (960, 0), (970, 0), (980, 1), (990, 1), (1000, 1), (1010, 1), (1020, 1), (1030, 1), (1040, 0), (1050, 0), (1060, 0), (1070, 0), (1080, 0), (1090, 1), (1100, 0), (1110, 1), (1120, 1), (1130, 1), (1140, 1), (1150, 1), (1160, 1), (1170, 0), (1180, 0), (1190, 0), (1200, 1), (1210, 0), (1220, 1), (1230, 1), (1240, 0), (1250, 0), (1260, 0), (1270, 0), (1280, 0), (1290, 0), (1300, 0), (1310, 0), (1320, 1), (1330, 1), (1340, 0), (1350, 0), (1360, 0), (1370, 0), (1380, 1), (1390, 1), (1400, 0), (1410, 1), (1420, 1), (1430, 1), (1440, 1), (1450, 1), (1460, 1), (1470, 1), (1480, 1), (1490, 0), (1500, 0), (1510, 0), (1520, 0), (1530, 1), (1540, 1), (1550, 0), (1560, 0), (1570, 0), (1580, 0), (1590, 0), (1600, 0), (1610, 0), (1620, 0), (1630, 0), (1640, 0), (1650, 0), (1660, 0), (1670, 1), (1680, 0), (1690, 1), (1700, 0), (1710, 0), (1720, 1), (1730, 1), (1740, 1), (1750, 1), (1760, 0), (1770, 0), (1780, 0), (1790, 1), (1800, 1), (1810, 0), (1820, 1), (1830, 0), (1840, 0), (1850, 0), (1860, 1), (1870, 1), (1880, 0), (1890, 0), (1900, 0), (1910, 0), (1920, 1), (1930, 1), (1940, 1), (1950, 0), (1960, 0), (1970, 1), (1980, 1), (1990, 0), (2000, 0), (2010, 0), (2020, 0), (2030, 1), (2040, 1), (2050, 1)]
Vdin0_31  din0_31  0 PWL (0n 0.0v 9.495n 0.0v 9.505n 0.0v 19.495n 0.0v 19.505n 0.0v 29.495n 0.0v 29.505n 0.0v 39.495n 0.0v 39.505n 0.0v 49.495n 0.0v 49.505n 0.0v 59.495n 0.0v 59.505n 1.7v 69.495n 1.7v 69.505n 0.0v 79.495n 0.0v 79.505n 0.0v 89.495n 0.0v 89.505n 0.0v 99.495n 0.0v 99.505n 0.0v 109.495n 0.0v 109.505n 0.0v 119.495n 0.0v 119.505n 1.7v 129.495n 1.7v 129.505n 1.7v 139.495n 1.7v 139.505n 0.0v 149.495n 0.0v 149.505n 0.0v 159.495n 0.0v 159.505n 0.0v 169.495n 0.0v 169.505n 0.0v 179.495n 0.0v 179.505n 0.0v 189.495n 0.0v 189.505n 0.0v 199.495n 0.0v 199.505n 0.0v 209.495n 0.0v 209.505n 1.7v 219.495n 1.7v 219.505n 1.7v 229.495n 1.7v 229.505n 1.7v 239.495n 1.7v 239.505n 1.7v 249.495n 1.7v 249.505n 1.7v 259.495n 1.7v 259.505n 1.7v 269.495n 1.7v 269.505n 0.0v 279.495n 0.0v 279.505n 0.0v 289.495n 0.0v 289.505n 0.0v 299.495n 0.0v 299.505n 0.0v 309.495n 0.0v 309.505n 1.7v 319.495n 1.7v 319.505n 1.7v 329.495n 1.7v 329.505n 1.7v 339.495n 1.7v 339.505n 1.7v 349.495n 1.7v 349.505n 1.7v 359.495n 1.7v 359.505n 1.7v 369.495n 1.7v 369.505n 1.7v 379.495n 1.7v 379.505n 1.7v 389.495n 1.7v 389.505n 1.7v 399.495n 1.7v 399.505n 1.7v 409.495n 1.7v 409.505n 1.7v 419.495n 1.7v 419.505n 1.7v 429.495n 1.7v 429.505n 1.7v 439.495n 1.7v 439.505n 0.0v 449.495n 0.0v 449.505n 0.0v 459.495n 0.0v 459.505n 1.7v 469.495n 1.7v 469.505n 0.0v 479.495n 0.0v 479.505n 0.0v 489.495n 0.0v 489.505n 0.0v 499.495n 0.0v 499.505n 0.0v 509.495n 0.0v 509.505n 0.0v 519.495n 0.0v 519.505n 0.0v 529.495n 0.0v 529.505n 0.0v 539.495n 0.0v 539.505n 1.7v 549.495n 1.7v 549.505n 0.0v 559.495n 0.0v 559.505n 0.0v 569.495n 0.0v 569.505n 0.0v 579.495n 0.0v 579.505n 0.0v 589.495n 0.0v 589.505n 1.7v 599.495n 1.7v 599.505n 1.7v 609.495n 1.7v 609.505n 1.7v 619.495n 1.7v 619.505n 1.7v 629.495n 1.7v 629.505n 1.7v 639.495n 1.7v 639.505n 1.7v 649.495n 1.7v 649.505n 1.7v 659.495n 1.7v 659.505n 1.7v 669.495n 1.7v 669.505n 1.7v 679.495n 1.7v 679.505n 1.7v 689.495n 1.7v 689.505n 0.0v 699.495n 0.0v 699.505n 0.0v 709.495n 0.0v 709.505n 1.7v 719.495n 1.7v 719.505n 0.0v 729.495n 0.0v 729.505n 0.0v 739.495n 0.0v 739.505n 0.0v 749.495n 0.0v 749.505n 0.0v 759.495n 0.0v 759.505n 0.0v 769.495n 0.0v 769.505n 0.0v 779.495n 0.0v 779.505n 0.0v 789.495n 0.0v 789.505n 1.7v 799.495n 1.7v 799.505n 1.7v 809.495n 1.7v 809.505n 0.0v 819.495n 0.0v 819.505n 1.7v 829.495n 1.7v 829.505n 1.7v 839.495n 1.7v 839.505n 1.7v 849.495n 1.7v 849.505n 0.0v 859.495n 0.0v 859.505n 0.0v 869.495n 0.0v 869.505n 0.0v 879.495n 0.0v 879.505n 0.0v 889.495n 0.0v 889.505n 0.0v 899.495n 0.0v 899.505n 0.0v 909.495n 0.0v 909.505n 0.0v 919.495n 0.0v 919.505n 1.7v 929.495n 1.7v 929.505n 0.0v 939.495n 0.0v 939.505n 0.0v 949.495n 0.0v 949.505n 0.0v 959.495n 0.0v 959.505n 0.0v 969.495n 0.0v 969.505n 0.0v 979.495n 0.0v 979.505n 1.7v 989.495n 1.7v 989.505n 1.7v 999.495n 1.7v 999.505n 1.7v 1009.495n 1.7v 1009.505n 1.7v 1019.495n 1.7v 1019.505n 1.7v 1029.495n 1.7v 1029.505n 1.7v 1039.495n 1.7v 1039.505n 0.0v 1049.495n 0.0v 1049.505n 0.0v 1059.495n 0.0v 1059.505n 0.0v 1069.495n 0.0v 1069.505n 0.0v 1079.495n 0.0v 1079.505n 0.0v 1089.495n 0.0v 1089.505n 1.7v 1099.495n 1.7v 1099.505n 0.0v 1109.495n 0.0v 1109.505n 1.7v 1119.495n 1.7v 1119.505n 1.7v 1129.495n 1.7v 1129.505n 1.7v 1139.495n 1.7v 1139.505n 1.7v 1149.495n 1.7v 1149.505n 1.7v 1159.495n 1.7v 1159.505n 1.7v 1169.495n 1.7v 1169.505n 0.0v 1179.495n 0.0v 1179.505n 0.0v 1189.495n 0.0v 1189.505n 0.0v 1199.495n 0.0v 1199.505n 1.7v 1209.495n 1.7v 1209.505n 0.0v 1219.495n 0.0v 1219.505n 1.7v 1229.495n 1.7v 1229.505n 1.7v 1239.495n 1.7v 1239.505n 0.0v 1249.495n 0.0v 1249.505n 0.0v 1259.495n 0.0v 1259.505n 0.0v 1269.495n 0.0v 1269.505n 0.0v 1279.495n 0.0v 1279.505n 0.0v 1289.495n 0.0v 1289.505n 0.0v 1299.495n 0.0v 1299.505n 0.0v 1309.495n 0.0v 1309.505n 0.0v 1319.495n 0.0v 1319.505n 1.7v 1329.495n 1.7v 1329.505n 1.7v 1339.495n 1.7v 1339.505n 0.0v 1349.495n 0.0v 1349.505n 0.0v 1359.495n 0.0v 1359.505n 0.0v 1369.495n 0.0v 1369.505n 0.0v 1379.495n 0.0v 1379.505n 1.7v 1389.495n 1.7v 1389.505n 1.7v 1399.495n 1.7v 1399.505n 0.0v 1409.495n 0.0v 1409.505n 1.7v 1419.495n 1.7v 1419.505n 1.7v 1429.495n 1.7v 1429.505n 1.7v 1439.495n 1.7v 1439.505n 1.7v 1449.495n 1.7v 1449.505n 1.7v 1459.495n 1.7v 1459.505n 1.7v 1469.495n 1.7v 1469.505n 1.7v 1479.495n 1.7v 1479.505n 1.7v 1489.495n 1.7v 1489.505n 0.0v 1499.495n 0.0v 1499.505n 0.0v 1509.495n 0.0v 1509.505n 0.0v 1519.495n 0.0v 1519.505n 0.0v 1529.495n 0.0v 1529.505n 1.7v 1539.495n 1.7v 1539.505n 1.7v 1549.495n 1.7v 1549.505n 0.0v 1559.495n 0.0v 1559.505n 0.0v 1569.495n 0.0v 1569.505n 0.0v 1579.495n 0.0v 1579.505n 0.0v 1589.495n 0.0v 1589.505n 0.0v 1599.495n 0.0v 1599.505n 0.0v 1609.495n 0.0v 1609.505n 0.0v 1619.495n 0.0v 1619.505n 0.0v 1629.495n 0.0v 1629.505n 0.0v 1639.495n 0.0v 1639.505n 0.0v 1649.495n 0.0v 1649.505n 0.0v 1659.495n 0.0v 1659.505n 0.0v 1669.495n 0.0v 1669.505n 1.7v 1679.495n 1.7v 1679.505n 0.0v 1689.495n 0.0v 1689.505n 1.7v 1699.495n 1.7v 1699.505n 0.0v 1709.495n 0.0v 1709.505n 0.0v 1719.495n 0.0v 1719.505n 1.7v 1729.495n 1.7v 1729.505n 1.7v 1739.495n 1.7v 1739.505n 1.7v 1749.495n 1.7v 1749.505n 1.7v 1759.495n 1.7v 1759.505n 0.0v 1769.495n 0.0v 1769.505n 0.0v 1779.495n 0.0v 1779.505n 0.0v 1789.495n 0.0v 1789.505n 1.7v 1799.495n 1.7v 1799.505n 1.7v 1809.495n 1.7v 1809.505n 0.0v 1819.495n 0.0v 1819.505n 1.7v 1829.495n 1.7v 1829.505n 0.0v 1839.495n 0.0v 1839.505n 0.0v 1849.495n 0.0v 1849.505n 0.0v 1859.495n 0.0v 1859.505n 1.7v 1869.495n 1.7v 1869.505n 1.7v 1879.495n 1.7v 1879.505n 0.0v 1889.495n 0.0v 1889.505n 0.0v 1899.495n 0.0v 1899.505n 0.0v 1909.495n 0.0v 1909.505n 0.0v 1919.495n 0.0v 1919.505n 1.7v 1929.495n 1.7v 1929.505n 1.7v 1939.495n 1.7v 1939.505n 1.7v 1949.495n 1.7v 1949.505n 0.0v 1959.495n 0.0v 1959.505n 0.0v 1969.495n 0.0v 1969.505n 1.7v 1979.495n 1.7v 1979.505n 1.7v 1989.495n 1.7v 1989.505n 0.0v 1999.495n 0.0v 1999.505n 0.0v 2009.495n 0.0v 2009.505n 0.0v 2019.495n 0.0v 2019.505n 0.0v 2029.495n 0.0v 2029.505n 1.7v 2039.495n 1.7v 2039.505n 1.7v 2049.495n 1.7v 2049.505n 1.7v )
* (time, data): [(0, 0), (10, 0), (20, 0), (30, 0), (40, 0), (50, 0), (60, 0), (70, 0), (80, 0), (90, 0), (100, 0), (110, 0), (120, 0), (130, 0), (140, 0), (150, 0), (160, 0), (170, 0), (180, 0), (190, 0), (200, 0), (210, 0), (220, 0), (230, 0), (240, 0), (250, 0), (260, 0), (270, 0), (280, 0), (290, 0), (300, 0), (310, 0), (320, 0), (330, 0), (340, 0), (350, 0), (360, 0), (370, 0), (380, 0), (390, 0), (400, 0), (410, 0), (420, 0), (430, 0), (440, 0), (450, 0), (460, 0), (470, 0), (480, 0), (490, 0), (500, 0), (510, 0), (520, 0), (530, 0), (540, 0), (550, 0), (560, 0), (570, 0), (580, 0), (590, 0), (600, 0), (610, 0), (620, 0), (630, 0), (640, 0), (650, 0), (660, 0), (670, 0), (680, 0), (690, 0), (700, 0), (710, 0), (720, 0), (730, 0), (740, 0), (750, 0), (760, 0), (770, 0), (780, 0), (790, 0), (800, 0), (810, 0), (820, 0), (830, 0), (840, 0), (850, 0), (860, 0), (870, 0), (880, 0), (890, 0), (900, 0), (910, 0), (920, 0), (930, 0), (940, 0), (950, 0), (960, 0), (970, 0), (980, 0), (990, 0), (1000, 0), (1010, 0), (1020, 0), (1030, 0), (1040, 0), (1050, 0), (1060, 0), (1070, 0), (1080, 0), (1090, 0), (1100, 0), (1110, 0), (1120, 0), (1130, 0), (1140, 0), (1150, 0), (1160, 0), (1170, 0), (1180, 0), (1190, 0), (1200, 0), (1210, 0), (1220, 0), (1230, 0), (1240, 0), (1250, 0), (1260, 0), (1270, 0), (1280, 0), (1290, 0), (1300, 0), (1310, 0), (1320, 0), (1330, 0), (1340, 0), (1350, 0), (1360, 0), (1370, 0), (1380, 0), (1390, 0), (1400, 0), (1410, 0), (1420, 0), (1430, 0), (1440, 0), (1450, 0), (1460, 0), (1470, 0), (1480, 0), (1490, 0), (1500, 0), (1510, 0), (1520, 0), (1530, 0), (1540, 0), (1550, 0), (1560, 0), (1570, 0), (1580, 0), (1590, 0), (1600, 0), (1610, 0), (1620, 0), (1630, 0), (1640, 0), (1650, 0), (1660, 0), (1670, 0), (1680, 0), (1690, 0), (1700, 0), (1710, 0), (1720, 0), (1730, 0), (1740, 0), (1750, 0), (1760, 0), (1770, 0), (1780, 0), (1790, 0), (1800, 0), (1810, 0), (1820, 0), (1830, 0), (1840, 0), (1850, 0), (1860, 0), (1870, 0), (1880, 0), (1890, 0), (1900, 0), (1910, 0), (1920, 0), (1930, 0), (1940, 0), (1950, 0), (1960, 0), (1970, 0), (1980, 0), (1990, 0), (2000, 0), (2010, 0), (2020, 0), (2030, 0), (2040, 0), (2050, 0)]
Vdin0_32  din0_32  0 PWL (0n 0.0v 9.495n 0.0v 9.505n 0.0v 19.495n 0.0v 19.505n 0.0v 29.495n 0.0v 29.505n 0.0v 39.495n 0.0v 39.505n 0.0v 49.495n 0.0v 49.505n 0.0v 59.495n 0.0v 59.505n 0.0v 69.495n 0.0v 69.505n 0.0v 79.495n 0.0v 79.505n 0.0v 89.495n 0.0v 89.505n 0.0v 99.495n 0.0v 99.505n 0.0v 109.495n 0.0v 109.505n 0.0v 119.495n 0.0v 119.505n 0.0v 129.495n 0.0v 129.505n 0.0v 139.495n 0.0v 139.505n 0.0v 149.495n 0.0v 149.505n 0.0v 159.495n 0.0v 159.505n 0.0v 169.495n 0.0v 169.505n 0.0v 179.495n 0.0v 179.505n 0.0v 189.495n 0.0v 189.505n 0.0v 199.495n 0.0v 199.505n 0.0v 209.495n 0.0v 209.505n 0.0v 219.495n 0.0v 219.505n 0.0v 229.495n 0.0v 229.505n 0.0v 239.495n 0.0v 239.505n 0.0v 249.495n 0.0v 249.505n 0.0v 259.495n 0.0v 259.505n 0.0v 269.495n 0.0v 269.505n 0.0v 279.495n 0.0v 279.505n 0.0v 289.495n 0.0v 289.505n 0.0v 299.495n 0.0v 299.505n 0.0v 309.495n 0.0v 309.505n 0.0v 319.495n 0.0v 319.505n 0.0v 329.495n 0.0v 329.505n 0.0v 339.495n 0.0v 339.505n 0.0v 349.495n 0.0v 349.505n 0.0v 359.495n 0.0v 359.505n 0.0v 369.495n 0.0v 369.505n 0.0v 379.495n 0.0v 379.505n 0.0v 389.495n 0.0v 389.505n 0.0v 399.495n 0.0v 399.505n 0.0v 409.495n 0.0v 409.505n 0.0v 419.495n 0.0v 419.505n 0.0v 429.495n 0.0v 429.505n 0.0v 439.495n 0.0v 439.505n 0.0v 449.495n 0.0v 449.505n 0.0v 459.495n 0.0v 459.505n 0.0v 469.495n 0.0v 469.505n 0.0v 479.495n 0.0v 479.505n 0.0v 489.495n 0.0v 489.505n 0.0v 499.495n 0.0v 499.505n 0.0v 509.495n 0.0v 509.505n 0.0v 519.495n 0.0v 519.505n 0.0v 529.495n 0.0v 529.505n 0.0v 539.495n 0.0v 539.505n 0.0v 549.495n 0.0v 549.505n 0.0v 559.495n 0.0v 559.505n 0.0v 569.495n 0.0v 569.505n 0.0v 579.495n 0.0v 579.505n 0.0v 589.495n 0.0v 589.505n 0.0v 599.495n 0.0v 599.505n 0.0v 609.495n 0.0v 609.505n 0.0v 619.495n 0.0v 619.505n 0.0v 629.495n 0.0v 629.505n 0.0v 639.495n 0.0v 639.505n 0.0v 649.495n 0.0v 649.505n 0.0v 659.495n 0.0v 659.505n 0.0v 669.495n 0.0v 669.505n 0.0v 679.495n 0.0v 679.505n 0.0v 689.495n 0.0v 689.505n 0.0v 699.495n 0.0v 699.505n 0.0v 709.495n 0.0v 709.505n 0.0v 719.495n 0.0v 719.505n 0.0v 729.495n 0.0v 729.505n 0.0v 739.495n 0.0v 739.505n 0.0v 749.495n 0.0v 749.505n 0.0v 759.495n 0.0v 759.505n 0.0v 769.495n 0.0v 769.505n 0.0v 779.495n 0.0v 779.505n 0.0v 789.495n 0.0v 789.505n 0.0v 799.495n 0.0v 799.505n 0.0v 809.495n 0.0v 809.505n 0.0v 819.495n 0.0v 819.505n 0.0v 829.495n 0.0v 829.505n 0.0v 839.495n 0.0v 839.505n 0.0v 849.495n 0.0v 849.505n 0.0v 859.495n 0.0v 859.505n 0.0v 869.495n 0.0v 869.505n 0.0v 879.495n 0.0v 879.505n 0.0v 889.495n 0.0v 889.505n 0.0v 899.495n 0.0v 899.505n 0.0v 909.495n 0.0v 909.505n 0.0v 919.495n 0.0v 919.505n 0.0v 929.495n 0.0v 929.505n 0.0v 939.495n 0.0v 939.505n 0.0v 949.495n 0.0v 949.505n 0.0v 959.495n 0.0v 959.505n 0.0v 969.495n 0.0v 969.505n 0.0v 979.495n 0.0v 979.505n 0.0v 989.495n 0.0v 989.505n 0.0v 999.495n 0.0v 999.505n 0.0v 1009.495n 0.0v 1009.505n 0.0v 1019.495n 0.0v 1019.505n 0.0v 1029.495n 0.0v 1029.505n 0.0v 1039.495n 0.0v 1039.505n 0.0v 1049.495n 0.0v 1049.505n 0.0v 1059.495n 0.0v 1059.505n 0.0v 1069.495n 0.0v 1069.505n 0.0v 1079.495n 0.0v 1079.505n 0.0v 1089.495n 0.0v 1089.505n 0.0v 1099.495n 0.0v 1099.505n 0.0v 1109.495n 0.0v 1109.505n 0.0v 1119.495n 0.0v 1119.505n 0.0v 1129.495n 0.0v 1129.505n 0.0v 1139.495n 0.0v 1139.505n 0.0v 1149.495n 0.0v 1149.505n 0.0v 1159.495n 0.0v 1159.505n 0.0v 1169.495n 0.0v 1169.505n 0.0v 1179.495n 0.0v 1179.505n 0.0v 1189.495n 0.0v 1189.505n 0.0v 1199.495n 0.0v 1199.505n 0.0v 1209.495n 0.0v 1209.505n 0.0v 1219.495n 0.0v 1219.505n 0.0v 1229.495n 0.0v 1229.505n 0.0v 1239.495n 0.0v 1239.505n 0.0v 1249.495n 0.0v 1249.505n 0.0v 1259.495n 0.0v 1259.505n 0.0v 1269.495n 0.0v 1269.505n 0.0v 1279.495n 0.0v 1279.505n 0.0v 1289.495n 0.0v 1289.505n 0.0v 1299.495n 0.0v 1299.505n 0.0v 1309.495n 0.0v 1309.505n 0.0v 1319.495n 0.0v 1319.505n 0.0v 1329.495n 0.0v 1329.505n 0.0v 1339.495n 0.0v 1339.505n 0.0v 1349.495n 0.0v 1349.505n 0.0v 1359.495n 0.0v 1359.505n 0.0v 1369.495n 0.0v 1369.505n 0.0v 1379.495n 0.0v 1379.505n 0.0v 1389.495n 0.0v 1389.505n 0.0v 1399.495n 0.0v 1399.505n 0.0v 1409.495n 0.0v 1409.505n 0.0v 1419.495n 0.0v 1419.505n 0.0v 1429.495n 0.0v 1429.505n 0.0v 1439.495n 0.0v 1439.505n 0.0v 1449.495n 0.0v 1449.505n 0.0v 1459.495n 0.0v 1459.505n 0.0v 1469.495n 0.0v 1469.505n 0.0v 1479.495n 0.0v 1479.505n 0.0v 1489.495n 0.0v 1489.505n 0.0v 1499.495n 0.0v 1499.505n 0.0v 1509.495n 0.0v 1509.505n 0.0v 1519.495n 0.0v 1519.505n 0.0v 1529.495n 0.0v 1529.505n 0.0v 1539.495n 0.0v 1539.505n 0.0v 1549.495n 0.0v 1549.505n 0.0v 1559.495n 0.0v 1559.505n 0.0v 1569.495n 0.0v 1569.505n 0.0v 1579.495n 0.0v 1579.505n 0.0v 1589.495n 0.0v 1589.505n 0.0v 1599.495n 0.0v 1599.505n 0.0v 1609.495n 0.0v 1609.505n 0.0v 1619.495n 0.0v 1619.505n 0.0v 1629.495n 0.0v 1629.505n 0.0v 1639.495n 0.0v 1639.505n 0.0v 1649.495n 0.0v 1649.505n 0.0v 1659.495n 0.0v 1659.505n 0.0v 1669.495n 0.0v 1669.505n 0.0v 1679.495n 0.0v 1679.505n 0.0v 1689.495n 0.0v 1689.505n 0.0v 1699.495n 0.0v 1699.505n 0.0v 1709.495n 0.0v 1709.505n 0.0v 1719.495n 0.0v 1719.505n 0.0v 1729.495n 0.0v 1729.505n 0.0v 1739.495n 0.0v 1739.505n 0.0v 1749.495n 0.0v 1749.505n 0.0v 1759.495n 0.0v 1759.505n 0.0v 1769.495n 0.0v 1769.505n 0.0v 1779.495n 0.0v 1779.505n 0.0v 1789.495n 0.0v 1789.505n 0.0v 1799.495n 0.0v 1799.505n 0.0v 1809.495n 0.0v 1809.505n 0.0v 1819.495n 0.0v 1819.505n 0.0v 1829.495n 0.0v 1829.505n 0.0v 1839.495n 0.0v 1839.505n 0.0v 1849.495n 0.0v 1849.505n 0.0v 1859.495n 0.0v 1859.505n 0.0v 1869.495n 0.0v 1869.505n 0.0v 1879.495n 0.0v 1879.505n 0.0v 1889.495n 0.0v 1889.505n 0.0v 1899.495n 0.0v 1899.505n 0.0v 1909.495n 0.0v 1909.505n 0.0v 1919.495n 0.0v 1919.505n 0.0v 1929.495n 0.0v 1929.505n 0.0v 1939.495n 0.0v 1939.505n 0.0v 1949.495n 0.0v 1949.505n 0.0v 1959.495n 0.0v 1959.505n 0.0v 1969.495n 0.0v 1969.505n 0.0v 1979.495n 0.0v 1979.505n 0.0v 1989.495n 0.0v 1989.505n 0.0v 1999.495n 0.0v 1999.505n 0.0v 2009.495n 0.0v 2009.505n 0.0v 2019.495n 0.0v 2019.505n 0.0v 2029.495n 0.0v 2029.505n 0.0v 2039.495n 0.0v 2039.505n 0.0v 2049.495n 0.0v 2049.505n 0.0v )
* (time, data): [(0, 0), (10, 0), (20, 0), (30, 0), (40, 0), (50, 1), (60, 1), (70, 0), (80, 1), (90, 1), (100, 1), (110, 1), (120, 1), (130, 1), (140, 1), (150, 1), (160, 1), (170, 1), (180, 1), (190, 1), (200, 1), (210, 1), (220, 1), (230, 1), (240, 0), (250, 0), (260, 0), (270, 1), (280, 1), (290, 1), (300, 0), (310, 0), (320, 0), (330, 1), (340, 1), (350, 1), (360, 1), (370, 1), (380, 0), (390, 0), (400, 0), (410, 0), (420, 0), (430, 1), (440, 1), (450, 1), (460, 0), (470, 0), (480, 0), (490, 0), (500, 0), (510, 0), (520, 1), (530, 1), (540, 1), (550, 1), (560, 1), (570, 1), (580, 1), (590, 1), (600, 1), (610, 1), (620, 1), (630, 1), (640, 1), (650, 1), (660, 1), (670, 0), (680, 0), (690, 1), (700, 0), (710, 1), (720, 1), (730, 1), (740, 1), (750, 1), (760, 1), (770, 0), (780, 0), (790, 1), (800, 1), (810, 0), (820, 1), (830, 1), (840, 1), (850, 1), (860, 1), (870, 0), (880, 0), (890, 0), (900, 0), (910, 0), (920, 0), (930, 1), (940, 1), (950, 1), (960, 1), (970, 0), (980, 1), (990, 1), (1000, 1), (1010, 1), (1020, 1), (1030, 1), (1040, 1), (1050, 1), (1060, 1), (1070, 1), (1080, 1), (1090, 1), (1100, 1), (1110, 1), (1120, 1), (1130, 1), (1140, 1), (1150, 0), (1160, 0), (1170, 1), (1180, 1), (1190, 1), (1200, 0), (1210, 0), (1220, 1), (1230, 0), (1240, 1), (1250, 1), (1260, 1), (1270, 1), (1280, 1), (1290, 0), (1300, 0), (1310, 0), (1320, 0), (1330, 0), (1340, 1), (1350, 1), (1360, 1), (1370, 1), (1380, 0), (1390, 0), (1400, 1), (1410, 1), (1420, 1), (1430, 1), (1440, 1), (1450, 0), (1460, 0), (1470, 0), (1480, 0), (1490, 1), (1500, 1), (1510, 1), (1520, 1), (1530, 0), (1540, 0), (1550, 0), (1560, 0), (1570, 1), (1580, 1), (1590, 0), (1600, 0), (1610, 1), (1620, 1), (1630, 1), (1640, 1), (1650, 1), (1660, 1), (1670, 0), (1680, 1), (1690, 1), (1700, 1), (1710, 0), (1720, 1), (1730, 1), (1740, 1), (1750, 1), (1760, 1), (1770, 0), (1780, 0), (1790, 1), (1800, 1), (1810, 1), (1820, 0), (1830, 0), (1840, 1), (1850, 1), (1860, 1), (1870, 1), (1880, 1), (1890, 1), (1900, 0), (1910, 0), (1920, 0), (1930, 1), (1940, 0), (1950, 1), (1960, 1), (1970, 0), (1980, 0), (1990, 1), (2000, 1), (2010, 1), (2020, 1), (2030, 0), (2040, 0), (2050, 0)]
Va0_0  a0_0  0 PWL (0n 0.0v 9.495n 0.0v 9.505n 0.0v 19.495n 0.0v 19.505n 0.0v 29.495n 0.0v 29.505n 0.0v 39.495n 0.0v 39.505n 0.0v 49.495n 0.0v 49.505n 1.7v 59.495n 1.7v 59.505n 1.7v 69.495n 1.7v 69.505n 0.0v 79.495n 0.0v 79.505n 1.7v 89.495n 1.7v 89.505n 1.7v 99.495n 1.7v 99.505n 1.7v 109.495n 1.7v 109.505n 1.7v 119.495n 1.7v 119.505n 1.7v 129.495n 1.7v 129.505n 1.7v 139.495n 1.7v 139.505n 1.7v 149.495n 1.7v 149.505n 1.7v 159.495n 1.7v 159.505n 1.7v 169.495n 1.7v 169.505n 1.7v 179.495n 1.7v 179.505n 1.7v 189.495n 1.7v 189.505n 1.7v 199.495n 1.7v 199.505n 1.7v 209.495n 1.7v 209.505n 1.7v 219.495n 1.7v 219.505n 1.7v 229.495n 1.7v 229.505n 1.7v 239.495n 1.7v 239.505n 0.0v 249.495n 0.0v 249.505n 0.0v 259.495n 0.0v 259.505n 0.0v 269.495n 0.0v 269.505n 1.7v 279.495n 1.7v 279.505n 1.7v 289.495n 1.7v 289.505n 1.7v 299.495n 1.7v 299.505n 0.0v 309.495n 0.0v 309.505n 0.0v 319.495n 0.0v 319.505n 0.0v 329.495n 0.0v 329.505n 1.7v 339.495n 1.7v 339.505n 1.7v 349.495n 1.7v 349.505n 1.7v 359.495n 1.7v 359.505n 1.7v 369.495n 1.7v 369.505n 1.7v 379.495n 1.7v 379.505n 0.0v 389.495n 0.0v 389.505n 0.0v 399.495n 0.0v 399.505n 0.0v 409.495n 0.0v 409.505n 0.0v 419.495n 0.0v 419.505n 0.0v 429.495n 0.0v 429.505n 1.7v 439.495n 1.7v 439.505n 1.7v 449.495n 1.7v 449.505n 1.7v 459.495n 1.7v 459.505n 0.0v 469.495n 0.0v 469.505n 0.0v 479.495n 0.0v 479.505n 0.0v 489.495n 0.0v 489.505n 0.0v 499.495n 0.0v 499.505n 0.0v 509.495n 0.0v 509.505n 0.0v 519.495n 0.0v 519.505n 1.7v 529.495n 1.7v 529.505n 1.7v 539.495n 1.7v 539.505n 1.7v 549.495n 1.7v 549.505n 1.7v 559.495n 1.7v 559.505n 1.7v 569.495n 1.7v 569.505n 1.7v 579.495n 1.7v 579.505n 1.7v 589.495n 1.7v 589.505n 1.7v 599.495n 1.7v 599.505n 1.7v 609.495n 1.7v 609.505n 1.7v 619.495n 1.7v 619.505n 1.7v 629.495n 1.7v 629.505n 1.7v 639.495n 1.7v 639.505n 1.7v 649.495n 1.7v 649.505n 1.7v 659.495n 1.7v 659.505n 1.7v 669.495n 1.7v 669.505n 0.0v 679.495n 0.0v 679.505n 0.0v 689.495n 0.0v 689.505n 1.7v 699.495n 1.7v 699.505n 0.0v 709.495n 0.0v 709.505n 1.7v 719.495n 1.7v 719.505n 1.7v 729.495n 1.7v 729.505n 1.7v 739.495n 1.7v 739.505n 1.7v 749.495n 1.7v 749.505n 1.7v 759.495n 1.7v 759.505n 1.7v 769.495n 1.7v 769.505n 0.0v 779.495n 0.0v 779.505n 0.0v 789.495n 0.0v 789.505n 1.7v 799.495n 1.7v 799.505n 1.7v 809.495n 1.7v 809.505n 0.0v 819.495n 0.0v 819.505n 1.7v 829.495n 1.7v 829.505n 1.7v 839.495n 1.7v 839.505n 1.7v 849.495n 1.7v 849.505n 1.7v 859.495n 1.7v 859.505n 1.7v 869.495n 1.7v 869.505n 0.0v 879.495n 0.0v 879.505n 0.0v 889.495n 0.0v 889.505n 0.0v 899.495n 0.0v 899.505n 0.0v 909.495n 0.0v 909.505n 0.0v 919.495n 0.0v 919.505n 0.0v 929.495n 0.0v 929.505n 1.7v 939.495n 1.7v 939.505n 1.7v 949.495n 1.7v 949.505n 1.7v 959.495n 1.7v 959.505n 1.7v 969.495n 1.7v 969.505n 0.0v 979.495n 0.0v 979.505n 1.7v 989.495n 1.7v 989.505n 1.7v 999.495n 1.7v 999.505n 1.7v 1009.495n 1.7v 1009.505n 1.7v 1019.495n 1.7v 1019.505n 1.7v 1029.495n 1.7v 1029.505n 1.7v 1039.495n 1.7v 1039.505n 1.7v 1049.495n 1.7v 1049.505n 1.7v 1059.495n 1.7v 1059.505n 1.7v 1069.495n 1.7v 1069.505n 1.7v 1079.495n 1.7v 1079.505n 1.7v 1089.495n 1.7v 1089.505n 1.7v 1099.495n 1.7v 1099.505n 1.7v 1109.495n 1.7v 1109.505n 1.7v 1119.495n 1.7v 1119.505n 1.7v 1129.495n 1.7v 1129.505n 1.7v 1139.495n 1.7v 1139.505n 1.7v 1149.495n 1.7v 1149.505n 0.0v 1159.495n 0.0v 1159.505n 0.0v 1169.495n 0.0v 1169.505n 1.7v 1179.495n 1.7v 1179.505n 1.7v 1189.495n 1.7v 1189.505n 1.7v 1199.495n 1.7v 1199.505n 0.0v 1209.495n 0.0v 1209.505n 0.0v 1219.495n 0.0v 1219.505n 1.7v 1229.495n 1.7v 1229.505n 0.0v 1239.495n 0.0v 1239.505n 1.7v 1249.495n 1.7v 1249.505n 1.7v 1259.495n 1.7v 1259.505n 1.7v 1269.495n 1.7v 1269.505n 1.7v 1279.495n 1.7v 1279.505n 1.7v 1289.495n 1.7v 1289.505n 0.0v 1299.495n 0.0v 1299.505n 0.0v 1309.495n 0.0v 1309.505n 0.0v 1319.495n 0.0v 1319.505n 0.0v 1329.495n 0.0v 1329.505n 0.0v 1339.495n 0.0v 1339.505n 1.7v 1349.495n 1.7v 1349.505n 1.7v 1359.495n 1.7v 1359.505n 1.7v 1369.495n 1.7v 1369.505n 1.7v 1379.495n 1.7v 1379.505n 0.0v 1389.495n 0.0v 1389.505n 0.0v 1399.495n 0.0v 1399.505n 1.7v 1409.495n 1.7v 1409.505n 1.7v 1419.495n 1.7v 1419.505n 1.7v 1429.495n 1.7v 1429.505n 1.7v 1439.495n 1.7v 1439.505n 1.7v 1449.495n 1.7v 1449.505n 0.0v 1459.495n 0.0v 1459.505n 0.0v 1469.495n 0.0v 1469.505n 0.0v 1479.495n 0.0v 1479.505n 0.0v 1489.495n 0.0v 1489.505n 1.7v 1499.495n 1.7v 1499.505n 1.7v 1509.495n 1.7v 1509.505n 1.7v 1519.495n 1.7v 1519.505n 1.7v 1529.495n 1.7v 1529.505n 0.0v 1539.495n 0.0v 1539.505n 0.0v 1549.495n 0.0v 1549.505n 0.0v 1559.495n 0.0v 1559.505n 0.0v 1569.495n 0.0v 1569.505n 1.7v 1579.495n 1.7v 1579.505n 1.7v 1589.495n 1.7v 1589.505n 0.0v 1599.495n 0.0v 1599.505n 0.0v 1609.495n 0.0v 1609.505n 1.7v 1619.495n 1.7v 1619.505n 1.7v 1629.495n 1.7v 1629.505n 1.7v 1639.495n 1.7v 1639.505n 1.7v 1649.495n 1.7v 1649.505n 1.7v 1659.495n 1.7v 1659.505n 1.7v 1669.495n 1.7v 1669.505n 0.0v 1679.495n 0.0v 1679.505n 1.7v 1689.495n 1.7v 1689.505n 1.7v 1699.495n 1.7v 1699.505n 1.7v 1709.495n 1.7v 1709.505n 0.0v 1719.495n 0.0v 1719.505n 1.7v 1729.495n 1.7v 1729.505n 1.7v 1739.495n 1.7v 1739.505n 1.7v 1749.495n 1.7v 1749.505n 1.7v 1759.495n 1.7v 1759.505n 1.7v 1769.495n 1.7v 1769.505n 0.0v 1779.495n 0.0v 1779.505n 0.0v 1789.495n 0.0v 1789.505n 1.7v 1799.495n 1.7v 1799.505n 1.7v 1809.495n 1.7v 1809.505n 1.7v 1819.495n 1.7v 1819.505n 0.0v 1829.495n 0.0v 1829.505n 0.0v 1839.495n 0.0v 1839.505n 1.7v 1849.495n 1.7v 1849.505n 1.7v 1859.495n 1.7v 1859.505n 1.7v 1869.495n 1.7v 1869.505n 1.7v 1879.495n 1.7v 1879.505n 1.7v 1889.495n 1.7v 1889.505n 1.7v 1899.495n 1.7v 1899.505n 0.0v 1909.495n 0.0v 1909.505n 0.0v 1919.495n 0.0v 1919.505n 0.0v 1929.495n 0.0v 1929.505n 1.7v 1939.495n 1.7v 1939.505n 0.0v 1949.495n 0.0v 1949.505n 1.7v 1959.495n 1.7v 1959.505n 1.7v 1969.495n 1.7v 1969.505n 0.0v 1979.495n 0.0v 1979.505n 0.0v 1989.495n 0.0v 1989.505n 1.7v 1999.495n 1.7v 1999.505n 1.7v 2009.495n 1.7v 2009.505n 1.7v 2019.495n 1.7v 2019.505n 1.7v 2029.495n 1.7v 2029.505n 0.0v 2039.495n 0.0v 2039.505n 0.0v 2049.495n 0.0v 2049.505n 0.0v )
* (time, data): [(0, 0), (10, 0), (20, 0), (30, 0), (40, 0), (50, 1), (60, 1), (70, 0), (80, 1), (90, 1), (100, 1), (110, 1), (120, 1), (130, 1), (140, 1), (150, 1), (160, 1), (170, 1), (180, 1), (190, 1), (200, 1), (210, 1), (220, 1), (230, 1), (240, 0), (250, 0), (260, 0), (270, 1), (280, 1), (290, 1), (300, 0), (310, 0), (320, 0), (330, 1), (340, 1), (350, 1), (360, 1), (370, 1), (380, 0), (390, 0), (400, 0), (410, 0), (420, 0), (430, 1), (440, 1), (450, 1), (460, 0), (470, 0), (480, 0), (490, 0), (500, 0), (510, 0), (520, 1), (530, 1), (540, 1), (550, 1), (560, 1), (570, 1), (580, 1), (590, 1), (600, 1), (610, 1), (620, 1), (630, 1), (640, 1), (650, 1), (660, 1), (670, 0), (680, 0), (690, 1), (700, 0), (710, 1), (720, 1), (730, 1), (740, 1), (750, 1), (760, 1), (770, 0), (780, 0), (790, 1), (800, 1), (810, 0), (820, 1), (830, 1), (840, 1), (850, 1), (860, 1), (870, 0), (880, 0), (890, 0), (900, 0), (910, 0), (920, 0), (930, 1), (940, 1), (950, 1), (960, 1), (970, 0), (980, 1), (990, 1), (1000, 1), (1010, 1), (1020, 1), (1030, 1), (1040, 1), (1050, 1), (1060, 1), (1070, 1), (1080, 1), (1090, 1), (1100, 1), (1110, 1), (1120, 1), (1130, 1), (1140, 1), (1150, 0), (1160, 0), (1170, 1), (1180, 1), (1190, 1), (1200, 0), (1210, 0), (1220, 1), (1230, 0), (1240, 1), (1250, 1), (1260, 1), (1270, 1), (1280, 1), (1290, 0), (1300, 0), (1310, 0), (1320, 0), (1330, 0), (1340, 1), (1350, 1), (1360, 1), (1370, 1), (1380, 0), (1390, 0), (1400, 1), (1410, 1), (1420, 1), (1430, 1), (1440, 1), (1450, 0), (1460, 0), (1470, 0), (1480, 0), (1490, 1), (1500, 1), (1510, 1), (1520, 1), (1530, 0), (1540, 0), (1550, 0), (1560, 0), (1570, 1), (1580, 1), (1590, 0), (1600, 0), (1610, 1), (1620, 1), (1630, 1), (1640, 1), (1650, 1), (1660, 1), (1670, 0), (1680, 1), (1690, 1), (1700, 1), (1710, 0), (1720, 1), (1730, 1), (1740, 1), (1750, 1), (1760, 1), (1770, 0), (1780, 0), (1790, 1), (1800, 1), (1810, 1), (1820, 0), (1830, 0), (1840, 1), (1850, 1), (1860, 1), (1870, 1), (1880, 1), (1890, 1), (1900, 0), (1910, 0), (1920, 0), (1930, 1), (1940, 0), (1950, 1), (1960, 1), (1970, 0), (1980, 0), (1990, 1), (2000, 1), (2010, 1), (2020, 1), (2030, 0), (2040, 0), (2050, 0)]
Va0_1  a0_1  0 PWL (0n 0.0v 9.495n 0.0v 9.505n 0.0v 19.495n 0.0v 19.505n 0.0v 29.495n 0.0v 29.505n 0.0v 39.495n 0.0v 39.505n 0.0v 49.495n 0.0v 49.505n 1.7v 59.495n 1.7v 59.505n 1.7v 69.495n 1.7v 69.505n 0.0v 79.495n 0.0v 79.505n 1.7v 89.495n 1.7v 89.505n 1.7v 99.495n 1.7v 99.505n 1.7v 109.495n 1.7v 109.505n 1.7v 119.495n 1.7v 119.505n 1.7v 129.495n 1.7v 129.505n 1.7v 139.495n 1.7v 139.505n 1.7v 149.495n 1.7v 149.505n 1.7v 159.495n 1.7v 159.505n 1.7v 169.495n 1.7v 169.505n 1.7v 179.495n 1.7v 179.505n 1.7v 189.495n 1.7v 189.505n 1.7v 199.495n 1.7v 199.505n 1.7v 209.495n 1.7v 209.505n 1.7v 219.495n 1.7v 219.505n 1.7v 229.495n 1.7v 229.505n 1.7v 239.495n 1.7v 239.505n 0.0v 249.495n 0.0v 249.505n 0.0v 259.495n 0.0v 259.505n 0.0v 269.495n 0.0v 269.505n 1.7v 279.495n 1.7v 279.505n 1.7v 289.495n 1.7v 289.505n 1.7v 299.495n 1.7v 299.505n 0.0v 309.495n 0.0v 309.505n 0.0v 319.495n 0.0v 319.505n 0.0v 329.495n 0.0v 329.505n 1.7v 339.495n 1.7v 339.505n 1.7v 349.495n 1.7v 349.505n 1.7v 359.495n 1.7v 359.505n 1.7v 369.495n 1.7v 369.505n 1.7v 379.495n 1.7v 379.505n 0.0v 389.495n 0.0v 389.505n 0.0v 399.495n 0.0v 399.505n 0.0v 409.495n 0.0v 409.505n 0.0v 419.495n 0.0v 419.505n 0.0v 429.495n 0.0v 429.505n 1.7v 439.495n 1.7v 439.505n 1.7v 449.495n 1.7v 449.505n 1.7v 459.495n 1.7v 459.505n 0.0v 469.495n 0.0v 469.505n 0.0v 479.495n 0.0v 479.505n 0.0v 489.495n 0.0v 489.505n 0.0v 499.495n 0.0v 499.505n 0.0v 509.495n 0.0v 509.505n 0.0v 519.495n 0.0v 519.505n 1.7v 529.495n 1.7v 529.505n 1.7v 539.495n 1.7v 539.505n 1.7v 549.495n 1.7v 549.505n 1.7v 559.495n 1.7v 559.505n 1.7v 569.495n 1.7v 569.505n 1.7v 579.495n 1.7v 579.505n 1.7v 589.495n 1.7v 589.505n 1.7v 599.495n 1.7v 599.505n 1.7v 609.495n 1.7v 609.505n 1.7v 619.495n 1.7v 619.505n 1.7v 629.495n 1.7v 629.505n 1.7v 639.495n 1.7v 639.505n 1.7v 649.495n 1.7v 649.505n 1.7v 659.495n 1.7v 659.505n 1.7v 669.495n 1.7v 669.505n 0.0v 679.495n 0.0v 679.505n 0.0v 689.495n 0.0v 689.505n 1.7v 699.495n 1.7v 699.505n 0.0v 709.495n 0.0v 709.505n 1.7v 719.495n 1.7v 719.505n 1.7v 729.495n 1.7v 729.505n 1.7v 739.495n 1.7v 739.505n 1.7v 749.495n 1.7v 749.505n 1.7v 759.495n 1.7v 759.505n 1.7v 769.495n 1.7v 769.505n 0.0v 779.495n 0.0v 779.505n 0.0v 789.495n 0.0v 789.505n 1.7v 799.495n 1.7v 799.505n 1.7v 809.495n 1.7v 809.505n 0.0v 819.495n 0.0v 819.505n 1.7v 829.495n 1.7v 829.505n 1.7v 839.495n 1.7v 839.505n 1.7v 849.495n 1.7v 849.505n 1.7v 859.495n 1.7v 859.505n 1.7v 869.495n 1.7v 869.505n 0.0v 879.495n 0.0v 879.505n 0.0v 889.495n 0.0v 889.505n 0.0v 899.495n 0.0v 899.505n 0.0v 909.495n 0.0v 909.505n 0.0v 919.495n 0.0v 919.505n 0.0v 929.495n 0.0v 929.505n 1.7v 939.495n 1.7v 939.505n 1.7v 949.495n 1.7v 949.505n 1.7v 959.495n 1.7v 959.505n 1.7v 969.495n 1.7v 969.505n 0.0v 979.495n 0.0v 979.505n 1.7v 989.495n 1.7v 989.505n 1.7v 999.495n 1.7v 999.505n 1.7v 1009.495n 1.7v 1009.505n 1.7v 1019.495n 1.7v 1019.505n 1.7v 1029.495n 1.7v 1029.505n 1.7v 1039.495n 1.7v 1039.505n 1.7v 1049.495n 1.7v 1049.505n 1.7v 1059.495n 1.7v 1059.505n 1.7v 1069.495n 1.7v 1069.505n 1.7v 1079.495n 1.7v 1079.505n 1.7v 1089.495n 1.7v 1089.505n 1.7v 1099.495n 1.7v 1099.505n 1.7v 1109.495n 1.7v 1109.505n 1.7v 1119.495n 1.7v 1119.505n 1.7v 1129.495n 1.7v 1129.505n 1.7v 1139.495n 1.7v 1139.505n 1.7v 1149.495n 1.7v 1149.505n 0.0v 1159.495n 0.0v 1159.505n 0.0v 1169.495n 0.0v 1169.505n 1.7v 1179.495n 1.7v 1179.505n 1.7v 1189.495n 1.7v 1189.505n 1.7v 1199.495n 1.7v 1199.505n 0.0v 1209.495n 0.0v 1209.505n 0.0v 1219.495n 0.0v 1219.505n 1.7v 1229.495n 1.7v 1229.505n 0.0v 1239.495n 0.0v 1239.505n 1.7v 1249.495n 1.7v 1249.505n 1.7v 1259.495n 1.7v 1259.505n 1.7v 1269.495n 1.7v 1269.505n 1.7v 1279.495n 1.7v 1279.505n 1.7v 1289.495n 1.7v 1289.505n 0.0v 1299.495n 0.0v 1299.505n 0.0v 1309.495n 0.0v 1309.505n 0.0v 1319.495n 0.0v 1319.505n 0.0v 1329.495n 0.0v 1329.505n 0.0v 1339.495n 0.0v 1339.505n 1.7v 1349.495n 1.7v 1349.505n 1.7v 1359.495n 1.7v 1359.505n 1.7v 1369.495n 1.7v 1369.505n 1.7v 1379.495n 1.7v 1379.505n 0.0v 1389.495n 0.0v 1389.505n 0.0v 1399.495n 0.0v 1399.505n 1.7v 1409.495n 1.7v 1409.505n 1.7v 1419.495n 1.7v 1419.505n 1.7v 1429.495n 1.7v 1429.505n 1.7v 1439.495n 1.7v 1439.505n 1.7v 1449.495n 1.7v 1449.505n 0.0v 1459.495n 0.0v 1459.505n 0.0v 1469.495n 0.0v 1469.505n 0.0v 1479.495n 0.0v 1479.505n 0.0v 1489.495n 0.0v 1489.505n 1.7v 1499.495n 1.7v 1499.505n 1.7v 1509.495n 1.7v 1509.505n 1.7v 1519.495n 1.7v 1519.505n 1.7v 1529.495n 1.7v 1529.505n 0.0v 1539.495n 0.0v 1539.505n 0.0v 1549.495n 0.0v 1549.505n 0.0v 1559.495n 0.0v 1559.505n 0.0v 1569.495n 0.0v 1569.505n 1.7v 1579.495n 1.7v 1579.505n 1.7v 1589.495n 1.7v 1589.505n 0.0v 1599.495n 0.0v 1599.505n 0.0v 1609.495n 0.0v 1609.505n 1.7v 1619.495n 1.7v 1619.505n 1.7v 1629.495n 1.7v 1629.505n 1.7v 1639.495n 1.7v 1639.505n 1.7v 1649.495n 1.7v 1649.505n 1.7v 1659.495n 1.7v 1659.505n 1.7v 1669.495n 1.7v 1669.505n 0.0v 1679.495n 0.0v 1679.505n 1.7v 1689.495n 1.7v 1689.505n 1.7v 1699.495n 1.7v 1699.505n 1.7v 1709.495n 1.7v 1709.505n 0.0v 1719.495n 0.0v 1719.505n 1.7v 1729.495n 1.7v 1729.505n 1.7v 1739.495n 1.7v 1739.505n 1.7v 1749.495n 1.7v 1749.505n 1.7v 1759.495n 1.7v 1759.505n 1.7v 1769.495n 1.7v 1769.505n 0.0v 1779.495n 0.0v 1779.505n 0.0v 1789.495n 0.0v 1789.505n 1.7v 1799.495n 1.7v 1799.505n 1.7v 1809.495n 1.7v 1809.505n 1.7v 1819.495n 1.7v 1819.505n 0.0v 1829.495n 0.0v 1829.505n 0.0v 1839.495n 0.0v 1839.505n 1.7v 1849.495n 1.7v 1849.505n 1.7v 1859.495n 1.7v 1859.505n 1.7v 1869.495n 1.7v 1869.505n 1.7v 1879.495n 1.7v 1879.505n 1.7v 1889.495n 1.7v 1889.505n 1.7v 1899.495n 1.7v 1899.505n 0.0v 1909.495n 0.0v 1909.505n 0.0v 1919.495n 0.0v 1919.505n 0.0v 1929.495n 0.0v 1929.505n 1.7v 1939.495n 1.7v 1939.505n 0.0v 1949.495n 0.0v 1949.505n 1.7v 1959.495n 1.7v 1959.505n 1.7v 1969.495n 1.7v 1969.505n 0.0v 1979.495n 0.0v 1979.505n 0.0v 1989.495n 0.0v 1989.505n 1.7v 1999.495n 1.7v 1999.505n 1.7v 2009.495n 1.7v 2009.505n 1.7v 2019.495n 1.7v 2019.505n 1.7v 2029.495n 1.7v 2029.505n 0.0v 2039.495n 0.0v 2039.505n 0.0v 2049.495n 0.0v 2049.505n 0.0v )
* (time, data): [(0, 0), (10, 0), (20, 0), (30, 0), (40, 0), (50, 1), (60, 1), (70, 0), (80, 1), (90, 1), (100, 1), (110, 1), (120, 1), (130, 1), (140, 1), (150, 1), (160, 1), (170, 1), (180, 1), (190, 1), (200, 1), (210, 1), (220, 1), (230, 1), (240, 0), (250, 0), (260, 0), (270, 1), (280, 1), (290, 1), (300, 0), (310, 0), (320, 0), (330, 1), (340, 1), (350, 1), (360, 1), (370, 1), (380, 0), (390, 0), (400, 0), (410, 0), (420, 0), (430, 1), (440, 1), (450, 1), (460, 0), (470, 0), (480, 0), (490, 0), (500, 0), (510, 0), (520, 1), (530, 1), (540, 1), (550, 1), (560, 1), (570, 1), (580, 1), (590, 1), (600, 1), (610, 1), (620, 1), (630, 1), (640, 1), (650, 1), (660, 1), (670, 0), (680, 0), (690, 1), (700, 0), (710, 1), (720, 1), (730, 1), (740, 1), (750, 1), (760, 1), (770, 0), (780, 0), (790, 1), (800, 1), (810, 0), (820, 1), (830, 1), (840, 1), (850, 1), (860, 1), (870, 0), (880, 0), (890, 0), (900, 0), (910, 0), (920, 0), (930, 1), (940, 1), (950, 1), (960, 1), (970, 0), (980, 1), (990, 1), (1000, 1), (1010, 1), (1020, 1), (1030, 1), (1040, 1), (1050, 1), (1060, 1), (1070, 1), (1080, 1), (1090, 1), (1100, 1), (1110, 1), (1120, 1), (1130, 1), (1140, 1), (1150, 0), (1160, 0), (1170, 1), (1180, 1), (1190, 1), (1200, 0), (1210, 0), (1220, 1), (1230, 0), (1240, 1), (1250, 1), (1260, 1), (1270, 1), (1280, 1), (1290, 0), (1300, 0), (1310, 0), (1320, 0), (1330, 0), (1340, 1), (1350, 1), (1360, 1), (1370, 1), (1380, 0), (1390, 0), (1400, 1), (1410, 1), (1420, 1), (1430, 1), (1440, 1), (1450, 0), (1460, 0), (1470, 0), (1480, 0), (1490, 1), (1500, 1), (1510, 1), (1520, 1), (1530, 0), (1540, 0), (1550, 0), (1560, 0), (1570, 1), (1580, 1), (1590, 0), (1600, 0), (1610, 1), (1620, 1), (1630, 1), (1640, 1), (1650, 1), (1660, 1), (1670, 0), (1680, 1), (1690, 1), (1700, 1), (1710, 0), (1720, 1), (1730, 1), (1740, 1), (1750, 1), (1760, 1), (1770, 0), (1780, 0), (1790, 1), (1800, 1), (1810, 1), (1820, 0), (1830, 0), (1840, 1), (1850, 1), (1860, 1), (1870, 1), (1880, 1), (1890, 1), (1900, 0), (1910, 0), (1920, 0), (1930, 1), (1940, 0), (1950, 1), (1960, 1), (1970, 0), (1980, 0), (1990, 1), (2000, 1), (2010, 1), (2020, 1), (2030, 0), (2040, 0), (2050, 0)]
Va0_2  a0_2  0 PWL (0n 0.0v 9.495n 0.0v 9.505n 0.0v 19.495n 0.0v 19.505n 0.0v 29.495n 0.0v 29.505n 0.0v 39.495n 0.0v 39.505n 0.0v 49.495n 0.0v 49.505n 1.7v 59.495n 1.7v 59.505n 1.7v 69.495n 1.7v 69.505n 0.0v 79.495n 0.0v 79.505n 1.7v 89.495n 1.7v 89.505n 1.7v 99.495n 1.7v 99.505n 1.7v 109.495n 1.7v 109.505n 1.7v 119.495n 1.7v 119.505n 1.7v 129.495n 1.7v 129.505n 1.7v 139.495n 1.7v 139.505n 1.7v 149.495n 1.7v 149.505n 1.7v 159.495n 1.7v 159.505n 1.7v 169.495n 1.7v 169.505n 1.7v 179.495n 1.7v 179.505n 1.7v 189.495n 1.7v 189.505n 1.7v 199.495n 1.7v 199.505n 1.7v 209.495n 1.7v 209.505n 1.7v 219.495n 1.7v 219.505n 1.7v 229.495n 1.7v 229.505n 1.7v 239.495n 1.7v 239.505n 0.0v 249.495n 0.0v 249.505n 0.0v 259.495n 0.0v 259.505n 0.0v 269.495n 0.0v 269.505n 1.7v 279.495n 1.7v 279.505n 1.7v 289.495n 1.7v 289.505n 1.7v 299.495n 1.7v 299.505n 0.0v 309.495n 0.0v 309.505n 0.0v 319.495n 0.0v 319.505n 0.0v 329.495n 0.0v 329.505n 1.7v 339.495n 1.7v 339.505n 1.7v 349.495n 1.7v 349.505n 1.7v 359.495n 1.7v 359.505n 1.7v 369.495n 1.7v 369.505n 1.7v 379.495n 1.7v 379.505n 0.0v 389.495n 0.0v 389.505n 0.0v 399.495n 0.0v 399.505n 0.0v 409.495n 0.0v 409.505n 0.0v 419.495n 0.0v 419.505n 0.0v 429.495n 0.0v 429.505n 1.7v 439.495n 1.7v 439.505n 1.7v 449.495n 1.7v 449.505n 1.7v 459.495n 1.7v 459.505n 0.0v 469.495n 0.0v 469.505n 0.0v 479.495n 0.0v 479.505n 0.0v 489.495n 0.0v 489.505n 0.0v 499.495n 0.0v 499.505n 0.0v 509.495n 0.0v 509.505n 0.0v 519.495n 0.0v 519.505n 1.7v 529.495n 1.7v 529.505n 1.7v 539.495n 1.7v 539.505n 1.7v 549.495n 1.7v 549.505n 1.7v 559.495n 1.7v 559.505n 1.7v 569.495n 1.7v 569.505n 1.7v 579.495n 1.7v 579.505n 1.7v 589.495n 1.7v 589.505n 1.7v 599.495n 1.7v 599.505n 1.7v 609.495n 1.7v 609.505n 1.7v 619.495n 1.7v 619.505n 1.7v 629.495n 1.7v 629.505n 1.7v 639.495n 1.7v 639.505n 1.7v 649.495n 1.7v 649.505n 1.7v 659.495n 1.7v 659.505n 1.7v 669.495n 1.7v 669.505n 0.0v 679.495n 0.0v 679.505n 0.0v 689.495n 0.0v 689.505n 1.7v 699.495n 1.7v 699.505n 0.0v 709.495n 0.0v 709.505n 1.7v 719.495n 1.7v 719.505n 1.7v 729.495n 1.7v 729.505n 1.7v 739.495n 1.7v 739.505n 1.7v 749.495n 1.7v 749.505n 1.7v 759.495n 1.7v 759.505n 1.7v 769.495n 1.7v 769.505n 0.0v 779.495n 0.0v 779.505n 0.0v 789.495n 0.0v 789.505n 1.7v 799.495n 1.7v 799.505n 1.7v 809.495n 1.7v 809.505n 0.0v 819.495n 0.0v 819.505n 1.7v 829.495n 1.7v 829.505n 1.7v 839.495n 1.7v 839.505n 1.7v 849.495n 1.7v 849.505n 1.7v 859.495n 1.7v 859.505n 1.7v 869.495n 1.7v 869.505n 0.0v 879.495n 0.0v 879.505n 0.0v 889.495n 0.0v 889.505n 0.0v 899.495n 0.0v 899.505n 0.0v 909.495n 0.0v 909.505n 0.0v 919.495n 0.0v 919.505n 0.0v 929.495n 0.0v 929.505n 1.7v 939.495n 1.7v 939.505n 1.7v 949.495n 1.7v 949.505n 1.7v 959.495n 1.7v 959.505n 1.7v 969.495n 1.7v 969.505n 0.0v 979.495n 0.0v 979.505n 1.7v 989.495n 1.7v 989.505n 1.7v 999.495n 1.7v 999.505n 1.7v 1009.495n 1.7v 1009.505n 1.7v 1019.495n 1.7v 1019.505n 1.7v 1029.495n 1.7v 1029.505n 1.7v 1039.495n 1.7v 1039.505n 1.7v 1049.495n 1.7v 1049.505n 1.7v 1059.495n 1.7v 1059.505n 1.7v 1069.495n 1.7v 1069.505n 1.7v 1079.495n 1.7v 1079.505n 1.7v 1089.495n 1.7v 1089.505n 1.7v 1099.495n 1.7v 1099.505n 1.7v 1109.495n 1.7v 1109.505n 1.7v 1119.495n 1.7v 1119.505n 1.7v 1129.495n 1.7v 1129.505n 1.7v 1139.495n 1.7v 1139.505n 1.7v 1149.495n 1.7v 1149.505n 0.0v 1159.495n 0.0v 1159.505n 0.0v 1169.495n 0.0v 1169.505n 1.7v 1179.495n 1.7v 1179.505n 1.7v 1189.495n 1.7v 1189.505n 1.7v 1199.495n 1.7v 1199.505n 0.0v 1209.495n 0.0v 1209.505n 0.0v 1219.495n 0.0v 1219.505n 1.7v 1229.495n 1.7v 1229.505n 0.0v 1239.495n 0.0v 1239.505n 1.7v 1249.495n 1.7v 1249.505n 1.7v 1259.495n 1.7v 1259.505n 1.7v 1269.495n 1.7v 1269.505n 1.7v 1279.495n 1.7v 1279.505n 1.7v 1289.495n 1.7v 1289.505n 0.0v 1299.495n 0.0v 1299.505n 0.0v 1309.495n 0.0v 1309.505n 0.0v 1319.495n 0.0v 1319.505n 0.0v 1329.495n 0.0v 1329.505n 0.0v 1339.495n 0.0v 1339.505n 1.7v 1349.495n 1.7v 1349.505n 1.7v 1359.495n 1.7v 1359.505n 1.7v 1369.495n 1.7v 1369.505n 1.7v 1379.495n 1.7v 1379.505n 0.0v 1389.495n 0.0v 1389.505n 0.0v 1399.495n 0.0v 1399.505n 1.7v 1409.495n 1.7v 1409.505n 1.7v 1419.495n 1.7v 1419.505n 1.7v 1429.495n 1.7v 1429.505n 1.7v 1439.495n 1.7v 1439.505n 1.7v 1449.495n 1.7v 1449.505n 0.0v 1459.495n 0.0v 1459.505n 0.0v 1469.495n 0.0v 1469.505n 0.0v 1479.495n 0.0v 1479.505n 0.0v 1489.495n 0.0v 1489.505n 1.7v 1499.495n 1.7v 1499.505n 1.7v 1509.495n 1.7v 1509.505n 1.7v 1519.495n 1.7v 1519.505n 1.7v 1529.495n 1.7v 1529.505n 0.0v 1539.495n 0.0v 1539.505n 0.0v 1549.495n 0.0v 1549.505n 0.0v 1559.495n 0.0v 1559.505n 0.0v 1569.495n 0.0v 1569.505n 1.7v 1579.495n 1.7v 1579.505n 1.7v 1589.495n 1.7v 1589.505n 0.0v 1599.495n 0.0v 1599.505n 0.0v 1609.495n 0.0v 1609.505n 1.7v 1619.495n 1.7v 1619.505n 1.7v 1629.495n 1.7v 1629.505n 1.7v 1639.495n 1.7v 1639.505n 1.7v 1649.495n 1.7v 1649.505n 1.7v 1659.495n 1.7v 1659.505n 1.7v 1669.495n 1.7v 1669.505n 0.0v 1679.495n 0.0v 1679.505n 1.7v 1689.495n 1.7v 1689.505n 1.7v 1699.495n 1.7v 1699.505n 1.7v 1709.495n 1.7v 1709.505n 0.0v 1719.495n 0.0v 1719.505n 1.7v 1729.495n 1.7v 1729.505n 1.7v 1739.495n 1.7v 1739.505n 1.7v 1749.495n 1.7v 1749.505n 1.7v 1759.495n 1.7v 1759.505n 1.7v 1769.495n 1.7v 1769.505n 0.0v 1779.495n 0.0v 1779.505n 0.0v 1789.495n 0.0v 1789.505n 1.7v 1799.495n 1.7v 1799.505n 1.7v 1809.495n 1.7v 1809.505n 1.7v 1819.495n 1.7v 1819.505n 0.0v 1829.495n 0.0v 1829.505n 0.0v 1839.495n 0.0v 1839.505n 1.7v 1849.495n 1.7v 1849.505n 1.7v 1859.495n 1.7v 1859.505n 1.7v 1869.495n 1.7v 1869.505n 1.7v 1879.495n 1.7v 1879.505n 1.7v 1889.495n 1.7v 1889.505n 1.7v 1899.495n 1.7v 1899.505n 0.0v 1909.495n 0.0v 1909.505n 0.0v 1919.495n 0.0v 1919.505n 0.0v 1929.495n 0.0v 1929.505n 1.7v 1939.495n 1.7v 1939.505n 0.0v 1949.495n 0.0v 1949.505n 1.7v 1959.495n 1.7v 1959.505n 1.7v 1969.495n 1.7v 1969.505n 0.0v 1979.495n 0.0v 1979.505n 0.0v 1989.495n 0.0v 1989.505n 1.7v 1999.495n 1.7v 1999.505n 1.7v 2009.495n 1.7v 2009.505n 1.7v 2019.495n 1.7v 2019.505n 1.7v 2029.495n 1.7v 2029.505n 0.0v 2039.495n 0.0v 2039.505n 0.0v 2049.495n 0.0v 2049.505n 0.0v )
* (time, data): [(0, 0), (10, 0), (20, 0), (30, 0), (40, 0), (50, 1), (60, 1), (70, 0), (80, 1), (90, 1), (100, 1), (110, 1), (120, 1), (130, 1), (140, 1), (150, 1), (160, 1), (170, 1), (180, 1), (190, 1), (200, 1), (210, 1), (220, 1), (230, 1), (240, 0), (250, 0), (260, 0), (270, 1), (280, 1), (290, 1), (300, 0), (310, 0), (320, 0), (330, 1), (340, 1), (350, 1), (360, 1), (370, 1), (380, 0), (390, 0), (400, 0), (410, 0), (420, 0), (430, 1), (440, 1), (450, 1), (460, 0), (470, 0), (480, 0), (490, 0), (500, 0), (510, 0), (520, 1), (530, 1), (540, 1), (550, 1), (560, 1), (570, 1), (580, 1), (590, 1), (600, 1), (610, 1), (620, 1), (630, 1), (640, 1), (650, 1), (660, 1), (670, 0), (680, 0), (690, 1), (700, 0), (710, 1), (720, 1), (730, 1), (740, 1), (750, 1), (760, 1), (770, 0), (780, 0), (790, 1), (800, 1), (810, 0), (820, 1), (830, 1), (840, 1), (850, 1), (860, 1), (870, 0), (880, 0), (890, 0), (900, 0), (910, 0), (920, 0), (930, 1), (940, 1), (950, 1), (960, 1), (970, 0), (980, 1), (990, 1), (1000, 1), (1010, 1), (1020, 1), (1030, 1), (1040, 1), (1050, 1), (1060, 1), (1070, 1), (1080, 1), (1090, 1), (1100, 1), (1110, 1), (1120, 1), (1130, 1), (1140, 1), (1150, 0), (1160, 0), (1170, 1), (1180, 1), (1190, 1), (1200, 0), (1210, 0), (1220, 1), (1230, 0), (1240, 1), (1250, 1), (1260, 1), (1270, 1), (1280, 1), (1290, 0), (1300, 0), (1310, 0), (1320, 0), (1330, 0), (1340, 1), (1350, 1), (1360, 1), (1370, 1), (1380, 0), (1390, 0), (1400, 1), (1410, 1), (1420, 1), (1430, 1), (1440, 1), (1450, 0), (1460, 0), (1470, 0), (1480, 0), (1490, 1), (1500, 1), (1510, 1), (1520, 1), (1530, 0), (1540, 0), (1550, 0), (1560, 0), (1570, 1), (1580, 1), (1590, 0), (1600, 0), (1610, 1), (1620, 1), (1630, 1), (1640, 1), (1650, 1), (1660, 1), (1670, 0), (1680, 1), (1690, 1), (1700, 1), (1710, 0), (1720, 1), (1730, 1), (1740, 1), (1750, 1), (1760, 1), (1770, 0), (1780, 0), (1790, 1), (1800, 1), (1810, 1), (1820, 0), (1830, 0), (1840, 1), (1850, 1), (1860, 1), (1870, 1), (1880, 1), (1890, 1), (1900, 0), (1910, 0), (1920, 0), (1930, 1), (1940, 0), (1950, 1), (1960, 1), (1970, 0), (1980, 0), (1990, 1), (2000, 1), (2010, 1), (2020, 1), (2030, 0), (2040, 0), (2050, 0)]
Va0_3  a0_3  0 PWL (0n 0.0v 9.495n 0.0v 9.505n 0.0v 19.495n 0.0v 19.505n 0.0v 29.495n 0.0v 29.505n 0.0v 39.495n 0.0v 39.505n 0.0v 49.495n 0.0v 49.505n 1.7v 59.495n 1.7v 59.505n 1.7v 69.495n 1.7v 69.505n 0.0v 79.495n 0.0v 79.505n 1.7v 89.495n 1.7v 89.505n 1.7v 99.495n 1.7v 99.505n 1.7v 109.495n 1.7v 109.505n 1.7v 119.495n 1.7v 119.505n 1.7v 129.495n 1.7v 129.505n 1.7v 139.495n 1.7v 139.505n 1.7v 149.495n 1.7v 149.505n 1.7v 159.495n 1.7v 159.505n 1.7v 169.495n 1.7v 169.505n 1.7v 179.495n 1.7v 179.505n 1.7v 189.495n 1.7v 189.505n 1.7v 199.495n 1.7v 199.505n 1.7v 209.495n 1.7v 209.505n 1.7v 219.495n 1.7v 219.505n 1.7v 229.495n 1.7v 229.505n 1.7v 239.495n 1.7v 239.505n 0.0v 249.495n 0.0v 249.505n 0.0v 259.495n 0.0v 259.505n 0.0v 269.495n 0.0v 269.505n 1.7v 279.495n 1.7v 279.505n 1.7v 289.495n 1.7v 289.505n 1.7v 299.495n 1.7v 299.505n 0.0v 309.495n 0.0v 309.505n 0.0v 319.495n 0.0v 319.505n 0.0v 329.495n 0.0v 329.505n 1.7v 339.495n 1.7v 339.505n 1.7v 349.495n 1.7v 349.505n 1.7v 359.495n 1.7v 359.505n 1.7v 369.495n 1.7v 369.505n 1.7v 379.495n 1.7v 379.505n 0.0v 389.495n 0.0v 389.505n 0.0v 399.495n 0.0v 399.505n 0.0v 409.495n 0.0v 409.505n 0.0v 419.495n 0.0v 419.505n 0.0v 429.495n 0.0v 429.505n 1.7v 439.495n 1.7v 439.505n 1.7v 449.495n 1.7v 449.505n 1.7v 459.495n 1.7v 459.505n 0.0v 469.495n 0.0v 469.505n 0.0v 479.495n 0.0v 479.505n 0.0v 489.495n 0.0v 489.505n 0.0v 499.495n 0.0v 499.505n 0.0v 509.495n 0.0v 509.505n 0.0v 519.495n 0.0v 519.505n 1.7v 529.495n 1.7v 529.505n 1.7v 539.495n 1.7v 539.505n 1.7v 549.495n 1.7v 549.505n 1.7v 559.495n 1.7v 559.505n 1.7v 569.495n 1.7v 569.505n 1.7v 579.495n 1.7v 579.505n 1.7v 589.495n 1.7v 589.505n 1.7v 599.495n 1.7v 599.505n 1.7v 609.495n 1.7v 609.505n 1.7v 619.495n 1.7v 619.505n 1.7v 629.495n 1.7v 629.505n 1.7v 639.495n 1.7v 639.505n 1.7v 649.495n 1.7v 649.505n 1.7v 659.495n 1.7v 659.505n 1.7v 669.495n 1.7v 669.505n 0.0v 679.495n 0.0v 679.505n 0.0v 689.495n 0.0v 689.505n 1.7v 699.495n 1.7v 699.505n 0.0v 709.495n 0.0v 709.505n 1.7v 719.495n 1.7v 719.505n 1.7v 729.495n 1.7v 729.505n 1.7v 739.495n 1.7v 739.505n 1.7v 749.495n 1.7v 749.505n 1.7v 759.495n 1.7v 759.505n 1.7v 769.495n 1.7v 769.505n 0.0v 779.495n 0.0v 779.505n 0.0v 789.495n 0.0v 789.505n 1.7v 799.495n 1.7v 799.505n 1.7v 809.495n 1.7v 809.505n 0.0v 819.495n 0.0v 819.505n 1.7v 829.495n 1.7v 829.505n 1.7v 839.495n 1.7v 839.505n 1.7v 849.495n 1.7v 849.505n 1.7v 859.495n 1.7v 859.505n 1.7v 869.495n 1.7v 869.505n 0.0v 879.495n 0.0v 879.505n 0.0v 889.495n 0.0v 889.505n 0.0v 899.495n 0.0v 899.505n 0.0v 909.495n 0.0v 909.505n 0.0v 919.495n 0.0v 919.505n 0.0v 929.495n 0.0v 929.505n 1.7v 939.495n 1.7v 939.505n 1.7v 949.495n 1.7v 949.505n 1.7v 959.495n 1.7v 959.505n 1.7v 969.495n 1.7v 969.505n 0.0v 979.495n 0.0v 979.505n 1.7v 989.495n 1.7v 989.505n 1.7v 999.495n 1.7v 999.505n 1.7v 1009.495n 1.7v 1009.505n 1.7v 1019.495n 1.7v 1019.505n 1.7v 1029.495n 1.7v 1029.505n 1.7v 1039.495n 1.7v 1039.505n 1.7v 1049.495n 1.7v 1049.505n 1.7v 1059.495n 1.7v 1059.505n 1.7v 1069.495n 1.7v 1069.505n 1.7v 1079.495n 1.7v 1079.505n 1.7v 1089.495n 1.7v 1089.505n 1.7v 1099.495n 1.7v 1099.505n 1.7v 1109.495n 1.7v 1109.505n 1.7v 1119.495n 1.7v 1119.505n 1.7v 1129.495n 1.7v 1129.505n 1.7v 1139.495n 1.7v 1139.505n 1.7v 1149.495n 1.7v 1149.505n 0.0v 1159.495n 0.0v 1159.505n 0.0v 1169.495n 0.0v 1169.505n 1.7v 1179.495n 1.7v 1179.505n 1.7v 1189.495n 1.7v 1189.505n 1.7v 1199.495n 1.7v 1199.505n 0.0v 1209.495n 0.0v 1209.505n 0.0v 1219.495n 0.0v 1219.505n 1.7v 1229.495n 1.7v 1229.505n 0.0v 1239.495n 0.0v 1239.505n 1.7v 1249.495n 1.7v 1249.505n 1.7v 1259.495n 1.7v 1259.505n 1.7v 1269.495n 1.7v 1269.505n 1.7v 1279.495n 1.7v 1279.505n 1.7v 1289.495n 1.7v 1289.505n 0.0v 1299.495n 0.0v 1299.505n 0.0v 1309.495n 0.0v 1309.505n 0.0v 1319.495n 0.0v 1319.505n 0.0v 1329.495n 0.0v 1329.505n 0.0v 1339.495n 0.0v 1339.505n 1.7v 1349.495n 1.7v 1349.505n 1.7v 1359.495n 1.7v 1359.505n 1.7v 1369.495n 1.7v 1369.505n 1.7v 1379.495n 1.7v 1379.505n 0.0v 1389.495n 0.0v 1389.505n 0.0v 1399.495n 0.0v 1399.505n 1.7v 1409.495n 1.7v 1409.505n 1.7v 1419.495n 1.7v 1419.505n 1.7v 1429.495n 1.7v 1429.505n 1.7v 1439.495n 1.7v 1439.505n 1.7v 1449.495n 1.7v 1449.505n 0.0v 1459.495n 0.0v 1459.505n 0.0v 1469.495n 0.0v 1469.505n 0.0v 1479.495n 0.0v 1479.505n 0.0v 1489.495n 0.0v 1489.505n 1.7v 1499.495n 1.7v 1499.505n 1.7v 1509.495n 1.7v 1509.505n 1.7v 1519.495n 1.7v 1519.505n 1.7v 1529.495n 1.7v 1529.505n 0.0v 1539.495n 0.0v 1539.505n 0.0v 1549.495n 0.0v 1549.505n 0.0v 1559.495n 0.0v 1559.505n 0.0v 1569.495n 0.0v 1569.505n 1.7v 1579.495n 1.7v 1579.505n 1.7v 1589.495n 1.7v 1589.505n 0.0v 1599.495n 0.0v 1599.505n 0.0v 1609.495n 0.0v 1609.505n 1.7v 1619.495n 1.7v 1619.505n 1.7v 1629.495n 1.7v 1629.505n 1.7v 1639.495n 1.7v 1639.505n 1.7v 1649.495n 1.7v 1649.505n 1.7v 1659.495n 1.7v 1659.505n 1.7v 1669.495n 1.7v 1669.505n 0.0v 1679.495n 0.0v 1679.505n 1.7v 1689.495n 1.7v 1689.505n 1.7v 1699.495n 1.7v 1699.505n 1.7v 1709.495n 1.7v 1709.505n 0.0v 1719.495n 0.0v 1719.505n 1.7v 1729.495n 1.7v 1729.505n 1.7v 1739.495n 1.7v 1739.505n 1.7v 1749.495n 1.7v 1749.505n 1.7v 1759.495n 1.7v 1759.505n 1.7v 1769.495n 1.7v 1769.505n 0.0v 1779.495n 0.0v 1779.505n 0.0v 1789.495n 0.0v 1789.505n 1.7v 1799.495n 1.7v 1799.505n 1.7v 1809.495n 1.7v 1809.505n 1.7v 1819.495n 1.7v 1819.505n 0.0v 1829.495n 0.0v 1829.505n 0.0v 1839.495n 0.0v 1839.505n 1.7v 1849.495n 1.7v 1849.505n 1.7v 1859.495n 1.7v 1859.505n 1.7v 1869.495n 1.7v 1869.505n 1.7v 1879.495n 1.7v 1879.505n 1.7v 1889.495n 1.7v 1889.505n 1.7v 1899.495n 1.7v 1899.505n 0.0v 1909.495n 0.0v 1909.505n 0.0v 1919.495n 0.0v 1919.505n 0.0v 1929.495n 0.0v 1929.505n 1.7v 1939.495n 1.7v 1939.505n 0.0v 1949.495n 0.0v 1949.505n 1.7v 1959.495n 1.7v 1959.505n 1.7v 1969.495n 1.7v 1969.505n 0.0v 1979.495n 0.0v 1979.505n 0.0v 1989.495n 0.0v 1989.505n 1.7v 1999.495n 1.7v 1999.505n 1.7v 2009.495n 1.7v 2009.505n 1.7v 2019.495n 1.7v 2019.505n 1.7v 2029.495n 1.7v 2029.505n 0.0v 2039.495n 0.0v 2039.505n 0.0v 2049.495n 0.0v 2049.505n 0.0v )
* (time, data): [(0, 0), (10, 0), (20, 0), (30, 0), (40, 0), (50, 1), (60, 1), (70, 0), (80, 1), (90, 1), (100, 1), (110, 1), (120, 1), (130, 1), (140, 1), (150, 1), (160, 1), (170, 1), (180, 1), (190, 1), (200, 1), (210, 1), (220, 1), (230, 1), (240, 0), (250, 0), (260, 0), (270, 1), (280, 1), (290, 1), (300, 0), (310, 0), (320, 0), (330, 1), (340, 1), (350, 1), (360, 1), (370, 1), (380, 0), (390, 0), (400, 0), (410, 0), (420, 0), (430, 1), (440, 1), (450, 1), (460, 0), (470, 0), (480, 0), (490, 0), (500, 0), (510, 0), (520, 1), (530, 1), (540, 1), (550, 1), (560, 1), (570, 1), (580, 1), (590, 1), (600, 1), (610, 1), (620, 1), (630, 1), (640, 1), (650, 1), (660, 1), (670, 0), (680, 0), (690, 1), (700, 0), (710, 1), (720, 1), (730, 1), (740, 1), (750, 1), (760, 1), (770, 0), (780, 0), (790, 1), (800, 1), (810, 0), (820, 1), (830, 1), (840, 1), (850, 1), (860, 1), (870, 0), (880, 0), (890, 0), (900, 0), (910, 0), (920, 0), (930, 1), (940, 1), (950, 1), (960, 1), (970, 0), (980, 1), (990, 1), (1000, 1), (1010, 1), (1020, 1), (1030, 1), (1040, 1), (1050, 1), (1060, 1), (1070, 1), (1080, 1), (1090, 1), (1100, 1), (1110, 1), (1120, 1), (1130, 1), (1140, 1), (1150, 0), (1160, 0), (1170, 1), (1180, 1), (1190, 1), (1200, 0), (1210, 0), (1220, 1), (1230, 0), (1240, 1), (1250, 1), (1260, 1), (1270, 1), (1280, 1), (1290, 0), (1300, 0), (1310, 0), (1320, 0), (1330, 0), (1340, 1), (1350, 1), (1360, 1), (1370, 1), (1380, 0), (1390, 0), (1400, 1), (1410, 1), (1420, 1), (1430, 1), (1440, 1), (1450, 0), (1460, 0), (1470, 0), (1480, 0), (1490, 1), (1500, 1), (1510, 1), (1520, 1), (1530, 0), (1540, 0), (1550, 0), (1560, 0), (1570, 1), (1580, 1), (1590, 0), (1600, 0), (1610, 1), (1620, 1), (1630, 1), (1640, 1), (1650, 1), (1660, 1), (1670, 0), (1680, 1), (1690, 1), (1700, 1), (1710, 0), (1720, 1), (1730, 1), (1740, 1), (1750, 1), (1760, 1), (1770, 0), (1780, 0), (1790, 1), (1800, 1), (1810, 1), (1820, 0), (1830, 0), (1840, 1), (1850, 1), (1860, 1), (1870, 1), (1880, 1), (1890, 1), (1900, 0), (1910, 0), (1920, 0), (1930, 1), (1940, 0), (1950, 1), (1960, 1), (1970, 0), (1980, 0), (1990, 1), (2000, 1), (2010, 1), (2020, 1), (2030, 0), (2040, 0), (2050, 0)]
Va0_4  a0_4  0 PWL (0n 0.0v 9.495n 0.0v 9.505n 0.0v 19.495n 0.0v 19.505n 0.0v 29.495n 0.0v 29.505n 0.0v 39.495n 0.0v 39.505n 0.0v 49.495n 0.0v 49.505n 1.7v 59.495n 1.7v 59.505n 1.7v 69.495n 1.7v 69.505n 0.0v 79.495n 0.0v 79.505n 1.7v 89.495n 1.7v 89.505n 1.7v 99.495n 1.7v 99.505n 1.7v 109.495n 1.7v 109.505n 1.7v 119.495n 1.7v 119.505n 1.7v 129.495n 1.7v 129.505n 1.7v 139.495n 1.7v 139.505n 1.7v 149.495n 1.7v 149.505n 1.7v 159.495n 1.7v 159.505n 1.7v 169.495n 1.7v 169.505n 1.7v 179.495n 1.7v 179.505n 1.7v 189.495n 1.7v 189.505n 1.7v 199.495n 1.7v 199.505n 1.7v 209.495n 1.7v 209.505n 1.7v 219.495n 1.7v 219.505n 1.7v 229.495n 1.7v 229.505n 1.7v 239.495n 1.7v 239.505n 0.0v 249.495n 0.0v 249.505n 0.0v 259.495n 0.0v 259.505n 0.0v 269.495n 0.0v 269.505n 1.7v 279.495n 1.7v 279.505n 1.7v 289.495n 1.7v 289.505n 1.7v 299.495n 1.7v 299.505n 0.0v 309.495n 0.0v 309.505n 0.0v 319.495n 0.0v 319.505n 0.0v 329.495n 0.0v 329.505n 1.7v 339.495n 1.7v 339.505n 1.7v 349.495n 1.7v 349.505n 1.7v 359.495n 1.7v 359.505n 1.7v 369.495n 1.7v 369.505n 1.7v 379.495n 1.7v 379.505n 0.0v 389.495n 0.0v 389.505n 0.0v 399.495n 0.0v 399.505n 0.0v 409.495n 0.0v 409.505n 0.0v 419.495n 0.0v 419.505n 0.0v 429.495n 0.0v 429.505n 1.7v 439.495n 1.7v 439.505n 1.7v 449.495n 1.7v 449.505n 1.7v 459.495n 1.7v 459.505n 0.0v 469.495n 0.0v 469.505n 0.0v 479.495n 0.0v 479.505n 0.0v 489.495n 0.0v 489.505n 0.0v 499.495n 0.0v 499.505n 0.0v 509.495n 0.0v 509.505n 0.0v 519.495n 0.0v 519.505n 1.7v 529.495n 1.7v 529.505n 1.7v 539.495n 1.7v 539.505n 1.7v 549.495n 1.7v 549.505n 1.7v 559.495n 1.7v 559.505n 1.7v 569.495n 1.7v 569.505n 1.7v 579.495n 1.7v 579.505n 1.7v 589.495n 1.7v 589.505n 1.7v 599.495n 1.7v 599.505n 1.7v 609.495n 1.7v 609.505n 1.7v 619.495n 1.7v 619.505n 1.7v 629.495n 1.7v 629.505n 1.7v 639.495n 1.7v 639.505n 1.7v 649.495n 1.7v 649.505n 1.7v 659.495n 1.7v 659.505n 1.7v 669.495n 1.7v 669.505n 0.0v 679.495n 0.0v 679.505n 0.0v 689.495n 0.0v 689.505n 1.7v 699.495n 1.7v 699.505n 0.0v 709.495n 0.0v 709.505n 1.7v 719.495n 1.7v 719.505n 1.7v 729.495n 1.7v 729.505n 1.7v 739.495n 1.7v 739.505n 1.7v 749.495n 1.7v 749.505n 1.7v 759.495n 1.7v 759.505n 1.7v 769.495n 1.7v 769.505n 0.0v 779.495n 0.0v 779.505n 0.0v 789.495n 0.0v 789.505n 1.7v 799.495n 1.7v 799.505n 1.7v 809.495n 1.7v 809.505n 0.0v 819.495n 0.0v 819.505n 1.7v 829.495n 1.7v 829.505n 1.7v 839.495n 1.7v 839.505n 1.7v 849.495n 1.7v 849.505n 1.7v 859.495n 1.7v 859.505n 1.7v 869.495n 1.7v 869.505n 0.0v 879.495n 0.0v 879.505n 0.0v 889.495n 0.0v 889.505n 0.0v 899.495n 0.0v 899.505n 0.0v 909.495n 0.0v 909.505n 0.0v 919.495n 0.0v 919.505n 0.0v 929.495n 0.0v 929.505n 1.7v 939.495n 1.7v 939.505n 1.7v 949.495n 1.7v 949.505n 1.7v 959.495n 1.7v 959.505n 1.7v 969.495n 1.7v 969.505n 0.0v 979.495n 0.0v 979.505n 1.7v 989.495n 1.7v 989.505n 1.7v 999.495n 1.7v 999.505n 1.7v 1009.495n 1.7v 1009.505n 1.7v 1019.495n 1.7v 1019.505n 1.7v 1029.495n 1.7v 1029.505n 1.7v 1039.495n 1.7v 1039.505n 1.7v 1049.495n 1.7v 1049.505n 1.7v 1059.495n 1.7v 1059.505n 1.7v 1069.495n 1.7v 1069.505n 1.7v 1079.495n 1.7v 1079.505n 1.7v 1089.495n 1.7v 1089.505n 1.7v 1099.495n 1.7v 1099.505n 1.7v 1109.495n 1.7v 1109.505n 1.7v 1119.495n 1.7v 1119.505n 1.7v 1129.495n 1.7v 1129.505n 1.7v 1139.495n 1.7v 1139.505n 1.7v 1149.495n 1.7v 1149.505n 0.0v 1159.495n 0.0v 1159.505n 0.0v 1169.495n 0.0v 1169.505n 1.7v 1179.495n 1.7v 1179.505n 1.7v 1189.495n 1.7v 1189.505n 1.7v 1199.495n 1.7v 1199.505n 0.0v 1209.495n 0.0v 1209.505n 0.0v 1219.495n 0.0v 1219.505n 1.7v 1229.495n 1.7v 1229.505n 0.0v 1239.495n 0.0v 1239.505n 1.7v 1249.495n 1.7v 1249.505n 1.7v 1259.495n 1.7v 1259.505n 1.7v 1269.495n 1.7v 1269.505n 1.7v 1279.495n 1.7v 1279.505n 1.7v 1289.495n 1.7v 1289.505n 0.0v 1299.495n 0.0v 1299.505n 0.0v 1309.495n 0.0v 1309.505n 0.0v 1319.495n 0.0v 1319.505n 0.0v 1329.495n 0.0v 1329.505n 0.0v 1339.495n 0.0v 1339.505n 1.7v 1349.495n 1.7v 1349.505n 1.7v 1359.495n 1.7v 1359.505n 1.7v 1369.495n 1.7v 1369.505n 1.7v 1379.495n 1.7v 1379.505n 0.0v 1389.495n 0.0v 1389.505n 0.0v 1399.495n 0.0v 1399.505n 1.7v 1409.495n 1.7v 1409.505n 1.7v 1419.495n 1.7v 1419.505n 1.7v 1429.495n 1.7v 1429.505n 1.7v 1439.495n 1.7v 1439.505n 1.7v 1449.495n 1.7v 1449.505n 0.0v 1459.495n 0.0v 1459.505n 0.0v 1469.495n 0.0v 1469.505n 0.0v 1479.495n 0.0v 1479.505n 0.0v 1489.495n 0.0v 1489.505n 1.7v 1499.495n 1.7v 1499.505n 1.7v 1509.495n 1.7v 1509.505n 1.7v 1519.495n 1.7v 1519.505n 1.7v 1529.495n 1.7v 1529.505n 0.0v 1539.495n 0.0v 1539.505n 0.0v 1549.495n 0.0v 1549.505n 0.0v 1559.495n 0.0v 1559.505n 0.0v 1569.495n 0.0v 1569.505n 1.7v 1579.495n 1.7v 1579.505n 1.7v 1589.495n 1.7v 1589.505n 0.0v 1599.495n 0.0v 1599.505n 0.0v 1609.495n 0.0v 1609.505n 1.7v 1619.495n 1.7v 1619.505n 1.7v 1629.495n 1.7v 1629.505n 1.7v 1639.495n 1.7v 1639.505n 1.7v 1649.495n 1.7v 1649.505n 1.7v 1659.495n 1.7v 1659.505n 1.7v 1669.495n 1.7v 1669.505n 0.0v 1679.495n 0.0v 1679.505n 1.7v 1689.495n 1.7v 1689.505n 1.7v 1699.495n 1.7v 1699.505n 1.7v 1709.495n 1.7v 1709.505n 0.0v 1719.495n 0.0v 1719.505n 1.7v 1729.495n 1.7v 1729.505n 1.7v 1739.495n 1.7v 1739.505n 1.7v 1749.495n 1.7v 1749.505n 1.7v 1759.495n 1.7v 1759.505n 1.7v 1769.495n 1.7v 1769.505n 0.0v 1779.495n 0.0v 1779.505n 0.0v 1789.495n 0.0v 1789.505n 1.7v 1799.495n 1.7v 1799.505n 1.7v 1809.495n 1.7v 1809.505n 1.7v 1819.495n 1.7v 1819.505n 0.0v 1829.495n 0.0v 1829.505n 0.0v 1839.495n 0.0v 1839.505n 1.7v 1849.495n 1.7v 1849.505n 1.7v 1859.495n 1.7v 1859.505n 1.7v 1869.495n 1.7v 1869.505n 1.7v 1879.495n 1.7v 1879.505n 1.7v 1889.495n 1.7v 1889.505n 1.7v 1899.495n 1.7v 1899.505n 0.0v 1909.495n 0.0v 1909.505n 0.0v 1919.495n 0.0v 1919.505n 0.0v 1929.495n 0.0v 1929.505n 1.7v 1939.495n 1.7v 1939.505n 0.0v 1949.495n 0.0v 1949.505n 1.7v 1959.495n 1.7v 1959.505n 1.7v 1969.495n 1.7v 1969.505n 0.0v 1979.495n 0.0v 1979.505n 0.0v 1989.495n 0.0v 1989.505n 1.7v 1999.495n 1.7v 1999.505n 1.7v 2009.495n 1.7v 2009.505n 1.7v 2019.495n 1.7v 2019.505n 1.7v 2029.495n 1.7v 2029.505n 0.0v 2039.495n 0.0v 2039.505n 0.0v 2049.495n 0.0v 2049.505n 0.0v )
* (time, data): [(0, 0), (10, 0), (20, 0), (30, 0), (40, 0), (50, 0), (60, 0), (70, 0), (80, 0), (90, 0), (100, 0), (110, 0), (120, 0), (130, 0), (140, 0), (150, 0), (160, 0), (170, 0), (180, 0), (190, 0), (200, 0), (210, 0), (220, 0), (230, 0), (240, 0), (250, 0), (260, 0), (270, 0), (280, 0), (290, 0), (300, 0), (310, 0), (320, 0), (330, 0), (340, 0), (350, 0), (360, 0), (370, 0), (380, 0), (390, 0), (400, 0), (410, 0), (420, 0), (430, 0), (440, 0), (450, 0), (460, 0), (470, 0), (480, 0), (490, 0), (500, 0), (510, 0), (520, 0), (530, 0), (540, 0), (550, 0), (560, 0), (570, 0), (580, 0), (590, 0), (600, 0), (610, 0), (620, 0), (630, 0), (640, 0), (650, 0), (660, 0), (670, 0), (680, 0), (690, 0), (700, 0), (710, 0), (720, 0), (730, 0), (740, 0), (750, 0), (760, 0), (770, 0), (780, 0), (790, 0), (800, 0), (810, 0), (820, 0), (830, 0), (840, 0), (850, 0), (860, 0), (870, 0), (880, 0), (890, 0), (900, 0), (910, 0), (920, 0), (930, 0), (940, 0), (950, 0), (960, 0), (970, 0), (980, 0), (990, 0), (1000, 0), (1010, 0), (1020, 0), (1030, 0), (1040, 0), (1050, 0), (1060, 0), (1070, 0), (1080, 0), (1090, 0), (1100, 0), (1110, 0), (1120, 0), (1130, 0), (1140, 0), (1150, 0), (1160, 0), (1170, 0), (1180, 0), (1190, 0), (1200, 0), (1210, 0), (1220, 0), (1230, 0), (1240, 0), (1250, 0), (1260, 0), (1270, 0), (1280, 0), (1290, 0), (1300, 0), (1310, 0), (1320, 0), (1330, 0), (1340, 0), (1350, 0), (1360, 0), (1370, 0), (1380, 0), (1390, 0), (1400, 0), (1410, 0), (1420, 0), (1430, 0), (1440, 0), (1450, 0), (1460, 0), (1470, 0), (1480, 0), (1490, 0), (1500, 0), (1510, 0), (1520, 0), (1530, 0), (1540, 0), (1550, 0), (1560, 0), (1570, 0), (1580, 0), (1590, 0), (1600, 0), (1610, 0), (1620, 0), (1630, 0), (1640, 0), (1650, 0), (1660, 0), (1670, 0), (1680, 0), (1690, 0), (1700, 0), (1710, 0), (1720, 0), (1730, 0), (1740, 0), (1750, 0), (1760, 0), (1770, 0), (1780, 0), (1790, 0), (1800, 0), (1810, 0), (1820, 0), (1830, 0), (1840, 0), (1850, 0), (1860, 0), (1870, 0), (1880, 0), (1890, 0), (1900, 0), (1910, 0), (1920, 0), (1930, 0), (1940, 0), (1950, 0), (1960, 0), (1970, 0), (1980, 0), (1990, 0), (2000, 0), (2010, 0), (2020, 0), (2030, 0), (2040, 0), (2050, 0)]
Va0_5  a0_5  0 PWL (0n 0.0v 9.495n 0.0v 9.505n 0.0v 19.495n 0.0v 19.505n 0.0v 29.495n 0.0v 29.505n 0.0v 39.495n 0.0v 39.505n 0.0v 49.495n 0.0v 49.505n 0.0v 59.495n 0.0v 59.505n 0.0v 69.495n 0.0v 69.505n 0.0v 79.495n 0.0v 79.505n 0.0v 89.495n 0.0v 89.505n 0.0v 99.495n 0.0v 99.505n 0.0v 109.495n 0.0v 109.505n 0.0v 119.495n 0.0v 119.505n 0.0v 129.495n 0.0v 129.505n 0.0v 139.495n 0.0v 139.505n 0.0v 149.495n 0.0v 149.505n 0.0v 159.495n 0.0v 159.505n 0.0v 169.495n 0.0v 169.505n 0.0v 179.495n 0.0v 179.505n 0.0v 189.495n 0.0v 189.505n 0.0v 199.495n 0.0v 199.505n 0.0v 209.495n 0.0v 209.505n 0.0v 219.495n 0.0v 219.505n 0.0v 229.495n 0.0v 229.505n 0.0v 239.495n 0.0v 239.505n 0.0v 249.495n 0.0v 249.505n 0.0v 259.495n 0.0v 259.505n 0.0v 269.495n 0.0v 269.505n 0.0v 279.495n 0.0v 279.505n 0.0v 289.495n 0.0v 289.505n 0.0v 299.495n 0.0v 299.505n 0.0v 309.495n 0.0v 309.505n 0.0v 319.495n 0.0v 319.505n 0.0v 329.495n 0.0v 329.505n 0.0v 339.495n 0.0v 339.505n 0.0v 349.495n 0.0v 349.505n 0.0v 359.495n 0.0v 359.505n 0.0v 369.495n 0.0v 369.505n 0.0v 379.495n 0.0v 379.505n 0.0v 389.495n 0.0v 389.505n 0.0v 399.495n 0.0v 399.505n 0.0v 409.495n 0.0v 409.505n 0.0v 419.495n 0.0v 419.505n 0.0v 429.495n 0.0v 429.505n 0.0v 439.495n 0.0v 439.505n 0.0v 449.495n 0.0v 449.505n 0.0v 459.495n 0.0v 459.505n 0.0v 469.495n 0.0v 469.505n 0.0v 479.495n 0.0v 479.505n 0.0v 489.495n 0.0v 489.505n 0.0v 499.495n 0.0v 499.505n 0.0v 509.495n 0.0v 509.505n 0.0v 519.495n 0.0v 519.505n 0.0v 529.495n 0.0v 529.505n 0.0v 539.495n 0.0v 539.505n 0.0v 549.495n 0.0v 549.505n 0.0v 559.495n 0.0v 559.505n 0.0v 569.495n 0.0v 569.505n 0.0v 579.495n 0.0v 579.505n 0.0v 589.495n 0.0v 589.505n 0.0v 599.495n 0.0v 599.505n 0.0v 609.495n 0.0v 609.505n 0.0v 619.495n 0.0v 619.505n 0.0v 629.495n 0.0v 629.505n 0.0v 639.495n 0.0v 639.505n 0.0v 649.495n 0.0v 649.505n 0.0v 659.495n 0.0v 659.505n 0.0v 669.495n 0.0v 669.505n 0.0v 679.495n 0.0v 679.505n 0.0v 689.495n 0.0v 689.505n 0.0v 699.495n 0.0v 699.505n 0.0v 709.495n 0.0v 709.505n 0.0v 719.495n 0.0v 719.505n 0.0v 729.495n 0.0v 729.505n 0.0v 739.495n 0.0v 739.505n 0.0v 749.495n 0.0v 749.505n 0.0v 759.495n 0.0v 759.505n 0.0v 769.495n 0.0v 769.505n 0.0v 779.495n 0.0v 779.505n 0.0v 789.495n 0.0v 789.505n 0.0v 799.495n 0.0v 799.505n 0.0v 809.495n 0.0v 809.505n 0.0v 819.495n 0.0v 819.505n 0.0v 829.495n 0.0v 829.505n 0.0v 839.495n 0.0v 839.505n 0.0v 849.495n 0.0v 849.505n 0.0v 859.495n 0.0v 859.505n 0.0v 869.495n 0.0v 869.505n 0.0v 879.495n 0.0v 879.505n 0.0v 889.495n 0.0v 889.505n 0.0v 899.495n 0.0v 899.505n 0.0v 909.495n 0.0v 909.505n 0.0v 919.495n 0.0v 919.505n 0.0v 929.495n 0.0v 929.505n 0.0v 939.495n 0.0v 939.505n 0.0v 949.495n 0.0v 949.505n 0.0v 959.495n 0.0v 959.505n 0.0v 969.495n 0.0v 969.505n 0.0v 979.495n 0.0v 979.505n 0.0v 989.495n 0.0v 989.505n 0.0v 999.495n 0.0v 999.505n 0.0v 1009.495n 0.0v 1009.505n 0.0v 1019.495n 0.0v 1019.505n 0.0v 1029.495n 0.0v 1029.505n 0.0v 1039.495n 0.0v 1039.505n 0.0v 1049.495n 0.0v 1049.505n 0.0v 1059.495n 0.0v 1059.505n 0.0v 1069.495n 0.0v 1069.505n 0.0v 1079.495n 0.0v 1079.505n 0.0v 1089.495n 0.0v 1089.505n 0.0v 1099.495n 0.0v 1099.505n 0.0v 1109.495n 0.0v 1109.505n 0.0v 1119.495n 0.0v 1119.505n 0.0v 1129.495n 0.0v 1129.505n 0.0v 1139.495n 0.0v 1139.505n 0.0v 1149.495n 0.0v 1149.505n 0.0v 1159.495n 0.0v 1159.505n 0.0v 1169.495n 0.0v 1169.505n 0.0v 1179.495n 0.0v 1179.505n 0.0v 1189.495n 0.0v 1189.505n 0.0v 1199.495n 0.0v 1199.505n 0.0v 1209.495n 0.0v 1209.505n 0.0v 1219.495n 0.0v 1219.505n 0.0v 1229.495n 0.0v 1229.505n 0.0v 1239.495n 0.0v 1239.505n 0.0v 1249.495n 0.0v 1249.505n 0.0v 1259.495n 0.0v 1259.505n 0.0v 1269.495n 0.0v 1269.505n 0.0v 1279.495n 0.0v 1279.505n 0.0v 1289.495n 0.0v 1289.505n 0.0v 1299.495n 0.0v 1299.505n 0.0v 1309.495n 0.0v 1309.505n 0.0v 1319.495n 0.0v 1319.505n 0.0v 1329.495n 0.0v 1329.505n 0.0v 1339.495n 0.0v 1339.505n 0.0v 1349.495n 0.0v 1349.505n 0.0v 1359.495n 0.0v 1359.505n 0.0v 1369.495n 0.0v 1369.505n 0.0v 1379.495n 0.0v 1379.505n 0.0v 1389.495n 0.0v 1389.505n 0.0v 1399.495n 0.0v 1399.505n 0.0v 1409.495n 0.0v 1409.505n 0.0v 1419.495n 0.0v 1419.505n 0.0v 1429.495n 0.0v 1429.505n 0.0v 1439.495n 0.0v 1439.505n 0.0v 1449.495n 0.0v 1449.505n 0.0v 1459.495n 0.0v 1459.505n 0.0v 1469.495n 0.0v 1469.505n 0.0v 1479.495n 0.0v 1479.505n 0.0v 1489.495n 0.0v 1489.505n 0.0v 1499.495n 0.0v 1499.505n 0.0v 1509.495n 0.0v 1509.505n 0.0v 1519.495n 0.0v 1519.505n 0.0v 1529.495n 0.0v 1529.505n 0.0v 1539.495n 0.0v 1539.505n 0.0v 1549.495n 0.0v 1549.505n 0.0v 1559.495n 0.0v 1559.505n 0.0v 1569.495n 0.0v 1569.505n 0.0v 1579.495n 0.0v 1579.505n 0.0v 1589.495n 0.0v 1589.505n 0.0v 1599.495n 0.0v 1599.505n 0.0v 1609.495n 0.0v 1609.505n 0.0v 1619.495n 0.0v 1619.505n 0.0v 1629.495n 0.0v 1629.505n 0.0v 1639.495n 0.0v 1639.505n 0.0v 1649.495n 0.0v 1649.505n 0.0v 1659.495n 0.0v 1659.505n 0.0v 1669.495n 0.0v 1669.505n 0.0v 1679.495n 0.0v 1679.505n 0.0v 1689.495n 0.0v 1689.505n 0.0v 1699.495n 0.0v 1699.505n 0.0v 1709.495n 0.0v 1709.505n 0.0v 1719.495n 0.0v 1719.505n 0.0v 1729.495n 0.0v 1729.505n 0.0v 1739.495n 0.0v 1739.505n 0.0v 1749.495n 0.0v 1749.505n 0.0v 1759.495n 0.0v 1759.505n 0.0v 1769.495n 0.0v 1769.505n 0.0v 1779.495n 0.0v 1779.505n 0.0v 1789.495n 0.0v 1789.505n 0.0v 1799.495n 0.0v 1799.505n 0.0v 1809.495n 0.0v 1809.505n 0.0v 1819.495n 0.0v 1819.505n 0.0v 1829.495n 0.0v 1829.505n 0.0v 1839.495n 0.0v 1839.505n 0.0v 1849.495n 0.0v 1849.505n 0.0v 1859.495n 0.0v 1859.505n 0.0v 1869.495n 0.0v 1869.505n 0.0v 1879.495n 0.0v 1879.505n 0.0v 1889.495n 0.0v 1889.505n 0.0v 1899.495n 0.0v 1899.505n 0.0v 1909.495n 0.0v 1909.505n 0.0v 1919.495n 0.0v 1919.505n 0.0v 1929.495n 0.0v 1929.505n 0.0v 1939.495n 0.0v 1939.505n 0.0v 1949.495n 0.0v 1949.505n 0.0v 1959.495n 0.0v 1959.505n 0.0v 1969.495n 0.0v 1969.505n 0.0v 1979.495n 0.0v 1979.505n 0.0v 1989.495n 0.0v 1989.505n 0.0v 1999.495n 0.0v 1999.505n 0.0v 2009.495n 0.0v 2009.505n 0.0v 2019.495n 0.0v 2019.505n 0.0v 2029.495n 0.0v 2029.505n 0.0v 2039.495n 0.0v 2039.505n 0.0v 2049.495n 0.0v 2049.505n 0.0v )
* (time, data): [(0, 0), (10, 0), (20, 0), (30, 0), (40, 0), (50, 0), (60, 0), (70, 0), (80, 0), (90, 0), (100, 0), (110, 0), (120, 0), (130, 0), (140, 0), (150, 1), (160, 1), (170, 1), (180, 1), (190, 1), (200, 1), (210, 1), (220, 1), (230, 1), (240, 1), (250, 0), (260, 1), (270, 1), (280, 1), (290, 0), (300, 1), (310, 1), (320, 1), (330, 1), (340, 1), (350, 1), (360, 1), (370, 1), (380, 1), (390, 0), (400, 0), (410, 0), (420, 0), (430, 0), (440, 0), (450, 0), (460, 0), (470, 0), (480, 0), (490, 0), (500, 0), (510, 0), (520, 0), (530, 0), (540, 0), (550, 0), (560, 0), (570, 0), (580, 1), (590, 1), (600, 1), (610, 0), (620, 0), (630, 0), (640, 0), (650, 0), (660, 0), (670, 0), (680, 0), (690, 0), (700, 1), (710, 1), (720, 1), (730, 0), (740, 0), (750, 0), (760, 0), (770, 0), (780, 0), (790, 0), (800, 0), (810, 1), (820, 0), (830, 0), (840, 1), (850, 1), (860, 1), (870, 1), (880, 1), (890, 1), (900, 1), (910, 1), (920, 1), (930, 1), (940, 1), (950, 1), (960, 1), (970, 1), (980, 1), (990, 1), (1000, 1), (1010, 1), (1020, 1), (1030, 1), (1040, 1), (1050, 1), (1060, 1), (1070, 1), (1080, 0), (1090, 0), (1100, 0), (1110, 0), (1120, 0), (1130, 0), (1140, 0), (1150, 0), (1160, 0), (1170, 0), (1180, 0), (1190, 0), (1200, 1), (1210, 1), (1220, 1), (1230, 1), (1240, 1), (1250, 1), (1260, 1), (1270, 1), (1280, 1), (1290, 1), (1300, 1), (1310, 1), (1320, 1), (1330, 1), (1340, 1), (1350, 1), (1360, 1), (1370, 1), (1380, 1), (1390, 1), (1400, 1), (1410, 1), (1420, 1), (1430, 0), (1440, 0), (1450, 0), (1460, 0), (1470, 0), (1480, 0), (1490, 0), (1500, 1), (1510, 1), (1520, 1), (1530, 1), (1540, 1), (1550, 1), (1560, 0), (1570, 0), (1580, 0), (1590, 0), (1600, 1), (1610, 1), (1620, 1), (1630, 1), (1640, 1), (1650, 1), (1660, 1), (1670, 1), (1680, 1), (1690, 1), (1700, 0), (1710, 0), (1720, 0), (1730, 1), (1740, 1), (1750, 1), (1760, 0), (1770, 0), (1780, 0), (1790, 0), (1800, 0), (1810, 0), (1820, 0), (1830, 0), (1840, 0), (1850, 0), (1860, 0), (1870, 1), (1880, 1), (1890, 1), (1900, 1), (1910, 1), (1920, 1), (1930, 1), (1940, 1), (1950, 1), (1960, 1), (1970, 1), (1980, 1), (1990, 0), (2000, 0), (2010, 0), (2020, 0), (2030, 0), (2040, 0), (2050, 0)]
Va1_0  a1_0  0 PWL (0n 0.0v 9.495n 0.0v 9.505n 0.0v 19.495n 0.0v 19.505n 0.0v 29.495n 0.0v 29.505n 0.0v 39.495n 0.0v 39.505n 0.0v 49.495n 0.0v 49.505n 0.0v 59.495n 0.0v 59.505n 0.0v 69.495n 0.0v 69.505n 0.0v 79.495n 0.0v 79.505n 0.0v 89.495n 0.0v 89.505n 0.0v 99.495n 0.0v 99.505n 0.0v 109.495n 0.0v 109.505n 0.0v 119.495n 0.0v 119.505n 0.0v 129.495n 0.0v 129.505n 0.0v 139.495n 0.0v 139.505n 0.0v 149.495n 0.0v 149.505n 1.7v 159.495n 1.7v 159.505n 1.7v 169.495n 1.7v 169.505n 1.7v 179.495n 1.7v 179.505n 1.7v 189.495n 1.7v 189.505n 1.7v 199.495n 1.7v 199.505n 1.7v 209.495n 1.7v 209.505n 1.7v 219.495n 1.7v 219.505n 1.7v 229.495n 1.7v 229.505n 1.7v 239.495n 1.7v 239.505n 1.7v 249.495n 1.7v 249.505n 0.0v 259.495n 0.0v 259.505n 1.7v 269.495n 1.7v 269.505n 1.7v 279.495n 1.7v 279.505n 1.7v 289.495n 1.7v 289.505n 0.0v 299.495n 0.0v 299.505n 1.7v 309.495n 1.7v 309.505n 1.7v 319.495n 1.7v 319.505n 1.7v 329.495n 1.7v 329.505n 1.7v 339.495n 1.7v 339.505n 1.7v 349.495n 1.7v 349.505n 1.7v 359.495n 1.7v 359.505n 1.7v 369.495n 1.7v 369.505n 1.7v 379.495n 1.7v 379.505n 1.7v 389.495n 1.7v 389.505n 0.0v 399.495n 0.0v 399.505n 0.0v 409.495n 0.0v 409.505n 0.0v 419.495n 0.0v 419.505n 0.0v 429.495n 0.0v 429.505n 0.0v 439.495n 0.0v 439.505n 0.0v 449.495n 0.0v 449.505n 0.0v 459.495n 0.0v 459.505n 0.0v 469.495n 0.0v 469.505n 0.0v 479.495n 0.0v 479.505n 0.0v 489.495n 0.0v 489.505n 0.0v 499.495n 0.0v 499.505n 0.0v 509.495n 0.0v 509.505n 0.0v 519.495n 0.0v 519.505n 0.0v 529.495n 0.0v 529.505n 0.0v 539.495n 0.0v 539.505n 0.0v 549.495n 0.0v 549.505n 0.0v 559.495n 0.0v 559.505n 0.0v 569.495n 0.0v 569.505n 0.0v 579.495n 0.0v 579.505n 1.7v 589.495n 1.7v 589.505n 1.7v 599.495n 1.7v 599.505n 1.7v 609.495n 1.7v 609.505n 0.0v 619.495n 0.0v 619.505n 0.0v 629.495n 0.0v 629.505n 0.0v 639.495n 0.0v 639.505n 0.0v 649.495n 0.0v 649.505n 0.0v 659.495n 0.0v 659.505n 0.0v 669.495n 0.0v 669.505n 0.0v 679.495n 0.0v 679.505n 0.0v 689.495n 0.0v 689.505n 0.0v 699.495n 0.0v 699.505n 1.7v 709.495n 1.7v 709.505n 1.7v 719.495n 1.7v 719.505n 1.7v 729.495n 1.7v 729.505n 0.0v 739.495n 0.0v 739.505n 0.0v 749.495n 0.0v 749.505n 0.0v 759.495n 0.0v 759.505n 0.0v 769.495n 0.0v 769.505n 0.0v 779.495n 0.0v 779.505n 0.0v 789.495n 0.0v 789.505n 0.0v 799.495n 0.0v 799.505n 0.0v 809.495n 0.0v 809.505n 1.7v 819.495n 1.7v 819.505n 0.0v 829.495n 0.0v 829.505n 0.0v 839.495n 0.0v 839.505n 1.7v 849.495n 1.7v 849.505n 1.7v 859.495n 1.7v 859.505n 1.7v 869.495n 1.7v 869.505n 1.7v 879.495n 1.7v 879.505n 1.7v 889.495n 1.7v 889.505n 1.7v 899.495n 1.7v 899.505n 1.7v 909.495n 1.7v 909.505n 1.7v 919.495n 1.7v 919.505n 1.7v 929.495n 1.7v 929.505n 1.7v 939.495n 1.7v 939.505n 1.7v 949.495n 1.7v 949.505n 1.7v 959.495n 1.7v 959.505n 1.7v 969.495n 1.7v 969.505n 1.7v 979.495n 1.7v 979.505n 1.7v 989.495n 1.7v 989.505n 1.7v 999.495n 1.7v 999.505n 1.7v 1009.495n 1.7v 1009.505n 1.7v 1019.495n 1.7v 1019.505n 1.7v 1029.495n 1.7v 1029.505n 1.7v 1039.495n 1.7v 1039.505n 1.7v 1049.495n 1.7v 1049.505n 1.7v 1059.495n 1.7v 1059.505n 1.7v 1069.495n 1.7v 1069.505n 1.7v 1079.495n 1.7v 1079.505n 0.0v 1089.495n 0.0v 1089.505n 0.0v 1099.495n 0.0v 1099.505n 0.0v 1109.495n 0.0v 1109.505n 0.0v 1119.495n 0.0v 1119.505n 0.0v 1129.495n 0.0v 1129.505n 0.0v 1139.495n 0.0v 1139.505n 0.0v 1149.495n 0.0v 1149.505n 0.0v 1159.495n 0.0v 1159.505n 0.0v 1169.495n 0.0v 1169.505n 0.0v 1179.495n 0.0v 1179.505n 0.0v 1189.495n 0.0v 1189.505n 0.0v 1199.495n 0.0v 1199.505n 1.7v 1209.495n 1.7v 1209.505n 1.7v 1219.495n 1.7v 1219.505n 1.7v 1229.495n 1.7v 1229.505n 1.7v 1239.495n 1.7v 1239.505n 1.7v 1249.495n 1.7v 1249.505n 1.7v 1259.495n 1.7v 1259.505n 1.7v 1269.495n 1.7v 1269.505n 1.7v 1279.495n 1.7v 1279.505n 1.7v 1289.495n 1.7v 1289.505n 1.7v 1299.495n 1.7v 1299.505n 1.7v 1309.495n 1.7v 1309.505n 1.7v 1319.495n 1.7v 1319.505n 1.7v 1329.495n 1.7v 1329.505n 1.7v 1339.495n 1.7v 1339.505n 1.7v 1349.495n 1.7v 1349.505n 1.7v 1359.495n 1.7v 1359.505n 1.7v 1369.495n 1.7v 1369.505n 1.7v 1379.495n 1.7v 1379.505n 1.7v 1389.495n 1.7v 1389.505n 1.7v 1399.495n 1.7v 1399.505n 1.7v 1409.495n 1.7v 1409.505n 1.7v 1419.495n 1.7v 1419.505n 1.7v 1429.495n 1.7v 1429.505n 0.0v 1439.495n 0.0v 1439.505n 0.0v 1449.495n 0.0v 1449.505n 0.0v 1459.495n 0.0v 1459.505n 0.0v 1469.495n 0.0v 1469.505n 0.0v 1479.495n 0.0v 1479.505n 0.0v 1489.495n 0.0v 1489.505n 0.0v 1499.495n 0.0v 1499.505n 1.7v 1509.495n 1.7v 1509.505n 1.7v 1519.495n 1.7v 1519.505n 1.7v 1529.495n 1.7v 1529.505n 1.7v 1539.495n 1.7v 1539.505n 1.7v 1549.495n 1.7v 1549.505n 1.7v 1559.495n 1.7v 1559.505n 0.0v 1569.495n 0.0v 1569.505n 0.0v 1579.495n 0.0v 1579.505n 0.0v 1589.495n 0.0v 1589.505n 0.0v 1599.495n 0.0v 1599.505n 1.7v 1609.495n 1.7v 1609.505n 1.7v 1619.495n 1.7v 1619.505n 1.7v 1629.495n 1.7v 1629.505n 1.7v 1639.495n 1.7v 1639.505n 1.7v 1649.495n 1.7v 1649.505n 1.7v 1659.495n 1.7v 1659.505n 1.7v 1669.495n 1.7v 1669.505n 1.7v 1679.495n 1.7v 1679.505n 1.7v 1689.495n 1.7v 1689.505n 1.7v 1699.495n 1.7v 1699.505n 0.0v 1709.495n 0.0v 1709.505n 0.0v 1719.495n 0.0v 1719.505n 0.0v 1729.495n 0.0v 1729.505n 1.7v 1739.495n 1.7v 1739.505n 1.7v 1749.495n 1.7v 1749.505n 1.7v 1759.495n 1.7v 1759.505n 0.0v 1769.495n 0.0v 1769.505n 0.0v 1779.495n 0.0v 1779.505n 0.0v 1789.495n 0.0v 1789.505n 0.0v 1799.495n 0.0v 1799.505n 0.0v 1809.495n 0.0v 1809.505n 0.0v 1819.495n 0.0v 1819.505n 0.0v 1829.495n 0.0v 1829.505n 0.0v 1839.495n 0.0v 1839.505n 0.0v 1849.495n 0.0v 1849.505n 0.0v 1859.495n 0.0v 1859.505n 0.0v 1869.495n 0.0v 1869.505n 1.7v 1879.495n 1.7v 1879.505n 1.7v 1889.495n 1.7v 1889.505n 1.7v 1899.495n 1.7v 1899.505n 1.7v 1909.495n 1.7v 1909.505n 1.7v 1919.495n 1.7v 1919.505n 1.7v 1929.495n 1.7v 1929.505n 1.7v 1939.495n 1.7v 1939.505n 1.7v 1949.495n 1.7v 1949.505n 1.7v 1959.495n 1.7v 1959.505n 1.7v 1969.495n 1.7v 1969.505n 1.7v 1979.495n 1.7v 1979.505n 1.7v 1989.495n 1.7v 1989.505n 0.0v 1999.495n 0.0v 1999.505n 0.0v 2009.495n 0.0v 2009.505n 0.0v 2019.495n 0.0v 2019.505n 0.0v 2029.495n 0.0v 2029.505n 0.0v 2039.495n 0.0v 2039.505n 0.0v 2049.495n 0.0v 2049.505n 0.0v )
* (time, data): [(0, 0), (10, 0), (20, 0), (30, 0), (40, 0), (50, 0), (60, 0), (70, 0), (80, 0), (90, 0), (100, 0), (110, 0), (120, 0), (130, 0), (140, 0), (150, 1), (160, 1), (170, 1), (180, 1), (190, 1), (200, 1), (210, 1), (220, 1), (230, 1), (240, 1), (250, 0), (260, 1), (270, 1), (280, 1), (290, 0), (300, 1), (310, 1), (320, 1), (330, 1), (340, 1), (350, 1), (360, 1), (370, 1), (380, 1), (390, 0), (400, 0), (410, 0), (420, 0), (430, 0), (440, 0), (450, 0), (460, 0), (470, 0), (480, 0), (490, 0), (500, 0), (510, 0), (520, 0), (530, 0), (540, 0), (550, 0), (560, 0), (570, 0), (580, 1), (590, 1), (600, 1), (610, 0), (620, 0), (630, 0), (640, 0), (650, 0), (660, 0), (670, 0), (680, 0), (690, 0), (700, 1), (710, 1), (720, 1), (730, 0), (740, 0), (750, 0), (760, 0), (770, 0), (780, 0), (790, 0), (800, 0), (810, 1), (820, 0), (830, 0), (840, 1), (850, 1), (860, 1), (870, 1), (880, 1), (890, 1), (900, 1), (910, 1), (920, 1), (930, 1), (940, 1), (950, 1), (960, 1), (970, 1), (980, 1), (990, 1), (1000, 1), (1010, 1), (1020, 1), (1030, 1), (1040, 1), (1050, 1), (1060, 1), (1070, 1), (1080, 0), (1090, 0), (1100, 0), (1110, 0), (1120, 0), (1130, 0), (1140, 0), (1150, 0), (1160, 0), (1170, 0), (1180, 0), (1190, 0), (1200, 1), (1210, 1), (1220, 1), (1230, 1), (1240, 1), (1250, 1), (1260, 1), (1270, 1), (1280, 1), (1290, 1), (1300, 1), (1310, 1), (1320, 1), (1330, 1), (1340, 1), (1350, 1), (1360, 1), (1370, 1), (1380, 1), (1390, 1), (1400, 1), (1410, 1), (1420, 1), (1430, 0), (1440, 0), (1450, 0), (1460, 0), (1470, 0), (1480, 0), (1490, 0), (1500, 1), (1510, 1), (1520, 1), (1530, 1), (1540, 1), (1550, 1), (1560, 0), (1570, 0), (1580, 0), (1590, 0), (1600, 1), (1610, 1), (1620, 1), (1630, 1), (1640, 1), (1650, 1), (1660, 1), (1670, 1), (1680, 1), (1690, 1), (1700, 0), (1710, 0), (1720, 0), (1730, 1), (1740, 1), (1750, 1), (1760, 0), (1770, 0), (1780, 0), (1790, 0), (1800, 0), (1810, 0), (1820, 0), (1830, 0), (1840, 0), (1850, 0), (1860, 0), (1870, 1), (1880, 1), (1890, 1), (1900, 1), (1910, 1), (1920, 1), (1930, 1), (1940, 1), (1950, 1), (1960, 1), (1970, 1), (1980, 1), (1990, 0), (2000, 0), (2010, 0), (2020, 0), (2030, 0), (2040, 0), (2050, 0)]
Va1_1  a1_1  0 PWL (0n 0.0v 9.495n 0.0v 9.505n 0.0v 19.495n 0.0v 19.505n 0.0v 29.495n 0.0v 29.505n 0.0v 39.495n 0.0v 39.505n 0.0v 49.495n 0.0v 49.505n 0.0v 59.495n 0.0v 59.505n 0.0v 69.495n 0.0v 69.505n 0.0v 79.495n 0.0v 79.505n 0.0v 89.495n 0.0v 89.505n 0.0v 99.495n 0.0v 99.505n 0.0v 109.495n 0.0v 109.505n 0.0v 119.495n 0.0v 119.505n 0.0v 129.495n 0.0v 129.505n 0.0v 139.495n 0.0v 139.505n 0.0v 149.495n 0.0v 149.505n 1.7v 159.495n 1.7v 159.505n 1.7v 169.495n 1.7v 169.505n 1.7v 179.495n 1.7v 179.505n 1.7v 189.495n 1.7v 189.505n 1.7v 199.495n 1.7v 199.505n 1.7v 209.495n 1.7v 209.505n 1.7v 219.495n 1.7v 219.505n 1.7v 229.495n 1.7v 229.505n 1.7v 239.495n 1.7v 239.505n 1.7v 249.495n 1.7v 249.505n 0.0v 259.495n 0.0v 259.505n 1.7v 269.495n 1.7v 269.505n 1.7v 279.495n 1.7v 279.505n 1.7v 289.495n 1.7v 289.505n 0.0v 299.495n 0.0v 299.505n 1.7v 309.495n 1.7v 309.505n 1.7v 319.495n 1.7v 319.505n 1.7v 329.495n 1.7v 329.505n 1.7v 339.495n 1.7v 339.505n 1.7v 349.495n 1.7v 349.505n 1.7v 359.495n 1.7v 359.505n 1.7v 369.495n 1.7v 369.505n 1.7v 379.495n 1.7v 379.505n 1.7v 389.495n 1.7v 389.505n 0.0v 399.495n 0.0v 399.505n 0.0v 409.495n 0.0v 409.505n 0.0v 419.495n 0.0v 419.505n 0.0v 429.495n 0.0v 429.505n 0.0v 439.495n 0.0v 439.505n 0.0v 449.495n 0.0v 449.505n 0.0v 459.495n 0.0v 459.505n 0.0v 469.495n 0.0v 469.505n 0.0v 479.495n 0.0v 479.505n 0.0v 489.495n 0.0v 489.505n 0.0v 499.495n 0.0v 499.505n 0.0v 509.495n 0.0v 509.505n 0.0v 519.495n 0.0v 519.505n 0.0v 529.495n 0.0v 529.505n 0.0v 539.495n 0.0v 539.505n 0.0v 549.495n 0.0v 549.505n 0.0v 559.495n 0.0v 559.505n 0.0v 569.495n 0.0v 569.505n 0.0v 579.495n 0.0v 579.505n 1.7v 589.495n 1.7v 589.505n 1.7v 599.495n 1.7v 599.505n 1.7v 609.495n 1.7v 609.505n 0.0v 619.495n 0.0v 619.505n 0.0v 629.495n 0.0v 629.505n 0.0v 639.495n 0.0v 639.505n 0.0v 649.495n 0.0v 649.505n 0.0v 659.495n 0.0v 659.505n 0.0v 669.495n 0.0v 669.505n 0.0v 679.495n 0.0v 679.505n 0.0v 689.495n 0.0v 689.505n 0.0v 699.495n 0.0v 699.505n 1.7v 709.495n 1.7v 709.505n 1.7v 719.495n 1.7v 719.505n 1.7v 729.495n 1.7v 729.505n 0.0v 739.495n 0.0v 739.505n 0.0v 749.495n 0.0v 749.505n 0.0v 759.495n 0.0v 759.505n 0.0v 769.495n 0.0v 769.505n 0.0v 779.495n 0.0v 779.505n 0.0v 789.495n 0.0v 789.505n 0.0v 799.495n 0.0v 799.505n 0.0v 809.495n 0.0v 809.505n 1.7v 819.495n 1.7v 819.505n 0.0v 829.495n 0.0v 829.505n 0.0v 839.495n 0.0v 839.505n 1.7v 849.495n 1.7v 849.505n 1.7v 859.495n 1.7v 859.505n 1.7v 869.495n 1.7v 869.505n 1.7v 879.495n 1.7v 879.505n 1.7v 889.495n 1.7v 889.505n 1.7v 899.495n 1.7v 899.505n 1.7v 909.495n 1.7v 909.505n 1.7v 919.495n 1.7v 919.505n 1.7v 929.495n 1.7v 929.505n 1.7v 939.495n 1.7v 939.505n 1.7v 949.495n 1.7v 949.505n 1.7v 959.495n 1.7v 959.505n 1.7v 969.495n 1.7v 969.505n 1.7v 979.495n 1.7v 979.505n 1.7v 989.495n 1.7v 989.505n 1.7v 999.495n 1.7v 999.505n 1.7v 1009.495n 1.7v 1009.505n 1.7v 1019.495n 1.7v 1019.505n 1.7v 1029.495n 1.7v 1029.505n 1.7v 1039.495n 1.7v 1039.505n 1.7v 1049.495n 1.7v 1049.505n 1.7v 1059.495n 1.7v 1059.505n 1.7v 1069.495n 1.7v 1069.505n 1.7v 1079.495n 1.7v 1079.505n 0.0v 1089.495n 0.0v 1089.505n 0.0v 1099.495n 0.0v 1099.505n 0.0v 1109.495n 0.0v 1109.505n 0.0v 1119.495n 0.0v 1119.505n 0.0v 1129.495n 0.0v 1129.505n 0.0v 1139.495n 0.0v 1139.505n 0.0v 1149.495n 0.0v 1149.505n 0.0v 1159.495n 0.0v 1159.505n 0.0v 1169.495n 0.0v 1169.505n 0.0v 1179.495n 0.0v 1179.505n 0.0v 1189.495n 0.0v 1189.505n 0.0v 1199.495n 0.0v 1199.505n 1.7v 1209.495n 1.7v 1209.505n 1.7v 1219.495n 1.7v 1219.505n 1.7v 1229.495n 1.7v 1229.505n 1.7v 1239.495n 1.7v 1239.505n 1.7v 1249.495n 1.7v 1249.505n 1.7v 1259.495n 1.7v 1259.505n 1.7v 1269.495n 1.7v 1269.505n 1.7v 1279.495n 1.7v 1279.505n 1.7v 1289.495n 1.7v 1289.505n 1.7v 1299.495n 1.7v 1299.505n 1.7v 1309.495n 1.7v 1309.505n 1.7v 1319.495n 1.7v 1319.505n 1.7v 1329.495n 1.7v 1329.505n 1.7v 1339.495n 1.7v 1339.505n 1.7v 1349.495n 1.7v 1349.505n 1.7v 1359.495n 1.7v 1359.505n 1.7v 1369.495n 1.7v 1369.505n 1.7v 1379.495n 1.7v 1379.505n 1.7v 1389.495n 1.7v 1389.505n 1.7v 1399.495n 1.7v 1399.505n 1.7v 1409.495n 1.7v 1409.505n 1.7v 1419.495n 1.7v 1419.505n 1.7v 1429.495n 1.7v 1429.505n 0.0v 1439.495n 0.0v 1439.505n 0.0v 1449.495n 0.0v 1449.505n 0.0v 1459.495n 0.0v 1459.505n 0.0v 1469.495n 0.0v 1469.505n 0.0v 1479.495n 0.0v 1479.505n 0.0v 1489.495n 0.0v 1489.505n 0.0v 1499.495n 0.0v 1499.505n 1.7v 1509.495n 1.7v 1509.505n 1.7v 1519.495n 1.7v 1519.505n 1.7v 1529.495n 1.7v 1529.505n 1.7v 1539.495n 1.7v 1539.505n 1.7v 1549.495n 1.7v 1549.505n 1.7v 1559.495n 1.7v 1559.505n 0.0v 1569.495n 0.0v 1569.505n 0.0v 1579.495n 0.0v 1579.505n 0.0v 1589.495n 0.0v 1589.505n 0.0v 1599.495n 0.0v 1599.505n 1.7v 1609.495n 1.7v 1609.505n 1.7v 1619.495n 1.7v 1619.505n 1.7v 1629.495n 1.7v 1629.505n 1.7v 1639.495n 1.7v 1639.505n 1.7v 1649.495n 1.7v 1649.505n 1.7v 1659.495n 1.7v 1659.505n 1.7v 1669.495n 1.7v 1669.505n 1.7v 1679.495n 1.7v 1679.505n 1.7v 1689.495n 1.7v 1689.505n 1.7v 1699.495n 1.7v 1699.505n 0.0v 1709.495n 0.0v 1709.505n 0.0v 1719.495n 0.0v 1719.505n 0.0v 1729.495n 0.0v 1729.505n 1.7v 1739.495n 1.7v 1739.505n 1.7v 1749.495n 1.7v 1749.505n 1.7v 1759.495n 1.7v 1759.505n 0.0v 1769.495n 0.0v 1769.505n 0.0v 1779.495n 0.0v 1779.505n 0.0v 1789.495n 0.0v 1789.505n 0.0v 1799.495n 0.0v 1799.505n 0.0v 1809.495n 0.0v 1809.505n 0.0v 1819.495n 0.0v 1819.505n 0.0v 1829.495n 0.0v 1829.505n 0.0v 1839.495n 0.0v 1839.505n 0.0v 1849.495n 0.0v 1849.505n 0.0v 1859.495n 0.0v 1859.505n 0.0v 1869.495n 0.0v 1869.505n 1.7v 1879.495n 1.7v 1879.505n 1.7v 1889.495n 1.7v 1889.505n 1.7v 1899.495n 1.7v 1899.505n 1.7v 1909.495n 1.7v 1909.505n 1.7v 1919.495n 1.7v 1919.505n 1.7v 1929.495n 1.7v 1929.505n 1.7v 1939.495n 1.7v 1939.505n 1.7v 1949.495n 1.7v 1949.505n 1.7v 1959.495n 1.7v 1959.505n 1.7v 1969.495n 1.7v 1969.505n 1.7v 1979.495n 1.7v 1979.505n 1.7v 1989.495n 1.7v 1989.505n 0.0v 1999.495n 0.0v 1999.505n 0.0v 2009.495n 0.0v 2009.505n 0.0v 2019.495n 0.0v 2019.505n 0.0v 2029.495n 0.0v 2029.505n 0.0v 2039.495n 0.0v 2039.505n 0.0v 2049.495n 0.0v 2049.505n 0.0v )
* (time, data): [(0, 0), (10, 0), (20, 0), (30, 0), (40, 0), (50, 0), (60, 0), (70, 0), (80, 0), (90, 0), (100, 0), (110, 0), (120, 0), (130, 0), (140, 0), (150, 1), (160, 1), (170, 1), (180, 1), (190, 1), (200, 1), (210, 1), (220, 1), (230, 1), (240, 1), (250, 0), (260, 1), (270, 1), (280, 1), (290, 0), (300, 1), (310, 1), (320, 1), (330, 1), (340, 1), (350, 1), (360, 1), (370, 1), (380, 1), (390, 0), (400, 0), (410, 0), (420, 0), (430, 0), (440, 0), (450, 0), (460, 0), (470, 0), (480, 0), (490, 0), (500, 0), (510, 0), (520, 0), (530, 0), (540, 0), (550, 0), (560, 0), (570, 0), (580, 1), (590, 1), (600, 1), (610, 0), (620, 0), (630, 0), (640, 0), (650, 0), (660, 0), (670, 0), (680, 0), (690, 0), (700, 1), (710, 1), (720, 1), (730, 0), (740, 0), (750, 0), (760, 0), (770, 0), (780, 0), (790, 0), (800, 0), (810, 1), (820, 0), (830, 0), (840, 1), (850, 1), (860, 1), (870, 1), (880, 1), (890, 1), (900, 1), (910, 1), (920, 1), (930, 1), (940, 1), (950, 1), (960, 1), (970, 1), (980, 1), (990, 1), (1000, 1), (1010, 1), (1020, 1), (1030, 1), (1040, 1), (1050, 1), (1060, 1), (1070, 1), (1080, 0), (1090, 0), (1100, 0), (1110, 0), (1120, 0), (1130, 0), (1140, 0), (1150, 0), (1160, 0), (1170, 0), (1180, 0), (1190, 0), (1200, 1), (1210, 1), (1220, 1), (1230, 1), (1240, 1), (1250, 1), (1260, 1), (1270, 1), (1280, 1), (1290, 1), (1300, 1), (1310, 1), (1320, 1), (1330, 1), (1340, 1), (1350, 1), (1360, 1), (1370, 1), (1380, 1), (1390, 1), (1400, 1), (1410, 1), (1420, 1), (1430, 0), (1440, 0), (1450, 0), (1460, 0), (1470, 0), (1480, 0), (1490, 0), (1500, 1), (1510, 1), (1520, 1), (1530, 1), (1540, 1), (1550, 1), (1560, 0), (1570, 0), (1580, 0), (1590, 0), (1600, 1), (1610, 1), (1620, 1), (1630, 1), (1640, 1), (1650, 1), (1660, 1), (1670, 1), (1680, 1), (1690, 1), (1700, 0), (1710, 0), (1720, 0), (1730, 1), (1740, 1), (1750, 1), (1760, 0), (1770, 0), (1780, 0), (1790, 0), (1800, 0), (1810, 0), (1820, 0), (1830, 0), (1840, 0), (1850, 0), (1860, 0), (1870, 1), (1880, 1), (1890, 1), (1900, 1), (1910, 1), (1920, 1), (1930, 1), (1940, 1), (1950, 1), (1960, 1), (1970, 1), (1980, 1), (1990, 0), (2000, 0), (2010, 0), (2020, 0), (2030, 0), (2040, 0), (2050, 0)]
Va1_2  a1_2  0 PWL (0n 0.0v 9.495n 0.0v 9.505n 0.0v 19.495n 0.0v 19.505n 0.0v 29.495n 0.0v 29.505n 0.0v 39.495n 0.0v 39.505n 0.0v 49.495n 0.0v 49.505n 0.0v 59.495n 0.0v 59.505n 0.0v 69.495n 0.0v 69.505n 0.0v 79.495n 0.0v 79.505n 0.0v 89.495n 0.0v 89.505n 0.0v 99.495n 0.0v 99.505n 0.0v 109.495n 0.0v 109.505n 0.0v 119.495n 0.0v 119.505n 0.0v 129.495n 0.0v 129.505n 0.0v 139.495n 0.0v 139.505n 0.0v 149.495n 0.0v 149.505n 1.7v 159.495n 1.7v 159.505n 1.7v 169.495n 1.7v 169.505n 1.7v 179.495n 1.7v 179.505n 1.7v 189.495n 1.7v 189.505n 1.7v 199.495n 1.7v 199.505n 1.7v 209.495n 1.7v 209.505n 1.7v 219.495n 1.7v 219.505n 1.7v 229.495n 1.7v 229.505n 1.7v 239.495n 1.7v 239.505n 1.7v 249.495n 1.7v 249.505n 0.0v 259.495n 0.0v 259.505n 1.7v 269.495n 1.7v 269.505n 1.7v 279.495n 1.7v 279.505n 1.7v 289.495n 1.7v 289.505n 0.0v 299.495n 0.0v 299.505n 1.7v 309.495n 1.7v 309.505n 1.7v 319.495n 1.7v 319.505n 1.7v 329.495n 1.7v 329.505n 1.7v 339.495n 1.7v 339.505n 1.7v 349.495n 1.7v 349.505n 1.7v 359.495n 1.7v 359.505n 1.7v 369.495n 1.7v 369.505n 1.7v 379.495n 1.7v 379.505n 1.7v 389.495n 1.7v 389.505n 0.0v 399.495n 0.0v 399.505n 0.0v 409.495n 0.0v 409.505n 0.0v 419.495n 0.0v 419.505n 0.0v 429.495n 0.0v 429.505n 0.0v 439.495n 0.0v 439.505n 0.0v 449.495n 0.0v 449.505n 0.0v 459.495n 0.0v 459.505n 0.0v 469.495n 0.0v 469.505n 0.0v 479.495n 0.0v 479.505n 0.0v 489.495n 0.0v 489.505n 0.0v 499.495n 0.0v 499.505n 0.0v 509.495n 0.0v 509.505n 0.0v 519.495n 0.0v 519.505n 0.0v 529.495n 0.0v 529.505n 0.0v 539.495n 0.0v 539.505n 0.0v 549.495n 0.0v 549.505n 0.0v 559.495n 0.0v 559.505n 0.0v 569.495n 0.0v 569.505n 0.0v 579.495n 0.0v 579.505n 1.7v 589.495n 1.7v 589.505n 1.7v 599.495n 1.7v 599.505n 1.7v 609.495n 1.7v 609.505n 0.0v 619.495n 0.0v 619.505n 0.0v 629.495n 0.0v 629.505n 0.0v 639.495n 0.0v 639.505n 0.0v 649.495n 0.0v 649.505n 0.0v 659.495n 0.0v 659.505n 0.0v 669.495n 0.0v 669.505n 0.0v 679.495n 0.0v 679.505n 0.0v 689.495n 0.0v 689.505n 0.0v 699.495n 0.0v 699.505n 1.7v 709.495n 1.7v 709.505n 1.7v 719.495n 1.7v 719.505n 1.7v 729.495n 1.7v 729.505n 0.0v 739.495n 0.0v 739.505n 0.0v 749.495n 0.0v 749.505n 0.0v 759.495n 0.0v 759.505n 0.0v 769.495n 0.0v 769.505n 0.0v 779.495n 0.0v 779.505n 0.0v 789.495n 0.0v 789.505n 0.0v 799.495n 0.0v 799.505n 0.0v 809.495n 0.0v 809.505n 1.7v 819.495n 1.7v 819.505n 0.0v 829.495n 0.0v 829.505n 0.0v 839.495n 0.0v 839.505n 1.7v 849.495n 1.7v 849.505n 1.7v 859.495n 1.7v 859.505n 1.7v 869.495n 1.7v 869.505n 1.7v 879.495n 1.7v 879.505n 1.7v 889.495n 1.7v 889.505n 1.7v 899.495n 1.7v 899.505n 1.7v 909.495n 1.7v 909.505n 1.7v 919.495n 1.7v 919.505n 1.7v 929.495n 1.7v 929.505n 1.7v 939.495n 1.7v 939.505n 1.7v 949.495n 1.7v 949.505n 1.7v 959.495n 1.7v 959.505n 1.7v 969.495n 1.7v 969.505n 1.7v 979.495n 1.7v 979.505n 1.7v 989.495n 1.7v 989.505n 1.7v 999.495n 1.7v 999.505n 1.7v 1009.495n 1.7v 1009.505n 1.7v 1019.495n 1.7v 1019.505n 1.7v 1029.495n 1.7v 1029.505n 1.7v 1039.495n 1.7v 1039.505n 1.7v 1049.495n 1.7v 1049.505n 1.7v 1059.495n 1.7v 1059.505n 1.7v 1069.495n 1.7v 1069.505n 1.7v 1079.495n 1.7v 1079.505n 0.0v 1089.495n 0.0v 1089.505n 0.0v 1099.495n 0.0v 1099.505n 0.0v 1109.495n 0.0v 1109.505n 0.0v 1119.495n 0.0v 1119.505n 0.0v 1129.495n 0.0v 1129.505n 0.0v 1139.495n 0.0v 1139.505n 0.0v 1149.495n 0.0v 1149.505n 0.0v 1159.495n 0.0v 1159.505n 0.0v 1169.495n 0.0v 1169.505n 0.0v 1179.495n 0.0v 1179.505n 0.0v 1189.495n 0.0v 1189.505n 0.0v 1199.495n 0.0v 1199.505n 1.7v 1209.495n 1.7v 1209.505n 1.7v 1219.495n 1.7v 1219.505n 1.7v 1229.495n 1.7v 1229.505n 1.7v 1239.495n 1.7v 1239.505n 1.7v 1249.495n 1.7v 1249.505n 1.7v 1259.495n 1.7v 1259.505n 1.7v 1269.495n 1.7v 1269.505n 1.7v 1279.495n 1.7v 1279.505n 1.7v 1289.495n 1.7v 1289.505n 1.7v 1299.495n 1.7v 1299.505n 1.7v 1309.495n 1.7v 1309.505n 1.7v 1319.495n 1.7v 1319.505n 1.7v 1329.495n 1.7v 1329.505n 1.7v 1339.495n 1.7v 1339.505n 1.7v 1349.495n 1.7v 1349.505n 1.7v 1359.495n 1.7v 1359.505n 1.7v 1369.495n 1.7v 1369.505n 1.7v 1379.495n 1.7v 1379.505n 1.7v 1389.495n 1.7v 1389.505n 1.7v 1399.495n 1.7v 1399.505n 1.7v 1409.495n 1.7v 1409.505n 1.7v 1419.495n 1.7v 1419.505n 1.7v 1429.495n 1.7v 1429.505n 0.0v 1439.495n 0.0v 1439.505n 0.0v 1449.495n 0.0v 1449.505n 0.0v 1459.495n 0.0v 1459.505n 0.0v 1469.495n 0.0v 1469.505n 0.0v 1479.495n 0.0v 1479.505n 0.0v 1489.495n 0.0v 1489.505n 0.0v 1499.495n 0.0v 1499.505n 1.7v 1509.495n 1.7v 1509.505n 1.7v 1519.495n 1.7v 1519.505n 1.7v 1529.495n 1.7v 1529.505n 1.7v 1539.495n 1.7v 1539.505n 1.7v 1549.495n 1.7v 1549.505n 1.7v 1559.495n 1.7v 1559.505n 0.0v 1569.495n 0.0v 1569.505n 0.0v 1579.495n 0.0v 1579.505n 0.0v 1589.495n 0.0v 1589.505n 0.0v 1599.495n 0.0v 1599.505n 1.7v 1609.495n 1.7v 1609.505n 1.7v 1619.495n 1.7v 1619.505n 1.7v 1629.495n 1.7v 1629.505n 1.7v 1639.495n 1.7v 1639.505n 1.7v 1649.495n 1.7v 1649.505n 1.7v 1659.495n 1.7v 1659.505n 1.7v 1669.495n 1.7v 1669.505n 1.7v 1679.495n 1.7v 1679.505n 1.7v 1689.495n 1.7v 1689.505n 1.7v 1699.495n 1.7v 1699.505n 0.0v 1709.495n 0.0v 1709.505n 0.0v 1719.495n 0.0v 1719.505n 0.0v 1729.495n 0.0v 1729.505n 1.7v 1739.495n 1.7v 1739.505n 1.7v 1749.495n 1.7v 1749.505n 1.7v 1759.495n 1.7v 1759.505n 0.0v 1769.495n 0.0v 1769.505n 0.0v 1779.495n 0.0v 1779.505n 0.0v 1789.495n 0.0v 1789.505n 0.0v 1799.495n 0.0v 1799.505n 0.0v 1809.495n 0.0v 1809.505n 0.0v 1819.495n 0.0v 1819.505n 0.0v 1829.495n 0.0v 1829.505n 0.0v 1839.495n 0.0v 1839.505n 0.0v 1849.495n 0.0v 1849.505n 0.0v 1859.495n 0.0v 1859.505n 0.0v 1869.495n 0.0v 1869.505n 1.7v 1879.495n 1.7v 1879.505n 1.7v 1889.495n 1.7v 1889.505n 1.7v 1899.495n 1.7v 1899.505n 1.7v 1909.495n 1.7v 1909.505n 1.7v 1919.495n 1.7v 1919.505n 1.7v 1929.495n 1.7v 1929.505n 1.7v 1939.495n 1.7v 1939.505n 1.7v 1949.495n 1.7v 1949.505n 1.7v 1959.495n 1.7v 1959.505n 1.7v 1969.495n 1.7v 1969.505n 1.7v 1979.495n 1.7v 1979.505n 1.7v 1989.495n 1.7v 1989.505n 0.0v 1999.495n 0.0v 1999.505n 0.0v 2009.495n 0.0v 2009.505n 0.0v 2019.495n 0.0v 2019.505n 0.0v 2029.495n 0.0v 2029.505n 0.0v 2039.495n 0.0v 2039.505n 0.0v 2049.495n 0.0v 2049.505n 0.0v )
* (time, data): [(0, 0), (10, 0), (20, 0), (30, 0), (40, 0), (50, 0), (60, 0), (70, 0), (80, 0), (90, 0), (100, 0), (110, 0), (120, 0), (130, 0), (140, 0), (150, 1), (160, 1), (170, 1), (180, 1), (190, 1), (200, 1), (210, 1), (220, 1), (230, 1), (240, 1), (250, 0), (260, 1), (270, 1), (280, 1), (290, 0), (300, 1), (310, 1), (320, 1), (330, 1), (340, 1), (350, 1), (360, 1), (370, 1), (380, 1), (390, 0), (400, 0), (410, 0), (420, 0), (430, 0), (440, 0), (450, 0), (460, 0), (470, 0), (480, 0), (490, 0), (500, 0), (510, 0), (520, 0), (530, 0), (540, 0), (550, 0), (560, 0), (570, 0), (580, 1), (590, 1), (600, 1), (610, 0), (620, 0), (630, 0), (640, 0), (650, 0), (660, 0), (670, 0), (680, 0), (690, 0), (700, 1), (710, 1), (720, 1), (730, 0), (740, 0), (750, 0), (760, 0), (770, 0), (780, 0), (790, 0), (800, 0), (810, 1), (820, 0), (830, 0), (840, 1), (850, 1), (860, 1), (870, 1), (880, 1), (890, 1), (900, 1), (910, 1), (920, 1), (930, 1), (940, 1), (950, 1), (960, 1), (970, 1), (980, 1), (990, 1), (1000, 1), (1010, 1), (1020, 1), (1030, 1), (1040, 1), (1050, 1), (1060, 1), (1070, 1), (1080, 0), (1090, 0), (1100, 0), (1110, 0), (1120, 0), (1130, 0), (1140, 0), (1150, 0), (1160, 0), (1170, 0), (1180, 0), (1190, 0), (1200, 1), (1210, 1), (1220, 1), (1230, 1), (1240, 1), (1250, 1), (1260, 1), (1270, 1), (1280, 1), (1290, 1), (1300, 1), (1310, 1), (1320, 1), (1330, 1), (1340, 1), (1350, 1), (1360, 1), (1370, 1), (1380, 1), (1390, 1), (1400, 1), (1410, 1), (1420, 1), (1430, 0), (1440, 0), (1450, 0), (1460, 0), (1470, 0), (1480, 0), (1490, 0), (1500, 1), (1510, 1), (1520, 1), (1530, 1), (1540, 1), (1550, 1), (1560, 0), (1570, 0), (1580, 0), (1590, 0), (1600, 1), (1610, 1), (1620, 1), (1630, 1), (1640, 1), (1650, 1), (1660, 1), (1670, 1), (1680, 1), (1690, 1), (1700, 0), (1710, 0), (1720, 0), (1730, 1), (1740, 1), (1750, 1), (1760, 0), (1770, 0), (1780, 0), (1790, 0), (1800, 0), (1810, 0), (1820, 0), (1830, 0), (1840, 0), (1850, 0), (1860, 0), (1870, 1), (1880, 1), (1890, 1), (1900, 1), (1910, 1), (1920, 1), (1930, 1), (1940, 1), (1950, 1), (1960, 1), (1970, 1), (1980, 1), (1990, 0), (2000, 0), (2010, 0), (2020, 0), (2030, 0), (2040, 0), (2050, 0)]
Va1_3  a1_3  0 PWL (0n 0.0v 9.495n 0.0v 9.505n 0.0v 19.495n 0.0v 19.505n 0.0v 29.495n 0.0v 29.505n 0.0v 39.495n 0.0v 39.505n 0.0v 49.495n 0.0v 49.505n 0.0v 59.495n 0.0v 59.505n 0.0v 69.495n 0.0v 69.505n 0.0v 79.495n 0.0v 79.505n 0.0v 89.495n 0.0v 89.505n 0.0v 99.495n 0.0v 99.505n 0.0v 109.495n 0.0v 109.505n 0.0v 119.495n 0.0v 119.505n 0.0v 129.495n 0.0v 129.505n 0.0v 139.495n 0.0v 139.505n 0.0v 149.495n 0.0v 149.505n 1.7v 159.495n 1.7v 159.505n 1.7v 169.495n 1.7v 169.505n 1.7v 179.495n 1.7v 179.505n 1.7v 189.495n 1.7v 189.505n 1.7v 199.495n 1.7v 199.505n 1.7v 209.495n 1.7v 209.505n 1.7v 219.495n 1.7v 219.505n 1.7v 229.495n 1.7v 229.505n 1.7v 239.495n 1.7v 239.505n 1.7v 249.495n 1.7v 249.505n 0.0v 259.495n 0.0v 259.505n 1.7v 269.495n 1.7v 269.505n 1.7v 279.495n 1.7v 279.505n 1.7v 289.495n 1.7v 289.505n 0.0v 299.495n 0.0v 299.505n 1.7v 309.495n 1.7v 309.505n 1.7v 319.495n 1.7v 319.505n 1.7v 329.495n 1.7v 329.505n 1.7v 339.495n 1.7v 339.505n 1.7v 349.495n 1.7v 349.505n 1.7v 359.495n 1.7v 359.505n 1.7v 369.495n 1.7v 369.505n 1.7v 379.495n 1.7v 379.505n 1.7v 389.495n 1.7v 389.505n 0.0v 399.495n 0.0v 399.505n 0.0v 409.495n 0.0v 409.505n 0.0v 419.495n 0.0v 419.505n 0.0v 429.495n 0.0v 429.505n 0.0v 439.495n 0.0v 439.505n 0.0v 449.495n 0.0v 449.505n 0.0v 459.495n 0.0v 459.505n 0.0v 469.495n 0.0v 469.505n 0.0v 479.495n 0.0v 479.505n 0.0v 489.495n 0.0v 489.505n 0.0v 499.495n 0.0v 499.505n 0.0v 509.495n 0.0v 509.505n 0.0v 519.495n 0.0v 519.505n 0.0v 529.495n 0.0v 529.505n 0.0v 539.495n 0.0v 539.505n 0.0v 549.495n 0.0v 549.505n 0.0v 559.495n 0.0v 559.505n 0.0v 569.495n 0.0v 569.505n 0.0v 579.495n 0.0v 579.505n 1.7v 589.495n 1.7v 589.505n 1.7v 599.495n 1.7v 599.505n 1.7v 609.495n 1.7v 609.505n 0.0v 619.495n 0.0v 619.505n 0.0v 629.495n 0.0v 629.505n 0.0v 639.495n 0.0v 639.505n 0.0v 649.495n 0.0v 649.505n 0.0v 659.495n 0.0v 659.505n 0.0v 669.495n 0.0v 669.505n 0.0v 679.495n 0.0v 679.505n 0.0v 689.495n 0.0v 689.505n 0.0v 699.495n 0.0v 699.505n 1.7v 709.495n 1.7v 709.505n 1.7v 719.495n 1.7v 719.505n 1.7v 729.495n 1.7v 729.505n 0.0v 739.495n 0.0v 739.505n 0.0v 749.495n 0.0v 749.505n 0.0v 759.495n 0.0v 759.505n 0.0v 769.495n 0.0v 769.505n 0.0v 779.495n 0.0v 779.505n 0.0v 789.495n 0.0v 789.505n 0.0v 799.495n 0.0v 799.505n 0.0v 809.495n 0.0v 809.505n 1.7v 819.495n 1.7v 819.505n 0.0v 829.495n 0.0v 829.505n 0.0v 839.495n 0.0v 839.505n 1.7v 849.495n 1.7v 849.505n 1.7v 859.495n 1.7v 859.505n 1.7v 869.495n 1.7v 869.505n 1.7v 879.495n 1.7v 879.505n 1.7v 889.495n 1.7v 889.505n 1.7v 899.495n 1.7v 899.505n 1.7v 909.495n 1.7v 909.505n 1.7v 919.495n 1.7v 919.505n 1.7v 929.495n 1.7v 929.505n 1.7v 939.495n 1.7v 939.505n 1.7v 949.495n 1.7v 949.505n 1.7v 959.495n 1.7v 959.505n 1.7v 969.495n 1.7v 969.505n 1.7v 979.495n 1.7v 979.505n 1.7v 989.495n 1.7v 989.505n 1.7v 999.495n 1.7v 999.505n 1.7v 1009.495n 1.7v 1009.505n 1.7v 1019.495n 1.7v 1019.505n 1.7v 1029.495n 1.7v 1029.505n 1.7v 1039.495n 1.7v 1039.505n 1.7v 1049.495n 1.7v 1049.505n 1.7v 1059.495n 1.7v 1059.505n 1.7v 1069.495n 1.7v 1069.505n 1.7v 1079.495n 1.7v 1079.505n 0.0v 1089.495n 0.0v 1089.505n 0.0v 1099.495n 0.0v 1099.505n 0.0v 1109.495n 0.0v 1109.505n 0.0v 1119.495n 0.0v 1119.505n 0.0v 1129.495n 0.0v 1129.505n 0.0v 1139.495n 0.0v 1139.505n 0.0v 1149.495n 0.0v 1149.505n 0.0v 1159.495n 0.0v 1159.505n 0.0v 1169.495n 0.0v 1169.505n 0.0v 1179.495n 0.0v 1179.505n 0.0v 1189.495n 0.0v 1189.505n 0.0v 1199.495n 0.0v 1199.505n 1.7v 1209.495n 1.7v 1209.505n 1.7v 1219.495n 1.7v 1219.505n 1.7v 1229.495n 1.7v 1229.505n 1.7v 1239.495n 1.7v 1239.505n 1.7v 1249.495n 1.7v 1249.505n 1.7v 1259.495n 1.7v 1259.505n 1.7v 1269.495n 1.7v 1269.505n 1.7v 1279.495n 1.7v 1279.505n 1.7v 1289.495n 1.7v 1289.505n 1.7v 1299.495n 1.7v 1299.505n 1.7v 1309.495n 1.7v 1309.505n 1.7v 1319.495n 1.7v 1319.505n 1.7v 1329.495n 1.7v 1329.505n 1.7v 1339.495n 1.7v 1339.505n 1.7v 1349.495n 1.7v 1349.505n 1.7v 1359.495n 1.7v 1359.505n 1.7v 1369.495n 1.7v 1369.505n 1.7v 1379.495n 1.7v 1379.505n 1.7v 1389.495n 1.7v 1389.505n 1.7v 1399.495n 1.7v 1399.505n 1.7v 1409.495n 1.7v 1409.505n 1.7v 1419.495n 1.7v 1419.505n 1.7v 1429.495n 1.7v 1429.505n 0.0v 1439.495n 0.0v 1439.505n 0.0v 1449.495n 0.0v 1449.505n 0.0v 1459.495n 0.0v 1459.505n 0.0v 1469.495n 0.0v 1469.505n 0.0v 1479.495n 0.0v 1479.505n 0.0v 1489.495n 0.0v 1489.505n 0.0v 1499.495n 0.0v 1499.505n 1.7v 1509.495n 1.7v 1509.505n 1.7v 1519.495n 1.7v 1519.505n 1.7v 1529.495n 1.7v 1529.505n 1.7v 1539.495n 1.7v 1539.505n 1.7v 1549.495n 1.7v 1549.505n 1.7v 1559.495n 1.7v 1559.505n 0.0v 1569.495n 0.0v 1569.505n 0.0v 1579.495n 0.0v 1579.505n 0.0v 1589.495n 0.0v 1589.505n 0.0v 1599.495n 0.0v 1599.505n 1.7v 1609.495n 1.7v 1609.505n 1.7v 1619.495n 1.7v 1619.505n 1.7v 1629.495n 1.7v 1629.505n 1.7v 1639.495n 1.7v 1639.505n 1.7v 1649.495n 1.7v 1649.505n 1.7v 1659.495n 1.7v 1659.505n 1.7v 1669.495n 1.7v 1669.505n 1.7v 1679.495n 1.7v 1679.505n 1.7v 1689.495n 1.7v 1689.505n 1.7v 1699.495n 1.7v 1699.505n 0.0v 1709.495n 0.0v 1709.505n 0.0v 1719.495n 0.0v 1719.505n 0.0v 1729.495n 0.0v 1729.505n 1.7v 1739.495n 1.7v 1739.505n 1.7v 1749.495n 1.7v 1749.505n 1.7v 1759.495n 1.7v 1759.505n 0.0v 1769.495n 0.0v 1769.505n 0.0v 1779.495n 0.0v 1779.505n 0.0v 1789.495n 0.0v 1789.505n 0.0v 1799.495n 0.0v 1799.505n 0.0v 1809.495n 0.0v 1809.505n 0.0v 1819.495n 0.0v 1819.505n 0.0v 1829.495n 0.0v 1829.505n 0.0v 1839.495n 0.0v 1839.505n 0.0v 1849.495n 0.0v 1849.505n 0.0v 1859.495n 0.0v 1859.505n 0.0v 1869.495n 0.0v 1869.505n 1.7v 1879.495n 1.7v 1879.505n 1.7v 1889.495n 1.7v 1889.505n 1.7v 1899.495n 1.7v 1899.505n 1.7v 1909.495n 1.7v 1909.505n 1.7v 1919.495n 1.7v 1919.505n 1.7v 1929.495n 1.7v 1929.505n 1.7v 1939.495n 1.7v 1939.505n 1.7v 1949.495n 1.7v 1949.505n 1.7v 1959.495n 1.7v 1959.505n 1.7v 1969.495n 1.7v 1969.505n 1.7v 1979.495n 1.7v 1979.505n 1.7v 1989.495n 1.7v 1989.505n 0.0v 1999.495n 0.0v 1999.505n 0.0v 2009.495n 0.0v 2009.505n 0.0v 2019.495n 0.0v 2019.505n 0.0v 2029.495n 0.0v 2029.505n 0.0v 2039.495n 0.0v 2039.505n 0.0v 2049.495n 0.0v 2049.505n 0.0v )
* (time, data): [(0, 0), (10, 0), (20, 0), (30, 0), (40, 0), (50, 0), (60, 0), (70, 0), (80, 0), (90, 0), (100, 0), (110, 0), (120, 0), (130, 0), (140, 0), (150, 1), (160, 1), (170, 1), (180, 1), (190, 1), (200, 1), (210, 1), (220, 1), (230, 1), (240, 1), (250, 0), (260, 1), (270, 1), (280, 1), (290, 0), (300, 1), (310, 1), (320, 1), (330, 1), (340, 1), (350, 1), (360, 1), (370, 1), (380, 1), (390, 0), (400, 0), (410, 0), (420, 0), (430, 0), (440, 0), (450, 0), (460, 0), (470, 0), (480, 0), (490, 0), (500, 0), (510, 0), (520, 0), (530, 0), (540, 0), (550, 0), (560, 0), (570, 0), (580, 1), (590, 1), (600, 1), (610, 0), (620, 0), (630, 0), (640, 0), (650, 0), (660, 0), (670, 0), (680, 0), (690, 0), (700, 1), (710, 1), (720, 1), (730, 0), (740, 0), (750, 0), (760, 0), (770, 0), (780, 0), (790, 0), (800, 0), (810, 1), (820, 0), (830, 0), (840, 1), (850, 1), (860, 1), (870, 1), (880, 1), (890, 1), (900, 1), (910, 1), (920, 1), (930, 1), (940, 1), (950, 1), (960, 1), (970, 1), (980, 1), (990, 1), (1000, 1), (1010, 1), (1020, 1), (1030, 1), (1040, 1), (1050, 1), (1060, 1), (1070, 1), (1080, 0), (1090, 0), (1100, 0), (1110, 0), (1120, 0), (1130, 0), (1140, 0), (1150, 0), (1160, 0), (1170, 0), (1180, 0), (1190, 0), (1200, 1), (1210, 1), (1220, 1), (1230, 1), (1240, 1), (1250, 1), (1260, 1), (1270, 1), (1280, 1), (1290, 1), (1300, 1), (1310, 1), (1320, 1), (1330, 1), (1340, 1), (1350, 1), (1360, 1), (1370, 1), (1380, 1), (1390, 1), (1400, 1), (1410, 1), (1420, 1), (1430, 0), (1440, 0), (1450, 0), (1460, 0), (1470, 0), (1480, 0), (1490, 0), (1500, 1), (1510, 1), (1520, 1), (1530, 1), (1540, 1), (1550, 1), (1560, 0), (1570, 0), (1580, 0), (1590, 0), (1600, 1), (1610, 1), (1620, 1), (1630, 1), (1640, 1), (1650, 1), (1660, 1), (1670, 1), (1680, 1), (1690, 1), (1700, 0), (1710, 0), (1720, 0), (1730, 1), (1740, 1), (1750, 1), (1760, 0), (1770, 0), (1780, 0), (1790, 0), (1800, 0), (1810, 0), (1820, 0), (1830, 0), (1840, 0), (1850, 0), (1860, 0), (1870, 1), (1880, 1), (1890, 1), (1900, 1), (1910, 1), (1920, 1), (1930, 1), (1940, 1), (1950, 1), (1960, 1), (1970, 1), (1980, 1), (1990, 0), (2000, 0), (2010, 0), (2020, 0), (2030, 0), (2040, 0), (2050, 0)]
Va1_4  a1_4  0 PWL (0n 0.0v 9.495n 0.0v 9.505n 0.0v 19.495n 0.0v 19.505n 0.0v 29.495n 0.0v 29.505n 0.0v 39.495n 0.0v 39.505n 0.0v 49.495n 0.0v 49.505n 0.0v 59.495n 0.0v 59.505n 0.0v 69.495n 0.0v 69.505n 0.0v 79.495n 0.0v 79.505n 0.0v 89.495n 0.0v 89.505n 0.0v 99.495n 0.0v 99.505n 0.0v 109.495n 0.0v 109.505n 0.0v 119.495n 0.0v 119.505n 0.0v 129.495n 0.0v 129.505n 0.0v 139.495n 0.0v 139.505n 0.0v 149.495n 0.0v 149.505n 1.7v 159.495n 1.7v 159.505n 1.7v 169.495n 1.7v 169.505n 1.7v 179.495n 1.7v 179.505n 1.7v 189.495n 1.7v 189.505n 1.7v 199.495n 1.7v 199.505n 1.7v 209.495n 1.7v 209.505n 1.7v 219.495n 1.7v 219.505n 1.7v 229.495n 1.7v 229.505n 1.7v 239.495n 1.7v 239.505n 1.7v 249.495n 1.7v 249.505n 0.0v 259.495n 0.0v 259.505n 1.7v 269.495n 1.7v 269.505n 1.7v 279.495n 1.7v 279.505n 1.7v 289.495n 1.7v 289.505n 0.0v 299.495n 0.0v 299.505n 1.7v 309.495n 1.7v 309.505n 1.7v 319.495n 1.7v 319.505n 1.7v 329.495n 1.7v 329.505n 1.7v 339.495n 1.7v 339.505n 1.7v 349.495n 1.7v 349.505n 1.7v 359.495n 1.7v 359.505n 1.7v 369.495n 1.7v 369.505n 1.7v 379.495n 1.7v 379.505n 1.7v 389.495n 1.7v 389.505n 0.0v 399.495n 0.0v 399.505n 0.0v 409.495n 0.0v 409.505n 0.0v 419.495n 0.0v 419.505n 0.0v 429.495n 0.0v 429.505n 0.0v 439.495n 0.0v 439.505n 0.0v 449.495n 0.0v 449.505n 0.0v 459.495n 0.0v 459.505n 0.0v 469.495n 0.0v 469.505n 0.0v 479.495n 0.0v 479.505n 0.0v 489.495n 0.0v 489.505n 0.0v 499.495n 0.0v 499.505n 0.0v 509.495n 0.0v 509.505n 0.0v 519.495n 0.0v 519.505n 0.0v 529.495n 0.0v 529.505n 0.0v 539.495n 0.0v 539.505n 0.0v 549.495n 0.0v 549.505n 0.0v 559.495n 0.0v 559.505n 0.0v 569.495n 0.0v 569.505n 0.0v 579.495n 0.0v 579.505n 1.7v 589.495n 1.7v 589.505n 1.7v 599.495n 1.7v 599.505n 1.7v 609.495n 1.7v 609.505n 0.0v 619.495n 0.0v 619.505n 0.0v 629.495n 0.0v 629.505n 0.0v 639.495n 0.0v 639.505n 0.0v 649.495n 0.0v 649.505n 0.0v 659.495n 0.0v 659.505n 0.0v 669.495n 0.0v 669.505n 0.0v 679.495n 0.0v 679.505n 0.0v 689.495n 0.0v 689.505n 0.0v 699.495n 0.0v 699.505n 1.7v 709.495n 1.7v 709.505n 1.7v 719.495n 1.7v 719.505n 1.7v 729.495n 1.7v 729.505n 0.0v 739.495n 0.0v 739.505n 0.0v 749.495n 0.0v 749.505n 0.0v 759.495n 0.0v 759.505n 0.0v 769.495n 0.0v 769.505n 0.0v 779.495n 0.0v 779.505n 0.0v 789.495n 0.0v 789.505n 0.0v 799.495n 0.0v 799.505n 0.0v 809.495n 0.0v 809.505n 1.7v 819.495n 1.7v 819.505n 0.0v 829.495n 0.0v 829.505n 0.0v 839.495n 0.0v 839.505n 1.7v 849.495n 1.7v 849.505n 1.7v 859.495n 1.7v 859.505n 1.7v 869.495n 1.7v 869.505n 1.7v 879.495n 1.7v 879.505n 1.7v 889.495n 1.7v 889.505n 1.7v 899.495n 1.7v 899.505n 1.7v 909.495n 1.7v 909.505n 1.7v 919.495n 1.7v 919.505n 1.7v 929.495n 1.7v 929.505n 1.7v 939.495n 1.7v 939.505n 1.7v 949.495n 1.7v 949.505n 1.7v 959.495n 1.7v 959.505n 1.7v 969.495n 1.7v 969.505n 1.7v 979.495n 1.7v 979.505n 1.7v 989.495n 1.7v 989.505n 1.7v 999.495n 1.7v 999.505n 1.7v 1009.495n 1.7v 1009.505n 1.7v 1019.495n 1.7v 1019.505n 1.7v 1029.495n 1.7v 1029.505n 1.7v 1039.495n 1.7v 1039.505n 1.7v 1049.495n 1.7v 1049.505n 1.7v 1059.495n 1.7v 1059.505n 1.7v 1069.495n 1.7v 1069.505n 1.7v 1079.495n 1.7v 1079.505n 0.0v 1089.495n 0.0v 1089.505n 0.0v 1099.495n 0.0v 1099.505n 0.0v 1109.495n 0.0v 1109.505n 0.0v 1119.495n 0.0v 1119.505n 0.0v 1129.495n 0.0v 1129.505n 0.0v 1139.495n 0.0v 1139.505n 0.0v 1149.495n 0.0v 1149.505n 0.0v 1159.495n 0.0v 1159.505n 0.0v 1169.495n 0.0v 1169.505n 0.0v 1179.495n 0.0v 1179.505n 0.0v 1189.495n 0.0v 1189.505n 0.0v 1199.495n 0.0v 1199.505n 1.7v 1209.495n 1.7v 1209.505n 1.7v 1219.495n 1.7v 1219.505n 1.7v 1229.495n 1.7v 1229.505n 1.7v 1239.495n 1.7v 1239.505n 1.7v 1249.495n 1.7v 1249.505n 1.7v 1259.495n 1.7v 1259.505n 1.7v 1269.495n 1.7v 1269.505n 1.7v 1279.495n 1.7v 1279.505n 1.7v 1289.495n 1.7v 1289.505n 1.7v 1299.495n 1.7v 1299.505n 1.7v 1309.495n 1.7v 1309.505n 1.7v 1319.495n 1.7v 1319.505n 1.7v 1329.495n 1.7v 1329.505n 1.7v 1339.495n 1.7v 1339.505n 1.7v 1349.495n 1.7v 1349.505n 1.7v 1359.495n 1.7v 1359.505n 1.7v 1369.495n 1.7v 1369.505n 1.7v 1379.495n 1.7v 1379.505n 1.7v 1389.495n 1.7v 1389.505n 1.7v 1399.495n 1.7v 1399.505n 1.7v 1409.495n 1.7v 1409.505n 1.7v 1419.495n 1.7v 1419.505n 1.7v 1429.495n 1.7v 1429.505n 0.0v 1439.495n 0.0v 1439.505n 0.0v 1449.495n 0.0v 1449.505n 0.0v 1459.495n 0.0v 1459.505n 0.0v 1469.495n 0.0v 1469.505n 0.0v 1479.495n 0.0v 1479.505n 0.0v 1489.495n 0.0v 1489.505n 0.0v 1499.495n 0.0v 1499.505n 1.7v 1509.495n 1.7v 1509.505n 1.7v 1519.495n 1.7v 1519.505n 1.7v 1529.495n 1.7v 1529.505n 1.7v 1539.495n 1.7v 1539.505n 1.7v 1549.495n 1.7v 1549.505n 1.7v 1559.495n 1.7v 1559.505n 0.0v 1569.495n 0.0v 1569.505n 0.0v 1579.495n 0.0v 1579.505n 0.0v 1589.495n 0.0v 1589.505n 0.0v 1599.495n 0.0v 1599.505n 1.7v 1609.495n 1.7v 1609.505n 1.7v 1619.495n 1.7v 1619.505n 1.7v 1629.495n 1.7v 1629.505n 1.7v 1639.495n 1.7v 1639.505n 1.7v 1649.495n 1.7v 1649.505n 1.7v 1659.495n 1.7v 1659.505n 1.7v 1669.495n 1.7v 1669.505n 1.7v 1679.495n 1.7v 1679.505n 1.7v 1689.495n 1.7v 1689.505n 1.7v 1699.495n 1.7v 1699.505n 0.0v 1709.495n 0.0v 1709.505n 0.0v 1719.495n 0.0v 1719.505n 0.0v 1729.495n 0.0v 1729.505n 1.7v 1739.495n 1.7v 1739.505n 1.7v 1749.495n 1.7v 1749.505n 1.7v 1759.495n 1.7v 1759.505n 0.0v 1769.495n 0.0v 1769.505n 0.0v 1779.495n 0.0v 1779.505n 0.0v 1789.495n 0.0v 1789.505n 0.0v 1799.495n 0.0v 1799.505n 0.0v 1809.495n 0.0v 1809.505n 0.0v 1819.495n 0.0v 1819.505n 0.0v 1829.495n 0.0v 1829.505n 0.0v 1839.495n 0.0v 1839.505n 0.0v 1849.495n 0.0v 1849.505n 0.0v 1859.495n 0.0v 1859.505n 0.0v 1869.495n 0.0v 1869.505n 1.7v 1879.495n 1.7v 1879.505n 1.7v 1889.495n 1.7v 1889.505n 1.7v 1899.495n 1.7v 1899.505n 1.7v 1909.495n 1.7v 1909.505n 1.7v 1919.495n 1.7v 1919.505n 1.7v 1929.495n 1.7v 1929.505n 1.7v 1939.495n 1.7v 1939.505n 1.7v 1949.495n 1.7v 1949.505n 1.7v 1959.495n 1.7v 1959.505n 1.7v 1969.495n 1.7v 1969.505n 1.7v 1979.495n 1.7v 1979.505n 1.7v 1989.495n 1.7v 1989.505n 0.0v 1999.495n 0.0v 1999.505n 0.0v 2009.495n 0.0v 2009.505n 0.0v 2019.495n 0.0v 2019.505n 0.0v 2029.495n 0.0v 2029.505n 0.0v 2039.495n 0.0v 2039.505n 0.0v 2049.495n 0.0v 2049.505n 0.0v )
* (time, data): [(0, 0), (10, 0), (20, 0), (30, 0), (40, 0), (50, 0), (60, 0), (70, 0), (80, 0), (90, 0), (100, 0), (110, 0), (120, 0), (130, 0), (140, 0), (150, 0), (160, 0), (170, 0), (180, 0), (190, 0), (200, 0), (210, 0), (220, 0), (230, 0), (240, 0), (250, 0), (260, 0), (270, 0), (280, 0), (290, 0), (300, 0), (310, 0), (320, 0), (330, 0), (340, 0), (350, 0), (360, 0), (370, 0), (380, 0), (390, 0), (400, 0), (410, 0), (420, 0), (430, 0), (440, 0), (450, 0), (460, 0), (470, 0), (480, 0), (490, 0), (500, 0), (510, 0), (520, 0), (530, 0), (540, 0), (550, 0), (560, 0), (570, 0), (580, 0), (590, 0), (600, 0), (610, 0), (620, 0), (630, 0), (640, 0), (650, 0), (660, 0), (670, 0), (680, 0), (690, 0), (700, 0), (710, 0), (720, 0), (730, 0), (740, 0), (750, 0), (760, 0), (770, 0), (780, 0), (790, 0), (800, 0), (810, 0), (820, 0), (830, 0), (840, 0), (850, 0), (860, 0), (870, 0), (880, 0), (890, 0), (900, 0), (910, 0), (920, 0), (930, 0), (940, 0), (950, 0), (960, 0), (970, 0), (980, 0), (990, 0), (1000, 0), (1010, 0), (1020, 0), (1030, 0), (1040, 0), (1050, 0), (1060, 0), (1070, 0), (1080, 0), (1090, 0), (1100, 0), (1110, 0), (1120, 0), (1130, 0), (1140, 0), (1150, 0), (1160, 0), (1170, 0), (1180, 0), (1190, 0), (1200, 0), (1210, 0), (1220, 0), (1230, 0), (1240, 0), (1250, 0), (1260, 0), (1270, 0), (1280, 0), (1290, 0), (1300, 0), (1310, 0), (1320, 0), (1330, 0), (1340, 0), (1350, 0), (1360, 0), (1370, 0), (1380, 0), (1390, 0), (1400, 0), (1410, 0), (1420, 0), (1430, 0), (1440, 0), (1450, 0), (1460, 0), (1470, 0), (1480, 0), (1490, 0), (1500, 0), (1510, 0), (1520, 0), (1530, 0), (1540, 0), (1550, 0), (1560, 0), (1570, 0), (1580, 0), (1590, 0), (1600, 0), (1610, 0), (1620, 0), (1630, 0), (1640, 0), (1650, 0), (1660, 0), (1670, 0), (1680, 0), (1690, 0), (1700, 0), (1710, 0), (1720, 0), (1730, 0), (1740, 0), (1750, 0), (1760, 0), (1770, 0), (1780, 0), (1790, 0), (1800, 0), (1810, 0), (1820, 0), (1830, 0), (1840, 0), (1850, 0), (1860, 0), (1870, 0), (1880, 0), (1890, 0), (1900, 0), (1910, 0), (1920, 0), (1930, 0), (1940, 0), (1950, 0), (1960, 0), (1970, 0), (1980, 0), (1990, 0), (2000, 0), (2010, 0), (2020, 0), (2030, 0), (2040, 0), (2050, 0)]
Va1_5  a1_5  0 PWL (0n 0.0v 9.495n 0.0v 9.505n 0.0v 19.495n 0.0v 19.505n 0.0v 29.495n 0.0v 29.505n 0.0v 39.495n 0.0v 39.505n 0.0v 49.495n 0.0v 49.505n 0.0v 59.495n 0.0v 59.505n 0.0v 69.495n 0.0v 69.505n 0.0v 79.495n 0.0v 79.505n 0.0v 89.495n 0.0v 89.505n 0.0v 99.495n 0.0v 99.505n 0.0v 109.495n 0.0v 109.505n 0.0v 119.495n 0.0v 119.505n 0.0v 129.495n 0.0v 129.505n 0.0v 139.495n 0.0v 139.505n 0.0v 149.495n 0.0v 149.505n 0.0v 159.495n 0.0v 159.505n 0.0v 169.495n 0.0v 169.505n 0.0v 179.495n 0.0v 179.505n 0.0v 189.495n 0.0v 189.505n 0.0v 199.495n 0.0v 199.505n 0.0v 209.495n 0.0v 209.505n 0.0v 219.495n 0.0v 219.505n 0.0v 229.495n 0.0v 229.505n 0.0v 239.495n 0.0v 239.505n 0.0v 249.495n 0.0v 249.505n 0.0v 259.495n 0.0v 259.505n 0.0v 269.495n 0.0v 269.505n 0.0v 279.495n 0.0v 279.505n 0.0v 289.495n 0.0v 289.505n 0.0v 299.495n 0.0v 299.505n 0.0v 309.495n 0.0v 309.505n 0.0v 319.495n 0.0v 319.505n 0.0v 329.495n 0.0v 329.505n 0.0v 339.495n 0.0v 339.505n 0.0v 349.495n 0.0v 349.505n 0.0v 359.495n 0.0v 359.505n 0.0v 369.495n 0.0v 369.505n 0.0v 379.495n 0.0v 379.505n 0.0v 389.495n 0.0v 389.505n 0.0v 399.495n 0.0v 399.505n 0.0v 409.495n 0.0v 409.505n 0.0v 419.495n 0.0v 419.505n 0.0v 429.495n 0.0v 429.505n 0.0v 439.495n 0.0v 439.505n 0.0v 449.495n 0.0v 449.505n 0.0v 459.495n 0.0v 459.505n 0.0v 469.495n 0.0v 469.505n 0.0v 479.495n 0.0v 479.505n 0.0v 489.495n 0.0v 489.505n 0.0v 499.495n 0.0v 499.505n 0.0v 509.495n 0.0v 509.505n 0.0v 519.495n 0.0v 519.505n 0.0v 529.495n 0.0v 529.505n 0.0v 539.495n 0.0v 539.505n 0.0v 549.495n 0.0v 549.505n 0.0v 559.495n 0.0v 559.505n 0.0v 569.495n 0.0v 569.505n 0.0v 579.495n 0.0v 579.505n 0.0v 589.495n 0.0v 589.505n 0.0v 599.495n 0.0v 599.505n 0.0v 609.495n 0.0v 609.505n 0.0v 619.495n 0.0v 619.505n 0.0v 629.495n 0.0v 629.505n 0.0v 639.495n 0.0v 639.505n 0.0v 649.495n 0.0v 649.505n 0.0v 659.495n 0.0v 659.505n 0.0v 669.495n 0.0v 669.505n 0.0v 679.495n 0.0v 679.505n 0.0v 689.495n 0.0v 689.505n 0.0v 699.495n 0.0v 699.505n 0.0v 709.495n 0.0v 709.505n 0.0v 719.495n 0.0v 719.505n 0.0v 729.495n 0.0v 729.505n 0.0v 739.495n 0.0v 739.505n 0.0v 749.495n 0.0v 749.505n 0.0v 759.495n 0.0v 759.505n 0.0v 769.495n 0.0v 769.505n 0.0v 779.495n 0.0v 779.505n 0.0v 789.495n 0.0v 789.505n 0.0v 799.495n 0.0v 799.505n 0.0v 809.495n 0.0v 809.505n 0.0v 819.495n 0.0v 819.505n 0.0v 829.495n 0.0v 829.505n 0.0v 839.495n 0.0v 839.505n 0.0v 849.495n 0.0v 849.505n 0.0v 859.495n 0.0v 859.505n 0.0v 869.495n 0.0v 869.505n 0.0v 879.495n 0.0v 879.505n 0.0v 889.495n 0.0v 889.505n 0.0v 899.495n 0.0v 899.505n 0.0v 909.495n 0.0v 909.505n 0.0v 919.495n 0.0v 919.505n 0.0v 929.495n 0.0v 929.505n 0.0v 939.495n 0.0v 939.505n 0.0v 949.495n 0.0v 949.505n 0.0v 959.495n 0.0v 959.505n 0.0v 969.495n 0.0v 969.505n 0.0v 979.495n 0.0v 979.505n 0.0v 989.495n 0.0v 989.505n 0.0v 999.495n 0.0v 999.505n 0.0v 1009.495n 0.0v 1009.505n 0.0v 1019.495n 0.0v 1019.505n 0.0v 1029.495n 0.0v 1029.505n 0.0v 1039.495n 0.0v 1039.505n 0.0v 1049.495n 0.0v 1049.505n 0.0v 1059.495n 0.0v 1059.505n 0.0v 1069.495n 0.0v 1069.505n 0.0v 1079.495n 0.0v 1079.505n 0.0v 1089.495n 0.0v 1089.505n 0.0v 1099.495n 0.0v 1099.505n 0.0v 1109.495n 0.0v 1109.505n 0.0v 1119.495n 0.0v 1119.505n 0.0v 1129.495n 0.0v 1129.505n 0.0v 1139.495n 0.0v 1139.505n 0.0v 1149.495n 0.0v 1149.505n 0.0v 1159.495n 0.0v 1159.505n 0.0v 1169.495n 0.0v 1169.505n 0.0v 1179.495n 0.0v 1179.505n 0.0v 1189.495n 0.0v 1189.505n 0.0v 1199.495n 0.0v 1199.505n 0.0v 1209.495n 0.0v 1209.505n 0.0v 1219.495n 0.0v 1219.505n 0.0v 1229.495n 0.0v 1229.505n 0.0v 1239.495n 0.0v 1239.505n 0.0v 1249.495n 0.0v 1249.505n 0.0v 1259.495n 0.0v 1259.505n 0.0v 1269.495n 0.0v 1269.505n 0.0v 1279.495n 0.0v 1279.505n 0.0v 1289.495n 0.0v 1289.505n 0.0v 1299.495n 0.0v 1299.505n 0.0v 1309.495n 0.0v 1309.505n 0.0v 1319.495n 0.0v 1319.505n 0.0v 1329.495n 0.0v 1329.505n 0.0v 1339.495n 0.0v 1339.505n 0.0v 1349.495n 0.0v 1349.505n 0.0v 1359.495n 0.0v 1359.505n 0.0v 1369.495n 0.0v 1369.505n 0.0v 1379.495n 0.0v 1379.505n 0.0v 1389.495n 0.0v 1389.505n 0.0v 1399.495n 0.0v 1399.505n 0.0v 1409.495n 0.0v 1409.505n 0.0v 1419.495n 0.0v 1419.505n 0.0v 1429.495n 0.0v 1429.505n 0.0v 1439.495n 0.0v 1439.505n 0.0v 1449.495n 0.0v 1449.505n 0.0v 1459.495n 0.0v 1459.505n 0.0v 1469.495n 0.0v 1469.505n 0.0v 1479.495n 0.0v 1479.505n 0.0v 1489.495n 0.0v 1489.505n 0.0v 1499.495n 0.0v 1499.505n 0.0v 1509.495n 0.0v 1509.505n 0.0v 1519.495n 0.0v 1519.505n 0.0v 1529.495n 0.0v 1529.505n 0.0v 1539.495n 0.0v 1539.505n 0.0v 1549.495n 0.0v 1549.505n 0.0v 1559.495n 0.0v 1559.505n 0.0v 1569.495n 0.0v 1569.505n 0.0v 1579.495n 0.0v 1579.505n 0.0v 1589.495n 0.0v 1589.505n 0.0v 1599.495n 0.0v 1599.505n 0.0v 1609.495n 0.0v 1609.505n 0.0v 1619.495n 0.0v 1619.505n 0.0v 1629.495n 0.0v 1629.505n 0.0v 1639.495n 0.0v 1639.505n 0.0v 1649.495n 0.0v 1649.505n 0.0v 1659.495n 0.0v 1659.505n 0.0v 1669.495n 0.0v 1669.505n 0.0v 1679.495n 0.0v 1679.505n 0.0v 1689.495n 0.0v 1689.505n 0.0v 1699.495n 0.0v 1699.505n 0.0v 1709.495n 0.0v 1709.505n 0.0v 1719.495n 0.0v 1719.505n 0.0v 1729.495n 0.0v 1729.505n 0.0v 1739.495n 0.0v 1739.505n 0.0v 1749.495n 0.0v 1749.505n 0.0v 1759.495n 0.0v 1759.505n 0.0v 1769.495n 0.0v 1769.505n 0.0v 1779.495n 0.0v 1779.505n 0.0v 1789.495n 0.0v 1789.505n 0.0v 1799.495n 0.0v 1799.505n 0.0v 1809.495n 0.0v 1809.505n 0.0v 1819.495n 0.0v 1819.505n 0.0v 1829.495n 0.0v 1829.505n 0.0v 1839.495n 0.0v 1839.505n 0.0v 1849.495n 0.0v 1849.505n 0.0v 1859.495n 0.0v 1859.505n 0.0v 1869.495n 0.0v 1869.505n 0.0v 1879.495n 0.0v 1879.505n 0.0v 1889.495n 0.0v 1889.505n 0.0v 1899.495n 0.0v 1899.505n 0.0v 1909.495n 0.0v 1909.505n 0.0v 1919.495n 0.0v 1919.505n 0.0v 1929.495n 0.0v 1929.505n 0.0v 1939.495n 0.0v 1939.505n 0.0v 1949.495n 0.0v 1949.505n 0.0v 1959.495n 0.0v 1959.505n 0.0v 1969.495n 0.0v 1969.505n 0.0v 1979.495n 0.0v 1979.505n 0.0v 1989.495n 0.0v 1989.505n 0.0v 1999.495n 0.0v 1999.505n 0.0v 2009.495n 0.0v 2009.505n 0.0v 2019.495n 0.0v 2019.505n 0.0v 2029.495n 0.0v 2029.505n 0.0v 2039.495n 0.0v 2039.505n 0.0v 2049.495n 0.0v 2049.505n 0.0v )

 * Generation of control signals
* (time, data): [(0, 1), (10, 0), (20, 0), (30, 0), (40, 1), (50, 0), (60, 0), (70, 0), (80, 0), (90, 1), (100, 1), (110, 1), (120, 0), (130, 0), (140, 0), (150, 1), (160, 1), (170, 1), (180, 0), (190, 1), (200, 1), (210, 0), (220, 1), (230, 1), (240, 0), (250, 1), (260, 1), (270, 0), (280, 1), (290, 1), (300, 0), (310, 0), (320, 0), (330, 0), (340, 1), (350, 1), (360, 1), (370, 1), (380, 0), (390, 1), (400, 1), (410, 1), (420, 1), (430, 0), (440, 0), (450, 1), (460, 0), (470, 0), (480, 1), (490, 1), (500, 1), (510, 0), (520, 0), (530, 0), (540, 0), (550, 0), (560, 1), (570, 1), (580, 1), (590, 0), (600, 1), (610, 1), (620, 1), (630, 0), (640, 0), (650, 1), (660, 0), (670, 0), (680, 1), (690, 0), (700, 0), (710, 0), (720, 0), (730, 1), (740, 0), (750, 0), (760, 0), (770, 0), (780, 1), (790, 0), (800, 1), (810, 0), (820, 0), (830, 1), (840, 1), (850, 0), (860, 0), (870, 0), (880, 1), (890, 1), (900, 1), (910, 1), (920, 0), (930, 0), (940, 0), (950, 0), (960, 1), (970, 0), (980, 0), (990, 1), (1000, 1), (1010, 1), (1020, 1), (1030, 1), (1040, 0), (1050, 1), (1060, 1), (1070, 1), (1080, 1), (1090, 0), (1100, 0), (1110, 0), (1120, 1), (1130, 1), (1140, 0), (1150, 0), (1160, 0), (1170, 0), (1180, 0), (1190, 1), (1200, 0), (1210, 0), (1220, 0), (1230, 0), (1240, 0), (1250, 1), (1260, 1), (1270, 0), (1280, 1), (1290, 0), (1300, 1), (1310, 1), (1320, 0), (1330, 1), (1340, 0), (1350, 0), (1360, 1), (1370, 0), (1380, 0), (1390, 1), (1400, 0), (1410, 0), (1420, 1), (1430, 1), (1440, 0), (1450, 0), (1460, 0), (1470, 0), (1480, 1), (1490, 0), (1500, 1), (1510, 0), (1520, 1), (1530, 0), (1540, 0), (1550, 0), (1560, 1), (1570, 0), (1580, 0), (1590, 0), (1600, 0), (1610, 0), (1620, 1), (1630, 1), (1640, 0), (1650, 1), (1660, 1), (1670, 0), (1680, 0), (1690, 0), (1700, 0), (1710, 0), (1720, 0), (1730, 1), (1740, 0), (1750, 1), (1760, 0), (1770, 0), (1780, 0), (1790, 0), (1800, 0), (1810, 0), (1820, 0), (1830, 0), (1840, 0), (1850, 1), (1860, 0), (1870, 1), (1880, 0), (1890, 1), (1900, 0), (1910, 0), (1920, 0), (1930, 0), (1940, 0), (1950, 0), (1960, 1), (1970, 0), (1980, 1), (1990, 0), (2000, 1), (2010, 1), (2020, 0), (2030, 0), (2040, 1), (2050, 1)]
VCSB0 CSB0 0 PWL (0n 1.7v 9.495n 1.7v 9.505n 0.0v 19.495n 0.0v 19.505n 0.0v 29.495n 0.0v 29.505n 0.0v 39.495n 0.0v 39.505n 1.7v 49.495n 1.7v 49.505n 0.0v 59.495n 0.0v 59.505n 0.0v 69.495n 0.0v 69.505n 0.0v 79.495n 0.0v 79.505n 0.0v 89.495n 0.0v 89.505n 1.7v 99.495n 1.7v 99.505n 1.7v 109.495n 1.7v 109.505n 1.7v 119.495n 1.7v 119.505n 0.0v 129.495n 0.0v 129.505n 0.0v 139.495n 0.0v 139.505n 0.0v 149.495n 0.0v 149.505n 1.7v 159.495n 1.7v 159.505n 1.7v 169.495n 1.7v 169.505n 1.7v 179.495n 1.7v 179.505n 0.0v 189.495n 0.0v 189.505n 1.7v 199.495n 1.7v 199.505n 1.7v 209.495n 1.7v 209.505n 0.0v 219.495n 0.0v 219.505n 1.7v 229.495n 1.7v 229.505n 1.7v 239.495n 1.7v 239.505n 0.0v 249.495n 0.0v 249.505n 1.7v 259.495n 1.7v 259.505n 1.7v 269.495n 1.7v 269.505n 0.0v 279.495n 0.0v 279.505n 1.7v 289.495n 1.7v 289.505n 1.7v 299.495n 1.7v 299.505n 0.0v 309.495n 0.0v 309.505n 0.0v 319.495n 0.0v 319.505n 0.0v 329.495n 0.0v 329.505n 0.0v 339.495n 0.0v 339.505n 1.7v 349.495n 1.7v 349.505n 1.7v 359.495n 1.7v 359.505n 1.7v 369.495n 1.7v 369.505n 1.7v 379.495n 1.7v 379.505n 0.0v 389.495n 0.0v 389.505n 1.7v 399.495n 1.7v 399.505n 1.7v 409.495n 1.7v 409.505n 1.7v 419.495n 1.7v 419.505n 1.7v 429.495n 1.7v 429.505n 0.0v 439.495n 0.0v 439.505n 0.0v 449.495n 0.0v 449.505n 1.7v 459.495n 1.7v 459.505n 0.0v 469.495n 0.0v 469.505n 0.0v 479.495n 0.0v 479.505n 1.7v 489.495n 1.7v 489.505n 1.7v 499.495n 1.7v 499.505n 1.7v 509.495n 1.7v 509.505n 0.0v 519.495n 0.0v 519.505n 0.0v 529.495n 0.0v 529.505n 0.0v 539.495n 0.0v 539.505n 0.0v 549.495n 0.0v 549.505n 0.0v 559.495n 0.0v 559.505n 1.7v 569.495n 1.7v 569.505n 1.7v 579.495n 1.7v 579.505n 1.7v 589.495n 1.7v 589.505n 0.0v 599.495n 0.0v 599.505n 1.7v 609.495n 1.7v 609.505n 1.7v 619.495n 1.7v 619.505n 1.7v 629.495n 1.7v 629.505n 0.0v 639.495n 0.0v 639.505n 0.0v 649.495n 0.0v 649.505n 1.7v 659.495n 1.7v 659.505n 0.0v 669.495n 0.0v 669.505n 0.0v 679.495n 0.0v 679.505n 1.7v 689.495n 1.7v 689.505n 0.0v 699.495n 0.0v 699.505n 0.0v 709.495n 0.0v 709.505n 0.0v 719.495n 0.0v 719.505n 0.0v 729.495n 0.0v 729.505n 1.7v 739.495n 1.7v 739.505n 0.0v 749.495n 0.0v 749.505n 0.0v 759.495n 0.0v 759.505n 0.0v 769.495n 0.0v 769.505n 0.0v 779.495n 0.0v 779.505n 1.7v 789.495n 1.7v 789.505n 0.0v 799.495n 0.0v 799.505n 1.7v 809.495n 1.7v 809.505n 0.0v 819.495n 0.0v 819.505n 0.0v 829.495n 0.0v 829.505n 1.7v 839.495n 1.7v 839.505n 1.7v 849.495n 1.7v 849.505n 0.0v 859.495n 0.0v 859.505n 0.0v 869.495n 0.0v 869.505n 0.0v 879.495n 0.0v 879.505n 1.7v 889.495n 1.7v 889.505n 1.7v 899.495n 1.7v 899.505n 1.7v 909.495n 1.7v 909.505n 1.7v 919.495n 1.7v 919.505n 0.0v 929.495n 0.0v 929.505n 0.0v 939.495n 0.0v 939.505n 0.0v 949.495n 0.0v 949.505n 0.0v 959.495n 0.0v 959.505n 1.7v 969.495n 1.7v 969.505n 0.0v 979.495n 0.0v 979.505n 0.0v 989.495n 0.0v 989.505n 1.7v 999.495n 1.7v 999.505n 1.7v 1009.495n 1.7v 1009.505n 1.7v 1019.495n 1.7v 1019.505n 1.7v 1029.495n 1.7v 1029.505n 1.7v 1039.495n 1.7v 1039.505n 0.0v 1049.495n 0.0v 1049.505n 1.7v 1059.495n 1.7v 1059.505n 1.7v 1069.495n 1.7v 1069.505n 1.7v 1079.495n 1.7v 1079.505n 1.7v 1089.495n 1.7v 1089.505n 0.0v 1099.495n 0.0v 1099.505n 0.0v 1109.495n 0.0v 1109.505n 0.0v 1119.495n 0.0v 1119.505n 1.7v 1129.495n 1.7v 1129.505n 1.7v 1139.495n 1.7v 1139.505n 0.0v 1149.495n 0.0v 1149.505n 0.0v 1159.495n 0.0v 1159.505n 0.0v 1169.495n 0.0v 1169.505n 0.0v 1179.495n 0.0v 1179.505n 0.0v 1189.495n 0.0v 1189.505n 1.7v 1199.495n 1.7v 1199.505n 0.0v 1209.495n 0.0v 1209.505n 0.0v 1219.495n 0.0v 1219.505n 0.0v 1229.495n 0.0v 1229.505n 0.0v 1239.495n 0.0v 1239.505n 0.0v 1249.495n 0.0v 1249.505n 1.7v 1259.495n 1.7v 1259.505n 1.7v 1269.495n 1.7v 1269.505n 0.0v 1279.495n 0.0v 1279.505n 1.7v 1289.495n 1.7v 1289.505n 0.0v 1299.495n 0.0v 1299.505n 1.7v 1309.495n 1.7v 1309.505n 1.7v 1319.495n 1.7v 1319.505n 0.0v 1329.495n 0.0v 1329.505n 1.7v 1339.495n 1.7v 1339.505n 0.0v 1349.495n 0.0v 1349.505n 0.0v 1359.495n 0.0v 1359.505n 1.7v 1369.495n 1.7v 1369.505n 0.0v 1379.495n 0.0v 1379.505n 0.0v 1389.495n 0.0v 1389.505n 1.7v 1399.495n 1.7v 1399.505n 0.0v 1409.495n 0.0v 1409.505n 0.0v 1419.495n 0.0v 1419.505n 1.7v 1429.495n 1.7v 1429.505n 1.7v 1439.495n 1.7v 1439.505n 0.0v 1449.495n 0.0v 1449.505n 0.0v 1459.495n 0.0v 1459.505n 0.0v 1469.495n 0.0v 1469.505n 0.0v 1479.495n 0.0v 1479.505n 1.7v 1489.495n 1.7v 1489.505n 0.0v 1499.495n 0.0v 1499.505n 1.7v 1509.495n 1.7v 1509.505n 0.0v 1519.495n 0.0v 1519.505n 1.7v 1529.495n 1.7v 1529.505n 0.0v 1539.495n 0.0v 1539.505n 0.0v 1549.495n 0.0v 1549.505n 0.0v 1559.495n 0.0v 1559.505n 1.7v 1569.495n 1.7v 1569.505n 0.0v 1579.495n 0.0v 1579.505n 0.0v 1589.495n 0.0v 1589.505n 0.0v 1599.495n 0.0v 1599.505n 0.0v 1609.495n 0.0v 1609.505n 0.0v 1619.495n 0.0v 1619.505n 1.7v 1629.495n 1.7v 1629.505n 1.7v 1639.495n 1.7v 1639.505n 0.0v 1649.495n 0.0v 1649.505n 1.7v 1659.495n 1.7v 1659.505n 1.7v 1669.495n 1.7v 1669.505n 0.0v 1679.495n 0.0v 1679.505n 0.0v 1689.495n 0.0v 1689.505n 0.0v 1699.495n 0.0v 1699.505n 0.0v 1709.495n 0.0v 1709.505n 0.0v 1719.495n 0.0v 1719.505n 0.0v 1729.495n 0.0v 1729.505n 1.7v 1739.495n 1.7v 1739.505n 0.0v 1749.495n 0.0v 1749.505n 1.7v 1759.495n 1.7v 1759.505n 0.0v 1769.495n 0.0v 1769.505n 0.0v 1779.495n 0.0v 1779.505n 0.0v 1789.495n 0.0v 1789.505n 0.0v 1799.495n 0.0v 1799.505n 0.0v 1809.495n 0.0v 1809.505n 0.0v 1819.495n 0.0v 1819.505n 0.0v 1829.495n 0.0v 1829.505n 0.0v 1839.495n 0.0v 1839.505n 0.0v 1849.495n 0.0v 1849.505n 1.7v 1859.495n 1.7v 1859.505n 0.0v 1869.495n 0.0v 1869.505n 1.7v 1879.495n 1.7v 1879.505n 0.0v 1889.495n 0.0v 1889.505n 1.7v 1899.495n 1.7v 1899.505n 0.0v 1909.495n 0.0v 1909.505n 0.0v 1919.495n 0.0v 1919.505n 0.0v 1929.495n 0.0v 1929.505n 0.0v 1939.495n 0.0v 1939.505n 0.0v 1949.495n 0.0v 1949.505n 0.0v 1959.495n 0.0v 1959.505n 1.7v 1969.495n 1.7v 1969.505n 0.0v 1979.495n 0.0v 1979.505n 1.7v 1989.495n 1.7v 1989.505n 0.0v 1999.495n 0.0v 1999.505n 1.7v 2009.495n 1.7v 2009.505n 1.7v 2019.495n 1.7v 2019.505n 0.0v 2029.495n 0.0v 2029.505n 0.0v 2039.495n 0.0v 2039.505n 1.7v 2049.495n 1.7v 2049.505n 1.7v )
* (time, data): [(0, 1), (10, 1), (20, 1), (30, 1), (40, 0), (50, 1), (60, 0), (70, 1), (80, 0), (90, 0), (100, 0), (110, 0), (120, 0), (130, 1), (140, 1), (150, 0), (160, 1), (170, 1), (180, 1), (190, 1), (200, 0), (210, 1), (220, 1), (230, 1), (240, 1), (250, 0), (260, 0), (270, 1), (280, 0), (290, 0), (300, 0), (310, 1), (320, 1), (330, 1), (340, 0), (350, 1), (360, 1), (370, 0), (380, 1), (390, 0), (400, 1), (410, 0), (420, 0), (430, 0), (440, 0), (450, 1), (460, 1), (470, 1), (480, 0), (490, 1), (500, 1), (510, 1), (520, 1), (530, 0), (540, 1), (550, 0), (560, 1), (570, 0), (580, 0), (590, 1), (600, 1), (610, 0), (620, 0), (630, 1), (640, 0), (650, 1), (660, 0), (670, 1), (680, 1), (690, 0), (700, 0), (710, 1), (720, 1), (730, 0), (740, 1), (750, 1), (760, 1), (770, 1), (780, 1), (790, 1), (800, 1), (810, 0), (820, 0), (830, 1), (840, 0), (850, 1), (860, 1), (870, 1), (880, 1), (890, 0), (900, 0), (910, 0), (920, 1), (930, 1), (940, 1), (950, 1), (960, 1), (970, 0), (980, 1), (990, 1), (1000, 0), (1010, 1), (1020, 0), (1030, 0), (1040, 1), (1050, 0), (1060, 1), (1070, 1), (1080, 0), (1090, 1), (1100, 1), (1110, 0), (1120, 0), (1130, 1), (1140, 0), (1150, 1), (1160, 1), (1170, 1), (1180, 1), (1190, 1), (1200, 0), (1210, 0), (1220, 1), (1230, 0), (1240, 1), (1250, 0), (1260, 1), (1270, 1), (1280, 0), (1290, 1), (1300, 1), (1310, 1), (1320, 1), (1330, 1), (1340, 1), (1350, 1), (1360, 1), (1370, 1), (1380, 1), (1390, 0), (1400, 1), (1410, 1), (1420, 1), (1430, 0), (1440, 1), (1450, 1), (1460, 1), (1470, 1), (1480, 1), (1490, 1), (1500, 0), (1510, 1), (1520, 0), (1530, 0), (1540, 1), (1550, 1), (1560, 0), (1570, 1), (1580, 1), (1590, 1), (1600, 0), (1610, 1), (1620, 0), (1630, 1), (1640, 1), (1650, 1), (1660, 1), (1670, 1), (1680, 1), (1690, 1), (1700, 0), (1710, 1), (1720, 1), (1730, 0), (1740, 1), (1750, 1), (1760, 0), (1770, 1), (1780, 1), (1790, 1), (1800, 0), (1810, 1), (1820, 1), (1830, 1), (1840, 1), (1850, 1), (1860, 0), (1870, 0), (1880, 1), (1890, 1), (1900, 1), (1910, 0), (1920, 1), (1930, 1), (1940, 1), (1950, 1), (1960, 0), (1970, 1), (1980, 1), (1990, 0), (2000, 1), (2010, 1), (2020, 1), (2030, 1), (2040, 1), (2050, 1)]
VCSB1 CSB1 0 PWL (0n 1.7v 9.495n 1.7v 9.505n 1.7v 19.495n 1.7v 19.505n 1.7v 29.495n 1.7v 29.505n 1.7v 39.495n 1.7v 39.505n 0.0v 49.495n 0.0v 49.505n 1.7v 59.495n 1.7v 59.505n 0.0v 69.495n 0.0v 69.505n 1.7v 79.495n 1.7v 79.505n 0.0v 89.495n 0.0v 89.505n 0.0v 99.495n 0.0v 99.505n 0.0v 109.495n 0.0v 109.505n 0.0v 119.495n 0.0v 119.505n 0.0v 129.495n 0.0v 129.505n 1.7v 139.495n 1.7v 139.505n 1.7v 149.495n 1.7v 149.505n 0.0v 159.495n 0.0v 159.505n 1.7v 169.495n 1.7v 169.505n 1.7v 179.495n 1.7v 179.505n 1.7v 189.495n 1.7v 189.505n 1.7v 199.495n 1.7v 199.505n 0.0v 209.495n 0.0v 209.505n 1.7v 219.495n 1.7v 219.505n 1.7v 229.495n 1.7v 229.505n 1.7v 239.495n 1.7v 239.505n 1.7v 249.495n 1.7v 249.505n 0.0v 259.495n 0.0v 259.505n 0.0v 269.495n 0.0v 269.505n 1.7v 279.495n 1.7v 279.505n 0.0v 289.495n 0.0v 289.505n 0.0v 299.495n 0.0v 299.505n 0.0v 309.495n 0.0v 309.505n 1.7v 319.495n 1.7v 319.505n 1.7v 329.495n 1.7v 329.505n 1.7v 339.495n 1.7v 339.505n 0.0v 349.495n 0.0v 349.505n 1.7v 359.495n 1.7v 359.505n 1.7v 369.495n 1.7v 369.505n 0.0v 379.495n 0.0v 379.505n 1.7v 389.495n 1.7v 389.505n 0.0v 399.495n 0.0v 399.505n 1.7v 409.495n 1.7v 409.505n 0.0v 419.495n 0.0v 419.505n 0.0v 429.495n 0.0v 429.505n 0.0v 439.495n 0.0v 439.505n 0.0v 449.495n 0.0v 449.505n 1.7v 459.495n 1.7v 459.505n 1.7v 469.495n 1.7v 469.505n 1.7v 479.495n 1.7v 479.505n 0.0v 489.495n 0.0v 489.505n 1.7v 499.495n 1.7v 499.505n 1.7v 509.495n 1.7v 509.505n 1.7v 519.495n 1.7v 519.505n 1.7v 529.495n 1.7v 529.505n 0.0v 539.495n 0.0v 539.505n 1.7v 549.495n 1.7v 549.505n 0.0v 559.495n 0.0v 559.505n 1.7v 569.495n 1.7v 569.505n 0.0v 579.495n 0.0v 579.505n 0.0v 589.495n 0.0v 589.505n 1.7v 599.495n 1.7v 599.505n 1.7v 609.495n 1.7v 609.505n 0.0v 619.495n 0.0v 619.505n 0.0v 629.495n 0.0v 629.505n 1.7v 639.495n 1.7v 639.505n 0.0v 649.495n 0.0v 649.505n 1.7v 659.495n 1.7v 659.505n 0.0v 669.495n 0.0v 669.505n 1.7v 679.495n 1.7v 679.505n 1.7v 689.495n 1.7v 689.505n 0.0v 699.495n 0.0v 699.505n 0.0v 709.495n 0.0v 709.505n 1.7v 719.495n 1.7v 719.505n 1.7v 729.495n 1.7v 729.505n 0.0v 739.495n 0.0v 739.505n 1.7v 749.495n 1.7v 749.505n 1.7v 759.495n 1.7v 759.505n 1.7v 769.495n 1.7v 769.505n 1.7v 779.495n 1.7v 779.505n 1.7v 789.495n 1.7v 789.505n 1.7v 799.495n 1.7v 799.505n 1.7v 809.495n 1.7v 809.505n 0.0v 819.495n 0.0v 819.505n 0.0v 829.495n 0.0v 829.505n 1.7v 839.495n 1.7v 839.505n 0.0v 849.495n 0.0v 849.505n 1.7v 859.495n 1.7v 859.505n 1.7v 869.495n 1.7v 869.505n 1.7v 879.495n 1.7v 879.505n 1.7v 889.495n 1.7v 889.505n 0.0v 899.495n 0.0v 899.505n 0.0v 909.495n 0.0v 909.505n 0.0v 919.495n 0.0v 919.505n 1.7v 929.495n 1.7v 929.505n 1.7v 939.495n 1.7v 939.505n 1.7v 949.495n 1.7v 949.505n 1.7v 959.495n 1.7v 959.505n 1.7v 969.495n 1.7v 969.505n 0.0v 979.495n 0.0v 979.505n 1.7v 989.495n 1.7v 989.505n 1.7v 999.495n 1.7v 999.505n 0.0v 1009.495n 0.0v 1009.505n 1.7v 1019.495n 1.7v 1019.505n 0.0v 1029.495n 0.0v 1029.505n 0.0v 1039.495n 0.0v 1039.505n 1.7v 1049.495n 1.7v 1049.505n 0.0v 1059.495n 0.0v 1059.505n 1.7v 1069.495n 1.7v 1069.505n 1.7v 1079.495n 1.7v 1079.505n 0.0v 1089.495n 0.0v 1089.505n 1.7v 1099.495n 1.7v 1099.505n 1.7v 1109.495n 1.7v 1109.505n 0.0v 1119.495n 0.0v 1119.505n 0.0v 1129.495n 0.0v 1129.505n 1.7v 1139.495n 1.7v 1139.505n 0.0v 1149.495n 0.0v 1149.505n 1.7v 1159.495n 1.7v 1159.505n 1.7v 1169.495n 1.7v 1169.505n 1.7v 1179.495n 1.7v 1179.505n 1.7v 1189.495n 1.7v 1189.505n 1.7v 1199.495n 1.7v 1199.505n 0.0v 1209.495n 0.0v 1209.505n 0.0v 1219.495n 0.0v 1219.505n 1.7v 1229.495n 1.7v 1229.505n 0.0v 1239.495n 0.0v 1239.505n 1.7v 1249.495n 1.7v 1249.505n 0.0v 1259.495n 0.0v 1259.505n 1.7v 1269.495n 1.7v 1269.505n 1.7v 1279.495n 1.7v 1279.505n 0.0v 1289.495n 0.0v 1289.505n 1.7v 1299.495n 1.7v 1299.505n 1.7v 1309.495n 1.7v 1309.505n 1.7v 1319.495n 1.7v 1319.505n 1.7v 1329.495n 1.7v 1329.505n 1.7v 1339.495n 1.7v 1339.505n 1.7v 1349.495n 1.7v 1349.505n 1.7v 1359.495n 1.7v 1359.505n 1.7v 1369.495n 1.7v 1369.505n 1.7v 1379.495n 1.7v 1379.505n 1.7v 1389.495n 1.7v 1389.505n 0.0v 1399.495n 0.0v 1399.505n 1.7v 1409.495n 1.7v 1409.505n 1.7v 1419.495n 1.7v 1419.505n 1.7v 1429.495n 1.7v 1429.505n 0.0v 1439.495n 0.0v 1439.505n 1.7v 1449.495n 1.7v 1449.505n 1.7v 1459.495n 1.7v 1459.505n 1.7v 1469.495n 1.7v 1469.505n 1.7v 1479.495n 1.7v 1479.505n 1.7v 1489.495n 1.7v 1489.505n 1.7v 1499.495n 1.7v 1499.505n 0.0v 1509.495n 0.0v 1509.505n 1.7v 1519.495n 1.7v 1519.505n 0.0v 1529.495n 0.0v 1529.505n 0.0v 1539.495n 0.0v 1539.505n 1.7v 1549.495n 1.7v 1549.505n 1.7v 1559.495n 1.7v 1559.505n 0.0v 1569.495n 0.0v 1569.505n 1.7v 1579.495n 1.7v 1579.505n 1.7v 1589.495n 1.7v 1589.505n 1.7v 1599.495n 1.7v 1599.505n 0.0v 1609.495n 0.0v 1609.505n 1.7v 1619.495n 1.7v 1619.505n 0.0v 1629.495n 0.0v 1629.505n 1.7v 1639.495n 1.7v 1639.505n 1.7v 1649.495n 1.7v 1649.505n 1.7v 1659.495n 1.7v 1659.505n 1.7v 1669.495n 1.7v 1669.505n 1.7v 1679.495n 1.7v 1679.505n 1.7v 1689.495n 1.7v 1689.505n 1.7v 1699.495n 1.7v 1699.505n 0.0v 1709.495n 0.0v 1709.505n 1.7v 1719.495n 1.7v 1719.505n 1.7v 1729.495n 1.7v 1729.505n 0.0v 1739.495n 0.0v 1739.505n 1.7v 1749.495n 1.7v 1749.505n 1.7v 1759.495n 1.7v 1759.505n 0.0v 1769.495n 0.0v 1769.505n 1.7v 1779.495n 1.7v 1779.505n 1.7v 1789.495n 1.7v 1789.505n 1.7v 1799.495n 1.7v 1799.505n 0.0v 1809.495n 0.0v 1809.505n 1.7v 1819.495n 1.7v 1819.505n 1.7v 1829.495n 1.7v 1829.505n 1.7v 1839.495n 1.7v 1839.505n 1.7v 1849.495n 1.7v 1849.505n 1.7v 1859.495n 1.7v 1859.505n 0.0v 1869.495n 0.0v 1869.505n 0.0v 1879.495n 0.0v 1879.505n 1.7v 1889.495n 1.7v 1889.505n 1.7v 1899.495n 1.7v 1899.505n 1.7v 1909.495n 1.7v 1909.505n 0.0v 1919.495n 0.0v 1919.505n 1.7v 1929.495n 1.7v 1929.505n 1.7v 1939.495n 1.7v 1939.505n 1.7v 1949.495n 1.7v 1949.505n 1.7v 1959.495n 1.7v 1959.505n 0.0v 1969.495n 0.0v 1969.505n 1.7v 1979.495n 1.7v 1979.505n 1.7v 1989.495n 1.7v 1989.505n 0.0v 1999.495n 0.0v 1999.505n 1.7v 2009.495n 1.7v 2009.505n 1.7v 2019.495n 1.7v 2019.505n 1.7v 2029.495n 1.7v 2029.505n 1.7v 2039.495n 1.7v 2039.505n 1.7v 2049.495n 1.7v 2049.505n 1.7v )

* Generation of spare enable signals
* (time, data): [(0, 0), (10, 0), (20, 0), (30, 0), (40, 0), (50, 0), (60, 0), (70, 0), (80, 0), (90, 0), (100, 0), (110, 0), (120, 0), (130, 0), (140, 0), (150, 0), (160, 0), (170, 0), (180, 0), (190, 0), (200, 0), (210, 0), (220, 0), (230, 0), (240, 0), (250, 0), (260, 0), (270, 0), (280, 0), (290, 0), (300, 0), (310, 0), (320, 0), (330, 0), (340, 0), (350, 0), (360, 0), (370, 0), (380, 0), (390, 0), (400, 0), (410, 0), (420, 0), (430, 0), (440, 0), (450, 0), (460, 0), (470, 0), (480, 0), (490, 0), (500, 0), (510, 0), (520, 0), (530, 0), (540, 0), (550, 0), (560, 0), (570, 0), (580, 0), (590, 0), (600, 0), (610, 0), (620, 0), (630, 0), (640, 0), (650, 0), (660, 0), (670, 0), (680, 0), (690, 0), (700, 0), (710, 0), (720, 0), (730, 0), (740, 0), (750, 0), (760, 0), (770, 0), (780, 0), (790, 0), (800, 0), (810, 0), (820, 0), (830, 0), (840, 0), (850, 0), (860, 0), (870, 0), (880, 0), (890, 0), (900, 0), (910, 0), (920, 0), (930, 0), (940, 0), (950, 0), (960, 0), (970, 0), (980, 0), (990, 0), (1000, 0), (1010, 0), (1020, 0), (1030, 0), (1040, 0), (1050, 0), (1060, 0), (1070, 0), (1080, 0), (1090, 0), (1100, 0), (1110, 0), (1120, 0), (1130, 0), (1140, 0), (1150, 0), (1160, 0), (1170, 0), (1180, 0), (1190, 0), (1200, 0), (1210, 0), (1220, 0), (1230, 0), (1240, 0), (1250, 0), (1260, 0), (1270, 0), (1280, 0), (1290, 0), (1300, 0), (1310, 0), (1320, 0), (1330, 0), (1340, 0), (1350, 0), (1360, 0), (1370, 0), (1380, 0), (1390, 0), (1400, 0), (1410, 0), (1420, 0), (1430, 0), (1440, 0), (1450, 0), (1460, 0), (1470, 0), (1480, 0), (1490, 0), (1500, 0), (1510, 0), (1520, 0), (1530, 0), (1540, 0), (1550, 0), (1560, 0), (1570, 0), (1580, 0), (1590, 0), (1600, 0), (1610, 0), (1620, 0), (1630, 0), (1640, 0), (1650, 0), (1660, 0), (1670, 0), (1680, 0), (1690, 0), (1700, 0), (1710, 0), (1720, 0), (1730, 0), (1740, 0), (1750, 0), (1760, 0), (1770, 0), (1780, 0), (1790, 0), (1800, 0), (1810, 0), (1820, 0), (1830, 0), (1840, 0), (1850, 0), (1860, 0), (1870, 0), (1880, 0), (1890, 0), (1900, 0), (1910, 0), (1920, 0), (1930, 0), (1940, 0), (1950, 0), (1960, 0), (1970, 0), (1980, 0), (1990, 0), (2000, 0), (2010, 0), (2020, 0), (2030, 0), (2040, 0), (2050, 0)]
VSPARE_WEN0_0  SPARE_WEN0_0  0 PWL (0n 0.0v 9.495n 0.0v 9.505n 0.0v 19.495n 0.0v 19.505n 0.0v 29.495n 0.0v 29.505n 0.0v 39.495n 0.0v 39.505n 0.0v 49.495n 0.0v 49.505n 0.0v 59.495n 0.0v 59.505n 0.0v 69.495n 0.0v 69.505n 0.0v 79.495n 0.0v 79.505n 0.0v 89.495n 0.0v 89.505n 0.0v 99.495n 0.0v 99.505n 0.0v 109.495n 0.0v 109.505n 0.0v 119.495n 0.0v 119.505n 0.0v 129.495n 0.0v 129.505n 0.0v 139.495n 0.0v 139.505n 0.0v 149.495n 0.0v 149.505n 0.0v 159.495n 0.0v 159.505n 0.0v 169.495n 0.0v 169.505n 0.0v 179.495n 0.0v 179.505n 0.0v 189.495n 0.0v 189.505n 0.0v 199.495n 0.0v 199.505n 0.0v 209.495n 0.0v 209.505n 0.0v 219.495n 0.0v 219.505n 0.0v 229.495n 0.0v 229.505n 0.0v 239.495n 0.0v 239.505n 0.0v 249.495n 0.0v 249.505n 0.0v 259.495n 0.0v 259.505n 0.0v 269.495n 0.0v 269.505n 0.0v 279.495n 0.0v 279.505n 0.0v 289.495n 0.0v 289.505n 0.0v 299.495n 0.0v 299.505n 0.0v 309.495n 0.0v 309.505n 0.0v 319.495n 0.0v 319.505n 0.0v 329.495n 0.0v 329.505n 0.0v 339.495n 0.0v 339.505n 0.0v 349.495n 0.0v 349.505n 0.0v 359.495n 0.0v 359.505n 0.0v 369.495n 0.0v 369.505n 0.0v 379.495n 0.0v 379.505n 0.0v 389.495n 0.0v 389.505n 0.0v 399.495n 0.0v 399.505n 0.0v 409.495n 0.0v 409.505n 0.0v 419.495n 0.0v 419.505n 0.0v 429.495n 0.0v 429.505n 0.0v 439.495n 0.0v 439.505n 0.0v 449.495n 0.0v 449.505n 0.0v 459.495n 0.0v 459.505n 0.0v 469.495n 0.0v 469.505n 0.0v 479.495n 0.0v 479.505n 0.0v 489.495n 0.0v 489.505n 0.0v 499.495n 0.0v 499.505n 0.0v 509.495n 0.0v 509.505n 0.0v 519.495n 0.0v 519.505n 0.0v 529.495n 0.0v 529.505n 0.0v 539.495n 0.0v 539.505n 0.0v 549.495n 0.0v 549.505n 0.0v 559.495n 0.0v 559.505n 0.0v 569.495n 0.0v 569.505n 0.0v 579.495n 0.0v 579.505n 0.0v 589.495n 0.0v 589.505n 0.0v 599.495n 0.0v 599.505n 0.0v 609.495n 0.0v 609.505n 0.0v 619.495n 0.0v 619.505n 0.0v 629.495n 0.0v 629.505n 0.0v 639.495n 0.0v 639.505n 0.0v 649.495n 0.0v 649.505n 0.0v 659.495n 0.0v 659.505n 0.0v 669.495n 0.0v 669.505n 0.0v 679.495n 0.0v 679.505n 0.0v 689.495n 0.0v 689.505n 0.0v 699.495n 0.0v 699.505n 0.0v 709.495n 0.0v 709.505n 0.0v 719.495n 0.0v 719.505n 0.0v 729.495n 0.0v 729.505n 0.0v 739.495n 0.0v 739.505n 0.0v 749.495n 0.0v 749.505n 0.0v 759.495n 0.0v 759.505n 0.0v 769.495n 0.0v 769.505n 0.0v 779.495n 0.0v 779.505n 0.0v 789.495n 0.0v 789.505n 0.0v 799.495n 0.0v 799.505n 0.0v 809.495n 0.0v 809.505n 0.0v 819.495n 0.0v 819.505n 0.0v 829.495n 0.0v 829.505n 0.0v 839.495n 0.0v 839.505n 0.0v 849.495n 0.0v 849.505n 0.0v 859.495n 0.0v 859.505n 0.0v 869.495n 0.0v 869.505n 0.0v 879.495n 0.0v 879.505n 0.0v 889.495n 0.0v 889.505n 0.0v 899.495n 0.0v 899.505n 0.0v 909.495n 0.0v 909.505n 0.0v 919.495n 0.0v 919.505n 0.0v 929.495n 0.0v 929.505n 0.0v 939.495n 0.0v 939.505n 0.0v 949.495n 0.0v 949.505n 0.0v 959.495n 0.0v 959.505n 0.0v 969.495n 0.0v 969.505n 0.0v 979.495n 0.0v 979.505n 0.0v 989.495n 0.0v 989.505n 0.0v 999.495n 0.0v 999.505n 0.0v 1009.495n 0.0v 1009.505n 0.0v 1019.495n 0.0v 1019.505n 0.0v 1029.495n 0.0v 1029.505n 0.0v 1039.495n 0.0v 1039.505n 0.0v 1049.495n 0.0v 1049.505n 0.0v 1059.495n 0.0v 1059.505n 0.0v 1069.495n 0.0v 1069.505n 0.0v 1079.495n 0.0v 1079.505n 0.0v 1089.495n 0.0v 1089.505n 0.0v 1099.495n 0.0v 1099.505n 0.0v 1109.495n 0.0v 1109.505n 0.0v 1119.495n 0.0v 1119.505n 0.0v 1129.495n 0.0v 1129.505n 0.0v 1139.495n 0.0v 1139.505n 0.0v 1149.495n 0.0v 1149.505n 0.0v 1159.495n 0.0v 1159.505n 0.0v 1169.495n 0.0v 1169.505n 0.0v 1179.495n 0.0v 1179.505n 0.0v 1189.495n 0.0v 1189.505n 0.0v 1199.495n 0.0v 1199.505n 0.0v 1209.495n 0.0v 1209.505n 0.0v 1219.495n 0.0v 1219.505n 0.0v 1229.495n 0.0v 1229.505n 0.0v 1239.495n 0.0v 1239.505n 0.0v 1249.495n 0.0v 1249.505n 0.0v 1259.495n 0.0v 1259.505n 0.0v 1269.495n 0.0v 1269.505n 0.0v 1279.495n 0.0v 1279.505n 0.0v 1289.495n 0.0v 1289.505n 0.0v 1299.495n 0.0v 1299.505n 0.0v 1309.495n 0.0v 1309.505n 0.0v 1319.495n 0.0v 1319.505n 0.0v 1329.495n 0.0v 1329.505n 0.0v 1339.495n 0.0v 1339.505n 0.0v 1349.495n 0.0v 1349.505n 0.0v 1359.495n 0.0v 1359.505n 0.0v 1369.495n 0.0v 1369.505n 0.0v 1379.495n 0.0v 1379.505n 0.0v 1389.495n 0.0v 1389.505n 0.0v 1399.495n 0.0v 1399.505n 0.0v 1409.495n 0.0v 1409.505n 0.0v 1419.495n 0.0v 1419.505n 0.0v 1429.495n 0.0v 1429.505n 0.0v 1439.495n 0.0v 1439.505n 0.0v 1449.495n 0.0v 1449.505n 0.0v 1459.495n 0.0v 1459.505n 0.0v 1469.495n 0.0v 1469.505n 0.0v 1479.495n 0.0v 1479.505n 0.0v 1489.495n 0.0v 1489.505n 0.0v 1499.495n 0.0v 1499.505n 0.0v 1509.495n 0.0v 1509.505n 0.0v 1519.495n 0.0v 1519.505n 0.0v 1529.495n 0.0v 1529.505n 0.0v 1539.495n 0.0v 1539.505n 0.0v 1549.495n 0.0v 1549.505n 0.0v 1559.495n 0.0v 1559.505n 0.0v 1569.495n 0.0v 1569.505n 0.0v 1579.495n 0.0v 1579.505n 0.0v 1589.495n 0.0v 1589.505n 0.0v 1599.495n 0.0v 1599.505n 0.0v 1609.495n 0.0v 1609.505n 0.0v 1619.495n 0.0v 1619.505n 0.0v 1629.495n 0.0v 1629.505n 0.0v 1639.495n 0.0v 1639.505n 0.0v 1649.495n 0.0v 1649.505n 0.0v 1659.495n 0.0v 1659.505n 0.0v 1669.495n 0.0v 1669.505n 0.0v 1679.495n 0.0v 1679.505n 0.0v 1689.495n 0.0v 1689.505n 0.0v 1699.495n 0.0v 1699.505n 0.0v 1709.495n 0.0v 1709.505n 0.0v 1719.495n 0.0v 1719.505n 0.0v 1729.495n 0.0v 1729.505n 0.0v 1739.495n 0.0v 1739.505n 0.0v 1749.495n 0.0v 1749.505n 0.0v 1759.495n 0.0v 1759.505n 0.0v 1769.495n 0.0v 1769.505n 0.0v 1779.495n 0.0v 1779.505n 0.0v 1789.495n 0.0v 1789.505n 0.0v 1799.495n 0.0v 1799.505n 0.0v 1809.495n 0.0v 1809.505n 0.0v 1819.495n 0.0v 1819.505n 0.0v 1829.495n 0.0v 1829.505n 0.0v 1839.495n 0.0v 1839.505n 0.0v 1849.495n 0.0v 1849.505n 0.0v 1859.495n 0.0v 1859.505n 0.0v 1869.495n 0.0v 1869.505n 0.0v 1879.495n 0.0v 1879.505n 0.0v 1889.495n 0.0v 1889.505n 0.0v 1899.495n 0.0v 1899.505n 0.0v 1909.495n 0.0v 1909.505n 0.0v 1919.495n 0.0v 1919.505n 0.0v 1929.495n 0.0v 1929.505n 0.0v 1939.495n 0.0v 1939.505n 0.0v 1949.495n 0.0v 1949.505n 0.0v 1959.495n 0.0v 1959.505n 0.0v 1969.495n 0.0v 1969.505n 0.0v 1979.495n 0.0v 1979.505n 0.0v 1989.495n 0.0v 1989.505n 0.0v 1999.495n 0.0v 1999.505n 0.0v 2009.495n 0.0v 2009.505n 0.0v 2019.495n 0.0v 2019.505n 0.0v 2029.495n 0.0v 2029.505n 0.0v 2039.495n 0.0v 2039.505n 0.0v 2049.495n 0.0v 2049.505n 0.0v )
* PULSE: period=10
Vclk0 clk0 0 PULSE (0 1.7 9.995n 0.01n 0.01n 4.99n 10n)
* PULSE: period=10
Vclk1 clk1 0 PULSE (0 1.7 9.995n 0.01n 0.01n 4.99n 10n)

 * Generation of dout measurements
* CHECK dout1_0 vdout1_0ck4 = 1.7 time = 50
* CHECK dout1_1 vdout1_1ck4 = 1.7 time = 50
* CHECK dout1_2 vdout1_2ck4 = 1.7 time = 50
* CHECK dout1_3 vdout1_3ck4 = 1.7 time = 50
* CHECK dout1_4 vdout1_4ck4 = 1.7 time = 50
* CHECK dout1_5 vdout1_5ck4 = 0 time = 50
* CHECK dout1_6 vdout1_6ck4 = 1.7 time = 50
* CHECK dout1_7 vdout1_7ck4 = 1.7 time = 50
* CHECK dout1_8 vdout1_8ck4 = 1.7 time = 50
* CHECK dout1_9 vdout1_9ck4 = 1.7 time = 50
* CHECK dout1_10 vdout1_10ck4 = 0 time = 50
* CHECK dout1_11 vdout1_11ck4 = 1.7 time = 50
* CHECK dout1_12 vdout1_12ck4 = 0 time = 50
* CHECK dout1_13 vdout1_13ck4 = 1.7 time = 50
* CHECK dout1_14 vdout1_14ck4 = 1.7 time = 50
* CHECK dout1_15 vdout1_15ck4 = 1.7 time = 50
* CHECK dout1_16 vdout1_16ck4 = 1.7 time = 50
* CHECK dout1_17 vdout1_17ck4 = 1.7 time = 50
* CHECK dout1_18 vdout1_18ck4 = 0 time = 50
* CHECK dout1_19 vdout1_19ck4 = 1.7 time = 50
* CHECK dout1_20 vdout1_20ck4 = 0 time = 50
* CHECK dout1_21 vdout1_21ck4 = 0 time = 50
* CHECK dout1_22 vdout1_22ck4 = 1.7 time = 50
* CHECK dout1_23 vdout1_23ck4 = 0 time = 50
* CHECK dout1_24 vdout1_24ck4 = 0 time = 50
* CHECK dout1_25 vdout1_25ck4 = 1.7 time = 50
* CHECK dout1_26 vdout1_26ck4 = 1.7 time = 50
* CHECK dout1_27 vdout1_27ck4 = 0 time = 50
* CHECK dout1_28 vdout1_28ck4 = 1.7 time = 50
* CHECK dout1_29 vdout1_29ck4 = 1.7 time = 50
* CHECK dout1_30 vdout1_30ck4 = 0 time = 50
* CHECK dout1_31 vdout1_31ck4 = 0 time = 50
* CHECK dout1_32 vdout1_32ck4 = 0 time = 50
* CHECK dout1_0 vdout1_0ck6 = 1.7 time = 70
* CHECK dout1_1 vdout1_1ck6 = 1.7 time = 70
* CHECK dout1_2 vdout1_2ck6 = 1.7 time = 70
* CHECK dout1_3 vdout1_3ck6 = 1.7 time = 70
* CHECK dout1_4 vdout1_4ck6 = 1.7 time = 70
* CHECK dout1_5 vdout1_5ck6 = 0 time = 70
* CHECK dout1_6 vdout1_6ck6 = 1.7 time = 70
* CHECK dout1_7 vdout1_7ck6 = 1.7 time = 70
* CHECK dout1_8 vdout1_8ck6 = 1.7 time = 70
* CHECK dout1_9 vdout1_9ck6 = 1.7 time = 70
* CHECK dout1_10 vdout1_10ck6 = 0 time = 70
* CHECK dout1_11 vdout1_11ck6 = 1.7 time = 70
* CHECK dout1_12 vdout1_12ck6 = 0 time = 70
* CHECK dout1_13 vdout1_13ck6 = 1.7 time = 70
* CHECK dout1_14 vdout1_14ck6 = 1.7 time = 70
* CHECK dout1_15 vdout1_15ck6 = 1.7 time = 70
* CHECK dout1_16 vdout1_16ck6 = 1.7 time = 70
* CHECK dout1_17 vdout1_17ck6 = 1.7 time = 70
* CHECK dout1_18 vdout1_18ck6 = 0 time = 70
* CHECK dout1_19 vdout1_19ck6 = 1.7 time = 70
* CHECK dout1_20 vdout1_20ck6 = 0 time = 70
* CHECK dout1_21 vdout1_21ck6 = 0 time = 70
* CHECK dout1_22 vdout1_22ck6 = 1.7 time = 70
* CHECK dout1_23 vdout1_23ck6 = 0 time = 70
* CHECK dout1_24 vdout1_24ck6 = 0 time = 70
* CHECK dout1_25 vdout1_25ck6 = 1.7 time = 70
* CHECK dout1_26 vdout1_26ck6 = 1.7 time = 70
* CHECK dout1_27 vdout1_27ck6 = 0 time = 70
* CHECK dout1_28 vdout1_28ck6 = 1.7 time = 70
* CHECK dout1_29 vdout1_29ck6 = 1.7 time = 70
* CHECK dout1_30 vdout1_30ck6 = 0 time = 70
* CHECK dout1_31 vdout1_31ck6 = 0 time = 70
* CHECK dout1_32 vdout1_32ck6 = 0 time = 70
* CHECK dout1_0 vdout1_0ck8 = 0 time = 90
* CHECK dout1_1 vdout1_1ck8 = 0 time = 90
* CHECK dout1_2 vdout1_2ck8 = 1.7 time = 90
* CHECK dout1_3 vdout1_3ck8 = 1.7 time = 90
* CHECK dout1_4 vdout1_4ck8 = 0 time = 90
* CHECK dout1_5 vdout1_5ck8 = 1.7 time = 90
* CHECK dout1_6 vdout1_6ck8 = 0 time = 90
* CHECK dout1_7 vdout1_7ck8 = 0 time = 90
* CHECK dout1_8 vdout1_8ck8 = 0 time = 90
* CHECK dout1_9 vdout1_9ck8 = 1.7 time = 90
* CHECK dout1_10 vdout1_10ck8 = 1.7 time = 90
* CHECK dout1_11 vdout1_11ck8 = 0 time = 90
* CHECK dout1_12 vdout1_12ck8 = 1.7 time = 90
* CHECK dout1_13 vdout1_13ck8 = 0 time = 90
* CHECK dout1_14 vdout1_14ck8 = 1.7 time = 90
* CHECK dout1_15 vdout1_15ck8 = 1.7 time = 90
* CHECK dout1_16 vdout1_16ck8 = 1.7 time = 90
* CHECK dout1_17 vdout1_17ck8 = 1.7 time = 90
* CHECK dout1_18 vdout1_18ck8 = 0 time = 90
* CHECK dout1_19 vdout1_19ck8 = 1.7 time = 90
* CHECK dout1_20 vdout1_20ck8 = 0 time = 90
* CHECK dout1_21 vdout1_21ck8 = 1.7 time = 90
* CHECK dout1_22 vdout1_22ck8 = 1.7 time = 90
* CHECK dout1_23 vdout1_23ck8 = 1.7 time = 90
* CHECK dout1_24 vdout1_24ck8 = 1.7 time = 90
* CHECK dout1_25 vdout1_25ck8 = 1.7 time = 90
* CHECK dout1_26 vdout1_26ck8 = 1.7 time = 90
* CHECK dout1_27 vdout1_27ck8 = 0 time = 90
* CHECK dout1_28 vdout1_28ck8 = 1.7 time = 90
* CHECK dout1_29 vdout1_29ck8 = 1.7 time = 90
* CHECK dout1_30 vdout1_30ck8 = 0 time = 90
* CHECK dout1_31 vdout1_31ck8 = 0 time = 90
* CHECK dout1_32 vdout1_32ck8 = 0 time = 90
* CHECK dout1_0 vdout1_0ck9 = 0 time = 100
* CHECK dout1_1 vdout1_1ck9 = 0 time = 100
* CHECK dout1_2 vdout1_2ck9 = 1.7 time = 100
* CHECK dout1_3 vdout1_3ck9 = 1.7 time = 100
* CHECK dout1_4 vdout1_4ck9 = 0 time = 100
* CHECK dout1_5 vdout1_5ck9 = 1.7 time = 100
* CHECK dout1_6 vdout1_6ck9 = 0 time = 100
* CHECK dout1_7 vdout1_7ck9 = 0 time = 100
* CHECK dout1_8 vdout1_8ck9 = 0 time = 100
* CHECK dout1_9 vdout1_9ck9 = 1.7 time = 100
* CHECK dout1_10 vdout1_10ck9 = 1.7 time = 100
* CHECK dout1_11 vdout1_11ck9 = 0 time = 100
* CHECK dout1_12 vdout1_12ck9 = 1.7 time = 100
* CHECK dout1_13 vdout1_13ck9 = 0 time = 100
* CHECK dout1_14 vdout1_14ck9 = 1.7 time = 100
* CHECK dout1_15 vdout1_15ck9 = 1.7 time = 100
* CHECK dout1_16 vdout1_16ck9 = 1.7 time = 100
* CHECK dout1_17 vdout1_17ck9 = 1.7 time = 100
* CHECK dout1_18 vdout1_18ck9 = 0 time = 100
* CHECK dout1_19 vdout1_19ck9 = 1.7 time = 100
* CHECK dout1_20 vdout1_20ck9 = 0 time = 100
* CHECK dout1_21 vdout1_21ck9 = 1.7 time = 100
* CHECK dout1_22 vdout1_22ck9 = 1.7 time = 100
* CHECK dout1_23 vdout1_23ck9 = 1.7 time = 100
* CHECK dout1_24 vdout1_24ck9 = 1.7 time = 100
* CHECK dout1_25 vdout1_25ck9 = 1.7 time = 100
* CHECK dout1_26 vdout1_26ck9 = 1.7 time = 100
* CHECK dout1_27 vdout1_27ck9 = 0 time = 100
* CHECK dout1_28 vdout1_28ck9 = 1.7 time = 100
* CHECK dout1_29 vdout1_29ck9 = 1.7 time = 100
* CHECK dout1_30 vdout1_30ck9 = 0 time = 100
* CHECK dout1_31 vdout1_31ck9 = 0 time = 100
* CHECK dout1_32 vdout1_32ck9 = 0 time = 100
* CHECK dout1_0 vdout1_0ck10 = 0 time = 110
* CHECK dout1_1 vdout1_1ck10 = 0 time = 110
* CHECK dout1_2 vdout1_2ck10 = 1.7 time = 110
* CHECK dout1_3 vdout1_3ck10 = 1.7 time = 110
* CHECK dout1_4 vdout1_4ck10 = 0 time = 110
* CHECK dout1_5 vdout1_5ck10 = 1.7 time = 110
* CHECK dout1_6 vdout1_6ck10 = 0 time = 110
* CHECK dout1_7 vdout1_7ck10 = 0 time = 110
* CHECK dout1_8 vdout1_8ck10 = 0 time = 110
* CHECK dout1_9 vdout1_9ck10 = 1.7 time = 110
* CHECK dout1_10 vdout1_10ck10 = 1.7 time = 110
* CHECK dout1_11 vdout1_11ck10 = 0 time = 110
* CHECK dout1_12 vdout1_12ck10 = 1.7 time = 110
* CHECK dout1_13 vdout1_13ck10 = 0 time = 110
* CHECK dout1_14 vdout1_14ck10 = 1.7 time = 110
* CHECK dout1_15 vdout1_15ck10 = 1.7 time = 110
* CHECK dout1_16 vdout1_16ck10 = 1.7 time = 110
* CHECK dout1_17 vdout1_17ck10 = 1.7 time = 110
* CHECK dout1_18 vdout1_18ck10 = 0 time = 110
* CHECK dout1_19 vdout1_19ck10 = 1.7 time = 110
* CHECK dout1_20 vdout1_20ck10 = 0 time = 110
* CHECK dout1_21 vdout1_21ck10 = 1.7 time = 110
* CHECK dout1_22 vdout1_22ck10 = 1.7 time = 110
* CHECK dout1_23 vdout1_23ck10 = 1.7 time = 110
* CHECK dout1_24 vdout1_24ck10 = 1.7 time = 110
* CHECK dout1_25 vdout1_25ck10 = 1.7 time = 110
* CHECK dout1_26 vdout1_26ck10 = 1.7 time = 110
* CHECK dout1_27 vdout1_27ck10 = 0 time = 110
* CHECK dout1_28 vdout1_28ck10 = 1.7 time = 110
* CHECK dout1_29 vdout1_29ck10 = 1.7 time = 110
* CHECK dout1_30 vdout1_30ck10 = 0 time = 110
* CHECK dout1_31 vdout1_31ck10 = 0 time = 110
* CHECK dout1_32 vdout1_32ck10 = 0 time = 110
* CHECK dout1_0 vdout1_0ck11 = 0 time = 120
* CHECK dout1_1 vdout1_1ck11 = 0 time = 120
* CHECK dout1_2 vdout1_2ck11 = 1.7 time = 120
* CHECK dout1_3 vdout1_3ck11 = 1.7 time = 120
* CHECK dout1_4 vdout1_4ck11 = 0 time = 120
* CHECK dout1_5 vdout1_5ck11 = 1.7 time = 120
* CHECK dout1_6 vdout1_6ck11 = 0 time = 120
* CHECK dout1_7 vdout1_7ck11 = 0 time = 120
* CHECK dout1_8 vdout1_8ck11 = 0 time = 120
* CHECK dout1_9 vdout1_9ck11 = 1.7 time = 120
* CHECK dout1_10 vdout1_10ck11 = 1.7 time = 120
* CHECK dout1_11 vdout1_11ck11 = 0 time = 120
* CHECK dout1_12 vdout1_12ck11 = 1.7 time = 120
* CHECK dout1_13 vdout1_13ck11 = 0 time = 120
* CHECK dout1_14 vdout1_14ck11 = 1.7 time = 120
* CHECK dout1_15 vdout1_15ck11 = 1.7 time = 120
* CHECK dout1_16 vdout1_16ck11 = 1.7 time = 120
* CHECK dout1_17 vdout1_17ck11 = 1.7 time = 120
* CHECK dout1_18 vdout1_18ck11 = 0 time = 120
* CHECK dout1_19 vdout1_19ck11 = 1.7 time = 120
* CHECK dout1_20 vdout1_20ck11 = 0 time = 120
* CHECK dout1_21 vdout1_21ck11 = 1.7 time = 120
* CHECK dout1_22 vdout1_22ck11 = 1.7 time = 120
* CHECK dout1_23 vdout1_23ck11 = 1.7 time = 120
* CHECK dout1_24 vdout1_24ck11 = 1.7 time = 120
* CHECK dout1_25 vdout1_25ck11 = 1.7 time = 120
* CHECK dout1_26 vdout1_26ck11 = 1.7 time = 120
* CHECK dout1_27 vdout1_27ck11 = 0 time = 120
* CHECK dout1_28 vdout1_28ck11 = 1.7 time = 120
* CHECK dout1_29 vdout1_29ck11 = 1.7 time = 120
* CHECK dout1_30 vdout1_30ck11 = 0 time = 120
* CHECK dout1_31 vdout1_31ck11 = 0 time = 120
* CHECK dout1_32 vdout1_32ck11 = 0 time = 120
* CHECK dout1_0 vdout1_0ck12 = 0 time = 130
* CHECK dout1_1 vdout1_1ck12 = 0 time = 130
* CHECK dout1_2 vdout1_2ck12 = 1.7 time = 130
* CHECK dout1_3 vdout1_3ck12 = 1.7 time = 130
* CHECK dout1_4 vdout1_4ck12 = 0 time = 130
* CHECK dout1_5 vdout1_5ck12 = 1.7 time = 130
* CHECK dout1_6 vdout1_6ck12 = 0 time = 130
* CHECK dout1_7 vdout1_7ck12 = 0 time = 130
* CHECK dout1_8 vdout1_8ck12 = 0 time = 130
* CHECK dout1_9 vdout1_9ck12 = 1.7 time = 130
* CHECK dout1_10 vdout1_10ck12 = 1.7 time = 130
* CHECK dout1_11 vdout1_11ck12 = 0 time = 130
* CHECK dout1_12 vdout1_12ck12 = 1.7 time = 130
* CHECK dout1_13 vdout1_13ck12 = 0 time = 130
* CHECK dout1_14 vdout1_14ck12 = 1.7 time = 130
* CHECK dout1_15 vdout1_15ck12 = 1.7 time = 130
* CHECK dout1_16 vdout1_16ck12 = 1.7 time = 130
* CHECK dout1_17 vdout1_17ck12 = 1.7 time = 130
* CHECK dout1_18 vdout1_18ck12 = 0 time = 130
* CHECK dout1_19 vdout1_19ck12 = 1.7 time = 130
* CHECK dout1_20 vdout1_20ck12 = 0 time = 130
* CHECK dout1_21 vdout1_21ck12 = 1.7 time = 130
* CHECK dout1_22 vdout1_22ck12 = 1.7 time = 130
* CHECK dout1_23 vdout1_23ck12 = 1.7 time = 130
* CHECK dout1_24 vdout1_24ck12 = 1.7 time = 130
* CHECK dout1_25 vdout1_25ck12 = 1.7 time = 130
* CHECK dout1_26 vdout1_26ck12 = 1.7 time = 130
* CHECK dout1_27 vdout1_27ck12 = 0 time = 130
* CHECK dout1_28 vdout1_28ck12 = 1.7 time = 130
* CHECK dout1_29 vdout1_29ck12 = 1.7 time = 130
* CHECK dout1_30 vdout1_30ck12 = 0 time = 130
* CHECK dout1_31 vdout1_31ck12 = 0 time = 130
* CHECK dout1_32 vdout1_32ck12 = 0 time = 130
* CHECK dout1_0 vdout1_0ck15 = 1.7 time = 160
* CHECK dout1_1 vdout1_1ck15 = 0 time = 160
* CHECK dout1_2 vdout1_2ck15 = 0 time = 160
* CHECK dout1_3 vdout1_3ck15 = 0 time = 160
* CHECK dout1_4 vdout1_4ck15 = 1.7 time = 160
* CHECK dout1_5 vdout1_5ck15 = 0 time = 160
* CHECK dout1_6 vdout1_6ck15 = 0 time = 160
* CHECK dout1_7 vdout1_7ck15 = 1.7 time = 160
* CHECK dout1_8 vdout1_8ck15 = 0 time = 160
* CHECK dout1_9 vdout1_9ck15 = 0 time = 160
* CHECK dout1_10 vdout1_10ck15 = 0 time = 160
* CHECK dout1_11 vdout1_11ck15 = 0 time = 160
* CHECK dout1_12 vdout1_12ck15 = 1.7 time = 160
* CHECK dout1_13 vdout1_13ck15 = 0 time = 160
* CHECK dout1_14 vdout1_14ck15 = 1.7 time = 160
* CHECK dout1_15 vdout1_15ck15 = 0 time = 160
* CHECK dout1_16 vdout1_16ck15 = 0 time = 160
* CHECK dout1_17 vdout1_17ck15 = 1.7 time = 160
* CHECK dout1_18 vdout1_18ck15 = 1.7 time = 160
* CHECK dout1_19 vdout1_19ck15 = 1.7 time = 160
* CHECK dout1_20 vdout1_20ck15 = 0 time = 160
* CHECK dout1_21 vdout1_21ck15 = 1.7 time = 160
* CHECK dout1_22 vdout1_22ck15 = 0 time = 160
* CHECK dout1_23 vdout1_23ck15 = 1.7 time = 160
* CHECK dout1_24 vdout1_24ck15 = 1.7 time = 160
* CHECK dout1_25 vdout1_25ck15 = 1.7 time = 160
* CHECK dout1_26 vdout1_26ck15 = 1.7 time = 160
* CHECK dout1_27 vdout1_27ck15 = 0 time = 160
* CHECK dout1_28 vdout1_28ck15 = 0 time = 160
* CHECK dout1_29 vdout1_29ck15 = 1.7 time = 160
* CHECK dout1_30 vdout1_30ck15 = 1.7 time = 160
* CHECK dout1_31 vdout1_31ck15 = 0 time = 160
* CHECK dout1_32 vdout1_32ck15 = 0 time = 160
* CHECK dout1_0 vdout1_0ck20 = 0 time = 210
* CHECK dout1_1 vdout1_1ck20 = 1.7 time = 210
* CHECK dout1_2 vdout1_2ck20 = 0 time = 210
* CHECK dout1_3 vdout1_3ck20 = 1.7 time = 210
* CHECK dout1_4 vdout1_4ck20 = 0 time = 210
* CHECK dout1_5 vdout1_5ck20 = 1.7 time = 210
* CHECK dout1_6 vdout1_6ck20 = 0 time = 210
* CHECK dout1_7 vdout1_7ck20 = 1.7 time = 210
* CHECK dout1_8 vdout1_8ck20 = 1.7 time = 210
* CHECK dout1_9 vdout1_9ck20 = 0 time = 210
* CHECK dout1_10 vdout1_10ck20 = 1.7 time = 210
* CHECK dout1_11 vdout1_11ck20 = 0 time = 210
* CHECK dout1_12 vdout1_12ck20 = 1.7 time = 210
* CHECK dout1_13 vdout1_13ck20 = 0 time = 210
* CHECK dout1_14 vdout1_14ck20 = 1.7 time = 210
* CHECK dout1_15 vdout1_15ck20 = 0 time = 210
* CHECK dout1_16 vdout1_16ck20 = 0 time = 210
* CHECK dout1_17 vdout1_17ck20 = 0 time = 210
* CHECK dout1_18 vdout1_18ck20 = 0 time = 210
* CHECK dout1_19 vdout1_19ck20 = 1.7 time = 210
* CHECK dout1_20 vdout1_20ck20 = 1.7 time = 210
* CHECK dout1_21 vdout1_21ck20 = 0 time = 210
* CHECK dout1_22 vdout1_22ck20 = 1.7 time = 210
* CHECK dout1_23 vdout1_23ck20 = 0 time = 210
* CHECK dout1_24 vdout1_24ck20 = 1.7 time = 210
* CHECK dout1_25 vdout1_25ck20 = 1.7 time = 210
* CHECK dout1_26 vdout1_26ck20 = 0 time = 210
* CHECK dout1_27 vdout1_27ck20 = 1.7 time = 210
* CHECK dout1_28 vdout1_28ck20 = 0 time = 210
* CHECK dout1_29 vdout1_29ck20 = 1.7 time = 210
* CHECK dout1_30 vdout1_30ck20 = 0 time = 210
* CHECK dout1_31 vdout1_31ck20 = 0 time = 210
* CHECK dout1_32 vdout1_32ck20 = 0 time = 210
* CHECK dout1_0 vdout1_0ck25 = 1.7 time = 260
* CHECK dout1_1 vdout1_1ck25 = 1.7 time = 260
* CHECK dout1_2 vdout1_2ck25 = 1.7 time = 260
* CHECK dout1_3 vdout1_3ck25 = 0 time = 260
* CHECK dout1_4 vdout1_4ck25 = 1.7 time = 260
* CHECK dout1_5 vdout1_5ck25 = 1.7 time = 260
* CHECK dout1_6 vdout1_6ck25 = 0 time = 260
* CHECK dout1_7 vdout1_7ck25 = 1.7 time = 260
* CHECK dout1_8 vdout1_8ck25 = 0 time = 260
* CHECK dout1_9 vdout1_9ck25 = 0 time = 260
* CHECK dout1_10 vdout1_10ck25 = 1.7 time = 260
* CHECK dout1_11 vdout1_11ck25 = 1.7 time = 260
* CHECK dout1_12 vdout1_12ck25 = 1.7 time = 260
* CHECK dout1_13 vdout1_13ck25 = 0 time = 260
* CHECK dout1_14 vdout1_14ck25 = 1.7 time = 260
* CHECK dout1_15 vdout1_15ck25 = 1.7 time = 260
* CHECK dout1_16 vdout1_16ck25 = 1.7 time = 260
* CHECK dout1_17 vdout1_17ck25 = 1.7 time = 260
* CHECK dout1_18 vdout1_18ck25 = 0 time = 260
* CHECK dout1_19 vdout1_19ck25 = 1.7 time = 260
* CHECK dout1_20 vdout1_20ck25 = 0 time = 260
* CHECK dout1_21 vdout1_21ck25 = 1.7 time = 260
* CHECK dout1_22 vdout1_22ck25 = 0 time = 260
* CHECK dout1_23 vdout1_23ck25 = 0 time = 260
* CHECK dout1_24 vdout1_24ck25 = 1.7 time = 260
* CHECK dout1_25 vdout1_25ck25 = 0 time = 260
* CHECK dout1_26 vdout1_26ck25 = 1.7 time = 260
* CHECK dout1_27 vdout1_27ck25 = 0 time = 260
* CHECK dout1_28 vdout1_28ck25 = 1.7 time = 260
* CHECK dout1_29 vdout1_29ck25 = 0 time = 260
* CHECK dout1_30 vdout1_30ck25 = 0 time = 260
* CHECK dout1_31 vdout1_31ck25 = 1.7 time = 260
* CHECK dout1_32 vdout1_32ck25 = 0 time = 260
* CHECK dout1_0 vdout1_0ck26 = 0 time = 270
* CHECK dout1_1 vdout1_1ck26 = 0 time = 270
* CHECK dout1_2 vdout1_2ck26 = 0 time = 270
* CHECK dout1_3 vdout1_3ck26 = 1.7 time = 270
* CHECK dout1_4 vdout1_4ck26 = 0 time = 270
* CHECK dout1_5 vdout1_5ck26 = 0 time = 270
* CHECK dout1_6 vdout1_6ck26 = 1.7 time = 270
* CHECK dout1_7 vdout1_7ck26 = 1.7 time = 270
* CHECK dout1_8 vdout1_8ck26 = 1.7 time = 270
* CHECK dout1_9 vdout1_9ck26 = 1.7 time = 270
* CHECK dout1_10 vdout1_10ck26 = 0 time = 270
* CHECK dout1_11 vdout1_11ck26 = 0 time = 270
* CHECK dout1_12 vdout1_12ck26 = 0 time = 270
* CHECK dout1_13 vdout1_13ck26 = 0 time = 270
* CHECK dout1_14 vdout1_14ck26 = 1.7 time = 270
* CHECK dout1_15 vdout1_15ck26 = 0 time = 270
* CHECK dout1_16 vdout1_16ck26 = 0 time = 270
* CHECK dout1_17 vdout1_17ck26 = 0 time = 270
* CHECK dout1_18 vdout1_18ck26 = 0 time = 270
* CHECK dout1_19 vdout1_19ck26 = 1.7 time = 270
* CHECK dout1_20 vdout1_20ck26 = 0 time = 270
* CHECK dout1_21 vdout1_21ck26 = 0 time = 270
* CHECK dout1_22 vdout1_22ck26 = 1.7 time = 270
* CHECK dout1_23 vdout1_23ck26 = 1.7 time = 270
* CHECK dout1_24 vdout1_24ck26 = 0 time = 270
* CHECK dout1_25 vdout1_25ck26 = 0 time = 270
* CHECK dout1_26 vdout1_26ck26 = 1.7 time = 270
* CHECK dout1_27 vdout1_27ck26 = 1.7 time = 270
* CHECK dout1_28 vdout1_28ck26 = 1.7 time = 270
* CHECK dout1_29 vdout1_29ck26 = 1.7 time = 270
* CHECK dout1_30 vdout1_30ck26 = 0 time = 270
* CHECK dout1_31 vdout1_31ck26 = 1.7 time = 270
* CHECK dout1_32 vdout1_32ck26 = 0 time = 270
* CHECK dout1_0 vdout1_0ck28 = 1.7 time = 290
* CHECK dout1_1 vdout1_1ck28 = 1.7 time = 290
* CHECK dout1_2 vdout1_2ck28 = 0 time = 290
* CHECK dout1_3 vdout1_3ck28 = 1.7 time = 290
* CHECK dout1_4 vdout1_4ck28 = 1.7 time = 290
* CHECK dout1_5 vdout1_5ck28 = 0 time = 290
* CHECK dout1_6 vdout1_6ck28 = 0 time = 290
* CHECK dout1_7 vdout1_7ck28 = 1.7 time = 290
* CHECK dout1_8 vdout1_8ck28 = 1.7 time = 290
* CHECK dout1_9 vdout1_9ck28 = 0 time = 290
* CHECK dout1_10 vdout1_10ck28 = 1.7 time = 290
* CHECK dout1_11 vdout1_11ck28 = 1.7 time = 290
* CHECK dout1_12 vdout1_12ck28 = 0 time = 290
* CHECK dout1_13 vdout1_13ck28 = 1.7 time = 290
* CHECK dout1_14 vdout1_14ck28 = 0 time = 290
* CHECK dout1_15 vdout1_15ck28 = 1.7 time = 290
* CHECK dout1_16 vdout1_16ck28 = 0 time = 290
* CHECK dout1_17 vdout1_17ck28 = 0 time = 290
* CHECK dout1_18 vdout1_18ck28 = 1.7 time = 290
* CHECK dout1_19 vdout1_19ck28 = 1.7 time = 290
* CHECK dout1_20 vdout1_20ck28 = 1.7 time = 290
* CHECK dout1_21 vdout1_21ck28 = 1.7 time = 290
* CHECK dout1_22 vdout1_22ck28 = 0 time = 290
* CHECK dout1_23 vdout1_23ck28 = 1.7 time = 290
* CHECK dout1_24 vdout1_24ck28 = 0 time = 290
* CHECK dout1_25 vdout1_25ck28 = 0 time = 290
* CHECK dout1_26 vdout1_26ck28 = 0 time = 290
* CHECK dout1_27 vdout1_27ck28 = 0 time = 290
* CHECK dout1_28 vdout1_28ck28 = 1.7 time = 290
* CHECK dout1_29 vdout1_29ck28 = 0 time = 290
* CHECK dout1_30 vdout1_30ck28 = 0 time = 290
* CHECK dout1_31 vdout1_31ck28 = 0 time = 290
* CHECK dout1_32 vdout1_32ck28 = 0 time = 290
* CHECK dout1_0 vdout1_0ck29 = 1.7 time = 300
* CHECK dout1_1 vdout1_1ck29 = 1.7 time = 300
* CHECK dout1_2 vdout1_2ck29 = 1.7 time = 300
* CHECK dout1_3 vdout1_3ck29 = 0 time = 300
* CHECK dout1_4 vdout1_4ck29 = 1.7 time = 300
* CHECK dout1_5 vdout1_5ck29 = 1.7 time = 300
* CHECK dout1_6 vdout1_6ck29 = 0 time = 300
* CHECK dout1_7 vdout1_7ck29 = 1.7 time = 300
* CHECK dout1_8 vdout1_8ck29 = 0 time = 300
* CHECK dout1_9 vdout1_9ck29 = 0 time = 300
* CHECK dout1_10 vdout1_10ck29 = 1.7 time = 300
* CHECK dout1_11 vdout1_11ck29 = 1.7 time = 300
* CHECK dout1_12 vdout1_12ck29 = 1.7 time = 300
* CHECK dout1_13 vdout1_13ck29 = 0 time = 300
* CHECK dout1_14 vdout1_14ck29 = 1.7 time = 300
* CHECK dout1_15 vdout1_15ck29 = 1.7 time = 300
* CHECK dout1_16 vdout1_16ck29 = 1.7 time = 300
* CHECK dout1_17 vdout1_17ck29 = 1.7 time = 300
* CHECK dout1_18 vdout1_18ck29 = 0 time = 300
* CHECK dout1_19 vdout1_19ck29 = 1.7 time = 300
* CHECK dout1_20 vdout1_20ck29 = 0 time = 300
* CHECK dout1_21 vdout1_21ck29 = 1.7 time = 300
* CHECK dout1_22 vdout1_22ck29 = 0 time = 300
* CHECK dout1_23 vdout1_23ck29 = 0 time = 300
* CHECK dout1_24 vdout1_24ck29 = 1.7 time = 300
* CHECK dout1_25 vdout1_25ck29 = 0 time = 300
* CHECK dout1_26 vdout1_26ck29 = 1.7 time = 300
* CHECK dout1_27 vdout1_27ck29 = 0 time = 300
* CHECK dout1_28 vdout1_28ck29 = 1.7 time = 300
* CHECK dout1_29 vdout1_29ck29 = 0 time = 300
* CHECK dout1_30 vdout1_30ck29 = 0 time = 300
* CHECK dout1_31 vdout1_31ck29 = 1.7 time = 300
* CHECK dout1_32 vdout1_32ck29 = 0 time = 300
* CHECK dout1_0 vdout1_0ck30 = 1.7 time = 310
* CHECK dout1_1 vdout1_1ck30 = 1.7 time = 310
* CHECK dout1_2 vdout1_2ck30 = 0 time = 310
* CHECK dout1_3 vdout1_3ck30 = 1.7 time = 310
* CHECK dout1_4 vdout1_4ck30 = 1.7 time = 310
* CHECK dout1_5 vdout1_5ck30 = 0 time = 310
* CHECK dout1_6 vdout1_6ck30 = 0 time = 310
* CHECK dout1_7 vdout1_7ck30 = 1.7 time = 310
* CHECK dout1_8 vdout1_8ck30 = 1.7 time = 310
* CHECK dout1_9 vdout1_9ck30 = 0 time = 310
* CHECK dout1_10 vdout1_10ck30 = 1.7 time = 310
* CHECK dout1_11 vdout1_11ck30 = 1.7 time = 310
* CHECK dout1_12 vdout1_12ck30 = 0 time = 310
* CHECK dout1_13 vdout1_13ck30 = 1.7 time = 310
* CHECK dout1_14 vdout1_14ck30 = 0 time = 310
* CHECK dout1_15 vdout1_15ck30 = 1.7 time = 310
* CHECK dout1_16 vdout1_16ck30 = 0 time = 310
* CHECK dout1_17 vdout1_17ck30 = 0 time = 310
* CHECK dout1_18 vdout1_18ck30 = 1.7 time = 310
* CHECK dout1_19 vdout1_19ck30 = 1.7 time = 310
* CHECK dout1_20 vdout1_20ck30 = 1.7 time = 310
* CHECK dout1_21 vdout1_21ck30 = 1.7 time = 310
* CHECK dout1_22 vdout1_22ck30 = 0 time = 310
* CHECK dout1_23 vdout1_23ck30 = 1.7 time = 310
* CHECK dout1_24 vdout1_24ck30 = 0 time = 310
* CHECK dout1_25 vdout1_25ck30 = 0 time = 310
* CHECK dout1_26 vdout1_26ck30 = 0 time = 310
* CHECK dout1_27 vdout1_27ck30 = 0 time = 310
* CHECK dout1_28 vdout1_28ck30 = 1.7 time = 310
* CHECK dout1_29 vdout1_29ck30 = 0 time = 310
* CHECK dout1_30 vdout1_30ck30 = 0 time = 310
* CHECK dout1_31 vdout1_31ck30 = 0 time = 310
* CHECK dout1_32 vdout1_32ck30 = 0 time = 310
* CHECK dout1_0 vdout1_0ck34 = 1.7 time = 350
* CHECK dout1_1 vdout1_1ck34 = 0 time = 350
* CHECK dout1_2 vdout1_2ck34 = 0 time = 350
* CHECK dout1_3 vdout1_3ck34 = 0 time = 350
* CHECK dout1_4 vdout1_4ck34 = 0 time = 350
* CHECK dout1_5 vdout1_5ck34 = 1.7 time = 350
* CHECK dout1_6 vdout1_6ck34 = 1.7 time = 350
* CHECK dout1_7 vdout1_7ck34 = 1.7 time = 350
* CHECK dout1_8 vdout1_8ck34 = 1.7 time = 350
* CHECK dout1_9 vdout1_9ck34 = 0 time = 350
* CHECK dout1_10 vdout1_10ck34 = 1.7 time = 350
* CHECK dout1_11 vdout1_11ck34 = 1.7 time = 350
* CHECK dout1_12 vdout1_12ck34 = 1.7 time = 350
* CHECK dout1_13 vdout1_13ck34 = 1.7 time = 350
* CHECK dout1_14 vdout1_14ck34 = 0 time = 350
* CHECK dout1_15 vdout1_15ck34 = 0 time = 350
* CHECK dout1_16 vdout1_16ck34 = 0 time = 350
* CHECK dout1_17 vdout1_17ck34 = 1.7 time = 350
* CHECK dout1_18 vdout1_18ck34 = 1.7 time = 350
* CHECK dout1_19 vdout1_19ck34 = 1.7 time = 350
* CHECK dout1_20 vdout1_20ck34 = 0 time = 350
* CHECK dout1_21 vdout1_21ck34 = 0 time = 350
* CHECK dout1_22 vdout1_22ck34 = 0 time = 350
* CHECK dout1_23 vdout1_23ck34 = 0 time = 350
* CHECK dout1_24 vdout1_24ck34 = 1.7 time = 350
* CHECK dout1_25 vdout1_25ck34 = 0 time = 350
* CHECK dout1_26 vdout1_26ck34 = 1.7 time = 350
* CHECK dout1_27 vdout1_27ck34 = 0 time = 350
* CHECK dout1_28 vdout1_28ck34 = 1.7 time = 350
* CHECK dout1_29 vdout1_29ck34 = 1.7 time = 350
* CHECK dout1_30 vdout1_30ck34 = 1.7 time = 350
* CHECK dout1_31 vdout1_31ck34 = 1.7 time = 350
* CHECK dout1_32 vdout1_32ck34 = 0 time = 350
* CHECK dout1_0 vdout1_0ck37 = 1.7 time = 380
* CHECK dout1_1 vdout1_1ck37 = 0 time = 380
* CHECK dout1_2 vdout1_2ck37 = 0 time = 380
* CHECK dout1_3 vdout1_3ck37 = 0 time = 380
* CHECK dout1_4 vdout1_4ck37 = 0 time = 380
* CHECK dout1_5 vdout1_5ck37 = 1.7 time = 380
* CHECK dout1_6 vdout1_6ck37 = 1.7 time = 380
* CHECK dout1_7 vdout1_7ck37 = 1.7 time = 380
* CHECK dout1_8 vdout1_8ck37 = 1.7 time = 380
* CHECK dout1_9 vdout1_9ck37 = 0 time = 380
* CHECK dout1_10 vdout1_10ck37 = 1.7 time = 380
* CHECK dout1_11 vdout1_11ck37 = 1.7 time = 380
* CHECK dout1_12 vdout1_12ck37 = 1.7 time = 380
* CHECK dout1_13 vdout1_13ck37 = 1.7 time = 380
* CHECK dout1_14 vdout1_14ck37 = 0 time = 380
* CHECK dout1_15 vdout1_15ck37 = 0 time = 380
* CHECK dout1_16 vdout1_16ck37 = 0 time = 380
* CHECK dout1_17 vdout1_17ck37 = 1.7 time = 380
* CHECK dout1_18 vdout1_18ck37 = 1.7 time = 380
* CHECK dout1_19 vdout1_19ck37 = 1.7 time = 380
* CHECK dout1_20 vdout1_20ck37 = 0 time = 380
* CHECK dout1_21 vdout1_21ck37 = 0 time = 380
* CHECK dout1_22 vdout1_22ck37 = 0 time = 380
* CHECK dout1_23 vdout1_23ck37 = 0 time = 380
* CHECK dout1_24 vdout1_24ck37 = 1.7 time = 380
* CHECK dout1_25 vdout1_25ck37 = 0 time = 380
* CHECK dout1_26 vdout1_26ck37 = 1.7 time = 380
* CHECK dout1_27 vdout1_27ck37 = 0 time = 380
* CHECK dout1_28 vdout1_28ck37 = 1.7 time = 380
* CHECK dout1_29 vdout1_29ck37 = 1.7 time = 380
* CHECK dout1_30 vdout1_30ck37 = 1.7 time = 380
* CHECK dout1_31 vdout1_31ck37 = 1.7 time = 380
* CHECK dout1_32 vdout1_32ck37 = 0 time = 380
* CHECK dout1_0 vdout1_0ck39 = 0 time = 400
* CHECK dout1_1 vdout1_1ck39 = 0 time = 400
* CHECK dout1_2 vdout1_2ck39 = 0 time = 400
* CHECK dout1_3 vdout1_3ck39 = 0 time = 400
* CHECK dout1_4 vdout1_4ck39 = 1.7 time = 400
* CHECK dout1_5 vdout1_5ck39 = 0 time = 400
* CHECK dout1_6 vdout1_6ck39 = 1.7 time = 400
* CHECK dout1_7 vdout1_7ck39 = 0 time = 400
* CHECK dout1_8 vdout1_8ck39 = 0 time = 400
* CHECK dout1_9 vdout1_9ck39 = 0 time = 400
* CHECK dout1_10 vdout1_10ck39 = 0 time = 400
* CHECK dout1_11 vdout1_11ck39 = 1.7 time = 400
* CHECK dout1_12 vdout1_12ck39 = 0 time = 400
* CHECK dout1_13 vdout1_13ck39 = 1.7 time = 400
* CHECK dout1_14 vdout1_14ck39 = 1.7 time = 400
* CHECK dout1_15 vdout1_15ck39 = 1.7 time = 400
* CHECK dout1_16 vdout1_16ck39 = 1.7 time = 400
* CHECK dout1_17 vdout1_17ck39 = 1.7 time = 400
* CHECK dout1_18 vdout1_18ck39 = 1.7 time = 400
* CHECK dout1_19 vdout1_19ck39 = 0 time = 400
* CHECK dout1_20 vdout1_20ck39 = 0 time = 400
* CHECK dout1_21 vdout1_21ck39 = 1.7 time = 400
* CHECK dout1_22 vdout1_22ck39 = 1.7 time = 400
* CHECK dout1_23 vdout1_23ck39 = 1.7 time = 400
* CHECK dout1_24 vdout1_24ck39 = 1.7 time = 400
* CHECK dout1_25 vdout1_25ck39 = 1.7 time = 400
* CHECK dout1_26 vdout1_26ck39 = 0 time = 400
* CHECK dout1_27 vdout1_27ck39 = 0 time = 400
* CHECK dout1_28 vdout1_28ck39 = 1.7 time = 400
* CHECK dout1_29 vdout1_29ck39 = 1.7 time = 400
* CHECK dout1_30 vdout1_30ck39 = 1.7 time = 400
* CHECK dout1_31 vdout1_31ck39 = 1.7 time = 400
* CHECK dout1_32 vdout1_32ck39 = 0 time = 400
* CHECK dout1_0 vdout1_0ck41 = 0 time = 420
* CHECK dout1_1 vdout1_1ck41 = 0 time = 420
* CHECK dout1_2 vdout1_2ck41 = 0 time = 420
* CHECK dout1_3 vdout1_3ck41 = 0 time = 420
* CHECK dout1_4 vdout1_4ck41 = 1.7 time = 420
* CHECK dout1_5 vdout1_5ck41 = 0 time = 420
* CHECK dout1_6 vdout1_6ck41 = 1.7 time = 420
* CHECK dout1_7 vdout1_7ck41 = 0 time = 420
* CHECK dout1_8 vdout1_8ck41 = 0 time = 420
* CHECK dout1_9 vdout1_9ck41 = 0 time = 420
* CHECK dout1_10 vdout1_10ck41 = 0 time = 420
* CHECK dout1_11 vdout1_11ck41 = 1.7 time = 420
* CHECK dout1_12 vdout1_12ck41 = 0 time = 420
* CHECK dout1_13 vdout1_13ck41 = 1.7 time = 420
* CHECK dout1_14 vdout1_14ck41 = 1.7 time = 420
* CHECK dout1_15 vdout1_15ck41 = 1.7 time = 420
* CHECK dout1_16 vdout1_16ck41 = 1.7 time = 420
* CHECK dout1_17 vdout1_17ck41 = 1.7 time = 420
* CHECK dout1_18 vdout1_18ck41 = 1.7 time = 420
* CHECK dout1_19 vdout1_19ck41 = 0 time = 420
* CHECK dout1_20 vdout1_20ck41 = 0 time = 420
* CHECK dout1_21 vdout1_21ck41 = 1.7 time = 420
* CHECK dout1_22 vdout1_22ck41 = 1.7 time = 420
* CHECK dout1_23 vdout1_23ck41 = 1.7 time = 420
* CHECK dout1_24 vdout1_24ck41 = 1.7 time = 420
* CHECK dout1_25 vdout1_25ck41 = 1.7 time = 420
* CHECK dout1_26 vdout1_26ck41 = 0 time = 420
* CHECK dout1_27 vdout1_27ck41 = 0 time = 420
* CHECK dout1_28 vdout1_28ck41 = 1.7 time = 420
* CHECK dout1_29 vdout1_29ck41 = 1.7 time = 420
* CHECK dout1_30 vdout1_30ck41 = 1.7 time = 420
* CHECK dout1_31 vdout1_31ck41 = 1.7 time = 420
* CHECK dout1_32 vdout1_32ck41 = 0 time = 420
* CHECK dout1_0 vdout1_0ck42 = 0 time = 430
* CHECK dout1_1 vdout1_1ck42 = 0 time = 430
* CHECK dout1_2 vdout1_2ck42 = 0 time = 430
* CHECK dout1_3 vdout1_3ck42 = 0 time = 430
* CHECK dout1_4 vdout1_4ck42 = 1.7 time = 430
* CHECK dout1_5 vdout1_5ck42 = 0 time = 430
* CHECK dout1_6 vdout1_6ck42 = 1.7 time = 430
* CHECK dout1_7 vdout1_7ck42 = 0 time = 430
* CHECK dout1_8 vdout1_8ck42 = 0 time = 430
* CHECK dout1_9 vdout1_9ck42 = 0 time = 430
* CHECK dout1_10 vdout1_10ck42 = 0 time = 430
* CHECK dout1_11 vdout1_11ck42 = 1.7 time = 430
* CHECK dout1_12 vdout1_12ck42 = 0 time = 430
* CHECK dout1_13 vdout1_13ck42 = 1.7 time = 430
* CHECK dout1_14 vdout1_14ck42 = 1.7 time = 430
* CHECK dout1_15 vdout1_15ck42 = 1.7 time = 430
* CHECK dout1_16 vdout1_16ck42 = 1.7 time = 430
* CHECK dout1_17 vdout1_17ck42 = 1.7 time = 430
* CHECK dout1_18 vdout1_18ck42 = 1.7 time = 430
* CHECK dout1_19 vdout1_19ck42 = 0 time = 430
* CHECK dout1_20 vdout1_20ck42 = 0 time = 430
* CHECK dout1_21 vdout1_21ck42 = 1.7 time = 430
* CHECK dout1_22 vdout1_22ck42 = 1.7 time = 430
* CHECK dout1_23 vdout1_23ck42 = 1.7 time = 430
* CHECK dout1_24 vdout1_24ck42 = 1.7 time = 430
* CHECK dout1_25 vdout1_25ck42 = 1.7 time = 430
* CHECK dout1_26 vdout1_26ck42 = 0 time = 430
* CHECK dout1_27 vdout1_27ck42 = 0 time = 430
* CHECK dout1_28 vdout1_28ck42 = 1.7 time = 430
* CHECK dout1_29 vdout1_29ck42 = 1.7 time = 430
* CHECK dout1_30 vdout1_30ck42 = 1.7 time = 430
* CHECK dout1_31 vdout1_31ck42 = 1.7 time = 430
* CHECK dout1_32 vdout1_32ck42 = 0 time = 430
* CHECK dout1_0 vdout1_0ck43 = 0 time = 440
* CHECK dout1_1 vdout1_1ck43 = 0 time = 440
* CHECK dout1_2 vdout1_2ck43 = 0 time = 440
* CHECK dout1_3 vdout1_3ck43 = 0 time = 440
* CHECK dout1_4 vdout1_4ck43 = 1.7 time = 440
* CHECK dout1_5 vdout1_5ck43 = 0 time = 440
* CHECK dout1_6 vdout1_6ck43 = 1.7 time = 440
* CHECK dout1_7 vdout1_7ck43 = 0 time = 440
* CHECK dout1_8 vdout1_8ck43 = 0 time = 440
* CHECK dout1_9 vdout1_9ck43 = 0 time = 440
* CHECK dout1_10 vdout1_10ck43 = 0 time = 440
* CHECK dout1_11 vdout1_11ck43 = 1.7 time = 440
* CHECK dout1_12 vdout1_12ck43 = 0 time = 440
* CHECK dout1_13 vdout1_13ck43 = 1.7 time = 440
* CHECK dout1_14 vdout1_14ck43 = 1.7 time = 440
* CHECK dout1_15 vdout1_15ck43 = 1.7 time = 440
* CHECK dout1_16 vdout1_16ck43 = 1.7 time = 440
* CHECK dout1_17 vdout1_17ck43 = 1.7 time = 440
* CHECK dout1_18 vdout1_18ck43 = 1.7 time = 440
* CHECK dout1_19 vdout1_19ck43 = 0 time = 440
* CHECK dout1_20 vdout1_20ck43 = 0 time = 440
* CHECK dout1_21 vdout1_21ck43 = 1.7 time = 440
* CHECK dout1_22 vdout1_22ck43 = 1.7 time = 440
* CHECK dout1_23 vdout1_23ck43 = 1.7 time = 440
* CHECK dout1_24 vdout1_24ck43 = 1.7 time = 440
* CHECK dout1_25 vdout1_25ck43 = 1.7 time = 440
* CHECK dout1_26 vdout1_26ck43 = 0 time = 440
* CHECK dout1_27 vdout1_27ck43 = 0 time = 440
* CHECK dout1_28 vdout1_28ck43 = 1.7 time = 440
* CHECK dout1_29 vdout1_29ck43 = 1.7 time = 440
* CHECK dout1_30 vdout1_30ck43 = 1.7 time = 440
* CHECK dout1_31 vdout1_31ck43 = 1.7 time = 440
* CHECK dout1_32 vdout1_32ck43 = 0 time = 440
* CHECK dout1_0 vdout1_0ck44 = 0 time = 450
* CHECK dout1_1 vdout1_1ck44 = 0 time = 450
* CHECK dout1_2 vdout1_2ck44 = 0 time = 450
* CHECK dout1_3 vdout1_3ck44 = 0 time = 450
* CHECK dout1_4 vdout1_4ck44 = 1.7 time = 450
* CHECK dout1_5 vdout1_5ck44 = 0 time = 450
* CHECK dout1_6 vdout1_6ck44 = 1.7 time = 450
* CHECK dout1_7 vdout1_7ck44 = 0 time = 450
* CHECK dout1_8 vdout1_8ck44 = 0 time = 450
* CHECK dout1_9 vdout1_9ck44 = 0 time = 450
* CHECK dout1_10 vdout1_10ck44 = 0 time = 450
* CHECK dout1_11 vdout1_11ck44 = 1.7 time = 450
* CHECK dout1_12 vdout1_12ck44 = 0 time = 450
* CHECK dout1_13 vdout1_13ck44 = 1.7 time = 450
* CHECK dout1_14 vdout1_14ck44 = 1.7 time = 450
* CHECK dout1_15 vdout1_15ck44 = 1.7 time = 450
* CHECK dout1_16 vdout1_16ck44 = 1.7 time = 450
* CHECK dout1_17 vdout1_17ck44 = 1.7 time = 450
* CHECK dout1_18 vdout1_18ck44 = 1.7 time = 450
* CHECK dout1_19 vdout1_19ck44 = 0 time = 450
* CHECK dout1_20 vdout1_20ck44 = 0 time = 450
* CHECK dout1_21 vdout1_21ck44 = 1.7 time = 450
* CHECK dout1_22 vdout1_22ck44 = 1.7 time = 450
* CHECK dout1_23 vdout1_23ck44 = 1.7 time = 450
* CHECK dout1_24 vdout1_24ck44 = 1.7 time = 450
* CHECK dout1_25 vdout1_25ck44 = 1.7 time = 450
* CHECK dout1_26 vdout1_26ck44 = 0 time = 450
* CHECK dout1_27 vdout1_27ck44 = 0 time = 450
* CHECK dout1_28 vdout1_28ck44 = 1.7 time = 450
* CHECK dout1_29 vdout1_29ck44 = 1.7 time = 450
* CHECK dout1_30 vdout1_30ck44 = 1.7 time = 450
* CHECK dout1_31 vdout1_31ck44 = 1.7 time = 450
* CHECK dout1_32 vdout1_32ck44 = 0 time = 450
* CHECK dout1_0 vdout1_0ck48 = 1.7 time = 490
* CHECK dout1_1 vdout1_1ck48 = 1.7 time = 490
* CHECK dout1_2 vdout1_2ck48 = 0 time = 490
* CHECK dout1_3 vdout1_3ck48 = 1.7 time = 490
* CHECK dout1_4 vdout1_4ck48 = 1.7 time = 490
* CHECK dout1_5 vdout1_5ck48 = 0 time = 490
* CHECK dout1_6 vdout1_6ck48 = 1.7 time = 490
* CHECK dout1_7 vdout1_7ck48 = 1.7 time = 490
* CHECK dout1_8 vdout1_8ck48 = 1.7 time = 490
* CHECK dout1_9 vdout1_9ck48 = 0 time = 490
* CHECK dout1_10 vdout1_10ck48 = 1.7 time = 490
* CHECK dout1_11 vdout1_11ck48 = 1.7 time = 490
* CHECK dout1_12 vdout1_12ck48 = 0 time = 490
* CHECK dout1_13 vdout1_13ck48 = 1.7 time = 490
* CHECK dout1_14 vdout1_14ck48 = 1.7 time = 490
* CHECK dout1_15 vdout1_15ck48 = 1.7 time = 490
* CHECK dout1_16 vdout1_16ck48 = 1.7 time = 490
* CHECK dout1_17 vdout1_17ck48 = 1.7 time = 490
* CHECK dout1_18 vdout1_18ck48 = 0 time = 490
* CHECK dout1_19 vdout1_19ck48 = 1.7 time = 490
* CHECK dout1_20 vdout1_20ck48 = 1.7 time = 490
* CHECK dout1_21 vdout1_21ck48 = 0 time = 490
* CHECK dout1_22 vdout1_22ck48 = 1.7 time = 490
* CHECK dout1_23 vdout1_23ck48 = 1.7 time = 490
* CHECK dout1_24 vdout1_24ck48 = 1.7 time = 490
* CHECK dout1_25 vdout1_25ck48 = 1.7 time = 490
* CHECK dout1_26 vdout1_26ck48 = 1.7 time = 490
* CHECK dout1_27 vdout1_27ck48 = 0 time = 490
* CHECK dout1_28 vdout1_28ck48 = 0 time = 490
* CHECK dout1_29 vdout1_29ck48 = 0 time = 490
* CHECK dout1_30 vdout1_30ck48 = 1.7 time = 490
* CHECK dout1_31 vdout1_31ck48 = 0 time = 490
* CHECK dout1_32 vdout1_32ck48 = 0 time = 490
* CHECK dout1_0 vdout1_0ck53 = 0 time = 540
* CHECK dout1_1 vdout1_1ck53 = 0 time = 540
* CHECK dout1_2 vdout1_2ck53 = 0 time = 540
* CHECK dout1_3 vdout1_3ck53 = 1.7 time = 540
* CHECK dout1_4 vdout1_4ck53 = 1.7 time = 540
* CHECK dout1_5 vdout1_5ck53 = 0 time = 540
* CHECK dout1_6 vdout1_6ck53 = 1.7 time = 540
* CHECK dout1_7 vdout1_7ck53 = 0 time = 540
* CHECK dout1_8 vdout1_8ck53 = 1.7 time = 540
* CHECK dout1_9 vdout1_9ck53 = 0 time = 540
* CHECK dout1_10 vdout1_10ck53 = 1.7 time = 540
* CHECK dout1_11 vdout1_11ck53 = 0 time = 540
* CHECK dout1_12 vdout1_12ck53 = 0 time = 540
* CHECK dout1_13 vdout1_13ck53 = 1.7 time = 540
* CHECK dout1_14 vdout1_14ck53 = 0 time = 540
* CHECK dout1_15 vdout1_15ck53 = 1.7 time = 540
* CHECK dout1_16 vdout1_16ck53 = 1.7 time = 540
* CHECK dout1_17 vdout1_17ck53 = 0 time = 540
* CHECK dout1_18 vdout1_18ck53 = 0 time = 540
* CHECK dout1_19 vdout1_19ck53 = 0 time = 540
* CHECK dout1_20 vdout1_20ck53 = 1.7 time = 540
* CHECK dout1_21 vdout1_21ck53 = 1.7 time = 540
* CHECK dout1_22 vdout1_22ck53 = 1.7 time = 540
* CHECK dout1_23 vdout1_23ck53 = 0 time = 540
* CHECK dout1_24 vdout1_24ck53 = 1.7 time = 540
* CHECK dout1_25 vdout1_25ck53 = 1.7 time = 540
* CHECK dout1_26 vdout1_26ck53 = 1.7 time = 540
* CHECK dout1_27 vdout1_27ck53 = 0 time = 540
* CHECK dout1_28 vdout1_28ck53 = 1.7 time = 540
* CHECK dout1_29 vdout1_29ck53 = 1.7 time = 540
* CHECK dout1_30 vdout1_30ck53 = 0 time = 540
* CHECK dout1_31 vdout1_31ck53 = 0 time = 540
* CHECK dout1_32 vdout1_32ck53 = 0 time = 540
* CHECK dout1_0 vdout1_0ck55 = 0 time = 560
* CHECK dout1_1 vdout1_1ck55 = 0 time = 560
* CHECK dout1_2 vdout1_2ck55 = 0 time = 560
* CHECK dout1_3 vdout1_3ck55 = 1.7 time = 560
* CHECK dout1_4 vdout1_4ck55 = 1.7 time = 560
* CHECK dout1_5 vdout1_5ck55 = 0 time = 560
* CHECK dout1_6 vdout1_6ck55 = 1.7 time = 560
* CHECK dout1_7 vdout1_7ck55 = 0 time = 560
* CHECK dout1_8 vdout1_8ck55 = 1.7 time = 560
* CHECK dout1_9 vdout1_9ck55 = 0 time = 560
* CHECK dout1_10 vdout1_10ck55 = 1.7 time = 560
* CHECK dout1_11 vdout1_11ck55 = 0 time = 560
* CHECK dout1_12 vdout1_12ck55 = 0 time = 560
* CHECK dout1_13 vdout1_13ck55 = 1.7 time = 560
* CHECK dout1_14 vdout1_14ck55 = 0 time = 560
* CHECK dout1_15 vdout1_15ck55 = 1.7 time = 560
* CHECK dout1_16 vdout1_16ck55 = 1.7 time = 560
* CHECK dout1_17 vdout1_17ck55 = 0 time = 560
* CHECK dout1_18 vdout1_18ck55 = 0 time = 560
* CHECK dout1_19 vdout1_19ck55 = 0 time = 560
* CHECK dout1_20 vdout1_20ck55 = 1.7 time = 560
* CHECK dout1_21 vdout1_21ck55 = 1.7 time = 560
* CHECK dout1_22 vdout1_22ck55 = 1.7 time = 560
* CHECK dout1_23 vdout1_23ck55 = 0 time = 560
* CHECK dout1_24 vdout1_24ck55 = 1.7 time = 560
* CHECK dout1_25 vdout1_25ck55 = 1.7 time = 560
* CHECK dout1_26 vdout1_26ck55 = 1.7 time = 560
* CHECK dout1_27 vdout1_27ck55 = 0 time = 560
* CHECK dout1_28 vdout1_28ck55 = 1.7 time = 560
* CHECK dout1_29 vdout1_29ck55 = 1.7 time = 560
* CHECK dout1_30 vdout1_30ck55 = 0 time = 560
* CHECK dout1_31 vdout1_31ck55 = 0 time = 560
* CHECK dout1_32 vdout1_32ck55 = 0 time = 560
* CHECK dout1_0 vdout1_0ck57 = 0 time = 580
* CHECK dout1_1 vdout1_1ck57 = 0 time = 580
* CHECK dout1_2 vdout1_2ck57 = 0 time = 580
* CHECK dout1_3 vdout1_3ck57 = 1.7 time = 580
* CHECK dout1_4 vdout1_4ck57 = 1.7 time = 580
* CHECK dout1_5 vdout1_5ck57 = 0 time = 580
* CHECK dout1_6 vdout1_6ck57 = 1.7 time = 580
* CHECK dout1_7 vdout1_7ck57 = 0 time = 580
* CHECK dout1_8 vdout1_8ck57 = 1.7 time = 580
* CHECK dout1_9 vdout1_9ck57 = 0 time = 580
* CHECK dout1_10 vdout1_10ck57 = 1.7 time = 580
* CHECK dout1_11 vdout1_11ck57 = 0 time = 580
* CHECK dout1_12 vdout1_12ck57 = 0 time = 580
* CHECK dout1_13 vdout1_13ck57 = 1.7 time = 580
* CHECK dout1_14 vdout1_14ck57 = 0 time = 580
* CHECK dout1_15 vdout1_15ck57 = 1.7 time = 580
* CHECK dout1_16 vdout1_16ck57 = 1.7 time = 580
* CHECK dout1_17 vdout1_17ck57 = 0 time = 580
* CHECK dout1_18 vdout1_18ck57 = 0 time = 580
* CHECK dout1_19 vdout1_19ck57 = 0 time = 580
* CHECK dout1_20 vdout1_20ck57 = 1.7 time = 580
* CHECK dout1_21 vdout1_21ck57 = 1.7 time = 580
* CHECK dout1_22 vdout1_22ck57 = 1.7 time = 580
* CHECK dout1_23 vdout1_23ck57 = 0 time = 580
* CHECK dout1_24 vdout1_24ck57 = 1.7 time = 580
* CHECK dout1_25 vdout1_25ck57 = 1.7 time = 580
* CHECK dout1_26 vdout1_26ck57 = 1.7 time = 580
* CHECK dout1_27 vdout1_27ck57 = 0 time = 580
* CHECK dout1_28 vdout1_28ck57 = 1.7 time = 580
* CHECK dout1_29 vdout1_29ck57 = 1.7 time = 580
* CHECK dout1_30 vdout1_30ck57 = 0 time = 580
* CHECK dout1_31 vdout1_31ck57 = 0 time = 580
* CHECK dout1_32 vdout1_32ck57 = 0 time = 580
* CHECK dout1_0 vdout1_0ck58 = 1.7 time = 590
* CHECK dout1_1 vdout1_1ck58 = 1.7 time = 590
* CHECK dout1_2 vdout1_2ck58 = 0 time = 590
* CHECK dout1_3 vdout1_3ck58 = 1.7 time = 590
* CHECK dout1_4 vdout1_4ck58 = 1.7 time = 590
* CHECK dout1_5 vdout1_5ck58 = 1.7 time = 590
* CHECK dout1_6 vdout1_6ck58 = 0 time = 590
* CHECK dout1_7 vdout1_7ck58 = 1.7 time = 590
* CHECK dout1_8 vdout1_8ck58 = 1.7 time = 590
* CHECK dout1_9 vdout1_9ck58 = 0 time = 590
* CHECK dout1_10 vdout1_10ck58 = 1.7 time = 590
* CHECK dout1_11 vdout1_11ck58 = 1.7 time = 590
* CHECK dout1_12 vdout1_12ck58 = 0 time = 590
* CHECK dout1_13 vdout1_13ck58 = 0 time = 590
* CHECK dout1_14 vdout1_14ck58 = 1.7 time = 590
* CHECK dout1_15 vdout1_15ck58 = 0 time = 590
* CHECK dout1_16 vdout1_16ck58 = 1.7 time = 590
* CHECK dout1_17 vdout1_17ck58 = 0 time = 590
* CHECK dout1_18 vdout1_18ck58 = 1.7 time = 590
* CHECK dout1_19 vdout1_19ck58 = 0 time = 590
* CHECK dout1_20 vdout1_20ck58 = 0 time = 590
* CHECK dout1_21 vdout1_21ck58 = 0 time = 590
* CHECK dout1_22 vdout1_22ck58 = 0 time = 590
* CHECK dout1_23 vdout1_23ck58 = 0 time = 590
* CHECK dout1_24 vdout1_24ck58 = 1.7 time = 590
* CHECK dout1_25 vdout1_25ck58 = 0 time = 590
* CHECK dout1_26 vdout1_26ck58 = 1.7 time = 590
* CHECK dout1_27 vdout1_27ck58 = 0 time = 590
* CHECK dout1_28 vdout1_28ck58 = 1.7 time = 590
* CHECK dout1_29 vdout1_29ck58 = 0 time = 590
* CHECK dout1_30 vdout1_30ck58 = 1.7 time = 590
* CHECK dout1_31 vdout1_31ck58 = 0 time = 590
* CHECK dout1_32 vdout1_32ck58 = 0 time = 590
* CHECK dout1_0 vdout1_0ck61 = 0 time = 620
* CHECK dout1_1 vdout1_1ck61 = 0 time = 620
* CHECK dout1_2 vdout1_2ck61 = 0 time = 620
* CHECK dout1_3 vdout1_3ck61 = 1.7 time = 620
* CHECK dout1_4 vdout1_4ck61 = 1.7 time = 620
* CHECK dout1_5 vdout1_5ck61 = 0 time = 620
* CHECK dout1_6 vdout1_6ck61 = 1.7 time = 620
* CHECK dout1_7 vdout1_7ck61 = 0 time = 620
* CHECK dout1_8 vdout1_8ck61 = 1.7 time = 620
* CHECK dout1_9 vdout1_9ck61 = 0 time = 620
* CHECK dout1_10 vdout1_10ck61 = 1.7 time = 620
* CHECK dout1_11 vdout1_11ck61 = 0 time = 620
* CHECK dout1_12 vdout1_12ck61 = 0 time = 620
* CHECK dout1_13 vdout1_13ck61 = 1.7 time = 620
* CHECK dout1_14 vdout1_14ck61 = 0 time = 620
* CHECK dout1_15 vdout1_15ck61 = 1.7 time = 620
* CHECK dout1_16 vdout1_16ck61 = 1.7 time = 620
* CHECK dout1_17 vdout1_17ck61 = 0 time = 620
* CHECK dout1_18 vdout1_18ck61 = 0 time = 620
* CHECK dout1_19 vdout1_19ck61 = 0 time = 620
* CHECK dout1_20 vdout1_20ck61 = 1.7 time = 620
* CHECK dout1_21 vdout1_21ck61 = 1.7 time = 620
* CHECK dout1_22 vdout1_22ck61 = 1.7 time = 620
* CHECK dout1_23 vdout1_23ck61 = 0 time = 620
* CHECK dout1_24 vdout1_24ck61 = 1.7 time = 620
* CHECK dout1_25 vdout1_25ck61 = 1.7 time = 620
* CHECK dout1_26 vdout1_26ck61 = 1.7 time = 620
* CHECK dout1_27 vdout1_27ck61 = 0 time = 620
* CHECK dout1_28 vdout1_28ck61 = 1.7 time = 620
* CHECK dout1_29 vdout1_29ck61 = 1.7 time = 620
* CHECK dout1_30 vdout1_30ck61 = 0 time = 620
* CHECK dout1_31 vdout1_31ck61 = 0 time = 620
* CHECK dout1_32 vdout1_32ck61 = 0 time = 620
* CHECK dout1_0 vdout1_0ck62 = 0 time = 630
* CHECK dout1_1 vdout1_1ck62 = 0 time = 630
* CHECK dout1_2 vdout1_2ck62 = 0 time = 630
* CHECK dout1_3 vdout1_3ck62 = 1.7 time = 630
* CHECK dout1_4 vdout1_4ck62 = 1.7 time = 630
* CHECK dout1_5 vdout1_5ck62 = 0 time = 630
* CHECK dout1_6 vdout1_6ck62 = 1.7 time = 630
* CHECK dout1_7 vdout1_7ck62 = 0 time = 630
* CHECK dout1_8 vdout1_8ck62 = 1.7 time = 630
* CHECK dout1_9 vdout1_9ck62 = 0 time = 630
* CHECK dout1_10 vdout1_10ck62 = 1.7 time = 630
* CHECK dout1_11 vdout1_11ck62 = 0 time = 630
* CHECK dout1_12 vdout1_12ck62 = 0 time = 630
* CHECK dout1_13 vdout1_13ck62 = 1.7 time = 630
* CHECK dout1_14 vdout1_14ck62 = 0 time = 630
* CHECK dout1_15 vdout1_15ck62 = 1.7 time = 630
* CHECK dout1_16 vdout1_16ck62 = 1.7 time = 630
* CHECK dout1_17 vdout1_17ck62 = 0 time = 630
* CHECK dout1_18 vdout1_18ck62 = 0 time = 630
* CHECK dout1_19 vdout1_19ck62 = 0 time = 630
* CHECK dout1_20 vdout1_20ck62 = 1.7 time = 630
* CHECK dout1_21 vdout1_21ck62 = 1.7 time = 630
* CHECK dout1_22 vdout1_22ck62 = 1.7 time = 630
* CHECK dout1_23 vdout1_23ck62 = 0 time = 630
* CHECK dout1_24 vdout1_24ck62 = 1.7 time = 630
* CHECK dout1_25 vdout1_25ck62 = 1.7 time = 630
* CHECK dout1_26 vdout1_26ck62 = 1.7 time = 630
* CHECK dout1_27 vdout1_27ck62 = 0 time = 630
* CHECK dout1_28 vdout1_28ck62 = 1.7 time = 630
* CHECK dout1_29 vdout1_29ck62 = 1.7 time = 630
* CHECK dout1_30 vdout1_30ck62 = 0 time = 630
* CHECK dout1_31 vdout1_31ck62 = 0 time = 630
* CHECK dout1_32 vdout1_32ck62 = 0 time = 630
* CHECK dout1_0 vdout1_0ck64 = 0 time = 650
* CHECK dout1_1 vdout1_1ck64 = 0 time = 650
* CHECK dout1_2 vdout1_2ck64 = 0 time = 650
* CHECK dout1_3 vdout1_3ck64 = 1.7 time = 650
* CHECK dout1_4 vdout1_4ck64 = 1.7 time = 650
* CHECK dout1_5 vdout1_5ck64 = 0 time = 650
* CHECK dout1_6 vdout1_6ck64 = 1.7 time = 650
* CHECK dout1_7 vdout1_7ck64 = 0 time = 650
* CHECK dout1_8 vdout1_8ck64 = 1.7 time = 650
* CHECK dout1_9 vdout1_9ck64 = 0 time = 650
* CHECK dout1_10 vdout1_10ck64 = 1.7 time = 650
* CHECK dout1_11 vdout1_11ck64 = 0 time = 650
* CHECK dout1_12 vdout1_12ck64 = 0 time = 650
* CHECK dout1_13 vdout1_13ck64 = 1.7 time = 650
* CHECK dout1_14 vdout1_14ck64 = 0 time = 650
* CHECK dout1_15 vdout1_15ck64 = 1.7 time = 650
* CHECK dout1_16 vdout1_16ck64 = 1.7 time = 650
* CHECK dout1_17 vdout1_17ck64 = 0 time = 650
* CHECK dout1_18 vdout1_18ck64 = 0 time = 650
* CHECK dout1_19 vdout1_19ck64 = 0 time = 650
* CHECK dout1_20 vdout1_20ck64 = 1.7 time = 650
* CHECK dout1_21 vdout1_21ck64 = 1.7 time = 650
* CHECK dout1_22 vdout1_22ck64 = 1.7 time = 650
* CHECK dout1_23 vdout1_23ck64 = 0 time = 650
* CHECK dout1_24 vdout1_24ck64 = 1.7 time = 650
* CHECK dout1_25 vdout1_25ck64 = 1.7 time = 650
* CHECK dout1_26 vdout1_26ck64 = 1.7 time = 650
* CHECK dout1_27 vdout1_27ck64 = 0 time = 650
* CHECK dout1_28 vdout1_28ck64 = 1.7 time = 650
* CHECK dout1_29 vdout1_29ck64 = 1.7 time = 650
* CHECK dout1_30 vdout1_30ck64 = 0 time = 650
* CHECK dout1_31 vdout1_31ck64 = 0 time = 650
* CHECK dout1_32 vdout1_32ck64 = 0 time = 650
* CHECK dout1_0 vdout1_0ck66 = 0 time = 670
* CHECK dout1_1 vdout1_1ck66 = 0 time = 670
* CHECK dout1_2 vdout1_2ck66 = 0 time = 670
* CHECK dout1_3 vdout1_3ck66 = 1.7 time = 670
* CHECK dout1_4 vdout1_4ck66 = 1.7 time = 670
* CHECK dout1_5 vdout1_5ck66 = 0 time = 670
* CHECK dout1_6 vdout1_6ck66 = 1.7 time = 670
* CHECK dout1_7 vdout1_7ck66 = 0 time = 670
* CHECK dout1_8 vdout1_8ck66 = 1.7 time = 670
* CHECK dout1_9 vdout1_9ck66 = 0 time = 670
* CHECK dout1_10 vdout1_10ck66 = 1.7 time = 670
* CHECK dout1_11 vdout1_11ck66 = 0 time = 670
* CHECK dout1_12 vdout1_12ck66 = 0 time = 670
* CHECK dout1_13 vdout1_13ck66 = 1.7 time = 670
* CHECK dout1_14 vdout1_14ck66 = 0 time = 670
* CHECK dout1_15 vdout1_15ck66 = 1.7 time = 670
* CHECK dout1_16 vdout1_16ck66 = 1.7 time = 670
* CHECK dout1_17 vdout1_17ck66 = 0 time = 670
* CHECK dout1_18 vdout1_18ck66 = 0 time = 670
* CHECK dout1_19 vdout1_19ck66 = 0 time = 670
* CHECK dout1_20 vdout1_20ck66 = 1.7 time = 670
* CHECK dout1_21 vdout1_21ck66 = 1.7 time = 670
* CHECK dout1_22 vdout1_22ck66 = 1.7 time = 670
* CHECK dout1_23 vdout1_23ck66 = 0 time = 670
* CHECK dout1_24 vdout1_24ck66 = 1.7 time = 670
* CHECK dout1_25 vdout1_25ck66 = 1.7 time = 670
* CHECK dout1_26 vdout1_26ck66 = 1.7 time = 670
* CHECK dout1_27 vdout1_27ck66 = 0 time = 670
* CHECK dout1_28 vdout1_28ck66 = 1.7 time = 670
* CHECK dout1_29 vdout1_29ck66 = 1.7 time = 670
* CHECK dout1_30 vdout1_30ck66 = 0 time = 670
* CHECK dout1_31 vdout1_31ck66 = 0 time = 670
* CHECK dout1_32 vdout1_32ck66 = 0 time = 670
* CHECK dout1_0 vdout1_0ck69 = 0 time = 700
* CHECK dout1_1 vdout1_1ck69 = 0 time = 700
* CHECK dout1_2 vdout1_2ck69 = 1.7 time = 700
* CHECK dout1_3 vdout1_3ck69 = 0 time = 700
* CHECK dout1_4 vdout1_4ck69 = 1.7 time = 700
* CHECK dout1_5 vdout1_5ck69 = 0 time = 700
* CHECK dout1_6 vdout1_6ck69 = 0 time = 700
* CHECK dout1_7 vdout1_7ck69 = 0 time = 700
* CHECK dout1_8 vdout1_8ck69 = 0 time = 700
* CHECK dout1_9 vdout1_9ck69 = 1.7 time = 700
* CHECK dout1_10 vdout1_10ck69 = 1.7 time = 700
* CHECK dout1_11 vdout1_11ck69 = 0 time = 700
* CHECK dout1_12 vdout1_12ck69 = 1.7 time = 700
* CHECK dout1_13 vdout1_13ck69 = 1.7 time = 700
* CHECK dout1_14 vdout1_14ck69 = 0 time = 700
* CHECK dout1_15 vdout1_15ck69 = 1.7 time = 700
* CHECK dout1_16 vdout1_16ck69 = 0 time = 700
* CHECK dout1_17 vdout1_17ck69 = 0 time = 700
* CHECK dout1_18 vdout1_18ck69 = 1.7 time = 700
* CHECK dout1_19 vdout1_19ck69 = 1.7 time = 700
* CHECK dout1_20 vdout1_20ck69 = 1.7 time = 700
* CHECK dout1_21 vdout1_21ck69 = 0 time = 700
* CHECK dout1_22 vdout1_22ck69 = 0 time = 700
* CHECK dout1_23 vdout1_23ck69 = 1.7 time = 700
* CHECK dout1_24 vdout1_24ck69 = 1.7 time = 700
* CHECK dout1_25 vdout1_25ck69 = 0 time = 700
* CHECK dout1_26 vdout1_26ck69 = 0 time = 700
* CHECK dout1_27 vdout1_27ck69 = 1.7 time = 700
* CHECK dout1_28 vdout1_28ck69 = 1.7 time = 700
* CHECK dout1_29 vdout1_29ck69 = 0 time = 700
* CHECK dout1_30 vdout1_30ck69 = 0 time = 700
* CHECK dout1_31 vdout1_31ck69 = 1.7 time = 700
* CHECK dout1_32 vdout1_32ck69 = 0 time = 700
* CHECK dout1_0 vdout1_0ck70 = 0 time = 710
* CHECK dout1_1 vdout1_1ck70 = 0 time = 710
* CHECK dout1_2 vdout1_2ck70 = 0 time = 710
* CHECK dout1_3 vdout1_3ck70 = 0 time = 710
* CHECK dout1_4 vdout1_4ck70 = 1.7 time = 710
* CHECK dout1_5 vdout1_5ck70 = 1.7 time = 710
* CHECK dout1_6 vdout1_6ck70 = 1.7 time = 710
* CHECK dout1_7 vdout1_7ck70 = 1.7 time = 710
* CHECK dout1_8 vdout1_8ck70 = 0 time = 710
* CHECK dout1_9 vdout1_9ck70 = 1.7 time = 710
* CHECK dout1_10 vdout1_10ck70 = 1.7 time = 710
* CHECK dout1_11 vdout1_11ck70 = 0 time = 710
* CHECK dout1_12 vdout1_12ck70 = 0 time = 710
* CHECK dout1_13 vdout1_13ck70 = 0 time = 710
* CHECK dout1_14 vdout1_14ck70 = 0 time = 710
* CHECK dout1_15 vdout1_15ck70 = 0 time = 710
* CHECK dout1_16 vdout1_16ck70 = 0 time = 710
* CHECK dout1_17 vdout1_17ck70 = 1.7 time = 710
* CHECK dout1_18 vdout1_18ck70 = 1.7 time = 710
* CHECK dout1_19 vdout1_19ck70 = 0 time = 710
* CHECK dout1_20 vdout1_20ck70 = 0 time = 710
* CHECK dout1_21 vdout1_21ck70 = 1.7 time = 710
* CHECK dout1_22 vdout1_22ck70 = 1.7 time = 710
* CHECK dout1_23 vdout1_23ck70 = 1.7 time = 710
* CHECK dout1_24 vdout1_24ck70 = 0 time = 710
* CHECK dout1_25 vdout1_25ck70 = 1.7 time = 710
* CHECK dout1_26 vdout1_26ck70 = 0 time = 710
* CHECK dout1_27 vdout1_27ck70 = 1.7 time = 710
* CHECK dout1_28 vdout1_28ck70 = 1.7 time = 710
* CHECK dout1_29 vdout1_29ck70 = 0 time = 710
* CHECK dout1_30 vdout1_30ck70 = 1.7 time = 710
* CHECK dout1_31 vdout1_31ck70 = 0 time = 710
* CHECK dout1_32 vdout1_32ck70 = 0 time = 710
* CHECK dout1_0 vdout1_0ck73 = 0 time = 740
* CHECK dout1_1 vdout1_1ck73 = 1.7 time = 740
* CHECK dout1_2 vdout1_2ck73 = 1.7 time = 740
* CHECK dout1_3 vdout1_3ck73 = 0 time = 740
* CHECK dout1_4 vdout1_4ck73 = 0 time = 740
* CHECK dout1_5 vdout1_5ck73 = 1.7 time = 740
* CHECK dout1_6 vdout1_6ck73 = 0 time = 740
* CHECK dout1_7 vdout1_7ck73 = 1.7 time = 740
* CHECK dout1_8 vdout1_8ck73 = 1.7 time = 740
* CHECK dout1_9 vdout1_9ck73 = 0 time = 740
* CHECK dout1_10 vdout1_10ck73 = 0 time = 740
* CHECK dout1_11 vdout1_11ck73 = 0 time = 740
* CHECK dout1_12 vdout1_12ck73 = 0 time = 740
* CHECK dout1_13 vdout1_13ck73 = 0 time = 740
* CHECK dout1_14 vdout1_14ck73 = 0 time = 740
* CHECK dout1_15 vdout1_15ck73 = 1.7 time = 740
* CHECK dout1_16 vdout1_16ck73 = 1.7 time = 740
* CHECK dout1_17 vdout1_17ck73 = 1.7 time = 740
* CHECK dout1_18 vdout1_18ck73 = 1.7 time = 740
* CHECK dout1_19 vdout1_19ck73 = 1.7 time = 740
* CHECK dout1_20 vdout1_20ck73 = 1.7 time = 740
* CHECK dout1_21 vdout1_21ck73 = 0 time = 740
* CHECK dout1_22 vdout1_22ck73 = 1.7 time = 740
* CHECK dout1_23 vdout1_23ck73 = 0 time = 740
* CHECK dout1_24 vdout1_24ck73 = 1.7 time = 740
* CHECK dout1_25 vdout1_25ck73 = 0 time = 740
* CHECK dout1_26 vdout1_26ck73 = 0 time = 740
* CHECK dout1_27 vdout1_27ck73 = 0 time = 740
* CHECK dout1_28 vdout1_28ck73 = 0 time = 740
* CHECK dout1_29 vdout1_29ck73 = 1.7 time = 740
* CHECK dout1_30 vdout1_30ck73 = 0 time = 740
* CHECK dout1_31 vdout1_31ck73 = 0 time = 740
* CHECK dout1_32 vdout1_32ck73 = 0 time = 740
* CHECK dout1_0 vdout1_0ck81 = 1.7 time = 820
* CHECK dout1_1 vdout1_1ck81 = 0 time = 820
* CHECK dout1_2 vdout1_2ck81 = 1.7 time = 820
* CHECK dout1_3 vdout1_3ck81 = 1.7 time = 820
* CHECK dout1_4 vdout1_4ck81 = 0 time = 820
* CHECK dout1_5 vdout1_5ck81 = 1.7 time = 820
* CHECK dout1_6 vdout1_6ck81 = 1.7 time = 820
* CHECK dout1_7 vdout1_7ck81 = 0 time = 820
* CHECK dout1_8 vdout1_8ck81 = 0 time = 820
* CHECK dout1_9 vdout1_9ck81 = 0 time = 820
* CHECK dout1_10 vdout1_10ck81 = 0 time = 820
* CHECK dout1_11 vdout1_11ck81 = 1.7 time = 820
* CHECK dout1_12 vdout1_12ck81 = 1.7 time = 820
* CHECK dout1_13 vdout1_13ck81 = 0 time = 820
* CHECK dout1_14 vdout1_14ck81 = 1.7 time = 820
* CHECK dout1_15 vdout1_15ck81 = 0 time = 820
* CHECK dout1_16 vdout1_16ck81 = 1.7 time = 820
* CHECK dout1_17 vdout1_17ck81 = 0 time = 820
* CHECK dout1_18 vdout1_18ck81 = 1.7 time = 820
* CHECK dout1_19 vdout1_19ck81 = 0 time = 820
* CHECK dout1_20 vdout1_20ck81 = 1.7 time = 820
* CHECK dout1_21 vdout1_21ck81 = 1.7 time = 820
* CHECK dout1_22 vdout1_22ck81 = 0 time = 820
* CHECK dout1_23 vdout1_23ck81 = 1.7 time = 820
* CHECK dout1_24 vdout1_24ck81 = 1.7 time = 820
* CHECK dout1_25 vdout1_25ck81 = 0 time = 820
* CHECK dout1_26 vdout1_26ck81 = 0 time = 820
* CHECK dout1_27 vdout1_27ck81 = 1.7 time = 820
* CHECK dout1_28 vdout1_28ck81 = 1.7 time = 820
* CHECK dout1_29 vdout1_29ck81 = 0 time = 820
* CHECK dout1_30 vdout1_30ck81 = 1.7 time = 820
* CHECK dout1_31 vdout1_31ck81 = 1.7 time = 820
* CHECK dout1_32 vdout1_32ck81 = 0 time = 820
* CHECK dout1_0 vdout1_0ck82 = 1.7 time = 830
* CHECK dout1_1 vdout1_1ck82 = 1.7 time = 830
* CHECK dout1_2 vdout1_2ck82 = 0 time = 830
* CHECK dout1_3 vdout1_3ck82 = 0 time = 830
* CHECK dout1_4 vdout1_4ck82 = 1.7 time = 830
* CHECK dout1_5 vdout1_5ck82 = 0 time = 830
* CHECK dout1_6 vdout1_6ck82 = 0 time = 830
* CHECK dout1_7 vdout1_7ck82 = 1.7 time = 830
* CHECK dout1_8 vdout1_8ck82 = 1.7 time = 830
* CHECK dout1_9 vdout1_9ck82 = 0 time = 830
* CHECK dout1_10 vdout1_10ck82 = 1.7 time = 830
* CHECK dout1_11 vdout1_11ck82 = 1.7 time = 830
* CHECK dout1_12 vdout1_12ck82 = 0 time = 830
* CHECK dout1_13 vdout1_13ck82 = 1.7 time = 830
* CHECK dout1_14 vdout1_14ck82 = 1.7 time = 830
* CHECK dout1_15 vdout1_15ck82 = 1.7 time = 830
* CHECK dout1_16 vdout1_16ck82 = 0 time = 830
* CHECK dout1_17 vdout1_17ck82 = 0 time = 830
* CHECK dout1_18 vdout1_18ck82 = 1.7 time = 830
* CHECK dout1_19 vdout1_19ck82 = 0 time = 830
* CHECK dout1_20 vdout1_20ck82 = 0 time = 830
* CHECK dout1_21 vdout1_21ck82 = 1.7 time = 830
* CHECK dout1_22 vdout1_22ck82 = 1.7 time = 830
* CHECK dout1_23 vdout1_23ck82 = 0 time = 830
* CHECK dout1_24 vdout1_24ck82 = 0 time = 830
* CHECK dout1_25 vdout1_25ck82 = 0 time = 830
* CHECK dout1_26 vdout1_26ck82 = 1.7 time = 830
* CHECK dout1_27 vdout1_27ck82 = 0 time = 830
* CHECK dout1_28 vdout1_28ck82 = 1.7 time = 830
* CHECK dout1_29 vdout1_29ck82 = 1.7 time = 830
* CHECK dout1_30 vdout1_30ck82 = 0 time = 830
* CHECK dout1_31 vdout1_31ck82 = 0 time = 830
* CHECK dout1_32 vdout1_32ck82 = 0 time = 830
* CHECK dout1_0 vdout1_0ck84 = 0 time = 850
* CHECK dout1_1 vdout1_1ck84 = 1.7 time = 850
* CHECK dout1_2 vdout1_2ck84 = 0 time = 850
* CHECK dout1_3 vdout1_3ck84 = 0 time = 850
* CHECK dout1_4 vdout1_4ck84 = 0 time = 850
* CHECK dout1_5 vdout1_5ck84 = 0 time = 850
* CHECK dout1_6 vdout1_6ck84 = 1.7 time = 850
* CHECK dout1_7 vdout1_7ck84 = 0 time = 850
* CHECK dout1_8 vdout1_8ck84 = 1.7 time = 850
* CHECK dout1_9 vdout1_9ck84 = 0 time = 850
* CHECK dout1_10 vdout1_10ck84 = 1.7 time = 850
* CHECK dout1_11 vdout1_11ck84 = 0 time = 850
* CHECK dout1_12 vdout1_12ck84 = 0 time = 850
* CHECK dout1_13 vdout1_13ck84 = 1.7 time = 850
* CHECK dout1_14 vdout1_14ck84 = 0 time = 850
* CHECK dout1_15 vdout1_15ck84 = 0 time = 850
* CHECK dout1_16 vdout1_16ck84 = 1.7 time = 850
* CHECK dout1_17 vdout1_17ck84 = 1.7 time = 850
* CHECK dout1_18 vdout1_18ck84 = 0 time = 850
* CHECK dout1_19 vdout1_19ck84 = 1.7 time = 850
* CHECK dout1_20 vdout1_20ck84 = 1.7 time = 850
* CHECK dout1_21 vdout1_21ck84 = 1.7 time = 850
* CHECK dout1_22 vdout1_22ck84 = 0 time = 850
* CHECK dout1_23 vdout1_23ck84 = 1.7 time = 850
* CHECK dout1_24 vdout1_24ck84 = 1.7 time = 850
* CHECK dout1_25 vdout1_25ck84 = 0 time = 850
* CHECK dout1_26 vdout1_26ck84 = 1.7 time = 850
* CHECK dout1_27 vdout1_27ck84 = 1.7 time = 850
* CHECK dout1_28 vdout1_28ck84 = 0 time = 850
* CHECK dout1_29 vdout1_29ck84 = 1.7 time = 850
* CHECK dout1_30 vdout1_30ck84 = 1.7 time = 850
* CHECK dout1_31 vdout1_31ck84 = 1.7 time = 850
* CHECK dout1_32 vdout1_32ck84 = 0 time = 850
* CHECK dout1_0 vdout1_0ck89 = 1.7 time = 900
* CHECK dout1_1 vdout1_1ck89 = 0 time = 900
* CHECK dout1_2 vdout1_2ck89 = 1.7 time = 900
* CHECK dout1_3 vdout1_3ck89 = 0 time = 900
* CHECK dout1_4 vdout1_4ck89 = 0 time = 900
* CHECK dout1_5 vdout1_5ck89 = 1.7 time = 900
* CHECK dout1_6 vdout1_6ck89 = 1.7 time = 900
* CHECK dout1_7 vdout1_7ck89 = 1.7 time = 900
* CHECK dout1_8 vdout1_8ck89 = 0 time = 900
* CHECK dout1_9 vdout1_9ck89 = 1.7 time = 900
* CHECK dout1_10 vdout1_10ck89 = 1.7 time = 900
* CHECK dout1_11 vdout1_11ck89 = 1.7 time = 900
* CHECK dout1_12 vdout1_12ck89 = 0 time = 900
* CHECK dout1_13 vdout1_13ck89 = 0 time = 900
* CHECK dout1_14 vdout1_14ck89 = 1.7 time = 900
* CHECK dout1_15 vdout1_15ck89 = 0 time = 900
* CHECK dout1_16 vdout1_16ck89 = 1.7 time = 900
* CHECK dout1_17 vdout1_17ck89 = 1.7 time = 900
* CHECK dout1_18 vdout1_18ck89 = 1.7 time = 900
* CHECK dout1_19 vdout1_19ck89 = 0 time = 900
* CHECK dout1_20 vdout1_20ck89 = 0 time = 900
* CHECK dout1_21 vdout1_21ck89 = 0 time = 900
* CHECK dout1_22 vdout1_22ck89 = 1.7 time = 900
* CHECK dout1_23 vdout1_23ck89 = 0 time = 900
* CHECK dout1_24 vdout1_24ck89 = 0 time = 900
* CHECK dout1_25 vdout1_25ck89 = 1.7 time = 900
* CHECK dout1_26 vdout1_26ck89 = 1.7 time = 900
* CHECK dout1_27 vdout1_27ck89 = 0 time = 900
* CHECK dout1_28 vdout1_28ck89 = 1.7 time = 900
* CHECK dout1_29 vdout1_29ck89 = 1.7 time = 900
* CHECK dout1_30 vdout1_30ck89 = 0 time = 900
* CHECK dout1_31 vdout1_31ck89 = 0 time = 900
* CHECK dout1_32 vdout1_32ck89 = 0 time = 900
* CHECK dout1_0 vdout1_0ck90 = 1.7 time = 910
* CHECK dout1_1 vdout1_1ck90 = 0 time = 910
* CHECK dout1_2 vdout1_2ck90 = 1.7 time = 910
* CHECK dout1_3 vdout1_3ck90 = 0 time = 910
* CHECK dout1_4 vdout1_4ck90 = 0 time = 910
* CHECK dout1_5 vdout1_5ck90 = 1.7 time = 910
* CHECK dout1_6 vdout1_6ck90 = 1.7 time = 910
* CHECK dout1_7 vdout1_7ck90 = 1.7 time = 910
* CHECK dout1_8 vdout1_8ck90 = 0 time = 910
* CHECK dout1_9 vdout1_9ck90 = 1.7 time = 910
* CHECK dout1_10 vdout1_10ck90 = 1.7 time = 910
* CHECK dout1_11 vdout1_11ck90 = 1.7 time = 910
* CHECK dout1_12 vdout1_12ck90 = 0 time = 910
* CHECK dout1_13 vdout1_13ck90 = 0 time = 910
* CHECK dout1_14 vdout1_14ck90 = 1.7 time = 910
* CHECK dout1_15 vdout1_15ck90 = 0 time = 910
* CHECK dout1_16 vdout1_16ck90 = 1.7 time = 910
* CHECK dout1_17 vdout1_17ck90 = 1.7 time = 910
* CHECK dout1_18 vdout1_18ck90 = 1.7 time = 910
* CHECK dout1_19 vdout1_19ck90 = 0 time = 910
* CHECK dout1_20 vdout1_20ck90 = 0 time = 910
* CHECK dout1_21 vdout1_21ck90 = 0 time = 910
* CHECK dout1_22 vdout1_22ck90 = 1.7 time = 910
* CHECK dout1_23 vdout1_23ck90 = 0 time = 910
* CHECK dout1_24 vdout1_24ck90 = 0 time = 910
* CHECK dout1_25 vdout1_25ck90 = 1.7 time = 910
* CHECK dout1_26 vdout1_26ck90 = 1.7 time = 910
* CHECK dout1_27 vdout1_27ck90 = 0 time = 910
* CHECK dout1_28 vdout1_28ck90 = 1.7 time = 910
* CHECK dout1_29 vdout1_29ck90 = 1.7 time = 910
* CHECK dout1_30 vdout1_30ck90 = 0 time = 910
* CHECK dout1_31 vdout1_31ck90 = 0 time = 910
* CHECK dout1_32 vdout1_32ck90 = 0 time = 910
* CHECK dout1_0 vdout1_0ck91 = 1.7 time = 920
* CHECK dout1_1 vdout1_1ck91 = 0 time = 920
* CHECK dout1_2 vdout1_2ck91 = 1.7 time = 920
* CHECK dout1_3 vdout1_3ck91 = 0 time = 920
* CHECK dout1_4 vdout1_4ck91 = 0 time = 920
* CHECK dout1_5 vdout1_5ck91 = 1.7 time = 920
* CHECK dout1_6 vdout1_6ck91 = 1.7 time = 920
* CHECK dout1_7 vdout1_7ck91 = 1.7 time = 920
* CHECK dout1_8 vdout1_8ck91 = 0 time = 920
* CHECK dout1_9 vdout1_9ck91 = 1.7 time = 920
* CHECK dout1_10 vdout1_10ck91 = 1.7 time = 920
* CHECK dout1_11 vdout1_11ck91 = 1.7 time = 920
* CHECK dout1_12 vdout1_12ck91 = 0 time = 920
* CHECK dout1_13 vdout1_13ck91 = 0 time = 920
* CHECK dout1_14 vdout1_14ck91 = 1.7 time = 920
* CHECK dout1_15 vdout1_15ck91 = 0 time = 920
* CHECK dout1_16 vdout1_16ck91 = 1.7 time = 920
* CHECK dout1_17 vdout1_17ck91 = 1.7 time = 920
* CHECK dout1_18 vdout1_18ck91 = 1.7 time = 920
* CHECK dout1_19 vdout1_19ck91 = 0 time = 920
* CHECK dout1_20 vdout1_20ck91 = 0 time = 920
* CHECK dout1_21 vdout1_21ck91 = 0 time = 920
* CHECK dout1_22 vdout1_22ck91 = 1.7 time = 920
* CHECK dout1_23 vdout1_23ck91 = 0 time = 920
* CHECK dout1_24 vdout1_24ck91 = 0 time = 920
* CHECK dout1_25 vdout1_25ck91 = 1.7 time = 920
* CHECK dout1_26 vdout1_26ck91 = 1.7 time = 920
* CHECK dout1_27 vdout1_27ck91 = 0 time = 920
* CHECK dout1_28 vdout1_28ck91 = 1.7 time = 920
* CHECK dout1_29 vdout1_29ck91 = 1.7 time = 920
* CHECK dout1_30 vdout1_30ck91 = 0 time = 920
* CHECK dout1_31 vdout1_31ck91 = 0 time = 920
* CHECK dout1_32 vdout1_32ck91 = 0 time = 920
* CHECK dout1_0 vdout1_0ck97 = 0 time = 980
* CHECK dout1_1 vdout1_1ck97 = 0 time = 980
* CHECK dout1_2 vdout1_2ck97 = 1.7 time = 980
* CHECK dout1_3 vdout1_3ck97 = 1.7 time = 980
* CHECK dout1_4 vdout1_4ck97 = 0 time = 980
* CHECK dout1_5 vdout1_5ck97 = 1.7 time = 980
* CHECK dout1_6 vdout1_6ck97 = 1.7 time = 980
* CHECK dout1_7 vdout1_7ck97 = 0 time = 980
* CHECK dout1_8 vdout1_8ck97 = 0 time = 980
* CHECK dout1_9 vdout1_9ck97 = 1.7 time = 980
* CHECK dout1_10 vdout1_10ck97 = 1.7 time = 980
* CHECK dout1_11 vdout1_11ck97 = 1.7 time = 980
* CHECK dout1_12 vdout1_12ck97 = 1.7 time = 980
* CHECK dout1_13 vdout1_13ck97 = 1.7 time = 980
* CHECK dout1_14 vdout1_14ck97 = 1.7 time = 980
* CHECK dout1_15 vdout1_15ck97 = 1.7 time = 980
* CHECK dout1_16 vdout1_16ck97 = 1.7 time = 980
* CHECK dout1_17 vdout1_17ck97 = 1.7 time = 980
* CHECK dout1_18 vdout1_18ck97 = 0 time = 980
* CHECK dout1_19 vdout1_19ck97 = 1.7 time = 980
* CHECK dout1_20 vdout1_20ck97 = 1.7 time = 980
* CHECK dout1_21 vdout1_21ck97 = 0 time = 980
* CHECK dout1_22 vdout1_22ck97 = 1.7 time = 980
* CHECK dout1_23 vdout1_23ck97 = 1.7 time = 980
* CHECK dout1_24 vdout1_24ck97 = 0 time = 980
* CHECK dout1_25 vdout1_25ck97 = 0 time = 980
* CHECK dout1_26 vdout1_26ck97 = 1.7 time = 980
* CHECK dout1_27 vdout1_27ck97 = 1.7 time = 980
* CHECK dout1_28 vdout1_28ck97 = 1.7 time = 980
* CHECK dout1_29 vdout1_29ck97 = 0 time = 980
* CHECK dout1_30 vdout1_30ck97 = 0 time = 980
* CHECK dout1_31 vdout1_31ck97 = 0 time = 980
* CHECK dout1_32 vdout1_32ck97 = 0 time = 980
* CHECK dout1_0 vdout1_0ck100 = 1.7 time = 1010
* CHECK dout1_1 vdout1_1ck100 = 0 time = 1010
* CHECK dout1_2 vdout1_2ck100 = 1.7 time = 1010
* CHECK dout1_3 vdout1_3ck100 = 1.7 time = 1010
* CHECK dout1_4 vdout1_4ck100 = 0 time = 1010
* CHECK dout1_5 vdout1_5ck100 = 0 time = 1010
* CHECK dout1_6 vdout1_6ck100 = 0 time = 1010
* CHECK dout1_7 vdout1_7ck100 = 0 time = 1010
* CHECK dout1_8 vdout1_8ck100 = 0 time = 1010
* CHECK dout1_9 vdout1_9ck100 = 0 time = 1010
* CHECK dout1_10 vdout1_10ck100 = 1.7 time = 1010
* CHECK dout1_11 vdout1_11ck100 = 0 time = 1010
* CHECK dout1_12 vdout1_12ck100 = 0 time = 1010
* CHECK dout1_13 vdout1_13ck100 = 0 time = 1010
* CHECK dout1_14 vdout1_14ck100 = 0 time = 1010
* CHECK dout1_15 vdout1_15ck100 = 0 time = 1010
* CHECK dout1_16 vdout1_16ck100 = 0 time = 1010
* CHECK dout1_17 vdout1_17ck100 = 0 time = 1010
* CHECK dout1_18 vdout1_18ck100 = 0 time = 1010
* CHECK dout1_19 vdout1_19ck100 = 0 time = 1010
* CHECK dout1_20 vdout1_20ck100 = 1.7 time = 1010
* CHECK dout1_21 vdout1_21ck100 = 0 time = 1010
* CHECK dout1_22 vdout1_22ck100 = 0 time = 1010
* CHECK dout1_23 vdout1_23ck100 = 0 time = 1010
* CHECK dout1_24 vdout1_24ck100 = 1.7 time = 1010
* CHECK dout1_25 vdout1_25ck100 = 1.7 time = 1010
* CHECK dout1_26 vdout1_26ck100 = 1.7 time = 1010
* CHECK dout1_27 vdout1_27ck100 = 1.7 time = 1010
* CHECK dout1_28 vdout1_28ck100 = 0 time = 1010
* CHECK dout1_29 vdout1_29ck100 = 1.7 time = 1010
* CHECK dout1_30 vdout1_30ck100 = 1.7 time = 1010
* CHECK dout1_31 vdout1_31ck100 = 1.7 time = 1010
* CHECK dout1_32 vdout1_32ck100 = 0 time = 1010
* CHECK dout1_0 vdout1_0ck102 = 1.7 time = 1030
* CHECK dout1_1 vdout1_1ck102 = 0 time = 1030
* CHECK dout1_2 vdout1_2ck102 = 1.7 time = 1030
* CHECK dout1_3 vdout1_3ck102 = 1.7 time = 1030
* CHECK dout1_4 vdout1_4ck102 = 0 time = 1030
* CHECK dout1_5 vdout1_5ck102 = 0 time = 1030
* CHECK dout1_6 vdout1_6ck102 = 0 time = 1030
* CHECK dout1_7 vdout1_7ck102 = 0 time = 1030
* CHECK dout1_8 vdout1_8ck102 = 0 time = 1030
* CHECK dout1_9 vdout1_9ck102 = 0 time = 1030
* CHECK dout1_10 vdout1_10ck102 = 1.7 time = 1030
* CHECK dout1_11 vdout1_11ck102 = 0 time = 1030
* CHECK dout1_12 vdout1_12ck102 = 0 time = 1030
* CHECK dout1_13 vdout1_13ck102 = 0 time = 1030
* CHECK dout1_14 vdout1_14ck102 = 0 time = 1030
* CHECK dout1_15 vdout1_15ck102 = 0 time = 1030
* CHECK dout1_16 vdout1_16ck102 = 0 time = 1030
* CHECK dout1_17 vdout1_17ck102 = 0 time = 1030
* CHECK dout1_18 vdout1_18ck102 = 0 time = 1030
* CHECK dout1_19 vdout1_19ck102 = 0 time = 1030
* CHECK dout1_20 vdout1_20ck102 = 1.7 time = 1030
* CHECK dout1_21 vdout1_21ck102 = 0 time = 1030
* CHECK dout1_22 vdout1_22ck102 = 0 time = 1030
* CHECK dout1_23 vdout1_23ck102 = 0 time = 1030
* CHECK dout1_24 vdout1_24ck102 = 1.7 time = 1030
* CHECK dout1_25 vdout1_25ck102 = 1.7 time = 1030
* CHECK dout1_26 vdout1_26ck102 = 1.7 time = 1030
* CHECK dout1_27 vdout1_27ck102 = 1.7 time = 1030
* CHECK dout1_28 vdout1_28ck102 = 0 time = 1030
* CHECK dout1_29 vdout1_29ck102 = 1.7 time = 1030
* CHECK dout1_30 vdout1_30ck102 = 1.7 time = 1030
* CHECK dout1_31 vdout1_31ck102 = 1.7 time = 1030
* CHECK dout1_32 vdout1_32ck102 = 0 time = 1030
* CHECK dout1_0 vdout1_0ck103 = 1.7 time = 1040
* CHECK dout1_1 vdout1_1ck103 = 0 time = 1040
* CHECK dout1_2 vdout1_2ck103 = 1.7 time = 1040
* CHECK dout1_3 vdout1_3ck103 = 1.7 time = 1040
* CHECK dout1_4 vdout1_4ck103 = 0 time = 1040
* CHECK dout1_5 vdout1_5ck103 = 0 time = 1040
* CHECK dout1_6 vdout1_6ck103 = 0 time = 1040
* CHECK dout1_7 vdout1_7ck103 = 0 time = 1040
* CHECK dout1_8 vdout1_8ck103 = 0 time = 1040
* CHECK dout1_9 vdout1_9ck103 = 0 time = 1040
* CHECK dout1_10 vdout1_10ck103 = 1.7 time = 1040
* CHECK dout1_11 vdout1_11ck103 = 0 time = 1040
* CHECK dout1_12 vdout1_12ck103 = 0 time = 1040
* CHECK dout1_13 vdout1_13ck103 = 0 time = 1040
* CHECK dout1_14 vdout1_14ck103 = 0 time = 1040
* CHECK dout1_15 vdout1_15ck103 = 0 time = 1040
* CHECK dout1_16 vdout1_16ck103 = 0 time = 1040
* CHECK dout1_17 vdout1_17ck103 = 0 time = 1040
* CHECK dout1_18 vdout1_18ck103 = 0 time = 1040
* CHECK dout1_19 vdout1_19ck103 = 0 time = 1040
* CHECK dout1_20 vdout1_20ck103 = 1.7 time = 1040
* CHECK dout1_21 vdout1_21ck103 = 0 time = 1040
* CHECK dout1_22 vdout1_22ck103 = 0 time = 1040
* CHECK dout1_23 vdout1_23ck103 = 0 time = 1040
* CHECK dout1_24 vdout1_24ck103 = 1.7 time = 1040
* CHECK dout1_25 vdout1_25ck103 = 1.7 time = 1040
* CHECK dout1_26 vdout1_26ck103 = 1.7 time = 1040
* CHECK dout1_27 vdout1_27ck103 = 1.7 time = 1040
* CHECK dout1_28 vdout1_28ck103 = 0 time = 1040
* CHECK dout1_29 vdout1_29ck103 = 1.7 time = 1040
* CHECK dout1_30 vdout1_30ck103 = 1.7 time = 1040
* CHECK dout1_31 vdout1_31ck103 = 1.7 time = 1040
* CHECK dout1_32 vdout1_32ck103 = 0 time = 1040
* CHECK dout1_0 vdout1_0ck105 = 0 time = 1060
* CHECK dout1_1 vdout1_1ck105 = 0 time = 1060
* CHECK dout1_2 vdout1_2ck105 = 0 time = 1060
* CHECK dout1_3 vdout1_3ck105 = 0 time = 1060
* CHECK dout1_4 vdout1_4ck105 = 0 time = 1060
* CHECK dout1_5 vdout1_5ck105 = 1.7 time = 1060
* CHECK dout1_6 vdout1_6ck105 = 1.7 time = 1060
* CHECK dout1_7 vdout1_7ck105 = 0 time = 1060
* CHECK dout1_8 vdout1_8ck105 = 1.7 time = 1060
* CHECK dout1_9 vdout1_9ck105 = 1.7 time = 1060
* CHECK dout1_10 vdout1_10ck105 = 0 time = 1060
* CHECK dout1_11 vdout1_11ck105 = 1.7 time = 1060
* CHECK dout1_12 vdout1_12ck105 = 0 time = 1060
* CHECK dout1_13 vdout1_13ck105 = 0 time = 1060
* CHECK dout1_14 vdout1_14ck105 = 0 time = 1060
* CHECK dout1_15 vdout1_15ck105 = 1.7 time = 1060
* CHECK dout1_16 vdout1_16ck105 = 1.7 time = 1060
* CHECK dout1_17 vdout1_17ck105 = 0 time = 1060
* CHECK dout1_18 vdout1_18ck105 = 0 time = 1060
* CHECK dout1_19 vdout1_19ck105 = 0 time = 1060
* CHECK dout1_20 vdout1_20ck105 = 1.7 time = 1060
* CHECK dout1_21 vdout1_21ck105 = 0 time = 1060
* CHECK dout1_22 vdout1_22ck105 = 0 time = 1060
* CHECK dout1_23 vdout1_23ck105 = 0 time = 1060
* CHECK dout1_24 vdout1_24ck105 = 1.7 time = 1060
* CHECK dout1_25 vdout1_25ck105 = 0 time = 1060
* CHECK dout1_26 vdout1_26ck105 = 1.7 time = 1060
* CHECK dout1_27 vdout1_27ck105 = 1.7 time = 1060
* CHECK dout1_28 vdout1_28ck105 = 0 time = 1060
* CHECK dout1_29 vdout1_29ck105 = 1.7 time = 1060
* CHECK dout1_30 vdout1_30ck105 = 1.7 time = 1060
* CHECK dout1_31 vdout1_31ck105 = 0 time = 1060
* CHECK dout1_32 vdout1_32ck105 = 0 time = 1060
* CHECK dout1_0 vdout1_0ck108 = 0 time = 1090
* CHECK dout1_1 vdout1_1ck108 = 1.7 time = 1090
* CHECK dout1_2 vdout1_2ck108 = 1.7 time = 1090
* CHECK dout1_3 vdout1_3ck108 = 1.7 time = 1090
* CHECK dout1_4 vdout1_4ck108 = 1.7 time = 1090
* CHECK dout1_5 vdout1_5ck108 = 0 time = 1090
* CHECK dout1_6 vdout1_6ck108 = 0 time = 1090
* CHECK dout1_7 vdout1_7ck108 = 0 time = 1090
* CHECK dout1_8 vdout1_8ck108 = 1.7 time = 1090
* CHECK dout1_9 vdout1_9ck108 = 1.7 time = 1090
* CHECK dout1_10 vdout1_10ck108 = 1.7 time = 1090
* CHECK dout1_11 vdout1_11ck108 = 1.7 time = 1090
* CHECK dout1_12 vdout1_12ck108 = 1.7 time = 1090
* CHECK dout1_13 vdout1_13ck108 = 1.7 time = 1090
* CHECK dout1_14 vdout1_14ck108 = 0 time = 1090
* CHECK dout1_15 vdout1_15ck108 = 1.7 time = 1090
* CHECK dout1_16 vdout1_16ck108 = 0 time = 1090
* CHECK dout1_17 vdout1_17ck108 = 0 time = 1090
* CHECK dout1_18 vdout1_18ck108 = 0 time = 1090
* CHECK dout1_19 vdout1_19ck108 = 0 time = 1090
* CHECK dout1_20 vdout1_20ck108 = 0 time = 1090
* CHECK dout1_21 vdout1_21ck108 = 1.7 time = 1090
* CHECK dout1_22 vdout1_22ck108 = 1.7 time = 1090
* CHECK dout1_23 vdout1_23ck108 = 1.7 time = 1090
* CHECK dout1_24 vdout1_24ck108 = 1.7 time = 1090
* CHECK dout1_25 vdout1_25ck108 = 0 time = 1090
* CHECK dout1_26 vdout1_26ck108 = 0 time = 1090
* CHECK dout1_27 vdout1_27ck108 = 1.7 time = 1090
* CHECK dout1_28 vdout1_28ck108 = 1.7 time = 1090
* CHECK dout1_29 vdout1_29ck108 = 1.7 time = 1090
* CHECK dout1_30 vdout1_30ck108 = 0 time = 1090
* CHECK dout1_31 vdout1_31ck108 = 0 time = 1090
* CHECK dout1_32 vdout1_32ck108 = 0 time = 1090
* CHECK dout1_0 vdout1_0ck111 = 0 time = 1120
* CHECK dout1_1 vdout1_1ck111 = 1.7 time = 1120
* CHECK dout1_2 vdout1_2ck111 = 1.7 time = 1120
* CHECK dout1_3 vdout1_3ck111 = 1.7 time = 1120
* CHECK dout1_4 vdout1_4ck111 = 1.7 time = 1120
* CHECK dout1_5 vdout1_5ck111 = 0 time = 1120
* CHECK dout1_6 vdout1_6ck111 = 0 time = 1120
* CHECK dout1_7 vdout1_7ck111 = 0 time = 1120
* CHECK dout1_8 vdout1_8ck111 = 1.7 time = 1120
* CHECK dout1_9 vdout1_9ck111 = 1.7 time = 1120
* CHECK dout1_10 vdout1_10ck111 = 1.7 time = 1120
* CHECK dout1_11 vdout1_11ck111 = 1.7 time = 1120
* CHECK dout1_12 vdout1_12ck111 = 1.7 time = 1120
* CHECK dout1_13 vdout1_13ck111 = 1.7 time = 1120
* CHECK dout1_14 vdout1_14ck111 = 0 time = 1120
* CHECK dout1_15 vdout1_15ck111 = 1.7 time = 1120
* CHECK dout1_16 vdout1_16ck111 = 0 time = 1120
* CHECK dout1_17 vdout1_17ck111 = 0 time = 1120
* CHECK dout1_18 vdout1_18ck111 = 0 time = 1120
* CHECK dout1_19 vdout1_19ck111 = 0 time = 1120
* CHECK dout1_20 vdout1_20ck111 = 0 time = 1120
* CHECK dout1_21 vdout1_21ck111 = 1.7 time = 1120
* CHECK dout1_22 vdout1_22ck111 = 1.7 time = 1120
* CHECK dout1_23 vdout1_23ck111 = 1.7 time = 1120
* CHECK dout1_24 vdout1_24ck111 = 1.7 time = 1120
* CHECK dout1_25 vdout1_25ck111 = 0 time = 1120
* CHECK dout1_26 vdout1_26ck111 = 0 time = 1120
* CHECK dout1_27 vdout1_27ck111 = 1.7 time = 1120
* CHECK dout1_28 vdout1_28ck111 = 1.7 time = 1120
* CHECK dout1_29 vdout1_29ck111 = 1.7 time = 1120
* CHECK dout1_30 vdout1_30ck111 = 0 time = 1120
* CHECK dout1_31 vdout1_31ck111 = 0 time = 1120
* CHECK dout1_32 vdout1_32ck111 = 0 time = 1120
* CHECK dout1_0 vdout1_0ck112 = 0 time = 1130
* CHECK dout1_1 vdout1_1ck112 = 1.7 time = 1130
* CHECK dout1_2 vdout1_2ck112 = 1.7 time = 1130
* CHECK dout1_3 vdout1_3ck112 = 1.7 time = 1130
* CHECK dout1_4 vdout1_4ck112 = 1.7 time = 1130
* CHECK dout1_5 vdout1_5ck112 = 0 time = 1130
* CHECK dout1_6 vdout1_6ck112 = 0 time = 1130
* CHECK dout1_7 vdout1_7ck112 = 0 time = 1130
* CHECK dout1_8 vdout1_8ck112 = 1.7 time = 1130
* CHECK dout1_9 vdout1_9ck112 = 1.7 time = 1130
* CHECK dout1_10 vdout1_10ck112 = 1.7 time = 1130
* CHECK dout1_11 vdout1_11ck112 = 1.7 time = 1130
* CHECK dout1_12 vdout1_12ck112 = 1.7 time = 1130
* CHECK dout1_13 vdout1_13ck112 = 1.7 time = 1130
* CHECK dout1_14 vdout1_14ck112 = 0 time = 1130
* CHECK dout1_15 vdout1_15ck112 = 1.7 time = 1130
* CHECK dout1_16 vdout1_16ck112 = 0 time = 1130
* CHECK dout1_17 vdout1_17ck112 = 0 time = 1130
* CHECK dout1_18 vdout1_18ck112 = 0 time = 1130
* CHECK dout1_19 vdout1_19ck112 = 0 time = 1130
* CHECK dout1_20 vdout1_20ck112 = 0 time = 1130
* CHECK dout1_21 vdout1_21ck112 = 1.7 time = 1130
* CHECK dout1_22 vdout1_22ck112 = 1.7 time = 1130
* CHECK dout1_23 vdout1_23ck112 = 1.7 time = 1130
* CHECK dout1_24 vdout1_24ck112 = 1.7 time = 1130
* CHECK dout1_25 vdout1_25ck112 = 0 time = 1130
* CHECK dout1_26 vdout1_26ck112 = 0 time = 1130
* CHECK dout1_27 vdout1_27ck112 = 1.7 time = 1130
* CHECK dout1_28 vdout1_28ck112 = 1.7 time = 1130
* CHECK dout1_29 vdout1_29ck112 = 1.7 time = 1130
* CHECK dout1_30 vdout1_30ck112 = 0 time = 1130
* CHECK dout1_31 vdout1_31ck112 = 0 time = 1130
* CHECK dout1_32 vdout1_32ck112 = 0 time = 1130
* CHECK dout1_0 vdout1_0ck114 = 0 time = 1150
* CHECK dout1_1 vdout1_1ck114 = 1.7 time = 1150
* CHECK dout1_2 vdout1_2ck114 = 1.7 time = 1150
* CHECK dout1_3 vdout1_3ck114 = 1.7 time = 1150
* CHECK dout1_4 vdout1_4ck114 = 1.7 time = 1150
* CHECK dout1_5 vdout1_5ck114 = 0 time = 1150
* CHECK dout1_6 vdout1_6ck114 = 0 time = 1150
* CHECK dout1_7 vdout1_7ck114 = 0 time = 1150
* CHECK dout1_8 vdout1_8ck114 = 1.7 time = 1150
* CHECK dout1_9 vdout1_9ck114 = 1.7 time = 1150
* CHECK dout1_10 vdout1_10ck114 = 1.7 time = 1150
* CHECK dout1_11 vdout1_11ck114 = 1.7 time = 1150
* CHECK dout1_12 vdout1_12ck114 = 1.7 time = 1150
* CHECK dout1_13 vdout1_13ck114 = 1.7 time = 1150
* CHECK dout1_14 vdout1_14ck114 = 0 time = 1150
* CHECK dout1_15 vdout1_15ck114 = 1.7 time = 1150
* CHECK dout1_16 vdout1_16ck114 = 0 time = 1150
* CHECK dout1_17 vdout1_17ck114 = 0 time = 1150
* CHECK dout1_18 vdout1_18ck114 = 0 time = 1150
* CHECK dout1_19 vdout1_19ck114 = 0 time = 1150
* CHECK dout1_20 vdout1_20ck114 = 0 time = 1150
* CHECK dout1_21 vdout1_21ck114 = 1.7 time = 1150
* CHECK dout1_22 vdout1_22ck114 = 1.7 time = 1150
* CHECK dout1_23 vdout1_23ck114 = 1.7 time = 1150
* CHECK dout1_24 vdout1_24ck114 = 1.7 time = 1150
* CHECK dout1_25 vdout1_25ck114 = 0 time = 1150
* CHECK dout1_26 vdout1_26ck114 = 0 time = 1150
* CHECK dout1_27 vdout1_27ck114 = 1.7 time = 1150
* CHECK dout1_28 vdout1_28ck114 = 1.7 time = 1150
* CHECK dout1_29 vdout1_29ck114 = 1.7 time = 1150
* CHECK dout1_30 vdout1_30ck114 = 0 time = 1150
* CHECK dout1_31 vdout1_31ck114 = 0 time = 1150
* CHECK dout1_32 vdout1_32ck114 = 0 time = 1150
* CHECK dout1_0 vdout1_0ck120 = 1.7 time = 1210
* CHECK dout1_1 vdout1_1ck120 = 1.7 time = 1210
* CHECK dout1_2 vdout1_2ck120 = 1.7 time = 1210
* CHECK dout1_3 vdout1_3ck120 = 0 time = 1210
* CHECK dout1_4 vdout1_4ck120 = 0 time = 1210
* CHECK dout1_5 vdout1_5ck120 = 0 time = 1210
* CHECK dout1_6 vdout1_6ck120 = 1.7 time = 1210
* CHECK dout1_7 vdout1_7ck120 = 1.7 time = 1210
* CHECK dout1_8 vdout1_8ck120 = 0 time = 1210
* CHECK dout1_9 vdout1_9ck120 = 1.7 time = 1210
* CHECK dout1_10 vdout1_10ck120 = 0 time = 1210
* CHECK dout1_11 vdout1_11ck120 = 1.7 time = 1210
* CHECK dout1_12 vdout1_12ck120 = 1.7 time = 1210
* CHECK dout1_13 vdout1_13ck120 = 1.7 time = 1210
* CHECK dout1_14 vdout1_14ck120 = 1.7 time = 1210
* CHECK dout1_15 vdout1_15ck120 = 1.7 time = 1210
* CHECK dout1_16 vdout1_16ck120 = 1.7 time = 1210
* CHECK dout1_17 vdout1_17ck120 = 1.7 time = 1210
* CHECK dout1_18 vdout1_18ck120 = 0 time = 1210
* CHECK dout1_19 vdout1_19ck120 = 0 time = 1210
* CHECK dout1_20 vdout1_20ck120 = 1.7 time = 1210
* CHECK dout1_21 vdout1_21ck120 = 1.7 time = 1210
* CHECK dout1_22 vdout1_22ck120 = 1.7 time = 1210
* CHECK dout1_23 vdout1_23ck120 = 0 time = 1210
* CHECK dout1_24 vdout1_24ck120 = 1.7 time = 1210
* CHECK dout1_25 vdout1_25ck120 = 0 time = 1210
* CHECK dout1_26 vdout1_26ck120 = 1.7 time = 1210
* CHECK dout1_27 vdout1_27ck120 = 0 time = 1210
* CHECK dout1_28 vdout1_28ck120 = 0 time = 1210
* CHECK dout1_29 vdout1_29ck120 = 1.7 time = 1210
* CHECK dout1_30 vdout1_30ck120 = 0 time = 1210
* CHECK dout1_31 vdout1_31ck120 = 0 time = 1210
* CHECK dout1_32 vdout1_32ck120 = 0 time = 1210
* CHECK dout1_0 vdout1_0ck121 = 1.7 time = 1220
* CHECK dout1_1 vdout1_1ck121 = 1.7 time = 1220
* CHECK dout1_2 vdout1_2ck121 = 1.7 time = 1220
* CHECK dout1_3 vdout1_3ck121 = 0 time = 1220
* CHECK dout1_4 vdout1_4ck121 = 0 time = 1220
* CHECK dout1_5 vdout1_5ck121 = 0 time = 1220
* CHECK dout1_6 vdout1_6ck121 = 1.7 time = 1220
* CHECK dout1_7 vdout1_7ck121 = 1.7 time = 1220
* CHECK dout1_8 vdout1_8ck121 = 0 time = 1220
* CHECK dout1_9 vdout1_9ck121 = 1.7 time = 1220
* CHECK dout1_10 vdout1_10ck121 = 0 time = 1220
* CHECK dout1_11 vdout1_11ck121 = 1.7 time = 1220
* CHECK dout1_12 vdout1_12ck121 = 1.7 time = 1220
* CHECK dout1_13 vdout1_13ck121 = 1.7 time = 1220
* CHECK dout1_14 vdout1_14ck121 = 1.7 time = 1220
* CHECK dout1_15 vdout1_15ck121 = 1.7 time = 1220
* CHECK dout1_16 vdout1_16ck121 = 1.7 time = 1220
* CHECK dout1_17 vdout1_17ck121 = 1.7 time = 1220
* CHECK dout1_18 vdout1_18ck121 = 0 time = 1220
* CHECK dout1_19 vdout1_19ck121 = 0 time = 1220
* CHECK dout1_20 vdout1_20ck121 = 1.7 time = 1220
* CHECK dout1_21 vdout1_21ck121 = 1.7 time = 1220
* CHECK dout1_22 vdout1_22ck121 = 1.7 time = 1220
* CHECK dout1_23 vdout1_23ck121 = 0 time = 1220
* CHECK dout1_24 vdout1_24ck121 = 1.7 time = 1220
* CHECK dout1_25 vdout1_25ck121 = 0 time = 1220
* CHECK dout1_26 vdout1_26ck121 = 1.7 time = 1220
* CHECK dout1_27 vdout1_27ck121 = 0 time = 1220
* CHECK dout1_28 vdout1_28ck121 = 0 time = 1220
* CHECK dout1_29 vdout1_29ck121 = 1.7 time = 1220
* CHECK dout1_30 vdout1_30ck121 = 0 time = 1220
* CHECK dout1_31 vdout1_31ck121 = 0 time = 1220
* CHECK dout1_32 vdout1_32ck121 = 0 time = 1220
* CHECK dout1_0 vdout1_0ck123 = 0 time = 1240
* CHECK dout1_1 vdout1_1ck123 = 0 time = 1240
* CHECK dout1_2 vdout1_2ck123 = 1.7 time = 1240
* CHECK dout1_3 vdout1_3ck123 = 1.7 time = 1240
* CHECK dout1_4 vdout1_4ck123 = 0 time = 1240
* CHECK dout1_5 vdout1_5ck123 = 1.7 time = 1240
* CHECK dout1_6 vdout1_6ck123 = 0 time = 1240
* CHECK dout1_7 vdout1_7ck123 = 0 time = 1240
* CHECK dout1_8 vdout1_8ck123 = 1.7 time = 1240
* CHECK dout1_9 vdout1_9ck123 = 1.7 time = 1240
* CHECK dout1_10 vdout1_10ck123 = 0 time = 1240
* CHECK dout1_11 vdout1_11ck123 = 1.7 time = 1240
* CHECK dout1_12 vdout1_12ck123 = 0 time = 1240
* CHECK dout1_13 vdout1_13ck123 = 0 time = 1240
* CHECK dout1_14 vdout1_14ck123 = 0 time = 1240
* CHECK dout1_15 vdout1_15ck123 = 1.7 time = 1240
* CHECK dout1_16 vdout1_16ck123 = 0 time = 1240
* CHECK dout1_17 vdout1_17ck123 = 0 time = 1240
* CHECK dout1_18 vdout1_18ck123 = 0 time = 1240
* CHECK dout1_19 vdout1_19ck123 = 1.7 time = 1240
* CHECK dout1_20 vdout1_20ck123 = 0 time = 1240
* CHECK dout1_21 vdout1_21ck123 = 1.7 time = 1240
* CHECK dout1_22 vdout1_22ck123 = 1.7 time = 1240
* CHECK dout1_23 vdout1_23ck123 = 0 time = 1240
* CHECK dout1_24 vdout1_24ck123 = 0 time = 1240
* CHECK dout1_25 vdout1_25ck123 = 0 time = 1240
* CHECK dout1_26 vdout1_26ck123 = 1.7 time = 1240
* CHECK dout1_27 vdout1_27ck123 = 1.7 time = 1240
* CHECK dout1_28 vdout1_28ck123 = 1.7 time = 1240
* CHECK dout1_29 vdout1_29ck123 = 1.7 time = 1240
* CHECK dout1_30 vdout1_30ck123 = 0 time = 1240
* CHECK dout1_31 vdout1_31ck123 = 1.7 time = 1240
* CHECK dout1_32 vdout1_32ck123 = 0 time = 1240
* CHECK dout1_0 vdout1_0ck125 = 0 time = 1260
* CHECK dout1_1 vdout1_1ck125 = 1.7 time = 1260
* CHECK dout1_2 vdout1_2ck125 = 1.7 time = 1260
* CHECK dout1_3 vdout1_3ck125 = 1.7 time = 1260
* CHECK dout1_4 vdout1_4ck125 = 0 time = 1260
* CHECK dout1_5 vdout1_5ck125 = 0 time = 1260
* CHECK dout1_6 vdout1_6ck125 = 0 time = 1260
* CHECK dout1_7 vdout1_7ck125 = 1.7 time = 1260
* CHECK dout1_8 vdout1_8ck125 = 0 time = 1260
* CHECK dout1_9 vdout1_9ck125 = 1.7 time = 1260
* CHECK dout1_10 vdout1_10ck125 = 0 time = 1260
* CHECK dout1_11 vdout1_11ck125 = 1.7 time = 1260
* CHECK dout1_12 vdout1_12ck125 = 0 time = 1260
* CHECK dout1_13 vdout1_13ck125 = 1.7 time = 1260
* CHECK dout1_14 vdout1_14ck125 = 1.7 time = 1260
* CHECK dout1_15 vdout1_15ck125 = 0 time = 1260
* CHECK dout1_16 vdout1_16ck125 = 0 time = 1260
* CHECK dout1_17 vdout1_17ck125 = 1.7 time = 1260
* CHECK dout1_18 vdout1_18ck125 = 1.7 time = 1260
* CHECK dout1_19 vdout1_19ck125 = 1.7 time = 1260
* CHECK dout1_20 vdout1_20ck125 = 1.7 time = 1260
* CHECK dout1_21 vdout1_21ck125 = 0 time = 1260
* CHECK dout1_22 vdout1_22ck125 = 1.7 time = 1260
* CHECK dout1_23 vdout1_23ck125 = 0 time = 1260
* CHECK dout1_24 vdout1_24ck125 = 1.7 time = 1260
* CHECK dout1_25 vdout1_25ck125 = 1.7 time = 1260
* CHECK dout1_26 vdout1_26ck125 = 0 time = 1260
* CHECK dout1_27 vdout1_27ck125 = 1.7 time = 1260
* CHECK dout1_28 vdout1_28ck125 = 1.7 time = 1260
* CHECK dout1_29 vdout1_29ck125 = 0 time = 1260
* CHECK dout1_30 vdout1_30ck125 = 1.7 time = 1260
* CHECK dout1_31 vdout1_31ck125 = 0 time = 1260
* CHECK dout1_32 vdout1_32ck125 = 0 time = 1260
* CHECK dout1_0 vdout1_0ck128 = 0 time = 1290
* CHECK dout1_1 vdout1_1ck128 = 0 time = 1290
* CHECK dout1_2 vdout1_2ck128 = 1.7 time = 1290
* CHECK dout1_3 vdout1_3ck128 = 0 time = 1290
* CHECK dout1_4 vdout1_4ck128 = 0 time = 1290
* CHECK dout1_5 vdout1_5ck128 = 1.7 time = 1290
* CHECK dout1_6 vdout1_6ck128 = 1.7 time = 1290
* CHECK dout1_7 vdout1_7ck128 = 1.7 time = 1290
* CHECK dout1_8 vdout1_8ck128 = 1.7 time = 1290
* CHECK dout1_9 vdout1_9ck128 = 1.7 time = 1290
* CHECK dout1_10 vdout1_10ck128 = 0 time = 1290
* CHECK dout1_11 vdout1_11ck128 = 0 time = 1290
* CHECK dout1_12 vdout1_12ck128 = 0 time = 1290
* CHECK dout1_13 vdout1_13ck128 = 1.7 time = 1290
* CHECK dout1_14 vdout1_14ck128 = 0 time = 1290
* CHECK dout1_15 vdout1_15ck128 = 0 time = 1290
* CHECK dout1_16 vdout1_16ck128 = 1.7 time = 1290
* CHECK dout1_17 vdout1_17ck128 = 0 time = 1290
* CHECK dout1_18 vdout1_18ck128 = 0 time = 1290
* CHECK dout1_19 vdout1_19ck128 = 0 time = 1290
* CHECK dout1_20 vdout1_20ck128 = 0 time = 1290
* CHECK dout1_21 vdout1_21ck128 = 1.7 time = 1290
* CHECK dout1_22 vdout1_22ck128 = 1.7 time = 1290
* CHECK dout1_23 vdout1_23ck128 = 0 time = 1290
* CHECK dout1_24 vdout1_24ck128 = 0 time = 1290
* CHECK dout1_25 vdout1_25ck128 = 1.7 time = 1290
* CHECK dout1_26 vdout1_26ck128 = 0 time = 1290
* CHECK dout1_27 vdout1_27ck128 = 1.7 time = 1290
* CHECK dout1_28 vdout1_28ck128 = 1.7 time = 1290
* CHECK dout1_29 vdout1_29ck128 = 1.7 time = 1290
* CHECK dout1_30 vdout1_30ck128 = 0 time = 1290
* CHECK dout1_31 vdout1_31ck128 = 0 time = 1290
* CHECK dout1_32 vdout1_32ck128 = 0 time = 1290
* CHECK dout1_0 vdout1_0ck139 = 1.7 time = 1400
* CHECK dout1_1 vdout1_1ck139 = 1.7 time = 1400
* CHECK dout1_2 vdout1_2ck139 = 1.7 time = 1400
* CHECK dout1_3 vdout1_3ck139 = 0 time = 1400
* CHECK dout1_4 vdout1_4ck139 = 0 time = 1400
* CHECK dout1_5 vdout1_5ck139 = 0 time = 1400
* CHECK dout1_6 vdout1_6ck139 = 1.7 time = 1400
* CHECK dout1_7 vdout1_7ck139 = 0 time = 1400
* CHECK dout1_8 vdout1_8ck139 = 0 time = 1400
* CHECK dout1_9 vdout1_9ck139 = 0 time = 1400
* CHECK dout1_10 vdout1_10ck139 = 0 time = 1400
* CHECK dout1_11 vdout1_11ck139 = 1.7 time = 1400
* CHECK dout1_12 vdout1_12ck139 = 0 time = 1400
* CHECK dout1_13 vdout1_13ck139 = 0 time = 1400
* CHECK dout1_14 vdout1_14ck139 = 1.7 time = 1400
* CHECK dout1_15 vdout1_15ck139 = 1.7 time = 1400
* CHECK dout1_16 vdout1_16ck139 = 0 time = 1400
* CHECK dout1_17 vdout1_17ck139 = 0 time = 1400
* CHECK dout1_18 vdout1_18ck139 = 0 time = 1400
* CHECK dout1_19 vdout1_19ck139 = 1.7 time = 1400
* CHECK dout1_20 vdout1_20ck139 = 0 time = 1400
* CHECK dout1_21 vdout1_21ck139 = 1.7 time = 1400
* CHECK dout1_22 vdout1_22ck139 = 1.7 time = 1400
* CHECK dout1_23 vdout1_23ck139 = 0 time = 1400
* CHECK dout1_24 vdout1_24ck139 = 0 time = 1400
* CHECK dout1_25 vdout1_25ck139 = 0 time = 1400
* CHECK dout1_26 vdout1_26ck139 = 0 time = 1400
* CHECK dout1_27 vdout1_27ck139 = 0 time = 1400
* CHECK dout1_28 vdout1_28ck139 = 0 time = 1400
* CHECK dout1_29 vdout1_29ck139 = 1.7 time = 1400
* CHECK dout1_30 vdout1_30ck139 = 0 time = 1400
* CHECK dout1_31 vdout1_31ck139 = 0 time = 1400
* CHECK dout1_32 vdout1_32ck139 = 0 time = 1400
* CHECK dout1_0 vdout1_0ck143 = 0 time = 1440
* CHECK dout1_1 vdout1_1ck143 = 1.7 time = 1440
* CHECK dout1_2 vdout1_2ck143 = 0 time = 1440
* CHECK dout1_3 vdout1_3ck143 = 1.7 time = 1440
* CHECK dout1_4 vdout1_4ck143 = 1.7 time = 1440
* CHECK dout1_5 vdout1_5ck143 = 1.7 time = 1440
* CHECK dout1_6 vdout1_6ck143 = 1.7 time = 1440
* CHECK dout1_7 vdout1_7ck143 = 1.7 time = 1440
* CHECK dout1_8 vdout1_8ck143 = 0 time = 1440
* CHECK dout1_9 vdout1_9ck143 = 1.7 time = 1440
* CHECK dout1_10 vdout1_10ck143 = 1.7 time = 1440
* CHECK dout1_11 vdout1_11ck143 = 0 time = 1440
* CHECK dout1_12 vdout1_12ck143 = 0 time = 1440
* CHECK dout1_13 vdout1_13ck143 = 1.7 time = 1440
* CHECK dout1_14 vdout1_14ck143 = 0 time = 1440
* CHECK dout1_15 vdout1_15ck143 = 0 time = 1440
* CHECK dout1_16 vdout1_16ck143 = 1.7 time = 1440
* CHECK dout1_17 vdout1_17ck143 = 1.7 time = 1440
* CHECK dout1_18 vdout1_18ck143 = 0 time = 1440
* CHECK dout1_19 vdout1_19ck143 = 0 time = 1440
* CHECK dout1_20 vdout1_20ck143 = 1.7 time = 1440
* CHECK dout1_21 vdout1_21ck143 = 1.7 time = 1440
* CHECK dout1_22 vdout1_22ck143 = 0 time = 1440
* CHECK dout1_23 vdout1_23ck143 = 1.7 time = 1440
* CHECK dout1_24 vdout1_24ck143 = 1.7 time = 1440
* CHECK dout1_25 vdout1_25ck143 = 1.7 time = 1440
* CHECK dout1_26 vdout1_26ck143 = 1.7 time = 1440
* CHECK dout1_27 vdout1_27ck143 = 1.7 time = 1440
* CHECK dout1_28 vdout1_28ck143 = 1.7 time = 1440
* CHECK dout1_29 vdout1_29ck143 = 1.7 time = 1440
* CHECK dout1_30 vdout1_30ck143 = 0 time = 1440
* CHECK dout1_31 vdout1_31ck143 = 1.7 time = 1440
* CHECK dout1_32 vdout1_32ck143 = 0 time = 1440
* CHECK dout1_0 vdout1_0ck150 = 0 time = 1510
* CHECK dout1_1 vdout1_1ck150 = 1.7 time = 1510
* CHECK dout1_2 vdout1_2ck150 = 1.7 time = 1510
* CHECK dout1_3 vdout1_3ck150 = 1.7 time = 1510
* CHECK dout1_4 vdout1_4ck150 = 0 time = 1510
* CHECK dout1_5 vdout1_5ck150 = 0 time = 1510
* CHECK dout1_6 vdout1_6ck150 = 1.7 time = 1510
* CHECK dout1_7 vdout1_7ck150 = 1.7 time = 1510
* CHECK dout1_8 vdout1_8ck150 = 1.7 time = 1510
* CHECK dout1_9 vdout1_9ck150 = 1.7 time = 1510
* CHECK dout1_10 vdout1_10ck150 = 0 time = 1510
* CHECK dout1_11 vdout1_11ck150 = 1.7 time = 1510
* CHECK dout1_12 vdout1_12ck150 = 0 time = 1510
* CHECK dout1_13 vdout1_13ck150 = 0 time = 1510
* CHECK dout1_14 vdout1_14ck150 = 0 time = 1510
* CHECK dout1_15 vdout1_15ck150 = 0 time = 1510
* CHECK dout1_16 vdout1_16ck150 = 0 time = 1510
* CHECK dout1_17 vdout1_17ck150 = 1.7 time = 1510
* CHECK dout1_18 vdout1_18ck150 = 0 time = 1510
* CHECK dout1_19 vdout1_19ck150 = 1.7 time = 1510
* CHECK dout1_20 vdout1_20ck150 = 0 time = 1510
* CHECK dout1_21 vdout1_21ck150 = 0 time = 1510
* CHECK dout1_22 vdout1_22ck150 = 0 time = 1510
* CHECK dout1_23 vdout1_23ck150 = 1.7 time = 1510
* CHECK dout1_24 vdout1_24ck150 = 0 time = 1510
* CHECK dout1_25 vdout1_25ck150 = 1.7 time = 1510
* CHECK dout1_26 vdout1_26ck150 = 1.7 time = 1510
* CHECK dout1_27 vdout1_27ck150 = 0 time = 1510
* CHECK dout1_28 vdout1_28ck150 = 0 time = 1510
* CHECK dout1_29 vdout1_29ck150 = 1.7 time = 1510
* CHECK dout1_30 vdout1_30ck150 = 0 time = 1510
* CHECK dout1_31 vdout1_31ck150 = 0 time = 1510
* CHECK dout1_32 vdout1_32ck150 = 0 time = 1510
* CHECK dout1_0 vdout1_0ck152 = 0 time = 1530
* CHECK dout1_1 vdout1_1ck152 = 0 time = 1530
* CHECK dout1_2 vdout1_2ck152 = 1.7 time = 1530
* CHECK dout1_3 vdout1_3ck152 = 1.7 time = 1530
* CHECK dout1_4 vdout1_4ck152 = 1.7 time = 1530
* CHECK dout1_5 vdout1_5ck152 = 1.7 time = 1530
* CHECK dout1_6 vdout1_6ck152 = 0 time = 1530
* CHECK dout1_7 vdout1_7ck152 = 1.7 time = 1530
* CHECK dout1_8 vdout1_8ck152 = 0 time = 1530
* CHECK dout1_9 vdout1_9ck152 = 1.7 time = 1530
* CHECK dout1_10 vdout1_10ck152 = 1.7 time = 1530
* CHECK dout1_11 vdout1_11ck152 = 0 time = 1530
* CHECK dout1_12 vdout1_12ck152 = 1.7 time = 1530
* CHECK dout1_13 vdout1_13ck152 = 1.7 time = 1530
* CHECK dout1_14 vdout1_14ck152 = 0 time = 1530
* CHECK dout1_15 vdout1_15ck152 = 0 time = 1530
* CHECK dout1_16 vdout1_16ck152 = 0 time = 1530
* CHECK dout1_17 vdout1_17ck152 = 1.7 time = 1530
* CHECK dout1_18 vdout1_18ck152 = 1.7 time = 1530
* CHECK dout1_19 vdout1_19ck152 = 0 time = 1530
* CHECK dout1_20 vdout1_20ck152 = 1.7 time = 1530
* CHECK dout1_21 vdout1_21ck152 = 1.7 time = 1530
* CHECK dout1_22 vdout1_22ck152 = 1.7 time = 1530
* CHECK dout1_23 vdout1_23ck152 = 1.7 time = 1530
* CHECK dout1_24 vdout1_24ck152 = 0 time = 1530
* CHECK dout1_25 vdout1_25ck152 = 1.7 time = 1530
* CHECK dout1_26 vdout1_26ck152 = 1.7 time = 1530
* CHECK dout1_27 vdout1_27ck152 = 1.7 time = 1530
* CHECK dout1_28 vdout1_28ck152 = 0 time = 1530
* CHECK dout1_29 vdout1_29ck152 = 1.7 time = 1530
* CHECK dout1_30 vdout1_30ck152 = 0 time = 1530
* CHECK dout1_31 vdout1_31ck152 = 0 time = 1530
* CHECK dout1_32 vdout1_32ck152 = 0 time = 1530
* CHECK dout1_0 vdout1_0ck153 = 0 time = 1540
* CHECK dout1_1 vdout1_1ck153 = 0 time = 1540
* CHECK dout1_2 vdout1_2ck153 = 1.7 time = 1540
* CHECK dout1_3 vdout1_3ck153 = 1.7 time = 1540
* CHECK dout1_4 vdout1_4ck153 = 1.7 time = 1540
* CHECK dout1_5 vdout1_5ck153 = 1.7 time = 1540
* CHECK dout1_6 vdout1_6ck153 = 0 time = 1540
* CHECK dout1_7 vdout1_7ck153 = 1.7 time = 1540
* CHECK dout1_8 vdout1_8ck153 = 0 time = 1540
* CHECK dout1_9 vdout1_9ck153 = 1.7 time = 1540
* CHECK dout1_10 vdout1_10ck153 = 1.7 time = 1540
* CHECK dout1_11 vdout1_11ck153 = 0 time = 1540
* CHECK dout1_12 vdout1_12ck153 = 1.7 time = 1540
* CHECK dout1_13 vdout1_13ck153 = 1.7 time = 1540
* CHECK dout1_14 vdout1_14ck153 = 0 time = 1540
* CHECK dout1_15 vdout1_15ck153 = 0 time = 1540
* CHECK dout1_16 vdout1_16ck153 = 0 time = 1540
* CHECK dout1_17 vdout1_17ck153 = 1.7 time = 1540
* CHECK dout1_18 vdout1_18ck153 = 1.7 time = 1540
* CHECK dout1_19 vdout1_19ck153 = 0 time = 1540
* CHECK dout1_20 vdout1_20ck153 = 1.7 time = 1540
* CHECK dout1_21 vdout1_21ck153 = 1.7 time = 1540
* CHECK dout1_22 vdout1_22ck153 = 1.7 time = 1540
* CHECK dout1_23 vdout1_23ck153 = 1.7 time = 1540
* CHECK dout1_24 vdout1_24ck153 = 0 time = 1540
* CHECK dout1_25 vdout1_25ck153 = 1.7 time = 1540
* CHECK dout1_26 vdout1_26ck153 = 1.7 time = 1540
* CHECK dout1_27 vdout1_27ck153 = 1.7 time = 1540
* CHECK dout1_28 vdout1_28ck153 = 0 time = 1540
* CHECK dout1_29 vdout1_29ck153 = 1.7 time = 1540
* CHECK dout1_30 vdout1_30ck153 = 0 time = 1540
* CHECK dout1_31 vdout1_31ck153 = 0 time = 1540
* CHECK dout1_32 vdout1_32ck153 = 0 time = 1540
* CHECK dout1_0 vdout1_0ck156 = 0 time = 1570
* CHECK dout1_1 vdout1_1ck156 = 0 time = 1570
* CHECK dout1_2 vdout1_2ck156 = 0 time = 1570
* CHECK dout1_3 vdout1_3ck156 = 0 time = 1570
* CHECK dout1_4 vdout1_4ck156 = 0 time = 1570
* CHECK dout1_5 vdout1_5ck156 = 1.7 time = 1570
* CHECK dout1_6 vdout1_6ck156 = 0 time = 1570
* CHECK dout1_7 vdout1_7ck156 = 1.7 time = 1570
* CHECK dout1_8 vdout1_8ck156 = 0 time = 1570
* CHECK dout1_9 vdout1_9ck156 = 0 time = 1570
* CHECK dout1_10 vdout1_10ck156 = 0 time = 1570
* CHECK dout1_11 vdout1_11ck156 = 1.7 time = 1570
* CHECK dout1_12 vdout1_12ck156 = 0 time = 1570
* CHECK dout1_13 vdout1_13ck156 = 1.7 time = 1570
* CHECK dout1_14 vdout1_14ck156 = 1.7 time = 1570
* CHECK dout1_15 vdout1_15ck156 = 1.7 time = 1570
* CHECK dout1_16 vdout1_16ck156 = 0 time = 1570
* CHECK dout1_17 vdout1_17ck156 = 0 time = 1570
* CHECK dout1_18 vdout1_18ck156 = 0 time = 1570
* CHECK dout1_19 vdout1_19ck156 = 1.7 time = 1570
* CHECK dout1_20 vdout1_20ck156 = 0 time = 1570
* CHECK dout1_21 vdout1_21ck156 = 0 time = 1570
* CHECK dout1_22 vdout1_22ck156 = 0 time = 1570
* CHECK dout1_23 vdout1_23ck156 = 1.7 time = 1570
* CHECK dout1_24 vdout1_24ck156 = 0 time = 1570
* CHECK dout1_25 vdout1_25ck156 = 1.7 time = 1570
* CHECK dout1_26 vdout1_26ck156 = 0 time = 1570
* CHECK dout1_27 vdout1_27ck156 = 1.7 time = 1570
* CHECK dout1_28 vdout1_28ck156 = 1.7 time = 1570
* CHECK dout1_29 vdout1_29ck156 = 0 time = 1570
* CHECK dout1_30 vdout1_30ck156 = 0 time = 1570
* CHECK dout1_31 vdout1_31ck156 = 0 time = 1570
* CHECK dout1_32 vdout1_32ck156 = 0 time = 1570
* CHECK dout1_0 vdout1_0ck160 = 0 time = 1610
* CHECK dout1_1 vdout1_1ck160 = 0 time = 1610
* CHECK dout1_2 vdout1_2ck160 = 0 time = 1610
* CHECK dout1_3 vdout1_3ck160 = 0 time = 1610
* CHECK dout1_4 vdout1_4ck160 = 0 time = 1610
* CHECK dout1_5 vdout1_5ck160 = 1.7 time = 1610
* CHECK dout1_6 vdout1_6ck160 = 1.7 time = 1610
* CHECK dout1_7 vdout1_7ck160 = 1.7 time = 1610
* CHECK dout1_8 vdout1_8ck160 = 0 time = 1610
* CHECK dout1_9 vdout1_9ck160 = 0 time = 1610
* CHECK dout1_10 vdout1_10ck160 = 1.7 time = 1610
* CHECK dout1_11 vdout1_11ck160 = 0 time = 1610
* CHECK dout1_12 vdout1_12ck160 = 1.7 time = 1610
* CHECK dout1_13 vdout1_13ck160 = 1.7 time = 1610
* CHECK dout1_14 vdout1_14ck160 = 0 time = 1610
* CHECK dout1_15 vdout1_15ck160 = 1.7 time = 1610
* CHECK dout1_16 vdout1_16ck160 = 0 time = 1610
* CHECK dout1_17 vdout1_17ck160 = 1.7 time = 1610
* CHECK dout1_18 vdout1_18ck160 = 0 time = 1610
* CHECK dout1_19 vdout1_19ck160 = 0 time = 1610
* CHECK dout1_20 vdout1_20ck160 = 0 time = 1610
* CHECK dout1_21 vdout1_21ck160 = 1.7 time = 1610
* CHECK dout1_22 vdout1_22ck160 = 1.7 time = 1610
* CHECK dout1_23 vdout1_23ck160 = 0 time = 1610
* CHECK dout1_24 vdout1_24ck160 = 0 time = 1610
* CHECK dout1_25 vdout1_25ck160 = 1.7 time = 1610
* CHECK dout1_26 vdout1_26ck160 = 0 time = 1610
* CHECK dout1_27 vdout1_27ck160 = 0 time = 1610
* CHECK dout1_28 vdout1_28ck160 = 1.7 time = 1610
* CHECK dout1_29 vdout1_29ck160 = 1.7 time = 1610
* CHECK dout1_30 vdout1_30ck160 = 1.7 time = 1610
* CHECK dout1_31 vdout1_31ck160 = 0 time = 1610
* CHECK dout1_32 vdout1_32ck160 = 0 time = 1610
* CHECK dout1_0 vdout1_0ck162 = 1.7 time = 1630
* CHECK dout1_1 vdout1_1ck162 = 1.7 time = 1630
* CHECK dout1_2 vdout1_2ck162 = 0 time = 1630
* CHECK dout1_3 vdout1_3ck162 = 0 time = 1630
* CHECK dout1_4 vdout1_4ck162 = 0 time = 1630
* CHECK dout1_5 vdout1_5ck162 = 1.7 time = 1630
* CHECK dout1_6 vdout1_6ck162 = 1.7 time = 1630
* CHECK dout1_7 vdout1_7ck162 = 1.7 time = 1630
* CHECK dout1_8 vdout1_8ck162 = 1.7 time = 1630
* CHECK dout1_9 vdout1_9ck162 = 1.7 time = 1630
* CHECK dout1_10 vdout1_10ck162 = 0 time = 1630
* CHECK dout1_11 vdout1_11ck162 = 1.7 time = 1630
* CHECK dout1_12 vdout1_12ck162 = 0 time = 1630
* CHECK dout1_13 vdout1_13ck162 = 0 time = 1630
* CHECK dout1_14 vdout1_14ck162 = 0 time = 1630
* CHECK dout1_15 vdout1_15ck162 = 0 time = 1630
* CHECK dout1_16 vdout1_16ck162 = 0 time = 1630
* CHECK dout1_17 vdout1_17ck162 = 1.7 time = 1630
* CHECK dout1_18 vdout1_18ck162 = 1.7 time = 1630
* CHECK dout1_19 vdout1_19ck162 = 0 time = 1630
* CHECK dout1_20 vdout1_20ck162 = 0 time = 1630
* CHECK dout1_21 vdout1_21ck162 = 0 time = 1630
* CHECK dout1_22 vdout1_22ck162 = 1.7 time = 1630
* CHECK dout1_23 vdout1_23ck162 = 0 time = 1630
* CHECK dout1_24 vdout1_24ck162 = 0 time = 1630
* CHECK dout1_25 vdout1_25ck162 = 0 time = 1630
* CHECK dout1_26 vdout1_26ck162 = 0 time = 1630
* CHECK dout1_27 vdout1_27ck162 = 0 time = 1630
* CHECK dout1_28 vdout1_28ck162 = 1.7 time = 1630
* CHECK dout1_29 vdout1_29ck162 = 1.7 time = 1630
* CHECK dout1_30 vdout1_30ck162 = 1.7 time = 1630
* CHECK dout1_31 vdout1_31ck162 = 0 time = 1630
* CHECK dout1_32 vdout1_32ck162 = 0 time = 1630
* CHECK dout1_0 vdout1_0ck170 = 1.7 time = 1710
* CHECK dout1_1 vdout1_1ck170 = 0 time = 1710
* CHECK dout1_2 vdout1_2ck170 = 0 time = 1710
* CHECK dout1_3 vdout1_3ck170 = 0 time = 1710
* CHECK dout1_4 vdout1_4ck170 = 1.7 time = 1710
* CHECK dout1_5 vdout1_5ck170 = 1.7 time = 1710
* CHECK dout1_6 vdout1_6ck170 = 1.7 time = 1710
* CHECK dout1_7 vdout1_7ck170 = 0 time = 1710
* CHECK dout1_8 vdout1_8ck170 = 1.7 time = 1710
* CHECK dout1_9 vdout1_9ck170 = 0 time = 1710
* CHECK dout1_10 vdout1_10ck170 = 1.7 time = 1710
* CHECK dout1_11 vdout1_11ck170 = 0 time = 1710
* CHECK dout1_12 vdout1_12ck170 = 0 time = 1710
* CHECK dout1_13 vdout1_13ck170 = 0 time = 1710
* CHECK dout1_14 vdout1_14ck170 = 1.7 time = 1710
* CHECK dout1_15 vdout1_15ck170 = 0 time = 1710
* CHECK dout1_16 vdout1_16ck170 = 0 time = 1710
* CHECK dout1_17 vdout1_17ck170 = 1.7 time = 1710
* CHECK dout1_18 vdout1_18ck170 = 1.7 time = 1710
* CHECK dout1_19 vdout1_19ck170 = 1.7 time = 1710
* CHECK dout1_20 vdout1_20ck170 = 0 time = 1710
* CHECK dout1_21 vdout1_21ck170 = 0 time = 1710
* CHECK dout1_22 vdout1_22ck170 = 0 time = 1710
* CHECK dout1_23 vdout1_23ck170 = 0 time = 1710
* CHECK dout1_24 vdout1_24ck170 = 0 time = 1710
* CHECK dout1_25 vdout1_25ck170 = 1.7 time = 1710
* CHECK dout1_26 vdout1_26ck170 = 1.7 time = 1710
* CHECK dout1_27 vdout1_27ck170 = 0 time = 1710
* CHECK dout1_28 vdout1_28ck170 = 1.7 time = 1710
* CHECK dout1_29 vdout1_29ck170 = 0 time = 1710
* CHECK dout1_30 vdout1_30ck170 = 0 time = 1710
* CHECK dout1_31 vdout1_31ck170 = 1.7 time = 1710
* CHECK dout1_32 vdout1_32ck170 = 0 time = 1710
* CHECK dout1_0 vdout1_0ck173 = 0 time = 1740
* CHECK dout1_1 vdout1_1ck173 = 0 time = 1740
* CHECK dout1_2 vdout1_2ck173 = 0 time = 1740
* CHECK dout1_3 vdout1_3ck173 = 0 time = 1740
* CHECK dout1_4 vdout1_4ck173 = 1.7 time = 1740
* CHECK dout1_5 vdout1_5ck173 = 0 time = 1740
* CHECK dout1_6 vdout1_6ck173 = 0 time = 1740
* CHECK dout1_7 vdout1_7ck173 = 1.7 time = 1740
* CHECK dout1_8 vdout1_8ck173 = 1.7 time = 1740
* CHECK dout1_9 vdout1_9ck173 = 1.7 time = 1740
* CHECK dout1_10 vdout1_10ck173 = 1.7 time = 1740
* CHECK dout1_11 vdout1_11ck173 = 1.7 time = 1740
* CHECK dout1_12 vdout1_12ck173 = 0 time = 1740
* CHECK dout1_13 vdout1_13ck173 = 0 time = 1740
* CHECK dout1_14 vdout1_14ck173 = 1.7 time = 1740
* CHECK dout1_15 vdout1_15ck173 = 1.7 time = 1740
* CHECK dout1_16 vdout1_16ck173 = 0 time = 1740
* CHECK dout1_17 vdout1_17ck173 = 0 time = 1740
* CHECK dout1_18 vdout1_18ck173 = 1.7 time = 1740
* CHECK dout1_19 vdout1_19ck173 = 0 time = 1740
* CHECK dout1_20 vdout1_20ck173 = 1.7 time = 1740
* CHECK dout1_21 vdout1_21ck173 = 0 time = 1740
* CHECK dout1_22 vdout1_22ck173 = 0 time = 1740
* CHECK dout1_23 vdout1_23ck173 = 0 time = 1740
* CHECK dout1_24 vdout1_24ck173 = 0 time = 1740
* CHECK dout1_25 vdout1_25ck173 = 0 time = 1740
* CHECK dout1_26 vdout1_26ck173 = 0 time = 1740
* CHECK dout1_27 vdout1_27ck173 = 0 time = 1740
* CHECK dout1_28 vdout1_28ck173 = 0 time = 1740
* CHECK dout1_29 vdout1_29ck173 = 0 time = 1740
* CHECK dout1_30 vdout1_30ck173 = 1.7 time = 1740
* CHECK dout1_31 vdout1_31ck173 = 1.7 time = 1740
* CHECK dout1_32 vdout1_32ck173 = 0 time = 1740
* CHECK dout1_0 vdout1_0ck176 = 0 time = 1770
* CHECK dout1_1 vdout1_1ck176 = 0 time = 1770
* CHECK dout1_2 vdout1_2ck176 = 1.7 time = 1770
* CHECK dout1_3 vdout1_3ck176 = 1.7 time = 1770
* CHECK dout1_4 vdout1_4ck176 = 1.7 time = 1770
* CHECK dout1_5 vdout1_5ck176 = 1.7 time = 1770
* CHECK dout1_6 vdout1_6ck176 = 1.7 time = 1770
* CHECK dout1_7 vdout1_7ck176 = 1.7 time = 1770
* CHECK dout1_8 vdout1_8ck176 = 0 time = 1770
* CHECK dout1_9 vdout1_9ck176 = 0 time = 1770
* CHECK dout1_10 vdout1_10ck176 = 1.7 time = 1770
* CHECK dout1_11 vdout1_11ck176 = 0 time = 1770
* CHECK dout1_12 vdout1_12ck176 = 1.7 time = 1770
* CHECK dout1_13 vdout1_13ck176 = 1.7 time = 1770
* CHECK dout1_14 vdout1_14ck176 = 0 time = 1770
* CHECK dout1_15 vdout1_15ck176 = 0 time = 1770
* CHECK dout1_16 vdout1_16ck176 = 0 time = 1770
* CHECK dout1_17 vdout1_17ck176 = 1.7 time = 1770
* CHECK dout1_18 vdout1_18ck176 = 1.7 time = 1770
* CHECK dout1_19 vdout1_19ck176 = 1.7 time = 1770
* CHECK dout1_20 vdout1_20ck176 = 0 time = 1770
* CHECK dout1_21 vdout1_21ck176 = 0 time = 1770
* CHECK dout1_22 vdout1_22ck176 = 1.7 time = 1770
* CHECK dout1_23 vdout1_23ck176 = 0 time = 1770
* CHECK dout1_24 vdout1_24ck176 = 1.7 time = 1770
* CHECK dout1_25 vdout1_25ck176 = 0 time = 1770
* CHECK dout1_26 vdout1_26ck176 = 0 time = 1770
* CHECK dout1_27 vdout1_27ck176 = 0 time = 1770
* CHECK dout1_28 vdout1_28ck176 = 1.7 time = 1770
* CHECK dout1_29 vdout1_29ck176 = 1.7 time = 1770
* CHECK dout1_30 vdout1_30ck176 = 1.7 time = 1770
* CHECK dout1_31 vdout1_31ck176 = 0 time = 1770
* CHECK dout1_32 vdout1_32ck176 = 0 time = 1770
* CHECK dout1_0 vdout1_0ck180 = 0 time = 1810
* CHECK dout1_1 vdout1_1ck180 = 0 time = 1810
* CHECK dout1_2 vdout1_2ck180 = 1.7 time = 1810
* CHECK dout1_3 vdout1_3ck180 = 0 time = 1810
* CHECK dout1_4 vdout1_4ck180 = 1.7 time = 1810
* CHECK dout1_5 vdout1_5ck180 = 1.7 time = 1810
* CHECK dout1_6 vdout1_6ck180 = 0 time = 1810
* CHECK dout1_7 vdout1_7ck180 = 0 time = 1810
* CHECK dout1_8 vdout1_8ck180 = 0 time = 1810
* CHECK dout1_9 vdout1_9ck180 = 0 time = 1810
* CHECK dout1_10 vdout1_10ck180 = 1.7 time = 1810
* CHECK dout1_11 vdout1_11ck180 = 1.7 time = 1810
* CHECK dout1_12 vdout1_12ck180 = 1.7 time = 1810
* CHECK dout1_13 vdout1_13ck180 = 0 time = 1810
* CHECK dout1_14 vdout1_14ck180 = 1.7 time = 1810
* CHECK dout1_15 vdout1_15ck180 = 1.7 time = 1810
* CHECK dout1_16 vdout1_16ck180 = 0 time = 1810
* CHECK dout1_17 vdout1_17ck180 = 0 time = 1810
* CHECK dout1_18 vdout1_18ck180 = 0 time = 1810
* CHECK dout1_19 vdout1_19ck180 = 1.7 time = 1810
* CHECK dout1_20 vdout1_20ck180 = 1.7 time = 1810
* CHECK dout1_21 vdout1_21ck180 = 0 time = 1810
* CHECK dout1_22 vdout1_22ck180 = 0 time = 1810
* CHECK dout1_23 vdout1_23ck180 = 0 time = 1810
* CHECK dout1_24 vdout1_24ck180 = 1.7 time = 1810
* CHECK dout1_25 vdout1_25ck180 = 1.7 time = 1810
* CHECK dout1_26 vdout1_26ck180 = 1.7 time = 1810
* CHECK dout1_27 vdout1_27ck180 = 0 time = 1810
* CHECK dout1_28 vdout1_28ck180 = 1.7 time = 1810
* CHECK dout1_29 vdout1_29ck180 = 1.7 time = 1810
* CHECK dout1_30 vdout1_30ck180 = 0 time = 1810
* CHECK dout1_31 vdout1_31ck180 = 0 time = 1810
* CHECK dout1_32 vdout1_32ck180 = 0 time = 1810
* CHECK dout1_0 vdout1_0ck186 = 0 time = 1870
* CHECK dout1_1 vdout1_1ck186 = 1.7 time = 1870
* CHECK dout1_2 vdout1_2ck186 = 1.7 time = 1870
* CHECK dout1_3 vdout1_3ck186 = 1.7 time = 1870
* CHECK dout1_4 vdout1_4ck186 = 0 time = 1870
* CHECK dout1_5 vdout1_5ck186 = 0 time = 1870
* CHECK dout1_6 vdout1_6ck186 = 1.7 time = 1870
* CHECK dout1_7 vdout1_7ck186 = 0 time = 1870
* CHECK dout1_8 vdout1_8ck186 = 1.7 time = 1870
* CHECK dout1_9 vdout1_9ck186 = 1.7 time = 1870
* CHECK dout1_10 vdout1_10ck186 = 1.7 time = 1870
* CHECK dout1_11 vdout1_11ck186 = 0 time = 1870
* CHECK dout1_12 vdout1_12ck186 = 1.7 time = 1870
* CHECK dout1_13 vdout1_13ck186 = 0 time = 1870
* CHECK dout1_14 vdout1_14ck186 = 1.7 time = 1870
* CHECK dout1_15 vdout1_15ck186 = 0 time = 1870
* CHECK dout1_16 vdout1_16ck186 = 0 time = 1870
* CHECK dout1_17 vdout1_17ck186 = 0 time = 1870
* CHECK dout1_18 vdout1_18ck186 = 0 time = 1870
* CHECK dout1_19 vdout1_19ck186 = 0 time = 1870
* CHECK dout1_20 vdout1_20ck186 = 0 time = 1870
* CHECK dout1_21 vdout1_21ck186 = 0 time = 1870
* CHECK dout1_22 vdout1_22ck186 = 1.7 time = 1870
* CHECK dout1_23 vdout1_23ck186 = 0 time = 1870
* CHECK dout1_24 vdout1_24ck186 = 1.7 time = 1870
* CHECK dout1_25 vdout1_25ck186 = 0 time = 1870
* CHECK dout1_26 vdout1_26ck186 = 1.7 time = 1870
* CHECK dout1_27 vdout1_27ck186 = 0 time = 1870
* CHECK dout1_28 vdout1_28ck186 = 0 time = 1870
* CHECK dout1_29 vdout1_29ck186 = 0 time = 1870
* CHECK dout1_30 vdout1_30ck186 = 1.7 time = 1870
* CHECK dout1_31 vdout1_31ck186 = 0 time = 1870
* CHECK dout1_32 vdout1_32ck186 = 0 time = 1870
* CHECK dout1_0 vdout1_0ck187 = 0 time = 1880
* CHECK dout1_1 vdout1_1ck187 = 0 time = 1880
* CHECK dout1_2 vdout1_2ck187 = 1.7 time = 1880
* CHECK dout1_3 vdout1_3ck187 = 0 time = 1880
* CHECK dout1_4 vdout1_4ck187 = 0 time = 1880
* CHECK dout1_5 vdout1_5ck187 = 0 time = 1880
* CHECK dout1_6 vdout1_6ck187 = 1.7 time = 1880
* CHECK dout1_7 vdout1_7ck187 = 0 time = 1880
* CHECK dout1_8 vdout1_8ck187 = 1.7 time = 1880
* CHECK dout1_9 vdout1_9ck187 = 0 time = 1880
* CHECK dout1_10 vdout1_10ck187 = 0 time = 1880
* CHECK dout1_11 vdout1_11ck187 = 1.7 time = 1880
* CHECK dout1_12 vdout1_12ck187 = 1.7 time = 1880
* CHECK dout1_13 vdout1_13ck187 = 0 time = 1880
* CHECK dout1_14 vdout1_14ck187 = 1.7 time = 1880
* CHECK dout1_15 vdout1_15ck187 = 0 time = 1880
* CHECK dout1_16 vdout1_16ck187 = 1.7 time = 1880
* CHECK dout1_17 vdout1_17ck187 = 1.7 time = 1880
* CHECK dout1_18 vdout1_18ck187 = 1.7 time = 1880
* CHECK dout1_19 vdout1_19ck187 = 0 time = 1880
* CHECK dout1_20 vdout1_20ck187 = 1.7 time = 1880
* CHECK dout1_21 vdout1_21ck187 = 1.7 time = 1880
* CHECK dout1_22 vdout1_22ck187 = 1.7 time = 1880
* CHECK dout1_23 vdout1_23ck187 = 1.7 time = 1880
* CHECK dout1_24 vdout1_24ck187 = 0 time = 1880
* CHECK dout1_25 vdout1_25ck187 = 0 time = 1880
* CHECK dout1_26 vdout1_26ck187 = 1.7 time = 1880
* CHECK dout1_27 vdout1_27ck187 = 0 time = 1880
* CHECK dout1_28 vdout1_28ck187 = 0 time = 1880
* CHECK dout1_29 vdout1_29ck187 = 1.7 time = 1880
* CHECK dout1_30 vdout1_30ck187 = 0 time = 1880
* CHECK dout1_31 vdout1_31ck187 = 1.7 time = 1880
* CHECK dout1_32 vdout1_32ck187 = 0 time = 1880
* CHECK dout1_0 vdout1_0ck191 = 0 time = 1920
* CHECK dout1_1 vdout1_1ck191 = 0 time = 1920
* CHECK dout1_2 vdout1_2ck191 = 0 time = 1920
* CHECK dout1_3 vdout1_3ck191 = 1.7 time = 1920
* CHECK dout1_4 vdout1_4ck191 = 0 time = 1920
* CHECK dout1_5 vdout1_5ck191 = 1.7 time = 1920
* CHECK dout1_6 vdout1_6ck191 = 0 time = 1920
* CHECK dout1_7 vdout1_7ck191 = 1.7 time = 1920
* CHECK dout1_8 vdout1_8ck191 = 1.7 time = 1920
* CHECK dout1_9 vdout1_9ck191 = 0 time = 1920
* CHECK dout1_10 vdout1_10ck191 = 1.7 time = 1920
* CHECK dout1_11 vdout1_11ck191 = 0 time = 1920
* CHECK dout1_12 vdout1_12ck191 = 0 time = 1920
* CHECK dout1_13 vdout1_13ck191 = 0 time = 1920
* CHECK dout1_14 vdout1_14ck191 = 1.7 time = 1920
* CHECK dout1_15 vdout1_15ck191 = 0 time = 1920
* CHECK dout1_16 vdout1_16ck191 = 1.7 time = 1920
* CHECK dout1_17 vdout1_17ck191 = 1.7 time = 1920
* CHECK dout1_18 vdout1_18ck191 = 0 time = 1920
* CHECK dout1_19 vdout1_19ck191 = 0 time = 1920
* CHECK dout1_20 vdout1_20ck191 = 0 time = 1920
* CHECK dout1_21 vdout1_21ck191 = 1.7 time = 1920
* CHECK dout1_22 vdout1_22ck191 = 0 time = 1920
* CHECK dout1_23 vdout1_23ck191 = 1.7 time = 1920
* CHECK dout1_24 vdout1_24ck191 = 1.7 time = 1920
* CHECK dout1_25 vdout1_25ck191 = 0 time = 1920
* CHECK dout1_26 vdout1_26ck191 = 1.7 time = 1920
* CHECK dout1_27 vdout1_27ck191 = 0 time = 1920
* CHECK dout1_28 vdout1_28ck191 = 1.7 time = 1920
* CHECK dout1_29 vdout1_29ck191 = 1.7 time = 1920
* CHECK dout1_30 vdout1_30ck191 = 1.7 time = 1920
* CHECK dout1_31 vdout1_31ck191 = 0 time = 1920
* CHECK dout1_32 vdout1_32ck191 = 0 time = 1920
* CHECK dout1_0 vdout1_0ck196 = 0 time = 1970
* CHECK dout1_1 vdout1_1ck196 = 1.7 time = 1970
* CHECK dout1_2 vdout1_2ck196 = 0 time = 1970
* CHECK dout1_3 vdout1_3ck196 = 1.7 time = 1970
* CHECK dout1_4 vdout1_4ck196 = 1.7 time = 1970
* CHECK dout1_5 vdout1_5ck196 = 0 time = 1970
* CHECK dout1_6 vdout1_6ck196 = 0 time = 1970
* CHECK dout1_7 vdout1_7ck196 = 0 time = 1970
* CHECK dout1_8 vdout1_8ck196 = 0 time = 1970
* CHECK dout1_9 vdout1_9ck196 = 1.7 time = 1970
* CHECK dout1_10 vdout1_10ck196 = 1.7 time = 1970
* CHECK dout1_11 vdout1_11ck196 = 1.7 time = 1970
* CHECK dout1_12 vdout1_12ck196 = 1.7 time = 1970
* CHECK dout1_13 vdout1_13ck196 = 1.7 time = 1970
* CHECK dout1_14 vdout1_14ck196 = 0 time = 1970
* CHECK dout1_15 vdout1_15ck196 = 0 time = 1970
* CHECK dout1_16 vdout1_16ck196 = 0 time = 1970
* CHECK dout1_17 vdout1_17ck196 = 1.7 time = 1970
* CHECK dout1_18 vdout1_18ck196 = 1.7 time = 1970
* CHECK dout1_19 vdout1_19ck196 = 1.7 time = 1970
* CHECK dout1_20 vdout1_20ck196 = 0 time = 1970
* CHECK dout1_21 vdout1_21ck196 = 0 time = 1970
* CHECK dout1_22 vdout1_22ck196 = 0 time = 1970
* CHECK dout1_23 vdout1_23ck196 = 1.7 time = 1970
* CHECK dout1_24 vdout1_24ck196 = 1.7 time = 1970
* CHECK dout1_25 vdout1_25ck196 = 0 time = 1970
* CHECK dout1_26 vdout1_26ck196 = 0 time = 1970
* CHECK dout1_27 vdout1_27ck196 = 0 time = 1970
* CHECK dout1_28 vdout1_28ck196 = 1.7 time = 1970
* CHECK dout1_29 vdout1_29ck196 = 1.7 time = 1970
* CHECK dout1_30 vdout1_30ck196 = 0 time = 1970
* CHECK dout1_31 vdout1_31ck196 = 0 time = 1970
* CHECK dout1_32 vdout1_32ck196 = 0 time = 1970
* CHECK dout1_0 vdout1_0ck199 = 0 time = 2000
* CHECK dout1_1 vdout1_1ck199 = 1.7 time = 2000
* CHECK dout1_2 vdout1_2ck199 = 0 time = 2000
* CHECK dout1_3 vdout1_3ck199 = 1.7 time = 2000
* CHECK dout1_4 vdout1_4ck199 = 0 time = 2000
* CHECK dout1_5 vdout1_5ck199 = 1.7 time = 2000
* CHECK dout1_6 vdout1_6ck199 = 1.7 time = 2000
* CHECK dout1_7 vdout1_7ck199 = 0 time = 2000
* CHECK dout1_8 vdout1_8ck199 = 0 time = 2000
* CHECK dout1_9 vdout1_9ck199 = 0 time = 2000
* CHECK dout1_10 vdout1_10ck199 = 0 time = 2000
* CHECK dout1_11 vdout1_11ck199 = 0 time = 2000
* CHECK dout1_12 vdout1_12ck199 = 0 time = 2000
* CHECK dout1_13 vdout1_13ck199 = 1.7 time = 2000
* CHECK dout1_14 vdout1_14ck199 = 0 time = 2000
* CHECK dout1_15 vdout1_15ck199 = 1.7 time = 2000
* CHECK dout1_16 vdout1_16ck199 = 1.7 time = 2000
* CHECK dout1_17 vdout1_17ck199 = 0 time = 2000
* CHECK dout1_18 vdout1_18ck199 = 0 time = 2000
* CHECK dout1_19 vdout1_19ck199 = 0 time = 2000
* CHECK dout1_20 vdout1_20ck199 = 0 time = 2000
* CHECK dout1_21 vdout1_21ck199 = 0 time = 2000
* CHECK dout1_22 vdout1_22ck199 = 1.7 time = 2000
* CHECK dout1_23 vdout1_23ck199 = 0 time = 2000
* CHECK dout1_24 vdout1_24ck199 = 0 time = 2000
* CHECK dout1_25 vdout1_25ck199 = 0 time = 2000
* CHECK dout1_26 vdout1_26ck199 = 0 time = 2000
* CHECK dout1_27 vdout1_27ck199 = 0 time = 2000
* CHECK dout1_28 vdout1_28ck199 = 1.7 time = 2000
* CHECK dout1_29 vdout1_29ck199 = 1.7 time = 2000
* CHECK dout1_30 vdout1_30ck199 = 1.7 time = 2000
* CHECK dout1_31 vdout1_31ck199 = 1.7 time = 2000
* CHECK dout1_32 vdout1_32ck199 = 0 time = 2000
.include /Sky130_memory/work/openram_builds/v20260612_1r1w_full/sky130_sram_128bytes_1r1w_32x32/functional_meas.sp
.TEMP 0
.TRAN 10p 2060n 0n 10p UIC
.OPTIONS POST=1 RELTOL=0.001 PROBE method=gear ACCT
* probe is used for hspice/xa, while plot is used in ngspice
*.probe V(*)
*.plot V(*)
.end
