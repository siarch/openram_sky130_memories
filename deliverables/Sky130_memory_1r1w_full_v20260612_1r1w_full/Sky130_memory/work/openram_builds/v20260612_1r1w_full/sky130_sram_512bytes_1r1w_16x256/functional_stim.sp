* Functional test stimulus file for 10ns period

* SS process corner
.lib "/Sky130_memory/pdk/sky130A/libs.tech/ngspice/sky130.lib.spice" ss
.include "/tmp/openram_ryan_34578_temp/sram.sp"

* Global Power Supplies
Vvdd vdd 0 1.7

*Nodes gnd and 0 are the same global ground node in ngspice/hspice/xa. Otherwise, this source may be needed.
*Vgnd gnd 0 0.0

* Instantiation of the SRAM
Xsky130_sram_512bytes_1r1w_16x256 din0_0 din0_1 din0_2 din0_3 din0_4 din0_5 din0_6 din0_7 din0_8 din0_9 din0_10 din0_11 din0_12 din0_13 din0_14 din0_15 din0_16 a0_0 a0_1 a0_2 a0_3 a0_4 a0_5 a0_6 a0_7 a0_8 a1_0 a1_1 a1_2 a1_3 a1_4 a1_5 a1_6 a1_7 a1_8 CSB0 CSB1 clk0 clk1 SPARE_WEN0_0 dout1_0 dout1_1 dout1_2 dout1_3 dout1_4 dout1_5 dout1_6 dout1_7 dout1_8 dout1_9 dout1_10 dout1_11 dout1_12 dout1_13 dout1_14 dout1_15 dout1_16 vdd gnd sky130_sram_512bytes_1r1w_16x256

* SRAM output loads
CD10 dout1_0  0 27.56f
CD11 dout1_1  0 27.56f
CD12 dout1_2  0 27.56f
CD13 dout1_3  0 27.56f
CD14 dout1_4  0 27.56f
CD15 dout1_5  0 27.56f
CD16 dout1_6  0 27.56f
CD17 dout1_7  0 27.56f
CD18 dout1_8  0 27.56f
CD19 dout1_9  0 27.56f
CD110 dout1_10  0 27.56f
CD111 dout1_11  0 27.56f
CD112 dout1_12  0 27.56f
CD113 dout1_13  0 27.56f
CD114 dout1_14  0 27.56f
CD115 dout1_15  0 27.56f
CD116 dout1_16  0 27.56f

* Important signals for debug
* bl:	xsram:xbank0:bl_0_1
* br:	xsram:xbank0:br_0_1
* s_en:	xsram:s_en
* q:	xsram:xbank0:xbitcell_array:xbitcell_array:xbit_r0_c0.Q
* qbar:	xsram:xbank0:xbitcell_array:xbitcell_array:xbit_r0_c0.Q_bar

* Sequence of operations
*	Idle during cycle 0 (0ns - 10ns)
*	Writing 0+0111100001100100  to  address 100000000 (from port 0) during cycle 1 (10ns - 20ns)
*	Writing 0+1001100101111000  to  address 000000010 (from port 0) during cycle 2 (20ns - 30ns)
*	Writing 0+1111110100010100  to  address 011111111 (from port 0) during cycle 3 (30ns - 40ns)
*	Reading 0+1001100101111000 from address 000000010 (from port 1) during cycle 4 (40ns - 50ns)
*	Writing 0+1011100101001111  to  address 000000001 (from port 0) during cycle 7 (70ns - 80ns)
*	Reading 0+1111110100010100 from address 011111111 (from port 1) during cycle 7 (70ns - 80ns)
*	Writing 0+1000010101110000  to  address 100000001 (from port 0) during cycle 8 (80ns - 90ns)
*	Reading 0+0111100001100100 from address 100000000 (from port 1) during cycle 10 (100ns - 110ns)
*	Writing 0+1000010111010011  to  address 000000000 (from port 0) during cycle 11 (110ns - 120ns)
*	Reading 0+1001100101111000 from address 000000010 (from port 1) during cycle 15 (150ns - 160ns)
*	Writing 0+0001011111010011  to  address 100000010 (from port 0) during cycle 16 (160ns - 170ns)
*	Reading 0+0111100001100100 from address 100000000 (from port 1) during cycle 17 (170ns - 180ns)
*	Reading 0+1000010111010011 from address 000000000 (from port 1) during cycle 18 (180ns - 190ns)
*	Writing 0+0100010000101001  to  address 011111111 (from port 0) during cycle 19 (190ns - 200ns)
*	Writing 0+0011101111001101  to  address 000000011 (from port 0) during cycle 21 (210ns - 220ns)
*	Writing 0+0110111110101011  to  address 000000000 (from port 0) during cycle 23 (230ns - 240ns)
*	Writing 0+1000000110000111  to  address 011111111 (from port 0) during cycle 25 (250ns - 260ns)
*	Reading 0+0111100001100100 from address 100000000 (from port 1) during cycle 25 (250ns - 260ns)
*	Reading 0+0111100001100100 from address 100000000 (from port 1) during cycle 27 (270ns - 280ns)
*	Writing 0+0110011100110101  to  address 000000000 (from port 0) during cycle 28 (280ns - 290ns)
*	Reading 0+1011100101001111 from address 000000001 (from port 1) during cycle 28 (280ns - 290ns)
*	Reading 0+1011100101001111 from address 000000001 (from port 1) during cycle 29 (290ns - 300ns)
*	Reading 0+1000000110000111 from address 011111111 (from port 1) during cycle 30 (300ns - 310ns)
*	Writing 0+1100110111101000  to  address 000000010 (from port 0) during cycle 31 (310ns - 320ns)
*	Writing 0+0011010111000100  to  address 000000011 (from port 0) during cycle 33 (330ns - 340ns)
*	Reading 0+0001011111010011 from address 100000010 (from port 1) during cycle 34 (340ns - 350ns)
*	Writing 0+1001000011100110  to  address 000000000 (from port 0) during cycle 35 (350ns - 360ns)
*	Reading 0+0111100001100100 from address 100000000 (from port 1) during cycle 35 (350ns - 360ns)
*	Reading 0+1011100101001111 from address 000000001 (from port 1) during cycle 36 (360ns - 370ns)
*	Writing 0+1011100011110010  to  address 000000001 (from port 0) during cycle 37 (370ns - 380ns)
*	Reading 0+1000000110000111 from address 011111111 (from port 1) during cycle 37 (370ns - 380ns)
*	Reading 0+0111100001100100 from address 100000000 (from port 1) during cycle 38 (380ns - 390ns)
*	Writing 0+0110010010011101  to  address 000000001 (from port 0) during cycle 39 (390ns - 400ns)
*	Reading 0+0111100001100100 from address 100000000 (from port 1) during cycle 41 (410ns - 420ns)
*	Writing 0+1111000011011011  to  address 000000000 (from port 0) during cycle 42 (420ns - 430ns)
*	Reading 0+1111000011011011 from address 000000000 (from port 1) during cycle 43 (430ns - 440ns)
*	Writing 0+1010000000100101  to  address 011111111 (from port 0) during cycle 45 (450ns - 460ns)
*	Writing 0+1101101001110000  to  address 100000001 (from port 0) during cycle 46 (460ns - 470ns)
*	Writing 0+1100011010000101  to  address 100000000 (from port 0) during cycle 47 (470ns - 480ns)
*	Writing 0+1001001101111001  to  address 011111111 (from port 0) during cycle 48 (480ns - 490ns)
*	Reading 0+1100011010000101 from address 100000000 (from port 1) during cycle 48 (480ns - 490ns)
*	Reading 0+1100110111101000 from address 000000010 (from port 1) during cycle 49 (490ns - 500ns)
*	Writing 0+1101011100000101  to  address 000000011 (from port 0) during cycle 50 (500ns - 510ns)
*	Reading 0+0001011111010011 from address 100000010 (from port 1) during cycle 51 (510ns - 520ns)
*	Reading 0+1100011010000101 from address 100000000 (from port 1) during cycle 54 (540ns - 550ns)
*	Writing 0+1110001011011001  to  address 100000010 (from port 0) during cycle 55 (550ns - 560ns)
*	Reading 0+0110010010011101 from address 000000001 (from port 1) during cycle 56 (560ns - 570ns)
*	Reading 0+1110001011011001 from address 100000010 (from port 1) during cycle 58 (580ns - 590ns)
*	Writing 0+0110011100110001  to  address 000000001 (from port 0) during cycle 59 (590ns - 600ns)
*	Reading 0+1110001011011001 from address 100000010 (from port 1) during cycle 59 (590ns - 600ns)
*	Writing 0+0010110010011001  to  address 100000001 (from port 0) during cycle 60 (600ns - 610ns)
*	Reading 0+1100011010000101 from address 100000000 (from port 1) during cycle 60 (600ns - 610ns)
*	Writing 0+0100101000011011  to  address 100000001 (from port 0) during cycle 62 (620ns - 630ns)
*	Reading 0+1100011010000101 from address 100000000 (from port 1) during cycle 62 (620ns - 630ns)
*	Writing 0+0000000000001111  to  address 000000011 (from port 0) during cycle 63 (630ns - 640ns)
*	Writing 0+0100111111110001  to  address 100000000 (from port 0) during cycle 65 (650ns - 660ns)
*	Reading 0+1110001011011001 from address 100000010 (from port 1) during cycle 65 (650ns - 660ns)
*	Writing 0+1001010001111001  to  address 000000001 (from port 0) during cycle 66 (660ns - 670ns)
*	Reading 0+1001001101111001 from address 011111111 (from port 1) during cycle 66 (660ns - 670ns)
*	Writing 0+1011011000110100  to  address 100000001 (from port 0) during cycle 67 (670ns - 680ns)
*	Writing 0+0111111000110101  to  address 100000001 (from port 0) during cycle 68 (680ns - 690ns)
*	Writing 0+0100001011100101  to  address 000000001 (from port 0) during cycle 69 (690ns - 700ns)
*	Reading 0+0111111000110101 from address 100000001 (from port 1) during cycle 69 (690ns - 700ns)
*	Writing 0+1001001100101011  to  address 100000001 (from port 0) during cycle 71 (710ns - 720ns)
*	Writing 0+0100101000111111  to  address 100000000 (from port 0) during cycle 72 (720ns - 730ns)
*	Reading 0+0000000000001111 from address 000000011 (from port 1) during cycle 73 (730ns - 740ns)
*	Writing 0+1010100100001011  to  address 100000001 (from port 0) during cycle 74 (740ns - 750ns)
*	Reading 0+1111000011011011 from address 000000000 (from port 1) during cycle 74 (740ns - 750ns)
*	Reading 0+1010100100001011 from address 100000001 (from port 1) during cycle 75 (750ns - 760ns)
*	Writing 0+1011001110111010  to  address 100000000 (from port 0) during cycle 77 (770ns - 780ns)
*	Reading 0+1110001011011001 from address 100000010 (from port 1) during cycle 77 (770ns - 780ns)
*	Writing 0+0001000110111011  to  address 000000000 (from port 0) during cycle 78 (780ns - 790ns)
*	Reading 0+0000000000001111 from address 000000011 (from port 1) during cycle 78 (780ns - 790ns)
*	Writing 0+0011010101000001  to  address 100000010 (from port 0) during cycle 79 (790ns - 800ns)
*	Writing 0+1011010100111001  to  address 000000011 (from port 0) during cycle 81 (810ns - 820ns)
*	Writing 0+0000101110111001  to  address 000000000 (from port 0) during cycle 84 (840ns - 850ns)
*	Writing 0+1000010100010010  to  address 100000001 (from port 0) during cycle 86 (860ns - 870ns)
*	Reading 0+1100110111101000 from address 000000010 (from port 1) during cycle 86 (860ns - 870ns)
*	Writing 0+1001101011100101  to  address 100000010 (from port 0) during cycle 87 (870ns - 880ns)
*	Reading 0+1100110111101000 from address 000000010 (from port 1) during cycle 87 (870ns - 880ns)
*	Writing 0+1001111101001001  to  address 000000001 (from port 0) during cycle 88 (880ns - 890ns)
*	Reading 0+1000010100010010 from address 100000001 (from port 1) during cycle 88 (880ns - 890ns)
*	Reading 0+1011010100111001 from address 000000011 (from port 1) during cycle 89 (890ns - 900ns)
*	Reading 0+1001001101111001 from address 011111111 (from port 1) during cycle 90 (900ns - 910ns)
*	Writing 0+1011101010101000  to  address 000000001 (from port 0) during cycle 91 (910ns - 920ns)
*	Reading 0+1011001110111010 from address 100000000 (from port 1) during cycle 92 (920ns - 930ns)
*	Reading 0+1001001101111001 from address 011111111 (from port 1) during cycle 93 (930ns - 940ns)
*	Reading 0+1001001101111001 from address 011111111 (from port 1) during cycle 94 (940ns - 950ns)
*	Writing 0+1111101010110001  to  address 000000011 (from port 0) during cycle 95 (950ns - 960ns)
*	Reading 0+1001101011100101 from address 100000010 (from port 1) during cycle 95 (950ns - 960ns)
*	Writing 0+1101000010000000  to  address 100000000 (from port 0) during cycle 96 (960ns - 970ns)
*	Reading 0+1111101010110001 from address 000000011 (from port 1) during cycle 96 (960ns - 970ns)
*	Reading 0+1001001101111001 from address 011111111 (from port 1) during cycle 97 (970ns - 980ns)
*	Reading 0+1001101011100101 from address 100000010 (from port 1) during cycle 98 (980ns - 990ns)
*	Writing 0+1101010001001000  to  address 100000001 (from port 0) during cycle 100 (1000ns - 1010ns)
*	Writing 0+1001000000100000  to  address 100000010 (from port 0) during cycle 102 (1020ns - 1030ns)
*	Reading 0+1011101010101000 from address 000000001 (from port 1) during cycle 102 (1020ns - 1030ns)
*	Writing 0+1001100110111000  to  address 000000010 (from port 0) during cycle 103 (1030ns - 1040ns)
*	Writing 0+0001010001101000  to  address 100000000 (from port 0) during cycle 105 (1050ns - 1060ns)
*	Writing 0+0000000010110101  to  address 000000011 (from port 0) during cycle 107 (1070ns - 1080ns)
*	Writing 0+0011001100011010  to  address 000000000 (from port 0) during cycle 110 (1100ns - 1110ns)
*	Reading 0+1101010001001000 from address 100000001 (from port 1) during cycle 110 (1100ns - 1110ns)
*	Writing 0+1100010010101000  to  address 000000001 (from port 0) during cycle 113 (1130ns - 1140ns)
*	Reading 0+0001010001101000 from address 100000000 (from port 1) during cycle 113 (1130ns - 1140ns)
*	Reading 0+1001000000100000 from address 100000010 (from port 1) during cycle 114 (1140ns - 1150ns)
*	Reading 0+1001000000100000 from address 100000010 (from port 1) during cycle 115 (1150ns - 1160ns)
*	Writing 0+0111100011100001  to  address 000000011 (from port 0) during cycle 116 (1160ns - 1170ns)
*	Writing 0+1001010110110100  to  address 000000000 (from port 0) during cycle 118 (1180ns - 1190ns)
*	Reading 0+0111100011100001 from address 000000011 (from port 1) during cycle 119 (1190ns - 1200ns)
*	Reading 0+0001010001101000 from address 100000000 (from port 1) during cycle 120 (1200ns - 1210ns)
*	Writing 0+1011100100110010  to  address 000000011 (from port 0) during cycle 123 (1230ns - 1240ns)
*	Reading 0+1001001101111001 from address 011111111 (from port 1) during cycle 123 (1230ns - 1240ns)
*	Reading 0+1001000000100000 from address 100000010 (from port 1) during cycle 124 (1240ns - 1250ns)
*	Writing 0+0010000101011110  to  address 000000000 (from port 0) during cycle 128 (1280ns - 1290ns)
*	Writing 0+1000110110001101  to  address 100000010 (from port 0) during cycle 129 (1290ns - 1300ns)
*	Reading 0+1011100100110010 from address 000000011 (from port 1) during cycle 129 (1290ns - 1300ns)
*	Writing 0+1110110101010001  to  address 100000000 (from port 0) during cycle 130 (1300ns - 1310ns)
*	Reading 0+1100010010101000 from address 000000001 (from port 1) during cycle 130 (1300ns - 1310ns)
*	Reading 0+1101010001001000 from address 100000001 (from port 1) during cycle 132 (1320ns - 1330ns)
*	Writing 0+0001010011001100  to  address 000000001 (from port 0) during cycle 135 (1350ns - 1360ns)
*	Reading 0+0010000101011110 from address 000000000 (from port 1) during cycle 137 (1370ns - 1380ns)
*	Reading 0+0010000101011110 from address 000000000 (from port 1) during cycle 138 (1380ns - 1390ns)
*	Writing 0+0101010010101100  to  address 100000001 (from port 0) during cycle 139 (1390ns - 1400ns)
*	Reading 0+1000110110001101 from address 100000010 (from port 1) during cycle 139 (1390ns - 1400ns)
*	Writing 0+0001101011001101  to  address 100000000 (from port 0) during cycle 140 (1400ns - 1410ns)
*	Reading 0+1000110110001101 from address 100000010 (from port 1) during cycle 140 (1400ns - 1410ns)
*	Writing 0+0111001010111000  to  address 000000010 (from port 0) during cycle 141 (1410ns - 1420ns)
*	Reading 0+0101010010101100 from address 100000001 (from port 1) during cycle 142 (1420ns - 1430ns)
*	Reading 0+0001101011001101 from address 100000000 (from port 1) during cycle 143 (1430ns - 1440ns)
*	Writing 0+1001010101010011  to  address 000000011 (from port 0) during cycle 144 (1440ns - 1450ns)
*	Writing 0+1110101011111111  to  address 011111111 (from port 0) during cycle 145 (1450ns - 1460ns)
*	Reading 0+1001010101010011 from address 000000011 (from port 1) during cycle 146 (1460ns - 1470ns)
*	Writing 0+0111011010100111  to  address 000000011 (from port 0) during cycle 147 (1470ns - 1480ns)
*	Writing 0+0001111010001001  to  address 000000001 (from port 0) during cycle 150 (1500ns - 1510ns)
*	Reading 0+0101010010101100 from address 100000001 (from port 1) during cycle 150 (1500ns - 1510ns)
*	Reading 0+0101010010101100 from address 100000001 (from port 1) during cycle 151 (1510ns - 1520ns)
*	Writing 0+1010110111000000  to  address 100000000 (from port 0) during cycle 152 (1520ns - 1530ns)
*	Reading 0+0111011010100111 from address 000000011 (from port 1) during cycle 153 (1530ns - 1540ns)
*	Writing 0+0000001000101111  to  address 000000011 (from port 0) during cycle 155 (1550ns - 1560ns)
*	Writing 0+1111111111001010  to  address 000000011 (from port 0) during cycle 156 (1560ns - 1570ns)
*	Writing 0+1000011010011110  to  address 000000011 (from port 0) during cycle 157 (1570ns - 1580ns)
*	Writing 0+0101100111111011  to  address 011111111 (from port 0) during cycle 158 (1580ns - 1590ns)
*	Reading 0+0101010010101100 from address 100000001 (from port 1) during cycle 160 (1600ns - 1610ns)
*	Writing 0+1010011110100010  to  address 000000001 (from port 0) during cycle 161 (1610ns - 1620ns)
*	Reading 0+0010000101011110 from address 000000000 (from port 1) during cycle 161 (1610ns - 1620ns)
*	Writing 0+1110010000000101  to  address 011111111 (from port 0) during cycle 164 (1640ns - 1650ns)
*	Writing 0+0000110100000100  to  address 100000010 (from port 0) during cycle 165 (1650ns - 1660ns)
*	Reading 0+1010110111000000 from address 100000000 (from port 1) during cycle 165 (1650ns - 1660ns)
*	Writing 0+1000001011010000  to  address 100000001 (from port 0) during cycle 167 (1670ns - 1680ns)
*	Writing 0+0100110100000110  to  address 000000000 (from port 0) during cycle 168 (1680ns - 1690ns)
*	Writing 0+0010100100001001  to  address 000000011 (from port 0) during cycle 169 (1690ns - 1700ns)
*	Writing 0+1011101101010000  to  address 100000010 (from port 0) during cycle 170 (1700ns - 1710ns)
*	Writing 0+0001100011111101  to  address 000000011 (from port 0) during cycle 172 (1720ns - 1730ns)
*	Writing 0+0000110100010111  to  address 100000010 (from port 0) during cycle 174 (1740ns - 1750ns)
*	Writing 0+0100011111111111  to  address 100000001 (from port 0) during cycle 176 (1760ns - 1770ns)
*	Reading 0+1010011110100010 from address 000000001 (from port 1) during cycle 177 (1770ns - 1780ns)
*	Writing 0+1010101011110011  to  address 000000001 (from port 0) during cycle 178 (1780ns - 1790ns)
*	Writing 0+1001001101100010  to  address 100000000 (from port 0) during cycle 181 (1810ns - 1820ns)
*	Reading 0+0100110100000110 from address 000000000 (from port 1) during cycle 181 (1810ns - 1820ns)
*	Writing 0+1111011011111100  to  address 011111111 (from port 0) during cycle 182 (1820ns - 1830ns)
*	Reading 0+1010101011110011 from address 000000001 (from port 1) during cycle 183 (1830ns - 1840ns)
*	Writing 0+0101001011110100  to  address 100000000 (from port 0) during cycle 185 (1850ns - 1860ns)
*	Writing 0+0110000100111001  to  address 100000001 (from port 0) during cycle 186 (1860ns - 1870ns)
*	Reading 0+0000110100010111 from address 100000010 (from port 1) during cycle 186 (1860ns - 1870ns)
*	Writing 0+0011000111110111  to  address 100000000 (from port 0) during cycle 188 (1880ns - 1890ns)
*	Writing 0+1111100011100000  to  address 000000011 (from port 0) during cycle 189 (1890ns - 1900ns)
*	Writing 0+1011110011101111  to  address 100000010 (from port 0) during cycle 190 (1900ns - 1910ns)
*	Reading 0+0111001010111000 from address 000000010 (from port 1) during cycle 190 (1900ns - 1910ns)
*	Writing 0+1101010011110010  to  address 000000011 (from port 0) during cycle 191 (1910ns - 1920ns)
*	Writing 0+0100100011011001  to  address 000000000 (from port 0) during cycle 192 (1920ns - 1930ns)
*	Reading 0+0110000100111001 from address 100000001 (from port 1) during cycle 192 (1920ns - 1930ns)
*	Reading 0+0100100011011001 from address 000000000 (from port 1) during cycle 194 (1940ns - 1950ns)
*	Writing 0+1000011101000011  to  address 000000011 (from port 0) during cycle 195 (1950ns - 1960ns)
*	Reading 0+1000011101000011 from address 000000011 (from port 1) during cycle 196 (1960ns - 1970ns)
*	Writing 0+1011001101101101  to  address 100000001 (from port 0) during cycle 197 (1970ns - 1980ns)
*	Writing 0+1110010001011010  to  address 000000010 (from port 0) during cycle 198 (1980ns - 1990ns)
*	Reading 0+0100100011011001 from address 000000000 (from port 1) during cycle 198 (1980ns - 1990ns)
*	Writing 0+0101100100001001  to  address 000000011 (from port 0) during cycle 199 (1990ns - 2000ns)
*	Writing 0+1010000110001101  to  address 100000000 (from port 0) during cycle 200 (2000ns - 2010ns)
*	Reading 0+0100100011011001 from address 000000000 (from port 1) during cycle 201 (2010ns - 2020ns)
*	Writing 0+1100000010011100  to  address 000000001 (from port 0) during cycle 202 (2020ns - 2030ns)
*	Writing 0+0111100000001010  to  address 100000000 (from port 0) during cycle 203 (2030ns - 2040ns)
*	Writing 0+1101110111111111  to  address 100000010 (from port 0) during cycle 204 (2040ns - 2050ns)
*	Idle during cycle 205 (2050ns - 2060ns)

* Generation of data and address signals
* (time, data): [(0, 0), (10, 0), (20, 0), (30, 0), (40, 0), (50, 0), (60, 0), (70, 1), (80, 0), (90, 0), (100, 0), (110, 1), (120, 1), (130, 1), (140, 1), (150, 1), (160, 1), (170, 1), (180, 1), (190, 1), (200, 1), (210, 1), (220, 1), (230, 1), (240, 1), (250, 1), (260, 1), (270, 1), (280, 1), (290, 1), (300, 1), (310, 0), (320, 0), (330, 0), (340, 0), (350, 0), (360, 0), (370, 0), (380, 0), (390, 1), (400, 1), (410, 1), (420, 1), (430, 1), (440, 1), (450, 1), (460, 0), (470, 1), (480, 1), (490, 1), (500, 1), (510, 1), (520, 1), (530, 1), (540, 1), (550, 1), (560, 1), (570, 1), (580, 1), (590, 1), (600, 1), (610, 1), (620, 1), (630, 1), (640, 1), (650, 1), (660, 1), (670, 0), (680, 1), (690, 1), (700, 1), (710, 1), (720, 1), (730, 1), (740, 1), (750, 1), (760, 1), (770, 0), (780, 1), (790, 1), (800, 1), (810, 1), (820, 1), (830, 1), (840, 1), (850, 1), (860, 0), (870, 1), (880, 1), (890, 1), (900, 1), (910, 0), (920, 0), (930, 0), (940, 0), (950, 1), (960, 0), (970, 0), (980, 0), (990, 0), (1000, 0), (1010, 0), (1020, 0), (1030, 0), (1040, 0), (1050, 0), (1060, 0), (1070, 1), (1080, 1), (1090, 1), (1100, 0), (1110, 0), (1120, 0), (1130, 0), (1140, 0), (1150, 0), (1160, 1), (1170, 1), (1180, 0), (1190, 0), (1200, 0), (1210, 0), (1220, 0), (1230, 0), (1240, 0), (1250, 0), (1260, 0), (1270, 0), (1280, 0), (1290, 1), (1300, 1), (1310, 1), (1320, 1), (1330, 1), (1340, 1), (1350, 0), (1360, 0), (1370, 0), (1380, 0), (1390, 0), (1400, 1), (1410, 0), (1420, 0), (1430, 0), (1440, 1), (1450, 1), (1460, 1), (1470, 1), (1480, 1), (1490, 1), (1500, 1), (1510, 1), (1520, 0), (1530, 0), (1540, 0), (1550, 1), (1560, 0), (1570, 0), (1580, 1), (1590, 1), (1600, 1), (1610, 0), (1620, 0), (1630, 0), (1640, 1), (1650, 0), (1660, 0), (1670, 0), (1680, 0), (1690, 1), (1700, 0), (1710, 0), (1720, 1), (1730, 1), (1740, 1), (1750, 1), (1760, 1), (1770, 1), (1780, 1), (1790, 1), (1800, 1), (1810, 0), (1820, 0), (1830, 0), (1840, 0), (1850, 0), (1860, 1), (1870, 1), (1880, 1), (1890, 0), (1900, 1), (1910, 0), (1920, 1), (1930, 1), (1940, 1), (1950, 1), (1960, 1), (1970, 1), (1980, 0), (1990, 1), (2000, 1), (2010, 1), (2020, 0), (2030, 0), (2040, 1), (2050, 1)]
Vdin0_0  din0_0  0 PWL (0n 0.0v 9.495n 0.0v 9.505n 0.0v 19.495n 0.0v 19.505n 0.0v 29.495n 0.0v 29.505n 0.0v 39.495n 0.0v 39.505n 0.0v 49.495n 0.0v 49.505n 0.0v 59.495n 0.0v 59.505n 0.0v 69.495n 0.0v 69.505n 1.7v 79.495n 1.7v 79.505n 0.0v 89.495n 0.0v 89.505n 0.0v 99.495n 0.0v 99.505n 0.0v 109.495n 0.0v 109.505n 1.7v 119.495n 1.7v 119.505n 1.7v 129.495n 1.7v 129.505n 1.7v 139.495n 1.7v 139.505n 1.7v 149.495n 1.7v 149.505n 1.7v 159.495n 1.7v 159.505n 1.7v 169.495n 1.7v 169.505n 1.7v 179.495n 1.7v 179.505n 1.7v 189.495n 1.7v 189.505n 1.7v 199.495n 1.7v 199.505n 1.7v 209.495n 1.7v 209.505n 1.7v 219.495n 1.7v 219.505n 1.7v 229.495n 1.7v 229.505n 1.7v 239.495n 1.7v 239.505n 1.7v 249.495n 1.7v 249.505n 1.7v 259.495n 1.7v 259.505n 1.7v 269.495n 1.7v 269.505n 1.7v 279.495n 1.7v 279.505n 1.7v 289.495n 1.7v 289.505n 1.7v 299.495n 1.7v 299.505n 1.7v 309.495n 1.7v 309.505n 0.0v 319.495n 0.0v 319.505n 0.0v 329.495n 0.0v 329.505n 0.0v 339.495n 0.0v 339.505n 0.0v 349.495n 0.0v 349.505n 0.0v 359.495n 0.0v 359.505n 0.0v 369.495n 0.0v 369.505n 0.0v 379.495n 0.0v 379.505n 0.0v 389.495n 0.0v 389.505n 1.7v 399.495n 1.7v 399.505n 1.7v 409.495n 1.7v 409.505n 1.7v 419.495n 1.7v 419.505n 1.7v 429.495n 1.7v 429.505n 1.7v 439.495n 1.7v 439.505n 1.7v 449.495n 1.7v 449.505n 1.7v 459.495n 1.7v 459.505n 0.0v 469.495n 0.0v 469.505n 1.7v 479.495n 1.7v 479.505n 1.7v 489.495n 1.7v 489.505n 1.7v 499.495n 1.7v 499.505n 1.7v 509.495n 1.7v 509.505n 1.7v 519.495n 1.7v 519.505n 1.7v 529.495n 1.7v 529.505n 1.7v 539.495n 1.7v 539.505n 1.7v 549.495n 1.7v 549.505n 1.7v 559.495n 1.7v 559.505n 1.7v 569.495n 1.7v 569.505n 1.7v 579.495n 1.7v 579.505n 1.7v 589.495n 1.7v 589.505n 1.7v 599.495n 1.7v 599.505n 1.7v 609.495n 1.7v 609.505n 1.7v 619.495n 1.7v 619.505n 1.7v 629.495n 1.7v 629.505n 1.7v 639.495n 1.7v 639.505n 1.7v 649.495n 1.7v 649.505n 1.7v 659.495n 1.7v 659.505n 1.7v 669.495n 1.7v 669.505n 0.0v 679.495n 0.0v 679.505n 1.7v 689.495n 1.7v 689.505n 1.7v 699.495n 1.7v 699.505n 1.7v 709.495n 1.7v 709.505n 1.7v 719.495n 1.7v 719.505n 1.7v 729.495n 1.7v 729.505n 1.7v 739.495n 1.7v 739.505n 1.7v 749.495n 1.7v 749.505n 1.7v 759.495n 1.7v 759.505n 1.7v 769.495n 1.7v 769.505n 0.0v 779.495n 0.0v 779.505n 1.7v 789.495n 1.7v 789.505n 1.7v 799.495n 1.7v 799.505n 1.7v 809.495n 1.7v 809.505n 1.7v 819.495n 1.7v 819.505n 1.7v 829.495n 1.7v 829.505n 1.7v 839.495n 1.7v 839.505n 1.7v 849.495n 1.7v 849.505n 1.7v 859.495n 1.7v 859.505n 0.0v 869.495n 0.0v 869.505n 1.7v 879.495n 1.7v 879.505n 1.7v 889.495n 1.7v 889.505n 1.7v 899.495n 1.7v 899.505n 1.7v 909.495n 1.7v 909.505n 0.0v 919.495n 0.0v 919.505n 0.0v 929.495n 0.0v 929.505n 0.0v 939.495n 0.0v 939.505n 0.0v 949.495n 0.0v 949.505n 1.7v 959.495n 1.7v 959.505n 0.0v 969.495n 0.0v 969.505n 0.0v 979.495n 0.0v 979.505n 0.0v 989.495n 0.0v 989.505n 0.0v 999.495n 0.0v 999.505n 0.0v 1009.495n 0.0v 1009.505n 0.0v 1019.495n 0.0v 1019.505n 0.0v 1029.495n 0.0v 1029.505n 0.0v 1039.495n 0.0v 1039.505n 0.0v 1049.495n 0.0v 1049.505n 0.0v 1059.495n 0.0v 1059.505n 0.0v 1069.495n 0.0v 1069.505n 1.7v 1079.495n 1.7v 1079.505n 1.7v 1089.495n 1.7v 1089.505n 1.7v 1099.495n 1.7v 1099.505n 0.0v 1109.495n 0.0v 1109.505n 0.0v 1119.495n 0.0v 1119.505n 0.0v 1129.495n 0.0v 1129.505n 0.0v 1139.495n 0.0v 1139.505n 0.0v 1149.495n 0.0v 1149.505n 0.0v 1159.495n 0.0v 1159.505n 1.7v 1169.495n 1.7v 1169.505n 1.7v 1179.495n 1.7v 1179.505n 0.0v 1189.495n 0.0v 1189.505n 0.0v 1199.495n 0.0v 1199.505n 0.0v 1209.495n 0.0v 1209.505n 0.0v 1219.495n 0.0v 1219.505n 0.0v 1229.495n 0.0v 1229.505n 0.0v 1239.495n 0.0v 1239.505n 0.0v 1249.495n 0.0v 1249.505n 0.0v 1259.495n 0.0v 1259.505n 0.0v 1269.495n 0.0v 1269.505n 0.0v 1279.495n 0.0v 1279.505n 0.0v 1289.495n 0.0v 1289.505n 1.7v 1299.495n 1.7v 1299.505n 1.7v 1309.495n 1.7v 1309.505n 1.7v 1319.495n 1.7v 1319.505n 1.7v 1329.495n 1.7v 1329.505n 1.7v 1339.495n 1.7v 1339.505n 1.7v 1349.495n 1.7v 1349.505n 0.0v 1359.495n 0.0v 1359.505n 0.0v 1369.495n 0.0v 1369.505n 0.0v 1379.495n 0.0v 1379.505n 0.0v 1389.495n 0.0v 1389.505n 0.0v 1399.495n 0.0v 1399.505n 1.7v 1409.495n 1.7v 1409.505n 0.0v 1419.495n 0.0v 1419.505n 0.0v 1429.495n 0.0v 1429.505n 0.0v 1439.495n 0.0v 1439.505n 1.7v 1449.495n 1.7v 1449.505n 1.7v 1459.495n 1.7v 1459.505n 1.7v 1469.495n 1.7v 1469.505n 1.7v 1479.495n 1.7v 1479.505n 1.7v 1489.495n 1.7v 1489.505n 1.7v 1499.495n 1.7v 1499.505n 1.7v 1509.495n 1.7v 1509.505n 1.7v 1519.495n 1.7v 1519.505n 0.0v 1529.495n 0.0v 1529.505n 0.0v 1539.495n 0.0v 1539.505n 0.0v 1549.495n 0.0v 1549.505n 1.7v 1559.495n 1.7v 1559.505n 0.0v 1569.495n 0.0v 1569.505n 0.0v 1579.495n 0.0v 1579.505n 1.7v 1589.495n 1.7v 1589.505n 1.7v 1599.495n 1.7v 1599.505n 1.7v 1609.495n 1.7v 1609.505n 0.0v 1619.495n 0.0v 1619.505n 0.0v 1629.495n 0.0v 1629.505n 0.0v 1639.495n 0.0v 1639.505n 1.7v 1649.495n 1.7v 1649.505n 0.0v 1659.495n 0.0v 1659.505n 0.0v 1669.495n 0.0v 1669.505n 0.0v 1679.495n 0.0v 1679.505n 0.0v 1689.495n 0.0v 1689.505n 1.7v 1699.495n 1.7v 1699.505n 0.0v 1709.495n 0.0v 1709.505n 0.0v 1719.495n 0.0v 1719.505n 1.7v 1729.495n 1.7v 1729.505n 1.7v 1739.495n 1.7v 1739.505n 1.7v 1749.495n 1.7v 1749.505n 1.7v 1759.495n 1.7v 1759.505n 1.7v 1769.495n 1.7v 1769.505n 1.7v 1779.495n 1.7v 1779.505n 1.7v 1789.495n 1.7v 1789.505n 1.7v 1799.495n 1.7v 1799.505n 1.7v 1809.495n 1.7v 1809.505n 0.0v 1819.495n 0.0v 1819.505n 0.0v 1829.495n 0.0v 1829.505n 0.0v 1839.495n 0.0v 1839.505n 0.0v 1849.495n 0.0v 1849.505n 0.0v 1859.495n 0.0v 1859.505n 1.7v 1869.495n 1.7v 1869.505n 1.7v 1879.495n 1.7v 1879.505n 1.7v 1889.495n 1.7v 1889.505n 0.0v 1899.495n 0.0v 1899.505n 1.7v 1909.495n 1.7v 1909.505n 0.0v 1919.495n 0.0v 1919.505n 1.7v 1929.495n 1.7v 1929.505n 1.7v 1939.495n 1.7v 1939.505n 1.7v 1949.495n 1.7v 1949.505n 1.7v 1959.495n 1.7v 1959.505n 1.7v 1969.495n 1.7v 1969.505n 1.7v 1979.495n 1.7v 1979.505n 0.0v 1989.495n 0.0v 1989.505n 1.7v 1999.495n 1.7v 1999.505n 1.7v 2009.495n 1.7v 2009.505n 1.7v 2019.495n 1.7v 2019.505n 0.0v 2029.495n 0.0v 2029.505n 0.0v 2039.495n 0.0v 2039.505n 1.7v 2049.495n 1.7v 2049.505n 1.7v )
* (time, data): [(0, 0), (10, 0), (20, 0), (30, 0), (40, 0), (50, 0), (60, 0), (70, 1), (80, 0), (90, 0), (100, 0), (110, 1), (120, 1), (130, 1), (140, 1), (150, 1), (160, 1), (170, 1), (180, 1), (190, 0), (200, 0), (210, 0), (220, 0), (230, 1), (240, 1), (250, 1), (260, 1), (270, 1), (280, 0), (290, 0), (300, 0), (310, 0), (320, 0), (330, 0), (340, 0), (350, 1), (360, 1), (370, 1), (380, 1), (390, 0), (400, 0), (410, 0), (420, 1), (430, 1), (440, 1), (450, 0), (460, 0), (470, 0), (480, 0), (490, 0), (500, 0), (510, 0), (520, 0), (530, 0), (540, 0), (550, 0), (560, 0), (570, 0), (580, 0), (590, 0), (600, 0), (610, 0), (620, 1), (630, 1), (640, 1), (650, 0), (660, 0), (670, 0), (680, 0), (690, 0), (700, 0), (710, 1), (720, 1), (730, 1), (740, 1), (750, 1), (760, 1), (770, 1), (780, 1), (790, 0), (800, 0), (810, 0), (820, 0), (830, 0), (840, 0), (850, 0), (860, 1), (870, 0), (880, 0), (890, 0), (900, 0), (910, 0), (920, 0), (930, 0), (940, 0), (950, 0), (960, 0), (970, 0), (980, 0), (990, 0), (1000, 0), (1010, 0), (1020, 0), (1030, 0), (1040, 0), (1050, 0), (1060, 0), (1070, 0), (1080, 0), (1090, 0), (1100, 1), (1110, 1), (1120, 1), (1130, 0), (1140, 0), (1150, 0), (1160, 0), (1170, 0), (1180, 0), (1190, 0), (1200, 0), (1210, 0), (1220, 0), (1230, 1), (1240, 1), (1250, 1), (1260, 1), (1270, 1), (1280, 1), (1290, 0), (1300, 0), (1310, 0), (1320, 0), (1330, 0), (1340, 0), (1350, 0), (1360, 0), (1370, 0), (1380, 0), (1390, 0), (1400, 0), (1410, 0), (1420, 0), (1430, 0), (1440, 1), (1450, 1), (1460, 1), (1470, 1), (1480, 1), (1490, 1), (1500, 0), (1510, 0), (1520, 0), (1530, 0), (1540, 0), (1550, 1), (1560, 1), (1570, 1), (1580, 1), (1590, 1), (1600, 1), (1610, 1), (1620, 1), (1630, 1), (1640, 0), (1650, 0), (1660, 0), (1670, 0), (1680, 1), (1690, 0), (1700, 0), (1710, 0), (1720, 0), (1730, 0), (1740, 1), (1750, 1), (1760, 1), (1770, 1), (1780, 1), (1790, 1), (1800, 1), (1810, 1), (1820, 0), (1830, 0), (1840, 0), (1850, 0), (1860, 0), (1870, 0), (1880, 1), (1890, 0), (1900, 1), (1910, 1), (1920, 0), (1930, 0), (1940, 0), (1950, 1), (1960, 1), (1970, 0), (1980, 1), (1990, 0), (2000, 0), (2010, 0), (2020, 0), (2030, 1), (2040, 1), (2050, 1)]
Vdin0_1  din0_1  0 PWL (0n 0.0v 9.495n 0.0v 9.505n 0.0v 19.495n 0.0v 19.505n 0.0v 29.495n 0.0v 29.505n 0.0v 39.495n 0.0v 39.505n 0.0v 49.495n 0.0v 49.505n 0.0v 59.495n 0.0v 59.505n 0.0v 69.495n 0.0v 69.505n 1.7v 79.495n 1.7v 79.505n 0.0v 89.495n 0.0v 89.505n 0.0v 99.495n 0.0v 99.505n 0.0v 109.495n 0.0v 109.505n 1.7v 119.495n 1.7v 119.505n 1.7v 129.495n 1.7v 129.505n 1.7v 139.495n 1.7v 139.505n 1.7v 149.495n 1.7v 149.505n 1.7v 159.495n 1.7v 159.505n 1.7v 169.495n 1.7v 169.505n 1.7v 179.495n 1.7v 179.505n 1.7v 189.495n 1.7v 189.505n 0.0v 199.495n 0.0v 199.505n 0.0v 209.495n 0.0v 209.505n 0.0v 219.495n 0.0v 219.505n 0.0v 229.495n 0.0v 229.505n 1.7v 239.495n 1.7v 239.505n 1.7v 249.495n 1.7v 249.505n 1.7v 259.495n 1.7v 259.505n 1.7v 269.495n 1.7v 269.505n 1.7v 279.495n 1.7v 279.505n 0.0v 289.495n 0.0v 289.505n 0.0v 299.495n 0.0v 299.505n 0.0v 309.495n 0.0v 309.505n 0.0v 319.495n 0.0v 319.505n 0.0v 329.495n 0.0v 329.505n 0.0v 339.495n 0.0v 339.505n 0.0v 349.495n 0.0v 349.505n 1.7v 359.495n 1.7v 359.505n 1.7v 369.495n 1.7v 369.505n 1.7v 379.495n 1.7v 379.505n 1.7v 389.495n 1.7v 389.505n 0.0v 399.495n 0.0v 399.505n 0.0v 409.495n 0.0v 409.505n 0.0v 419.495n 0.0v 419.505n 1.7v 429.495n 1.7v 429.505n 1.7v 439.495n 1.7v 439.505n 1.7v 449.495n 1.7v 449.505n 0.0v 459.495n 0.0v 459.505n 0.0v 469.495n 0.0v 469.505n 0.0v 479.495n 0.0v 479.505n 0.0v 489.495n 0.0v 489.505n 0.0v 499.495n 0.0v 499.505n 0.0v 509.495n 0.0v 509.505n 0.0v 519.495n 0.0v 519.505n 0.0v 529.495n 0.0v 529.505n 0.0v 539.495n 0.0v 539.505n 0.0v 549.495n 0.0v 549.505n 0.0v 559.495n 0.0v 559.505n 0.0v 569.495n 0.0v 569.505n 0.0v 579.495n 0.0v 579.505n 0.0v 589.495n 0.0v 589.505n 0.0v 599.495n 0.0v 599.505n 0.0v 609.495n 0.0v 609.505n 0.0v 619.495n 0.0v 619.505n 1.7v 629.495n 1.7v 629.505n 1.7v 639.495n 1.7v 639.505n 1.7v 649.495n 1.7v 649.505n 0.0v 659.495n 0.0v 659.505n 0.0v 669.495n 0.0v 669.505n 0.0v 679.495n 0.0v 679.505n 0.0v 689.495n 0.0v 689.505n 0.0v 699.495n 0.0v 699.505n 0.0v 709.495n 0.0v 709.505n 1.7v 719.495n 1.7v 719.505n 1.7v 729.495n 1.7v 729.505n 1.7v 739.495n 1.7v 739.505n 1.7v 749.495n 1.7v 749.505n 1.7v 759.495n 1.7v 759.505n 1.7v 769.495n 1.7v 769.505n 1.7v 779.495n 1.7v 779.505n 1.7v 789.495n 1.7v 789.505n 0.0v 799.495n 0.0v 799.505n 0.0v 809.495n 0.0v 809.505n 0.0v 819.495n 0.0v 819.505n 0.0v 829.495n 0.0v 829.505n 0.0v 839.495n 0.0v 839.505n 0.0v 849.495n 0.0v 849.505n 0.0v 859.495n 0.0v 859.505n 1.7v 869.495n 1.7v 869.505n 0.0v 879.495n 0.0v 879.505n 0.0v 889.495n 0.0v 889.505n 0.0v 899.495n 0.0v 899.505n 0.0v 909.495n 0.0v 909.505n 0.0v 919.495n 0.0v 919.505n 0.0v 929.495n 0.0v 929.505n 0.0v 939.495n 0.0v 939.505n 0.0v 949.495n 0.0v 949.505n 0.0v 959.495n 0.0v 959.505n 0.0v 969.495n 0.0v 969.505n 0.0v 979.495n 0.0v 979.505n 0.0v 989.495n 0.0v 989.505n 0.0v 999.495n 0.0v 999.505n 0.0v 1009.495n 0.0v 1009.505n 0.0v 1019.495n 0.0v 1019.505n 0.0v 1029.495n 0.0v 1029.505n 0.0v 1039.495n 0.0v 1039.505n 0.0v 1049.495n 0.0v 1049.505n 0.0v 1059.495n 0.0v 1059.505n 0.0v 1069.495n 0.0v 1069.505n 0.0v 1079.495n 0.0v 1079.505n 0.0v 1089.495n 0.0v 1089.505n 0.0v 1099.495n 0.0v 1099.505n 1.7v 1109.495n 1.7v 1109.505n 1.7v 1119.495n 1.7v 1119.505n 1.7v 1129.495n 1.7v 1129.505n 0.0v 1139.495n 0.0v 1139.505n 0.0v 1149.495n 0.0v 1149.505n 0.0v 1159.495n 0.0v 1159.505n 0.0v 1169.495n 0.0v 1169.505n 0.0v 1179.495n 0.0v 1179.505n 0.0v 1189.495n 0.0v 1189.505n 0.0v 1199.495n 0.0v 1199.505n 0.0v 1209.495n 0.0v 1209.505n 0.0v 1219.495n 0.0v 1219.505n 0.0v 1229.495n 0.0v 1229.505n 1.7v 1239.495n 1.7v 1239.505n 1.7v 1249.495n 1.7v 1249.505n 1.7v 1259.495n 1.7v 1259.505n 1.7v 1269.495n 1.7v 1269.505n 1.7v 1279.495n 1.7v 1279.505n 1.7v 1289.495n 1.7v 1289.505n 0.0v 1299.495n 0.0v 1299.505n 0.0v 1309.495n 0.0v 1309.505n 0.0v 1319.495n 0.0v 1319.505n 0.0v 1329.495n 0.0v 1329.505n 0.0v 1339.495n 0.0v 1339.505n 0.0v 1349.495n 0.0v 1349.505n 0.0v 1359.495n 0.0v 1359.505n 0.0v 1369.495n 0.0v 1369.505n 0.0v 1379.495n 0.0v 1379.505n 0.0v 1389.495n 0.0v 1389.505n 0.0v 1399.495n 0.0v 1399.505n 0.0v 1409.495n 0.0v 1409.505n 0.0v 1419.495n 0.0v 1419.505n 0.0v 1429.495n 0.0v 1429.505n 0.0v 1439.495n 0.0v 1439.505n 1.7v 1449.495n 1.7v 1449.505n 1.7v 1459.495n 1.7v 1459.505n 1.7v 1469.495n 1.7v 1469.505n 1.7v 1479.495n 1.7v 1479.505n 1.7v 1489.495n 1.7v 1489.505n 1.7v 1499.495n 1.7v 1499.505n 0.0v 1509.495n 0.0v 1509.505n 0.0v 1519.495n 0.0v 1519.505n 0.0v 1529.495n 0.0v 1529.505n 0.0v 1539.495n 0.0v 1539.505n 0.0v 1549.495n 0.0v 1549.505n 1.7v 1559.495n 1.7v 1559.505n 1.7v 1569.495n 1.7v 1569.505n 1.7v 1579.495n 1.7v 1579.505n 1.7v 1589.495n 1.7v 1589.505n 1.7v 1599.495n 1.7v 1599.505n 1.7v 1609.495n 1.7v 1609.505n 1.7v 1619.495n 1.7v 1619.505n 1.7v 1629.495n 1.7v 1629.505n 1.7v 1639.495n 1.7v 1639.505n 0.0v 1649.495n 0.0v 1649.505n 0.0v 1659.495n 0.0v 1659.505n 0.0v 1669.495n 0.0v 1669.505n 0.0v 1679.495n 0.0v 1679.505n 1.7v 1689.495n 1.7v 1689.505n 0.0v 1699.495n 0.0v 1699.505n 0.0v 1709.495n 0.0v 1709.505n 0.0v 1719.495n 0.0v 1719.505n 0.0v 1729.495n 0.0v 1729.505n 0.0v 1739.495n 0.0v 1739.505n 1.7v 1749.495n 1.7v 1749.505n 1.7v 1759.495n 1.7v 1759.505n 1.7v 1769.495n 1.7v 1769.505n 1.7v 1779.495n 1.7v 1779.505n 1.7v 1789.495n 1.7v 1789.505n 1.7v 1799.495n 1.7v 1799.505n 1.7v 1809.495n 1.7v 1809.505n 1.7v 1819.495n 1.7v 1819.505n 0.0v 1829.495n 0.0v 1829.505n 0.0v 1839.495n 0.0v 1839.505n 0.0v 1849.495n 0.0v 1849.505n 0.0v 1859.495n 0.0v 1859.505n 0.0v 1869.495n 0.0v 1869.505n 0.0v 1879.495n 0.0v 1879.505n 1.7v 1889.495n 1.7v 1889.505n 0.0v 1899.495n 0.0v 1899.505n 1.7v 1909.495n 1.7v 1909.505n 1.7v 1919.495n 1.7v 1919.505n 0.0v 1929.495n 0.0v 1929.505n 0.0v 1939.495n 0.0v 1939.505n 0.0v 1949.495n 0.0v 1949.505n 1.7v 1959.495n 1.7v 1959.505n 1.7v 1969.495n 1.7v 1969.505n 0.0v 1979.495n 0.0v 1979.505n 1.7v 1989.495n 1.7v 1989.505n 0.0v 1999.495n 0.0v 1999.505n 0.0v 2009.495n 0.0v 2009.505n 0.0v 2019.495n 0.0v 2019.505n 0.0v 2029.495n 0.0v 2029.505n 1.7v 2039.495n 1.7v 2039.505n 1.7v 2049.495n 1.7v 2049.505n 1.7v )
* (time, data): [(0, 0), (10, 1), (20, 0), (30, 1), (40, 1), (50, 1), (60, 1), (70, 1), (80, 0), (90, 0), (100, 0), (110, 0), (120, 0), (130, 0), (140, 0), (150, 0), (160, 0), (170, 0), (180, 0), (190, 0), (200, 0), (210, 1), (220, 1), (230, 0), (240, 0), (250, 1), (260, 1), (270, 1), (280, 1), (290, 1), (300, 1), (310, 0), (320, 0), (330, 1), (340, 1), (350, 1), (360, 1), (370, 0), (380, 0), (390, 1), (400, 1), (410, 1), (420, 0), (430, 0), (440, 0), (450, 1), (460, 0), (470, 1), (480, 0), (490, 0), (500, 1), (510, 1), (520, 1), (530, 1), (540, 1), (550, 0), (560, 0), (570, 0), (580, 0), (590, 0), (600, 0), (610, 0), (620, 0), (630, 1), (640, 1), (650, 0), (660, 0), (670, 1), (680, 1), (690, 1), (700, 1), (710, 0), (720, 1), (730, 1), (740, 0), (750, 0), (760, 0), (770, 0), (780, 0), (790, 0), (800, 0), (810, 0), (820, 0), (830, 0), (840, 0), (850, 0), (860, 0), (870, 1), (880, 0), (890, 0), (900, 0), (910, 0), (920, 0), (930, 0), (940, 0), (950, 0), (960, 0), (970, 0), (980, 0), (990, 0), (1000, 0), (1010, 0), (1020, 0), (1030, 0), (1040, 0), (1050, 0), (1060, 0), (1070, 1), (1080, 1), (1090, 1), (1100, 0), (1110, 0), (1120, 0), (1130, 0), (1140, 0), (1150, 0), (1160, 0), (1170, 0), (1180, 1), (1190, 1), (1200, 1), (1210, 1), (1220, 1), (1230, 0), (1240, 0), (1250, 0), (1260, 0), (1270, 0), (1280, 1), (1290, 1), (1300, 0), (1310, 0), (1320, 0), (1330, 0), (1340, 0), (1350, 1), (1360, 1), (1370, 1), (1380, 1), (1390, 1), (1400, 1), (1410, 0), (1420, 0), (1430, 0), (1440, 0), (1450, 1), (1460, 1), (1470, 1), (1480, 1), (1490, 1), (1500, 0), (1510, 0), (1520, 0), (1530, 0), (1540, 0), (1550, 1), (1560, 0), (1570, 1), (1580, 0), (1590, 0), (1600, 0), (1610, 0), (1620, 0), (1630, 0), (1640, 1), (1650, 1), (1660, 1), (1670, 0), (1680, 1), (1690, 0), (1700, 0), (1710, 0), (1720, 1), (1730, 1), (1740, 1), (1750, 1), (1760, 1), (1770, 1), (1780, 0), (1790, 0), (1800, 0), (1810, 0), (1820, 1), (1830, 1), (1840, 1), (1850, 1), (1860, 0), (1870, 0), (1880, 1), (1890, 0), (1900, 1), (1910, 0), (1920, 0), (1930, 0), (1940, 0), (1950, 0), (1960, 0), (1970, 1), (1980, 0), (1990, 0), (2000, 1), (2010, 1), (2020, 1), (2030, 0), (2040, 1), (2050, 1)]
Vdin0_2  din0_2  0 PWL (0n 0.0v 9.495n 0.0v 9.505n 1.7v 19.495n 1.7v 19.505n 0.0v 29.495n 0.0v 29.505n 1.7v 39.495n 1.7v 39.505n 1.7v 49.495n 1.7v 49.505n 1.7v 59.495n 1.7v 59.505n 1.7v 69.495n 1.7v 69.505n 1.7v 79.495n 1.7v 79.505n 0.0v 89.495n 0.0v 89.505n 0.0v 99.495n 0.0v 99.505n 0.0v 109.495n 0.0v 109.505n 0.0v 119.495n 0.0v 119.505n 0.0v 129.495n 0.0v 129.505n 0.0v 139.495n 0.0v 139.505n 0.0v 149.495n 0.0v 149.505n 0.0v 159.495n 0.0v 159.505n 0.0v 169.495n 0.0v 169.505n 0.0v 179.495n 0.0v 179.505n 0.0v 189.495n 0.0v 189.505n 0.0v 199.495n 0.0v 199.505n 0.0v 209.495n 0.0v 209.505n 1.7v 219.495n 1.7v 219.505n 1.7v 229.495n 1.7v 229.505n 0.0v 239.495n 0.0v 239.505n 0.0v 249.495n 0.0v 249.505n 1.7v 259.495n 1.7v 259.505n 1.7v 269.495n 1.7v 269.505n 1.7v 279.495n 1.7v 279.505n 1.7v 289.495n 1.7v 289.505n 1.7v 299.495n 1.7v 299.505n 1.7v 309.495n 1.7v 309.505n 0.0v 319.495n 0.0v 319.505n 0.0v 329.495n 0.0v 329.505n 1.7v 339.495n 1.7v 339.505n 1.7v 349.495n 1.7v 349.505n 1.7v 359.495n 1.7v 359.505n 1.7v 369.495n 1.7v 369.505n 0.0v 379.495n 0.0v 379.505n 0.0v 389.495n 0.0v 389.505n 1.7v 399.495n 1.7v 399.505n 1.7v 409.495n 1.7v 409.505n 1.7v 419.495n 1.7v 419.505n 0.0v 429.495n 0.0v 429.505n 0.0v 439.495n 0.0v 439.505n 0.0v 449.495n 0.0v 449.505n 1.7v 459.495n 1.7v 459.505n 0.0v 469.495n 0.0v 469.505n 1.7v 479.495n 1.7v 479.505n 0.0v 489.495n 0.0v 489.505n 0.0v 499.495n 0.0v 499.505n 1.7v 509.495n 1.7v 509.505n 1.7v 519.495n 1.7v 519.505n 1.7v 529.495n 1.7v 529.505n 1.7v 539.495n 1.7v 539.505n 1.7v 549.495n 1.7v 549.505n 0.0v 559.495n 0.0v 559.505n 0.0v 569.495n 0.0v 569.505n 0.0v 579.495n 0.0v 579.505n 0.0v 589.495n 0.0v 589.505n 0.0v 599.495n 0.0v 599.505n 0.0v 609.495n 0.0v 609.505n 0.0v 619.495n 0.0v 619.505n 0.0v 629.495n 0.0v 629.505n 1.7v 639.495n 1.7v 639.505n 1.7v 649.495n 1.7v 649.505n 0.0v 659.495n 0.0v 659.505n 0.0v 669.495n 0.0v 669.505n 1.7v 679.495n 1.7v 679.505n 1.7v 689.495n 1.7v 689.505n 1.7v 699.495n 1.7v 699.505n 1.7v 709.495n 1.7v 709.505n 0.0v 719.495n 0.0v 719.505n 1.7v 729.495n 1.7v 729.505n 1.7v 739.495n 1.7v 739.505n 0.0v 749.495n 0.0v 749.505n 0.0v 759.495n 0.0v 759.505n 0.0v 769.495n 0.0v 769.505n 0.0v 779.495n 0.0v 779.505n 0.0v 789.495n 0.0v 789.505n 0.0v 799.495n 0.0v 799.505n 0.0v 809.495n 0.0v 809.505n 0.0v 819.495n 0.0v 819.505n 0.0v 829.495n 0.0v 829.505n 0.0v 839.495n 0.0v 839.505n 0.0v 849.495n 0.0v 849.505n 0.0v 859.495n 0.0v 859.505n 0.0v 869.495n 0.0v 869.505n 1.7v 879.495n 1.7v 879.505n 0.0v 889.495n 0.0v 889.505n 0.0v 899.495n 0.0v 899.505n 0.0v 909.495n 0.0v 909.505n 0.0v 919.495n 0.0v 919.505n 0.0v 929.495n 0.0v 929.505n 0.0v 939.495n 0.0v 939.505n 0.0v 949.495n 0.0v 949.505n 0.0v 959.495n 0.0v 959.505n 0.0v 969.495n 0.0v 969.505n 0.0v 979.495n 0.0v 979.505n 0.0v 989.495n 0.0v 989.505n 0.0v 999.495n 0.0v 999.505n 0.0v 1009.495n 0.0v 1009.505n 0.0v 1019.495n 0.0v 1019.505n 0.0v 1029.495n 0.0v 1029.505n 0.0v 1039.495n 0.0v 1039.505n 0.0v 1049.495n 0.0v 1049.505n 0.0v 1059.495n 0.0v 1059.505n 0.0v 1069.495n 0.0v 1069.505n 1.7v 1079.495n 1.7v 1079.505n 1.7v 1089.495n 1.7v 1089.505n 1.7v 1099.495n 1.7v 1099.505n 0.0v 1109.495n 0.0v 1109.505n 0.0v 1119.495n 0.0v 1119.505n 0.0v 1129.495n 0.0v 1129.505n 0.0v 1139.495n 0.0v 1139.505n 0.0v 1149.495n 0.0v 1149.505n 0.0v 1159.495n 0.0v 1159.505n 0.0v 1169.495n 0.0v 1169.505n 0.0v 1179.495n 0.0v 1179.505n 1.7v 1189.495n 1.7v 1189.505n 1.7v 1199.495n 1.7v 1199.505n 1.7v 1209.495n 1.7v 1209.505n 1.7v 1219.495n 1.7v 1219.505n 1.7v 1229.495n 1.7v 1229.505n 0.0v 1239.495n 0.0v 1239.505n 0.0v 1249.495n 0.0v 1249.505n 0.0v 1259.495n 0.0v 1259.505n 0.0v 1269.495n 0.0v 1269.505n 0.0v 1279.495n 0.0v 1279.505n 1.7v 1289.495n 1.7v 1289.505n 1.7v 1299.495n 1.7v 1299.505n 0.0v 1309.495n 0.0v 1309.505n 0.0v 1319.495n 0.0v 1319.505n 0.0v 1329.495n 0.0v 1329.505n 0.0v 1339.495n 0.0v 1339.505n 0.0v 1349.495n 0.0v 1349.505n 1.7v 1359.495n 1.7v 1359.505n 1.7v 1369.495n 1.7v 1369.505n 1.7v 1379.495n 1.7v 1379.505n 1.7v 1389.495n 1.7v 1389.505n 1.7v 1399.495n 1.7v 1399.505n 1.7v 1409.495n 1.7v 1409.505n 0.0v 1419.495n 0.0v 1419.505n 0.0v 1429.495n 0.0v 1429.505n 0.0v 1439.495n 0.0v 1439.505n 0.0v 1449.495n 0.0v 1449.505n 1.7v 1459.495n 1.7v 1459.505n 1.7v 1469.495n 1.7v 1469.505n 1.7v 1479.495n 1.7v 1479.505n 1.7v 1489.495n 1.7v 1489.505n 1.7v 1499.495n 1.7v 1499.505n 0.0v 1509.495n 0.0v 1509.505n 0.0v 1519.495n 0.0v 1519.505n 0.0v 1529.495n 0.0v 1529.505n 0.0v 1539.495n 0.0v 1539.505n 0.0v 1549.495n 0.0v 1549.505n 1.7v 1559.495n 1.7v 1559.505n 0.0v 1569.495n 0.0v 1569.505n 1.7v 1579.495n 1.7v 1579.505n 0.0v 1589.495n 0.0v 1589.505n 0.0v 1599.495n 0.0v 1599.505n 0.0v 1609.495n 0.0v 1609.505n 0.0v 1619.495n 0.0v 1619.505n 0.0v 1629.495n 0.0v 1629.505n 0.0v 1639.495n 0.0v 1639.505n 1.7v 1649.495n 1.7v 1649.505n 1.7v 1659.495n 1.7v 1659.505n 1.7v 1669.495n 1.7v 1669.505n 0.0v 1679.495n 0.0v 1679.505n 1.7v 1689.495n 1.7v 1689.505n 0.0v 1699.495n 0.0v 1699.505n 0.0v 1709.495n 0.0v 1709.505n 0.0v 1719.495n 0.0v 1719.505n 1.7v 1729.495n 1.7v 1729.505n 1.7v 1739.495n 1.7v 1739.505n 1.7v 1749.495n 1.7v 1749.505n 1.7v 1759.495n 1.7v 1759.505n 1.7v 1769.495n 1.7v 1769.505n 1.7v 1779.495n 1.7v 1779.505n 0.0v 1789.495n 0.0v 1789.505n 0.0v 1799.495n 0.0v 1799.505n 0.0v 1809.495n 0.0v 1809.505n 0.0v 1819.495n 0.0v 1819.505n 1.7v 1829.495n 1.7v 1829.505n 1.7v 1839.495n 1.7v 1839.505n 1.7v 1849.495n 1.7v 1849.505n 1.7v 1859.495n 1.7v 1859.505n 0.0v 1869.495n 0.0v 1869.505n 0.0v 1879.495n 0.0v 1879.505n 1.7v 1889.495n 1.7v 1889.505n 0.0v 1899.495n 0.0v 1899.505n 1.7v 1909.495n 1.7v 1909.505n 0.0v 1919.495n 0.0v 1919.505n 0.0v 1929.495n 0.0v 1929.505n 0.0v 1939.495n 0.0v 1939.505n 0.0v 1949.495n 0.0v 1949.505n 0.0v 1959.495n 0.0v 1959.505n 0.0v 1969.495n 0.0v 1969.505n 1.7v 1979.495n 1.7v 1979.505n 0.0v 1989.495n 0.0v 1989.505n 0.0v 1999.495n 0.0v 1999.505n 1.7v 2009.495n 1.7v 2009.505n 1.7v 2019.495n 1.7v 2019.505n 1.7v 2029.495n 1.7v 2029.505n 0.0v 2039.495n 0.0v 2039.505n 1.7v 2049.495n 1.7v 2049.505n 1.7v )
* (time, data): [(0, 0), (10, 0), (20, 1), (30, 0), (40, 0), (50, 0), (60, 0), (70, 1), (80, 0), (90, 0), (100, 0), (110, 0), (120, 0), (130, 0), (140, 0), (150, 0), (160, 0), (170, 0), (180, 0), (190, 1), (200, 1), (210, 1), (220, 1), (230, 1), (240, 1), (250, 0), (260, 0), (270, 0), (280, 0), (290, 0), (300, 0), (310, 1), (320, 1), (330, 0), (340, 0), (350, 0), (360, 0), (370, 0), (380, 0), (390, 1), (400, 1), (410, 1), (420, 1), (430, 1), (440, 1), (450, 0), (460, 0), (470, 0), (480, 1), (490, 1), (500, 0), (510, 0), (520, 0), (530, 0), (540, 0), (550, 1), (560, 1), (570, 1), (580, 1), (590, 0), (600, 1), (610, 1), (620, 1), (630, 1), (640, 1), (650, 0), (660, 1), (670, 0), (680, 0), (690, 0), (700, 0), (710, 1), (720, 1), (730, 1), (740, 1), (750, 1), (760, 1), (770, 1), (780, 1), (790, 0), (800, 0), (810, 1), (820, 1), (830, 1), (840, 1), (850, 1), (860, 0), (870, 0), (880, 1), (890, 1), (900, 1), (910, 1), (920, 1), (930, 1), (940, 1), (950, 0), (960, 0), (970, 0), (980, 0), (990, 0), (1000, 1), (1010, 1), (1020, 0), (1030, 1), (1040, 1), (1050, 1), (1060, 1), (1070, 0), (1080, 0), (1090, 0), (1100, 1), (1110, 1), (1120, 1), (1130, 1), (1140, 1), (1150, 1), (1160, 0), (1170, 0), (1180, 0), (1190, 0), (1200, 0), (1210, 0), (1220, 0), (1230, 0), (1240, 0), (1250, 0), (1260, 0), (1270, 0), (1280, 1), (1290, 1), (1300, 0), (1310, 0), (1320, 0), (1330, 0), (1340, 0), (1350, 1), (1360, 1), (1370, 1), (1380, 1), (1390, 1), (1400, 1), (1410, 1), (1420, 1), (1430, 1), (1440, 0), (1450, 1), (1460, 1), (1470, 0), (1480, 0), (1490, 0), (1500, 1), (1510, 1), (1520, 0), (1530, 0), (1540, 0), (1550, 1), (1560, 1), (1570, 1), (1580, 1), (1590, 1), (1600, 1), (1610, 0), (1620, 0), (1630, 0), (1640, 0), (1650, 0), (1660, 0), (1670, 0), (1680, 0), (1690, 1), (1700, 0), (1710, 0), (1720, 1), (1730, 1), (1740, 0), (1750, 0), (1760, 1), (1770, 1), (1780, 0), (1790, 0), (1800, 0), (1810, 0), (1820, 1), (1830, 1), (1840, 1), (1850, 0), (1860, 1), (1870, 1), (1880, 0), (1890, 0), (1900, 1), (1910, 0), (1920, 1), (1930, 1), (1940, 1), (1950, 0), (1960, 0), (1970, 1), (1980, 1), (1990, 1), (2000, 1), (2010, 1), (2020, 1), (2030, 1), (2040, 1), (2050, 1)]
Vdin0_3  din0_3  0 PWL (0n 0.0v 9.495n 0.0v 9.505n 0.0v 19.495n 0.0v 19.505n 1.7v 29.495n 1.7v 29.505n 0.0v 39.495n 0.0v 39.505n 0.0v 49.495n 0.0v 49.505n 0.0v 59.495n 0.0v 59.505n 0.0v 69.495n 0.0v 69.505n 1.7v 79.495n 1.7v 79.505n 0.0v 89.495n 0.0v 89.505n 0.0v 99.495n 0.0v 99.505n 0.0v 109.495n 0.0v 109.505n 0.0v 119.495n 0.0v 119.505n 0.0v 129.495n 0.0v 129.505n 0.0v 139.495n 0.0v 139.505n 0.0v 149.495n 0.0v 149.505n 0.0v 159.495n 0.0v 159.505n 0.0v 169.495n 0.0v 169.505n 0.0v 179.495n 0.0v 179.505n 0.0v 189.495n 0.0v 189.505n 1.7v 199.495n 1.7v 199.505n 1.7v 209.495n 1.7v 209.505n 1.7v 219.495n 1.7v 219.505n 1.7v 229.495n 1.7v 229.505n 1.7v 239.495n 1.7v 239.505n 1.7v 249.495n 1.7v 249.505n 0.0v 259.495n 0.0v 259.505n 0.0v 269.495n 0.0v 269.505n 0.0v 279.495n 0.0v 279.505n 0.0v 289.495n 0.0v 289.505n 0.0v 299.495n 0.0v 299.505n 0.0v 309.495n 0.0v 309.505n 1.7v 319.495n 1.7v 319.505n 1.7v 329.495n 1.7v 329.505n 0.0v 339.495n 0.0v 339.505n 0.0v 349.495n 0.0v 349.505n 0.0v 359.495n 0.0v 359.505n 0.0v 369.495n 0.0v 369.505n 0.0v 379.495n 0.0v 379.505n 0.0v 389.495n 0.0v 389.505n 1.7v 399.495n 1.7v 399.505n 1.7v 409.495n 1.7v 409.505n 1.7v 419.495n 1.7v 419.505n 1.7v 429.495n 1.7v 429.505n 1.7v 439.495n 1.7v 439.505n 1.7v 449.495n 1.7v 449.505n 0.0v 459.495n 0.0v 459.505n 0.0v 469.495n 0.0v 469.505n 0.0v 479.495n 0.0v 479.505n 1.7v 489.495n 1.7v 489.505n 1.7v 499.495n 1.7v 499.505n 0.0v 509.495n 0.0v 509.505n 0.0v 519.495n 0.0v 519.505n 0.0v 529.495n 0.0v 529.505n 0.0v 539.495n 0.0v 539.505n 0.0v 549.495n 0.0v 549.505n 1.7v 559.495n 1.7v 559.505n 1.7v 569.495n 1.7v 569.505n 1.7v 579.495n 1.7v 579.505n 1.7v 589.495n 1.7v 589.505n 0.0v 599.495n 0.0v 599.505n 1.7v 609.495n 1.7v 609.505n 1.7v 619.495n 1.7v 619.505n 1.7v 629.495n 1.7v 629.505n 1.7v 639.495n 1.7v 639.505n 1.7v 649.495n 1.7v 649.505n 0.0v 659.495n 0.0v 659.505n 1.7v 669.495n 1.7v 669.505n 0.0v 679.495n 0.0v 679.505n 0.0v 689.495n 0.0v 689.505n 0.0v 699.495n 0.0v 699.505n 0.0v 709.495n 0.0v 709.505n 1.7v 719.495n 1.7v 719.505n 1.7v 729.495n 1.7v 729.505n 1.7v 739.495n 1.7v 739.505n 1.7v 749.495n 1.7v 749.505n 1.7v 759.495n 1.7v 759.505n 1.7v 769.495n 1.7v 769.505n 1.7v 779.495n 1.7v 779.505n 1.7v 789.495n 1.7v 789.505n 0.0v 799.495n 0.0v 799.505n 0.0v 809.495n 0.0v 809.505n 1.7v 819.495n 1.7v 819.505n 1.7v 829.495n 1.7v 829.505n 1.7v 839.495n 1.7v 839.505n 1.7v 849.495n 1.7v 849.505n 1.7v 859.495n 1.7v 859.505n 0.0v 869.495n 0.0v 869.505n 0.0v 879.495n 0.0v 879.505n 1.7v 889.495n 1.7v 889.505n 1.7v 899.495n 1.7v 899.505n 1.7v 909.495n 1.7v 909.505n 1.7v 919.495n 1.7v 919.505n 1.7v 929.495n 1.7v 929.505n 1.7v 939.495n 1.7v 939.505n 1.7v 949.495n 1.7v 949.505n 0.0v 959.495n 0.0v 959.505n 0.0v 969.495n 0.0v 969.505n 0.0v 979.495n 0.0v 979.505n 0.0v 989.495n 0.0v 989.505n 0.0v 999.495n 0.0v 999.505n 1.7v 1009.495n 1.7v 1009.505n 1.7v 1019.495n 1.7v 1019.505n 0.0v 1029.495n 0.0v 1029.505n 1.7v 1039.495n 1.7v 1039.505n 1.7v 1049.495n 1.7v 1049.505n 1.7v 1059.495n 1.7v 1059.505n 1.7v 1069.495n 1.7v 1069.505n 0.0v 1079.495n 0.0v 1079.505n 0.0v 1089.495n 0.0v 1089.505n 0.0v 1099.495n 0.0v 1099.505n 1.7v 1109.495n 1.7v 1109.505n 1.7v 1119.495n 1.7v 1119.505n 1.7v 1129.495n 1.7v 1129.505n 1.7v 1139.495n 1.7v 1139.505n 1.7v 1149.495n 1.7v 1149.505n 1.7v 1159.495n 1.7v 1159.505n 0.0v 1169.495n 0.0v 1169.505n 0.0v 1179.495n 0.0v 1179.505n 0.0v 1189.495n 0.0v 1189.505n 0.0v 1199.495n 0.0v 1199.505n 0.0v 1209.495n 0.0v 1209.505n 0.0v 1219.495n 0.0v 1219.505n 0.0v 1229.495n 0.0v 1229.505n 0.0v 1239.495n 0.0v 1239.505n 0.0v 1249.495n 0.0v 1249.505n 0.0v 1259.495n 0.0v 1259.505n 0.0v 1269.495n 0.0v 1269.505n 0.0v 1279.495n 0.0v 1279.505n 1.7v 1289.495n 1.7v 1289.505n 1.7v 1299.495n 1.7v 1299.505n 0.0v 1309.495n 0.0v 1309.505n 0.0v 1319.495n 0.0v 1319.505n 0.0v 1329.495n 0.0v 1329.505n 0.0v 1339.495n 0.0v 1339.505n 0.0v 1349.495n 0.0v 1349.505n 1.7v 1359.495n 1.7v 1359.505n 1.7v 1369.495n 1.7v 1369.505n 1.7v 1379.495n 1.7v 1379.505n 1.7v 1389.495n 1.7v 1389.505n 1.7v 1399.495n 1.7v 1399.505n 1.7v 1409.495n 1.7v 1409.505n 1.7v 1419.495n 1.7v 1419.505n 1.7v 1429.495n 1.7v 1429.505n 1.7v 1439.495n 1.7v 1439.505n 0.0v 1449.495n 0.0v 1449.505n 1.7v 1459.495n 1.7v 1459.505n 1.7v 1469.495n 1.7v 1469.505n 0.0v 1479.495n 0.0v 1479.505n 0.0v 1489.495n 0.0v 1489.505n 0.0v 1499.495n 0.0v 1499.505n 1.7v 1509.495n 1.7v 1509.505n 1.7v 1519.495n 1.7v 1519.505n 0.0v 1529.495n 0.0v 1529.505n 0.0v 1539.495n 0.0v 1539.505n 0.0v 1549.495n 0.0v 1549.505n 1.7v 1559.495n 1.7v 1559.505n 1.7v 1569.495n 1.7v 1569.505n 1.7v 1579.495n 1.7v 1579.505n 1.7v 1589.495n 1.7v 1589.505n 1.7v 1599.495n 1.7v 1599.505n 1.7v 1609.495n 1.7v 1609.505n 0.0v 1619.495n 0.0v 1619.505n 0.0v 1629.495n 0.0v 1629.505n 0.0v 1639.495n 0.0v 1639.505n 0.0v 1649.495n 0.0v 1649.505n 0.0v 1659.495n 0.0v 1659.505n 0.0v 1669.495n 0.0v 1669.505n 0.0v 1679.495n 0.0v 1679.505n 0.0v 1689.495n 0.0v 1689.505n 1.7v 1699.495n 1.7v 1699.505n 0.0v 1709.495n 0.0v 1709.505n 0.0v 1719.495n 0.0v 1719.505n 1.7v 1729.495n 1.7v 1729.505n 1.7v 1739.495n 1.7v 1739.505n 0.0v 1749.495n 0.0v 1749.505n 0.0v 1759.495n 0.0v 1759.505n 1.7v 1769.495n 1.7v 1769.505n 1.7v 1779.495n 1.7v 1779.505n 0.0v 1789.495n 0.0v 1789.505n 0.0v 1799.495n 0.0v 1799.505n 0.0v 1809.495n 0.0v 1809.505n 0.0v 1819.495n 0.0v 1819.505n 1.7v 1829.495n 1.7v 1829.505n 1.7v 1839.495n 1.7v 1839.505n 1.7v 1849.495n 1.7v 1849.505n 0.0v 1859.495n 0.0v 1859.505n 1.7v 1869.495n 1.7v 1869.505n 1.7v 1879.495n 1.7v 1879.505n 0.0v 1889.495n 0.0v 1889.505n 0.0v 1899.495n 0.0v 1899.505n 1.7v 1909.495n 1.7v 1909.505n 0.0v 1919.495n 0.0v 1919.505n 1.7v 1929.495n 1.7v 1929.505n 1.7v 1939.495n 1.7v 1939.505n 1.7v 1949.495n 1.7v 1949.505n 0.0v 1959.495n 0.0v 1959.505n 0.0v 1969.495n 0.0v 1969.505n 1.7v 1979.495n 1.7v 1979.505n 1.7v 1989.495n 1.7v 1989.505n 1.7v 1999.495n 1.7v 1999.505n 1.7v 2009.495n 1.7v 2009.505n 1.7v 2019.495n 1.7v 2019.505n 1.7v 2029.495n 1.7v 2029.505n 1.7v 2039.495n 1.7v 2039.505n 1.7v 2049.495n 1.7v 2049.505n 1.7v )
* (time, data): [(0, 0), (10, 0), (20, 1), (30, 1), (40, 1), (50, 1), (60, 1), (70, 0), (80, 1), (90, 1), (100, 1), (110, 1), (120, 1), (130, 1), (140, 1), (150, 1), (160, 1), (170, 1), (180, 1), (190, 0), (200, 0), (210, 0), (220, 0), (230, 0), (240, 0), (250, 0), (260, 0), (270, 0), (280, 1), (290, 1), (300, 1), (310, 0), (320, 0), (330, 0), (340, 0), (350, 0), (360, 0), (370, 1), (380, 1), (390, 1), (400, 1), (410, 1), (420, 1), (430, 1), (440, 1), (450, 0), (460, 1), (470, 0), (480, 1), (490, 1), (500, 0), (510, 0), (520, 0), (530, 0), (540, 0), (550, 1), (560, 1), (570, 1), (580, 1), (590, 1), (600, 1), (610, 1), (620, 1), (630, 0), (640, 0), (650, 1), (660, 1), (670, 1), (680, 1), (690, 0), (700, 0), (710, 0), (720, 1), (730, 1), (740, 0), (750, 0), (760, 0), (770, 1), (780, 1), (790, 0), (800, 0), (810, 1), (820, 1), (830, 1), (840, 1), (850, 1), (860, 1), (870, 0), (880, 0), (890, 0), (900, 0), (910, 0), (920, 0), (930, 0), (940, 0), (950, 1), (960, 0), (970, 0), (980, 0), (990, 0), (1000, 0), (1010, 0), (1020, 0), (1030, 1), (1040, 1), (1050, 0), (1060, 0), (1070, 1), (1080, 1), (1090, 1), (1100, 1), (1110, 1), (1120, 1), (1130, 0), (1140, 0), (1150, 0), (1160, 0), (1170, 0), (1180, 1), (1190, 1), (1200, 1), (1210, 1), (1220, 1), (1230, 1), (1240, 1), (1250, 1), (1260, 1), (1270, 1), (1280, 1), (1290, 0), (1300, 1), (1310, 1), (1320, 1), (1330, 1), (1340, 1), (1350, 0), (1360, 0), (1370, 0), (1380, 0), (1390, 0), (1400, 0), (1410, 1), (1420, 1), (1430, 1), (1440, 1), (1450, 1), (1460, 1), (1470, 0), (1480, 0), (1490, 0), (1500, 0), (1510, 0), (1520, 0), (1530, 0), (1540, 0), (1550, 0), (1560, 0), (1570, 1), (1580, 1), (1590, 1), (1600, 1), (1610, 0), (1620, 0), (1630, 0), (1640, 0), (1650, 0), (1660, 0), (1670, 1), (1680, 0), (1690, 0), (1700, 1), (1710, 1), (1720, 1), (1730, 1), (1740, 1), (1750, 1), (1760, 1), (1770, 1), (1780, 1), (1790, 1), (1800, 1), (1810, 0), (1820, 1), (1830, 1), (1840, 1), (1850, 1), (1860, 1), (1870, 1), (1880, 1), (1890, 0), (1900, 0), (1910, 1), (1920, 1), (1930, 1), (1940, 1), (1950, 0), (1960, 0), (1970, 0), (1980, 1), (1990, 0), (2000, 0), (2010, 0), (2020, 1), (2030, 0), (2040, 1), (2050, 1)]
Vdin0_4  din0_4  0 PWL (0n 0.0v 9.495n 0.0v 9.505n 0.0v 19.495n 0.0v 19.505n 1.7v 29.495n 1.7v 29.505n 1.7v 39.495n 1.7v 39.505n 1.7v 49.495n 1.7v 49.505n 1.7v 59.495n 1.7v 59.505n 1.7v 69.495n 1.7v 69.505n 0.0v 79.495n 0.0v 79.505n 1.7v 89.495n 1.7v 89.505n 1.7v 99.495n 1.7v 99.505n 1.7v 109.495n 1.7v 109.505n 1.7v 119.495n 1.7v 119.505n 1.7v 129.495n 1.7v 129.505n 1.7v 139.495n 1.7v 139.505n 1.7v 149.495n 1.7v 149.505n 1.7v 159.495n 1.7v 159.505n 1.7v 169.495n 1.7v 169.505n 1.7v 179.495n 1.7v 179.505n 1.7v 189.495n 1.7v 189.505n 0.0v 199.495n 0.0v 199.505n 0.0v 209.495n 0.0v 209.505n 0.0v 219.495n 0.0v 219.505n 0.0v 229.495n 0.0v 229.505n 0.0v 239.495n 0.0v 239.505n 0.0v 249.495n 0.0v 249.505n 0.0v 259.495n 0.0v 259.505n 0.0v 269.495n 0.0v 269.505n 0.0v 279.495n 0.0v 279.505n 1.7v 289.495n 1.7v 289.505n 1.7v 299.495n 1.7v 299.505n 1.7v 309.495n 1.7v 309.505n 0.0v 319.495n 0.0v 319.505n 0.0v 329.495n 0.0v 329.505n 0.0v 339.495n 0.0v 339.505n 0.0v 349.495n 0.0v 349.505n 0.0v 359.495n 0.0v 359.505n 0.0v 369.495n 0.0v 369.505n 1.7v 379.495n 1.7v 379.505n 1.7v 389.495n 1.7v 389.505n 1.7v 399.495n 1.7v 399.505n 1.7v 409.495n 1.7v 409.505n 1.7v 419.495n 1.7v 419.505n 1.7v 429.495n 1.7v 429.505n 1.7v 439.495n 1.7v 439.505n 1.7v 449.495n 1.7v 449.505n 0.0v 459.495n 0.0v 459.505n 1.7v 469.495n 1.7v 469.505n 0.0v 479.495n 0.0v 479.505n 1.7v 489.495n 1.7v 489.505n 1.7v 499.495n 1.7v 499.505n 0.0v 509.495n 0.0v 509.505n 0.0v 519.495n 0.0v 519.505n 0.0v 529.495n 0.0v 529.505n 0.0v 539.495n 0.0v 539.505n 0.0v 549.495n 0.0v 549.505n 1.7v 559.495n 1.7v 559.505n 1.7v 569.495n 1.7v 569.505n 1.7v 579.495n 1.7v 579.505n 1.7v 589.495n 1.7v 589.505n 1.7v 599.495n 1.7v 599.505n 1.7v 609.495n 1.7v 609.505n 1.7v 619.495n 1.7v 619.505n 1.7v 629.495n 1.7v 629.505n 0.0v 639.495n 0.0v 639.505n 0.0v 649.495n 0.0v 649.505n 1.7v 659.495n 1.7v 659.505n 1.7v 669.495n 1.7v 669.505n 1.7v 679.495n 1.7v 679.505n 1.7v 689.495n 1.7v 689.505n 0.0v 699.495n 0.0v 699.505n 0.0v 709.495n 0.0v 709.505n 0.0v 719.495n 0.0v 719.505n 1.7v 729.495n 1.7v 729.505n 1.7v 739.495n 1.7v 739.505n 0.0v 749.495n 0.0v 749.505n 0.0v 759.495n 0.0v 759.505n 0.0v 769.495n 0.0v 769.505n 1.7v 779.495n 1.7v 779.505n 1.7v 789.495n 1.7v 789.505n 0.0v 799.495n 0.0v 799.505n 0.0v 809.495n 0.0v 809.505n 1.7v 819.495n 1.7v 819.505n 1.7v 829.495n 1.7v 829.505n 1.7v 839.495n 1.7v 839.505n 1.7v 849.495n 1.7v 849.505n 1.7v 859.495n 1.7v 859.505n 1.7v 869.495n 1.7v 869.505n 0.0v 879.495n 0.0v 879.505n 0.0v 889.495n 0.0v 889.505n 0.0v 899.495n 0.0v 899.505n 0.0v 909.495n 0.0v 909.505n 0.0v 919.495n 0.0v 919.505n 0.0v 929.495n 0.0v 929.505n 0.0v 939.495n 0.0v 939.505n 0.0v 949.495n 0.0v 949.505n 1.7v 959.495n 1.7v 959.505n 0.0v 969.495n 0.0v 969.505n 0.0v 979.495n 0.0v 979.505n 0.0v 989.495n 0.0v 989.505n 0.0v 999.495n 0.0v 999.505n 0.0v 1009.495n 0.0v 1009.505n 0.0v 1019.495n 0.0v 1019.505n 0.0v 1029.495n 0.0v 1029.505n 1.7v 1039.495n 1.7v 1039.505n 1.7v 1049.495n 1.7v 1049.505n 0.0v 1059.495n 0.0v 1059.505n 0.0v 1069.495n 0.0v 1069.505n 1.7v 1079.495n 1.7v 1079.505n 1.7v 1089.495n 1.7v 1089.505n 1.7v 1099.495n 1.7v 1099.505n 1.7v 1109.495n 1.7v 1109.505n 1.7v 1119.495n 1.7v 1119.505n 1.7v 1129.495n 1.7v 1129.505n 0.0v 1139.495n 0.0v 1139.505n 0.0v 1149.495n 0.0v 1149.505n 0.0v 1159.495n 0.0v 1159.505n 0.0v 1169.495n 0.0v 1169.505n 0.0v 1179.495n 0.0v 1179.505n 1.7v 1189.495n 1.7v 1189.505n 1.7v 1199.495n 1.7v 1199.505n 1.7v 1209.495n 1.7v 1209.505n 1.7v 1219.495n 1.7v 1219.505n 1.7v 1229.495n 1.7v 1229.505n 1.7v 1239.495n 1.7v 1239.505n 1.7v 1249.495n 1.7v 1249.505n 1.7v 1259.495n 1.7v 1259.505n 1.7v 1269.495n 1.7v 1269.505n 1.7v 1279.495n 1.7v 1279.505n 1.7v 1289.495n 1.7v 1289.505n 0.0v 1299.495n 0.0v 1299.505n 1.7v 1309.495n 1.7v 1309.505n 1.7v 1319.495n 1.7v 1319.505n 1.7v 1329.495n 1.7v 1329.505n 1.7v 1339.495n 1.7v 1339.505n 1.7v 1349.495n 1.7v 1349.505n 0.0v 1359.495n 0.0v 1359.505n 0.0v 1369.495n 0.0v 1369.505n 0.0v 1379.495n 0.0v 1379.505n 0.0v 1389.495n 0.0v 1389.505n 0.0v 1399.495n 0.0v 1399.505n 0.0v 1409.495n 0.0v 1409.505n 1.7v 1419.495n 1.7v 1419.505n 1.7v 1429.495n 1.7v 1429.505n 1.7v 1439.495n 1.7v 1439.505n 1.7v 1449.495n 1.7v 1449.505n 1.7v 1459.495n 1.7v 1459.505n 1.7v 1469.495n 1.7v 1469.505n 0.0v 1479.495n 0.0v 1479.505n 0.0v 1489.495n 0.0v 1489.505n 0.0v 1499.495n 0.0v 1499.505n 0.0v 1509.495n 0.0v 1509.505n 0.0v 1519.495n 0.0v 1519.505n 0.0v 1529.495n 0.0v 1529.505n 0.0v 1539.495n 0.0v 1539.505n 0.0v 1549.495n 0.0v 1549.505n 0.0v 1559.495n 0.0v 1559.505n 0.0v 1569.495n 0.0v 1569.505n 1.7v 1579.495n 1.7v 1579.505n 1.7v 1589.495n 1.7v 1589.505n 1.7v 1599.495n 1.7v 1599.505n 1.7v 1609.495n 1.7v 1609.505n 0.0v 1619.495n 0.0v 1619.505n 0.0v 1629.495n 0.0v 1629.505n 0.0v 1639.495n 0.0v 1639.505n 0.0v 1649.495n 0.0v 1649.505n 0.0v 1659.495n 0.0v 1659.505n 0.0v 1669.495n 0.0v 1669.505n 1.7v 1679.495n 1.7v 1679.505n 0.0v 1689.495n 0.0v 1689.505n 0.0v 1699.495n 0.0v 1699.505n 1.7v 1709.495n 1.7v 1709.505n 1.7v 1719.495n 1.7v 1719.505n 1.7v 1729.495n 1.7v 1729.505n 1.7v 1739.495n 1.7v 1739.505n 1.7v 1749.495n 1.7v 1749.505n 1.7v 1759.495n 1.7v 1759.505n 1.7v 1769.495n 1.7v 1769.505n 1.7v 1779.495n 1.7v 1779.505n 1.7v 1789.495n 1.7v 1789.505n 1.7v 1799.495n 1.7v 1799.505n 1.7v 1809.495n 1.7v 1809.505n 0.0v 1819.495n 0.0v 1819.505n 1.7v 1829.495n 1.7v 1829.505n 1.7v 1839.495n 1.7v 1839.505n 1.7v 1849.495n 1.7v 1849.505n 1.7v 1859.495n 1.7v 1859.505n 1.7v 1869.495n 1.7v 1869.505n 1.7v 1879.495n 1.7v 1879.505n 1.7v 1889.495n 1.7v 1889.505n 0.0v 1899.495n 0.0v 1899.505n 0.0v 1909.495n 0.0v 1909.505n 1.7v 1919.495n 1.7v 1919.505n 1.7v 1929.495n 1.7v 1929.505n 1.7v 1939.495n 1.7v 1939.505n 1.7v 1949.495n 1.7v 1949.505n 0.0v 1959.495n 0.0v 1959.505n 0.0v 1969.495n 0.0v 1969.505n 0.0v 1979.495n 0.0v 1979.505n 1.7v 1989.495n 1.7v 1989.505n 0.0v 1999.495n 0.0v 1999.505n 0.0v 2009.495n 0.0v 2009.505n 0.0v 2019.495n 0.0v 2019.505n 1.7v 2029.495n 1.7v 2029.505n 0.0v 2039.495n 0.0v 2039.505n 1.7v 2049.495n 1.7v 2049.505n 1.7v )
* (time, data): [(0, 0), (10, 1), (20, 1), (30, 0), (40, 0), (50, 0), (60, 0), (70, 0), (80, 1), (90, 1), (100, 1), (110, 0), (120, 0), (130, 0), (140, 0), (150, 0), (160, 0), (170, 0), (180, 0), (190, 1), (200, 1), (210, 0), (220, 0), (230, 1), (240, 1), (250, 0), (260, 0), (270, 0), (280, 1), (290, 1), (300, 1), (310, 1), (320, 1), (330, 0), (340, 0), (350, 1), (360, 1), (370, 1), (380, 1), (390, 0), (400, 0), (410, 0), (420, 0), (430, 0), (440, 0), (450, 1), (460, 1), (470, 0), (480, 1), (490, 1), (500, 0), (510, 0), (520, 0), (530, 0), (540, 0), (550, 0), (560, 0), (570, 0), (580, 0), (590, 1), (600, 0), (610, 0), (620, 0), (630, 0), (640, 0), (650, 1), (660, 1), (670, 1), (680, 1), (690, 1), (700, 1), (710, 1), (720, 1), (730, 1), (740, 0), (750, 0), (760, 0), (770, 1), (780, 1), (790, 0), (800, 0), (810, 1), (820, 1), (830, 1), (840, 1), (850, 1), (860, 0), (870, 1), (880, 0), (890, 0), (900, 0), (910, 1), (920, 1), (930, 1), (940, 1), (950, 1), (960, 0), (970, 0), (980, 0), (990, 0), (1000, 0), (1010, 0), (1020, 1), (1030, 1), (1040, 1), (1050, 1), (1060, 1), (1070, 1), (1080, 1), (1090, 1), (1100, 0), (1110, 0), (1120, 0), (1130, 1), (1140, 1), (1150, 1), (1160, 1), (1170, 1), (1180, 1), (1190, 1), (1200, 1), (1210, 1), (1220, 1), (1230, 1), (1240, 1), (1250, 1), (1260, 1), (1270, 1), (1280, 0), (1290, 0), (1300, 0), (1310, 0), (1320, 0), (1330, 0), (1340, 0), (1350, 0), (1360, 0), (1370, 0), (1380, 0), (1390, 1), (1400, 0), (1410, 1), (1420, 1), (1430, 1), (1440, 0), (1450, 1), (1460, 1), (1470, 1), (1480, 1), (1490, 1), (1500, 0), (1510, 0), (1520, 0), (1530, 0), (1540, 0), (1550, 1), (1560, 0), (1570, 0), (1580, 1), (1590, 1), (1600, 1), (1610, 1), (1620, 1), (1630, 1), (1640, 0), (1650, 0), (1660, 0), (1670, 0), (1680, 0), (1690, 0), (1700, 0), (1710, 0), (1720, 1), (1730, 1), (1740, 0), (1750, 0), (1760, 1), (1770, 1), (1780, 1), (1790, 1), (1800, 1), (1810, 1), (1820, 1), (1830, 1), (1840, 1), (1850, 1), (1860, 1), (1870, 1), (1880, 1), (1890, 1), (1900, 1), (1910, 1), (1920, 0), (1930, 0), (1940, 0), (1950, 0), (1960, 0), (1970, 1), (1980, 0), (1990, 0), (2000, 0), (2010, 0), (2020, 0), (2030, 0), (2040, 1), (2050, 1)]
Vdin0_5  din0_5  0 PWL (0n 0.0v 9.495n 0.0v 9.505n 1.7v 19.495n 1.7v 19.505n 1.7v 29.495n 1.7v 29.505n 0.0v 39.495n 0.0v 39.505n 0.0v 49.495n 0.0v 49.505n 0.0v 59.495n 0.0v 59.505n 0.0v 69.495n 0.0v 69.505n 0.0v 79.495n 0.0v 79.505n 1.7v 89.495n 1.7v 89.505n 1.7v 99.495n 1.7v 99.505n 1.7v 109.495n 1.7v 109.505n 0.0v 119.495n 0.0v 119.505n 0.0v 129.495n 0.0v 129.505n 0.0v 139.495n 0.0v 139.505n 0.0v 149.495n 0.0v 149.505n 0.0v 159.495n 0.0v 159.505n 0.0v 169.495n 0.0v 169.505n 0.0v 179.495n 0.0v 179.505n 0.0v 189.495n 0.0v 189.505n 1.7v 199.495n 1.7v 199.505n 1.7v 209.495n 1.7v 209.505n 0.0v 219.495n 0.0v 219.505n 0.0v 229.495n 0.0v 229.505n 1.7v 239.495n 1.7v 239.505n 1.7v 249.495n 1.7v 249.505n 0.0v 259.495n 0.0v 259.505n 0.0v 269.495n 0.0v 269.505n 0.0v 279.495n 0.0v 279.505n 1.7v 289.495n 1.7v 289.505n 1.7v 299.495n 1.7v 299.505n 1.7v 309.495n 1.7v 309.505n 1.7v 319.495n 1.7v 319.505n 1.7v 329.495n 1.7v 329.505n 0.0v 339.495n 0.0v 339.505n 0.0v 349.495n 0.0v 349.505n 1.7v 359.495n 1.7v 359.505n 1.7v 369.495n 1.7v 369.505n 1.7v 379.495n 1.7v 379.505n 1.7v 389.495n 1.7v 389.505n 0.0v 399.495n 0.0v 399.505n 0.0v 409.495n 0.0v 409.505n 0.0v 419.495n 0.0v 419.505n 0.0v 429.495n 0.0v 429.505n 0.0v 439.495n 0.0v 439.505n 0.0v 449.495n 0.0v 449.505n 1.7v 459.495n 1.7v 459.505n 1.7v 469.495n 1.7v 469.505n 0.0v 479.495n 0.0v 479.505n 1.7v 489.495n 1.7v 489.505n 1.7v 499.495n 1.7v 499.505n 0.0v 509.495n 0.0v 509.505n 0.0v 519.495n 0.0v 519.505n 0.0v 529.495n 0.0v 529.505n 0.0v 539.495n 0.0v 539.505n 0.0v 549.495n 0.0v 549.505n 0.0v 559.495n 0.0v 559.505n 0.0v 569.495n 0.0v 569.505n 0.0v 579.495n 0.0v 579.505n 0.0v 589.495n 0.0v 589.505n 1.7v 599.495n 1.7v 599.505n 0.0v 609.495n 0.0v 609.505n 0.0v 619.495n 0.0v 619.505n 0.0v 629.495n 0.0v 629.505n 0.0v 639.495n 0.0v 639.505n 0.0v 649.495n 0.0v 649.505n 1.7v 659.495n 1.7v 659.505n 1.7v 669.495n 1.7v 669.505n 1.7v 679.495n 1.7v 679.505n 1.7v 689.495n 1.7v 689.505n 1.7v 699.495n 1.7v 699.505n 1.7v 709.495n 1.7v 709.505n 1.7v 719.495n 1.7v 719.505n 1.7v 729.495n 1.7v 729.505n 1.7v 739.495n 1.7v 739.505n 0.0v 749.495n 0.0v 749.505n 0.0v 759.495n 0.0v 759.505n 0.0v 769.495n 0.0v 769.505n 1.7v 779.495n 1.7v 779.505n 1.7v 789.495n 1.7v 789.505n 0.0v 799.495n 0.0v 799.505n 0.0v 809.495n 0.0v 809.505n 1.7v 819.495n 1.7v 819.505n 1.7v 829.495n 1.7v 829.505n 1.7v 839.495n 1.7v 839.505n 1.7v 849.495n 1.7v 849.505n 1.7v 859.495n 1.7v 859.505n 0.0v 869.495n 0.0v 869.505n 1.7v 879.495n 1.7v 879.505n 0.0v 889.495n 0.0v 889.505n 0.0v 899.495n 0.0v 899.505n 0.0v 909.495n 0.0v 909.505n 1.7v 919.495n 1.7v 919.505n 1.7v 929.495n 1.7v 929.505n 1.7v 939.495n 1.7v 939.505n 1.7v 949.495n 1.7v 949.505n 1.7v 959.495n 1.7v 959.505n 0.0v 969.495n 0.0v 969.505n 0.0v 979.495n 0.0v 979.505n 0.0v 989.495n 0.0v 989.505n 0.0v 999.495n 0.0v 999.505n 0.0v 1009.495n 0.0v 1009.505n 0.0v 1019.495n 0.0v 1019.505n 1.7v 1029.495n 1.7v 1029.505n 1.7v 1039.495n 1.7v 1039.505n 1.7v 1049.495n 1.7v 1049.505n 1.7v 1059.495n 1.7v 1059.505n 1.7v 1069.495n 1.7v 1069.505n 1.7v 1079.495n 1.7v 1079.505n 1.7v 1089.495n 1.7v 1089.505n 1.7v 1099.495n 1.7v 1099.505n 0.0v 1109.495n 0.0v 1109.505n 0.0v 1119.495n 0.0v 1119.505n 0.0v 1129.495n 0.0v 1129.505n 1.7v 1139.495n 1.7v 1139.505n 1.7v 1149.495n 1.7v 1149.505n 1.7v 1159.495n 1.7v 1159.505n 1.7v 1169.495n 1.7v 1169.505n 1.7v 1179.495n 1.7v 1179.505n 1.7v 1189.495n 1.7v 1189.505n 1.7v 1199.495n 1.7v 1199.505n 1.7v 1209.495n 1.7v 1209.505n 1.7v 1219.495n 1.7v 1219.505n 1.7v 1229.495n 1.7v 1229.505n 1.7v 1239.495n 1.7v 1239.505n 1.7v 1249.495n 1.7v 1249.505n 1.7v 1259.495n 1.7v 1259.505n 1.7v 1269.495n 1.7v 1269.505n 1.7v 1279.495n 1.7v 1279.505n 0.0v 1289.495n 0.0v 1289.505n 0.0v 1299.495n 0.0v 1299.505n 0.0v 1309.495n 0.0v 1309.505n 0.0v 1319.495n 0.0v 1319.505n 0.0v 1329.495n 0.0v 1329.505n 0.0v 1339.495n 0.0v 1339.505n 0.0v 1349.495n 0.0v 1349.505n 0.0v 1359.495n 0.0v 1359.505n 0.0v 1369.495n 0.0v 1369.505n 0.0v 1379.495n 0.0v 1379.505n 0.0v 1389.495n 0.0v 1389.505n 1.7v 1399.495n 1.7v 1399.505n 0.0v 1409.495n 0.0v 1409.505n 1.7v 1419.495n 1.7v 1419.505n 1.7v 1429.495n 1.7v 1429.505n 1.7v 1439.495n 1.7v 1439.505n 0.0v 1449.495n 0.0v 1449.505n 1.7v 1459.495n 1.7v 1459.505n 1.7v 1469.495n 1.7v 1469.505n 1.7v 1479.495n 1.7v 1479.505n 1.7v 1489.495n 1.7v 1489.505n 1.7v 1499.495n 1.7v 1499.505n 0.0v 1509.495n 0.0v 1509.505n 0.0v 1519.495n 0.0v 1519.505n 0.0v 1529.495n 0.0v 1529.505n 0.0v 1539.495n 0.0v 1539.505n 0.0v 1549.495n 0.0v 1549.505n 1.7v 1559.495n 1.7v 1559.505n 0.0v 1569.495n 0.0v 1569.505n 0.0v 1579.495n 0.0v 1579.505n 1.7v 1589.495n 1.7v 1589.505n 1.7v 1599.495n 1.7v 1599.505n 1.7v 1609.495n 1.7v 1609.505n 1.7v 1619.495n 1.7v 1619.505n 1.7v 1629.495n 1.7v 1629.505n 1.7v 1639.495n 1.7v 1639.505n 0.0v 1649.495n 0.0v 1649.505n 0.0v 1659.495n 0.0v 1659.505n 0.0v 1669.495n 0.0v 1669.505n 0.0v 1679.495n 0.0v 1679.505n 0.0v 1689.495n 0.0v 1689.505n 0.0v 1699.495n 0.0v 1699.505n 0.0v 1709.495n 0.0v 1709.505n 0.0v 1719.495n 0.0v 1719.505n 1.7v 1729.495n 1.7v 1729.505n 1.7v 1739.495n 1.7v 1739.505n 0.0v 1749.495n 0.0v 1749.505n 0.0v 1759.495n 0.0v 1759.505n 1.7v 1769.495n 1.7v 1769.505n 1.7v 1779.495n 1.7v 1779.505n 1.7v 1789.495n 1.7v 1789.505n 1.7v 1799.495n 1.7v 1799.505n 1.7v 1809.495n 1.7v 1809.505n 1.7v 1819.495n 1.7v 1819.505n 1.7v 1829.495n 1.7v 1829.505n 1.7v 1839.495n 1.7v 1839.505n 1.7v 1849.495n 1.7v 1849.505n 1.7v 1859.495n 1.7v 1859.505n 1.7v 1869.495n 1.7v 1869.505n 1.7v 1879.495n 1.7v 1879.505n 1.7v 1889.495n 1.7v 1889.505n 1.7v 1899.495n 1.7v 1899.505n 1.7v 1909.495n 1.7v 1909.505n 1.7v 1919.495n 1.7v 1919.505n 0.0v 1929.495n 0.0v 1929.505n 0.0v 1939.495n 0.0v 1939.505n 0.0v 1949.495n 0.0v 1949.505n 0.0v 1959.495n 0.0v 1959.505n 0.0v 1969.495n 0.0v 1969.505n 1.7v 1979.495n 1.7v 1979.505n 0.0v 1989.495n 0.0v 1989.505n 0.0v 1999.495n 0.0v 1999.505n 0.0v 2009.495n 0.0v 2009.505n 0.0v 2019.495n 0.0v 2019.505n 0.0v 2029.495n 0.0v 2029.505n 0.0v 2039.495n 0.0v 2039.505n 1.7v 2049.495n 1.7v 2049.505n 1.7v )
* (time, data): [(0, 0), (10, 1), (20, 1), (30, 0), (40, 0), (50, 0), (60, 0), (70, 1), (80, 1), (90, 1), (100, 1), (110, 1), (120, 1), (130, 1), (140, 1), (150, 1), (160, 1), (170, 1), (180, 1), (190, 0), (200, 0), (210, 1), (220, 1), (230, 0), (240, 0), (250, 0), (260, 0), (270, 0), (280, 0), (290, 0), (300, 0), (310, 1), (320, 1), (330, 1), (340, 1), (350, 1), (360, 1), (370, 1), (380, 1), (390, 0), (400, 0), (410, 0), (420, 1), (430, 1), (440, 1), (450, 0), (460, 1), (470, 0), (480, 1), (490, 1), (500, 0), (510, 0), (520, 0), (530, 0), (540, 0), (550, 1), (560, 1), (570, 1), (580, 1), (590, 0), (600, 0), (610, 0), (620, 0), (630, 0), (640, 0), (650, 1), (660, 1), (670, 0), (680, 0), (690, 1), (700, 1), (710, 0), (720, 0), (730, 0), (740, 0), (750, 0), (760, 0), (770, 0), (780, 0), (790, 1), (800, 1), (810, 0), (820, 0), (830, 0), (840, 0), (850, 0), (860, 0), (870, 1), (880, 1), (890, 1), (900, 1), (910, 0), (920, 0), (930, 0), (940, 0), (950, 0), (960, 0), (970, 0), (980, 0), (990, 0), (1000, 1), (1010, 1), (1020, 0), (1030, 0), (1040, 0), (1050, 1), (1060, 1), (1070, 0), (1080, 0), (1090, 0), (1100, 0), (1110, 0), (1120, 0), (1130, 0), (1140, 0), (1150, 0), (1160, 1), (1170, 1), (1180, 0), (1190, 0), (1200, 0), (1210, 0), (1220, 0), (1230, 0), (1240, 0), (1250, 0), (1260, 0), (1270, 0), (1280, 1), (1290, 0), (1300, 1), (1310, 1), (1320, 1), (1330, 1), (1340, 1), (1350, 1), (1360, 1), (1370, 1), (1380, 1), (1390, 0), (1400, 1), (1410, 0), (1420, 0), (1430, 0), (1440, 1), (1450, 1), (1460, 1), (1470, 0), (1480, 0), (1490, 0), (1500, 0), (1510, 0), (1520, 1), (1530, 1), (1540, 1), (1550, 0), (1560, 1), (1570, 0), (1580, 1), (1590, 1), (1600, 1), (1610, 0), (1620, 0), (1630, 0), (1640, 0), (1650, 0), (1660, 0), (1670, 1), (1680, 0), (1690, 0), (1700, 1), (1710, 1), (1720, 1), (1730, 1), (1740, 0), (1750, 0), (1760, 1), (1770, 1), (1780, 1), (1790, 1), (1800, 1), (1810, 1), (1820, 1), (1830, 1), (1840, 1), (1850, 1), (1860, 0), (1870, 0), (1880, 1), (1890, 1), (1900, 1), (1910, 1), (1920, 1), (1930, 1), (1940, 1), (1950, 1), (1960, 1), (1970, 1), (1980, 1), (1990, 0), (2000, 0), (2010, 0), (2020, 0), (2030, 0), (2040, 1), (2050, 1)]
Vdin0_6  din0_6  0 PWL (0n 0.0v 9.495n 0.0v 9.505n 1.7v 19.495n 1.7v 19.505n 1.7v 29.495n 1.7v 29.505n 0.0v 39.495n 0.0v 39.505n 0.0v 49.495n 0.0v 49.505n 0.0v 59.495n 0.0v 59.505n 0.0v 69.495n 0.0v 69.505n 1.7v 79.495n 1.7v 79.505n 1.7v 89.495n 1.7v 89.505n 1.7v 99.495n 1.7v 99.505n 1.7v 109.495n 1.7v 109.505n 1.7v 119.495n 1.7v 119.505n 1.7v 129.495n 1.7v 129.505n 1.7v 139.495n 1.7v 139.505n 1.7v 149.495n 1.7v 149.505n 1.7v 159.495n 1.7v 159.505n 1.7v 169.495n 1.7v 169.505n 1.7v 179.495n 1.7v 179.505n 1.7v 189.495n 1.7v 189.505n 0.0v 199.495n 0.0v 199.505n 0.0v 209.495n 0.0v 209.505n 1.7v 219.495n 1.7v 219.505n 1.7v 229.495n 1.7v 229.505n 0.0v 239.495n 0.0v 239.505n 0.0v 249.495n 0.0v 249.505n 0.0v 259.495n 0.0v 259.505n 0.0v 269.495n 0.0v 269.505n 0.0v 279.495n 0.0v 279.505n 0.0v 289.495n 0.0v 289.505n 0.0v 299.495n 0.0v 299.505n 0.0v 309.495n 0.0v 309.505n 1.7v 319.495n 1.7v 319.505n 1.7v 329.495n 1.7v 329.505n 1.7v 339.495n 1.7v 339.505n 1.7v 349.495n 1.7v 349.505n 1.7v 359.495n 1.7v 359.505n 1.7v 369.495n 1.7v 369.505n 1.7v 379.495n 1.7v 379.505n 1.7v 389.495n 1.7v 389.505n 0.0v 399.495n 0.0v 399.505n 0.0v 409.495n 0.0v 409.505n 0.0v 419.495n 0.0v 419.505n 1.7v 429.495n 1.7v 429.505n 1.7v 439.495n 1.7v 439.505n 1.7v 449.495n 1.7v 449.505n 0.0v 459.495n 0.0v 459.505n 1.7v 469.495n 1.7v 469.505n 0.0v 479.495n 0.0v 479.505n 1.7v 489.495n 1.7v 489.505n 1.7v 499.495n 1.7v 499.505n 0.0v 509.495n 0.0v 509.505n 0.0v 519.495n 0.0v 519.505n 0.0v 529.495n 0.0v 529.505n 0.0v 539.495n 0.0v 539.505n 0.0v 549.495n 0.0v 549.505n 1.7v 559.495n 1.7v 559.505n 1.7v 569.495n 1.7v 569.505n 1.7v 579.495n 1.7v 579.505n 1.7v 589.495n 1.7v 589.505n 0.0v 599.495n 0.0v 599.505n 0.0v 609.495n 0.0v 609.505n 0.0v 619.495n 0.0v 619.505n 0.0v 629.495n 0.0v 629.505n 0.0v 639.495n 0.0v 639.505n 0.0v 649.495n 0.0v 649.505n 1.7v 659.495n 1.7v 659.505n 1.7v 669.495n 1.7v 669.505n 0.0v 679.495n 0.0v 679.505n 0.0v 689.495n 0.0v 689.505n 1.7v 699.495n 1.7v 699.505n 1.7v 709.495n 1.7v 709.505n 0.0v 719.495n 0.0v 719.505n 0.0v 729.495n 0.0v 729.505n 0.0v 739.495n 0.0v 739.505n 0.0v 749.495n 0.0v 749.505n 0.0v 759.495n 0.0v 759.505n 0.0v 769.495n 0.0v 769.505n 0.0v 779.495n 0.0v 779.505n 0.0v 789.495n 0.0v 789.505n 1.7v 799.495n 1.7v 799.505n 1.7v 809.495n 1.7v 809.505n 0.0v 819.495n 0.0v 819.505n 0.0v 829.495n 0.0v 829.505n 0.0v 839.495n 0.0v 839.505n 0.0v 849.495n 0.0v 849.505n 0.0v 859.495n 0.0v 859.505n 0.0v 869.495n 0.0v 869.505n 1.7v 879.495n 1.7v 879.505n 1.7v 889.495n 1.7v 889.505n 1.7v 899.495n 1.7v 899.505n 1.7v 909.495n 1.7v 909.505n 0.0v 919.495n 0.0v 919.505n 0.0v 929.495n 0.0v 929.505n 0.0v 939.495n 0.0v 939.505n 0.0v 949.495n 0.0v 949.505n 0.0v 959.495n 0.0v 959.505n 0.0v 969.495n 0.0v 969.505n 0.0v 979.495n 0.0v 979.505n 0.0v 989.495n 0.0v 989.505n 0.0v 999.495n 0.0v 999.505n 1.7v 1009.495n 1.7v 1009.505n 1.7v 1019.495n 1.7v 1019.505n 0.0v 1029.495n 0.0v 1029.505n 0.0v 1039.495n 0.0v 1039.505n 0.0v 1049.495n 0.0v 1049.505n 1.7v 1059.495n 1.7v 1059.505n 1.7v 1069.495n 1.7v 1069.505n 0.0v 1079.495n 0.0v 1079.505n 0.0v 1089.495n 0.0v 1089.505n 0.0v 1099.495n 0.0v 1099.505n 0.0v 1109.495n 0.0v 1109.505n 0.0v 1119.495n 0.0v 1119.505n 0.0v 1129.495n 0.0v 1129.505n 0.0v 1139.495n 0.0v 1139.505n 0.0v 1149.495n 0.0v 1149.505n 0.0v 1159.495n 0.0v 1159.505n 1.7v 1169.495n 1.7v 1169.505n 1.7v 1179.495n 1.7v 1179.505n 0.0v 1189.495n 0.0v 1189.505n 0.0v 1199.495n 0.0v 1199.505n 0.0v 1209.495n 0.0v 1209.505n 0.0v 1219.495n 0.0v 1219.505n 0.0v 1229.495n 0.0v 1229.505n 0.0v 1239.495n 0.0v 1239.505n 0.0v 1249.495n 0.0v 1249.505n 0.0v 1259.495n 0.0v 1259.505n 0.0v 1269.495n 0.0v 1269.505n 0.0v 1279.495n 0.0v 1279.505n 1.7v 1289.495n 1.7v 1289.505n 0.0v 1299.495n 0.0v 1299.505n 1.7v 1309.495n 1.7v 1309.505n 1.7v 1319.495n 1.7v 1319.505n 1.7v 1329.495n 1.7v 1329.505n 1.7v 1339.495n 1.7v 1339.505n 1.7v 1349.495n 1.7v 1349.505n 1.7v 1359.495n 1.7v 1359.505n 1.7v 1369.495n 1.7v 1369.505n 1.7v 1379.495n 1.7v 1379.505n 1.7v 1389.495n 1.7v 1389.505n 0.0v 1399.495n 0.0v 1399.505n 1.7v 1409.495n 1.7v 1409.505n 0.0v 1419.495n 0.0v 1419.505n 0.0v 1429.495n 0.0v 1429.505n 0.0v 1439.495n 0.0v 1439.505n 1.7v 1449.495n 1.7v 1449.505n 1.7v 1459.495n 1.7v 1459.505n 1.7v 1469.495n 1.7v 1469.505n 0.0v 1479.495n 0.0v 1479.505n 0.0v 1489.495n 0.0v 1489.505n 0.0v 1499.495n 0.0v 1499.505n 0.0v 1509.495n 0.0v 1509.505n 0.0v 1519.495n 0.0v 1519.505n 1.7v 1529.495n 1.7v 1529.505n 1.7v 1539.495n 1.7v 1539.505n 1.7v 1549.495n 1.7v 1549.505n 0.0v 1559.495n 0.0v 1559.505n 1.7v 1569.495n 1.7v 1569.505n 0.0v 1579.495n 0.0v 1579.505n 1.7v 1589.495n 1.7v 1589.505n 1.7v 1599.495n 1.7v 1599.505n 1.7v 1609.495n 1.7v 1609.505n 0.0v 1619.495n 0.0v 1619.505n 0.0v 1629.495n 0.0v 1629.505n 0.0v 1639.495n 0.0v 1639.505n 0.0v 1649.495n 0.0v 1649.505n 0.0v 1659.495n 0.0v 1659.505n 0.0v 1669.495n 0.0v 1669.505n 1.7v 1679.495n 1.7v 1679.505n 0.0v 1689.495n 0.0v 1689.505n 0.0v 1699.495n 0.0v 1699.505n 1.7v 1709.495n 1.7v 1709.505n 1.7v 1719.495n 1.7v 1719.505n 1.7v 1729.495n 1.7v 1729.505n 1.7v 1739.495n 1.7v 1739.505n 0.0v 1749.495n 0.0v 1749.505n 0.0v 1759.495n 0.0v 1759.505n 1.7v 1769.495n 1.7v 1769.505n 1.7v 1779.495n 1.7v 1779.505n 1.7v 1789.495n 1.7v 1789.505n 1.7v 1799.495n 1.7v 1799.505n 1.7v 1809.495n 1.7v 1809.505n 1.7v 1819.495n 1.7v 1819.505n 1.7v 1829.495n 1.7v 1829.505n 1.7v 1839.495n 1.7v 1839.505n 1.7v 1849.495n 1.7v 1849.505n 1.7v 1859.495n 1.7v 1859.505n 0.0v 1869.495n 0.0v 1869.505n 0.0v 1879.495n 0.0v 1879.505n 1.7v 1889.495n 1.7v 1889.505n 1.7v 1899.495n 1.7v 1899.505n 1.7v 1909.495n 1.7v 1909.505n 1.7v 1919.495n 1.7v 1919.505n 1.7v 1929.495n 1.7v 1929.505n 1.7v 1939.495n 1.7v 1939.505n 1.7v 1949.495n 1.7v 1949.505n 1.7v 1959.495n 1.7v 1959.505n 1.7v 1969.495n 1.7v 1969.505n 1.7v 1979.495n 1.7v 1979.505n 1.7v 1989.495n 1.7v 1989.505n 0.0v 1999.495n 0.0v 1999.505n 0.0v 2009.495n 0.0v 2009.505n 0.0v 2019.495n 0.0v 2019.505n 0.0v 2029.495n 0.0v 2029.505n 0.0v 2039.495n 0.0v 2039.505n 1.7v 2049.495n 1.7v 2049.505n 1.7v )
* (time, data): [(0, 0), (10, 0), (20, 0), (30, 0), (40, 0), (50, 0), (60, 0), (70, 0), (80, 0), (90, 0), (100, 0), (110, 1), (120, 1), (130, 1), (140, 1), (150, 1), (160, 1), (170, 1), (180, 1), (190, 0), (200, 0), (210, 1), (220, 1), (230, 1), (240, 1), (250, 1), (260, 1), (270, 1), (280, 0), (290, 0), (300, 0), (310, 1), (320, 1), (330, 1), (340, 1), (350, 1), (360, 1), (370, 1), (380, 1), (390, 1), (400, 1), (410, 1), (420, 1), (430, 1), (440, 1), (450, 0), (460, 0), (470, 1), (480, 0), (490, 0), (500, 0), (510, 0), (520, 0), (530, 0), (540, 0), (550, 1), (560, 1), (570, 1), (580, 1), (590, 0), (600, 1), (610, 1), (620, 0), (630, 0), (640, 0), (650, 1), (660, 0), (670, 0), (680, 0), (690, 1), (700, 1), (710, 0), (720, 0), (730, 0), (740, 0), (750, 0), (760, 0), (770, 1), (780, 1), (790, 0), (800, 0), (810, 0), (820, 0), (830, 0), (840, 1), (850, 1), (860, 0), (870, 1), (880, 0), (890, 0), (900, 0), (910, 1), (920, 1), (930, 1), (940, 1), (950, 1), (960, 1), (970, 1), (980, 1), (990, 1), (1000, 0), (1010, 0), (1020, 0), (1030, 1), (1040, 1), (1050, 0), (1060, 0), (1070, 1), (1080, 1), (1090, 1), (1100, 0), (1110, 0), (1120, 0), (1130, 1), (1140, 1), (1150, 1), (1160, 1), (1170, 1), (1180, 1), (1190, 1), (1200, 1), (1210, 1), (1220, 1), (1230, 0), (1240, 0), (1250, 0), (1260, 0), (1270, 0), (1280, 0), (1290, 1), (1300, 0), (1310, 0), (1320, 0), (1330, 0), (1340, 0), (1350, 1), (1360, 1), (1370, 1), (1380, 1), (1390, 1), (1400, 1), (1410, 1), (1420, 1), (1430, 1), (1440, 0), (1450, 1), (1460, 1), (1470, 1), (1480, 1), (1490, 1), (1500, 1), (1510, 1), (1520, 1), (1530, 1), (1540, 1), (1550, 0), (1560, 1), (1570, 1), (1580, 1), (1590, 1), (1600, 1), (1610, 1), (1620, 1), (1630, 1), (1640, 0), (1650, 0), (1660, 0), (1670, 1), (1680, 0), (1690, 0), (1700, 0), (1710, 0), (1720, 1), (1730, 1), (1740, 0), (1750, 0), (1760, 1), (1770, 1), (1780, 1), (1790, 1), (1800, 1), (1810, 0), (1820, 1), (1830, 1), (1840, 1), (1850, 1), (1860, 0), (1870, 0), (1880, 1), (1890, 1), (1900, 1), (1910, 1), (1920, 1), (1930, 1), (1940, 1), (1950, 0), (1960, 0), (1970, 0), (1980, 0), (1990, 0), (2000, 1), (2010, 1), (2020, 1), (2030, 0), (2040, 1), (2050, 1)]
Vdin0_7  din0_7  0 PWL (0n 0.0v 9.495n 0.0v 9.505n 0.0v 19.495n 0.0v 19.505n 0.0v 29.495n 0.0v 29.505n 0.0v 39.495n 0.0v 39.505n 0.0v 49.495n 0.0v 49.505n 0.0v 59.495n 0.0v 59.505n 0.0v 69.495n 0.0v 69.505n 0.0v 79.495n 0.0v 79.505n 0.0v 89.495n 0.0v 89.505n 0.0v 99.495n 0.0v 99.505n 0.0v 109.495n 0.0v 109.505n 1.7v 119.495n 1.7v 119.505n 1.7v 129.495n 1.7v 129.505n 1.7v 139.495n 1.7v 139.505n 1.7v 149.495n 1.7v 149.505n 1.7v 159.495n 1.7v 159.505n 1.7v 169.495n 1.7v 169.505n 1.7v 179.495n 1.7v 179.505n 1.7v 189.495n 1.7v 189.505n 0.0v 199.495n 0.0v 199.505n 0.0v 209.495n 0.0v 209.505n 1.7v 219.495n 1.7v 219.505n 1.7v 229.495n 1.7v 229.505n 1.7v 239.495n 1.7v 239.505n 1.7v 249.495n 1.7v 249.505n 1.7v 259.495n 1.7v 259.505n 1.7v 269.495n 1.7v 269.505n 1.7v 279.495n 1.7v 279.505n 0.0v 289.495n 0.0v 289.505n 0.0v 299.495n 0.0v 299.505n 0.0v 309.495n 0.0v 309.505n 1.7v 319.495n 1.7v 319.505n 1.7v 329.495n 1.7v 329.505n 1.7v 339.495n 1.7v 339.505n 1.7v 349.495n 1.7v 349.505n 1.7v 359.495n 1.7v 359.505n 1.7v 369.495n 1.7v 369.505n 1.7v 379.495n 1.7v 379.505n 1.7v 389.495n 1.7v 389.505n 1.7v 399.495n 1.7v 399.505n 1.7v 409.495n 1.7v 409.505n 1.7v 419.495n 1.7v 419.505n 1.7v 429.495n 1.7v 429.505n 1.7v 439.495n 1.7v 439.505n 1.7v 449.495n 1.7v 449.505n 0.0v 459.495n 0.0v 459.505n 0.0v 469.495n 0.0v 469.505n 1.7v 479.495n 1.7v 479.505n 0.0v 489.495n 0.0v 489.505n 0.0v 499.495n 0.0v 499.505n 0.0v 509.495n 0.0v 509.505n 0.0v 519.495n 0.0v 519.505n 0.0v 529.495n 0.0v 529.505n 0.0v 539.495n 0.0v 539.505n 0.0v 549.495n 0.0v 549.505n 1.7v 559.495n 1.7v 559.505n 1.7v 569.495n 1.7v 569.505n 1.7v 579.495n 1.7v 579.505n 1.7v 589.495n 1.7v 589.505n 0.0v 599.495n 0.0v 599.505n 1.7v 609.495n 1.7v 609.505n 1.7v 619.495n 1.7v 619.505n 0.0v 629.495n 0.0v 629.505n 0.0v 639.495n 0.0v 639.505n 0.0v 649.495n 0.0v 649.505n 1.7v 659.495n 1.7v 659.505n 0.0v 669.495n 0.0v 669.505n 0.0v 679.495n 0.0v 679.505n 0.0v 689.495n 0.0v 689.505n 1.7v 699.495n 1.7v 699.505n 1.7v 709.495n 1.7v 709.505n 0.0v 719.495n 0.0v 719.505n 0.0v 729.495n 0.0v 729.505n 0.0v 739.495n 0.0v 739.505n 0.0v 749.495n 0.0v 749.505n 0.0v 759.495n 0.0v 759.505n 0.0v 769.495n 0.0v 769.505n 1.7v 779.495n 1.7v 779.505n 1.7v 789.495n 1.7v 789.505n 0.0v 799.495n 0.0v 799.505n 0.0v 809.495n 0.0v 809.505n 0.0v 819.495n 0.0v 819.505n 0.0v 829.495n 0.0v 829.505n 0.0v 839.495n 0.0v 839.505n 1.7v 849.495n 1.7v 849.505n 1.7v 859.495n 1.7v 859.505n 0.0v 869.495n 0.0v 869.505n 1.7v 879.495n 1.7v 879.505n 0.0v 889.495n 0.0v 889.505n 0.0v 899.495n 0.0v 899.505n 0.0v 909.495n 0.0v 909.505n 1.7v 919.495n 1.7v 919.505n 1.7v 929.495n 1.7v 929.505n 1.7v 939.495n 1.7v 939.505n 1.7v 949.495n 1.7v 949.505n 1.7v 959.495n 1.7v 959.505n 1.7v 969.495n 1.7v 969.505n 1.7v 979.495n 1.7v 979.505n 1.7v 989.495n 1.7v 989.505n 1.7v 999.495n 1.7v 999.505n 0.0v 1009.495n 0.0v 1009.505n 0.0v 1019.495n 0.0v 1019.505n 0.0v 1029.495n 0.0v 1029.505n 1.7v 1039.495n 1.7v 1039.505n 1.7v 1049.495n 1.7v 1049.505n 0.0v 1059.495n 0.0v 1059.505n 0.0v 1069.495n 0.0v 1069.505n 1.7v 1079.495n 1.7v 1079.505n 1.7v 1089.495n 1.7v 1089.505n 1.7v 1099.495n 1.7v 1099.505n 0.0v 1109.495n 0.0v 1109.505n 0.0v 1119.495n 0.0v 1119.505n 0.0v 1129.495n 0.0v 1129.505n 1.7v 1139.495n 1.7v 1139.505n 1.7v 1149.495n 1.7v 1149.505n 1.7v 1159.495n 1.7v 1159.505n 1.7v 1169.495n 1.7v 1169.505n 1.7v 1179.495n 1.7v 1179.505n 1.7v 1189.495n 1.7v 1189.505n 1.7v 1199.495n 1.7v 1199.505n 1.7v 1209.495n 1.7v 1209.505n 1.7v 1219.495n 1.7v 1219.505n 1.7v 1229.495n 1.7v 1229.505n 0.0v 1239.495n 0.0v 1239.505n 0.0v 1249.495n 0.0v 1249.505n 0.0v 1259.495n 0.0v 1259.505n 0.0v 1269.495n 0.0v 1269.505n 0.0v 1279.495n 0.0v 1279.505n 0.0v 1289.495n 0.0v 1289.505n 1.7v 1299.495n 1.7v 1299.505n 0.0v 1309.495n 0.0v 1309.505n 0.0v 1319.495n 0.0v 1319.505n 0.0v 1329.495n 0.0v 1329.505n 0.0v 1339.495n 0.0v 1339.505n 0.0v 1349.495n 0.0v 1349.505n 1.7v 1359.495n 1.7v 1359.505n 1.7v 1369.495n 1.7v 1369.505n 1.7v 1379.495n 1.7v 1379.505n 1.7v 1389.495n 1.7v 1389.505n 1.7v 1399.495n 1.7v 1399.505n 1.7v 1409.495n 1.7v 1409.505n 1.7v 1419.495n 1.7v 1419.505n 1.7v 1429.495n 1.7v 1429.505n 1.7v 1439.495n 1.7v 1439.505n 0.0v 1449.495n 0.0v 1449.505n 1.7v 1459.495n 1.7v 1459.505n 1.7v 1469.495n 1.7v 1469.505n 1.7v 1479.495n 1.7v 1479.505n 1.7v 1489.495n 1.7v 1489.505n 1.7v 1499.495n 1.7v 1499.505n 1.7v 1509.495n 1.7v 1509.505n 1.7v 1519.495n 1.7v 1519.505n 1.7v 1529.495n 1.7v 1529.505n 1.7v 1539.495n 1.7v 1539.505n 1.7v 1549.495n 1.7v 1549.505n 0.0v 1559.495n 0.0v 1559.505n 1.7v 1569.495n 1.7v 1569.505n 1.7v 1579.495n 1.7v 1579.505n 1.7v 1589.495n 1.7v 1589.505n 1.7v 1599.495n 1.7v 1599.505n 1.7v 1609.495n 1.7v 1609.505n 1.7v 1619.495n 1.7v 1619.505n 1.7v 1629.495n 1.7v 1629.505n 1.7v 1639.495n 1.7v 1639.505n 0.0v 1649.495n 0.0v 1649.505n 0.0v 1659.495n 0.0v 1659.505n 0.0v 1669.495n 0.0v 1669.505n 1.7v 1679.495n 1.7v 1679.505n 0.0v 1689.495n 0.0v 1689.505n 0.0v 1699.495n 0.0v 1699.505n 0.0v 1709.495n 0.0v 1709.505n 0.0v 1719.495n 0.0v 1719.505n 1.7v 1729.495n 1.7v 1729.505n 1.7v 1739.495n 1.7v 1739.505n 0.0v 1749.495n 0.0v 1749.505n 0.0v 1759.495n 0.0v 1759.505n 1.7v 1769.495n 1.7v 1769.505n 1.7v 1779.495n 1.7v 1779.505n 1.7v 1789.495n 1.7v 1789.505n 1.7v 1799.495n 1.7v 1799.505n 1.7v 1809.495n 1.7v 1809.505n 0.0v 1819.495n 0.0v 1819.505n 1.7v 1829.495n 1.7v 1829.505n 1.7v 1839.495n 1.7v 1839.505n 1.7v 1849.495n 1.7v 1849.505n 1.7v 1859.495n 1.7v 1859.505n 0.0v 1869.495n 0.0v 1869.505n 0.0v 1879.495n 0.0v 1879.505n 1.7v 1889.495n 1.7v 1889.505n 1.7v 1899.495n 1.7v 1899.505n 1.7v 1909.495n 1.7v 1909.505n 1.7v 1919.495n 1.7v 1919.505n 1.7v 1929.495n 1.7v 1929.505n 1.7v 1939.495n 1.7v 1939.505n 1.7v 1949.495n 1.7v 1949.505n 0.0v 1959.495n 0.0v 1959.505n 0.0v 1969.495n 0.0v 1969.505n 0.0v 1979.495n 0.0v 1979.505n 0.0v 1989.495n 0.0v 1989.505n 0.0v 1999.495n 0.0v 1999.505n 1.7v 2009.495n 1.7v 2009.505n 1.7v 2019.495n 1.7v 2019.505n 1.7v 2029.495n 1.7v 2029.505n 0.0v 2039.495n 0.0v 2039.505n 1.7v 2049.495n 1.7v 2049.505n 1.7v )
* (time, data): [(0, 0), (10, 0), (20, 1), (30, 1), (40, 1), (50, 1), (60, 1), (70, 1), (80, 1), (90, 1), (100, 1), (110, 1), (120, 1), (130, 1), (140, 1), (150, 1), (160, 1), (170, 1), (180, 1), (190, 0), (200, 0), (210, 1), (220, 1), (230, 1), (240, 1), (250, 1), (260, 1), (270, 1), (280, 1), (290, 1), (300, 1), (310, 1), (320, 1), (330, 1), (340, 1), (350, 0), (360, 0), (370, 0), (380, 0), (390, 0), (400, 0), (410, 0), (420, 0), (430, 0), (440, 0), (450, 0), (460, 0), (470, 0), (480, 1), (490, 1), (500, 1), (510, 1), (520, 1), (530, 1), (540, 1), (550, 0), (560, 0), (570, 0), (580, 0), (590, 1), (600, 0), (610, 0), (620, 0), (630, 0), (640, 0), (650, 1), (660, 0), (670, 0), (680, 0), (690, 0), (700, 0), (710, 1), (720, 0), (730, 0), (740, 1), (750, 1), (760, 1), (770, 1), (780, 1), (790, 1), (800, 1), (810, 1), (820, 1), (830, 1), (840, 1), (850, 1), (860, 1), (870, 0), (880, 1), (890, 1), (900, 1), (910, 0), (920, 0), (930, 0), (940, 0), (950, 0), (960, 0), (970, 0), (980, 0), (990, 0), (1000, 0), (1010, 0), (1020, 0), (1030, 1), (1040, 1), (1050, 0), (1060, 0), (1070, 0), (1080, 0), (1090, 0), (1100, 1), (1110, 1), (1120, 1), (1130, 0), (1140, 0), (1150, 0), (1160, 0), (1170, 0), (1180, 1), (1190, 1), (1200, 1), (1210, 1), (1220, 1), (1230, 1), (1240, 1), (1250, 1), (1260, 1), (1270, 1), (1280, 1), (1290, 1), (1300, 1), (1310, 1), (1320, 1), (1330, 1), (1340, 1), (1350, 0), (1360, 0), (1370, 0), (1380, 0), (1390, 0), (1400, 0), (1410, 0), (1420, 0), (1430, 0), (1440, 1), (1450, 0), (1460, 0), (1470, 0), (1480, 0), (1490, 0), (1500, 0), (1510, 0), (1520, 1), (1530, 1), (1540, 1), (1550, 0), (1560, 1), (1570, 0), (1580, 1), (1590, 1), (1600, 1), (1610, 1), (1620, 1), (1630, 1), (1640, 0), (1650, 1), (1660, 1), (1670, 0), (1680, 1), (1690, 1), (1700, 1), (1710, 1), (1720, 0), (1730, 0), (1740, 1), (1750, 1), (1760, 1), (1770, 1), (1780, 0), (1790, 0), (1800, 0), (1810, 1), (1820, 0), (1830, 0), (1840, 0), (1850, 0), (1860, 1), (1870, 1), (1880, 1), (1890, 0), (1900, 0), (1910, 0), (1920, 0), (1930, 0), (1940, 0), (1950, 1), (1960, 1), (1970, 1), (1980, 0), (1990, 1), (2000, 1), (2010, 1), (2020, 0), (2030, 0), (2040, 1), (2050, 1)]
Vdin0_8  din0_8  0 PWL (0n 0.0v 9.495n 0.0v 9.505n 0.0v 19.495n 0.0v 19.505n 1.7v 29.495n 1.7v 29.505n 1.7v 39.495n 1.7v 39.505n 1.7v 49.495n 1.7v 49.505n 1.7v 59.495n 1.7v 59.505n 1.7v 69.495n 1.7v 69.505n 1.7v 79.495n 1.7v 79.505n 1.7v 89.495n 1.7v 89.505n 1.7v 99.495n 1.7v 99.505n 1.7v 109.495n 1.7v 109.505n 1.7v 119.495n 1.7v 119.505n 1.7v 129.495n 1.7v 129.505n 1.7v 139.495n 1.7v 139.505n 1.7v 149.495n 1.7v 149.505n 1.7v 159.495n 1.7v 159.505n 1.7v 169.495n 1.7v 169.505n 1.7v 179.495n 1.7v 179.505n 1.7v 189.495n 1.7v 189.505n 0.0v 199.495n 0.0v 199.505n 0.0v 209.495n 0.0v 209.505n 1.7v 219.495n 1.7v 219.505n 1.7v 229.495n 1.7v 229.505n 1.7v 239.495n 1.7v 239.505n 1.7v 249.495n 1.7v 249.505n 1.7v 259.495n 1.7v 259.505n 1.7v 269.495n 1.7v 269.505n 1.7v 279.495n 1.7v 279.505n 1.7v 289.495n 1.7v 289.505n 1.7v 299.495n 1.7v 299.505n 1.7v 309.495n 1.7v 309.505n 1.7v 319.495n 1.7v 319.505n 1.7v 329.495n 1.7v 329.505n 1.7v 339.495n 1.7v 339.505n 1.7v 349.495n 1.7v 349.505n 0.0v 359.495n 0.0v 359.505n 0.0v 369.495n 0.0v 369.505n 0.0v 379.495n 0.0v 379.505n 0.0v 389.495n 0.0v 389.505n 0.0v 399.495n 0.0v 399.505n 0.0v 409.495n 0.0v 409.505n 0.0v 419.495n 0.0v 419.505n 0.0v 429.495n 0.0v 429.505n 0.0v 439.495n 0.0v 439.505n 0.0v 449.495n 0.0v 449.505n 0.0v 459.495n 0.0v 459.505n 0.0v 469.495n 0.0v 469.505n 0.0v 479.495n 0.0v 479.505n 1.7v 489.495n 1.7v 489.505n 1.7v 499.495n 1.7v 499.505n 1.7v 509.495n 1.7v 509.505n 1.7v 519.495n 1.7v 519.505n 1.7v 529.495n 1.7v 529.505n 1.7v 539.495n 1.7v 539.505n 1.7v 549.495n 1.7v 549.505n 0.0v 559.495n 0.0v 559.505n 0.0v 569.495n 0.0v 569.505n 0.0v 579.495n 0.0v 579.505n 0.0v 589.495n 0.0v 589.505n 1.7v 599.495n 1.7v 599.505n 0.0v 609.495n 0.0v 609.505n 0.0v 619.495n 0.0v 619.505n 0.0v 629.495n 0.0v 629.505n 0.0v 639.495n 0.0v 639.505n 0.0v 649.495n 0.0v 649.505n 1.7v 659.495n 1.7v 659.505n 0.0v 669.495n 0.0v 669.505n 0.0v 679.495n 0.0v 679.505n 0.0v 689.495n 0.0v 689.505n 0.0v 699.495n 0.0v 699.505n 0.0v 709.495n 0.0v 709.505n 1.7v 719.495n 1.7v 719.505n 0.0v 729.495n 0.0v 729.505n 0.0v 739.495n 0.0v 739.505n 1.7v 749.495n 1.7v 749.505n 1.7v 759.495n 1.7v 759.505n 1.7v 769.495n 1.7v 769.505n 1.7v 779.495n 1.7v 779.505n 1.7v 789.495n 1.7v 789.505n 1.7v 799.495n 1.7v 799.505n 1.7v 809.495n 1.7v 809.505n 1.7v 819.495n 1.7v 819.505n 1.7v 829.495n 1.7v 829.505n 1.7v 839.495n 1.7v 839.505n 1.7v 849.495n 1.7v 849.505n 1.7v 859.495n 1.7v 859.505n 1.7v 869.495n 1.7v 869.505n 0.0v 879.495n 0.0v 879.505n 1.7v 889.495n 1.7v 889.505n 1.7v 899.495n 1.7v 899.505n 1.7v 909.495n 1.7v 909.505n 0.0v 919.495n 0.0v 919.505n 0.0v 929.495n 0.0v 929.505n 0.0v 939.495n 0.0v 939.505n 0.0v 949.495n 0.0v 949.505n 0.0v 959.495n 0.0v 959.505n 0.0v 969.495n 0.0v 969.505n 0.0v 979.495n 0.0v 979.505n 0.0v 989.495n 0.0v 989.505n 0.0v 999.495n 0.0v 999.505n 0.0v 1009.495n 0.0v 1009.505n 0.0v 1019.495n 0.0v 1019.505n 0.0v 1029.495n 0.0v 1029.505n 1.7v 1039.495n 1.7v 1039.505n 1.7v 1049.495n 1.7v 1049.505n 0.0v 1059.495n 0.0v 1059.505n 0.0v 1069.495n 0.0v 1069.505n 0.0v 1079.495n 0.0v 1079.505n 0.0v 1089.495n 0.0v 1089.505n 0.0v 1099.495n 0.0v 1099.505n 1.7v 1109.495n 1.7v 1109.505n 1.7v 1119.495n 1.7v 1119.505n 1.7v 1129.495n 1.7v 1129.505n 0.0v 1139.495n 0.0v 1139.505n 0.0v 1149.495n 0.0v 1149.505n 0.0v 1159.495n 0.0v 1159.505n 0.0v 1169.495n 0.0v 1169.505n 0.0v 1179.495n 0.0v 1179.505n 1.7v 1189.495n 1.7v 1189.505n 1.7v 1199.495n 1.7v 1199.505n 1.7v 1209.495n 1.7v 1209.505n 1.7v 1219.495n 1.7v 1219.505n 1.7v 1229.495n 1.7v 1229.505n 1.7v 1239.495n 1.7v 1239.505n 1.7v 1249.495n 1.7v 1249.505n 1.7v 1259.495n 1.7v 1259.505n 1.7v 1269.495n 1.7v 1269.505n 1.7v 1279.495n 1.7v 1279.505n 1.7v 1289.495n 1.7v 1289.505n 1.7v 1299.495n 1.7v 1299.505n 1.7v 1309.495n 1.7v 1309.505n 1.7v 1319.495n 1.7v 1319.505n 1.7v 1329.495n 1.7v 1329.505n 1.7v 1339.495n 1.7v 1339.505n 1.7v 1349.495n 1.7v 1349.505n 0.0v 1359.495n 0.0v 1359.505n 0.0v 1369.495n 0.0v 1369.505n 0.0v 1379.495n 0.0v 1379.505n 0.0v 1389.495n 0.0v 1389.505n 0.0v 1399.495n 0.0v 1399.505n 0.0v 1409.495n 0.0v 1409.505n 0.0v 1419.495n 0.0v 1419.505n 0.0v 1429.495n 0.0v 1429.505n 0.0v 1439.495n 0.0v 1439.505n 1.7v 1449.495n 1.7v 1449.505n 0.0v 1459.495n 0.0v 1459.505n 0.0v 1469.495n 0.0v 1469.505n 0.0v 1479.495n 0.0v 1479.505n 0.0v 1489.495n 0.0v 1489.505n 0.0v 1499.495n 0.0v 1499.505n 0.0v 1509.495n 0.0v 1509.505n 0.0v 1519.495n 0.0v 1519.505n 1.7v 1529.495n 1.7v 1529.505n 1.7v 1539.495n 1.7v 1539.505n 1.7v 1549.495n 1.7v 1549.505n 0.0v 1559.495n 0.0v 1559.505n 1.7v 1569.495n 1.7v 1569.505n 0.0v 1579.495n 0.0v 1579.505n 1.7v 1589.495n 1.7v 1589.505n 1.7v 1599.495n 1.7v 1599.505n 1.7v 1609.495n 1.7v 1609.505n 1.7v 1619.495n 1.7v 1619.505n 1.7v 1629.495n 1.7v 1629.505n 1.7v 1639.495n 1.7v 1639.505n 0.0v 1649.495n 0.0v 1649.505n 1.7v 1659.495n 1.7v 1659.505n 1.7v 1669.495n 1.7v 1669.505n 0.0v 1679.495n 0.0v 1679.505n 1.7v 1689.495n 1.7v 1689.505n 1.7v 1699.495n 1.7v 1699.505n 1.7v 1709.495n 1.7v 1709.505n 1.7v 1719.495n 1.7v 1719.505n 0.0v 1729.495n 0.0v 1729.505n 0.0v 1739.495n 0.0v 1739.505n 1.7v 1749.495n 1.7v 1749.505n 1.7v 1759.495n 1.7v 1759.505n 1.7v 1769.495n 1.7v 1769.505n 1.7v 1779.495n 1.7v 1779.505n 0.0v 1789.495n 0.0v 1789.505n 0.0v 1799.495n 0.0v 1799.505n 0.0v 1809.495n 0.0v 1809.505n 1.7v 1819.495n 1.7v 1819.505n 0.0v 1829.495n 0.0v 1829.505n 0.0v 1839.495n 0.0v 1839.505n 0.0v 1849.495n 0.0v 1849.505n 0.0v 1859.495n 0.0v 1859.505n 1.7v 1869.495n 1.7v 1869.505n 1.7v 1879.495n 1.7v 1879.505n 1.7v 1889.495n 1.7v 1889.505n 0.0v 1899.495n 0.0v 1899.505n 0.0v 1909.495n 0.0v 1909.505n 0.0v 1919.495n 0.0v 1919.505n 0.0v 1929.495n 0.0v 1929.505n 0.0v 1939.495n 0.0v 1939.505n 0.0v 1949.495n 0.0v 1949.505n 1.7v 1959.495n 1.7v 1959.505n 1.7v 1969.495n 1.7v 1969.505n 1.7v 1979.495n 1.7v 1979.505n 0.0v 1989.495n 0.0v 1989.505n 1.7v 1999.495n 1.7v 1999.505n 1.7v 2009.495n 1.7v 2009.505n 1.7v 2019.495n 1.7v 2019.505n 0.0v 2029.495n 0.0v 2029.505n 0.0v 2039.495n 0.0v 2039.505n 1.7v 2049.495n 1.7v 2049.505n 1.7v )
* (time, data): [(0, 0), (10, 0), (20, 0), (30, 0), (40, 0), (50, 0), (60, 0), (70, 0), (80, 0), (90, 0), (100, 0), (110, 0), (120, 0), (130, 0), (140, 0), (150, 0), (160, 1), (170, 1), (180, 1), (190, 0), (200, 0), (210, 1), (220, 1), (230, 1), (240, 1), (250, 0), (260, 0), (270, 0), (280, 1), (290, 1), (300, 1), (310, 0), (320, 0), (330, 0), (340, 0), (350, 0), (360, 0), (370, 0), (380, 0), (390, 0), (400, 0), (410, 0), (420, 0), (430, 0), (440, 0), (450, 0), (460, 1), (470, 1), (480, 1), (490, 1), (500, 1), (510, 1), (520, 1), (530, 1), (540, 1), (550, 1), (560, 1), (570, 1), (580, 1), (590, 1), (600, 0), (610, 0), (620, 1), (630, 0), (640, 0), (650, 1), (660, 0), (670, 1), (680, 1), (690, 1), (700, 1), (710, 1), (720, 1), (730, 1), (740, 0), (750, 0), (760, 0), (770, 1), (780, 0), (790, 0), (800, 0), (810, 0), (820, 0), (830, 0), (840, 1), (850, 1), (860, 0), (870, 1), (880, 1), (890, 1), (900, 1), (910, 1), (920, 1), (930, 1), (940, 1), (950, 1), (960, 0), (970, 0), (980, 0), (990, 0), (1000, 0), (1010, 0), (1020, 0), (1030, 0), (1040, 0), (1050, 0), (1060, 0), (1070, 0), (1080, 0), (1090, 0), (1100, 1), (1110, 1), (1120, 1), (1130, 0), (1140, 0), (1150, 0), (1160, 0), (1170, 0), (1180, 0), (1190, 0), (1200, 0), (1210, 0), (1220, 0), (1230, 0), (1240, 0), (1250, 0), (1260, 0), (1270, 0), (1280, 0), (1290, 0), (1300, 0), (1310, 0), (1320, 0), (1330, 0), (1340, 0), (1350, 0), (1360, 0), (1370, 0), (1380, 0), (1390, 0), (1400, 1), (1410, 1), (1420, 1), (1430, 1), (1440, 0), (1450, 1), (1460, 1), (1470, 1), (1480, 1), (1490, 1), (1500, 1), (1510, 1), (1520, 0), (1530, 0), (1540, 0), (1550, 1), (1560, 1), (1570, 1), (1580, 0), (1590, 0), (1600, 0), (1610, 1), (1620, 1), (1630, 1), (1640, 0), (1650, 0), (1660, 0), (1670, 1), (1680, 0), (1690, 0), (1700, 1), (1710, 1), (1720, 0), (1730, 0), (1740, 0), (1750, 0), (1760, 1), (1770, 1), (1780, 1), (1790, 1), (1800, 1), (1810, 1), (1820, 1), (1830, 1), (1840, 1), (1850, 1), (1860, 0), (1870, 0), (1880, 0), (1890, 0), (1900, 0), (1910, 0), (1920, 0), (1930, 0), (1940, 0), (1950, 1), (1960, 1), (1970, 1), (1980, 0), (1990, 0), (2000, 0), (2010, 0), (2020, 0), (2030, 0), (2040, 0), (2050, 0)]
Vdin0_9  din0_9  0 PWL (0n 0.0v 9.495n 0.0v 9.505n 0.0v 19.495n 0.0v 19.505n 0.0v 29.495n 0.0v 29.505n 0.0v 39.495n 0.0v 39.505n 0.0v 49.495n 0.0v 49.505n 0.0v 59.495n 0.0v 59.505n 0.0v 69.495n 0.0v 69.505n 0.0v 79.495n 0.0v 79.505n 0.0v 89.495n 0.0v 89.505n 0.0v 99.495n 0.0v 99.505n 0.0v 109.495n 0.0v 109.505n 0.0v 119.495n 0.0v 119.505n 0.0v 129.495n 0.0v 129.505n 0.0v 139.495n 0.0v 139.505n 0.0v 149.495n 0.0v 149.505n 0.0v 159.495n 0.0v 159.505n 1.7v 169.495n 1.7v 169.505n 1.7v 179.495n 1.7v 179.505n 1.7v 189.495n 1.7v 189.505n 0.0v 199.495n 0.0v 199.505n 0.0v 209.495n 0.0v 209.505n 1.7v 219.495n 1.7v 219.505n 1.7v 229.495n 1.7v 229.505n 1.7v 239.495n 1.7v 239.505n 1.7v 249.495n 1.7v 249.505n 0.0v 259.495n 0.0v 259.505n 0.0v 269.495n 0.0v 269.505n 0.0v 279.495n 0.0v 279.505n 1.7v 289.495n 1.7v 289.505n 1.7v 299.495n 1.7v 299.505n 1.7v 309.495n 1.7v 309.505n 0.0v 319.495n 0.0v 319.505n 0.0v 329.495n 0.0v 329.505n 0.0v 339.495n 0.0v 339.505n 0.0v 349.495n 0.0v 349.505n 0.0v 359.495n 0.0v 359.505n 0.0v 369.495n 0.0v 369.505n 0.0v 379.495n 0.0v 379.505n 0.0v 389.495n 0.0v 389.505n 0.0v 399.495n 0.0v 399.505n 0.0v 409.495n 0.0v 409.505n 0.0v 419.495n 0.0v 419.505n 0.0v 429.495n 0.0v 429.505n 0.0v 439.495n 0.0v 439.505n 0.0v 449.495n 0.0v 449.505n 0.0v 459.495n 0.0v 459.505n 1.7v 469.495n 1.7v 469.505n 1.7v 479.495n 1.7v 479.505n 1.7v 489.495n 1.7v 489.505n 1.7v 499.495n 1.7v 499.505n 1.7v 509.495n 1.7v 509.505n 1.7v 519.495n 1.7v 519.505n 1.7v 529.495n 1.7v 529.505n 1.7v 539.495n 1.7v 539.505n 1.7v 549.495n 1.7v 549.505n 1.7v 559.495n 1.7v 559.505n 1.7v 569.495n 1.7v 569.505n 1.7v 579.495n 1.7v 579.505n 1.7v 589.495n 1.7v 589.505n 1.7v 599.495n 1.7v 599.505n 0.0v 609.495n 0.0v 609.505n 0.0v 619.495n 0.0v 619.505n 1.7v 629.495n 1.7v 629.505n 0.0v 639.495n 0.0v 639.505n 0.0v 649.495n 0.0v 649.505n 1.7v 659.495n 1.7v 659.505n 0.0v 669.495n 0.0v 669.505n 1.7v 679.495n 1.7v 679.505n 1.7v 689.495n 1.7v 689.505n 1.7v 699.495n 1.7v 699.505n 1.7v 709.495n 1.7v 709.505n 1.7v 719.495n 1.7v 719.505n 1.7v 729.495n 1.7v 729.505n 1.7v 739.495n 1.7v 739.505n 0.0v 749.495n 0.0v 749.505n 0.0v 759.495n 0.0v 759.505n 0.0v 769.495n 0.0v 769.505n 1.7v 779.495n 1.7v 779.505n 0.0v 789.495n 0.0v 789.505n 0.0v 799.495n 0.0v 799.505n 0.0v 809.495n 0.0v 809.505n 0.0v 819.495n 0.0v 819.505n 0.0v 829.495n 0.0v 829.505n 0.0v 839.495n 0.0v 839.505n 1.7v 849.495n 1.7v 849.505n 1.7v 859.495n 1.7v 859.505n 0.0v 869.495n 0.0v 869.505n 1.7v 879.495n 1.7v 879.505n 1.7v 889.495n 1.7v 889.505n 1.7v 899.495n 1.7v 899.505n 1.7v 909.495n 1.7v 909.505n 1.7v 919.495n 1.7v 919.505n 1.7v 929.495n 1.7v 929.505n 1.7v 939.495n 1.7v 939.505n 1.7v 949.495n 1.7v 949.505n 1.7v 959.495n 1.7v 959.505n 0.0v 969.495n 0.0v 969.505n 0.0v 979.495n 0.0v 979.505n 0.0v 989.495n 0.0v 989.505n 0.0v 999.495n 0.0v 999.505n 0.0v 1009.495n 0.0v 1009.505n 0.0v 1019.495n 0.0v 1019.505n 0.0v 1029.495n 0.0v 1029.505n 0.0v 1039.495n 0.0v 1039.505n 0.0v 1049.495n 0.0v 1049.505n 0.0v 1059.495n 0.0v 1059.505n 0.0v 1069.495n 0.0v 1069.505n 0.0v 1079.495n 0.0v 1079.505n 0.0v 1089.495n 0.0v 1089.505n 0.0v 1099.495n 0.0v 1099.505n 1.7v 1109.495n 1.7v 1109.505n 1.7v 1119.495n 1.7v 1119.505n 1.7v 1129.495n 1.7v 1129.505n 0.0v 1139.495n 0.0v 1139.505n 0.0v 1149.495n 0.0v 1149.505n 0.0v 1159.495n 0.0v 1159.505n 0.0v 1169.495n 0.0v 1169.505n 0.0v 1179.495n 0.0v 1179.505n 0.0v 1189.495n 0.0v 1189.505n 0.0v 1199.495n 0.0v 1199.505n 0.0v 1209.495n 0.0v 1209.505n 0.0v 1219.495n 0.0v 1219.505n 0.0v 1229.495n 0.0v 1229.505n 0.0v 1239.495n 0.0v 1239.505n 0.0v 1249.495n 0.0v 1249.505n 0.0v 1259.495n 0.0v 1259.505n 0.0v 1269.495n 0.0v 1269.505n 0.0v 1279.495n 0.0v 1279.505n 0.0v 1289.495n 0.0v 1289.505n 0.0v 1299.495n 0.0v 1299.505n 0.0v 1309.495n 0.0v 1309.505n 0.0v 1319.495n 0.0v 1319.505n 0.0v 1329.495n 0.0v 1329.505n 0.0v 1339.495n 0.0v 1339.505n 0.0v 1349.495n 0.0v 1349.505n 0.0v 1359.495n 0.0v 1359.505n 0.0v 1369.495n 0.0v 1369.505n 0.0v 1379.495n 0.0v 1379.505n 0.0v 1389.495n 0.0v 1389.505n 0.0v 1399.495n 0.0v 1399.505n 1.7v 1409.495n 1.7v 1409.505n 1.7v 1419.495n 1.7v 1419.505n 1.7v 1429.495n 1.7v 1429.505n 1.7v 1439.495n 1.7v 1439.505n 0.0v 1449.495n 0.0v 1449.505n 1.7v 1459.495n 1.7v 1459.505n 1.7v 1469.495n 1.7v 1469.505n 1.7v 1479.495n 1.7v 1479.505n 1.7v 1489.495n 1.7v 1489.505n 1.7v 1499.495n 1.7v 1499.505n 1.7v 1509.495n 1.7v 1509.505n 1.7v 1519.495n 1.7v 1519.505n 0.0v 1529.495n 0.0v 1529.505n 0.0v 1539.495n 0.0v 1539.505n 0.0v 1549.495n 0.0v 1549.505n 1.7v 1559.495n 1.7v 1559.505n 1.7v 1569.495n 1.7v 1569.505n 1.7v 1579.495n 1.7v 1579.505n 0.0v 1589.495n 0.0v 1589.505n 0.0v 1599.495n 0.0v 1599.505n 0.0v 1609.495n 0.0v 1609.505n 1.7v 1619.495n 1.7v 1619.505n 1.7v 1629.495n 1.7v 1629.505n 1.7v 1639.495n 1.7v 1639.505n 0.0v 1649.495n 0.0v 1649.505n 0.0v 1659.495n 0.0v 1659.505n 0.0v 1669.495n 0.0v 1669.505n 1.7v 1679.495n 1.7v 1679.505n 0.0v 1689.495n 0.0v 1689.505n 0.0v 1699.495n 0.0v 1699.505n 1.7v 1709.495n 1.7v 1709.505n 1.7v 1719.495n 1.7v 1719.505n 0.0v 1729.495n 0.0v 1729.505n 0.0v 1739.495n 0.0v 1739.505n 0.0v 1749.495n 0.0v 1749.505n 0.0v 1759.495n 0.0v 1759.505n 1.7v 1769.495n 1.7v 1769.505n 1.7v 1779.495n 1.7v 1779.505n 1.7v 1789.495n 1.7v 1789.505n 1.7v 1799.495n 1.7v 1799.505n 1.7v 1809.495n 1.7v 1809.505n 1.7v 1819.495n 1.7v 1819.505n 1.7v 1829.495n 1.7v 1829.505n 1.7v 1839.495n 1.7v 1839.505n 1.7v 1849.495n 1.7v 1849.505n 1.7v 1859.495n 1.7v 1859.505n 0.0v 1869.495n 0.0v 1869.505n 0.0v 1879.495n 0.0v 1879.505n 0.0v 1889.495n 0.0v 1889.505n 0.0v 1899.495n 0.0v 1899.505n 0.0v 1909.495n 0.0v 1909.505n 0.0v 1919.495n 0.0v 1919.505n 0.0v 1929.495n 0.0v 1929.505n 0.0v 1939.495n 0.0v 1939.505n 0.0v 1949.495n 0.0v 1949.505n 1.7v 1959.495n 1.7v 1959.505n 1.7v 1969.495n 1.7v 1969.505n 1.7v 1979.495n 1.7v 1979.505n 0.0v 1989.495n 0.0v 1989.505n 0.0v 1999.495n 0.0v 1999.505n 0.0v 2009.495n 0.0v 2009.505n 0.0v 2019.495n 0.0v 2019.505n 0.0v 2029.495n 0.0v 2029.505n 0.0v 2039.495n 0.0v 2039.505n 0.0v 2049.495n 0.0v 2049.505n 0.0v )
* (time, data): [(0, 0), (10, 0), (20, 0), (30, 1), (40, 1), (50, 1), (60, 1), (70, 0), (80, 1), (90, 1), (100, 1), (110, 1), (120, 1), (130, 1), (140, 1), (150, 1), (160, 1), (170, 1), (180, 1), (190, 1), (200, 1), (210, 0), (220, 0), (230, 1), (240, 1), (250, 0), (260, 0), (270, 0), (280, 1), (290, 1), (300, 1), (310, 1), (320, 1), (330, 1), (340, 1), (350, 0), (360, 0), (370, 0), (380, 0), (390, 1), (400, 1), (410, 1), (420, 0), (430, 0), (440, 0), (450, 0), (460, 0), (470, 1), (480, 0), (490, 0), (500, 1), (510, 1), (520, 1), (530, 1), (540, 1), (550, 0), (560, 0), (570, 0), (580, 0), (590, 1), (600, 1), (610, 1), (620, 0), (630, 0), (640, 0), (650, 1), (660, 1), (670, 1), (680, 1), (690, 0), (700, 0), (710, 0), (720, 0), (730, 0), (740, 0), (750, 0), (760, 0), (770, 0), (780, 0), (790, 1), (800, 1), (810, 1), (820, 1), (830, 1), (840, 0), (850, 0), (860, 1), (870, 0), (880, 1), (890, 1), (900, 1), (910, 0), (920, 0), (930, 0), (940, 0), (950, 0), (960, 0), (970, 0), (980, 0), (990, 0), (1000, 1), (1010, 1), (1020, 0), (1030, 0), (1040, 0), (1050, 1), (1060, 1), (1070, 0), (1080, 0), (1090, 0), (1100, 0), (1110, 0), (1120, 0), (1130, 1), (1140, 1), (1150, 1), (1160, 0), (1170, 0), (1180, 1), (1190, 1), (1200, 1), (1210, 1), (1220, 1), (1230, 0), (1240, 0), (1250, 0), (1260, 0), (1270, 0), (1280, 0), (1290, 1), (1300, 1), (1310, 1), (1320, 1), (1330, 1), (1340, 1), (1350, 1), (1360, 1), (1370, 1), (1380, 1), (1390, 1), (1400, 0), (1410, 0), (1420, 0), (1430, 0), (1440, 1), (1450, 0), (1460, 0), (1470, 1), (1480, 1), (1490, 1), (1500, 1), (1510, 1), (1520, 1), (1530, 1), (1540, 1), (1550, 0), (1560, 1), (1570, 1), (1580, 0), (1590, 0), (1600, 0), (1610, 1), (1620, 1), (1630, 1), (1640, 1), (1650, 1), (1660, 1), (1670, 0), (1680, 1), (1690, 0), (1700, 0), (1710, 0), (1720, 0), (1730, 0), (1740, 1), (1750, 1), (1760, 1), (1770, 1), (1780, 0), (1790, 0), (1800, 0), (1810, 0), (1820, 1), (1830, 1), (1840, 1), (1850, 0), (1860, 0), (1870, 0), (1880, 0), (1890, 0), (1900, 1), (1910, 1), (1920, 0), (1930, 0), (1940, 0), (1950, 1), (1960, 1), (1970, 0), (1980, 1), (1990, 0), (2000, 0), (2010, 0), (2020, 0), (2030, 0), (2040, 1), (2050, 1)]
Vdin0_10  din0_10  0 PWL (0n 0.0v 9.495n 0.0v 9.505n 0.0v 19.495n 0.0v 19.505n 0.0v 29.495n 0.0v 29.505n 1.7v 39.495n 1.7v 39.505n 1.7v 49.495n 1.7v 49.505n 1.7v 59.495n 1.7v 59.505n 1.7v 69.495n 1.7v 69.505n 0.0v 79.495n 0.0v 79.505n 1.7v 89.495n 1.7v 89.505n 1.7v 99.495n 1.7v 99.505n 1.7v 109.495n 1.7v 109.505n 1.7v 119.495n 1.7v 119.505n 1.7v 129.495n 1.7v 129.505n 1.7v 139.495n 1.7v 139.505n 1.7v 149.495n 1.7v 149.505n 1.7v 159.495n 1.7v 159.505n 1.7v 169.495n 1.7v 169.505n 1.7v 179.495n 1.7v 179.505n 1.7v 189.495n 1.7v 189.505n 1.7v 199.495n 1.7v 199.505n 1.7v 209.495n 1.7v 209.505n 0.0v 219.495n 0.0v 219.505n 0.0v 229.495n 0.0v 229.505n 1.7v 239.495n 1.7v 239.505n 1.7v 249.495n 1.7v 249.505n 0.0v 259.495n 0.0v 259.505n 0.0v 269.495n 0.0v 269.505n 0.0v 279.495n 0.0v 279.505n 1.7v 289.495n 1.7v 289.505n 1.7v 299.495n 1.7v 299.505n 1.7v 309.495n 1.7v 309.505n 1.7v 319.495n 1.7v 319.505n 1.7v 329.495n 1.7v 329.505n 1.7v 339.495n 1.7v 339.505n 1.7v 349.495n 1.7v 349.505n 0.0v 359.495n 0.0v 359.505n 0.0v 369.495n 0.0v 369.505n 0.0v 379.495n 0.0v 379.505n 0.0v 389.495n 0.0v 389.505n 1.7v 399.495n 1.7v 399.505n 1.7v 409.495n 1.7v 409.505n 1.7v 419.495n 1.7v 419.505n 0.0v 429.495n 0.0v 429.505n 0.0v 439.495n 0.0v 439.505n 0.0v 449.495n 0.0v 449.505n 0.0v 459.495n 0.0v 459.505n 0.0v 469.495n 0.0v 469.505n 1.7v 479.495n 1.7v 479.505n 0.0v 489.495n 0.0v 489.505n 0.0v 499.495n 0.0v 499.505n 1.7v 509.495n 1.7v 509.505n 1.7v 519.495n 1.7v 519.505n 1.7v 529.495n 1.7v 529.505n 1.7v 539.495n 1.7v 539.505n 1.7v 549.495n 1.7v 549.505n 0.0v 559.495n 0.0v 559.505n 0.0v 569.495n 0.0v 569.505n 0.0v 579.495n 0.0v 579.505n 0.0v 589.495n 0.0v 589.505n 1.7v 599.495n 1.7v 599.505n 1.7v 609.495n 1.7v 609.505n 1.7v 619.495n 1.7v 619.505n 0.0v 629.495n 0.0v 629.505n 0.0v 639.495n 0.0v 639.505n 0.0v 649.495n 0.0v 649.505n 1.7v 659.495n 1.7v 659.505n 1.7v 669.495n 1.7v 669.505n 1.7v 679.495n 1.7v 679.505n 1.7v 689.495n 1.7v 689.505n 0.0v 699.495n 0.0v 699.505n 0.0v 709.495n 0.0v 709.505n 0.0v 719.495n 0.0v 719.505n 0.0v 729.495n 0.0v 729.505n 0.0v 739.495n 0.0v 739.505n 0.0v 749.495n 0.0v 749.505n 0.0v 759.495n 0.0v 759.505n 0.0v 769.495n 0.0v 769.505n 0.0v 779.495n 0.0v 779.505n 0.0v 789.495n 0.0v 789.505n 1.7v 799.495n 1.7v 799.505n 1.7v 809.495n 1.7v 809.505n 1.7v 819.495n 1.7v 819.505n 1.7v 829.495n 1.7v 829.505n 1.7v 839.495n 1.7v 839.505n 0.0v 849.495n 0.0v 849.505n 0.0v 859.495n 0.0v 859.505n 1.7v 869.495n 1.7v 869.505n 0.0v 879.495n 0.0v 879.505n 1.7v 889.495n 1.7v 889.505n 1.7v 899.495n 1.7v 899.505n 1.7v 909.495n 1.7v 909.505n 0.0v 919.495n 0.0v 919.505n 0.0v 929.495n 0.0v 929.505n 0.0v 939.495n 0.0v 939.505n 0.0v 949.495n 0.0v 949.505n 0.0v 959.495n 0.0v 959.505n 0.0v 969.495n 0.0v 969.505n 0.0v 979.495n 0.0v 979.505n 0.0v 989.495n 0.0v 989.505n 0.0v 999.495n 0.0v 999.505n 1.7v 1009.495n 1.7v 1009.505n 1.7v 1019.495n 1.7v 1019.505n 0.0v 1029.495n 0.0v 1029.505n 0.0v 1039.495n 0.0v 1039.505n 0.0v 1049.495n 0.0v 1049.505n 1.7v 1059.495n 1.7v 1059.505n 1.7v 1069.495n 1.7v 1069.505n 0.0v 1079.495n 0.0v 1079.505n 0.0v 1089.495n 0.0v 1089.505n 0.0v 1099.495n 0.0v 1099.505n 0.0v 1109.495n 0.0v 1109.505n 0.0v 1119.495n 0.0v 1119.505n 0.0v 1129.495n 0.0v 1129.505n 1.7v 1139.495n 1.7v 1139.505n 1.7v 1149.495n 1.7v 1149.505n 1.7v 1159.495n 1.7v 1159.505n 0.0v 1169.495n 0.0v 1169.505n 0.0v 1179.495n 0.0v 1179.505n 1.7v 1189.495n 1.7v 1189.505n 1.7v 1199.495n 1.7v 1199.505n 1.7v 1209.495n 1.7v 1209.505n 1.7v 1219.495n 1.7v 1219.505n 1.7v 1229.495n 1.7v 1229.505n 0.0v 1239.495n 0.0v 1239.505n 0.0v 1249.495n 0.0v 1249.505n 0.0v 1259.495n 0.0v 1259.505n 0.0v 1269.495n 0.0v 1269.505n 0.0v 1279.495n 0.0v 1279.505n 0.0v 1289.495n 0.0v 1289.505n 1.7v 1299.495n 1.7v 1299.505n 1.7v 1309.495n 1.7v 1309.505n 1.7v 1319.495n 1.7v 1319.505n 1.7v 1329.495n 1.7v 1329.505n 1.7v 1339.495n 1.7v 1339.505n 1.7v 1349.495n 1.7v 1349.505n 1.7v 1359.495n 1.7v 1359.505n 1.7v 1369.495n 1.7v 1369.505n 1.7v 1379.495n 1.7v 1379.505n 1.7v 1389.495n 1.7v 1389.505n 1.7v 1399.495n 1.7v 1399.505n 0.0v 1409.495n 0.0v 1409.505n 0.0v 1419.495n 0.0v 1419.505n 0.0v 1429.495n 0.0v 1429.505n 0.0v 1439.495n 0.0v 1439.505n 1.7v 1449.495n 1.7v 1449.505n 0.0v 1459.495n 0.0v 1459.505n 0.0v 1469.495n 0.0v 1469.505n 1.7v 1479.495n 1.7v 1479.505n 1.7v 1489.495n 1.7v 1489.505n 1.7v 1499.495n 1.7v 1499.505n 1.7v 1509.495n 1.7v 1509.505n 1.7v 1519.495n 1.7v 1519.505n 1.7v 1529.495n 1.7v 1529.505n 1.7v 1539.495n 1.7v 1539.505n 1.7v 1549.495n 1.7v 1549.505n 0.0v 1559.495n 0.0v 1559.505n 1.7v 1569.495n 1.7v 1569.505n 1.7v 1579.495n 1.7v 1579.505n 0.0v 1589.495n 0.0v 1589.505n 0.0v 1599.495n 0.0v 1599.505n 0.0v 1609.495n 0.0v 1609.505n 1.7v 1619.495n 1.7v 1619.505n 1.7v 1629.495n 1.7v 1629.505n 1.7v 1639.495n 1.7v 1639.505n 1.7v 1649.495n 1.7v 1649.505n 1.7v 1659.495n 1.7v 1659.505n 1.7v 1669.495n 1.7v 1669.505n 0.0v 1679.495n 0.0v 1679.505n 1.7v 1689.495n 1.7v 1689.505n 0.0v 1699.495n 0.0v 1699.505n 0.0v 1709.495n 0.0v 1709.505n 0.0v 1719.495n 0.0v 1719.505n 0.0v 1729.495n 0.0v 1729.505n 0.0v 1739.495n 0.0v 1739.505n 1.7v 1749.495n 1.7v 1749.505n 1.7v 1759.495n 1.7v 1759.505n 1.7v 1769.495n 1.7v 1769.505n 1.7v 1779.495n 1.7v 1779.505n 0.0v 1789.495n 0.0v 1789.505n 0.0v 1799.495n 0.0v 1799.505n 0.0v 1809.495n 0.0v 1809.505n 0.0v 1819.495n 0.0v 1819.505n 1.7v 1829.495n 1.7v 1829.505n 1.7v 1839.495n 1.7v 1839.505n 1.7v 1849.495n 1.7v 1849.505n 0.0v 1859.495n 0.0v 1859.505n 0.0v 1869.495n 0.0v 1869.505n 0.0v 1879.495n 0.0v 1879.505n 0.0v 1889.495n 0.0v 1889.505n 0.0v 1899.495n 0.0v 1899.505n 1.7v 1909.495n 1.7v 1909.505n 1.7v 1919.495n 1.7v 1919.505n 0.0v 1929.495n 0.0v 1929.505n 0.0v 1939.495n 0.0v 1939.505n 0.0v 1949.495n 0.0v 1949.505n 1.7v 1959.495n 1.7v 1959.505n 1.7v 1969.495n 1.7v 1969.505n 0.0v 1979.495n 0.0v 1979.505n 1.7v 1989.495n 1.7v 1989.505n 0.0v 1999.495n 0.0v 1999.505n 0.0v 2009.495n 0.0v 2009.505n 0.0v 2019.495n 0.0v 2019.505n 0.0v 2029.495n 0.0v 2029.505n 0.0v 2039.495n 0.0v 2039.505n 1.7v 2049.495n 1.7v 2049.505n 1.7v )
* (time, data): [(0, 0), (10, 1), (20, 1), (30, 1), (40, 1), (50, 1), (60, 1), (70, 1), (80, 0), (90, 0), (100, 0), (110, 0), (120, 0), (130, 0), (140, 0), (150, 0), (160, 0), (170, 0), (180, 0), (190, 0), (200, 0), (210, 1), (220, 1), (230, 1), (240, 1), (250, 0), (260, 0), (270, 0), (280, 0), (290, 0), (300, 0), (310, 1), (320, 1), (330, 0), (340, 0), (350, 0), (360, 0), (370, 1), (380, 1), (390, 0), (400, 0), (410, 0), (420, 0), (430, 0), (440, 0), (450, 0), (460, 1), (470, 0), (480, 0), (490, 0), (500, 0), (510, 0), (520, 0), (530, 0), (540, 0), (550, 0), (560, 0), (570, 0), (580, 0), (590, 0), (600, 1), (610, 1), (620, 1), (630, 0), (640, 0), (650, 1), (660, 0), (670, 0), (680, 1), (690, 0), (700, 0), (710, 0), (720, 1), (730, 1), (740, 1), (750, 1), (760, 1), (770, 0), (780, 0), (790, 0), (800, 0), (810, 0), (820, 0), (830, 0), (840, 1), (850, 1), (860, 0), (870, 1), (880, 1), (890, 1), (900, 1), (910, 1), (920, 1), (930, 1), (940, 1), (950, 1), (960, 0), (970, 0), (980, 0), (990, 0), (1000, 0), (1010, 0), (1020, 0), (1030, 1), (1040, 1), (1050, 0), (1060, 0), (1070, 0), (1080, 0), (1090, 0), (1100, 0), (1110, 0), (1120, 0), (1130, 0), (1140, 0), (1150, 0), (1160, 1), (1170, 1), (1180, 0), (1190, 0), (1200, 0), (1210, 0), (1220, 0), (1230, 1), (1240, 1), (1250, 1), (1260, 1), (1270, 1), (1280, 0), (1290, 1), (1300, 1), (1310, 1), (1320, 1), (1330, 1), (1340, 1), (1350, 0), (1360, 0), (1370, 0), (1380, 0), (1390, 0), (1400, 1), (1410, 0), (1420, 0), (1430, 0), (1440, 0), (1450, 1), (1460, 1), (1470, 0), (1480, 0), (1490, 0), (1500, 1), (1510, 1), (1520, 1), (1530, 1), (1540, 1), (1550, 0), (1560, 1), (1570, 0), (1580, 1), (1590, 1), (1600, 1), (1610, 0), (1620, 0), (1630, 0), (1640, 0), (1650, 1), (1660, 1), (1670, 0), (1680, 1), (1690, 1), (1700, 1), (1710, 1), (1720, 1), (1730, 1), (1740, 1), (1750, 1), (1760, 0), (1770, 0), (1780, 1), (1790, 1), (1800, 1), (1810, 0), (1820, 0), (1830, 0), (1840, 0), (1850, 0), (1860, 0), (1870, 0), (1880, 0), (1890, 1), (1900, 1), (1910, 0), (1920, 1), (1930, 1), (1940, 1), (1950, 0), (1960, 0), (1970, 0), (1980, 0), (1990, 1), (2000, 0), (2010, 0), (2020, 0), (2030, 1), (2040, 1), (2050, 1)]
Vdin0_11  din0_11  0 PWL (0n 0.0v 9.495n 0.0v 9.505n 1.7v 19.495n 1.7v 19.505n 1.7v 29.495n 1.7v 29.505n 1.7v 39.495n 1.7v 39.505n 1.7v 49.495n 1.7v 49.505n 1.7v 59.495n 1.7v 59.505n 1.7v 69.495n 1.7v 69.505n 1.7v 79.495n 1.7v 79.505n 0.0v 89.495n 0.0v 89.505n 0.0v 99.495n 0.0v 99.505n 0.0v 109.495n 0.0v 109.505n 0.0v 119.495n 0.0v 119.505n 0.0v 129.495n 0.0v 129.505n 0.0v 139.495n 0.0v 139.505n 0.0v 149.495n 0.0v 149.505n 0.0v 159.495n 0.0v 159.505n 0.0v 169.495n 0.0v 169.505n 0.0v 179.495n 0.0v 179.505n 0.0v 189.495n 0.0v 189.505n 0.0v 199.495n 0.0v 199.505n 0.0v 209.495n 0.0v 209.505n 1.7v 219.495n 1.7v 219.505n 1.7v 229.495n 1.7v 229.505n 1.7v 239.495n 1.7v 239.505n 1.7v 249.495n 1.7v 249.505n 0.0v 259.495n 0.0v 259.505n 0.0v 269.495n 0.0v 269.505n 0.0v 279.495n 0.0v 279.505n 0.0v 289.495n 0.0v 289.505n 0.0v 299.495n 0.0v 299.505n 0.0v 309.495n 0.0v 309.505n 1.7v 319.495n 1.7v 319.505n 1.7v 329.495n 1.7v 329.505n 0.0v 339.495n 0.0v 339.505n 0.0v 349.495n 0.0v 349.505n 0.0v 359.495n 0.0v 359.505n 0.0v 369.495n 0.0v 369.505n 1.7v 379.495n 1.7v 379.505n 1.7v 389.495n 1.7v 389.505n 0.0v 399.495n 0.0v 399.505n 0.0v 409.495n 0.0v 409.505n 0.0v 419.495n 0.0v 419.505n 0.0v 429.495n 0.0v 429.505n 0.0v 439.495n 0.0v 439.505n 0.0v 449.495n 0.0v 449.505n 0.0v 459.495n 0.0v 459.505n 1.7v 469.495n 1.7v 469.505n 0.0v 479.495n 0.0v 479.505n 0.0v 489.495n 0.0v 489.505n 0.0v 499.495n 0.0v 499.505n 0.0v 509.495n 0.0v 509.505n 0.0v 519.495n 0.0v 519.505n 0.0v 529.495n 0.0v 529.505n 0.0v 539.495n 0.0v 539.505n 0.0v 549.495n 0.0v 549.505n 0.0v 559.495n 0.0v 559.505n 0.0v 569.495n 0.0v 569.505n 0.0v 579.495n 0.0v 579.505n 0.0v 589.495n 0.0v 589.505n 0.0v 599.495n 0.0v 599.505n 1.7v 609.495n 1.7v 609.505n 1.7v 619.495n 1.7v 619.505n 1.7v 629.495n 1.7v 629.505n 0.0v 639.495n 0.0v 639.505n 0.0v 649.495n 0.0v 649.505n 1.7v 659.495n 1.7v 659.505n 0.0v 669.495n 0.0v 669.505n 0.0v 679.495n 0.0v 679.505n 1.7v 689.495n 1.7v 689.505n 0.0v 699.495n 0.0v 699.505n 0.0v 709.495n 0.0v 709.505n 0.0v 719.495n 0.0v 719.505n 1.7v 729.495n 1.7v 729.505n 1.7v 739.495n 1.7v 739.505n 1.7v 749.495n 1.7v 749.505n 1.7v 759.495n 1.7v 759.505n 1.7v 769.495n 1.7v 769.505n 0.0v 779.495n 0.0v 779.505n 0.0v 789.495n 0.0v 789.505n 0.0v 799.495n 0.0v 799.505n 0.0v 809.495n 0.0v 809.505n 0.0v 819.495n 0.0v 819.505n 0.0v 829.495n 0.0v 829.505n 0.0v 839.495n 0.0v 839.505n 1.7v 849.495n 1.7v 849.505n 1.7v 859.495n 1.7v 859.505n 0.0v 869.495n 0.0v 869.505n 1.7v 879.495n 1.7v 879.505n 1.7v 889.495n 1.7v 889.505n 1.7v 899.495n 1.7v 899.505n 1.7v 909.495n 1.7v 909.505n 1.7v 919.495n 1.7v 919.505n 1.7v 929.495n 1.7v 929.505n 1.7v 939.495n 1.7v 939.505n 1.7v 949.495n 1.7v 949.505n 1.7v 959.495n 1.7v 959.505n 0.0v 969.495n 0.0v 969.505n 0.0v 979.495n 0.0v 979.505n 0.0v 989.495n 0.0v 989.505n 0.0v 999.495n 0.0v 999.505n 0.0v 1009.495n 0.0v 1009.505n 0.0v 1019.495n 0.0v 1019.505n 0.0v 1029.495n 0.0v 1029.505n 1.7v 1039.495n 1.7v 1039.505n 1.7v 1049.495n 1.7v 1049.505n 0.0v 1059.495n 0.0v 1059.505n 0.0v 1069.495n 0.0v 1069.505n 0.0v 1079.495n 0.0v 1079.505n 0.0v 1089.495n 0.0v 1089.505n 0.0v 1099.495n 0.0v 1099.505n 0.0v 1109.495n 0.0v 1109.505n 0.0v 1119.495n 0.0v 1119.505n 0.0v 1129.495n 0.0v 1129.505n 0.0v 1139.495n 0.0v 1139.505n 0.0v 1149.495n 0.0v 1149.505n 0.0v 1159.495n 0.0v 1159.505n 1.7v 1169.495n 1.7v 1169.505n 1.7v 1179.495n 1.7v 1179.505n 0.0v 1189.495n 0.0v 1189.505n 0.0v 1199.495n 0.0v 1199.505n 0.0v 1209.495n 0.0v 1209.505n 0.0v 1219.495n 0.0v 1219.505n 0.0v 1229.495n 0.0v 1229.505n 1.7v 1239.495n 1.7v 1239.505n 1.7v 1249.495n 1.7v 1249.505n 1.7v 1259.495n 1.7v 1259.505n 1.7v 1269.495n 1.7v 1269.505n 1.7v 1279.495n 1.7v 1279.505n 0.0v 1289.495n 0.0v 1289.505n 1.7v 1299.495n 1.7v 1299.505n 1.7v 1309.495n 1.7v 1309.505n 1.7v 1319.495n 1.7v 1319.505n 1.7v 1329.495n 1.7v 1329.505n 1.7v 1339.495n 1.7v 1339.505n 1.7v 1349.495n 1.7v 1349.505n 0.0v 1359.495n 0.0v 1359.505n 0.0v 1369.495n 0.0v 1369.505n 0.0v 1379.495n 0.0v 1379.505n 0.0v 1389.495n 0.0v 1389.505n 0.0v 1399.495n 0.0v 1399.505n 1.7v 1409.495n 1.7v 1409.505n 0.0v 1419.495n 0.0v 1419.505n 0.0v 1429.495n 0.0v 1429.505n 0.0v 1439.495n 0.0v 1439.505n 0.0v 1449.495n 0.0v 1449.505n 1.7v 1459.495n 1.7v 1459.505n 1.7v 1469.495n 1.7v 1469.505n 0.0v 1479.495n 0.0v 1479.505n 0.0v 1489.495n 0.0v 1489.505n 0.0v 1499.495n 0.0v 1499.505n 1.7v 1509.495n 1.7v 1509.505n 1.7v 1519.495n 1.7v 1519.505n 1.7v 1529.495n 1.7v 1529.505n 1.7v 1539.495n 1.7v 1539.505n 1.7v 1549.495n 1.7v 1549.505n 0.0v 1559.495n 0.0v 1559.505n 1.7v 1569.495n 1.7v 1569.505n 0.0v 1579.495n 0.0v 1579.505n 1.7v 1589.495n 1.7v 1589.505n 1.7v 1599.495n 1.7v 1599.505n 1.7v 1609.495n 1.7v 1609.505n 0.0v 1619.495n 0.0v 1619.505n 0.0v 1629.495n 0.0v 1629.505n 0.0v 1639.495n 0.0v 1639.505n 0.0v 1649.495n 0.0v 1649.505n 1.7v 1659.495n 1.7v 1659.505n 1.7v 1669.495n 1.7v 1669.505n 0.0v 1679.495n 0.0v 1679.505n 1.7v 1689.495n 1.7v 1689.505n 1.7v 1699.495n 1.7v 1699.505n 1.7v 1709.495n 1.7v 1709.505n 1.7v 1719.495n 1.7v 1719.505n 1.7v 1729.495n 1.7v 1729.505n 1.7v 1739.495n 1.7v 1739.505n 1.7v 1749.495n 1.7v 1749.505n 1.7v 1759.495n 1.7v 1759.505n 0.0v 1769.495n 0.0v 1769.505n 0.0v 1779.495n 0.0v 1779.505n 1.7v 1789.495n 1.7v 1789.505n 1.7v 1799.495n 1.7v 1799.505n 1.7v 1809.495n 1.7v 1809.505n 0.0v 1819.495n 0.0v 1819.505n 0.0v 1829.495n 0.0v 1829.505n 0.0v 1839.495n 0.0v 1839.505n 0.0v 1849.495n 0.0v 1849.505n 0.0v 1859.495n 0.0v 1859.505n 0.0v 1869.495n 0.0v 1869.505n 0.0v 1879.495n 0.0v 1879.505n 0.0v 1889.495n 0.0v 1889.505n 1.7v 1899.495n 1.7v 1899.505n 1.7v 1909.495n 1.7v 1909.505n 0.0v 1919.495n 0.0v 1919.505n 1.7v 1929.495n 1.7v 1929.505n 1.7v 1939.495n 1.7v 1939.505n 1.7v 1949.495n 1.7v 1949.505n 0.0v 1959.495n 0.0v 1959.505n 0.0v 1969.495n 0.0v 1969.505n 0.0v 1979.495n 0.0v 1979.505n 0.0v 1989.495n 0.0v 1989.505n 1.7v 1999.495n 1.7v 1999.505n 0.0v 2009.495n 0.0v 2009.505n 0.0v 2019.495n 0.0v 2019.505n 0.0v 2029.495n 0.0v 2029.505n 1.7v 2039.495n 1.7v 2039.505n 1.7v 2049.495n 1.7v 2049.505n 1.7v )
* (time, data): [(0, 0), (10, 1), (20, 1), (30, 1), (40, 1), (50, 1), (60, 1), (70, 1), (80, 0), (90, 0), (100, 0), (110, 0), (120, 0), (130, 0), (140, 0), (150, 0), (160, 1), (170, 1), (180, 1), (190, 0), (200, 0), (210, 1), (220, 1), (230, 0), (240, 0), (250, 0), (260, 0), (270, 0), (280, 0), (290, 0), (300, 0), (310, 0), (320, 0), (330, 1), (340, 1), (350, 1), (360, 1), (370, 1), (380, 1), (390, 0), (400, 0), (410, 0), (420, 1), (430, 1), (440, 1), (450, 0), (460, 1), (470, 0), (480, 1), (490, 1), (500, 1), (510, 1), (520, 1), (530, 1), (540, 1), (550, 0), (560, 0), (570, 0), (580, 0), (590, 0), (600, 0), (610, 0), (620, 0), (630, 0), (640, 0), (650, 0), (660, 1), (670, 1), (680, 1), (690, 0), (700, 0), (710, 1), (720, 0), (730, 0), (740, 0), (750, 0), (760, 0), (770, 1), (780, 1), (790, 1), (800, 1), (810, 1), (820, 1), (830, 1), (840, 0), (850, 0), (860, 0), (870, 1), (880, 1), (890, 1), (900, 1), (910, 1), (920, 1), (930, 1), (940, 1), (950, 1), (960, 1), (970, 1), (980, 1), (990, 1), (1000, 1), (1010, 1), (1020, 1), (1030, 1), (1040, 1), (1050, 1), (1060, 1), (1070, 0), (1080, 0), (1090, 0), (1100, 1), (1110, 1), (1120, 1), (1130, 0), (1140, 0), (1150, 0), (1160, 1), (1170, 1), (1180, 1), (1190, 1), (1200, 1), (1210, 1), (1220, 1), (1230, 1), (1240, 1), (1250, 1), (1260, 1), (1270, 1), (1280, 0), (1290, 0), (1300, 0), (1310, 0), (1320, 0), (1330, 0), (1340, 0), (1350, 1), (1360, 1), (1370, 1), (1380, 1), (1390, 1), (1400, 1), (1410, 1), (1420, 1), (1430, 1), (1440, 1), (1450, 0), (1460, 0), (1470, 1), (1480, 1), (1490, 1), (1500, 1), (1510, 1), (1520, 0), (1530, 0), (1540, 0), (1550, 0), (1560, 1), (1570, 0), (1580, 1), (1590, 1), (1600, 1), (1610, 0), (1620, 0), (1630, 0), (1640, 0), (1650, 0), (1660, 0), (1670, 0), (1680, 0), (1690, 0), (1700, 1), (1710, 1), (1720, 1), (1730, 1), (1740, 0), (1750, 0), (1760, 0), (1770, 0), (1780, 0), (1790, 0), (1800, 0), (1810, 1), (1820, 1), (1830, 1), (1840, 1), (1850, 1), (1860, 0), (1870, 0), (1880, 1), (1890, 1), (1900, 1), (1910, 1), (1920, 0), (1930, 0), (1940, 0), (1950, 0), (1960, 0), (1970, 1), (1980, 0), (1990, 1), (2000, 0), (2010, 0), (2020, 0), (2030, 1), (2040, 1), (2050, 1)]
Vdin0_12  din0_12  0 PWL (0n 0.0v 9.495n 0.0v 9.505n 1.7v 19.495n 1.7v 19.505n 1.7v 29.495n 1.7v 29.505n 1.7v 39.495n 1.7v 39.505n 1.7v 49.495n 1.7v 49.505n 1.7v 59.495n 1.7v 59.505n 1.7v 69.495n 1.7v 69.505n 1.7v 79.495n 1.7v 79.505n 0.0v 89.495n 0.0v 89.505n 0.0v 99.495n 0.0v 99.505n 0.0v 109.495n 0.0v 109.505n 0.0v 119.495n 0.0v 119.505n 0.0v 129.495n 0.0v 129.505n 0.0v 139.495n 0.0v 139.505n 0.0v 149.495n 0.0v 149.505n 0.0v 159.495n 0.0v 159.505n 1.7v 169.495n 1.7v 169.505n 1.7v 179.495n 1.7v 179.505n 1.7v 189.495n 1.7v 189.505n 0.0v 199.495n 0.0v 199.505n 0.0v 209.495n 0.0v 209.505n 1.7v 219.495n 1.7v 219.505n 1.7v 229.495n 1.7v 229.505n 0.0v 239.495n 0.0v 239.505n 0.0v 249.495n 0.0v 249.505n 0.0v 259.495n 0.0v 259.505n 0.0v 269.495n 0.0v 269.505n 0.0v 279.495n 0.0v 279.505n 0.0v 289.495n 0.0v 289.505n 0.0v 299.495n 0.0v 299.505n 0.0v 309.495n 0.0v 309.505n 0.0v 319.495n 0.0v 319.505n 0.0v 329.495n 0.0v 329.505n 1.7v 339.495n 1.7v 339.505n 1.7v 349.495n 1.7v 349.505n 1.7v 359.495n 1.7v 359.505n 1.7v 369.495n 1.7v 369.505n 1.7v 379.495n 1.7v 379.505n 1.7v 389.495n 1.7v 389.505n 0.0v 399.495n 0.0v 399.505n 0.0v 409.495n 0.0v 409.505n 0.0v 419.495n 0.0v 419.505n 1.7v 429.495n 1.7v 429.505n 1.7v 439.495n 1.7v 439.505n 1.7v 449.495n 1.7v 449.505n 0.0v 459.495n 0.0v 459.505n 1.7v 469.495n 1.7v 469.505n 0.0v 479.495n 0.0v 479.505n 1.7v 489.495n 1.7v 489.505n 1.7v 499.495n 1.7v 499.505n 1.7v 509.495n 1.7v 509.505n 1.7v 519.495n 1.7v 519.505n 1.7v 529.495n 1.7v 529.505n 1.7v 539.495n 1.7v 539.505n 1.7v 549.495n 1.7v 549.505n 0.0v 559.495n 0.0v 559.505n 0.0v 569.495n 0.0v 569.505n 0.0v 579.495n 0.0v 579.505n 0.0v 589.495n 0.0v 589.505n 0.0v 599.495n 0.0v 599.505n 0.0v 609.495n 0.0v 609.505n 0.0v 619.495n 0.0v 619.505n 0.0v 629.495n 0.0v 629.505n 0.0v 639.495n 0.0v 639.505n 0.0v 649.495n 0.0v 649.505n 0.0v 659.495n 0.0v 659.505n 1.7v 669.495n 1.7v 669.505n 1.7v 679.495n 1.7v 679.505n 1.7v 689.495n 1.7v 689.505n 0.0v 699.495n 0.0v 699.505n 0.0v 709.495n 0.0v 709.505n 1.7v 719.495n 1.7v 719.505n 0.0v 729.495n 0.0v 729.505n 0.0v 739.495n 0.0v 739.505n 0.0v 749.495n 0.0v 749.505n 0.0v 759.495n 0.0v 759.505n 0.0v 769.495n 0.0v 769.505n 1.7v 779.495n 1.7v 779.505n 1.7v 789.495n 1.7v 789.505n 1.7v 799.495n 1.7v 799.505n 1.7v 809.495n 1.7v 809.505n 1.7v 819.495n 1.7v 819.505n 1.7v 829.495n 1.7v 829.505n 1.7v 839.495n 1.7v 839.505n 0.0v 849.495n 0.0v 849.505n 0.0v 859.495n 0.0v 859.505n 0.0v 869.495n 0.0v 869.505n 1.7v 879.495n 1.7v 879.505n 1.7v 889.495n 1.7v 889.505n 1.7v 899.495n 1.7v 899.505n 1.7v 909.495n 1.7v 909.505n 1.7v 919.495n 1.7v 919.505n 1.7v 929.495n 1.7v 929.505n 1.7v 939.495n 1.7v 939.505n 1.7v 949.495n 1.7v 949.505n 1.7v 959.495n 1.7v 959.505n 1.7v 969.495n 1.7v 969.505n 1.7v 979.495n 1.7v 979.505n 1.7v 989.495n 1.7v 989.505n 1.7v 999.495n 1.7v 999.505n 1.7v 1009.495n 1.7v 1009.505n 1.7v 1019.495n 1.7v 1019.505n 1.7v 1029.495n 1.7v 1029.505n 1.7v 1039.495n 1.7v 1039.505n 1.7v 1049.495n 1.7v 1049.505n 1.7v 1059.495n 1.7v 1059.505n 1.7v 1069.495n 1.7v 1069.505n 0.0v 1079.495n 0.0v 1079.505n 0.0v 1089.495n 0.0v 1089.505n 0.0v 1099.495n 0.0v 1099.505n 1.7v 1109.495n 1.7v 1109.505n 1.7v 1119.495n 1.7v 1119.505n 1.7v 1129.495n 1.7v 1129.505n 0.0v 1139.495n 0.0v 1139.505n 0.0v 1149.495n 0.0v 1149.505n 0.0v 1159.495n 0.0v 1159.505n 1.7v 1169.495n 1.7v 1169.505n 1.7v 1179.495n 1.7v 1179.505n 1.7v 1189.495n 1.7v 1189.505n 1.7v 1199.495n 1.7v 1199.505n 1.7v 1209.495n 1.7v 1209.505n 1.7v 1219.495n 1.7v 1219.505n 1.7v 1229.495n 1.7v 1229.505n 1.7v 1239.495n 1.7v 1239.505n 1.7v 1249.495n 1.7v 1249.505n 1.7v 1259.495n 1.7v 1259.505n 1.7v 1269.495n 1.7v 1269.505n 1.7v 1279.495n 1.7v 1279.505n 0.0v 1289.495n 0.0v 1289.505n 0.0v 1299.495n 0.0v 1299.505n 0.0v 1309.495n 0.0v 1309.505n 0.0v 1319.495n 0.0v 1319.505n 0.0v 1329.495n 0.0v 1329.505n 0.0v 1339.495n 0.0v 1339.505n 0.0v 1349.495n 0.0v 1349.505n 1.7v 1359.495n 1.7v 1359.505n 1.7v 1369.495n 1.7v 1369.505n 1.7v 1379.495n 1.7v 1379.505n 1.7v 1389.495n 1.7v 1389.505n 1.7v 1399.495n 1.7v 1399.505n 1.7v 1409.495n 1.7v 1409.505n 1.7v 1419.495n 1.7v 1419.505n 1.7v 1429.495n 1.7v 1429.505n 1.7v 1439.495n 1.7v 1439.505n 1.7v 1449.495n 1.7v 1449.505n 0.0v 1459.495n 0.0v 1459.505n 0.0v 1469.495n 0.0v 1469.505n 1.7v 1479.495n 1.7v 1479.505n 1.7v 1489.495n 1.7v 1489.505n 1.7v 1499.495n 1.7v 1499.505n 1.7v 1509.495n 1.7v 1509.505n 1.7v 1519.495n 1.7v 1519.505n 0.0v 1529.495n 0.0v 1529.505n 0.0v 1539.495n 0.0v 1539.505n 0.0v 1549.495n 0.0v 1549.505n 0.0v 1559.495n 0.0v 1559.505n 1.7v 1569.495n 1.7v 1569.505n 0.0v 1579.495n 0.0v 1579.505n 1.7v 1589.495n 1.7v 1589.505n 1.7v 1599.495n 1.7v 1599.505n 1.7v 1609.495n 1.7v 1609.505n 0.0v 1619.495n 0.0v 1619.505n 0.0v 1629.495n 0.0v 1629.505n 0.0v 1639.495n 0.0v 1639.505n 0.0v 1649.495n 0.0v 1649.505n 0.0v 1659.495n 0.0v 1659.505n 0.0v 1669.495n 0.0v 1669.505n 0.0v 1679.495n 0.0v 1679.505n 0.0v 1689.495n 0.0v 1689.505n 0.0v 1699.495n 0.0v 1699.505n 1.7v 1709.495n 1.7v 1709.505n 1.7v 1719.495n 1.7v 1719.505n 1.7v 1729.495n 1.7v 1729.505n 1.7v 1739.495n 1.7v 1739.505n 0.0v 1749.495n 0.0v 1749.505n 0.0v 1759.495n 0.0v 1759.505n 0.0v 1769.495n 0.0v 1769.505n 0.0v 1779.495n 0.0v 1779.505n 0.0v 1789.495n 0.0v 1789.505n 0.0v 1799.495n 0.0v 1799.505n 0.0v 1809.495n 0.0v 1809.505n 1.7v 1819.495n 1.7v 1819.505n 1.7v 1829.495n 1.7v 1829.505n 1.7v 1839.495n 1.7v 1839.505n 1.7v 1849.495n 1.7v 1849.505n 1.7v 1859.495n 1.7v 1859.505n 0.0v 1869.495n 0.0v 1869.505n 0.0v 1879.495n 0.0v 1879.505n 1.7v 1889.495n 1.7v 1889.505n 1.7v 1899.495n 1.7v 1899.505n 1.7v 1909.495n 1.7v 1909.505n 1.7v 1919.495n 1.7v 1919.505n 0.0v 1929.495n 0.0v 1929.505n 0.0v 1939.495n 0.0v 1939.505n 0.0v 1949.495n 0.0v 1949.505n 0.0v 1959.495n 0.0v 1959.505n 0.0v 1969.495n 0.0v 1969.505n 1.7v 1979.495n 1.7v 1979.505n 0.0v 1989.495n 0.0v 1989.505n 1.7v 1999.495n 1.7v 1999.505n 0.0v 2009.495n 0.0v 2009.505n 0.0v 2019.495n 0.0v 2019.505n 0.0v 2029.495n 0.0v 2029.505n 1.7v 2039.495n 1.7v 2039.505n 1.7v 2049.495n 1.7v 2049.505n 1.7v )
* (time, data): [(0, 0), (10, 1), (20, 0), (30, 1), (40, 1), (50, 1), (60, 1), (70, 1), (80, 0), (90, 0), (100, 0), (110, 0), (120, 0), (130, 0), (140, 0), (150, 0), (160, 0), (170, 0), (180, 0), (190, 0), (200, 0), (210, 1), (220, 1), (230, 1), (240, 1), (250, 0), (260, 0), (270, 0), (280, 1), (290, 1), (300, 1), (310, 0), (320, 0), (330, 1), (340, 1), (350, 0), (360, 0), (370, 1), (380, 1), (390, 1), (400, 1), (410, 1), (420, 1), (430, 1), (440, 1), (450, 1), (460, 0), (470, 0), (480, 0), (490, 0), (500, 0), (510, 0), (520, 0), (530, 0), (540, 0), (550, 1), (560, 1), (570, 1), (580, 1), (590, 1), (600, 1), (610, 1), (620, 0), (630, 0), (640, 0), (650, 0), (660, 0), (670, 1), (680, 1), (690, 0), (700, 0), (710, 0), (720, 0), (730, 0), (740, 1), (750, 1), (760, 1), (770, 1), (780, 0), (790, 1), (800, 1), (810, 1), (820, 1), (830, 1), (840, 0), (850, 0), (860, 0), (870, 0), (880, 0), (890, 0), (900, 0), (910, 1), (920, 1), (930, 1), (940, 1), (950, 1), (960, 0), (970, 0), (980, 0), (990, 0), (1000, 0), (1010, 0), (1020, 0), (1030, 0), (1040, 0), (1050, 0), (1060, 0), (1070, 0), (1080, 0), (1090, 0), (1100, 1), (1110, 1), (1120, 1), (1130, 0), (1140, 0), (1150, 0), (1160, 1), (1170, 1), (1180, 0), (1190, 0), (1200, 0), (1210, 0), (1220, 0), (1230, 1), (1240, 1), (1250, 1), (1260, 1), (1270, 1), (1280, 1), (1290, 0), (1300, 1), (1310, 1), (1320, 1), (1330, 1), (1340, 1), (1350, 0), (1360, 0), (1370, 0), (1380, 0), (1390, 0), (1400, 0), (1410, 1), (1420, 1), (1430, 1), (1440, 0), (1450, 1), (1460, 1), (1470, 1), (1480, 1), (1490, 1), (1500, 0), (1510, 0), (1520, 1), (1530, 1), (1540, 1), (1550, 0), (1560, 1), (1570, 0), (1580, 0), (1590, 0), (1600, 0), (1610, 1), (1620, 1), (1630, 1), (1640, 1), (1650, 0), (1660, 0), (1670, 0), (1680, 0), (1690, 1), (1700, 1), (1710, 1), (1720, 0), (1730, 0), (1740, 0), (1750, 0), (1760, 0), (1770, 0), (1780, 1), (1790, 1), (1800, 1), (1810, 0), (1820, 1), (1830, 1), (1840, 1), (1850, 0), (1860, 1), (1870, 1), (1880, 1), (1890, 1), (1900, 1), (1910, 0), (1920, 0), (1930, 0), (1940, 0), (1950, 0), (1960, 0), (1970, 1), (1980, 1), (1990, 0), (2000, 1), (2010, 1), (2020, 0), (2030, 1), (2040, 0), (2050, 0)]
Vdin0_13  din0_13  0 PWL (0n 0.0v 9.495n 0.0v 9.505n 1.7v 19.495n 1.7v 19.505n 0.0v 29.495n 0.0v 29.505n 1.7v 39.495n 1.7v 39.505n 1.7v 49.495n 1.7v 49.505n 1.7v 59.495n 1.7v 59.505n 1.7v 69.495n 1.7v 69.505n 1.7v 79.495n 1.7v 79.505n 0.0v 89.495n 0.0v 89.505n 0.0v 99.495n 0.0v 99.505n 0.0v 109.495n 0.0v 109.505n 0.0v 119.495n 0.0v 119.505n 0.0v 129.495n 0.0v 129.505n 0.0v 139.495n 0.0v 139.505n 0.0v 149.495n 0.0v 149.505n 0.0v 159.495n 0.0v 159.505n 0.0v 169.495n 0.0v 169.505n 0.0v 179.495n 0.0v 179.505n 0.0v 189.495n 0.0v 189.505n 0.0v 199.495n 0.0v 199.505n 0.0v 209.495n 0.0v 209.505n 1.7v 219.495n 1.7v 219.505n 1.7v 229.495n 1.7v 229.505n 1.7v 239.495n 1.7v 239.505n 1.7v 249.495n 1.7v 249.505n 0.0v 259.495n 0.0v 259.505n 0.0v 269.495n 0.0v 269.505n 0.0v 279.495n 0.0v 279.505n 1.7v 289.495n 1.7v 289.505n 1.7v 299.495n 1.7v 299.505n 1.7v 309.495n 1.7v 309.505n 0.0v 319.495n 0.0v 319.505n 0.0v 329.495n 0.0v 329.505n 1.7v 339.495n 1.7v 339.505n 1.7v 349.495n 1.7v 349.505n 0.0v 359.495n 0.0v 359.505n 0.0v 369.495n 0.0v 369.505n 1.7v 379.495n 1.7v 379.505n 1.7v 389.495n 1.7v 389.505n 1.7v 399.495n 1.7v 399.505n 1.7v 409.495n 1.7v 409.505n 1.7v 419.495n 1.7v 419.505n 1.7v 429.495n 1.7v 429.505n 1.7v 439.495n 1.7v 439.505n 1.7v 449.495n 1.7v 449.505n 1.7v 459.495n 1.7v 459.505n 0.0v 469.495n 0.0v 469.505n 0.0v 479.495n 0.0v 479.505n 0.0v 489.495n 0.0v 489.505n 0.0v 499.495n 0.0v 499.505n 0.0v 509.495n 0.0v 509.505n 0.0v 519.495n 0.0v 519.505n 0.0v 529.495n 0.0v 529.505n 0.0v 539.495n 0.0v 539.505n 0.0v 549.495n 0.0v 549.505n 1.7v 559.495n 1.7v 559.505n 1.7v 569.495n 1.7v 569.505n 1.7v 579.495n 1.7v 579.505n 1.7v 589.495n 1.7v 589.505n 1.7v 599.495n 1.7v 599.505n 1.7v 609.495n 1.7v 609.505n 1.7v 619.495n 1.7v 619.505n 0.0v 629.495n 0.0v 629.505n 0.0v 639.495n 0.0v 639.505n 0.0v 649.495n 0.0v 649.505n 0.0v 659.495n 0.0v 659.505n 0.0v 669.495n 0.0v 669.505n 1.7v 679.495n 1.7v 679.505n 1.7v 689.495n 1.7v 689.505n 0.0v 699.495n 0.0v 699.505n 0.0v 709.495n 0.0v 709.505n 0.0v 719.495n 0.0v 719.505n 0.0v 729.495n 0.0v 729.505n 0.0v 739.495n 0.0v 739.505n 1.7v 749.495n 1.7v 749.505n 1.7v 759.495n 1.7v 759.505n 1.7v 769.495n 1.7v 769.505n 1.7v 779.495n 1.7v 779.505n 0.0v 789.495n 0.0v 789.505n 1.7v 799.495n 1.7v 799.505n 1.7v 809.495n 1.7v 809.505n 1.7v 819.495n 1.7v 819.505n 1.7v 829.495n 1.7v 829.505n 1.7v 839.495n 1.7v 839.505n 0.0v 849.495n 0.0v 849.505n 0.0v 859.495n 0.0v 859.505n 0.0v 869.495n 0.0v 869.505n 0.0v 879.495n 0.0v 879.505n 0.0v 889.495n 0.0v 889.505n 0.0v 899.495n 0.0v 899.505n 0.0v 909.495n 0.0v 909.505n 1.7v 919.495n 1.7v 919.505n 1.7v 929.495n 1.7v 929.505n 1.7v 939.495n 1.7v 939.505n 1.7v 949.495n 1.7v 949.505n 1.7v 959.495n 1.7v 959.505n 0.0v 969.495n 0.0v 969.505n 0.0v 979.495n 0.0v 979.505n 0.0v 989.495n 0.0v 989.505n 0.0v 999.495n 0.0v 999.505n 0.0v 1009.495n 0.0v 1009.505n 0.0v 1019.495n 0.0v 1019.505n 0.0v 1029.495n 0.0v 1029.505n 0.0v 1039.495n 0.0v 1039.505n 0.0v 1049.495n 0.0v 1049.505n 0.0v 1059.495n 0.0v 1059.505n 0.0v 1069.495n 0.0v 1069.505n 0.0v 1079.495n 0.0v 1079.505n 0.0v 1089.495n 0.0v 1089.505n 0.0v 1099.495n 0.0v 1099.505n 1.7v 1109.495n 1.7v 1109.505n 1.7v 1119.495n 1.7v 1119.505n 1.7v 1129.495n 1.7v 1129.505n 0.0v 1139.495n 0.0v 1139.505n 0.0v 1149.495n 0.0v 1149.505n 0.0v 1159.495n 0.0v 1159.505n 1.7v 1169.495n 1.7v 1169.505n 1.7v 1179.495n 1.7v 1179.505n 0.0v 1189.495n 0.0v 1189.505n 0.0v 1199.495n 0.0v 1199.505n 0.0v 1209.495n 0.0v 1209.505n 0.0v 1219.495n 0.0v 1219.505n 0.0v 1229.495n 0.0v 1229.505n 1.7v 1239.495n 1.7v 1239.505n 1.7v 1249.495n 1.7v 1249.505n 1.7v 1259.495n 1.7v 1259.505n 1.7v 1269.495n 1.7v 1269.505n 1.7v 1279.495n 1.7v 1279.505n 1.7v 1289.495n 1.7v 1289.505n 0.0v 1299.495n 0.0v 1299.505n 1.7v 1309.495n 1.7v 1309.505n 1.7v 1319.495n 1.7v 1319.505n 1.7v 1329.495n 1.7v 1329.505n 1.7v 1339.495n 1.7v 1339.505n 1.7v 1349.495n 1.7v 1349.505n 0.0v 1359.495n 0.0v 1359.505n 0.0v 1369.495n 0.0v 1369.505n 0.0v 1379.495n 0.0v 1379.505n 0.0v 1389.495n 0.0v 1389.505n 0.0v 1399.495n 0.0v 1399.505n 0.0v 1409.495n 0.0v 1409.505n 1.7v 1419.495n 1.7v 1419.505n 1.7v 1429.495n 1.7v 1429.505n 1.7v 1439.495n 1.7v 1439.505n 0.0v 1449.495n 0.0v 1449.505n 1.7v 1459.495n 1.7v 1459.505n 1.7v 1469.495n 1.7v 1469.505n 1.7v 1479.495n 1.7v 1479.505n 1.7v 1489.495n 1.7v 1489.505n 1.7v 1499.495n 1.7v 1499.505n 0.0v 1509.495n 0.0v 1509.505n 0.0v 1519.495n 0.0v 1519.505n 1.7v 1529.495n 1.7v 1529.505n 1.7v 1539.495n 1.7v 1539.505n 1.7v 1549.495n 1.7v 1549.505n 0.0v 1559.495n 0.0v 1559.505n 1.7v 1569.495n 1.7v 1569.505n 0.0v 1579.495n 0.0v 1579.505n 0.0v 1589.495n 0.0v 1589.505n 0.0v 1599.495n 0.0v 1599.505n 0.0v 1609.495n 0.0v 1609.505n 1.7v 1619.495n 1.7v 1619.505n 1.7v 1629.495n 1.7v 1629.505n 1.7v 1639.495n 1.7v 1639.505n 1.7v 1649.495n 1.7v 1649.505n 0.0v 1659.495n 0.0v 1659.505n 0.0v 1669.495n 0.0v 1669.505n 0.0v 1679.495n 0.0v 1679.505n 0.0v 1689.495n 0.0v 1689.505n 1.7v 1699.495n 1.7v 1699.505n 1.7v 1709.495n 1.7v 1709.505n 1.7v 1719.495n 1.7v 1719.505n 0.0v 1729.495n 0.0v 1729.505n 0.0v 1739.495n 0.0v 1739.505n 0.0v 1749.495n 0.0v 1749.505n 0.0v 1759.495n 0.0v 1759.505n 0.0v 1769.495n 0.0v 1769.505n 0.0v 1779.495n 0.0v 1779.505n 1.7v 1789.495n 1.7v 1789.505n 1.7v 1799.495n 1.7v 1799.505n 1.7v 1809.495n 1.7v 1809.505n 0.0v 1819.495n 0.0v 1819.505n 1.7v 1829.495n 1.7v 1829.505n 1.7v 1839.495n 1.7v 1839.505n 1.7v 1849.495n 1.7v 1849.505n 0.0v 1859.495n 0.0v 1859.505n 1.7v 1869.495n 1.7v 1869.505n 1.7v 1879.495n 1.7v 1879.505n 1.7v 1889.495n 1.7v 1889.505n 1.7v 1899.495n 1.7v 1899.505n 1.7v 1909.495n 1.7v 1909.505n 0.0v 1919.495n 0.0v 1919.505n 0.0v 1929.495n 0.0v 1929.505n 0.0v 1939.495n 0.0v 1939.505n 0.0v 1949.495n 0.0v 1949.505n 0.0v 1959.495n 0.0v 1959.505n 0.0v 1969.495n 0.0v 1969.505n 1.7v 1979.495n 1.7v 1979.505n 1.7v 1989.495n 1.7v 1989.505n 0.0v 1999.495n 0.0v 1999.505n 1.7v 2009.495n 1.7v 2009.505n 1.7v 2019.495n 1.7v 2019.505n 0.0v 2029.495n 0.0v 2029.505n 1.7v 2039.495n 1.7v 2039.505n 0.0v 2049.495n 0.0v 2049.505n 0.0v )
* (time, data): [(0, 0), (10, 1), (20, 0), (30, 1), (40, 1), (50, 1), (60, 1), (70, 0), (80, 0), (90, 0), (100, 0), (110, 0), (120, 0), (130, 0), (140, 0), (150, 0), (160, 0), (170, 0), (180, 0), (190, 1), (200, 1), (210, 0), (220, 0), (230, 1), (240, 1), (250, 0), (260, 0), (270, 0), (280, 1), (290, 1), (300, 1), (310, 1), (320, 1), (330, 0), (340, 0), (350, 0), (360, 0), (370, 0), (380, 0), (390, 1), (400, 1), (410, 1), (420, 1), (430, 1), (440, 1), (450, 0), (460, 1), (470, 1), (480, 0), (490, 0), (500, 1), (510, 1), (520, 1), (530, 1), (540, 1), (550, 1), (560, 1), (570, 1), (580, 1), (590, 1), (600, 0), (610, 0), (620, 1), (630, 0), (640, 0), (650, 1), (660, 0), (670, 0), (680, 1), (690, 1), (700, 1), (710, 0), (720, 1), (730, 1), (740, 0), (750, 0), (760, 0), (770, 0), (780, 0), (790, 0), (800, 0), (810, 0), (820, 0), (830, 0), (840, 0), (850, 0), (860, 0), (870, 0), (880, 0), (890, 0), (900, 0), (910, 0), (920, 0), (930, 0), (940, 0), (950, 1), (960, 1), (970, 1), (980, 1), (990, 1), (1000, 1), (1010, 1), (1020, 0), (1030, 0), (1040, 0), (1050, 0), (1060, 0), (1070, 0), (1080, 0), (1090, 0), (1100, 0), (1110, 0), (1120, 0), (1130, 1), (1140, 1), (1150, 1), (1160, 1), (1170, 1), (1180, 0), (1190, 0), (1200, 0), (1210, 0), (1220, 0), (1230, 0), (1240, 0), (1250, 0), (1260, 0), (1270, 0), (1280, 0), (1290, 0), (1300, 1), (1310, 1), (1320, 1), (1330, 1), (1340, 1), (1350, 0), (1360, 0), (1370, 0), (1380, 0), (1390, 1), (1400, 0), (1410, 1), (1420, 1), (1430, 1), (1440, 0), (1450, 1), (1460, 1), (1470, 1), (1480, 1), (1490, 1), (1500, 0), (1510, 0), (1520, 0), (1530, 0), (1540, 0), (1550, 0), (1560, 1), (1570, 0), (1580, 1), (1590, 1), (1600, 1), (1610, 0), (1620, 0), (1630, 0), (1640, 1), (1650, 0), (1660, 0), (1670, 0), (1680, 1), (1690, 0), (1700, 0), (1710, 0), (1720, 0), (1730, 0), (1740, 0), (1750, 0), (1760, 1), (1770, 1), (1780, 0), (1790, 0), (1800, 0), (1810, 0), (1820, 1), (1830, 1), (1840, 1), (1850, 1), (1860, 1), (1870, 1), (1880, 0), (1890, 1), (1900, 0), (1910, 1), (1920, 1), (1930, 1), (1940, 1), (1950, 0), (1960, 0), (1970, 0), (1980, 1), (1990, 1), (2000, 0), (2010, 0), (2020, 1), (2030, 1), (2040, 1), (2050, 1)]
Vdin0_14  din0_14  0 PWL (0n 0.0v 9.495n 0.0v 9.505n 1.7v 19.495n 1.7v 19.505n 0.0v 29.495n 0.0v 29.505n 1.7v 39.495n 1.7v 39.505n 1.7v 49.495n 1.7v 49.505n 1.7v 59.495n 1.7v 59.505n 1.7v 69.495n 1.7v 69.505n 0.0v 79.495n 0.0v 79.505n 0.0v 89.495n 0.0v 89.505n 0.0v 99.495n 0.0v 99.505n 0.0v 109.495n 0.0v 109.505n 0.0v 119.495n 0.0v 119.505n 0.0v 129.495n 0.0v 129.505n 0.0v 139.495n 0.0v 139.505n 0.0v 149.495n 0.0v 149.505n 0.0v 159.495n 0.0v 159.505n 0.0v 169.495n 0.0v 169.505n 0.0v 179.495n 0.0v 179.505n 0.0v 189.495n 0.0v 189.505n 1.7v 199.495n 1.7v 199.505n 1.7v 209.495n 1.7v 209.505n 0.0v 219.495n 0.0v 219.505n 0.0v 229.495n 0.0v 229.505n 1.7v 239.495n 1.7v 239.505n 1.7v 249.495n 1.7v 249.505n 0.0v 259.495n 0.0v 259.505n 0.0v 269.495n 0.0v 269.505n 0.0v 279.495n 0.0v 279.505n 1.7v 289.495n 1.7v 289.505n 1.7v 299.495n 1.7v 299.505n 1.7v 309.495n 1.7v 309.505n 1.7v 319.495n 1.7v 319.505n 1.7v 329.495n 1.7v 329.505n 0.0v 339.495n 0.0v 339.505n 0.0v 349.495n 0.0v 349.505n 0.0v 359.495n 0.0v 359.505n 0.0v 369.495n 0.0v 369.505n 0.0v 379.495n 0.0v 379.505n 0.0v 389.495n 0.0v 389.505n 1.7v 399.495n 1.7v 399.505n 1.7v 409.495n 1.7v 409.505n 1.7v 419.495n 1.7v 419.505n 1.7v 429.495n 1.7v 429.505n 1.7v 439.495n 1.7v 439.505n 1.7v 449.495n 1.7v 449.505n 0.0v 459.495n 0.0v 459.505n 1.7v 469.495n 1.7v 469.505n 1.7v 479.495n 1.7v 479.505n 0.0v 489.495n 0.0v 489.505n 0.0v 499.495n 0.0v 499.505n 1.7v 509.495n 1.7v 509.505n 1.7v 519.495n 1.7v 519.505n 1.7v 529.495n 1.7v 529.505n 1.7v 539.495n 1.7v 539.505n 1.7v 549.495n 1.7v 549.505n 1.7v 559.495n 1.7v 559.505n 1.7v 569.495n 1.7v 569.505n 1.7v 579.495n 1.7v 579.505n 1.7v 589.495n 1.7v 589.505n 1.7v 599.495n 1.7v 599.505n 0.0v 609.495n 0.0v 609.505n 0.0v 619.495n 0.0v 619.505n 1.7v 629.495n 1.7v 629.505n 0.0v 639.495n 0.0v 639.505n 0.0v 649.495n 0.0v 649.505n 1.7v 659.495n 1.7v 659.505n 0.0v 669.495n 0.0v 669.505n 0.0v 679.495n 0.0v 679.505n 1.7v 689.495n 1.7v 689.505n 1.7v 699.495n 1.7v 699.505n 1.7v 709.495n 1.7v 709.505n 0.0v 719.495n 0.0v 719.505n 1.7v 729.495n 1.7v 729.505n 1.7v 739.495n 1.7v 739.505n 0.0v 749.495n 0.0v 749.505n 0.0v 759.495n 0.0v 759.505n 0.0v 769.495n 0.0v 769.505n 0.0v 779.495n 0.0v 779.505n 0.0v 789.495n 0.0v 789.505n 0.0v 799.495n 0.0v 799.505n 0.0v 809.495n 0.0v 809.505n 0.0v 819.495n 0.0v 819.505n 0.0v 829.495n 0.0v 829.505n 0.0v 839.495n 0.0v 839.505n 0.0v 849.495n 0.0v 849.505n 0.0v 859.495n 0.0v 859.505n 0.0v 869.495n 0.0v 869.505n 0.0v 879.495n 0.0v 879.505n 0.0v 889.495n 0.0v 889.505n 0.0v 899.495n 0.0v 899.505n 0.0v 909.495n 0.0v 909.505n 0.0v 919.495n 0.0v 919.505n 0.0v 929.495n 0.0v 929.505n 0.0v 939.495n 0.0v 939.505n 0.0v 949.495n 0.0v 949.505n 1.7v 959.495n 1.7v 959.505n 1.7v 969.495n 1.7v 969.505n 1.7v 979.495n 1.7v 979.505n 1.7v 989.495n 1.7v 989.505n 1.7v 999.495n 1.7v 999.505n 1.7v 1009.495n 1.7v 1009.505n 1.7v 1019.495n 1.7v 1019.505n 0.0v 1029.495n 0.0v 1029.505n 0.0v 1039.495n 0.0v 1039.505n 0.0v 1049.495n 0.0v 1049.505n 0.0v 1059.495n 0.0v 1059.505n 0.0v 1069.495n 0.0v 1069.505n 0.0v 1079.495n 0.0v 1079.505n 0.0v 1089.495n 0.0v 1089.505n 0.0v 1099.495n 0.0v 1099.505n 0.0v 1109.495n 0.0v 1109.505n 0.0v 1119.495n 0.0v 1119.505n 0.0v 1129.495n 0.0v 1129.505n 1.7v 1139.495n 1.7v 1139.505n 1.7v 1149.495n 1.7v 1149.505n 1.7v 1159.495n 1.7v 1159.505n 1.7v 1169.495n 1.7v 1169.505n 1.7v 1179.495n 1.7v 1179.505n 0.0v 1189.495n 0.0v 1189.505n 0.0v 1199.495n 0.0v 1199.505n 0.0v 1209.495n 0.0v 1209.505n 0.0v 1219.495n 0.0v 1219.505n 0.0v 1229.495n 0.0v 1229.505n 0.0v 1239.495n 0.0v 1239.505n 0.0v 1249.495n 0.0v 1249.505n 0.0v 1259.495n 0.0v 1259.505n 0.0v 1269.495n 0.0v 1269.505n 0.0v 1279.495n 0.0v 1279.505n 0.0v 1289.495n 0.0v 1289.505n 0.0v 1299.495n 0.0v 1299.505n 1.7v 1309.495n 1.7v 1309.505n 1.7v 1319.495n 1.7v 1319.505n 1.7v 1329.495n 1.7v 1329.505n 1.7v 1339.495n 1.7v 1339.505n 1.7v 1349.495n 1.7v 1349.505n 0.0v 1359.495n 0.0v 1359.505n 0.0v 1369.495n 0.0v 1369.505n 0.0v 1379.495n 0.0v 1379.505n 0.0v 1389.495n 0.0v 1389.505n 1.7v 1399.495n 1.7v 1399.505n 0.0v 1409.495n 0.0v 1409.505n 1.7v 1419.495n 1.7v 1419.505n 1.7v 1429.495n 1.7v 1429.505n 1.7v 1439.495n 1.7v 1439.505n 0.0v 1449.495n 0.0v 1449.505n 1.7v 1459.495n 1.7v 1459.505n 1.7v 1469.495n 1.7v 1469.505n 1.7v 1479.495n 1.7v 1479.505n 1.7v 1489.495n 1.7v 1489.505n 1.7v 1499.495n 1.7v 1499.505n 0.0v 1509.495n 0.0v 1509.505n 0.0v 1519.495n 0.0v 1519.505n 0.0v 1529.495n 0.0v 1529.505n 0.0v 1539.495n 0.0v 1539.505n 0.0v 1549.495n 0.0v 1549.505n 0.0v 1559.495n 0.0v 1559.505n 1.7v 1569.495n 1.7v 1569.505n 0.0v 1579.495n 0.0v 1579.505n 1.7v 1589.495n 1.7v 1589.505n 1.7v 1599.495n 1.7v 1599.505n 1.7v 1609.495n 1.7v 1609.505n 0.0v 1619.495n 0.0v 1619.505n 0.0v 1629.495n 0.0v 1629.505n 0.0v 1639.495n 0.0v 1639.505n 1.7v 1649.495n 1.7v 1649.505n 0.0v 1659.495n 0.0v 1659.505n 0.0v 1669.495n 0.0v 1669.505n 0.0v 1679.495n 0.0v 1679.505n 1.7v 1689.495n 1.7v 1689.505n 0.0v 1699.495n 0.0v 1699.505n 0.0v 1709.495n 0.0v 1709.505n 0.0v 1719.495n 0.0v 1719.505n 0.0v 1729.495n 0.0v 1729.505n 0.0v 1739.495n 0.0v 1739.505n 0.0v 1749.495n 0.0v 1749.505n 0.0v 1759.495n 0.0v 1759.505n 1.7v 1769.495n 1.7v 1769.505n 1.7v 1779.495n 1.7v 1779.505n 0.0v 1789.495n 0.0v 1789.505n 0.0v 1799.495n 0.0v 1799.505n 0.0v 1809.495n 0.0v 1809.505n 0.0v 1819.495n 0.0v 1819.505n 1.7v 1829.495n 1.7v 1829.505n 1.7v 1839.495n 1.7v 1839.505n 1.7v 1849.495n 1.7v 1849.505n 1.7v 1859.495n 1.7v 1859.505n 1.7v 1869.495n 1.7v 1869.505n 1.7v 1879.495n 1.7v 1879.505n 0.0v 1889.495n 0.0v 1889.505n 1.7v 1899.495n 1.7v 1899.505n 0.0v 1909.495n 0.0v 1909.505n 1.7v 1919.495n 1.7v 1919.505n 1.7v 1929.495n 1.7v 1929.505n 1.7v 1939.495n 1.7v 1939.505n 1.7v 1949.495n 1.7v 1949.505n 0.0v 1959.495n 0.0v 1959.505n 0.0v 1969.495n 0.0v 1969.505n 0.0v 1979.495n 0.0v 1979.505n 1.7v 1989.495n 1.7v 1989.505n 1.7v 1999.495n 1.7v 1999.505n 0.0v 2009.495n 0.0v 2009.505n 0.0v 2019.495n 0.0v 2019.505n 1.7v 2029.495n 1.7v 2029.505n 1.7v 2039.495n 1.7v 2039.505n 1.7v 2049.495n 1.7v 2049.505n 1.7v )
* (time, data): [(0, 0), (10, 0), (20, 1), (30, 1), (40, 1), (50, 1), (60, 1), (70, 1), (80, 1), (90, 1), (100, 1), (110, 1), (120, 1), (130, 1), (140, 1), (150, 1), (160, 0), (170, 0), (180, 0), (190, 0), (200, 0), (210, 0), (220, 0), (230, 0), (240, 0), (250, 1), (260, 1), (270, 1), (280, 0), (290, 0), (300, 0), (310, 1), (320, 1), (330, 0), (340, 0), (350, 1), (360, 1), (370, 1), (380, 1), (390, 0), (400, 0), (410, 0), (420, 1), (430, 1), (440, 1), (450, 1), (460, 1), (470, 1), (480, 1), (490, 1), (500, 1), (510, 1), (520, 1), (530, 1), (540, 1), (550, 1), (560, 1), (570, 1), (580, 1), (590, 0), (600, 0), (610, 0), (620, 0), (630, 0), (640, 0), (650, 0), (660, 1), (670, 1), (680, 0), (690, 0), (700, 0), (710, 1), (720, 0), (730, 0), (740, 1), (750, 1), (760, 1), (770, 1), (780, 0), (790, 0), (800, 0), (810, 1), (820, 1), (830, 1), (840, 0), (850, 0), (860, 1), (870, 1), (880, 1), (890, 1), (900, 1), (910, 1), (920, 1), (930, 1), (940, 1), (950, 1), (960, 1), (970, 1), (980, 1), (990, 1), (1000, 1), (1010, 1), (1020, 1), (1030, 1), (1040, 1), (1050, 0), (1060, 0), (1070, 0), (1080, 0), (1090, 0), (1100, 0), (1110, 0), (1120, 0), (1130, 1), (1140, 1), (1150, 1), (1160, 0), (1170, 0), (1180, 1), (1190, 1), (1200, 1), (1210, 1), (1220, 1), (1230, 1), (1240, 1), (1250, 1), (1260, 1), (1270, 1), (1280, 0), (1290, 1), (1300, 1), (1310, 1), (1320, 1), (1330, 1), (1340, 1), (1350, 0), (1360, 0), (1370, 0), (1380, 0), (1390, 0), (1400, 0), (1410, 0), (1420, 0), (1430, 0), (1440, 1), (1450, 1), (1460, 1), (1470, 0), (1480, 0), (1490, 0), (1500, 0), (1510, 0), (1520, 1), (1530, 1), (1540, 1), (1550, 0), (1560, 1), (1570, 1), (1580, 0), (1590, 0), (1600, 0), (1610, 1), (1620, 1), (1630, 1), (1640, 1), (1650, 0), (1660, 0), (1670, 1), (1680, 0), (1690, 0), (1700, 1), (1710, 1), (1720, 0), (1730, 0), (1740, 0), (1750, 0), (1760, 0), (1770, 0), (1780, 1), (1790, 1), (1800, 1), (1810, 1), (1820, 1), (1830, 1), (1840, 1), (1850, 0), (1860, 0), (1870, 0), (1880, 0), (1890, 1), (1900, 1), (1910, 1), (1920, 0), (1930, 0), (1940, 0), (1950, 1), (1960, 1), (1970, 1), (1980, 1), (1990, 0), (2000, 1), (2010, 1), (2020, 1), (2030, 0), (2040, 1), (2050, 1)]
Vdin0_15  din0_15  0 PWL (0n 0.0v 9.495n 0.0v 9.505n 0.0v 19.495n 0.0v 19.505n 1.7v 29.495n 1.7v 29.505n 1.7v 39.495n 1.7v 39.505n 1.7v 49.495n 1.7v 49.505n 1.7v 59.495n 1.7v 59.505n 1.7v 69.495n 1.7v 69.505n 1.7v 79.495n 1.7v 79.505n 1.7v 89.495n 1.7v 89.505n 1.7v 99.495n 1.7v 99.505n 1.7v 109.495n 1.7v 109.505n 1.7v 119.495n 1.7v 119.505n 1.7v 129.495n 1.7v 129.505n 1.7v 139.495n 1.7v 139.505n 1.7v 149.495n 1.7v 149.505n 1.7v 159.495n 1.7v 159.505n 0.0v 169.495n 0.0v 169.505n 0.0v 179.495n 0.0v 179.505n 0.0v 189.495n 0.0v 189.505n 0.0v 199.495n 0.0v 199.505n 0.0v 209.495n 0.0v 209.505n 0.0v 219.495n 0.0v 219.505n 0.0v 229.495n 0.0v 229.505n 0.0v 239.495n 0.0v 239.505n 0.0v 249.495n 0.0v 249.505n 1.7v 259.495n 1.7v 259.505n 1.7v 269.495n 1.7v 269.505n 1.7v 279.495n 1.7v 279.505n 0.0v 289.495n 0.0v 289.505n 0.0v 299.495n 0.0v 299.505n 0.0v 309.495n 0.0v 309.505n 1.7v 319.495n 1.7v 319.505n 1.7v 329.495n 1.7v 329.505n 0.0v 339.495n 0.0v 339.505n 0.0v 349.495n 0.0v 349.505n 1.7v 359.495n 1.7v 359.505n 1.7v 369.495n 1.7v 369.505n 1.7v 379.495n 1.7v 379.505n 1.7v 389.495n 1.7v 389.505n 0.0v 399.495n 0.0v 399.505n 0.0v 409.495n 0.0v 409.505n 0.0v 419.495n 0.0v 419.505n 1.7v 429.495n 1.7v 429.505n 1.7v 439.495n 1.7v 439.505n 1.7v 449.495n 1.7v 449.505n 1.7v 459.495n 1.7v 459.505n 1.7v 469.495n 1.7v 469.505n 1.7v 479.495n 1.7v 479.505n 1.7v 489.495n 1.7v 489.505n 1.7v 499.495n 1.7v 499.505n 1.7v 509.495n 1.7v 509.505n 1.7v 519.495n 1.7v 519.505n 1.7v 529.495n 1.7v 529.505n 1.7v 539.495n 1.7v 539.505n 1.7v 549.495n 1.7v 549.505n 1.7v 559.495n 1.7v 559.505n 1.7v 569.495n 1.7v 569.505n 1.7v 579.495n 1.7v 579.505n 1.7v 589.495n 1.7v 589.505n 0.0v 599.495n 0.0v 599.505n 0.0v 609.495n 0.0v 609.505n 0.0v 619.495n 0.0v 619.505n 0.0v 629.495n 0.0v 629.505n 0.0v 639.495n 0.0v 639.505n 0.0v 649.495n 0.0v 649.505n 0.0v 659.495n 0.0v 659.505n 1.7v 669.495n 1.7v 669.505n 1.7v 679.495n 1.7v 679.505n 0.0v 689.495n 0.0v 689.505n 0.0v 699.495n 0.0v 699.505n 0.0v 709.495n 0.0v 709.505n 1.7v 719.495n 1.7v 719.505n 0.0v 729.495n 0.0v 729.505n 0.0v 739.495n 0.0v 739.505n 1.7v 749.495n 1.7v 749.505n 1.7v 759.495n 1.7v 759.505n 1.7v 769.495n 1.7v 769.505n 1.7v 779.495n 1.7v 779.505n 0.0v 789.495n 0.0v 789.505n 0.0v 799.495n 0.0v 799.505n 0.0v 809.495n 0.0v 809.505n 1.7v 819.495n 1.7v 819.505n 1.7v 829.495n 1.7v 829.505n 1.7v 839.495n 1.7v 839.505n 0.0v 849.495n 0.0v 849.505n 0.0v 859.495n 0.0v 859.505n 1.7v 869.495n 1.7v 869.505n 1.7v 879.495n 1.7v 879.505n 1.7v 889.495n 1.7v 889.505n 1.7v 899.495n 1.7v 899.505n 1.7v 909.495n 1.7v 909.505n 1.7v 919.495n 1.7v 919.505n 1.7v 929.495n 1.7v 929.505n 1.7v 939.495n 1.7v 939.505n 1.7v 949.495n 1.7v 949.505n 1.7v 959.495n 1.7v 959.505n 1.7v 969.495n 1.7v 969.505n 1.7v 979.495n 1.7v 979.505n 1.7v 989.495n 1.7v 989.505n 1.7v 999.495n 1.7v 999.505n 1.7v 1009.495n 1.7v 1009.505n 1.7v 1019.495n 1.7v 1019.505n 1.7v 1029.495n 1.7v 1029.505n 1.7v 1039.495n 1.7v 1039.505n 1.7v 1049.495n 1.7v 1049.505n 0.0v 1059.495n 0.0v 1059.505n 0.0v 1069.495n 0.0v 1069.505n 0.0v 1079.495n 0.0v 1079.505n 0.0v 1089.495n 0.0v 1089.505n 0.0v 1099.495n 0.0v 1099.505n 0.0v 1109.495n 0.0v 1109.505n 0.0v 1119.495n 0.0v 1119.505n 0.0v 1129.495n 0.0v 1129.505n 1.7v 1139.495n 1.7v 1139.505n 1.7v 1149.495n 1.7v 1149.505n 1.7v 1159.495n 1.7v 1159.505n 0.0v 1169.495n 0.0v 1169.505n 0.0v 1179.495n 0.0v 1179.505n 1.7v 1189.495n 1.7v 1189.505n 1.7v 1199.495n 1.7v 1199.505n 1.7v 1209.495n 1.7v 1209.505n 1.7v 1219.495n 1.7v 1219.505n 1.7v 1229.495n 1.7v 1229.505n 1.7v 1239.495n 1.7v 1239.505n 1.7v 1249.495n 1.7v 1249.505n 1.7v 1259.495n 1.7v 1259.505n 1.7v 1269.495n 1.7v 1269.505n 1.7v 1279.495n 1.7v 1279.505n 0.0v 1289.495n 0.0v 1289.505n 1.7v 1299.495n 1.7v 1299.505n 1.7v 1309.495n 1.7v 1309.505n 1.7v 1319.495n 1.7v 1319.505n 1.7v 1329.495n 1.7v 1329.505n 1.7v 1339.495n 1.7v 1339.505n 1.7v 1349.495n 1.7v 1349.505n 0.0v 1359.495n 0.0v 1359.505n 0.0v 1369.495n 0.0v 1369.505n 0.0v 1379.495n 0.0v 1379.505n 0.0v 1389.495n 0.0v 1389.505n 0.0v 1399.495n 0.0v 1399.505n 0.0v 1409.495n 0.0v 1409.505n 0.0v 1419.495n 0.0v 1419.505n 0.0v 1429.495n 0.0v 1429.505n 0.0v 1439.495n 0.0v 1439.505n 1.7v 1449.495n 1.7v 1449.505n 1.7v 1459.495n 1.7v 1459.505n 1.7v 1469.495n 1.7v 1469.505n 0.0v 1479.495n 0.0v 1479.505n 0.0v 1489.495n 0.0v 1489.505n 0.0v 1499.495n 0.0v 1499.505n 0.0v 1509.495n 0.0v 1509.505n 0.0v 1519.495n 0.0v 1519.505n 1.7v 1529.495n 1.7v 1529.505n 1.7v 1539.495n 1.7v 1539.505n 1.7v 1549.495n 1.7v 1549.505n 0.0v 1559.495n 0.0v 1559.505n 1.7v 1569.495n 1.7v 1569.505n 1.7v 1579.495n 1.7v 1579.505n 0.0v 1589.495n 0.0v 1589.505n 0.0v 1599.495n 0.0v 1599.505n 0.0v 1609.495n 0.0v 1609.505n 1.7v 1619.495n 1.7v 1619.505n 1.7v 1629.495n 1.7v 1629.505n 1.7v 1639.495n 1.7v 1639.505n 1.7v 1649.495n 1.7v 1649.505n 0.0v 1659.495n 0.0v 1659.505n 0.0v 1669.495n 0.0v 1669.505n 1.7v 1679.495n 1.7v 1679.505n 0.0v 1689.495n 0.0v 1689.505n 0.0v 1699.495n 0.0v 1699.505n 1.7v 1709.495n 1.7v 1709.505n 1.7v 1719.495n 1.7v 1719.505n 0.0v 1729.495n 0.0v 1729.505n 0.0v 1739.495n 0.0v 1739.505n 0.0v 1749.495n 0.0v 1749.505n 0.0v 1759.495n 0.0v 1759.505n 0.0v 1769.495n 0.0v 1769.505n 0.0v 1779.495n 0.0v 1779.505n 1.7v 1789.495n 1.7v 1789.505n 1.7v 1799.495n 1.7v 1799.505n 1.7v 1809.495n 1.7v 1809.505n 1.7v 1819.495n 1.7v 1819.505n 1.7v 1829.495n 1.7v 1829.505n 1.7v 1839.495n 1.7v 1839.505n 1.7v 1849.495n 1.7v 1849.505n 0.0v 1859.495n 0.0v 1859.505n 0.0v 1869.495n 0.0v 1869.505n 0.0v 1879.495n 0.0v 1879.505n 0.0v 1889.495n 0.0v 1889.505n 1.7v 1899.495n 1.7v 1899.505n 1.7v 1909.495n 1.7v 1909.505n 1.7v 1919.495n 1.7v 1919.505n 0.0v 1929.495n 0.0v 1929.505n 0.0v 1939.495n 0.0v 1939.505n 0.0v 1949.495n 0.0v 1949.505n 1.7v 1959.495n 1.7v 1959.505n 1.7v 1969.495n 1.7v 1969.505n 1.7v 1979.495n 1.7v 1979.505n 1.7v 1989.495n 1.7v 1989.505n 0.0v 1999.495n 0.0v 1999.505n 1.7v 2009.495n 1.7v 2009.505n 1.7v 2019.495n 1.7v 2019.505n 1.7v 2029.495n 1.7v 2029.505n 0.0v 2039.495n 0.0v 2039.505n 1.7v 2049.495n 1.7v 2049.505n 1.7v )
* (time, data): [(0, 0), (10, 0), (20, 0), (30, 0), (40, 0), (50, 0), (60, 0), (70, 0), (80, 0), (90, 0), (100, 0), (110, 0), (120, 0), (130, 0), (140, 0), (150, 0), (160, 0), (170, 0), (180, 0), (190, 0), (200, 0), (210, 0), (220, 0), (230, 0), (240, 0), (250, 0), (260, 0), (270, 0), (280, 0), (290, 0), (300, 0), (310, 0), (320, 0), (330, 0), (340, 0), (350, 0), (360, 0), (370, 0), (380, 0), (390, 0), (400, 0), (410, 0), (420, 0), (430, 0), (440, 0), (450, 0), (460, 0), (470, 0), (480, 0), (490, 0), (500, 0), (510, 0), (520, 0), (530, 0), (540, 0), (550, 0), (560, 0), (570, 0), (580, 0), (590, 0), (600, 0), (610, 0), (620, 0), (630, 0), (640, 0), (650, 0), (660, 0), (670, 0), (680, 0), (690, 0), (700, 0), (710, 0), (720, 0), (730, 0), (740, 0), (750, 0), (760, 0), (770, 0), (780, 0), (790, 0), (800, 0), (810, 0), (820, 0), (830, 0), (840, 0), (850, 0), (860, 0), (870, 0), (880, 0), (890, 0), (900, 0), (910, 0), (920, 0), (930, 0), (940, 0), (950, 0), (960, 0), (970, 0), (980, 0), (990, 0), (1000, 0), (1010, 0), (1020, 0), (1030, 0), (1040, 0), (1050, 0), (1060, 0), (1070, 0), (1080, 0), (1090, 0), (1100, 0), (1110, 0), (1120, 0), (1130, 0), (1140, 0), (1150, 0), (1160, 0), (1170, 0), (1180, 0), (1190, 0), (1200, 0), (1210, 0), (1220, 0), (1230, 0), (1240, 0), (1250, 0), (1260, 0), (1270, 0), (1280, 0), (1290, 0), (1300, 0), (1310, 0), (1320, 0), (1330, 0), (1340, 0), (1350, 0), (1360, 0), (1370, 0), (1380, 0), (1390, 0), (1400, 0), (1410, 0), (1420, 0), (1430, 0), (1440, 0), (1450, 0), (1460, 0), (1470, 0), (1480, 0), (1490, 0), (1500, 0), (1510, 0), (1520, 0), (1530, 0), (1540, 0), (1550, 0), (1560, 0), (1570, 0), (1580, 0), (1590, 0), (1600, 0), (1610, 0), (1620, 0), (1630, 0), (1640, 0), (1650, 0), (1660, 0), (1670, 0), (1680, 0), (1690, 0), (1700, 0), (1710, 0), (1720, 0), (1730, 0), (1740, 0), (1750, 0), (1760, 0), (1770, 0), (1780, 0), (1790, 0), (1800, 0), (1810, 0), (1820, 0), (1830, 0), (1840, 0), (1850, 0), (1860, 0), (1870, 0), (1880, 0), (1890, 0), (1900, 0), (1910, 0), (1920, 0), (1930, 0), (1940, 0), (1950, 0), (1960, 0), (1970, 0), (1980, 0), (1990, 0), (2000, 0), (2010, 0), (2020, 0), (2030, 0), (2040, 0), (2050, 0)]
Vdin0_16  din0_16  0 PWL (0n 0.0v 9.495n 0.0v 9.505n 0.0v 19.495n 0.0v 19.505n 0.0v 29.495n 0.0v 29.505n 0.0v 39.495n 0.0v 39.505n 0.0v 49.495n 0.0v 49.505n 0.0v 59.495n 0.0v 59.505n 0.0v 69.495n 0.0v 69.505n 0.0v 79.495n 0.0v 79.505n 0.0v 89.495n 0.0v 89.505n 0.0v 99.495n 0.0v 99.505n 0.0v 109.495n 0.0v 109.505n 0.0v 119.495n 0.0v 119.505n 0.0v 129.495n 0.0v 129.505n 0.0v 139.495n 0.0v 139.505n 0.0v 149.495n 0.0v 149.505n 0.0v 159.495n 0.0v 159.505n 0.0v 169.495n 0.0v 169.505n 0.0v 179.495n 0.0v 179.505n 0.0v 189.495n 0.0v 189.505n 0.0v 199.495n 0.0v 199.505n 0.0v 209.495n 0.0v 209.505n 0.0v 219.495n 0.0v 219.505n 0.0v 229.495n 0.0v 229.505n 0.0v 239.495n 0.0v 239.505n 0.0v 249.495n 0.0v 249.505n 0.0v 259.495n 0.0v 259.505n 0.0v 269.495n 0.0v 269.505n 0.0v 279.495n 0.0v 279.505n 0.0v 289.495n 0.0v 289.505n 0.0v 299.495n 0.0v 299.505n 0.0v 309.495n 0.0v 309.505n 0.0v 319.495n 0.0v 319.505n 0.0v 329.495n 0.0v 329.505n 0.0v 339.495n 0.0v 339.505n 0.0v 349.495n 0.0v 349.505n 0.0v 359.495n 0.0v 359.505n 0.0v 369.495n 0.0v 369.505n 0.0v 379.495n 0.0v 379.505n 0.0v 389.495n 0.0v 389.505n 0.0v 399.495n 0.0v 399.505n 0.0v 409.495n 0.0v 409.505n 0.0v 419.495n 0.0v 419.505n 0.0v 429.495n 0.0v 429.505n 0.0v 439.495n 0.0v 439.505n 0.0v 449.495n 0.0v 449.505n 0.0v 459.495n 0.0v 459.505n 0.0v 469.495n 0.0v 469.505n 0.0v 479.495n 0.0v 479.505n 0.0v 489.495n 0.0v 489.505n 0.0v 499.495n 0.0v 499.505n 0.0v 509.495n 0.0v 509.505n 0.0v 519.495n 0.0v 519.505n 0.0v 529.495n 0.0v 529.505n 0.0v 539.495n 0.0v 539.505n 0.0v 549.495n 0.0v 549.505n 0.0v 559.495n 0.0v 559.505n 0.0v 569.495n 0.0v 569.505n 0.0v 579.495n 0.0v 579.505n 0.0v 589.495n 0.0v 589.505n 0.0v 599.495n 0.0v 599.505n 0.0v 609.495n 0.0v 609.505n 0.0v 619.495n 0.0v 619.505n 0.0v 629.495n 0.0v 629.505n 0.0v 639.495n 0.0v 639.505n 0.0v 649.495n 0.0v 649.505n 0.0v 659.495n 0.0v 659.505n 0.0v 669.495n 0.0v 669.505n 0.0v 679.495n 0.0v 679.505n 0.0v 689.495n 0.0v 689.505n 0.0v 699.495n 0.0v 699.505n 0.0v 709.495n 0.0v 709.505n 0.0v 719.495n 0.0v 719.505n 0.0v 729.495n 0.0v 729.505n 0.0v 739.495n 0.0v 739.505n 0.0v 749.495n 0.0v 749.505n 0.0v 759.495n 0.0v 759.505n 0.0v 769.495n 0.0v 769.505n 0.0v 779.495n 0.0v 779.505n 0.0v 789.495n 0.0v 789.505n 0.0v 799.495n 0.0v 799.505n 0.0v 809.495n 0.0v 809.505n 0.0v 819.495n 0.0v 819.505n 0.0v 829.495n 0.0v 829.505n 0.0v 839.495n 0.0v 839.505n 0.0v 849.495n 0.0v 849.505n 0.0v 859.495n 0.0v 859.505n 0.0v 869.495n 0.0v 869.505n 0.0v 879.495n 0.0v 879.505n 0.0v 889.495n 0.0v 889.505n 0.0v 899.495n 0.0v 899.505n 0.0v 909.495n 0.0v 909.505n 0.0v 919.495n 0.0v 919.505n 0.0v 929.495n 0.0v 929.505n 0.0v 939.495n 0.0v 939.505n 0.0v 949.495n 0.0v 949.505n 0.0v 959.495n 0.0v 959.505n 0.0v 969.495n 0.0v 969.505n 0.0v 979.495n 0.0v 979.505n 0.0v 989.495n 0.0v 989.505n 0.0v 999.495n 0.0v 999.505n 0.0v 1009.495n 0.0v 1009.505n 0.0v 1019.495n 0.0v 1019.505n 0.0v 1029.495n 0.0v 1029.505n 0.0v 1039.495n 0.0v 1039.505n 0.0v 1049.495n 0.0v 1049.505n 0.0v 1059.495n 0.0v 1059.505n 0.0v 1069.495n 0.0v 1069.505n 0.0v 1079.495n 0.0v 1079.505n 0.0v 1089.495n 0.0v 1089.505n 0.0v 1099.495n 0.0v 1099.505n 0.0v 1109.495n 0.0v 1109.505n 0.0v 1119.495n 0.0v 1119.505n 0.0v 1129.495n 0.0v 1129.505n 0.0v 1139.495n 0.0v 1139.505n 0.0v 1149.495n 0.0v 1149.505n 0.0v 1159.495n 0.0v 1159.505n 0.0v 1169.495n 0.0v 1169.505n 0.0v 1179.495n 0.0v 1179.505n 0.0v 1189.495n 0.0v 1189.505n 0.0v 1199.495n 0.0v 1199.505n 0.0v 1209.495n 0.0v 1209.505n 0.0v 1219.495n 0.0v 1219.505n 0.0v 1229.495n 0.0v 1229.505n 0.0v 1239.495n 0.0v 1239.505n 0.0v 1249.495n 0.0v 1249.505n 0.0v 1259.495n 0.0v 1259.505n 0.0v 1269.495n 0.0v 1269.505n 0.0v 1279.495n 0.0v 1279.505n 0.0v 1289.495n 0.0v 1289.505n 0.0v 1299.495n 0.0v 1299.505n 0.0v 1309.495n 0.0v 1309.505n 0.0v 1319.495n 0.0v 1319.505n 0.0v 1329.495n 0.0v 1329.505n 0.0v 1339.495n 0.0v 1339.505n 0.0v 1349.495n 0.0v 1349.505n 0.0v 1359.495n 0.0v 1359.505n 0.0v 1369.495n 0.0v 1369.505n 0.0v 1379.495n 0.0v 1379.505n 0.0v 1389.495n 0.0v 1389.505n 0.0v 1399.495n 0.0v 1399.505n 0.0v 1409.495n 0.0v 1409.505n 0.0v 1419.495n 0.0v 1419.505n 0.0v 1429.495n 0.0v 1429.505n 0.0v 1439.495n 0.0v 1439.505n 0.0v 1449.495n 0.0v 1449.505n 0.0v 1459.495n 0.0v 1459.505n 0.0v 1469.495n 0.0v 1469.505n 0.0v 1479.495n 0.0v 1479.505n 0.0v 1489.495n 0.0v 1489.505n 0.0v 1499.495n 0.0v 1499.505n 0.0v 1509.495n 0.0v 1509.505n 0.0v 1519.495n 0.0v 1519.505n 0.0v 1529.495n 0.0v 1529.505n 0.0v 1539.495n 0.0v 1539.505n 0.0v 1549.495n 0.0v 1549.505n 0.0v 1559.495n 0.0v 1559.505n 0.0v 1569.495n 0.0v 1569.505n 0.0v 1579.495n 0.0v 1579.505n 0.0v 1589.495n 0.0v 1589.505n 0.0v 1599.495n 0.0v 1599.505n 0.0v 1609.495n 0.0v 1609.505n 0.0v 1619.495n 0.0v 1619.505n 0.0v 1629.495n 0.0v 1629.505n 0.0v 1639.495n 0.0v 1639.505n 0.0v 1649.495n 0.0v 1649.505n 0.0v 1659.495n 0.0v 1659.505n 0.0v 1669.495n 0.0v 1669.505n 0.0v 1679.495n 0.0v 1679.505n 0.0v 1689.495n 0.0v 1689.505n 0.0v 1699.495n 0.0v 1699.505n 0.0v 1709.495n 0.0v 1709.505n 0.0v 1719.495n 0.0v 1719.505n 0.0v 1729.495n 0.0v 1729.505n 0.0v 1739.495n 0.0v 1739.505n 0.0v 1749.495n 0.0v 1749.505n 0.0v 1759.495n 0.0v 1759.505n 0.0v 1769.495n 0.0v 1769.505n 0.0v 1779.495n 0.0v 1779.505n 0.0v 1789.495n 0.0v 1789.505n 0.0v 1799.495n 0.0v 1799.505n 0.0v 1809.495n 0.0v 1809.505n 0.0v 1819.495n 0.0v 1819.505n 0.0v 1829.495n 0.0v 1829.505n 0.0v 1839.495n 0.0v 1839.505n 0.0v 1849.495n 0.0v 1849.505n 0.0v 1859.495n 0.0v 1859.505n 0.0v 1869.495n 0.0v 1869.505n 0.0v 1879.495n 0.0v 1879.505n 0.0v 1889.495n 0.0v 1889.505n 0.0v 1899.495n 0.0v 1899.505n 0.0v 1909.495n 0.0v 1909.505n 0.0v 1919.495n 0.0v 1919.505n 0.0v 1929.495n 0.0v 1929.505n 0.0v 1939.495n 0.0v 1939.505n 0.0v 1949.495n 0.0v 1949.505n 0.0v 1959.495n 0.0v 1959.505n 0.0v 1969.495n 0.0v 1969.505n 0.0v 1979.495n 0.0v 1979.505n 0.0v 1989.495n 0.0v 1989.505n 0.0v 1999.495n 0.0v 1999.505n 0.0v 2009.495n 0.0v 2009.505n 0.0v 2019.495n 0.0v 2019.505n 0.0v 2029.495n 0.0v 2029.505n 0.0v 2039.495n 0.0v 2039.505n 0.0v 2049.495n 0.0v 2049.505n 0.0v )
* (time, data): [(0, 0), (10, 0), (20, 0), (30, 1), (40, 1), (50, 1), (60, 1), (70, 1), (80, 1), (90, 1), (100, 1), (110, 0), (120, 0), (130, 0), (140, 0), (150, 0), (160, 0), (170, 0), (180, 0), (190, 1), (200, 1), (210, 1), (220, 1), (230, 0), (240, 0), (250, 1), (260, 1), (270, 1), (280, 0), (290, 0), (300, 0), (310, 0), (320, 0), (330, 1), (340, 1), (350, 0), (360, 0), (370, 1), (380, 1), (390, 1), (400, 1), (410, 1), (420, 0), (430, 0), (440, 0), (450, 1), (460, 1), (470, 0), (480, 1), (490, 1), (500, 1), (510, 1), (520, 1), (530, 1), (540, 1), (550, 0), (560, 0), (570, 0), (580, 0), (590, 1), (600, 1), (610, 1), (620, 1), (630, 1), (640, 1), (650, 0), (660, 1), (670, 1), (680, 1), (690, 1), (700, 1), (710, 1), (720, 0), (730, 0), (740, 1), (750, 1), (760, 1), (770, 0), (780, 0), (790, 0), (800, 0), (810, 1), (820, 1), (830, 1), (840, 0), (850, 0), (860, 1), (870, 0), (880, 1), (890, 1), (900, 1), (910, 1), (920, 1), (930, 1), (940, 1), (950, 1), (960, 0), (970, 0), (980, 0), (990, 0), (1000, 1), (1010, 1), (1020, 0), (1030, 0), (1040, 0), (1050, 0), (1060, 0), (1070, 1), (1080, 1), (1090, 1), (1100, 0), (1110, 0), (1120, 0), (1130, 1), (1140, 1), (1150, 1), (1160, 1), (1170, 1), (1180, 0), (1190, 0), (1200, 0), (1210, 0), (1220, 0), (1230, 1), (1240, 1), (1250, 1), (1260, 1), (1270, 1), (1280, 0), (1290, 0), (1300, 0), (1310, 0), (1320, 0), (1330, 0), (1340, 0), (1350, 1), (1360, 1), (1370, 1), (1380, 1), (1390, 1), (1400, 0), (1410, 0), (1420, 0), (1430, 0), (1440, 1), (1450, 1), (1460, 1), (1470, 1), (1480, 1), (1490, 1), (1500, 1), (1510, 1), (1520, 0), (1530, 0), (1540, 0), (1550, 1), (1560, 1), (1570, 1), (1580, 1), (1590, 1), (1600, 1), (1610, 1), (1620, 1), (1630, 1), (1640, 1), (1650, 0), (1660, 0), (1670, 1), (1680, 0), (1690, 1), (1700, 0), (1710, 0), (1720, 1), (1730, 1), (1740, 0), (1750, 0), (1760, 1), (1770, 1), (1780, 1), (1790, 1), (1800, 1), (1810, 0), (1820, 1), (1830, 1), (1840, 1), (1850, 0), (1860, 1), (1870, 1), (1880, 0), (1890, 1), (1900, 0), (1910, 1), (1920, 0), (1930, 0), (1940, 0), (1950, 1), (1960, 1), (1970, 1), (1980, 0), (1990, 1), (2000, 0), (2010, 0), (2020, 1), (2030, 0), (2040, 0), (2050, 0)]
Va0_0  a0_0  0 PWL (0n 0.0v 9.495n 0.0v 9.505n 0.0v 19.495n 0.0v 19.505n 0.0v 29.495n 0.0v 29.505n 1.7v 39.495n 1.7v 39.505n 1.7v 49.495n 1.7v 49.505n 1.7v 59.495n 1.7v 59.505n 1.7v 69.495n 1.7v 69.505n 1.7v 79.495n 1.7v 79.505n 1.7v 89.495n 1.7v 89.505n 1.7v 99.495n 1.7v 99.505n 1.7v 109.495n 1.7v 109.505n 0.0v 119.495n 0.0v 119.505n 0.0v 129.495n 0.0v 129.505n 0.0v 139.495n 0.0v 139.505n 0.0v 149.495n 0.0v 149.505n 0.0v 159.495n 0.0v 159.505n 0.0v 169.495n 0.0v 169.505n 0.0v 179.495n 0.0v 179.505n 0.0v 189.495n 0.0v 189.505n 1.7v 199.495n 1.7v 199.505n 1.7v 209.495n 1.7v 209.505n 1.7v 219.495n 1.7v 219.505n 1.7v 229.495n 1.7v 229.505n 0.0v 239.495n 0.0v 239.505n 0.0v 249.495n 0.0v 249.505n 1.7v 259.495n 1.7v 259.505n 1.7v 269.495n 1.7v 269.505n 1.7v 279.495n 1.7v 279.505n 0.0v 289.495n 0.0v 289.505n 0.0v 299.495n 0.0v 299.505n 0.0v 309.495n 0.0v 309.505n 0.0v 319.495n 0.0v 319.505n 0.0v 329.495n 0.0v 329.505n 1.7v 339.495n 1.7v 339.505n 1.7v 349.495n 1.7v 349.505n 0.0v 359.495n 0.0v 359.505n 0.0v 369.495n 0.0v 369.505n 1.7v 379.495n 1.7v 379.505n 1.7v 389.495n 1.7v 389.505n 1.7v 399.495n 1.7v 399.505n 1.7v 409.495n 1.7v 409.505n 1.7v 419.495n 1.7v 419.505n 0.0v 429.495n 0.0v 429.505n 0.0v 439.495n 0.0v 439.505n 0.0v 449.495n 0.0v 449.505n 1.7v 459.495n 1.7v 459.505n 1.7v 469.495n 1.7v 469.505n 0.0v 479.495n 0.0v 479.505n 1.7v 489.495n 1.7v 489.505n 1.7v 499.495n 1.7v 499.505n 1.7v 509.495n 1.7v 509.505n 1.7v 519.495n 1.7v 519.505n 1.7v 529.495n 1.7v 529.505n 1.7v 539.495n 1.7v 539.505n 1.7v 549.495n 1.7v 549.505n 0.0v 559.495n 0.0v 559.505n 0.0v 569.495n 0.0v 569.505n 0.0v 579.495n 0.0v 579.505n 0.0v 589.495n 0.0v 589.505n 1.7v 599.495n 1.7v 599.505n 1.7v 609.495n 1.7v 609.505n 1.7v 619.495n 1.7v 619.505n 1.7v 629.495n 1.7v 629.505n 1.7v 639.495n 1.7v 639.505n 1.7v 649.495n 1.7v 649.505n 0.0v 659.495n 0.0v 659.505n 1.7v 669.495n 1.7v 669.505n 1.7v 679.495n 1.7v 679.505n 1.7v 689.495n 1.7v 689.505n 1.7v 699.495n 1.7v 699.505n 1.7v 709.495n 1.7v 709.505n 1.7v 719.495n 1.7v 719.505n 0.0v 729.495n 0.0v 729.505n 0.0v 739.495n 0.0v 739.505n 1.7v 749.495n 1.7v 749.505n 1.7v 759.495n 1.7v 759.505n 1.7v 769.495n 1.7v 769.505n 0.0v 779.495n 0.0v 779.505n 0.0v 789.495n 0.0v 789.505n 0.0v 799.495n 0.0v 799.505n 0.0v 809.495n 0.0v 809.505n 1.7v 819.495n 1.7v 819.505n 1.7v 829.495n 1.7v 829.505n 1.7v 839.495n 1.7v 839.505n 0.0v 849.495n 0.0v 849.505n 0.0v 859.495n 0.0v 859.505n 1.7v 869.495n 1.7v 869.505n 0.0v 879.495n 0.0v 879.505n 1.7v 889.495n 1.7v 889.505n 1.7v 899.495n 1.7v 899.505n 1.7v 909.495n 1.7v 909.505n 1.7v 919.495n 1.7v 919.505n 1.7v 929.495n 1.7v 929.505n 1.7v 939.495n 1.7v 939.505n 1.7v 949.495n 1.7v 949.505n 1.7v 959.495n 1.7v 959.505n 0.0v 969.495n 0.0v 969.505n 0.0v 979.495n 0.0v 979.505n 0.0v 989.495n 0.0v 989.505n 0.0v 999.495n 0.0v 999.505n 1.7v 1009.495n 1.7v 1009.505n 1.7v 1019.495n 1.7v 1019.505n 0.0v 1029.495n 0.0v 1029.505n 0.0v 1039.495n 0.0v 1039.505n 0.0v 1049.495n 0.0v 1049.505n 0.0v 1059.495n 0.0v 1059.505n 0.0v 1069.495n 0.0v 1069.505n 1.7v 1079.495n 1.7v 1079.505n 1.7v 1089.495n 1.7v 1089.505n 1.7v 1099.495n 1.7v 1099.505n 0.0v 1109.495n 0.0v 1109.505n 0.0v 1119.495n 0.0v 1119.505n 0.0v 1129.495n 0.0v 1129.505n 1.7v 1139.495n 1.7v 1139.505n 1.7v 1149.495n 1.7v 1149.505n 1.7v 1159.495n 1.7v 1159.505n 1.7v 1169.495n 1.7v 1169.505n 1.7v 1179.495n 1.7v 1179.505n 0.0v 1189.495n 0.0v 1189.505n 0.0v 1199.495n 0.0v 1199.505n 0.0v 1209.495n 0.0v 1209.505n 0.0v 1219.495n 0.0v 1219.505n 0.0v 1229.495n 0.0v 1229.505n 1.7v 1239.495n 1.7v 1239.505n 1.7v 1249.495n 1.7v 1249.505n 1.7v 1259.495n 1.7v 1259.505n 1.7v 1269.495n 1.7v 1269.505n 1.7v 1279.495n 1.7v 1279.505n 0.0v 1289.495n 0.0v 1289.505n 0.0v 1299.495n 0.0v 1299.505n 0.0v 1309.495n 0.0v 1309.505n 0.0v 1319.495n 0.0v 1319.505n 0.0v 1329.495n 0.0v 1329.505n 0.0v 1339.495n 0.0v 1339.505n 0.0v 1349.495n 0.0v 1349.505n 1.7v 1359.495n 1.7v 1359.505n 1.7v 1369.495n 1.7v 1369.505n 1.7v 1379.495n 1.7v 1379.505n 1.7v 1389.495n 1.7v 1389.505n 1.7v 1399.495n 1.7v 1399.505n 0.0v 1409.495n 0.0v 1409.505n 0.0v 1419.495n 0.0v 1419.505n 0.0v 1429.495n 0.0v 1429.505n 0.0v 1439.495n 0.0v 1439.505n 1.7v 1449.495n 1.7v 1449.505n 1.7v 1459.495n 1.7v 1459.505n 1.7v 1469.495n 1.7v 1469.505n 1.7v 1479.495n 1.7v 1479.505n 1.7v 1489.495n 1.7v 1489.505n 1.7v 1499.495n 1.7v 1499.505n 1.7v 1509.495n 1.7v 1509.505n 1.7v 1519.495n 1.7v 1519.505n 0.0v 1529.495n 0.0v 1529.505n 0.0v 1539.495n 0.0v 1539.505n 0.0v 1549.495n 0.0v 1549.505n 1.7v 1559.495n 1.7v 1559.505n 1.7v 1569.495n 1.7v 1569.505n 1.7v 1579.495n 1.7v 1579.505n 1.7v 1589.495n 1.7v 1589.505n 1.7v 1599.495n 1.7v 1599.505n 1.7v 1609.495n 1.7v 1609.505n 1.7v 1619.495n 1.7v 1619.505n 1.7v 1629.495n 1.7v 1629.505n 1.7v 1639.495n 1.7v 1639.505n 1.7v 1649.495n 1.7v 1649.505n 0.0v 1659.495n 0.0v 1659.505n 0.0v 1669.495n 0.0v 1669.505n 1.7v 1679.495n 1.7v 1679.505n 0.0v 1689.495n 0.0v 1689.505n 1.7v 1699.495n 1.7v 1699.505n 0.0v 1709.495n 0.0v 1709.505n 0.0v 1719.495n 0.0v 1719.505n 1.7v 1729.495n 1.7v 1729.505n 1.7v 1739.495n 1.7v 1739.505n 0.0v 1749.495n 0.0v 1749.505n 0.0v 1759.495n 0.0v 1759.505n 1.7v 1769.495n 1.7v 1769.505n 1.7v 1779.495n 1.7v 1779.505n 1.7v 1789.495n 1.7v 1789.505n 1.7v 1799.495n 1.7v 1799.505n 1.7v 1809.495n 1.7v 1809.505n 0.0v 1819.495n 0.0v 1819.505n 1.7v 1829.495n 1.7v 1829.505n 1.7v 1839.495n 1.7v 1839.505n 1.7v 1849.495n 1.7v 1849.505n 0.0v 1859.495n 0.0v 1859.505n 1.7v 1869.495n 1.7v 1869.505n 1.7v 1879.495n 1.7v 1879.505n 0.0v 1889.495n 0.0v 1889.505n 1.7v 1899.495n 1.7v 1899.505n 0.0v 1909.495n 0.0v 1909.505n 1.7v 1919.495n 1.7v 1919.505n 0.0v 1929.495n 0.0v 1929.505n 0.0v 1939.495n 0.0v 1939.505n 0.0v 1949.495n 0.0v 1949.505n 1.7v 1959.495n 1.7v 1959.505n 1.7v 1969.495n 1.7v 1969.505n 1.7v 1979.495n 1.7v 1979.505n 0.0v 1989.495n 0.0v 1989.505n 1.7v 1999.495n 1.7v 1999.505n 0.0v 2009.495n 0.0v 2009.505n 0.0v 2019.495n 0.0v 2019.505n 1.7v 2029.495n 1.7v 2029.505n 0.0v 2039.495n 0.0v 2039.505n 0.0v 2049.495n 0.0v 2049.505n 0.0v )
* (time, data): [(0, 0), (10, 0), (20, 1), (30, 1), (40, 1), (50, 1), (60, 1), (70, 0), (80, 0), (90, 0), (100, 0), (110, 0), (120, 0), (130, 0), (140, 0), (150, 0), (160, 1), (170, 1), (180, 1), (190, 1), (200, 1), (210, 1), (220, 1), (230, 0), (240, 0), (250, 1), (260, 1), (270, 1), (280, 0), (290, 0), (300, 0), (310, 1), (320, 1), (330, 1), (340, 1), (350, 0), (360, 0), (370, 0), (380, 0), (390, 0), (400, 0), (410, 0), (420, 0), (430, 0), (440, 0), (450, 1), (460, 0), (470, 0), (480, 1), (490, 1), (500, 1), (510, 1), (520, 1), (530, 1), (540, 1), (550, 1), (560, 1), (570, 1), (580, 1), (590, 0), (600, 0), (610, 0), (620, 0), (630, 1), (640, 1), (650, 0), (660, 0), (670, 0), (680, 0), (690, 0), (700, 0), (710, 0), (720, 0), (730, 0), (740, 0), (750, 0), (760, 0), (770, 0), (780, 0), (790, 1), (800, 1), (810, 1), (820, 1), (830, 1), (840, 0), (850, 0), (860, 0), (870, 1), (880, 0), (890, 0), (900, 0), (910, 0), (920, 0), (930, 0), (940, 0), (950, 1), (960, 0), (970, 0), (980, 0), (990, 0), (1000, 0), (1010, 0), (1020, 1), (1030, 1), (1040, 1), (1050, 0), (1060, 0), (1070, 1), (1080, 1), (1090, 1), (1100, 0), (1110, 0), (1120, 0), (1130, 0), (1140, 0), (1150, 0), (1160, 1), (1170, 1), (1180, 0), (1190, 0), (1200, 0), (1210, 0), (1220, 0), (1230, 1), (1240, 1), (1250, 1), (1260, 1), (1270, 1), (1280, 0), (1290, 1), (1300, 0), (1310, 0), (1320, 0), (1330, 0), (1340, 0), (1350, 0), (1360, 0), (1370, 0), (1380, 0), (1390, 0), (1400, 0), (1410, 1), (1420, 1), (1430, 1), (1440, 1), (1450, 1), (1460, 1), (1470, 1), (1480, 1), (1490, 1), (1500, 0), (1510, 0), (1520, 0), (1530, 0), (1540, 0), (1550, 1), (1560, 1), (1570, 1), (1580, 1), (1590, 1), (1600, 1), (1610, 0), (1620, 0), (1630, 0), (1640, 1), (1650, 1), (1660, 1), (1670, 0), (1680, 0), (1690, 1), (1700, 1), (1710, 1), (1720, 1), (1730, 1), (1740, 1), (1750, 1), (1760, 0), (1770, 0), (1780, 0), (1790, 0), (1800, 0), (1810, 0), (1820, 1), (1830, 1), (1840, 1), (1850, 0), (1860, 0), (1870, 0), (1880, 0), (1890, 1), (1900, 1), (1910, 1), (1920, 0), (1930, 0), (1940, 0), (1950, 1), (1960, 1), (1970, 0), (1980, 1), (1990, 1), (2000, 0), (2010, 0), (2020, 0), (2030, 0), (2040, 1), (2050, 1)]
Va0_1  a0_1  0 PWL (0n 0.0v 9.495n 0.0v 9.505n 0.0v 19.495n 0.0v 19.505n 1.7v 29.495n 1.7v 29.505n 1.7v 39.495n 1.7v 39.505n 1.7v 49.495n 1.7v 49.505n 1.7v 59.495n 1.7v 59.505n 1.7v 69.495n 1.7v 69.505n 0.0v 79.495n 0.0v 79.505n 0.0v 89.495n 0.0v 89.505n 0.0v 99.495n 0.0v 99.505n 0.0v 109.495n 0.0v 109.505n 0.0v 119.495n 0.0v 119.505n 0.0v 129.495n 0.0v 129.505n 0.0v 139.495n 0.0v 139.505n 0.0v 149.495n 0.0v 149.505n 0.0v 159.495n 0.0v 159.505n 1.7v 169.495n 1.7v 169.505n 1.7v 179.495n 1.7v 179.505n 1.7v 189.495n 1.7v 189.505n 1.7v 199.495n 1.7v 199.505n 1.7v 209.495n 1.7v 209.505n 1.7v 219.495n 1.7v 219.505n 1.7v 229.495n 1.7v 229.505n 0.0v 239.495n 0.0v 239.505n 0.0v 249.495n 0.0v 249.505n 1.7v 259.495n 1.7v 259.505n 1.7v 269.495n 1.7v 269.505n 1.7v 279.495n 1.7v 279.505n 0.0v 289.495n 0.0v 289.505n 0.0v 299.495n 0.0v 299.505n 0.0v 309.495n 0.0v 309.505n 1.7v 319.495n 1.7v 319.505n 1.7v 329.495n 1.7v 329.505n 1.7v 339.495n 1.7v 339.505n 1.7v 349.495n 1.7v 349.505n 0.0v 359.495n 0.0v 359.505n 0.0v 369.495n 0.0v 369.505n 0.0v 379.495n 0.0v 379.505n 0.0v 389.495n 0.0v 389.505n 0.0v 399.495n 0.0v 399.505n 0.0v 409.495n 0.0v 409.505n 0.0v 419.495n 0.0v 419.505n 0.0v 429.495n 0.0v 429.505n 0.0v 439.495n 0.0v 439.505n 0.0v 449.495n 0.0v 449.505n 1.7v 459.495n 1.7v 459.505n 0.0v 469.495n 0.0v 469.505n 0.0v 479.495n 0.0v 479.505n 1.7v 489.495n 1.7v 489.505n 1.7v 499.495n 1.7v 499.505n 1.7v 509.495n 1.7v 509.505n 1.7v 519.495n 1.7v 519.505n 1.7v 529.495n 1.7v 529.505n 1.7v 539.495n 1.7v 539.505n 1.7v 549.495n 1.7v 549.505n 1.7v 559.495n 1.7v 559.505n 1.7v 569.495n 1.7v 569.505n 1.7v 579.495n 1.7v 579.505n 1.7v 589.495n 1.7v 589.505n 0.0v 599.495n 0.0v 599.505n 0.0v 609.495n 0.0v 609.505n 0.0v 619.495n 0.0v 619.505n 0.0v 629.495n 0.0v 629.505n 1.7v 639.495n 1.7v 639.505n 1.7v 649.495n 1.7v 649.505n 0.0v 659.495n 0.0v 659.505n 0.0v 669.495n 0.0v 669.505n 0.0v 679.495n 0.0v 679.505n 0.0v 689.495n 0.0v 689.505n 0.0v 699.495n 0.0v 699.505n 0.0v 709.495n 0.0v 709.505n 0.0v 719.495n 0.0v 719.505n 0.0v 729.495n 0.0v 729.505n 0.0v 739.495n 0.0v 739.505n 0.0v 749.495n 0.0v 749.505n 0.0v 759.495n 0.0v 759.505n 0.0v 769.495n 0.0v 769.505n 0.0v 779.495n 0.0v 779.505n 0.0v 789.495n 0.0v 789.505n 1.7v 799.495n 1.7v 799.505n 1.7v 809.495n 1.7v 809.505n 1.7v 819.495n 1.7v 819.505n 1.7v 829.495n 1.7v 829.505n 1.7v 839.495n 1.7v 839.505n 0.0v 849.495n 0.0v 849.505n 0.0v 859.495n 0.0v 859.505n 0.0v 869.495n 0.0v 869.505n 1.7v 879.495n 1.7v 879.505n 0.0v 889.495n 0.0v 889.505n 0.0v 899.495n 0.0v 899.505n 0.0v 909.495n 0.0v 909.505n 0.0v 919.495n 0.0v 919.505n 0.0v 929.495n 0.0v 929.505n 0.0v 939.495n 0.0v 939.505n 0.0v 949.495n 0.0v 949.505n 1.7v 959.495n 1.7v 959.505n 0.0v 969.495n 0.0v 969.505n 0.0v 979.495n 0.0v 979.505n 0.0v 989.495n 0.0v 989.505n 0.0v 999.495n 0.0v 999.505n 0.0v 1009.495n 0.0v 1009.505n 0.0v 1019.495n 0.0v 1019.505n 1.7v 1029.495n 1.7v 1029.505n 1.7v 1039.495n 1.7v 1039.505n 1.7v 1049.495n 1.7v 1049.505n 0.0v 1059.495n 0.0v 1059.505n 0.0v 1069.495n 0.0v 1069.505n 1.7v 1079.495n 1.7v 1079.505n 1.7v 1089.495n 1.7v 1089.505n 1.7v 1099.495n 1.7v 1099.505n 0.0v 1109.495n 0.0v 1109.505n 0.0v 1119.495n 0.0v 1119.505n 0.0v 1129.495n 0.0v 1129.505n 0.0v 1139.495n 0.0v 1139.505n 0.0v 1149.495n 0.0v 1149.505n 0.0v 1159.495n 0.0v 1159.505n 1.7v 1169.495n 1.7v 1169.505n 1.7v 1179.495n 1.7v 1179.505n 0.0v 1189.495n 0.0v 1189.505n 0.0v 1199.495n 0.0v 1199.505n 0.0v 1209.495n 0.0v 1209.505n 0.0v 1219.495n 0.0v 1219.505n 0.0v 1229.495n 0.0v 1229.505n 1.7v 1239.495n 1.7v 1239.505n 1.7v 1249.495n 1.7v 1249.505n 1.7v 1259.495n 1.7v 1259.505n 1.7v 1269.495n 1.7v 1269.505n 1.7v 1279.495n 1.7v 1279.505n 0.0v 1289.495n 0.0v 1289.505n 1.7v 1299.495n 1.7v 1299.505n 0.0v 1309.495n 0.0v 1309.505n 0.0v 1319.495n 0.0v 1319.505n 0.0v 1329.495n 0.0v 1329.505n 0.0v 1339.495n 0.0v 1339.505n 0.0v 1349.495n 0.0v 1349.505n 0.0v 1359.495n 0.0v 1359.505n 0.0v 1369.495n 0.0v 1369.505n 0.0v 1379.495n 0.0v 1379.505n 0.0v 1389.495n 0.0v 1389.505n 0.0v 1399.495n 0.0v 1399.505n 0.0v 1409.495n 0.0v 1409.505n 1.7v 1419.495n 1.7v 1419.505n 1.7v 1429.495n 1.7v 1429.505n 1.7v 1439.495n 1.7v 1439.505n 1.7v 1449.495n 1.7v 1449.505n 1.7v 1459.495n 1.7v 1459.505n 1.7v 1469.495n 1.7v 1469.505n 1.7v 1479.495n 1.7v 1479.505n 1.7v 1489.495n 1.7v 1489.505n 1.7v 1499.495n 1.7v 1499.505n 0.0v 1509.495n 0.0v 1509.505n 0.0v 1519.495n 0.0v 1519.505n 0.0v 1529.495n 0.0v 1529.505n 0.0v 1539.495n 0.0v 1539.505n 0.0v 1549.495n 0.0v 1549.505n 1.7v 1559.495n 1.7v 1559.505n 1.7v 1569.495n 1.7v 1569.505n 1.7v 1579.495n 1.7v 1579.505n 1.7v 1589.495n 1.7v 1589.505n 1.7v 1599.495n 1.7v 1599.505n 1.7v 1609.495n 1.7v 1609.505n 0.0v 1619.495n 0.0v 1619.505n 0.0v 1629.495n 0.0v 1629.505n 0.0v 1639.495n 0.0v 1639.505n 1.7v 1649.495n 1.7v 1649.505n 1.7v 1659.495n 1.7v 1659.505n 1.7v 1669.495n 1.7v 1669.505n 0.0v 1679.495n 0.0v 1679.505n 0.0v 1689.495n 0.0v 1689.505n 1.7v 1699.495n 1.7v 1699.505n 1.7v 1709.495n 1.7v 1709.505n 1.7v 1719.495n 1.7v 1719.505n 1.7v 1729.495n 1.7v 1729.505n 1.7v 1739.495n 1.7v 1739.505n 1.7v 1749.495n 1.7v 1749.505n 1.7v 1759.495n 1.7v 1759.505n 0.0v 1769.495n 0.0v 1769.505n 0.0v 1779.495n 0.0v 1779.505n 0.0v 1789.495n 0.0v 1789.505n 0.0v 1799.495n 0.0v 1799.505n 0.0v 1809.495n 0.0v 1809.505n 0.0v 1819.495n 0.0v 1819.505n 1.7v 1829.495n 1.7v 1829.505n 1.7v 1839.495n 1.7v 1839.505n 1.7v 1849.495n 1.7v 1849.505n 0.0v 1859.495n 0.0v 1859.505n 0.0v 1869.495n 0.0v 1869.505n 0.0v 1879.495n 0.0v 1879.505n 0.0v 1889.495n 0.0v 1889.505n 1.7v 1899.495n 1.7v 1899.505n 1.7v 1909.495n 1.7v 1909.505n 1.7v 1919.495n 1.7v 1919.505n 0.0v 1929.495n 0.0v 1929.505n 0.0v 1939.495n 0.0v 1939.505n 0.0v 1949.495n 0.0v 1949.505n 1.7v 1959.495n 1.7v 1959.505n 1.7v 1969.495n 1.7v 1969.505n 0.0v 1979.495n 0.0v 1979.505n 1.7v 1989.495n 1.7v 1989.505n 1.7v 1999.495n 1.7v 1999.505n 0.0v 2009.495n 0.0v 2009.505n 0.0v 2019.495n 0.0v 2019.505n 0.0v 2029.495n 0.0v 2029.505n 0.0v 2039.495n 0.0v 2039.505n 1.7v 2049.495n 1.7v 2049.505n 1.7v )
* (time, data): [(0, 0), (10, 0), (20, 0), (30, 1), (40, 1), (50, 1), (60, 1), (70, 0), (80, 0), (90, 0), (100, 0), (110, 0), (120, 0), (130, 0), (140, 0), (150, 0), (160, 0), (170, 0), (180, 0), (190, 1), (200, 1), (210, 0), (220, 0), (230, 0), (240, 0), (250, 1), (260, 1), (270, 1), (280, 0), (290, 0), (300, 0), (310, 0), (320, 0), (330, 0), (340, 0), (350, 0), (360, 0), (370, 0), (380, 0), (390, 0), (400, 0), (410, 0), (420, 0), (430, 0), (440, 0), (450, 1), (460, 0), (470, 0), (480, 1), (490, 1), (500, 0), (510, 0), (520, 0), (530, 0), (540, 0), (550, 0), (560, 0), (570, 0), (580, 0), (590, 0), (600, 0), (610, 0), (620, 0), (630, 0), (640, 0), (650, 0), (660, 0), (670, 0), (680, 0), (690, 0), (700, 0), (710, 0), (720, 0), (730, 0), (740, 0), (750, 0), (760, 0), (770, 0), (780, 0), (790, 0), (800, 0), (810, 0), (820, 0), (830, 0), (840, 0), (850, 0), (860, 0), (870, 0), (880, 0), (890, 0), (900, 0), (910, 0), (920, 0), (930, 0), (940, 0), (950, 0), (960, 0), (970, 0), (980, 0), (990, 0), (1000, 0), (1010, 0), (1020, 0), (1030, 0), (1040, 0), (1050, 0), (1060, 0), (1070, 0), (1080, 0), (1090, 0), (1100, 0), (1110, 0), (1120, 0), (1130, 0), (1140, 0), (1150, 0), (1160, 0), (1170, 0), (1180, 0), (1190, 0), (1200, 0), (1210, 0), (1220, 0), (1230, 0), (1240, 0), (1250, 0), (1260, 0), (1270, 0), (1280, 0), (1290, 0), (1300, 0), (1310, 0), (1320, 0), (1330, 0), (1340, 0), (1350, 0), (1360, 0), (1370, 0), (1380, 0), (1390, 0), (1400, 0), (1410, 0), (1420, 0), (1430, 0), (1440, 0), (1450, 1), (1460, 1), (1470, 0), (1480, 0), (1490, 0), (1500, 0), (1510, 0), (1520, 0), (1530, 0), (1540, 0), (1550, 0), (1560, 0), (1570, 0), (1580, 1), (1590, 1), (1600, 1), (1610, 0), (1620, 0), (1630, 0), (1640, 1), (1650, 0), (1660, 0), (1670, 0), (1680, 0), (1690, 0), (1700, 0), (1710, 0), (1720, 0), (1730, 0), (1740, 0), (1750, 0), (1760, 0), (1770, 0), (1780, 0), (1790, 0), (1800, 0), (1810, 0), (1820, 1), (1830, 1), (1840, 1), (1850, 0), (1860, 0), (1870, 0), (1880, 0), (1890, 0), (1900, 0), (1910, 0), (1920, 0), (1930, 0), (1940, 0), (1950, 0), (1960, 0), (1970, 0), (1980, 0), (1990, 0), (2000, 0), (2010, 0), (2020, 0), (2030, 0), (2040, 0), (2050, 0)]
Va0_2  a0_2  0 PWL (0n 0.0v 9.495n 0.0v 9.505n 0.0v 19.495n 0.0v 19.505n 0.0v 29.495n 0.0v 29.505n 1.7v 39.495n 1.7v 39.505n 1.7v 49.495n 1.7v 49.505n 1.7v 59.495n 1.7v 59.505n 1.7v 69.495n 1.7v 69.505n 0.0v 79.495n 0.0v 79.505n 0.0v 89.495n 0.0v 89.505n 0.0v 99.495n 0.0v 99.505n 0.0v 109.495n 0.0v 109.505n 0.0v 119.495n 0.0v 119.505n 0.0v 129.495n 0.0v 129.505n 0.0v 139.495n 0.0v 139.505n 0.0v 149.495n 0.0v 149.505n 0.0v 159.495n 0.0v 159.505n 0.0v 169.495n 0.0v 169.505n 0.0v 179.495n 0.0v 179.505n 0.0v 189.495n 0.0v 189.505n 1.7v 199.495n 1.7v 199.505n 1.7v 209.495n 1.7v 209.505n 0.0v 219.495n 0.0v 219.505n 0.0v 229.495n 0.0v 229.505n 0.0v 239.495n 0.0v 239.505n 0.0v 249.495n 0.0v 249.505n 1.7v 259.495n 1.7v 259.505n 1.7v 269.495n 1.7v 269.505n 1.7v 279.495n 1.7v 279.505n 0.0v 289.495n 0.0v 289.505n 0.0v 299.495n 0.0v 299.505n 0.0v 309.495n 0.0v 309.505n 0.0v 319.495n 0.0v 319.505n 0.0v 329.495n 0.0v 329.505n 0.0v 339.495n 0.0v 339.505n 0.0v 349.495n 0.0v 349.505n 0.0v 359.495n 0.0v 359.505n 0.0v 369.495n 0.0v 369.505n 0.0v 379.495n 0.0v 379.505n 0.0v 389.495n 0.0v 389.505n 0.0v 399.495n 0.0v 399.505n 0.0v 409.495n 0.0v 409.505n 0.0v 419.495n 0.0v 419.505n 0.0v 429.495n 0.0v 429.505n 0.0v 439.495n 0.0v 439.505n 0.0v 449.495n 0.0v 449.505n 1.7v 459.495n 1.7v 459.505n 0.0v 469.495n 0.0v 469.505n 0.0v 479.495n 0.0v 479.505n 1.7v 489.495n 1.7v 489.505n 1.7v 499.495n 1.7v 499.505n 0.0v 509.495n 0.0v 509.505n 0.0v 519.495n 0.0v 519.505n 0.0v 529.495n 0.0v 529.505n 0.0v 539.495n 0.0v 539.505n 0.0v 549.495n 0.0v 549.505n 0.0v 559.495n 0.0v 559.505n 0.0v 569.495n 0.0v 569.505n 0.0v 579.495n 0.0v 579.505n 0.0v 589.495n 0.0v 589.505n 0.0v 599.495n 0.0v 599.505n 0.0v 609.495n 0.0v 609.505n 0.0v 619.495n 0.0v 619.505n 0.0v 629.495n 0.0v 629.505n 0.0v 639.495n 0.0v 639.505n 0.0v 649.495n 0.0v 649.505n 0.0v 659.495n 0.0v 659.505n 0.0v 669.495n 0.0v 669.505n 0.0v 679.495n 0.0v 679.505n 0.0v 689.495n 0.0v 689.505n 0.0v 699.495n 0.0v 699.505n 0.0v 709.495n 0.0v 709.505n 0.0v 719.495n 0.0v 719.505n 0.0v 729.495n 0.0v 729.505n 0.0v 739.495n 0.0v 739.505n 0.0v 749.495n 0.0v 749.505n 0.0v 759.495n 0.0v 759.505n 0.0v 769.495n 0.0v 769.505n 0.0v 779.495n 0.0v 779.505n 0.0v 789.495n 0.0v 789.505n 0.0v 799.495n 0.0v 799.505n 0.0v 809.495n 0.0v 809.505n 0.0v 819.495n 0.0v 819.505n 0.0v 829.495n 0.0v 829.505n 0.0v 839.495n 0.0v 839.505n 0.0v 849.495n 0.0v 849.505n 0.0v 859.495n 0.0v 859.505n 0.0v 869.495n 0.0v 869.505n 0.0v 879.495n 0.0v 879.505n 0.0v 889.495n 0.0v 889.505n 0.0v 899.495n 0.0v 899.505n 0.0v 909.495n 0.0v 909.505n 0.0v 919.495n 0.0v 919.505n 0.0v 929.495n 0.0v 929.505n 0.0v 939.495n 0.0v 939.505n 0.0v 949.495n 0.0v 949.505n 0.0v 959.495n 0.0v 959.505n 0.0v 969.495n 0.0v 969.505n 0.0v 979.495n 0.0v 979.505n 0.0v 989.495n 0.0v 989.505n 0.0v 999.495n 0.0v 999.505n 0.0v 1009.495n 0.0v 1009.505n 0.0v 1019.495n 0.0v 1019.505n 0.0v 1029.495n 0.0v 1029.505n 0.0v 1039.495n 0.0v 1039.505n 0.0v 1049.495n 0.0v 1049.505n 0.0v 1059.495n 0.0v 1059.505n 0.0v 1069.495n 0.0v 1069.505n 0.0v 1079.495n 0.0v 1079.505n 0.0v 1089.495n 0.0v 1089.505n 0.0v 1099.495n 0.0v 1099.505n 0.0v 1109.495n 0.0v 1109.505n 0.0v 1119.495n 0.0v 1119.505n 0.0v 1129.495n 0.0v 1129.505n 0.0v 1139.495n 0.0v 1139.505n 0.0v 1149.495n 0.0v 1149.505n 0.0v 1159.495n 0.0v 1159.505n 0.0v 1169.495n 0.0v 1169.505n 0.0v 1179.495n 0.0v 1179.505n 0.0v 1189.495n 0.0v 1189.505n 0.0v 1199.495n 0.0v 1199.505n 0.0v 1209.495n 0.0v 1209.505n 0.0v 1219.495n 0.0v 1219.505n 0.0v 1229.495n 0.0v 1229.505n 0.0v 1239.495n 0.0v 1239.505n 0.0v 1249.495n 0.0v 1249.505n 0.0v 1259.495n 0.0v 1259.505n 0.0v 1269.495n 0.0v 1269.505n 0.0v 1279.495n 0.0v 1279.505n 0.0v 1289.495n 0.0v 1289.505n 0.0v 1299.495n 0.0v 1299.505n 0.0v 1309.495n 0.0v 1309.505n 0.0v 1319.495n 0.0v 1319.505n 0.0v 1329.495n 0.0v 1329.505n 0.0v 1339.495n 0.0v 1339.505n 0.0v 1349.495n 0.0v 1349.505n 0.0v 1359.495n 0.0v 1359.505n 0.0v 1369.495n 0.0v 1369.505n 0.0v 1379.495n 0.0v 1379.505n 0.0v 1389.495n 0.0v 1389.505n 0.0v 1399.495n 0.0v 1399.505n 0.0v 1409.495n 0.0v 1409.505n 0.0v 1419.495n 0.0v 1419.505n 0.0v 1429.495n 0.0v 1429.505n 0.0v 1439.495n 0.0v 1439.505n 0.0v 1449.495n 0.0v 1449.505n 1.7v 1459.495n 1.7v 1459.505n 1.7v 1469.495n 1.7v 1469.505n 0.0v 1479.495n 0.0v 1479.505n 0.0v 1489.495n 0.0v 1489.505n 0.0v 1499.495n 0.0v 1499.505n 0.0v 1509.495n 0.0v 1509.505n 0.0v 1519.495n 0.0v 1519.505n 0.0v 1529.495n 0.0v 1529.505n 0.0v 1539.495n 0.0v 1539.505n 0.0v 1549.495n 0.0v 1549.505n 0.0v 1559.495n 0.0v 1559.505n 0.0v 1569.495n 0.0v 1569.505n 0.0v 1579.495n 0.0v 1579.505n 1.7v 1589.495n 1.7v 1589.505n 1.7v 1599.495n 1.7v 1599.505n 1.7v 1609.495n 1.7v 1609.505n 0.0v 1619.495n 0.0v 1619.505n 0.0v 1629.495n 0.0v 1629.505n 0.0v 1639.495n 0.0v 1639.505n 1.7v 1649.495n 1.7v 1649.505n 0.0v 1659.495n 0.0v 1659.505n 0.0v 1669.495n 0.0v 1669.505n 0.0v 1679.495n 0.0v 1679.505n 0.0v 1689.495n 0.0v 1689.505n 0.0v 1699.495n 0.0v 1699.505n 0.0v 1709.495n 0.0v 1709.505n 0.0v 1719.495n 0.0v 1719.505n 0.0v 1729.495n 0.0v 1729.505n 0.0v 1739.495n 0.0v 1739.505n 0.0v 1749.495n 0.0v 1749.505n 0.0v 1759.495n 0.0v 1759.505n 0.0v 1769.495n 0.0v 1769.505n 0.0v 1779.495n 0.0v 1779.505n 0.0v 1789.495n 0.0v 1789.505n 0.0v 1799.495n 0.0v 1799.505n 0.0v 1809.495n 0.0v 1809.505n 0.0v 1819.495n 0.0v 1819.505n 1.7v 1829.495n 1.7v 1829.505n 1.7v 1839.495n 1.7v 1839.505n 1.7v 1849.495n 1.7v 1849.505n 0.0v 1859.495n 0.0v 1859.505n 0.0v 1869.495n 0.0v 1869.505n 0.0v 1879.495n 0.0v 1879.505n 0.0v 1889.495n 0.0v 1889.505n 0.0v 1899.495n 0.0v 1899.505n 0.0v 1909.495n 0.0v 1909.505n 0.0v 1919.495n 0.0v 1919.505n 0.0v 1929.495n 0.0v 1929.505n 0.0v 1939.495n 0.0v 1939.505n 0.0v 1949.495n 0.0v 1949.505n 0.0v 1959.495n 0.0v 1959.505n 0.0v 1969.495n 0.0v 1969.505n 0.0v 1979.495n 0.0v 1979.505n 0.0v 1989.495n 0.0v 1989.505n 0.0v 1999.495n 0.0v 1999.505n 0.0v 2009.495n 0.0v 2009.505n 0.0v 2019.495n 0.0v 2019.505n 0.0v 2029.495n 0.0v 2029.505n 0.0v 2039.495n 0.0v 2039.505n 0.0v 2049.495n 0.0v 2049.505n 0.0v )
* (time, data): [(0, 0), (10, 0), (20, 0), (30, 1), (40, 1), (50, 1), (60, 1), (70, 0), (80, 0), (90, 0), (100, 0), (110, 0), (120, 0), (130, 0), (140, 0), (150, 0), (160, 0), (170, 0), (180, 0), (190, 1), (200, 1), (210, 0), (220, 0), (230, 0), (240, 0), (250, 1), (260, 1), (270, 1), (280, 0), (290, 0), (300, 0), (310, 0), (320, 0), (330, 0), (340, 0), (350, 0), (360, 0), (370, 0), (380, 0), (390, 0), (400, 0), (410, 0), (420, 0), (430, 0), (440, 0), (450, 1), (460, 0), (470, 0), (480, 1), (490, 1), (500, 0), (510, 0), (520, 0), (530, 0), (540, 0), (550, 0), (560, 0), (570, 0), (580, 0), (590, 0), (600, 0), (610, 0), (620, 0), (630, 0), (640, 0), (650, 0), (660, 0), (670, 0), (680, 0), (690, 0), (700, 0), (710, 0), (720, 0), (730, 0), (740, 0), (750, 0), (760, 0), (770, 0), (780, 0), (790, 0), (800, 0), (810, 0), (820, 0), (830, 0), (840, 0), (850, 0), (860, 0), (870, 0), (880, 0), (890, 0), (900, 0), (910, 0), (920, 0), (930, 0), (940, 0), (950, 0), (960, 0), (970, 0), (980, 0), (990, 0), (1000, 0), (1010, 0), (1020, 0), (1030, 0), (1040, 0), (1050, 0), (1060, 0), (1070, 0), (1080, 0), (1090, 0), (1100, 0), (1110, 0), (1120, 0), (1130, 0), (1140, 0), (1150, 0), (1160, 0), (1170, 0), (1180, 0), (1190, 0), (1200, 0), (1210, 0), (1220, 0), (1230, 0), (1240, 0), (1250, 0), (1260, 0), (1270, 0), (1280, 0), (1290, 0), (1300, 0), (1310, 0), (1320, 0), (1330, 0), (1340, 0), (1350, 0), (1360, 0), (1370, 0), (1380, 0), (1390, 0), (1400, 0), (1410, 0), (1420, 0), (1430, 0), (1440, 0), (1450, 1), (1460, 1), (1470, 0), (1480, 0), (1490, 0), (1500, 0), (1510, 0), (1520, 0), (1530, 0), (1540, 0), (1550, 0), (1560, 0), (1570, 0), (1580, 1), (1590, 1), (1600, 1), (1610, 0), (1620, 0), (1630, 0), (1640, 1), (1650, 0), (1660, 0), (1670, 0), (1680, 0), (1690, 0), (1700, 0), (1710, 0), (1720, 0), (1730, 0), (1740, 0), (1750, 0), (1760, 0), (1770, 0), (1780, 0), (1790, 0), (1800, 0), (1810, 0), (1820, 1), (1830, 1), (1840, 1), (1850, 0), (1860, 0), (1870, 0), (1880, 0), (1890, 0), (1900, 0), (1910, 0), (1920, 0), (1930, 0), (1940, 0), (1950, 0), (1960, 0), (1970, 0), (1980, 0), (1990, 0), (2000, 0), (2010, 0), (2020, 0), (2030, 0), (2040, 0), (2050, 0)]
Va0_3  a0_3  0 PWL (0n 0.0v 9.495n 0.0v 9.505n 0.0v 19.495n 0.0v 19.505n 0.0v 29.495n 0.0v 29.505n 1.7v 39.495n 1.7v 39.505n 1.7v 49.495n 1.7v 49.505n 1.7v 59.495n 1.7v 59.505n 1.7v 69.495n 1.7v 69.505n 0.0v 79.495n 0.0v 79.505n 0.0v 89.495n 0.0v 89.505n 0.0v 99.495n 0.0v 99.505n 0.0v 109.495n 0.0v 109.505n 0.0v 119.495n 0.0v 119.505n 0.0v 129.495n 0.0v 129.505n 0.0v 139.495n 0.0v 139.505n 0.0v 149.495n 0.0v 149.505n 0.0v 159.495n 0.0v 159.505n 0.0v 169.495n 0.0v 169.505n 0.0v 179.495n 0.0v 179.505n 0.0v 189.495n 0.0v 189.505n 1.7v 199.495n 1.7v 199.505n 1.7v 209.495n 1.7v 209.505n 0.0v 219.495n 0.0v 219.505n 0.0v 229.495n 0.0v 229.505n 0.0v 239.495n 0.0v 239.505n 0.0v 249.495n 0.0v 249.505n 1.7v 259.495n 1.7v 259.505n 1.7v 269.495n 1.7v 269.505n 1.7v 279.495n 1.7v 279.505n 0.0v 289.495n 0.0v 289.505n 0.0v 299.495n 0.0v 299.505n 0.0v 309.495n 0.0v 309.505n 0.0v 319.495n 0.0v 319.505n 0.0v 329.495n 0.0v 329.505n 0.0v 339.495n 0.0v 339.505n 0.0v 349.495n 0.0v 349.505n 0.0v 359.495n 0.0v 359.505n 0.0v 369.495n 0.0v 369.505n 0.0v 379.495n 0.0v 379.505n 0.0v 389.495n 0.0v 389.505n 0.0v 399.495n 0.0v 399.505n 0.0v 409.495n 0.0v 409.505n 0.0v 419.495n 0.0v 419.505n 0.0v 429.495n 0.0v 429.505n 0.0v 439.495n 0.0v 439.505n 0.0v 449.495n 0.0v 449.505n 1.7v 459.495n 1.7v 459.505n 0.0v 469.495n 0.0v 469.505n 0.0v 479.495n 0.0v 479.505n 1.7v 489.495n 1.7v 489.505n 1.7v 499.495n 1.7v 499.505n 0.0v 509.495n 0.0v 509.505n 0.0v 519.495n 0.0v 519.505n 0.0v 529.495n 0.0v 529.505n 0.0v 539.495n 0.0v 539.505n 0.0v 549.495n 0.0v 549.505n 0.0v 559.495n 0.0v 559.505n 0.0v 569.495n 0.0v 569.505n 0.0v 579.495n 0.0v 579.505n 0.0v 589.495n 0.0v 589.505n 0.0v 599.495n 0.0v 599.505n 0.0v 609.495n 0.0v 609.505n 0.0v 619.495n 0.0v 619.505n 0.0v 629.495n 0.0v 629.505n 0.0v 639.495n 0.0v 639.505n 0.0v 649.495n 0.0v 649.505n 0.0v 659.495n 0.0v 659.505n 0.0v 669.495n 0.0v 669.505n 0.0v 679.495n 0.0v 679.505n 0.0v 689.495n 0.0v 689.505n 0.0v 699.495n 0.0v 699.505n 0.0v 709.495n 0.0v 709.505n 0.0v 719.495n 0.0v 719.505n 0.0v 729.495n 0.0v 729.505n 0.0v 739.495n 0.0v 739.505n 0.0v 749.495n 0.0v 749.505n 0.0v 759.495n 0.0v 759.505n 0.0v 769.495n 0.0v 769.505n 0.0v 779.495n 0.0v 779.505n 0.0v 789.495n 0.0v 789.505n 0.0v 799.495n 0.0v 799.505n 0.0v 809.495n 0.0v 809.505n 0.0v 819.495n 0.0v 819.505n 0.0v 829.495n 0.0v 829.505n 0.0v 839.495n 0.0v 839.505n 0.0v 849.495n 0.0v 849.505n 0.0v 859.495n 0.0v 859.505n 0.0v 869.495n 0.0v 869.505n 0.0v 879.495n 0.0v 879.505n 0.0v 889.495n 0.0v 889.505n 0.0v 899.495n 0.0v 899.505n 0.0v 909.495n 0.0v 909.505n 0.0v 919.495n 0.0v 919.505n 0.0v 929.495n 0.0v 929.505n 0.0v 939.495n 0.0v 939.505n 0.0v 949.495n 0.0v 949.505n 0.0v 959.495n 0.0v 959.505n 0.0v 969.495n 0.0v 969.505n 0.0v 979.495n 0.0v 979.505n 0.0v 989.495n 0.0v 989.505n 0.0v 999.495n 0.0v 999.505n 0.0v 1009.495n 0.0v 1009.505n 0.0v 1019.495n 0.0v 1019.505n 0.0v 1029.495n 0.0v 1029.505n 0.0v 1039.495n 0.0v 1039.505n 0.0v 1049.495n 0.0v 1049.505n 0.0v 1059.495n 0.0v 1059.505n 0.0v 1069.495n 0.0v 1069.505n 0.0v 1079.495n 0.0v 1079.505n 0.0v 1089.495n 0.0v 1089.505n 0.0v 1099.495n 0.0v 1099.505n 0.0v 1109.495n 0.0v 1109.505n 0.0v 1119.495n 0.0v 1119.505n 0.0v 1129.495n 0.0v 1129.505n 0.0v 1139.495n 0.0v 1139.505n 0.0v 1149.495n 0.0v 1149.505n 0.0v 1159.495n 0.0v 1159.505n 0.0v 1169.495n 0.0v 1169.505n 0.0v 1179.495n 0.0v 1179.505n 0.0v 1189.495n 0.0v 1189.505n 0.0v 1199.495n 0.0v 1199.505n 0.0v 1209.495n 0.0v 1209.505n 0.0v 1219.495n 0.0v 1219.505n 0.0v 1229.495n 0.0v 1229.505n 0.0v 1239.495n 0.0v 1239.505n 0.0v 1249.495n 0.0v 1249.505n 0.0v 1259.495n 0.0v 1259.505n 0.0v 1269.495n 0.0v 1269.505n 0.0v 1279.495n 0.0v 1279.505n 0.0v 1289.495n 0.0v 1289.505n 0.0v 1299.495n 0.0v 1299.505n 0.0v 1309.495n 0.0v 1309.505n 0.0v 1319.495n 0.0v 1319.505n 0.0v 1329.495n 0.0v 1329.505n 0.0v 1339.495n 0.0v 1339.505n 0.0v 1349.495n 0.0v 1349.505n 0.0v 1359.495n 0.0v 1359.505n 0.0v 1369.495n 0.0v 1369.505n 0.0v 1379.495n 0.0v 1379.505n 0.0v 1389.495n 0.0v 1389.505n 0.0v 1399.495n 0.0v 1399.505n 0.0v 1409.495n 0.0v 1409.505n 0.0v 1419.495n 0.0v 1419.505n 0.0v 1429.495n 0.0v 1429.505n 0.0v 1439.495n 0.0v 1439.505n 0.0v 1449.495n 0.0v 1449.505n 1.7v 1459.495n 1.7v 1459.505n 1.7v 1469.495n 1.7v 1469.505n 0.0v 1479.495n 0.0v 1479.505n 0.0v 1489.495n 0.0v 1489.505n 0.0v 1499.495n 0.0v 1499.505n 0.0v 1509.495n 0.0v 1509.505n 0.0v 1519.495n 0.0v 1519.505n 0.0v 1529.495n 0.0v 1529.505n 0.0v 1539.495n 0.0v 1539.505n 0.0v 1549.495n 0.0v 1549.505n 0.0v 1559.495n 0.0v 1559.505n 0.0v 1569.495n 0.0v 1569.505n 0.0v 1579.495n 0.0v 1579.505n 1.7v 1589.495n 1.7v 1589.505n 1.7v 1599.495n 1.7v 1599.505n 1.7v 1609.495n 1.7v 1609.505n 0.0v 1619.495n 0.0v 1619.505n 0.0v 1629.495n 0.0v 1629.505n 0.0v 1639.495n 0.0v 1639.505n 1.7v 1649.495n 1.7v 1649.505n 0.0v 1659.495n 0.0v 1659.505n 0.0v 1669.495n 0.0v 1669.505n 0.0v 1679.495n 0.0v 1679.505n 0.0v 1689.495n 0.0v 1689.505n 0.0v 1699.495n 0.0v 1699.505n 0.0v 1709.495n 0.0v 1709.505n 0.0v 1719.495n 0.0v 1719.505n 0.0v 1729.495n 0.0v 1729.505n 0.0v 1739.495n 0.0v 1739.505n 0.0v 1749.495n 0.0v 1749.505n 0.0v 1759.495n 0.0v 1759.505n 0.0v 1769.495n 0.0v 1769.505n 0.0v 1779.495n 0.0v 1779.505n 0.0v 1789.495n 0.0v 1789.505n 0.0v 1799.495n 0.0v 1799.505n 0.0v 1809.495n 0.0v 1809.505n 0.0v 1819.495n 0.0v 1819.505n 1.7v 1829.495n 1.7v 1829.505n 1.7v 1839.495n 1.7v 1839.505n 1.7v 1849.495n 1.7v 1849.505n 0.0v 1859.495n 0.0v 1859.505n 0.0v 1869.495n 0.0v 1869.505n 0.0v 1879.495n 0.0v 1879.505n 0.0v 1889.495n 0.0v 1889.505n 0.0v 1899.495n 0.0v 1899.505n 0.0v 1909.495n 0.0v 1909.505n 0.0v 1919.495n 0.0v 1919.505n 0.0v 1929.495n 0.0v 1929.505n 0.0v 1939.495n 0.0v 1939.505n 0.0v 1949.495n 0.0v 1949.505n 0.0v 1959.495n 0.0v 1959.505n 0.0v 1969.495n 0.0v 1969.505n 0.0v 1979.495n 0.0v 1979.505n 0.0v 1989.495n 0.0v 1989.505n 0.0v 1999.495n 0.0v 1999.505n 0.0v 2009.495n 0.0v 2009.505n 0.0v 2019.495n 0.0v 2019.505n 0.0v 2029.495n 0.0v 2029.505n 0.0v 2039.495n 0.0v 2039.505n 0.0v 2049.495n 0.0v 2049.505n 0.0v )
* (time, data): [(0, 0), (10, 0), (20, 0), (30, 1), (40, 1), (50, 1), (60, 1), (70, 0), (80, 0), (90, 0), (100, 0), (110, 0), (120, 0), (130, 0), (140, 0), (150, 0), (160, 0), (170, 0), (180, 0), (190, 1), (200, 1), (210, 0), (220, 0), (230, 0), (240, 0), (250, 1), (260, 1), (270, 1), (280, 0), (290, 0), (300, 0), (310, 0), (320, 0), (330, 0), (340, 0), (350, 0), (360, 0), (370, 0), (380, 0), (390, 0), (400, 0), (410, 0), (420, 0), (430, 0), (440, 0), (450, 1), (460, 0), (470, 0), (480, 1), (490, 1), (500, 0), (510, 0), (520, 0), (530, 0), (540, 0), (550, 0), (560, 0), (570, 0), (580, 0), (590, 0), (600, 0), (610, 0), (620, 0), (630, 0), (640, 0), (650, 0), (660, 0), (670, 0), (680, 0), (690, 0), (700, 0), (710, 0), (720, 0), (730, 0), (740, 0), (750, 0), (760, 0), (770, 0), (780, 0), (790, 0), (800, 0), (810, 0), (820, 0), (830, 0), (840, 0), (850, 0), (860, 0), (870, 0), (880, 0), (890, 0), (900, 0), (910, 0), (920, 0), (930, 0), (940, 0), (950, 0), (960, 0), (970, 0), (980, 0), (990, 0), (1000, 0), (1010, 0), (1020, 0), (1030, 0), (1040, 0), (1050, 0), (1060, 0), (1070, 0), (1080, 0), (1090, 0), (1100, 0), (1110, 0), (1120, 0), (1130, 0), (1140, 0), (1150, 0), (1160, 0), (1170, 0), (1180, 0), (1190, 0), (1200, 0), (1210, 0), (1220, 0), (1230, 0), (1240, 0), (1250, 0), (1260, 0), (1270, 0), (1280, 0), (1290, 0), (1300, 0), (1310, 0), (1320, 0), (1330, 0), (1340, 0), (1350, 0), (1360, 0), (1370, 0), (1380, 0), (1390, 0), (1400, 0), (1410, 0), (1420, 0), (1430, 0), (1440, 0), (1450, 1), (1460, 1), (1470, 0), (1480, 0), (1490, 0), (1500, 0), (1510, 0), (1520, 0), (1530, 0), (1540, 0), (1550, 0), (1560, 0), (1570, 0), (1580, 1), (1590, 1), (1600, 1), (1610, 0), (1620, 0), (1630, 0), (1640, 1), (1650, 0), (1660, 0), (1670, 0), (1680, 0), (1690, 0), (1700, 0), (1710, 0), (1720, 0), (1730, 0), (1740, 0), (1750, 0), (1760, 0), (1770, 0), (1780, 0), (1790, 0), (1800, 0), (1810, 0), (1820, 1), (1830, 1), (1840, 1), (1850, 0), (1860, 0), (1870, 0), (1880, 0), (1890, 0), (1900, 0), (1910, 0), (1920, 0), (1930, 0), (1940, 0), (1950, 0), (1960, 0), (1970, 0), (1980, 0), (1990, 0), (2000, 0), (2010, 0), (2020, 0), (2030, 0), (2040, 0), (2050, 0)]
Va0_4  a0_4  0 PWL (0n 0.0v 9.495n 0.0v 9.505n 0.0v 19.495n 0.0v 19.505n 0.0v 29.495n 0.0v 29.505n 1.7v 39.495n 1.7v 39.505n 1.7v 49.495n 1.7v 49.505n 1.7v 59.495n 1.7v 59.505n 1.7v 69.495n 1.7v 69.505n 0.0v 79.495n 0.0v 79.505n 0.0v 89.495n 0.0v 89.505n 0.0v 99.495n 0.0v 99.505n 0.0v 109.495n 0.0v 109.505n 0.0v 119.495n 0.0v 119.505n 0.0v 129.495n 0.0v 129.505n 0.0v 139.495n 0.0v 139.505n 0.0v 149.495n 0.0v 149.505n 0.0v 159.495n 0.0v 159.505n 0.0v 169.495n 0.0v 169.505n 0.0v 179.495n 0.0v 179.505n 0.0v 189.495n 0.0v 189.505n 1.7v 199.495n 1.7v 199.505n 1.7v 209.495n 1.7v 209.505n 0.0v 219.495n 0.0v 219.505n 0.0v 229.495n 0.0v 229.505n 0.0v 239.495n 0.0v 239.505n 0.0v 249.495n 0.0v 249.505n 1.7v 259.495n 1.7v 259.505n 1.7v 269.495n 1.7v 269.505n 1.7v 279.495n 1.7v 279.505n 0.0v 289.495n 0.0v 289.505n 0.0v 299.495n 0.0v 299.505n 0.0v 309.495n 0.0v 309.505n 0.0v 319.495n 0.0v 319.505n 0.0v 329.495n 0.0v 329.505n 0.0v 339.495n 0.0v 339.505n 0.0v 349.495n 0.0v 349.505n 0.0v 359.495n 0.0v 359.505n 0.0v 369.495n 0.0v 369.505n 0.0v 379.495n 0.0v 379.505n 0.0v 389.495n 0.0v 389.505n 0.0v 399.495n 0.0v 399.505n 0.0v 409.495n 0.0v 409.505n 0.0v 419.495n 0.0v 419.505n 0.0v 429.495n 0.0v 429.505n 0.0v 439.495n 0.0v 439.505n 0.0v 449.495n 0.0v 449.505n 1.7v 459.495n 1.7v 459.505n 0.0v 469.495n 0.0v 469.505n 0.0v 479.495n 0.0v 479.505n 1.7v 489.495n 1.7v 489.505n 1.7v 499.495n 1.7v 499.505n 0.0v 509.495n 0.0v 509.505n 0.0v 519.495n 0.0v 519.505n 0.0v 529.495n 0.0v 529.505n 0.0v 539.495n 0.0v 539.505n 0.0v 549.495n 0.0v 549.505n 0.0v 559.495n 0.0v 559.505n 0.0v 569.495n 0.0v 569.505n 0.0v 579.495n 0.0v 579.505n 0.0v 589.495n 0.0v 589.505n 0.0v 599.495n 0.0v 599.505n 0.0v 609.495n 0.0v 609.505n 0.0v 619.495n 0.0v 619.505n 0.0v 629.495n 0.0v 629.505n 0.0v 639.495n 0.0v 639.505n 0.0v 649.495n 0.0v 649.505n 0.0v 659.495n 0.0v 659.505n 0.0v 669.495n 0.0v 669.505n 0.0v 679.495n 0.0v 679.505n 0.0v 689.495n 0.0v 689.505n 0.0v 699.495n 0.0v 699.505n 0.0v 709.495n 0.0v 709.505n 0.0v 719.495n 0.0v 719.505n 0.0v 729.495n 0.0v 729.505n 0.0v 739.495n 0.0v 739.505n 0.0v 749.495n 0.0v 749.505n 0.0v 759.495n 0.0v 759.505n 0.0v 769.495n 0.0v 769.505n 0.0v 779.495n 0.0v 779.505n 0.0v 789.495n 0.0v 789.505n 0.0v 799.495n 0.0v 799.505n 0.0v 809.495n 0.0v 809.505n 0.0v 819.495n 0.0v 819.505n 0.0v 829.495n 0.0v 829.505n 0.0v 839.495n 0.0v 839.505n 0.0v 849.495n 0.0v 849.505n 0.0v 859.495n 0.0v 859.505n 0.0v 869.495n 0.0v 869.505n 0.0v 879.495n 0.0v 879.505n 0.0v 889.495n 0.0v 889.505n 0.0v 899.495n 0.0v 899.505n 0.0v 909.495n 0.0v 909.505n 0.0v 919.495n 0.0v 919.505n 0.0v 929.495n 0.0v 929.505n 0.0v 939.495n 0.0v 939.505n 0.0v 949.495n 0.0v 949.505n 0.0v 959.495n 0.0v 959.505n 0.0v 969.495n 0.0v 969.505n 0.0v 979.495n 0.0v 979.505n 0.0v 989.495n 0.0v 989.505n 0.0v 999.495n 0.0v 999.505n 0.0v 1009.495n 0.0v 1009.505n 0.0v 1019.495n 0.0v 1019.505n 0.0v 1029.495n 0.0v 1029.505n 0.0v 1039.495n 0.0v 1039.505n 0.0v 1049.495n 0.0v 1049.505n 0.0v 1059.495n 0.0v 1059.505n 0.0v 1069.495n 0.0v 1069.505n 0.0v 1079.495n 0.0v 1079.505n 0.0v 1089.495n 0.0v 1089.505n 0.0v 1099.495n 0.0v 1099.505n 0.0v 1109.495n 0.0v 1109.505n 0.0v 1119.495n 0.0v 1119.505n 0.0v 1129.495n 0.0v 1129.505n 0.0v 1139.495n 0.0v 1139.505n 0.0v 1149.495n 0.0v 1149.505n 0.0v 1159.495n 0.0v 1159.505n 0.0v 1169.495n 0.0v 1169.505n 0.0v 1179.495n 0.0v 1179.505n 0.0v 1189.495n 0.0v 1189.505n 0.0v 1199.495n 0.0v 1199.505n 0.0v 1209.495n 0.0v 1209.505n 0.0v 1219.495n 0.0v 1219.505n 0.0v 1229.495n 0.0v 1229.505n 0.0v 1239.495n 0.0v 1239.505n 0.0v 1249.495n 0.0v 1249.505n 0.0v 1259.495n 0.0v 1259.505n 0.0v 1269.495n 0.0v 1269.505n 0.0v 1279.495n 0.0v 1279.505n 0.0v 1289.495n 0.0v 1289.505n 0.0v 1299.495n 0.0v 1299.505n 0.0v 1309.495n 0.0v 1309.505n 0.0v 1319.495n 0.0v 1319.505n 0.0v 1329.495n 0.0v 1329.505n 0.0v 1339.495n 0.0v 1339.505n 0.0v 1349.495n 0.0v 1349.505n 0.0v 1359.495n 0.0v 1359.505n 0.0v 1369.495n 0.0v 1369.505n 0.0v 1379.495n 0.0v 1379.505n 0.0v 1389.495n 0.0v 1389.505n 0.0v 1399.495n 0.0v 1399.505n 0.0v 1409.495n 0.0v 1409.505n 0.0v 1419.495n 0.0v 1419.505n 0.0v 1429.495n 0.0v 1429.505n 0.0v 1439.495n 0.0v 1439.505n 0.0v 1449.495n 0.0v 1449.505n 1.7v 1459.495n 1.7v 1459.505n 1.7v 1469.495n 1.7v 1469.505n 0.0v 1479.495n 0.0v 1479.505n 0.0v 1489.495n 0.0v 1489.505n 0.0v 1499.495n 0.0v 1499.505n 0.0v 1509.495n 0.0v 1509.505n 0.0v 1519.495n 0.0v 1519.505n 0.0v 1529.495n 0.0v 1529.505n 0.0v 1539.495n 0.0v 1539.505n 0.0v 1549.495n 0.0v 1549.505n 0.0v 1559.495n 0.0v 1559.505n 0.0v 1569.495n 0.0v 1569.505n 0.0v 1579.495n 0.0v 1579.505n 1.7v 1589.495n 1.7v 1589.505n 1.7v 1599.495n 1.7v 1599.505n 1.7v 1609.495n 1.7v 1609.505n 0.0v 1619.495n 0.0v 1619.505n 0.0v 1629.495n 0.0v 1629.505n 0.0v 1639.495n 0.0v 1639.505n 1.7v 1649.495n 1.7v 1649.505n 0.0v 1659.495n 0.0v 1659.505n 0.0v 1669.495n 0.0v 1669.505n 0.0v 1679.495n 0.0v 1679.505n 0.0v 1689.495n 0.0v 1689.505n 0.0v 1699.495n 0.0v 1699.505n 0.0v 1709.495n 0.0v 1709.505n 0.0v 1719.495n 0.0v 1719.505n 0.0v 1729.495n 0.0v 1729.505n 0.0v 1739.495n 0.0v 1739.505n 0.0v 1749.495n 0.0v 1749.505n 0.0v 1759.495n 0.0v 1759.505n 0.0v 1769.495n 0.0v 1769.505n 0.0v 1779.495n 0.0v 1779.505n 0.0v 1789.495n 0.0v 1789.505n 0.0v 1799.495n 0.0v 1799.505n 0.0v 1809.495n 0.0v 1809.505n 0.0v 1819.495n 0.0v 1819.505n 1.7v 1829.495n 1.7v 1829.505n 1.7v 1839.495n 1.7v 1839.505n 1.7v 1849.495n 1.7v 1849.505n 0.0v 1859.495n 0.0v 1859.505n 0.0v 1869.495n 0.0v 1869.505n 0.0v 1879.495n 0.0v 1879.505n 0.0v 1889.495n 0.0v 1889.505n 0.0v 1899.495n 0.0v 1899.505n 0.0v 1909.495n 0.0v 1909.505n 0.0v 1919.495n 0.0v 1919.505n 0.0v 1929.495n 0.0v 1929.505n 0.0v 1939.495n 0.0v 1939.505n 0.0v 1949.495n 0.0v 1949.505n 0.0v 1959.495n 0.0v 1959.505n 0.0v 1969.495n 0.0v 1969.505n 0.0v 1979.495n 0.0v 1979.505n 0.0v 1989.495n 0.0v 1989.505n 0.0v 1999.495n 0.0v 1999.505n 0.0v 2009.495n 0.0v 2009.505n 0.0v 2019.495n 0.0v 2019.505n 0.0v 2029.495n 0.0v 2029.505n 0.0v 2039.495n 0.0v 2039.505n 0.0v 2049.495n 0.0v 2049.505n 0.0v )
* (time, data): [(0, 0), (10, 0), (20, 0), (30, 1), (40, 1), (50, 1), (60, 1), (70, 0), (80, 0), (90, 0), (100, 0), (110, 0), (120, 0), (130, 0), (140, 0), (150, 0), (160, 0), (170, 0), (180, 0), (190, 1), (200, 1), (210, 0), (220, 0), (230, 0), (240, 0), (250, 1), (260, 1), (270, 1), (280, 0), (290, 0), (300, 0), (310, 0), (320, 0), (330, 0), (340, 0), (350, 0), (360, 0), (370, 0), (380, 0), (390, 0), (400, 0), (410, 0), (420, 0), (430, 0), (440, 0), (450, 1), (460, 0), (470, 0), (480, 1), (490, 1), (500, 0), (510, 0), (520, 0), (530, 0), (540, 0), (550, 0), (560, 0), (570, 0), (580, 0), (590, 0), (600, 0), (610, 0), (620, 0), (630, 0), (640, 0), (650, 0), (660, 0), (670, 0), (680, 0), (690, 0), (700, 0), (710, 0), (720, 0), (730, 0), (740, 0), (750, 0), (760, 0), (770, 0), (780, 0), (790, 0), (800, 0), (810, 0), (820, 0), (830, 0), (840, 0), (850, 0), (860, 0), (870, 0), (880, 0), (890, 0), (900, 0), (910, 0), (920, 0), (930, 0), (940, 0), (950, 0), (960, 0), (970, 0), (980, 0), (990, 0), (1000, 0), (1010, 0), (1020, 0), (1030, 0), (1040, 0), (1050, 0), (1060, 0), (1070, 0), (1080, 0), (1090, 0), (1100, 0), (1110, 0), (1120, 0), (1130, 0), (1140, 0), (1150, 0), (1160, 0), (1170, 0), (1180, 0), (1190, 0), (1200, 0), (1210, 0), (1220, 0), (1230, 0), (1240, 0), (1250, 0), (1260, 0), (1270, 0), (1280, 0), (1290, 0), (1300, 0), (1310, 0), (1320, 0), (1330, 0), (1340, 0), (1350, 0), (1360, 0), (1370, 0), (1380, 0), (1390, 0), (1400, 0), (1410, 0), (1420, 0), (1430, 0), (1440, 0), (1450, 1), (1460, 1), (1470, 0), (1480, 0), (1490, 0), (1500, 0), (1510, 0), (1520, 0), (1530, 0), (1540, 0), (1550, 0), (1560, 0), (1570, 0), (1580, 1), (1590, 1), (1600, 1), (1610, 0), (1620, 0), (1630, 0), (1640, 1), (1650, 0), (1660, 0), (1670, 0), (1680, 0), (1690, 0), (1700, 0), (1710, 0), (1720, 0), (1730, 0), (1740, 0), (1750, 0), (1760, 0), (1770, 0), (1780, 0), (1790, 0), (1800, 0), (1810, 0), (1820, 1), (1830, 1), (1840, 1), (1850, 0), (1860, 0), (1870, 0), (1880, 0), (1890, 0), (1900, 0), (1910, 0), (1920, 0), (1930, 0), (1940, 0), (1950, 0), (1960, 0), (1970, 0), (1980, 0), (1990, 0), (2000, 0), (2010, 0), (2020, 0), (2030, 0), (2040, 0), (2050, 0)]
Va0_5  a0_5  0 PWL (0n 0.0v 9.495n 0.0v 9.505n 0.0v 19.495n 0.0v 19.505n 0.0v 29.495n 0.0v 29.505n 1.7v 39.495n 1.7v 39.505n 1.7v 49.495n 1.7v 49.505n 1.7v 59.495n 1.7v 59.505n 1.7v 69.495n 1.7v 69.505n 0.0v 79.495n 0.0v 79.505n 0.0v 89.495n 0.0v 89.505n 0.0v 99.495n 0.0v 99.505n 0.0v 109.495n 0.0v 109.505n 0.0v 119.495n 0.0v 119.505n 0.0v 129.495n 0.0v 129.505n 0.0v 139.495n 0.0v 139.505n 0.0v 149.495n 0.0v 149.505n 0.0v 159.495n 0.0v 159.505n 0.0v 169.495n 0.0v 169.505n 0.0v 179.495n 0.0v 179.505n 0.0v 189.495n 0.0v 189.505n 1.7v 199.495n 1.7v 199.505n 1.7v 209.495n 1.7v 209.505n 0.0v 219.495n 0.0v 219.505n 0.0v 229.495n 0.0v 229.505n 0.0v 239.495n 0.0v 239.505n 0.0v 249.495n 0.0v 249.505n 1.7v 259.495n 1.7v 259.505n 1.7v 269.495n 1.7v 269.505n 1.7v 279.495n 1.7v 279.505n 0.0v 289.495n 0.0v 289.505n 0.0v 299.495n 0.0v 299.505n 0.0v 309.495n 0.0v 309.505n 0.0v 319.495n 0.0v 319.505n 0.0v 329.495n 0.0v 329.505n 0.0v 339.495n 0.0v 339.505n 0.0v 349.495n 0.0v 349.505n 0.0v 359.495n 0.0v 359.505n 0.0v 369.495n 0.0v 369.505n 0.0v 379.495n 0.0v 379.505n 0.0v 389.495n 0.0v 389.505n 0.0v 399.495n 0.0v 399.505n 0.0v 409.495n 0.0v 409.505n 0.0v 419.495n 0.0v 419.505n 0.0v 429.495n 0.0v 429.505n 0.0v 439.495n 0.0v 439.505n 0.0v 449.495n 0.0v 449.505n 1.7v 459.495n 1.7v 459.505n 0.0v 469.495n 0.0v 469.505n 0.0v 479.495n 0.0v 479.505n 1.7v 489.495n 1.7v 489.505n 1.7v 499.495n 1.7v 499.505n 0.0v 509.495n 0.0v 509.505n 0.0v 519.495n 0.0v 519.505n 0.0v 529.495n 0.0v 529.505n 0.0v 539.495n 0.0v 539.505n 0.0v 549.495n 0.0v 549.505n 0.0v 559.495n 0.0v 559.505n 0.0v 569.495n 0.0v 569.505n 0.0v 579.495n 0.0v 579.505n 0.0v 589.495n 0.0v 589.505n 0.0v 599.495n 0.0v 599.505n 0.0v 609.495n 0.0v 609.505n 0.0v 619.495n 0.0v 619.505n 0.0v 629.495n 0.0v 629.505n 0.0v 639.495n 0.0v 639.505n 0.0v 649.495n 0.0v 649.505n 0.0v 659.495n 0.0v 659.505n 0.0v 669.495n 0.0v 669.505n 0.0v 679.495n 0.0v 679.505n 0.0v 689.495n 0.0v 689.505n 0.0v 699.495n 0.0v 699.505n 0.0v 709.495n 0.0v 709.505n 0.0v 719.495n 0.0v 719.505n 0.0v 729.495n 0.0v 729.505n 0.0v 739.495n 0.0v 739.505n 0.0v 749.495n 0.0v 749.505n 0.0v 759.495n 0.0v 759.505n 0.0v 769.495n 0.0v 769.505n 0.0v 779.495n 0.0v 779.505n 0.0v 789.495n 0.0v 789.505n 0.0v 799.495n 0.0v 799.505n 0.0v 809.495n 0.0v 809.505n 0.0v 819.495n 0.0v 819.505n 0.0v 829.495n 0.0v 829.505n 0.0v 839.495n 0.0v 839.505n 0.0v 849.495n 0.0v 849.505n 0.0v 859.495n 0.0v 859.505n 0.0v 869.495n 0.0v 869.505n 0.0v 879.495n 0.0v 879.505n 0.0v 889.495n 0.0v 889.505n 0.0v 899.495n 0.0v 899.505n 0.0v 909.495n 0.0v 909.505n 0.0v 919.495n 0.0v 919.505n 0.0v 929.495n 0.0v 929.505n 0.0v 939.495n 0.0v 939.505n 0.0v 949.495n 0.0v 949.505n 0.0v 959.495n 0.0v 959.505n 0.0v 969.495n 0.0v 969.505n 0.0v 979.495n 0.0v 979.505n 0.0v 989.495n 0.0v 989.505n 0.0v 999.495n 0.0v 999.505n 0.0v 1009.495n 0.0v 1009.505n 0.0v 1019.495n 0.0v 1019.505n 0.0v 1029.495n 0.0v 1029.505n 0.0v 1039.495n 0.0v 1039.505n 0.0v 1049.495n 0.0v 1049.505n 0.0v 1059.495n 0.0v 1059.505n 0.0v 1069.495n 0.0v 1069.505n 0.0v 1079.495n 0.0v 1079.505n 0.0v 1089.495n 0.0v 1089.505n 0.0v 1099.495n 0.0v 1099.505n 0.0v 1109.495n 0.0v 1109.505n 0.0v 1119.495n 0.0v 1119.505n 0.0v 1129.495n 0.0v 1129.505n 0.0v 1139.495n 0.0v 1139.505n 0.0v 1149.495n 0.0v 1149.505n 0.0v 1159.495n 0.0v 1159.505n 0.0v 1169.495n 0.0v 1169.505n 0.0v 1179.495n 0.0v 1179.505n 0.0v 1189.495n 0.0v 1189.505n 0.0v 1199.495n 0.0v 1199.505n 0.0v 1209.495n 0.0v 1209.505n 0.0v 1219.495n 0.0v 1219.505n 0.0v 1229.495n 0.0v 1229.505n 0.0v 1239.495n 0.0v 1239.505n 0.0v 1249.495n 0.0v 1249.505n 0.0v 1259.495n 0.0v 1259.505n 0.0v 1269.495n 0.0v 1269.505n 0.0v 1279.495n 0.0v 1279.505n 0.0v 1289.495n 0.0v 1289.505n 0.0v 1299.495n 0.0v 1299.505n 0.0v 1309.495n 0.0v 1309.505n 0.0v 1319.495n 0.0v 1319.505n 0.0v 1329.495n 0.0v 1329.505n 0.0v 1339.495n 0.0v 1339.505n 0.0v 1349.495n 0.0v 1349.505n 0.0v 1359.495n 0.0v 1359.505n 0.0v 1369.495n 0.0v 1369.505n 0.0v 1379.495n 0.0v 1379.505n 0.0v 1389.495n 0.0v 1389.505n 0.0v 1399.495n 0.0v 1399.505n 0.0v 1409.495n 0.0v 1409.505n 0.0v 1419.495n 0.0v 1419.505n 0.0v 1429.495n 0.0v 1429.505n 0.0v 1439.495n 0.0v 1439.505n 0.0v 1449.495n 0.0v 1449.505n 1.7v 1459.495n 1.7v 1459.505n 1.7v 1469.495n 1.7v 1469.505n 0.0v 1479.495n 0.0v 1479.505n 0.0v 1489.495n 0.0v 1489.505n 0.0v 1499.495n 0.0v 1499.505n 0.0v 1509.495n 0.0v 1509.505n 0.0v 1519.495n 0.0v 1519.505n 0.0v 1529.495n 0.0v 1529.505n 0.0v 1539.495n 0.0v 1539.505n 0.0v 1549.495n 0.0v 1549.505n 0.0v 1559.495n 0.0v 1559.505n 0.0v 1569.495n 0.0v 1569.505n 0.0v 1579.495n 0.0v 1579.505n 1.7v 1589.495n 1.7v 1589.505n 1.7v 1599.495n 1.7v 1599.505n 1.7v 1609.495n 1.7v 1609.505n 0.0v 1619.495n 0.0v 1619.505n 0.0v 1629.495n 0.0v 1629.505n 0.0v 1639.495n 0.0v 1639.505n 1.7v 1649.495n 1.7v 1649.505n 0.0v 1659.495n 0.0v 1659.505n 0.0v 1669.495n 0.0v 1669.505n 0.0v 1679.495n 0.0v 1679.505n 0.0v 1689.495n 0.0v 1689.505n 0.0v 1699.495n 0.0v 1699.505n 0.0v 1709.495n 0.0v 1709.505n 0.0v 1719.495n 0.0v 1719.505n 0.0v 1729.495n 0.0v 1729.505n 0.0v 1739.495n 0.0v 1739.505n 0.0v 1749.495n 0.0v 1749.505n 0.0v 1759.495n 0.0v 1759.505n 0.0v 1769.495n 0.0v 1769.505n 0.0v 1779.495n 0.0v 1779.505n 0.0v 1789.495n 0.0v 1789.505n 0.0v 1799.495n 0.0v 1799.505n 0.0v 1809.495n 0.0v 1809.505n 0.0v 1819.495n 0.0v 1819.505n 1.7v 1829.495n 1.7v 1829.505n 1.7v 1839.495n 1.7v 1839.505n 1.7v 1849.495n 1.7v 1849.505n 0.0v 1859.495n 0.0v 1859.505n 0.0v 1869.495n 0.0v 1869.505n 0.0v 1879.495n 0.0v 1879.505n 0.0v 1889.495n 0.0v 1889.505n 0.0v 1899.495n 0.0v 1899.505n 0.0v 1909.495n 0.0v 1909.505n 0.0v 1919.495n 0.0v 1919.505n 0.0v 1929.495n 0.0v 1929.505n 0.0v 1939.495n 0.0v 1939.505n 0.0v 1949.495n 0.0v 1949.505n 0.0v 1959.495n 0.0v 1959.505n 0.0v 1969.495n 0.0v 1969.505n 0.0v 1979.495n 0.0v 1979.505n 0.0v 1989.495n 0.0v 1989.505n 0.0v 1999.495n 0.0v 1999.505n 0.0v 2009.495n 0.0v 2009.505n 0.0v 2019.495n 0.0v 2019.505n 0.0v 2029.495n 0.0v 2029.505n 0.0v 2039.495n 0.0v 2039.505n 0.0v 2049.495n 0.0v 2049.505n 0.0v )
* (time, data): [(0, 0), (10, 0), (20, 0), (30, 1), (40, 1), (50, 1), (60, 1), (70, 0), (80, 0), (90, 0), (100, 0), (110, 0), (120, 0), (130, 0), (140, 0), (150, 0), (160, 0), (170, 0), (180, 0), (190, 1), (200, 1), (210, 0), (220, 0), (230, 0), (240, 0), (250, 1), (260, 1), (270, 1), (280, 0), (290, 0), (300, 0), (310, 0), (320, 0), (330, 0), (340, 0), (350, 0), (360, 0), (370, 0), (380, 0), (390, 0), (400, 0), (410, 0), (420, 0), (430, 0), (440, 0), (450, 1), (460, 0), (470, 0), (480, 1), (490, 1), (500, 0), (510, 0), (520, 0), (530, 0), (540, 0), (550, 0), (560, 0), (570, 0), (580, 0), (590, 0), (600, 0), (610, 0), (620, 0), (630, 0), (640, 0), (650, 0), (660, 0), (670, 0), (680, 0), (690, 0), (700, 0), (710, 0), (720, 0), (730, 0), (740, 0), (750, 0), (760, 0), (770, 0), (780, 0), (790, 0), (800, 0), (810, 0), (820, 0), (830, 0), (840, 0), (850, 0), (860, 0), (870, 0), (880, 0), (890, 0), (900, 0), (910, 0), (920, 0), (930, 0), (940, 0), (950, 0), (960, 0), (970, 0), (980, 0), (990, 0), (1000, 0), (1010, 0), (1020, 0), (1030, 0), (1040, 0), (1050, 0), (1060, 0), (1070, 0), (1080, 0), (1090, 0), (1100, 0), (1110, 0), (1120, 0), (1130, 0), (1140, 0), (1150, 0), (1160, 0), (1170, 0), (1180, 0), (1190, 0), (1200, 0), (1210, 0), (1220, 0), (1230, 0), (1240, 0), (1250, 0), (1260, 0), (1270, 0), (1280, 0), (1290, 0), (1300, 0), (1310, 0), (1320, 0), (1330, 0), (1340, 0), (1350, 0), (1360, 0), (1370, 0), (1380, 0), (1390, 0), (1400, 0), (1410, 0), (1420, 0), (1430, 0), (1440, 0), (1450, 1), (1460, 1), (1470, 0), (1480, 0), (1490, 0), (1500, 0), (1510, 0), (1520, 0), (1530, 0), (1540, 0), (1550, 0), (1560, 0), (1570, 0), (1580, 1), (1590, 1), (1600, 1), (1610, 0), (1620, 0), (1630, 0), (1640, 1), (1650, 0), (1660, 0), (1670, 0), (1680, 0), (1690, 0), (1700, 0), (1710, 0), (1720, 0), (1730, 0), (1740, 0), (1750, 0), (1760, 0), (1770, 0), (1780, 0), (1790, 0), (1800, 0), (1810, 0), (1820, 1), (1830, 1), (1840, 1), (1850, 0), (1860, 0), (1870, 0), (1880, 0), (1890, 0), (1900, 0), (1910, 0), (1920, 0), (1930, 0), (1940, 0), (1950, 0), (1960, 0), (1970, 0), (1980, 0), (1990, 0), (2000, 0), (2010, 0), (2020, 0), (2030, 0), (2040, 0), (2050, 0)]
Va0_6  a0_6  0 PWL (0n 0.0v 9.495n 0.0v 9.505n 0.0v 19.495n 0.0v 19.505n 0.0v 29.495n 0.0v 29.505n 1.7v 39.495n 1.7v 39.505n 1.7v 49.495n 1.7v 49.505n 1.7v 59.495n 1.7v 59.505n 1.7v 69.495n 1.7v 69.505n 0.0v 79.495n 0.0v 79.505n 0.0v 89.495n 0.0v 89.505n 0.0v 99.495n 0.0v 99.505n 0.0v 109.495n 0.0v 109.505n 0.0v 119.495n 0.0v 119.505n 0.0v 129.495n 0.0v 129.505n 0.0v 139.495n 0.0v 139.505n 0.0v 149.495n 0.0v 149.505n 0.0v 159.495n 0.0v 159.505n 0.0v 169.495n 0.0v 169.505n 0.0v 179.495n 0.0v 179.505n 0.0v 189.495n 0.0v 189.505n 1.7v 199.495n 1.7v 199.505n 1.7v 209.495n 1.7v 209.505n 0.0v 219.495n 0.0v 219.505n 0.0v 229.495n 0.0v 229.505n 0.0v 239.495n 0.0v 239.505n 0.0v 249.495n 0.0v 249.505n 1.7v 259.495n 1.7v 259.505n 1.7v 269.495n 1.7v 269.505n 1.7v 279.495n 1.7v 279.505n 0.0v 289.495n 0.0v 289.505n 0.0v 299.495n 0.0v 299.505n 0.0v 309.495n 0.0v 309.505n 0.0v 319.495n 0.0v 319.505n 0.0v 329.495n 0.0v 329.505n 0.0v 339.495n 0.0v 339.505n 0.0v 349.495n 0.0v 349.505n 0.0v 359.495n 0.0v 359.505n 0.0v 369.495n 0.0v 369.505n 0.0v 379.495n 0.0v 379.505n 0.0v 389.495n 0.0v 389.505n 0.0v 399.495n 0.0v 399.505n 0.0v 409.495n 0.0v 409.505n 0.0v 419.495n 0.0v 419.505n 0.0v 429.495n 0.0v 429.505n 0.0v 439.495n 0.0v 439.505n 0.0v 449.495n 0.0v 449.505n 1.7v 459.495n 1.7v 459.505n 0.0v 469.495n 0.0v 469.505n 0.0v 479.495n 0.0v 479.505n 1.7v 489.495n 1.7v 489.505n 1.7v 499.495n 1.7v 499.505n 0.0v 509.495n 0.0v 509.505n 0.0v 519.495n 0.0v 519.505n 0.0v 529.495n 0.0v 529.505n 0.0v 539.495n 0.0v 539.505n 0.0v 549.495n 0.0v 549.505n 0.0v 559.495n 0.0v 559.505n 0.0v 569.495n 0.0v 569.505n 0.0v 579.495n 0.0v 579.505n 0.0v 589.495n 0.0v 589.505n 0.0v 599.495n 0.0v 599.505n 0.0v 609.495n 0.0v 609.505n 0.0v 619.495n 0.0v 619.505n 0.0v 629.495n 0.0v 629.505n 0.0v 639.495n 0.0v 639.505n 0.0v 649.495n 0.0v 649.505n 0.0v 659.495n 0.0v 659.505n 0.0v 669.495n 0.0v 669.505n 0.0v 679.495n 0.0v 679.505n 0.0v 689.495n 0.0v 689.505n 0.0v 699.495n 0.0v 699.505n 0.0v 709.495n 0.0v 709.505n 0.0v 719.495n 0.0v 719.505n 0.0v 729.495n 0.0v 729.505n 0.0v 739.495n 0.0v 739.505n 0.0v 749.495n 0.0v 749.505n 0.0v 759.495n 0.0v 759.505n 0.0v 769.495n 0.0v 769.505n 0.0v 779.495n 0.0v 779.505n 0.0v 789.495n 0.0v 789.505n 0.0v 799.495n 0.0v 799.505n 0.0v 809.495n 0.0v 809.505n 0.0v 819.495n 0.0v 819.505n 0.0v 829.495n 0.0v 829.505n 0.0v 839.495n 0.0v 839.505n 0.0v 849.495n 0.0v 849.505n 0.0v 859.495n 0.0v 859.505n 0.0v 869.495n 0.0v 869.505n 0.0v 879.495n 0.0v 879.505n 0.0v 889.495n 0.0v 889.505n 0.0v 899.495n 0.0v 899.505n 0.0v 909.495n 0.0v 909.505n 0.0v 919.495n 0.0v 919.505n 0.0v 929.495n 0.0v 929.505n 0.0v 939.495n 0.0v 939.505n 0.0v 949.495n 0.0v 949.505n 0.0v 959.495n 0.0v 959.505n 0.0v 969.495n 0.0v 969.505n 0.0v 979.495n 0.0v 979.505n 0.0v 989.495n 0.0v 989.505n 0.0v 999.495n 0.0v 999.505n 0.0v 1009.495n 0.0v 1009.505n 0.0v 1019.495n 0.0v 1019.505n 0.0v 1029.495n 0.0v 1029.505n 0.0v 1039.495n 0.0v 1039.505n 0.0v 1049.495n 0.0v 1049.505n 0.0v 1059.495n 0.0v 1059.505n 0.0v 1069.495n 0.0v 1069.505n 0.0v 1079.495n 0.0v 1079.505n 0.0v 1089.495n 0.0v 1089.505n 0.0v 1099.495n 0.0v 1099.505n 0.0v 1109.495n 0.0v 1109.505n 0.0v 1119.495n 0.0v 1119.505n 0.0v 1129.495n 0.0v 1129.505n 0.0v 1139.495n 0.0v 1139.505n 0.0v 1149.495n 0.0v 1149.505n 0.0v 1159.495n 0.0v 1159.505n 0.0v 1169.495n 0.0v 1169.505n 0.0v 1179.495n 0.0v 1179.505n 0.0v 1189.495n 0.0v 1189.505n 0.0v 1199.495n 0.0v 1199.505n 0.0v 1209.495n 0.0v 1209.505n 0.0v 1219.495n 0.0v 1219.505n 0.0v 1229.495n 0.0v 1229.505n 0.0v 1239.495n 0.0v 1239.505n 0.0v 1249.495n 0.0v 1249.505n 0.0v 1259.495n 0.0v 1259.505n 0.0v 1269.495n 0.0v 1269.505n 0.0v 1279.495n 0.0v 1279.505n 0.0v 1289.495n 0.0v 1289.505n 0.0v 1299.495n 0.0v 1299.505n 0.0v 1309.495n 0.0v 1309.505n 0.0v 1319.495n 0.0v 1319.505n 0.0v 1329.495n 0.0v 1329.505n 0.0v 1339.495n 0.0v 1339.505n 0.0v 1349.495n 0.0v 1349.505n 0.0v 1359.495n 0.0v 1359.505n 0.0v 1369.495n 0.0v 1369.505n 0.0v 1379.495n 0.0v 1379.505n 0.0v 1389.495n 0.0v 1389.505n 0.0v 1399.495n 0.0v 1399.505n 0.0v 1409.495n 0.0v 1409.505n 0.0v 1419.495n 0.0v 1419.505n 0.0v 1429.495n 0.0v 1429.505n 0.0v 1439.495n 0.0v 1439.505n 0.0v 1449.495n 0.0v 1449.505n 1.7v 1459.495n 1.7v 1459.505n 1.7v 1469.495n 1.7v 1469.505n 0.0v 1479.495n 0.0v 1479.505n 0.0v 1489.495n 0.0v 1489.505n 0.0v 1499.495n 0.0v 1499.505n 0.0v 1509.495n 0.0v 1509.505n 0.0v 1519.495n 0.0v 1519.505n 0.0v 1529.495n 0.0v 1529.505n 0.0v 1539.495n 0.0v 1539.505n 0.0v 1549.495n 0.0v 1549.505n 0.0v 1559.495n 0.0v 1559.505n 0.0v 1569.495n 0.0v 1569.505n 0.0v 1579.495n 0.0v 1579.505n 1.7v 1589.495n 1.7v 1589.505n 1.7v 1599.495n 1.7v 1599.505n 1.7v 1609.495n 1.7v 1609.505n 0.0v 1619.495n 0.0v 1619.505n 0.0v 1629.495n 0.0v 1629.505n 0.0v 1639.495n 0.0v 1639.505n 1.7v 1649.495n 1.7v 1649.505n 0.0v 1659.495n 0.0v 1659.505n 0.0v 1669.495n 0.0v 1669.505n 0.0v 1679.495n 0.0v 1679.505n 0.0v 1689.495n 0.0v 1689.505n 0.0v 1699.495n 0.0v 1699.505n 0.0v 1709.495n 0.0v 1709.505n 0.0v 1719.495n 0.0v 1719.505n 0.0v 1729.495n 0.0v 1729.505n 0.0v 1739.495n 0.0v 1739.505n 0.0v 1749.495n 0.0v 1749.505n 0.0v 1759.495n 0.0v 1759.505n 0.0v 1769.495n 0.0v 1769.505n 0.0v 1779.495n 0.0v 1779.505n 0.0v 1789.495n 0.0v 1789.505n 0.0v 1799.495n 0.0v 1799.505n 0.0v 1809.495n 0.0v 1809.505n 0.0v 1819.495n 0.0v 1819.505n 1.7v 1829.495n 1.7v 1829.505n 1.7v 1839.495n 1.7v 1839.505n 1.7v 1849.495n 1.7v 1849.505n 0.0v 1859.495n 0.0v 1859.505n 0.0v 1869.495n 0.0v 1869.505n 0.0v 1879.495n 0.0v 1879.505n 0.0v 1889.495n 0.0v 1889.505n 0.0v 1899.495n 0.0v 1899.505n 0.0v 1909.495n 0.0v 1909.505n 0.0v 1919.495n 0.0v 1919.505n 0.0v 1929.495n 0.0v 1929.505n 0.0v 1939.495n 0.0v 1939.505n 0.0v 1949.495n 0.0v 1949.505n 0.0v 1959.495n 0.0v 1959.505n 0.0v 1969.495n 0.0v 1969.505n 0.0v 1979.495n 0.0v 1979.505n 0.0v 1989.495n 0.0v 1989.505n 0.0v 1999.495n 0.0v 1999.505n 0.0v 2009.495n 0.0v 2009.505n 0.0v 2019.495n 0.0v 2019.505n 0.0v 2029.495n 0.0v 2029.505n 0.0v 2039.495n 0.0v 2039.505n 0.0v 2049.495n 0.0v 2049.505n 0.0v )
* (time, data): [(0, 0), (10, 0), (20, 0), (30, 1), (40, 1), (50, 1), (60, 1), (70, 0), (80, 0), (90, 0), (100, 0), (110, 0), (120, 0), (130, 0), (140, 0), (150, 0), (160, 0), (170, 0), (180, 0), (190, 1), (200, 1), (210, 0), (220, 0), (230, 0), (240, 0), (250, 1), (260, 1), (270, 1), (280, 0), (290, 0), (300, 0), (310, 0), (320, 0), (330, 0), (340, 0), (350, 0), (360, 0), (370, 0), (380, 0), (390, 0), (400, 0), (410, 0), (420, 0), (430, 0), (440, 0), (450, 1), (460, 0), (470, 0), (480, 1), (490, 1), (500, 0), (510, 0), (520, 0), (530, 0), (540, 0), (550, 0), (560, 0), (570, 0), (580, 0), (590, 0), (600, 0), (610, 0), (620, 0), (630, 0), (640, 0), (650, 0), (660, 0), (670, 0), (680, 0), (690, 0), (700, 0), (710, 0), (720, 0), (730, 0), (740, 0), (750, 0), (760, 0), (770, 0), (780, 0), (790, 0), (800, 0), (810, 0), (820, 0), (830, 0), (840, 0), (850, 0), (860, 0), (870, 0), (880, 0), (890, 0), (900, 0), (910, 0), (920, 0), (930, 0), (940, 0), (950, 0), (960, 0), (970, 0), (980, 0), (990, 0), (1000, 0), (1010, 0), (1020, 0), (1030, 0), (1040, 0), (1050, 0), (1060, 0), (1070, 0), (1080, 0), (1090, 0), (1100, 0), (1110, 0), (1120, 0), (1130, 0), (1140, 0), (1150, 0), (1160, 0), (1170, 0), (1180, 0), (1190, 0), (1200, 0), (1210, 0), (1220, 0), (1230, 0), (1240, 0), (1250, 0), (1260, 0), (1270, 0), (1280, 0), (1290, 0), (1300, 0), (1310, 0), (1320, 0), (1330, 0), (1340, 0), (1350, 0), (1360, 0), (1370, 0), (1380, 0), (1390, 0), (1400, 0), (1410, 0), (1420, 0), (1430, 0), (1440, 0), (1450, 1), (1460, 1), (1470, 0), (1480, 0), (1490, 0), (1500, 0), (1510, 0), (1520, 0), (1530, 0), (1540, 0), (1550, 0), (1560, 0), (1570, 0), (1580, 1), (1590, 1), (1600, 1), (1610, 0), (1620, 0), (1630, 0), (1640, 1), (1650, 0), (1660, 0), (1670, 0), (1680, 0), (1690, 0), (1700, 0), (1710, 0), (1720, 0), (1730, 0), (1740, 0), (1750, 0), (1760, 0), (1770, 0), (1780, 0), (1790, 0), (1800, 0), (1810, 0), (1820, 1), (1830, 1), (1840, 1), (1850, 0), (1860, 0), (1870, 0), (1880, 0), (1890, 0), (1900, 0), (1910, 0), (1920, 0), (1930, 0), (1940, 0), (1950, 0), (1960, 0), (1970, 0), (1980, 0), (1990, 0), (2000, 0), (2010, 0), (2020, 0), (2030, 0), (2040, 0), (2050, 0)]
Va0_7  a0_7  0 PWL (0n 0.0v 9.495n 0.0v 9.505n 0.0v 19.495n 0.0v 19.505n 0.0v 29.495n 0.0v 29.505n 1.7v 39.495n 1.7v 39.505n 1.7v 49.495n 1.7v 49.505n 1.7v 59.495n 1.7v 59.505n 1.7v 69.495n 1.7v 69.505n 0.0v 79.495n 0.0v 79.505n 0.0v 89.495n 0.0v 89.505n 0.0v 99.495n 0.0v 99.505n 0.0v 109.495n 0.0v 109.505n 0.0v 119.495n 0.0v 119.505n 0.0v 129.495n 0.0v 129.505n 0.0v 139.495n 0.0v 139.505n 0.0v 149.495n 0.0v 149.505n 0.0v 159.495n 0.0v 159.505n 0.0v 169.495n 0.0v 169.505n 0.0v 179.495n 0.0v 179.505n 0.0v 189.495n 0.0v 189.505n 1.7v 199.495n 1.7v 199.505n 1.7v 209.495n 1.7v 209.505n 0.0v 219.495n 0.0v 219.505n 0.0v 229.495n 0.0v 229.505n 0.0v 239.495n 0.0v 239.505n 0.0v 249.495n 0.0v 249.505n 1.7v 259.495n 1.7v 259.505n 1.7v 269.495n 1.7v 269.505n 1.7v 279.495n 1.7v 279.505n 0.0v 289.495n 0.0v 289.505n 0.0v 299.495n 0.0v 299.505n 0.0v 309.495n 0.0v 309.505n 0.0v 319.495n 0.0v 319.505n 0.0v 329.495n 0.0v 329.505n 0.0v 339.495n 0.0v 339.505n 0.0v 349.495n 0.0v 349.505n 0.0v 359.495n 0.0v 359.505n 0.0v 369.495n 0.0v 369.505n 0.0v 379.495n 0.0v 379.505n 0.0v 389.495n 0.0v 389.505n 0.0v 399.495n 0.0v 399.505n 0.0v 409.495n 0.0v 409.505n 0.0v 419.495n 0.0v 419.505n 0.0v 429.495n 0.0v 429.505n 0.0v 439.495n 0.0v 439.505n 0.0v 449.495n 0.0v 449.505n 1.7v 459.495n 1.7v 459.505n 0.0v 469.495n 0.0v 469.505n 0.0v 479.495n 0.0v 479.505n 1.7v 489.495n 1.7v 489.505n 1.7v 499.495n 1.7v 499.505n 0.0v 509.495n 0.0v 509.505n 0.0v 519.495n 0.0v 519.505n 0.0v 529.495n 0.0v 529.505n 0.0v 539.495n 0.0v 539.505n 0.0v 549.495n 0.0v 549.505n 0.0v 559.495n 0.0v 559.505n 0.0v 569.495n 0.0v 569.505n 0.0v 579.495n 0.0v 579.505n 0.0v 589.495n 0.0v 589.505n 0.0v 599.495n 0.0v 599.505n 0.0v 609.495n 0.0v 609.505n 0.0v 619.495n 0.0v 619.505n 0.0v 629.495n 0.0v 629.505n 0.0v 639.495n 0.0v 639.505n 0.0v 649.495n 0.0v 649.505n 0.0v 659.495n 0.0v 659.505n 0.0v 669.495n 0.0v 669.505n 0.0v 679.495n 0.0v 679.505n 0.0v 689.495n 0.0v 689.505n 0.0v 699.495n 0.0v 699.505n 0.0v 709.495n 0.0v 709.505n 0.0v 719.495n 0.0v 719.505n 0.0v 729.495n 0.0v 729.505n 0.0v 739.495n 0.0v 739.505n 0.0v 749.495n 0.0v 749.505n 0.0v 759.495n 0.0v 759.505n 0.0v 769.495n 0.0v 769.505n 0.0v 779.495n 0.0v 779.505n 0.0v 789.495n 0.0v 789.505n 0.0v 799.495n 0.0v 799.505n 0.0v 809.495n 0.0v 809.505n 0.0v 819.495n 0.0v 819.505n 0.0v 829.495n 0.0v 829.505n 0.0v 839.495n 0.0v 839.505n 0.0v 849.495n 0.0v 849.505n 0.0v 859.495n 0.0v 859.505n 0.0v 869.495n 0.0v 869.505n 0.0v 879.495n 0.0v 879.505n 0.0v 889.495n 0.0v 889.505n 0.0v 899.495n 0.0v 899.505n 0.0v 909.495n 0.0v 909.505n 0.0v 919.495n 0.0v 919.505n 0.0v 929.495n 0.0v 929.505n 0.0v 939.495n 0.0v 939.505n 0.0v 949.495n 0.0v 949.505n 0.0v 959.495n 0.0v 959.505n 0.0v 969.495n 0.0v 969.505n 0.0v 979.495n 0.0v 979.505n 0.0v 989.495n 0.0v 989.505n 0.0v 999.495n 0.0v 999.505n 0.0v 1009.495n 0.0v 1009.505n 0.0v 1019.495n 0.0v 1019.505n 0.0v 1029.495n 0.0v 1029.505n 0.0v 1039.495n 0.0v 1039.505n 0.0v 1049.495n 0.0v 1049.505n 0.0v 1059.495n 0.0v 1059.505n 0.0v 1069.495n 0.0v 1069.505n 0.0v 1079.495n 0.0v 1079.505n 0.0v 1089.495n 0.0v 1089.505n 0.0v 1099.495n 0.0v 1099.505n 0.0v 1109.495n 0.0v 1109.505n 0.0v 1119.495n 0.0v 1119.505n 0.0v 1129.495n 0.0v 1129.505n 0.0v 1139.495n 0.0v 1139.505n 0.0v 1149.495n 0.0v 1149.505n 0.0v 1159.495n 0.0v 1159.505n 0.0v 1169.495n 0.0v 1169.505n 0.0v 1179.495n 0.0v 1179.505n 0.0v 1189.495n 0.0v 1189.505n 0.0v 1199.495n 0.0v 1199.505n 0.0v 1209.495n 0.0v 1209.505n 0.0v 1219.495n 0.0v 1219.505n 0.0v 1229.495n 0.0v 1229.505n 0.0v 1239.495n 0.0v 1239.505n 0.0v 1249.495n 0.0v 1249.505n 0.0v 1259.495n 0.0v 1259.505n 0.0v 1269.495n 0.0v 1269.505n 0.0v 1279.495n 0.0v 1279.505n 0.0v 1289.495n 0.0v 1289.505n 0.0v 1299.495n 0.0v 1299.505n 0.0v 1309.495n 0.0v 1309.505n 0.0v 1319.495n 0.0v 1319.505n 0.0v 1329.495n 0.0v 1329.505n 0.0v 1339.495n 0.0v 1339.505n 0.0v 1349.495n 0.0v 1349.505n 0.0v 1359.495n 0.0v 1359.505n 0.0v 1369.495n 0.0v 1369.505n 0.0v 1379.495n 0.0v 1379.505n 0.0v 1389.495n 0.0v 1389.505n 0.0v 1399.495n 0.0v 1399.505n 0.0v 1409.495n 0.0v 1409.505n 0.0v 1419.495n 0.0v 1419.505n 0.0v 1429.495n 0.0v 1429.505n 0.0v 1439.495n 0.0v 1439.505n 0.0v 1449.495n 0.0v 1449.505n 1.7v 1459.495n 1.7v 1459.505n 1.7v 1469.495n 1.7v 1469.505n 0.0v 1479.495n 0.0v 1479.505n 0.0v 1489.495n 0.0v 1489.505n 0.0v 1499.495n 0.0v 1499.505n 0.0v 1509.495n 0.0v 1509.505n 0.0v 1519.495n 0.0v 1519.505n 0.0v 1529.495n 0.0v 1529.505n 0.0v 1539.495n 0.0v 1539.505n 0.0v 1549.495n 0.0v 1549.505n 0.0v 1559.495n 0.0v 1559.505n 0.0v 1569.495n 0.0v 1569.505n 0.0v 1579.495n 0.0v 1579.505n 1.7v 1589.495n 1.7v 1589.505n 1.7v 1599.495n 1.7v 1599.505n 1.7v 1609.495n 1.7v 1609.505n 0.0v 1619.495n 0.0v 1619.505n 0.0v 1629.495n 0.0v 1629.505n 0.0v 1639.495n 0.0v 1639.505n 1.7v 1649.495n 1.7v 1649.505n 0.0v 1659.495n 0.0v 1659.505n 0.0v 1669.495n 0.0v 1669.505n 0.0v 1679.495n 0.0v 1679.505n 0.0v 1689.495n 0.0v 1689.505n 0.0v 1699.495n 0.0v 1699.505n 0.0v 1709.495n 0.0v 1709.505n 0.0v 1719.495n 0.0v 1719.505n 0.0v 1729.495n 0.0v 1729.505n 0.0v 1739.495n 0.0v 1739.505n 0.0v 1749.495n 0.0v 1749.505n 0.0v 1759.495n 0.0v 1759.505n 0.0v 1769.495n 0.0v 1769.505n 0.0v 1779.495n 0.0v 1779.505n 0.0v 1789.495n 0.0v 1789.505n 0.0v 1799.495n 0.0v 1799.505n 0.0v 1809.495n 0.0v 1809.505n 0.0v 1819.495n 0.0v 1819.505n 1.7v 1829.495n 1.7v 1829.505n 1.7v 1839.495n 1.7v 1839.505n 1.7v 1849.495n 1.7v 1849.505n 0.0v 1859.495n 0.0v 1859.505n 0.0v 1869.495n 0.0v 1869.505n 0.0v 1879.495n 0.0v 1879.505n 0.0v 1889.495n 0.0v 1889.505n 0.0v 1899.495n 0.0v 1899.505n 0.0v 1909.495n 0.0v 1909.505n 0.0v 1919.495n 0.0v 1919.505n 0.0v 1929.495n 0.0v 1929.505n 0.0v 1939.495n 0.0v 1939.505n 0.0v 1949.495n 0.0v 1949.505n 0.0v 1959.495n 0.0v 1959.505n 0.0v 1969.495n 0.0v 1969.505n 0.0v 1979.495n 0.0v 1979.505n 0.0v 1989.495n 0.0v 1989.505n 0.0v 1999.495n 0.0v 1999.505n 0.0v 2009.495n 0.0v 2009.505n 0.0v 2019.495n 0.0v 2019.505n 0.0v 2029.495n 0.0v 2029.505n 0.0v 2039.495n 0.0v 2039.505n 0.0v 2049.495n 0.0v 2049.505n 0.0v )
* (time, data): [(0, 0), (10, 1), (20, 0), (30, 0), (40, 0), (50, 0), (60, 0), (70, 0), (80, 1), (90, 1), (100, 1), (110, 0), (120, 0), (130, 0), (140, 0), (150, 0), (160, 1), (170, 1), (180, 1), (190, 0), (200, 0), (210, 0), (220, 0), (230, 0), (240, 0), (250, 0), (260, 0), (270, 0), (280, 0), (290, 0), (300, 0), (310, 0), (320, 0), (330, 0), (340, 0), (350, 0), (360, 0), (370, 0), (380, 0), (390, 0), (400, 0), (410, 0), (420, 0), (430, 0), (440, 0), (450, 0), (460, 1), (470, 1), (480, 0), (490, 0), (500, 0), (510, 0), (520, 0), (530, 0), (540, 0), (550, 1), (560, 1), (570, 1), (580, 1), (590, 0), (600, 1), (610, 1), (620, 1), (630, 0), (640, 0), (650, 1), (660, 0), (670, 1), (680, 1), (690, 0), (700, 0), (710, 1), (720, 1), (730, 1), (740, 1), (750, 1), (760, 1), (770, 1), (780, 0), (790, 1), (800, 1), (810, 0), (820, 0), (830, 0), (840, 0), (850, 0), (860, 1), (870, 1), (880, 0), (890, 0), (900, 0), (910, 0), (920, 0), (930, 0), (940, 0), (950, 0), (960, 1), (970, 1), (980, 1), (990, 1), (1000, 1), (1010, 1), (1020, 1), (1030, 0), (1040, 0), (1050, 1), (1060, 1), (1070, 0), (1080, 0), (1090, 0), (1100, 0), (1110, 0), (1120, 0), (1130, 0), (1140, 0), (1150, 0), (1160, 0), (1170, 0), (1180, 0), (1190, 0), (1200, 0), (1210, 0), (1220, 0), (1230, 0), (1240, 0), (1250, 0), (1260, 0), (1270, 0), (1280, 0), (1290, 1), (1300, 1), (1310, 1), (1320, 1), (1330, 1), (1340, 1), (1350, 0), (1360, 0), (1370, 0), (1380, 0), (1390, 1), (1400, 1), (1410, 0), (1420, 0), (1430, 0), (1440, 0), (1450, 0), (1460, 0), (1470, 0), (1480, 0), (1490, 0), (1500, 0), (1510, 0), (1520, 1), (1530, 1), (1540, 1), (1550, 0), (1560, 0), (1570, 0), (1580, 0), (1590, 0), (1600, 0), (1610, 0), (1620, 0), (1630, 0), (1640, 0), (1650, 1), (1660, 1), (1670, 1), (1680, 0), (1690, 0), (1700, 1), (1710, 1), (1720, 0), (1730, 0), (1740, 1), (1750, 1), (1760, 1), (1770, 1), (1780, 0), (1790, 0), (1800, 0), (1810, 1), (1820, 0), (1830, 0), (1840, 0), (1850, 1), (1860, 1), (1870, 1), (1880, 1), (1890, 0), (1900, 1), (1910, 0), (1920, 0), (1930, 0), (1940, 0), (1950, 0), (1960, 0), (1970, 1), (1980, 0), (1990, 0), (2000, 1), (2010, 1), (2020, 0), (2030, 1), (2040, 1), (2050, 1)]
Va0_8  a0_8  0 PWL (0n 0.0v 9.495n 0.0v 9.505n 1.7v 19.495n 1.7v 19.505n 0.0v 29.495n 0.0v 29.505n 0.0v 39.495n 0.0v 39.505n 0.0v 49.495n 0.0v 49.505n 0.0v 59.495n 0.0v 59.505n 0.0v 69.495n 0.0v 69.505n 0.0v 79.495n 0.0v 79.505n 1.7v 89.495n 1.7v 89.505n 1.7v 99.495n 1.7v 99.505n 1.7v 109.495n 1.7v 109.505n 0.0v 119.495n 0.0v 119.505n 0.0v 129.495n 0.0v 129.505n 0.0v 139.495n 0.0v 139.505n 0.0v 149.495n 0.0v 149.505n 0.0v 159.495n 0.0v 159.505n 1.7v 169.495n 1.7v 169.505n 1.7v 179.495n 1.7v 179.505n 1.7v 189.495n 1.7v 189.505n 0.0v 199.495n 0.0v 199.505n 0.0v 209.495n 0.0v 209.505n 0.0v 219.495n 0.0v 219.505n 0.0v 229.495n 0.0v 229.505n 0.0v 239.495n 0.0v 239.505n 0.0v 249.495n 0.0v 249.505n 0.0v 259.495n 0.0v 259.505n 0.0v 269.495n 0.0v 269.505n 0.0v 279.495n 0.0v 279.505n 0.0v 289.495n 0.0v 289.505n 0.0v 299.495n 0.0v 299.505n 0.0v 309.495n 0.0v 309.505n 0.0v 319.495n 0.0v 319.505n 0.0v 329.495n 0.0v 329.505n 0.0v 339.495n 0.0v 339.505n 0.0v 349.495n 0.0v 349.505n 0.0v 359.495n 0.0v 359.505n 0.0v 369.495n 0.0v 369.505n 0.0v 379.495n 0.0v 379.505n 0.0v 389.495n 0.0v 389.505n 0.0v 399.495n 0.0v 399.505n 0.0v 409.495n 0.0v 409.505n 0.0v 419.495n 0.0v 419.505n 0.0v 429.495n 0.0v 429.505n 0.0v 439.495n 0.0v 439.505n 0.0v 449.495n 0.0v 449.505n 0.0v 459.495n 0.0v 459.505n 1.7v 469.495n 1.7v 469.505n 1.7v 479.495n 1.7v 479.505n 0.0v 489.495n 0.0v 489.505n 0.0v 499.495n 0.0v 499.505n 0.0v 509.495n 0.0v 509.505n 0.0v 519.495n 0.0v 519.505n 0.0v 529.495n 0.0v 529.505n 0.0v 539.495n 0.0v 539.505n 0.0v 549.495n 0.0v 549.505n 1.7v 559.495n 1.7v 559.505n 1.7v 569.495n 1.7v 569.505n 1.7v 579.495n 1.7v 579.505n 1.7v 589.495n 1.7v 589.505n 0.0v 599.495n 0.0v 599.505n 1.7v 609.495n 1.7v 609.505n 1.7v 619.495n 1.7v 619.505n 1.7v 629.495n 1.7v 629.505n 0.0v 639.495n 0.0v 639.505n 0.0v 649.495n 0.0v 649.505n 1.7v 659.495n 1.7v 659.505n 0.0v 669.495n 0.0v 669.505n 1.7v 679.495n 1.7v 679.505n 1.7v 689.495n 1.7v 689.505n 0.0v 699.495n 0.0v 699.505n 0.0v 709.495n 0.0v 709.505n 1.7v 719.495n 1.7v 719.505n 1.7v 729.495n 1.7v 729.505n 1.7v 739.495n 1.7v 739.505n 1.7v 749.495n 1.7v 749.505n 1.7v 759.495n 1.7v 759.505n 1.7v 769.495n 1.7v 769.505n 1.7v 779.495n 1.7v 779.505n 0.0v 789.495n 0.0v 789.505n 1.7v 799.495n 1.7v 799.505n 1.7v 809.495n 1.7v 809.505n 0.0v 819.495n 0.0v 819.505n 0.0v 829.495n 0.0v 829.505n 0.0v 839.495n 0.0v 839.505n 0.0v 849.495n 0.0v 849.505n 0.0v 859.495n 0.0v 859.505n 1.7v 869.495n 1.7v 869.505n 1.7v 879.495n 1.7v 879.505n 0.0v 889.495n 0.0v 889.505n 0.0v 899.495n 0.0v 899.505n 0.0v 909.495n 0.0v 909.505n 0.0v 919.495n 0.0v 919.505n 0.0v 929.495n 0.0v 929.505n 0.0v 939.495n 0.0v 939.505n 0.0v 949.495n 0.0v 949.505n 0.0v 959.495n 0.0v 959.505n 1.7v 969.495n 1.7v 969.505n 1.7v 979.495n 1.7v 979.505n 1.7v 989.495n 1.7v 989.505n 1.7v 999.495n 1.7v 999.505n 1.7v 1009.495n 1.7v 1009.505n 1.7v 1019.495n 1.7v 1019.505n 1.7v 1029.495n 1.7v 1029.505n 0.0v 1039.495n 0.0v 1039.505n 0.0v 1049.495n 0.0v 1049.505n 1.7v 1059.495n 1.7v 1059.505n 1.7v 1069.495n 1.7v 1069.505n 0.0v 1079.495n 0.0v 1079.505n 0.0v 1089.495n 0.0v 1089.505n 0.0v 1099.495n 0.0v 1099.505n 0.0v 1109.495n 0.0v 1109.505n 0.0v 1119.495n 0.0v 1119.505n 0.0v 1129.495n 0.0v 1129.505n 0.0v 1139.495n 0.0v 1139.505n 0.0v 1149.495n 0.0v 1149.505n 0.0v 1159.495n 0.0v 1159.505n 0.0v 1169.495n 0.0v 1169.505n 0.0v 1179.495n 0.0v 1179.505n 0.0v 1189.495n 0.0v 1189.505n 0.0v 1199.495n 0.0v 1199.505n 0.0v 1209.495n 0.0v 1209.505n 0.0v 1219.495n 0.0v 1219.505n 0.0v 1229.495n 0.0v 1229.505n 0.0v 1239.495n 0.0v 1239.505n 0.0v 1249.495n 0.0v 1249.505n 0.0v 1259.495n 0.0v 1259.505n 0.0v 1269.495n 0.0v 1269.505n 0.0v 1279.495n 0.0v 1279.505n 0.0v 1289.495n 0.0v 1289.505n 1.7v 1299.495n 1.7v 1299.505n 1.7v 1309.495n 1.7v 1309.505n 1.7v 1319.495n 1.7v 1319.505n 1.7v 1329.495n 1.7v 1329.505n 1.7v 1339.495n 1.7v 1339.505n 1.7v 1349.495n 1.7v 1349.505n 0.0v 1359.495n 0.0v 1359.505n 0.0v 1369.495n 0.0v 1369.505n 0.0v 1379.495n 0.0v 1379.505n 0.0v 1389.495n 0.0v 1389.505n 1.7v 1399.495n 1.7v 1399.505n 1.7v 1409.495n 1.7v 1409.505n 0.0v 1419.495n 0.0v 1419.505n 0.0v 1429.495n 0.0v 1429.505n 0.0v 1439.495n 0.0v 1439.505n 0.0v 1449.495n 0.0v 1449.505n 0.0v 1459.495n 0.0v 1459.505n 0.0v 1469.495n 0.0v 1469.505n 0.0v 1479.495n 0.0v 1479.505n 0.0v 1489.495n 0.0v 1489.505n 0.0v 1499.495n 0.0v 1499.505n 0.0v 1509.495n 0.0v 1509.505n 0.0v 1519.495n 0.0v 1519.505n 1.7v 1529.495n 1.7v 1529.505n 1.7v 1539.495n 1.7v 1539.505n 1.7v 1549.495n 1.7v 1549.505n 0.0v 1559.495n 0.0v 1559.505n 0.0v 1569.495n 0.0v 1569.505n 0.0v 1579.495n 0.0v 1579.505n 0.0v 1589.495n 0.0v 1589.505n 0.0v 1599.495n 0.0v 1599.505n 0.0v 1609.495n 0.0v 1609.505n 0.0v 1619.495n 0.0v 1619.505n 0.0v 1629.495n 0.0v 1629.505n 0.0v 1639.495n 0.0v 1639.505n 0.0v 1649.495n 0.0v 1649.505n 1.7v 1659.495n 1.7v 1659.505n 1.7v 1669.495n 1.7v 1669.505n 1.7v 1679.495n 1.7v 1679.505n 0.0v 1689.495n 0.0v 1689.505n 0.0v 1699.495n 0.0v 1699.505n 1.7v 1709.495n 1.7v 1709.505n 1.7v 1719.495n 1.7v 1719.505n 0.0v 1729.495n 0.0v 1729.505n 0.0v 1739.495n 0.0v 1739.505n 1.7v 1749.495n 1.7v 1749.505n 1.7v 1759.495n 1.7v 1759.505n 1.7v 1769.495n 1.7v 1769.505n 1.7v 1779.495n 1.7v 1779.505n 0.0v 1789.495n 0.0v 1789.505n 0.0v 1799.495n 0.0v 1799.505n 0.0v 1809.495n 0.0v 1809.505n 1.7v 1819.495n 1.7v 1819.505n 0.0v 1829.495n 0.0v 1829.505n 0.0v 1839.495n 0.0v 1839.505n 0.0v 1849.495n 0.0v 1849.505n 1.7v 1859.495n 1.7v 1859.505n 1.7v 1869.495n 1.7v 1869.505n 1.7v 1879.495n 1.7v 1879.505n 1.7v 1889.495n 1.7v 1889.505n 0.0v 1899.495n 0.0v 1899.505n 1.7v 1909.495n 1.7v 1909.505n 0.0v 1919.495n 0.0v 1919.505n 0.0v 1929.495n 0.0v 1929.505n 0.0v 1939.495n 0.0v 1939.505n 0.0v 1949.495n 0.0v 1949.505n 0.0v 1959.495n 0.0v 1959.505n 0.0v 1969.495n 0.0v 1969.505n 1.7v 1979.495n 1.7v 1979.505n 0.0v 1989.495n 0.0v 1989.505n 0.0v 1999.495n 0.0v 1999.505n 1.7v 2009.495n 1.7v 2009.505n 1.7v 2019.495n 1.7v 2019.505n 0.0v 2029.495n 0.0v 2029.505n 1.7v 2039.495n 1.7v 2039.505n 1.7v 2049.495n 1.7v 2049.505n 1.7v )
* (time, data): [(0, 0), (10, 0), (20, 0), (30, 0), (40, 0), (50, 0), (60, 0), (70, 1), (80, 1), (90, 1), (100, 0), (110, 0), (120, 0), (130, 0), (140, 0), (150, 0), (160, 0), (170, 0), (180, 0), (190, 0), (200, 0), (210, 0), (220, 0), (230, 0), (240, 0), (250, 0), (260, 0), (270, 0), (280, 1), (290, 1), (300, 1), (310, 1), (320, 1), (330, 1), (340, 0), (350, 0), (360, 1), (370, 1), (380, 0), (390, 0), (400, 0), (410, 0), (420, 0), (430, 0), (440, 0), (450, 0), (460, 0), (470, 0), (480, 0), (490, 0), (500, 0), (510, 0), (520, 0), (530, 0), (540, 0), (550, 0), (560, 1), (570, 1), (580, 0), (590, 0), (600, 0), (610, 0), (620, 0), (630, 0), (640, 0), (650, 0), (660, 1), (670, 1), (680, 1), (690, 1), (700, 1), (710, 1), (720, 1), (730, 1), (740, 0), (750, 1), (760, 1), (770, 0), (780, 1), (790, 1), (800, 1), (810, 1), (820, 1), (830, 1), (840, 1), (850, 1), (860, 0), (870, 0), (880, 1), (890, 1), (900, 1), (910, 1), (920, 0), (930, 1), (940, 1), (950, 0), (960, 1), (970, 1), (980, 0), (990, 0), (1000, 0), (1010, 0), (1020, 1), (1030, 1), (1040, 1), (1050, 1), (1060, 1), (1070, 1), (1080, 1), (1090, 1), (1100, 1), (1110, 1), (1120, 1), (1130, 0), (1140, 0), (1150, 0), (1160, 0), (1170, 0), (1180, 0), (1190, 1), (1200, 0), (1210, 0), (1220, 0), (1230, 1), (1240, 0), (1250, 0), (1260, 0), (1270, 0), (1280, 0), (1290, 1), (1300, 1), (1310, 1), (1320, 1), (1330, 1), (1340, 1), (1350, 1), (1360, 1), (1370, 0), (1380, 0), (1390, 0), (1400, 0), (1410, 0), (1420, 1), (1430, 0), (1440, 0), (1450, 0), (1460, 1), (1470, 1), (1480, 1), (1490, 1), (1500, 1), (1510, 1), (1520, 1), (1530, 1), (1540, 1), (1550, 1), (1560, 1), (1570, 1), (1580, 1), (1590, 1), (1600, 1), (1610, 0), (1620, 0), (1630, 0), (1640, 0), (1650, 0), (1660, 0), (1670, 0), (1680, 0), (1690, 0), (1700, 0), (1710, 0), (1720, 0), (1730, 0), (1740, 0), (1750, 0), (1760, 0), (1770, 1), (1780, 1), (1790, 1), (1800, 1), (1810, 0), (1820, 0), (1830, 1), (1840, 1), (1850, 1), (1860, 0), (1870, 0), (1880, 0), (1890, 0), (1900, 0), (1910, 0), (1920, 1), (1930, 1), (1940, 0), (1950, 0), (1960, 1), (1970, 1), (1980, 0), (1990, 0), (2000, 0), (2010, 0), (2020, 0), (2030, 0), (2040, 0), (2050, 0)]
Va1_0  a1_0  0 PWL (0n 0.0v 9.495n 0.0v 9.505n 0.0v 19.495n 0.0v 19.505n 0.0v 29.495n 0.0v 29.505n 0.0v 39.495n 0.0v 39.505n 0.0v 49.495n 0.0v 49.505n 0.0v 59.495n 0.0v 59.505n 0.0v 69.495n 0.0v 69.505n 1.7v 79.495n 1.7v 79.505n 1.7v 89.495n 1.7v 89.505n 1.7v 99.495n 1.7v 99.505n 0.0v 109.495n 0.0v 109.505n 0.0v 119.495n 0.0v 119.505n 0.0v 129.495n 0.0v 129.505n 0.0v 139.495n 0.0v 139.505n 0.0v 149.495n 0.0v 149.505n 0.0v 159.495n 0.0v 159.505n 0.0v 169.495n 0.0v 169.505n 0.0v 179.495n 0.0v 179.505n 0.0v 189.495n 0.0v 189.505n 0.0v 199.495n 0.0v 199.505n 0.0v 209.495n 0.0v 209.505n 0.0v 219.495n 0.0v 219.505n 0.0v 229.495n 0.0v 229.505n 0.0v 239.495n 0.0v 239.505n 0.0v 249.495n 0.0v 249.505n 0.0v 259.495n 0.0v 259.505n 0.0v 269.495n 0.0v 269.505n 0.0v 279.495n 0.0v 279.505n 1.7v 289.495n 1.7v 289.505n 1.7v 299.495n 1.7v 299.505n 1.7v 309.495n 1.7v 309.505n 1.7v 319.495n 1.7v 319.505n 1.7v 329.495n 1.7v 329.505n 1.7v 339.495n 1.7v 339.505n 0.0v 349.495n 0.0v 349.505n 0.0v 359.495n 0.0v 359.505n 1.7v 369.495n 1.7v 369.505n 1.7v 379.495n 1.7v 379.505n 0.0v 389.495n 0.0v 389.505n 0.0v 399.495n 0.0v 399.505n 0.0v 409.495n 0.0v 409.505n 0.0v 419.495n 0.0v 419.505n 0.0v 429.495n 0.0v 429.505n 0.0v 439.495n 0.0v 439.505n 0.0v 449.495n 0.0v 449.505n 0.0v 459.495n 0.0v 459.505n 0.0v 469.495n 0.0v 469.505n 0.0v 479.495n 0.0v 479.505n 0.0v 489.495n 0.0v 489.505n 0.0v 499.495n 0.0v 499.505n 0.0v 509.495n 0.0v 509.505n 0.0v 519.495n 0.0v 519.505n 0.0v 529.495n 0.0v 529.505n 0.0v 539.495n 0.0v 539.505n 0.0v 549.495n 0.0v 549.505n 0.0v 559.495n 0.0v 559.505n 1.7v 569.495n 1.7v 569.505n 1.7v 579.495n 1.7v 579.505n 0.0v 589.495n 0.0v 589.505n 0.0v 599.495n 0.0v 599.505n 0.0v 609.495n 0.0v 609.505n 0.0v 619.495n 0.0v 619.505n 0.0v 629.495n 0.0v 629.505n 0.0v 639.495n 0.0v 639.505n 0.0v 649.495n 0.0v 649.505n 0.0v 659.495n 0.0v 659.505n 1.7v 669.495n 1.7v 669.505n 1.7v 679.495n 1.7v 679.505n 1.7v 689.495n 1.7v 689.505n 1.7v 699.495n 1.7v 699.505n 1.7v 709.495n 1.7v 709.505n 1.7v 719.495n 1.7v 719.505n 1.7v 729.495n 1.7v 729.505n 1.7v 739.495n 1.7v 739.505n 0.0v 749.495n 0.0v 749.505n 1.7v 759.495n 1.7v 759.505n 1.7v 769.495n 1.7v 769.505n 0.0v 779.495n 0.0v 779.505n 1.7v 789.495n 1.7v 789.505n 1.7v 799.495n 1.7v 799.505n 1.7v 809.495n 1.7v 809.505n 1.7v 819.495n 1.7v 819.505n 1.7v 829.495n 1.7v 829.505n 1.7v 839.495n 1.7v 839.505n 1.7v 849.495n 1.7v 849.505n 1.7v 859.495n 1.7v 859.505n 0.0v 869.495n 0.0v 869.505n 0.0v 879.495n 0.0v 879.505n 1.7v 889.495n 1.7v 889.505n 1.7v 899.495n 1.7v 899.505n 1.7v 909.495n 1.7v 909.505n 1.7v 919.495n 1.7v 919.505n 0.0v 929.495n 0.0v 929.505n 1.7v 939.495n 1.7v 939.505n 1.7v 949.495n 1.7v 949.505n 0.0v 959.495n 0.0v 959.505n 1.7v 969.495n 1.7v 969.505n 1.7v 979.495n 1.7v 979.505n 0.0v 989.495n 0.0v 989.505n 0.0v 999.495n 0.0v 999.505n 0.0v 1009.495n 0.0v 1009.505n 0.0v 1019.495n 0.0v 1019.505n 1.7v 1029.495n 1.7v 1029.505n 1.7v 1039.495n 1.7v 1039.505n 1.7v 1049.495n 1.7v 1049.505n 1.7v 1059.495n 1.7v 1059.505n 1.7v 1069.495n 1.7v 1069.505n 1.7v 1079.495n 1.7v 1079.505n 1.7v 1089.495n 1.7v 1089.505n 1.7v 1099.495n 1.7v 1099.505n 1.7v 1109.495n 1.7v 1109.505n 1.7v 1119.495n 1.7v 1119.505n 1.7v 1129.495n 1.7v 1129.505n 0.0v 1139.495n 0.0v 1139.505n 0.0v 1149.495n 0.0v 1149.505n 0.0v 1159.495n 0.0v 1159.505n 0.0v 1169.495n 0.0v 1169.505n 0.0v 1179.495n 0.0v 1179.505n 0.0v 1189.495n 0.0v 1189.505n 1.7v 1199.495n 1.7v 1199.505n 0.0v 1209.495n 0.0v 1209.505n 0.0v 1219.495n 0.0v 1219.505n 0.0v 1229.495n 0.0v 1229.505n 1.7v 1239.495n 1.7v 1239.505n 0.0v 1249.495n 0.0v 1249.505n 0.0v 1259.495n 0.0v 1259.505n 0.0v 1269.495n 0.0v 1269.505n 0.0v 1279.495n 0.0v 1279.505n 0.0v 1289.495n 0.0v 1289.505n 1.7v 1299.495n 1.7v 1299.505n 1.7v 1309.495n 1.7v 1309.505n 1.7v 1319.495n 1.7v 1319.505n 1.7v 1329.495n 1.7v 1329.505n 1.7v 1339.495n 1.7v 1339.505n 1.7v 1349.495n 1.7v 1349.505n 1.7v 1359.495n 1.7v 1359.505n 1.7v 1369.495n 1.7v 1369.505n 0.0v 1379.495n 0.0v 1379.505n 0.0v 1389.495n 0.0v 1389.505n 0.0v 1399.495n 0.0v 1399.505n 0.0v 1409.495n 0.0v 1409.505n 0.0v 1419.495n 0.0v 1419.505n 1.7v 1429.495n 1.7v 1429.505n 0.0v 1439.495n 0.0v 1439.505n 0.0v 1449.495n 0.0v 1449.505n 0.0v 1459.495n 0.0v 1459.505n 1.7v 1469.495n 1.7v 1469.505n 1.7v 1479.495n 1.7v 1479.505n 1.7v 1489.495n 1.7v 1489.505n 1.7v 1499.495n 1.7v 1499.505n 1.7v 1509.495n 1.7v 1509.505n 1.7v 1519.495n 1.7v 1519.505n 1.7v 1529.495n 1.7v 1529.505n 1.7v 1539.495n 1.7v 1539.505n 1.7v 1549.495n 1.7v 1549.505n 1.7v 1559.495n 1.7v 1559.505n 1.7v 1569.495n 1.7v 1569.505n 1.7v 1579.495n 1.7v 1579.505n 1.7v 1589.495n 1.7v 1589.505n 1.7v 1599.495n 1.7v 1599.505n 1.7v 1609.495n 1.7v 1609.505n 0.0v 1619.495n 0.0v 1619.505n 0.0v 1629.495n 0.0v 1629.505n 0.0v 1639.495n 0.0v 1639.505n 0.0v 1649.495n 0.0v 1649.505n 0.0v 1659.495n 0.0v 1659.505n 0.0v 1669.495n 0.0v 1669.505n 0.0v 1679.495n 0.0v 1679.505n 0.0v 1689.495n 0.0v 1689.505n 0.0v 1699.495n 0.0v 1699.505n 0.0v 1709.495n 0.0v 1709.505n 0.0v 1719.495n 0.0v 1719.505n 0.0v 1729.495n 0.0v 1729.505n 0.0v 1739.495n 0.0v 1739.505n 0.0v 1749.495n 0.0v 1749.505n 0.0v 1759.495n 0.0v 1759.505n 0.0v 1769.495n 0.0v 1769.505n 1.7v 1779.495n 1.7v 1779.505n 1.7v 1789.495n 1.7v 1789.505n 1.7v 1799.495n 1.7v 1799.505n 1.7v 1809.495n 1.7v 1809.505n 0.0v 1819.495n 0.0v 1819.505n 0.0v 1829.495n 0.0v 1829.505n 1.7v 1839.495n 1.7v 1839.505n 1.7v 1849.495n 1.7v 1849.505n 1.7v 1859.495n 1.7v 1859.505n 0.0v 1869.495n 0.0v 1869.505n 0.0v 1879.495n 0.0v 1879.505n 0.0v 1889.495n 0.0v 1889.505n 0.0v 1899.495n 0.0v 1899.505n 0.0v 1909.495n 0.0v 1909.505n 0.0v 1919.495n 0.0v 1919.505n 1.7v 1929.495n 1.7v 1929.505n 1.7v 1939.495n 1.7v 1939.505n 0.0v 1949.495n 0.0v 1949.505n 0.0v 1959.495n 0.0v 1959.505n 1.7v 1969.495n 1.7v 1969.505n 1.7v 1979.495n 1.7v 1979.505n 0.0v 1989.495n 0.0v 1989.505n 0.0v 1999.495n 0.0v 1999.505n 0.0v 2009.495n 0.0v 2009.505n 0.0v 2019.495n 0.0v 2019.505n 0.0v 2029.495n 0.0v 2029.505n 0.0v 2039.495n 0.0v 2039.505n 0.0v 2049.495n 0.0v 2049.505n 0.0v )
* (time, data): [(0, 0), (10, 0), (20, 0), (30, 0), (40, 1), (50, 1), (60, 1), (70, 1), (80, 1), (90, 1), (100, 0), (110, 0), (120, 0), (130, 0), (140, 0), (150, 1), (160, 1), (170, 0), (180, 0), (190, 0), (200, 0), (210, 0), (220, 0), (230, 0), (240, 0), (250, 0), (260, 0), (270, 0), (280, 0), (290, 0), (300, 1), (310, 1), (320, 1), (330, 1), (340, 1), (350, 0), (360, 0), (370, 1), (380, 0), (390, 0), (400, 0), (410, 0), (420, 0), (430, 0), (440, 0), (450, 0), (460, 0), (470, 0), (480, 0), (490, 1), (500, 1), (510, 1), (520, 1), (530, 1), (540, 0), (550, 0), (560, 0), (570, 0), (580, 1), (590, 1), (600, 0), (610, 0), (620, 0), (630, 0), (640, 0), (650, 1), (660, 1), (670, 1), (680, 1), (690, 0), (700, 0), (710, 0), (720, 0), (730, 1), (740, 0), (750, 0), (760, 0), (770, 1), (780, 1), (790, 1), (800, 1), (810, 1), (820, 1), (830, 1), (840, 1), (850, 1), (860, 1), (870, 1), (880, 0), (890, 1), (900, 1), (910, 1), (920, 0), (930, 1), (940, 1), (950, 1), (960, 1), (970, 1), (980, 1), (990, 1), (1000, 1), (1010, 1), (1020, 0), (1030, 0), (1040, 0), (1050, 0), (1060, 0), (1070, 0), (1080, 0), (1090, 0), (1100, 0), (1110, 0), (1120, 0), (1130, 0), (1140, 1), (1150, 1), (1160, 1), (1170, 1), (1180, 1), (1190, 1), (1200, 0), (1210, 0), (1220, 0), (1230, 1), (1240, 1), (1250, 1), (1260, 1), (1270, 1), (1280, 1), (1290, 1), (1300, 0), (1310, 0), (1320, 0), (1330, 0), (1340, 0), (1350, 0), (1360, 0), (1370, 0), (1380, 0), (1390, 1), (1400, 1), (1410, 1), (1420, 0), (1430, 0), (1440, 0), (1450, 0), (1460, 1), (1470, 1), (1480, 1), (1490, 1), (1500, 0), (1510, 0), (1520, 0), (1530, 1), (1540, 1), (1550, 1), (1560, 1), (1570, 1), (1580, 1), (1590, 1), (1600, 0), (1610, 0), (1620, 0), (1630, 0), (1640, 0), (1650, 0), (1660, 0), (1670, 0), (1680, 0), (1690, 0), (1700, 0), (1710, 0), (1720, 0), (1730, 0), (1740, 0), (1750, 0), (1760, 0), (1770, 0), (1780, 0), (1790, 0), (1800, 0), (1810, 0), (1820, 0), (1830, 0), (1840, 0), (1850, 0), (1860, 1), (1870, 1), (1880, 1), (1890, 1), (1900, 1), (1910, 1), (1920, 0), (1930, 0), (1940, 0), (1950, 0), (1960, 1), (1970, 1), (1980, 0), (1990, 0), (2000, 0), (2010, 0), (2020, 0), (2030, 0), (2040, 0), (2050, 0)]
Va1_1  a1_1  0 PWL (0n 0.0v 9.495n 0.0v 9.505n 0.0v 19.495n 0.0v 19.505n 0.0v 29.495n 0.0v 29.505n 0.0v 39.495n 0.0v 39.505n 1.7v 49.495n 1.7v 49.505n 1.7v 59.495n 1.7v 59.505n 1.7v 69.495n 1.7v 69.505n 1.7v 79.495n 1.7v 79.505n 1.7v 89.495n 1.7v 89.505n 1.7v 99.495n 1.7v 99.505n 0.0v 109.495n 0.0v 109.505n 0.0v 119.495n 0.0v 119.505n 0.0v 129.495n 0.0v 129.505n 0.0v 139.495n 0.0v 139.505n 0.0v 149.495n 0.0v 149.505n 1.7v 159.495n 1.7v 159.505n 1.7v 169.495n 1.7v 169.505n 0.0v 179.495n 0.0v 179.505n 0.0v 189.495n 0.0v 189.505n 0.0v 199.495n 0.0v 199.505n 0.0v 209.495n 0.0v 209.505n 0.0v 219.495n 0.0v 219.505n 0.0v 229.495n 0.0v 229.505n 0.0v 239.495n 0.0v 239.505n 0.0v 249.495n 0.0v 249.505n 0.0v 259.495n 0.0v 259.505n 0.0v 269.495n 0.0v 269.505n 0.0v 279.495n 0.0v 279.505n 0.0v 289.495n 0.0v 289.505n 0.0v 299.495n 0.0v 299.505n 1.7v 309.495n 1.7v 309.505n 1.7v 319.495n 1.7v 319.505n 1.7v 329.495n 1.7v 329.505n 1.7v 339.495n 1.7v 339.505n 1.7v 349.495n 1.7v 349.505n 0.0v 359.495n 0.0v 359.505n 0.0v 369.495n 0.0v 369.505n 1.7v 379.495n 1.7v 379.505n 0.0v 389.495n 0.0v 389.505n 0.0v 399.495n 0.0v 399.505n 0.0v 409.495n 0.0v 409.505n 0.0v 419.495n 0.0v 419.505n 0.0v 429.495n 0.0v 429.505n 0.0v 439.495n 0.0v 439.505n 0.0v 449.495n 0.0v 449.505n 0.0v 459.495n 0.0v 459.505n 0.0v 469.495n 0.0v 469.505n 0.0v 479.495n 0.0v 479.505n 0.0v 489.495n 0.0v 489.505n 1.7v 499.495n 1.7v 499.505n 1.7v 509.495n 1.7v 509.505n 1.7v 519.495n 1.7v 519.505n 1.7v 529.495n 1.7v 529.505n 1.7v 539.495n 1.7v 539.505n 0.0v 549.495n 0.0v 549.505n 0.0v 559.495n 0.0v 559.505n 0.0v 569.495n 0.0v 569.505n 0.0v 579.495n 0.0v 579.505n 1.7v 589.495n 1.7v 589.505n 1.7v 599.495n 1.7v 599.505n 0.0v 609.495n 0.0v 609.505n 0.0v 619.495n 0.0v 619.505n 0.0v 629.495n 0.0v 629.505n 0.0v 639.495n 0.0v 639.505n 0.0v 649.495n 0.0v 649.505n 1.7v 659.495n 1.7v 659.505n 1.7v 669.495n 1.7v 669.505n 1.7v 679.495n 1.7v 679.505n 1.7v 689.495n 1.7v 689.505n 0.0v 699.495n 0.0v 699.505n 0.0v 709.495n 0.0v 709.505n 0.0v 719.495n 0.0v 719.505n 0.0v 729.495n 0.0v 729.505n 1.7v 739.495n 1.7v 739.505n 0.0v 749.495n 0.0v 749.505n 0.0v 759.495n 0.0v 759.505n 0.0v 769.495n 0.0v 769.505n 1.7v 779.495n 1.7v 779.505n 1.7v 789.495n 1.7v 789.505n 1.7v 799.495n 1.7v 799.505n 1.7v 809.495n 1.7v 809.505n 1.7v 819.495n 1.7v 819.505n 1.7v 829.495n 1.7v 829.505n 1.7v 839.495n 1.7v 839.505n 1.7v 849.495n 1.7v 849.505n 1.7v 859.495n 1.7v 859.505n 1.7v 869.495n 1.7v 869.505n 1.7v 879.495n 1.7v 879.505n 0.0v 889.495n 0.0v 889.505n 1.7v 899.495n 1.7v 899.505n 1.7v 909.495n 1.7v 909.505n 1.7v 919.495n 1.7v 919.505n 0.0v 929.495n 0.0v 929.505n 1.7v 939.495n 1.7v 939.505n 1.7v 949.495n 1.7v 949.505n 1.7v 959.495n 1.7v 959.505n 1.7v 969.495n 1.7v 969.505n 1.7v 979.495n 1.7v 979.505n 1.7v 989.495n 1.7v 989.505n 1.7v 999.495n 1.7v 999.505n 1.7v 1009.495n 1.7v 1009.505n 1.7v 1019.495n 1.7v 1019.505n 0.0v 1029.495n 0.0v 1029.505n 0.0v 1039.495n 0.0v 1039.505n 0.0v 1049.495n 0.0v 1049.505n 0.0v 1059.495n 0.0v 1059.505n 0.0v 1069.495n 0.0v 1069.505n 0.0v 1079.495n 0.0v 1079.505n 0.0v 1089.495n 0.0v 1089.505n 0.0v 1099.495n 0.0v 1099.505n 0.0v 1109.495n 0.0v 1109.505n 0.0v 1119.495n 0.0v 1119.505n 0.0v 1129.495n 0.0v 1129.505n 0.0v 1139.495n 0.0v 1139.505n 1.7v 1149.495n 1.7v 1149.505n 1.7v 1159.495n 1.7v 1159.505n 1.7v 1169.495n 1.7v 1169.505n 1.7v 1179.495n 1.7v 1179.505n 1.7v 1189.495n 1.7v 1189.505n 1.7v 1199.495n 1.7v 1199.505n 0.0v 1209.495n 0.0v 1209.505n 0.0v 1219.495n 0.0v 1219.505n 0.0v 1229.495n 0.0v 1229.505n 1.7v 1239.495n 1.7v 1239.505n 1.7v 1249.495n 1.7v 1249.505n 1.7v 1259.495n 1.7v 1259.505n 1.7v 1269.495n 1.7v 1269.505n 1.7v 1279.495n 1.7v 1279.505n 1.7v 1289.495n 1.7v 1289.505n 1.7v 1299.495n 1.7v 1299.505n 0.0v 1309.495n 0.0v 1309.505n 0.0v 1319.495n 0.0v 1319.505n 0.0v 1329.495n 0.0v 1329.505n 0.0v 1339.495n 0.0v 1339.505n 0.0v 1349.495n 0.0v 1349.505n 0.0v 1359.495n 0.0v 1359.505n 0.0v 1369.495n 0.0v 1369.505n 0.0v 1379.495n 0.0v 1379.505n 0.0v 1389.495n 0.0v 1389.505n 1.7v 1399.495n 1.7v 1399.505n 1.7v 1409.495n 1.7v 1409.505n 1.7v 1419.495n 1.7v 1419.505n 0.0v 1429.495n 0.0v 1429.505n 0.0v 1439.495n 0.0v 1439.505n 0.0v 1449.495n 0.0v 1449.505n 0.0v 1459.495n 0.0v 1459.505n 1.7v 1469.495n 1.7v 1469.505n 1.7v 1479.495n 1.7v 1479.505n 1.7v 1489.495n 1.7v 1489.505n 1.7v 1499.495n 1.7v 1499.505n 0.0v 1509.495n 0.0v 1509.505n 0.0v 1519.495n 0.0v 1519.505n 0.0v 1529.495n 0.0v 1529.505n 1.7v 1539.495n 1.7v 1539.505n 1.7v 1549.495n 1.7v 1549.505n 1.7v 1559.495n 1.7v 1559.505n 1.7v 1569.495n 1.7v 1569.505n 1.7v 1579.495n 1.7v 1579.505n 1.7v 1589.495n 1.7v 1589.505n 1.7v 1599.495n 1.7v 1599.505n 0.0v 1609.495n 0.0v 1609.505n 0.0v 1619.495n 0.0v 1619.505n 0.0v 1629.495n 0.0v 1629.505n 0.0v 1639.495n 0.0v 1639.505n 0.0v 1649.495n 0.0v 1649.505n 0.0v 1659.495n 0.0v 1659.505n 0.0v 1669.495n 0.0v 1669.505n 0.0v 1679.495n 0.0v 1679.505n 0.0v 1689.495n 0.0v 1689.505n 0.0v 1699.495n 0.0v 1699.505n 0.0v 1709.495n 0.0v 1709.505n 0.0v 1719.495n 0.0v 1719.505n 0.0v 1729.495n 0.0v 1729.505n 0.0v 1739.495n 0.0v 1739.505n 0.0v 1749.495n 0.0v 1749.505n 0.0v 1759.495n 0.0v 1759.505n 0.0v 1769.495n 0.0v 1769.505n 0.0v 1779.495n 0.0v 1779.505n 0.0v 1789.495n 0.0v 1789.505n 0.0v 1799.495n 0.0v 1799.505n 0.0v 1809.495n 0.0v 1809.505n 0.0v 1819.495n 0.0v 1819.505n 0.0v 1829.495n 0.0v 1829.505n 0.0v 1839.495n 0.0v 1839.505n 0.0v 1849.495n 0.0v 1849.505n 0.0v 1859.495n 0.0v 1859.505n 1.7v 1869.495n 1.7v 1869.505n 1.7v 1879.495n 1.7v 1879.505n 1.7v 1889.495n 1.7v 1889.505n 1.7v 1899.495n 1.7v 1899.505n 1.7v 1909.495n 1.7v 1909.505n 1.7v 1919.495n 1.7v 1919.505n 0.0v 1929.495n 0.0v 1929.505n 0.0v 1939.495n 0.0v 1939.505n 0.0v 1949.495n 0.0v 1949.505n 0.0v 1959.495n 0.0v 1959.505n 1.7v 1969.495n 1.7v 1969.505n 1.7v 1979.495n 1.7v 1979.505n 0.0v 1989.495n 0.0v 1989.505n 0.0v 1999.495n 0.0v 1999.505n 0.0v 2009.495n 0.0v 2009.505n 0.0v 2019.495n 0.0v 2019.505n 0.0v 2029.495n 0.0v 2029.505n 0.0v 2039.495n 0.0v 2039.505n 0.0v 2049.495n 0.0v 2049.505n 0.0v )
* (time, data): [(0, 0), (10, 0), (20, 0), (30, 0), (40, 0), (50, 0), (60, 0), (70, 1), (80, 1), (90, 1), (100, 0), (110, 0), (120, 0), (130, 0), (140, 0), (150, 0), (160, 0), (170, 0), (180, 0), (190, 0), (200, 0), (210, 0), (220, 0), (230, 0), (240, 0), (250, 0), (260, 0), (270, 0), (280, 0), (290, 0), (300, 1), (310, 1), (320, 1), (330, 1), (340, 0), (350, 0), (360, 0), (370, 1), (380, 0), (390, 0), (400, 0), (410, 0), (420, 0), (430, 0), (440, 0), (450, 0), (460, 0), (470, 0), (480, 0), (490, 0), (500, 0), (510, 0), (520, 0), (530, 0), (540, 0), (550, 0), (560, 0), (570, 0), (580, 0), (590, 0), (600, 0), (610, 0), (620, 0), (630, 0), (640, 0), (650, 0), (660, 1), (670, 1), (680, 1), (690, 0), (700, 0), (710, 0), (720, 0), (730, 0), (740, 0), (750, 0), (760, 0), (770, 0), (780, 0), (790, 0), (800, 0), (810, 0), (820, 0), (830, 0), (840, 0), (850, 0), (860, 0), (870, 0), (880, 0), (890, 0), (900, 1), (910, 1), (920, 0), (930, 1), (940, 1), (950, 0), (960, 0), (970, 1), (980, 0), (990, 0), (1000, 0), (1010, 0), (1020, 0), (1030, 0), (1040, 0), (1050, 0), (1060, 0), (1070, 0), (1080, 0), (1090, 0), (1100, 0), (1110, 0), (1120, 0), (1130, 0), (1140, 0), (1150, 0), (1160, 0), (1170, 0), (1180, 0), (1190, 0), (1200, 0), (1210, 0), (1220, 0), (1230, 1), (1240, 0), (1250, 0), (1260, 0), (1270, 0), (1280, 0), (1290, 0), (1300, 0), (1310, 0), (1320, 0), (1330, 0), (1340, 0), (1350, 0), (1360, 0), (1370, 0), (1380, 0), (1390, 0), (1400, 0), (1410, 0), (1420, 0), (1430, 0), (1440, 0), (1450, 0), (1460, 0), (1470, 0), (1480, 0), (1490, 0), (1500, 0), (1510, 0), (1520, 0), (1530, 0), (1540, 0), (1550, 0), (1560, 0), (1570, 0), (1580, 0), (1590, 0), (1600, 0), (1610, 0), (1620, 0), (1630, 0), (1640, 0), (1650, 0), (1660, 0), (1670, 0), (1680, 0), (1690, 0), (1700, 0), (1710, 0), (1720, 0), (1730, 0), (1740, 0), (1750, 0), (1760, 0), (1770, 0), (1780, 0), (1790, 0), (1800, 0), (1810, 0), (1820, 0), (1830, 0), (1840, 0), (1850, 0), (1860, 0), (1870, 0), (1880, 0), (1890, 0), (1900, 0), (1910, 0), (1920, 0), (1930, 0), (1940, 0), (1950, 0), (1960, 0), (1970, 0), (1980, 0), (1990, 0), (2000, 0), (2010, 0), (2020, 0), (2030, 0), (2040, 0), (2050, 0)]
Va1_2  a1_2  0 PWL (0n 0.0v 9.495n 0.0v 9.505n 0.0v 19.495n 0.0v 19.505n 0.0v 29.495n 0.0v 29.505n 0.0v 39.495n 0.0v 39.505n 0.0v 49.495n 0.0v 49.505n 0.0v 59.495n 0.0v 59.505n 0.0v 69.495n 0.0v 69.505n 1.7v 79.495n 1.7v 79.505n 1.7v 89.495n 1.7v 89.505n 1.7v 99.495n 1.7v 99.505n 0.0v 109.495n 0.0v 109.505n 0.0v 119.495n 0.0v 119.505n 0.0v 129.495n 0.0v 129.505n 0.0v 139.495n 0.0v 139.505n 0.0v 149.495n 0.0v 149.505n 0.0v 159.495n 0.0v 159.505n 0.0v 169.495n 0.0v 169.505n 0.0v 179.495n 0.0v 179.505n 0.0v 189.495n 0.0v 189.505n 0.0v 199.495n 0.0v 199.505n 0.0v 209.495n 0.0v 209.505n 0.0v 219.495n 0.0v 219.505n 0.0v 229.495n 0.0v 229.505n 0.0v 239.495n 0.0v 239.505n 0.0v 249.495n 0.0v 249.505n 0.0v 259.495n 0.0v 259.505n 0.0v 269.495n 0.0v 269.505n 0.0v 279.495n 0.0v 279.505n 0.0v 289.495n 0.0v 289.505n 0.0v 299.495n 0.0v 299.505n 1.7v 309.495n 1.7v 309.505n 1.7v 319.495n 1.7v 319.505n 1.7v 329.495n 1.7v 329.505n 1.7v 339.495n 1.7v 339.505n 0.0v 349.495n 0.0v 349.505n 0.0v 359.495n 0.0v 359.505n 0.0v 369.495n 0.0v 369.505n 1.7v 379.495n 1.7v 379.505n 0.0v 389.495n 0.0v 389.505n 0.0v 399.495n 0.0v 399.505n 0.0v 409.495n 0.0v 409.505n 0.0v 419.495n 0.0v 419.505n 0.0v 429.495n 0.0v 429.505n 0.0v 439.495n 0.0v 439.505n 0.0v 449.495n 0.0v 449.505n 0.0v 459.495n 0.0v 459.505n 0.0v 469.495n 0.0v 469.505n 0.0v 479.495n 0.0v 479.505n 0.0v 489.495n 0.0v 489.505n 0.0v 499.495n 0.0v 499.505n 0.0v 509.495n 0.0v 509.505n 0.0v 519.495n 0.0v 519.505n 0.0v 529.495n 0.0v 529.505n 0.0v 539.495n 0.0v 539.505n 0.0v 549.495n 0.0v 549.505n 0.0v 559.495n 0.0v 559.505n 0.0v 569.495n 0.0v 569.505n 0.0v 579.495n 0.0v 579.505n 0.0v 589.495n 0.0v 589.505n 0.0v 599.495n 0.0v 599.505n 0.0v 609.495n 0.0v 609.505n 0.0v 619.495n 0.0v 619.505n 0.0v 629.495n 0.0v 629.505n 0.0v 639.495n 0.0v 639.505n 0.0v 649.495n 0.0v 649.505n 0.0v 659.495n 0.0v 659.505n 1.7v 669.495n 1.7v 669.505n 1.7v 679.495n 1.7v 679.505n 1.7v 689.495n 1.7v 689.505n 0.0v 699.495n 0.0v 699.505n 0.0v 709.495n 0.0v 709.505n 0.0v 719.495n 0.0v 719.505n 0.0v 729.495n 0.0v 729.505n 0.0v 739.495n 0.0v 739.505n 0.0v 749.495n 0.0v 749.505n 0.0v 759.495n 0.0v 759.505n 0.0v 769.495n 0.0v 769.505n 0.0v 779.495n 0.0v 779.505n 0.0v 789.495n 0.0v 789.505n 0.0v 799.495n 0.0v 799.505n 0.0v 809.495n 0.0v 809.505n 0.0v 819.495n 0.0v 819.505n 0.0v 829.495n 0.0v 829.505n 0.0v 839.495n 0.0v 839.505n 0.0v 849.495n 0.0v 849.505n 0.0v 859.495n 0.0v 859.505n 0.0v 869.495n 0.0v 869.505n 0.0v 879.495n 0.0v 879.505n 0.0v 889.495n 0.0v 889.505n 0.0v 899.495n 0.0v 899.505n 1.7v 909.495n 1.7v 909.505n 1.7v 919.495n 1.7v 919.505n 0.0v 929.495n 0.0v 929.505n 1.7v 939.495n 1.7v 939.505n 1.7v 949.495n 1.7v 949.505n 0.0v 959.495n 0.0v 959.505n 0.0v 969.495n 0.0v 969.505n 1.7v 979.495n 1.7v 979.505n 0.0v 989.495n 0.0v 989.505n 0.0v 999.495n 0.0v 999.505n 0.0v 1009.495n 0.0v 1009.505n 0.0v 1019.495n 0.0v 1019.505n 0.0v 1029.495n 0.0v 1029.505n 0.0v 1039.495n 0.0v 1039.505n 0.0v 1049.495n 0.0v 1049.505n 0.0v 1059.495n 0.0v 1059.505n 0.0v 1069.495n 0.0v 1069.505n 0.0v 1079.495n 0.0v 1079.505n 0.0v 1089.495n 0.0v 1089.505n 0.0v 1099.495n 0.0v 1099.505n 0.0v 1109.495n 0.0v 1109.505n 0.0v 1119.495n 0.0v 1119.505n 0.0v 1129.495n 0.0v 1129.505n 0.0v 1139.495n 0.0v 1139.505n 0.0v 1149.495n 0.0v 1149.505n 0.0v 1159.495n 0.0v 1159.505n 0.0v 1169.495n 0.0v 1169.505n 0.0v 1179.495n 0.0v 1179.505n 0.0v 1189.495n 0.0v 1189.505n 0.0v 1199.495n 0.0v 1199.505n 0.0v 1209.495n 0.0v 1209.505n 0.0v 1219.495n 0.0v 1219.505n 0.0v 1229.495n 0.0v 1229.505n 1.7v 1239.495n 1.7v 1239.505n 0.0v 1249.495n 0.0v 1249.505n 0.0v 1259.495n 0.0v 1259.505n 0.0v 1269.495n 0.0v 1269.505n 0.0v 1279.495n 0.0v 1279.505n 0.0v 1289.495n 0.0v 1289.505n 0.0v 1299.495n 0.0v 1299.505n 0.0v 1309.495n 0.0v 1309.505n 0.0v 1319.495n 0.0v 1319.505n 0.0v 1329.495n 0.0v 1329.505n 0.0v 1339.495n 0.0v 1339.505n 0.0v 1349.495n 0.0v 1349.505n 0.0v 1359.495n 0.0v 1359.505n 0.0v 1369.495n 0.0v 1369.505n 0.0v 1379.495n 0.0v 1379.505n 0.0v 1389.495n 0.0v 1389.505n 0.0v 1399.495n 0.0v 1399.505n 0.0v 1409.495n 0.0v 1409.505n 0.0v 1419.495n 0.0v 1419.505n 0.0v 1429.495n 0.0v 1429.505n 0.0v 1439.495n 0.0v 1439.505n 0.0v 1449.495n 0.0v 1449.505n 0.0v 1459.495n 0.0v 1459.505n 0.0v 1469.495n 0.0v 1469.505n 0.0v 1479.495n 0.0v 1479.505n 0.0v 1489.495n 0.0v 1489.505n 0.0v 1499.495n 0.0v 1499.505n 0.0v 1509.495n 0.0v 1509.505n 0.0v 1519.495n 0.0v 1519.505n 0.0v 1529.495n 0.0v 1529.505n 0.0v 1539.495n 0.0v 1539.505n 0.0v 1549.495n 0.0v 1549.505n 0.0v 1559.495n 0.0v 1559.505n 0.0v 1569.495n 0.0v 1569.505n 0.0v 1579.495n 0.0v 1579.505n 0.0v 1589.495n 0.0v 1589.505n 0.0v 1599.495n 0.0v 1599.505n 0.0v 1609.495n 0.0v 1609.505n 0.0v 1619.495n 0.0v 1619.505n 0.0v 1629.495n 0.0v 1629.505n 0.0v 1639.495n 0.0v 1639.505n 0.0v 1649.495n 0.0v 1649.505n 0.0v 1659.495n 0.0v 1659.505n 0.0v 1669.495n 0.0v 1669.505n 0.0v 1679.495n 0.0v 1679.505n 0.0v 1689.495n 0.0v 1689.505n 0.0v 1699.495n 0.0v 1699.505n 0.0v 1709.495n 0.0v 1709.505n 0.0v 1719.495n 0.0v 1719.505n 0.0v 1729.495n 0.0v 1729.505n 0.0v 1739.495n 0.0v 1739.505n 0.0v 1749.495n 0.0v 1749.505n 0.0v 1759.495n 0.0v 1759.505n 0.0v 1769.495n 0.0v 1769.505n 0.0v 1779.495n 0.0v 1779.505n 0.0v 1789.495n 0.0v 1789.505n 0.0v 1799.495n 0.0v 1799.505n 0.0v 1809.495n 0.0v 1809.505n 0.0v 1819.495n 0.0v 1819.505n 0.0v 1829.495n 0.0v 1829.505n 0.0v 1839.495n 0.0v 1839.505n 0.0v 1849.495n 0.0v 1849.505n 0.0v 1859.495n 0.0v 1859.505n 0.0v 1869.495n 0.0v 1869.505n 0.0v 1879.495n 0.0v 1879.505n 0.0v 1889.495n 0.0v 1889.505n 0.0v 1899.495n 0.0v 1899.505n 0.0v 1909.495n 0.0v 1909.505n 0.0v 1919.495n 0.0v 1919.505n 0.0v 1929.495n 0.0v 1929.505n 0.0v 1939.495n 0.0v 1939.505n 0.0v 1949.495n 0.0v 1949.505n 0.0v 1959.495n 0.0v 1959.505n 0.0v 1969.495n 0.0v 1969.505n 0.0v 1979.495n 0.0v 1979.505n 0.0v 1989.495n 0.0v 1989.505n 0.0v 1999.495n 0.0v 1999.505n 0.0v 2009.495n 0.0v 2009.505n 0.0v 2019.495n 0.0v 2019.505n 0.0v 2029.495n 0.0v 2029.505n 0.0v 2039.495n 0.0v 2039.505n 0.0v 2049.495n 0.0v 2049.505n 0.0v )
* (time, data): [(0, 0), (10, 0), (20, 0), (30, 0), (40, 0), (50, 0), (60, 0), (70, 1), (80, 1), (90, 1), (100, 0), (110, 0), (120, 0), (130, 0), (140, 0), (150, 0), (160, 0), (170, 0), (180, 0), (190, 0), (200, 0), (210, 0), (220, 0), (230, 0), (240, 0), (250, 0), (260, 0), (270, 0), (280, 0), (290, 0), (300, 1), (310, 1), (320, 1), (330, 1), (340, 0), (350, 0), (360, 0), (370, 1), (380, 0), (390, 0), (400, 0), (410, 0), (420, 0), (430, 0), (440, 0), (450, 0), (460, 0), (470, 0), (480, 0), (490, 0), (500, 0), (510, 0), (520, 0), (530, 0), (540, 0), (550, 0), (560, 0), (570, 0), (580, 0), (590, 0), (600, 0), (610, 0), (620, 0), (630, 0), (640, 0), (650, 0), (660, 1), (670, 1), (680, 1), (690, 0), (700, 0), (710, 0), (720, 0), (730, 0), (740, 0), (750, 0), (760, 0), (770, 0), (780, 0), (790, 0), (800, 0), (810, 0), (820, 0), (830, 0), (840, 0), (850, 0), (860, 0), (870, 0), (880, 0), (890, 0), (900, 1), (910, 1), (920, 0), (930, 1), (940, 1), (950, 0), (960, 0), (970, 1), (980, 0), (990, 0), (1000, 0), (1010, 0), (1020, 0), (1030, 0), (1040, 0), (1050, 0), (1060, 0), (1070, 0), (1080, 0), (1090, 0), (1100, 0), (1110, 0), (1120, 0), (1130, 0), (1140, 0), (1150, 0), (1160, 0), (1170, 0), (1180, 0), (1190, 0), (1200, 0), (1210, 0), (1220, 0), (1230, 1), (1240, 0), (1250, 0), (1260, 0), (1270, 0), (1280, 0), (1290, 0), (1300, 0), (1310, 0), (1320, 0), (1330, 0), (1340, 0), (1350, 0), (1360, 0), (1370, 0), (1380, 0), (1390, 0), (1400, 0), (1410, 0), (1420, 0), (1430, 0), (1440, 0), (1450, 0), (1460, 0), (1470, 0), (1480, 0), (1490, 0), (1500, 0), (1510, 0), (1520, 0), (1530, 0), (1540, 0), (1550, 0), (1560, 0), (1570, 0), (1580, 0), (1590, 0), (1600, 0), (1610, 0), (1620, 0), (1630, 0), (1640, 0), (1650, 0), (1660, 0), (1670, 0), (1680, 0), (1690, 0), (1700, 0), (1710, 0), (1720, 0), (1730, 0), (1740, 0), (1750, 0), (1760, 0), (1770, 0), (1780, 0), (1790, 0), (1800, 0), (1810, 0), (1820, 0), (1830, 0), (1840, 0), (1850, 0), (1860, 0), (1870, 0), (1880, 0), (1890, 0), (1900, 0), (1910, 0), (1920, 0), (1930, 0), (1940, 0), (1950, 0), (1960, 0), (1970, 0), (1980, 0), (1990, 0), (2000, 0), (2010, 0), (2020, 0), (2030, 0), (2040, 0), (2050, 0)]
Va1_3  a1_3  0 PWL (0n 0.0v 9.495n 0.0v 9.505n 0.0v 19.495n 0.0v 19.505n 0.0v 29.495n 0.0v 29.505n 0.0v 39.495n 0.0v 39.505n 0.0v 49.495n 0.0v 49.505n 0.0v 59.495n 0.0v 59.505n 0.0v 69.495n 0.0v 69.505n 1.7v 79.495n 1.7v 79.505n 1.7v 89.495n 1.7v 89.505n 1.7v 99.495n 1.7v 99.505n 0.0v 109.495n 0.0v 109.505n 0.0v 119.495n 0.0v 119.505n 0.0v 129.495n 0.0v 129.505n 0.0v 139.495n 0.0v 139.505n 0.0v 149.495n 0.0v 149.505n 0.0v 159.495n 0.0v 159.505n 0.0v 169.495n 0.0v 169.505n 0.0v 179.495n 0.0v 179.505n 0.0v 189.495n 0.0v 189.505n 0.0v 199.495n 0.0v 199.505n 0.0v 209.495n 0.0v 209.505n 0.0v 219.495n 0.0v 219.505n 0.0v 229.495n 0.0v 229.505n 0.0v 239.495n 0.0v 239.505n 0.0v 249.495n 0.0v 249.505n 0.0v 259.495n 0.0v 259.505n 0.0v 269.495n 0.0v 269.505n 0.0v 279.495n 0.0v 279.505n 0.0v 289.495n 0.0v 289.505n 0.0v 299.495n 0.0v 299.505n 1.7v 309.495n 1.7v 309.505n 1.7v 319.495n 1.7v 319.505n 1.7v 329.495n 1.7v 329.505n 1.7v 339.495n 1.7v 339.505n 0.0v 349.495n 0.0v 349.505n 0.0v 359.495n 0.0v 359.505n 0.0v 369.495n 0.0v 369.505n 1.7v 379.495n 1.7v 379.505n 0.0v 389.495n 0.0v 389.505n 0.0v 399.495n 0.0v 399.505n 0.0v 409.495n 0.0v 409.505n 0.0v 419.495n 0.0v 419.505n 0.0v 429.495n 0.0v 429.505n 0.0v 439.495n 0.0v 439.505n 0.0v 449.495n 0.0v 449.505n 0.0v 459.495n 0.0v 459.505n 0.0v 469.495n 0.0v 469.505n 0.0v 479.495n 0.0v 479.505n 0.0v 489.495n 0.0v 489.505n 0.0v 499.495n 0.0v 499.505n 0.0v 509.495n 0.0v 509.505n 0.0v 519.495n 0.0v 519.505n 0.0v 529.495n 0.0v 529.505n 0.0v 539.495n 0.0v 539.505n 0.0v 549.495n 0.0v 549.505n 0.0v 559.495n 0.0v 559.505n 0.0v 569.495n 0.0v 569.505n 0.0v 579.495n 0.0v 579.505n 0.0v 589.495n 0.0v 589.505n 0.0v 599.495n 0.0v 599.505n 0.0v 609.495n 0.0v 609.505n 0.0v 619.495n 0.0v 619.505n 0.0v 629.495n 0.0v 629.505n 0.0v 639.495n 0.0v 639.505n 0.0v 649.495n 0.0v 649.505n 0.0v 659.495n 0.0v 659.505n 1.7v 669.495n 1.7v 669.505n 1.7v 679.495n 1.7v 679.505n 1.7v 689.495n 1.7v 689.505n 0.0v 699.495n 0.0v 699.505n 0.0v 709.495n 0.0v 709.505n 0.0v 719.495n 0.0v 719.505n 0.0v 729.495n 0.0v 729.505n 0.0v 739.495n 0.0v 739.505n 0.0v 749.495n 0.0v 749.505n 0.0v 759.495n 0.0v 759.505n 0.0v 769.495n 0.0v 769.505n 0.0v 779.495n 0.0v 779.505n 0.0v 789.495n 0.0v 789.505n 0.0v 799.495n 0.0v 799.505n 0.0v 809.495n 0.0v 809.505n 0.0v 819.495n 0.0v 819.505n 0.0v 829.495n 0.0v 829.505n 0.0v 839.495n 0.0v 839.505n 0.0v 849.495n 0.0v 849.505n 0.0v 859.495n 0.0v 859.505n 0.0v 869.495n 0.0v 869.505n 0.0v 879.495n 0.0v 879.505n 0.0v 889.495n 0.0v 889.505n 0.0v 899.495n 0.0v 899.505n 1.7v 909.495n 1.7v 909.505n 1.7v 919.495n 1.7v 919.505n 0.0v 929.495n 0.0v 929.505n 1.7v 939.495n 1.7v 939.505n 1.7v 949.495n 1.7v 949.505n 0.0v 959.495n 0.0v 959.505n 0.0v 969.495n 0.0v 969.505n 1.7v 979.495n 1.7v 979.505n 0.0v 989.495n 0.0v 989.505n 0.0v 999.495n 0.0v 999.505n 0.0v 1009.495n 0.0v 1009.505n 0.0v 1019.495n 0.0v 1019.505n 0.0v 1029.495n 0.0v 1029.505n 0.0v 1039.495n 0.0v 1039.505n 0.0v 1049.495n 0.0v 1049.505n 0.0v 1059.495n 0.0v 1059.505n 0.0v 1069.495n 0.0v 1069.505n 0.0v 1079.495n 0.0v 1079.505n 0.0v 1089.495n 0.0v 1089.505n 0.0v 1099.495n 0.0v 1099.505n 0.0v 1109.495n 0.0v 1109.505n 0.0v 1119.495n 0.0v 1119.505n 0.0v 1129.495n 0.0v 1129.505n 0.0v 1139.495n 0.0v 1139.505n 0.0v 1149.495n 0.0v 1149.505n 0.0v 1159.495n 0.0v 1159.505n 0.0v 1169.495n 0.0v 1169.505n 0.0v 1179.495n 0.0v 1179.505n 0.0v 1189.495n 0.0v 1189.505n 0.0v 1199.495n 0.0v 1199.505n 0.0v 1209.495n 0.0v 1209.505n 0.0v 1219.495n 0.0v 1219.505n 0.0v 1229.495n 0.0v 1229.505n 1.7v 1239.495n 1.7v 1239.505n 0.0v 1249.495n 0.0v 1249.505n 0.0v 1259.495n 0.0v 1259.505n 0.0v 1269.495n 0.0v 1269.505n 0.0v 1279.495n 0.0v 1279.505n 0.0v 1289.495n 0.0v 1289.505n 0.0v 1299.495n 0.0v 1299.505n 0.0v 1309.495n 0.0v 1309.505n 0.0v 1319.495n 0.0v 1319.505n 0.0v 1329.495n 0.0v 1329.505n 0.0v 1339.495n 0.0v 1339.505n 0.0v 1349.495n 0.0v 1349.505n 0.0v 1359.495n 0.0v 1359.505n 0.0v 1369.495n 0.0v 1369.505n 0.0v 1379.495n 0.0v 1379.505n 0.0v 1389.495n 0.0v 1389.505n 0.0v 1399.495n 0.0v 1399.505n 0.0v 1409.495n 0.0v 1409.505n 0.0v 1419.495n 0.0v 1419.505n 0.0v 1429.495n 0.0v 1429.505n 0.0v 1439.495n 0.0v 1439.505n 0.0v 1449.495n 0.0v 1449.505n 0.0v 1459.495n 0.0v 1459.505n 0.0v 1469.495n 0.0v 1469.505n 0.0v 1479.495n 0.0v 1479.505n 0.0v 1489.495n 0.0v 1489.505n 0.0v 1499.495n 0.0v 1499.505n 0.0v 1509.495n 0.0v 1509.505n 0.0v 1519.495n 0.0v 1519.505n 0.0v 1529.495n 0.0v 1529.505n 0.0v 1539.495n 0.0v 1539.505n 0.0v 1549.495n 0.0v 1549.505n 0.0v 1559.495n 0.0v 1559.505n 0.0v 1569.495n 0.0v 1569.505n 0.0v 1579.495n 0.0v 1579.505n 0.0v 1589.495n 0.0v 1589.505n 0.0v 1599.495n 0.0v 1599.505n 0.0v 1609.495n 0.0v 1609.505n 0.0v 1619.495n 0.0v 1619.505n 0.0v 1629.495n 0.0v 1629.505n 0.0v 1639.495n 0.0v 1639.505n 0.0v 1649.495n 0.0v 1649.505n 0.0v 1659.495n 0.0v 1659.505n 0.0v 1669.495n 0.0v 1669.505n 0.0v 1679.495n 0.0v 1679.505n 0.0v 1689.495n 0.0v 1689.505n 0.0v 1699.495n 0.0v 1699.505n 0.0v 1709.495n 0.0v 1709.505n 0.0v 1719.495n 0.0v 1719.505n 0.0v 1729.495n 0.0v 1729.505n 0.0v 1739.495n 0.0v 1739.505n 0.0v 1749.495n 0.0v 1749.505n 0.0v 1759.495n 0.0v 1759.505n 0.0v 1769.495n 0.0v 1769.505n 0.0v 1779.495n 0.0v 1779.505n 0.0v 1789.495n 0.0v 1789.505n 0.0v 1799.495n 0.0v 1799.505n 0.0v 1809.495n 0.0v 1809.505n 0.0v 1819.495n 0.0v 1819.505n 0.0v 1829.495n 0.0v 1829.505n 0.0v 1839.495n 0.0v 1839.505n 0.0v 1849.495n 0.0v 1849.505n 0.0v 1859.495n 0.0v 1859.505n 0.0v 1869.495n 0.0v 1869.505n 0.0v 1879.495n 0.0v 1879.505n 0.0v 1889.495n 0.0v 1889.505n 0.0v 1899.495n 0.0v 1899.505n 0.0v 1909.495n 0.0v 1909.505n 0.0v 1919.495n 0.0v 1919.505n 0.0v 1929.495n 0.0v 1929.505n 0.0v 1939.495n 0.0v 1939.505n 0.0v 1949.495n 0.0v 1949.505n 0.0v 1959.495n 0.0v 1959.505n 0.0v 1969.495n 0.0v 1969.505n 0.0v 1979.495n 0.0v 1979.505n 0.0v 1989.495n 0.0v 1989.505n 0.0v 1999.495n 0.0v 1999.505n 0.0v 2009.495n 0.0v 2009.505n 0.0v 2019.495n 0.0v 2019.505n 0.0v 2029.495n 0.0v 2029.505n 0.0v 2039.495n 0.0v 2039.505n 0.0v 2049.495n 0.0v 2049.505n 0.0v )
* (time, data): [(0, 0), (10, 0), (20, 0), (30, 0), (40, 0), (50, 0), (60, 0), (70, 1), (80, 1), (90, 1), (100, 0), (110, 0), (120, 0), (130, 0), (140, 0), (150, 0), (160, 0), (170, 0), (180, 0), (190, 0), (200, 0), (210, 0), (220, 0), (230, 0), (240, 0), (250, 0), (260, 0), (270, 0), (280, 0), (290, 0), (300, 1), (310, 1), (320, 1), (330, 1), (340, 0), (350, 0), (360, 0), (370, 1), (380, 0), (390, 0), (400, 0), (410, 0), (420, 0), (430, 0), (440, 0), (450, 0), (460, 0), (470, 0), (480, 0), (490, 0), (500, 0), (510, 0), (520, 0), (530, 0), (540, 0), (550, 0), (560, 0), (570, 0), (580, 0), (590, 0), (600, 0), (610, 0), (620, 0), (630, 0), (640, 0), (650, 0), (660, 1), (670, 1), (680, 1), (690, 0), (700, 0), (710, 0), (720, 0), (730, 0), (740, 0), (750, 0), (760, 0), (770, 0), (780, 0), (790, 0), (800, 0), (810, 0), (820, 0), (830, 0), (840, 0), (850, 0), (860, 0), (870, 0), (880, 0), (890, 0), (900, 1), (910, 1), (920, 0), (930, 1), (940, 1), (950, 0), (960, 0), (970, 1), (980, 0), (990, 0), (1000, 0), (1010, 0), (1020, 0), (1030, 0), (1040, 0), (1050, 0), (1060, 0), (1070, 0), (1080, 0), (1090, 0), (1100, 0), (1110, 0), (1120, 0), (1130, 0), (1140, 0), (1150, 0), (1160, 0), (1170, 0), (1180, 0), (1190, 0), (1200, 0), (1210, 0), (1220, 0), (1230, 1), (1240, 0), (1250, 0), (1260, 0), (1270, 0), (1280, 0), (1290, 0), (1300, 0), (1310, 0), (1320, 0), (1330, 0), (1340, 0), (1350, 0), (1360, 0), (1370, 0), (1380, 0), (1390, 0), (1400, 0), (1410, 0), (1420, 0), (1430, 0), (1440, 0), (1450, 0), (1460, 0), (1470, 0), (1480, 0), (1490, 0), (1500, 0), (1510, 0), (1520, 0), (1530, 0), (1540, 0), (1550, 0), (1560, 0), (1570, 0), (1580, 0), (1590, 0), (1600, 0), (1610, 0), (1620, 0), (1630, 0), (1640, 0), (1650, 0), (1660, 0), (1670, 0), (1680, 0), (1690, 0), (1700, 0), (1710, 0), (1720, 0), (1730, 0), (1740, 0), (1750, 0), (1760, 0), (1770, 0), (1780, 0), (1790, 0), (1800, 0), (1810, 0), (1820, 0), (1830, 0), (1840, 0), (1850, 0), (1860, 0), (1870, 0), (1880, 0), (1890, 0), (1900, 0), (1910, 0), (1920, 0), (1930, 0), (1940, 0), (1950, 0), (1960, 0), (1970, 0), (1980, 0), (1990, 0), (2000, 0), (2010, 0), (2020, 0), (2030, 0), (2040, 0), (2050, 0)]
Va1_4  a1_4  0 PWL (0n 0.0v 9.495n 0.0v 9.505n 0.0v 19.495n 0.0v 19.505n 0.0v 29.495n 0.0v 29.505n 0.0v 39.495n 0.0v 39.505n 0.0v 49.495n 0.0v 49.505n 0.0v 59.495n 0.0v 59.505n 0.0v 69.495n 0.0v 69.505n 1.7v 79.495n 1.7v 79.505n 1.7v 89.495n 1.7v 89.505n 1.7v 99.495n 1.7v 99.505n 0.0v 109.495n 0.0v 109.505n 0.0v 119.495n 0.0v 119.505n 0.0v 129.495n 0.0v 129.505n 0.0v 139.495n 0.0v 139.505n 0.0v 149.495n 0.0v 149.505n 0.0v 159.495n 0.0v 159.505n 0.0v 169.495n 0.0v 169.505n 0.0v 179.495n 0.0v 179.505n 0.0v 189.495n 0.0v 189.505n 0.0v 199.495n 0.0v 199.505n 0.0v 209.495n 0.0v 209.505n 0.0v 219.495n 0.0v 219.505n 0.0v 229.495n 0.0v 229.505n 0.0v 239.495n 0.0v 239.505n 0.0v 249.495n 0.0v 249.505n 0.0v 259.495n 0.0v 259.505n 0.0v 269.495n 0.0v 269.505n 0.0v 279.495n 0.0v 279.505n 0.0v 289.495n 0.0v 289.505n 0.0v 299.495n 0.0v 299.505n 1.7v 309.495n 1.7v 309.505n 1.7v 319.495n 1.7v 319.505n 1.7v 329.495n 1.7v 329.505n 1.7v 339.495n 1.7v 339.505n 0.0v 349.495n 0.0v 349.505n 0.0v 359.495n 0.0v 359.505n 0.0v 369.495n 0.0v 369.505n 1.7v 379.495n 1.7v 379.505n 0.0v 389.495n 0.0v 389.505n 0.0v 399.495n 0.0v 399.505n 0.0v 409.495n 0.0v 409.505n 0.0v 419.495n 0.0v 419.505n 0.0v 429.495n 0.0v 429.505n 0.0v 439.495n 0.0v 439.505n 0.0v 449.495n 0.0v 449.505n 0.0v 459.495n 0.0v 459.505n 0.0v 469.495n 0.0v 469.505n 0.0v 479.495n 0.0v 479.505n 0.0v 489.495n 0.0v 489.505n 0.0v 499.495n 0.0v 499.505n 0.0v 509.495n 0.0v 509.505n 0.0v 519.495n 0.0v 519.505n 0.0v 529.495n 0.0v 529.505n 0.0v 539.495n 0.0v 539.505n 0.0v 549.495n 0.0v 549.505n 0.0v 559.495n 0.0v 559.505n 0.0v 569.495n 0.0v 569.505n 0.0v 579.495n 0.0v 579.505n 0.0v 589.495n 0.0v 589.505n 0.0v 599.495n 0.0v 599.505n 0.0v 609.495n 0.0v 609.505n 0.0v 619.495n 0.0v 619.505n 0.0v 629.495n 0.0v 629.505n 0.0v 639.495n 0.0v 639.505n 0.0v 649.495n 0.0v 649.505n 0.0v 659.495n 0.0v 659.505n 1.7v 669.495n 1.7v 669.505n 1.7v 679.495n 1.7v 679.505n 1.7v 689.495n 1.7v 689.505n 0.0v 699.495n 0.0v 699.505n 0.0v 709.495n 0.0v 709.505n 0.0v 719.495n 0.0v 719.505n 0.0v 729.495n 0.0v 729.505n 0.0v 739.495n 0.0v 739.505n 0.0v 749.495n 0.0v 749.505n 0.0v 759.495n 0.0v 759.505n 0.0v 769.495n 0.0v 769.505n 0.0v 779.495n 0.0v 779.505n 0.0v 789.495n 0.0v 789.505n 0.0v 799.495n 0.0v 799.505n 0.0v 809.495n 0.0v 809.505n 0.0v 819.495n 0.0v 819.505n 0.0v 829.495n 0.0v 829.505n 0.0v 839.495n 0.0v 839.505n 0.0v 849.495n 0.0v 849.505n 0.0v 859.495n 0.0v 859.505n 0.0v 869.495n 0.0v 869.505n 0.0v 879.495n 0.0v 879.505n 0.0v 889.495n 0.0v 889.505n 0.0v 899.495n 0.0v 899.505n 1.7v 909.495n 1.7v 909.505n 1.7v 919.495n 1.7v 919.505n 0.0v 929.495n 0.0v 929.505n 1.7v 939.495n 1.7v 939.505n 1.7v 949.495n 1.7v 949.505n 0.0v 959.495n 0.0v 959.505n 0.0v 969.495n 0.0v 969.505n 1.7v 979.495n 1.7v 979.505n 0.0v 989.495n 0.0v 989.505n 0.0v 999.495n 0.0v 999.505n 0.0v 1009.495n 0.0v 1009.505n 0.0v 1019.495n 0.0v 1019.505n 0.0v 1029.495n 0.0v 1029.505n 0.0v 1039.495n 0.0v 1039.505n 0.0v 1049.495n 0.0v 1049.505n 0.0v 1059.495n 0.0v 1059.505n 0.0v 1069.495n 0.0v 1069.505n 0.0v 1079.495n 0.0v 1079.505n 0.0v 1089.495n 0.0v 1089.505n 0.0v 1099.495n 0.0v 1099.505n 0.0v 1109.495n 0.0v 1109.505n 0.0v 1119.495n 0.0v 1119.505n 0.0v 1129.495n 0.0v 1129.505n 0.0v 1139.495n 0.0v 1139.505n 0.0v 1149.495n 0.0v 1149.505n 0.0v 1159.495n 0.0v 1159.505n 0.0v 1169.495n 0.0v 1169.505n 0.0v 1179.495n 0.0v 1179.505n 0.0v 1189.495n 0.0v 1189.505n 0.0v 1199.495n 0.0v 1199.505n 0.0v 1209.495n 0.0v 1209.505n 0.0v 1219.495n 0.0v 1219.505n 0.0v 1229.495n 0.0v 1229.505n 1.7v 1239.495n 1.7v 1239.505n 0.0v 1249.495n 0.0v 1249.505n 0.0v 1259.495n 0.0v 1259.505n 0.0v 1269.495n 0.0v 1269.505n 0.0v 1279.495n 0.0v 1279.505n 0.0v 1289.495n 0.0v 1289.505n 0.0v 1299.495n 0.0v 1299.505n 0.0v 1309.495n 0.0v 1309.505n 0.0v 1319.495n 0.0v 1319.505n 0.0v 1329.495n 0.0v 1329.505n 0.0v 1339.495n 0.0v 1339.505n 0.0v 1349.495n 0.0v 1349.505n 0.0v 1359.495n 0.0v 1359.505n 0.0v 1369.495n 0.0v 1369.505n 0.0v 1379.495n 0.0v 1379.505n 0.0v 1389.495n 0.0v 1389.505n 0.0v 1399.495n 0.0v 1399.505n 0.0v 1409.495n 0.0v 1409.505n 0.0v 1419.495n 0.0v 1419.505n 0.0v 1429.495n 0.0v 1429.505n 0.0v 1439.495n 0.0v 1439.505n 0.0v 1449.495n 0.0v 1449.505n 0.0v 1459.495n 0.0v 1459.505n 0.0v 1469.495n 0.0v 1469.505n 0.0v 1479.495n 0.0v 1479.505n 0.0v 1489.495n 0.0v 1489.505n 0.0v 1499.495n 0.0v 1499.505n 0.0v 1509.495n 0.0v 1509.505n 0.0v 1519.495n 0.0v 1519.505n 0.0v 1529.495n 0.0v 1529.505n 0.0v 1539.495n 0.0v 1539.505n 0.0v 1549.495n 0.0v 1549.505n 0.0v 1559.495n 0.0v 1559.505n 0.0v 1569.495n 0.0v 1569.505n 0.0v 1579.495n 0.0v 1579.505n 0.0v 1589.495n 0.0v 1589.505n 0.0v 1599.495n 0.0v 1599.505n 0.0v 1609.495n 0.0v 1609.505n 0.0v 1619.495n 0.0v 1619.505n 0.0v 1629.495n 0.0v 1629.505n 0.0v 1639.495n 0.0v 1639.505n 0.0v 1649.495n 0.0v 1649.505n 0.0v 1659.495n 0.0v 1659.505n 0.0v 1669.495n 0.0v 1669.505n 0.0v 1679.495n 0.0v 1679.505n 0.0v 1689.495n 0.0v 1689.505n 0.0v 1699.495n 0.0v 1699.505n 0.0v 1709.495n 0.0v 1709.505n 0.0v 1719.495n 0.0v 1719.505n 0.0v 1729.495n 0.0v 1729.505n 0.0v 1739.495n 0.0v 1739.505n 0.0v 1749.495n 0.0v 1749.505n 0.0v 1759.495n 0.0v 1759.505n 0.0v 1769.495n 0.0v 1769.505n 0.0v 1779.495n 0.0v 1779.505n 0.0v 1789.495n 0.0v 1789.505n 0.0v 1799.495n 0.0v 1799.505n 0.0v 1809.495n 0.0v 1809.505n 0.0v 1819.495n 0.0v 1819.505n 0.0v 1829.495n 0.0v 1829.505n 0.0v 1839.495n 0.0v 1839.505n 0.0v 1849.495n 0.0v 1849.505n 0.0v 1859.495n 0.0v 1859.505n 0.0v 1869.495n 0.0v 1869.505n 0.0v 1879.495n 0.0v 1879.505n 0.0v 1889.495n 0.0v 1889.505n 0.0v 1899.495n 0.0v 1899.505n 0.0v 1909.495n 0.0v 1909.505n 0.0v 1919.495n 0.0v 1919.505n 0.0v 1929.495n 0.0v 1929.505n 0.0v 1939.495n 0.0v 1939.505n 0.0v 1949.495n 0.0v 1949.505n 0.0v 1959.495n 0.0v 1959.505n 0.0v 1969.495n 0.0v 1969.505n 0.0v 1979.495n 0.0v 1979.505n 0.0v 1989.495n 0.0v 1989.505n 0.0v 1999.495n 0.0v 1999.505n 0.0v 2009.495n 0.0v 2009.505n 0.0v 2019.495n 0.0v 2019.505n 0.0v 2029.495n 0.0v 2029.505n 0.0v 2039.495n 0.0v 2039.505n 0.0v 2049.495n 0.0v 2049.505n 0.0v )
* (time, data): [(0, 0), (10, 0), (20, 0), (30, 0), (40, 0), (50, 0), (60, 0), (70, 1), (80, 1), (90, 1), (100, 0), (110, 0), (120, 0), (130, 0), (140, 0), (150, 0), (160, 0), (170, 0), (180, 0), (190, 0), (200, 0), (210, 0), (220, 0), (230, 0), (240, 0), (250, 0), (260, 0), (270, 0), (280, 0), (290, 0), (300, 1), (310, 1), (320, 1), (330, 1), (340, 0), (350, 0), (360, 0), (370, 1), (380, 0), (390, 0), (400, 0), (410, 0), (420, 0), (430, 0), (440, 0), (450, 0), (460, 0), (470, 0), (480, 0), (490, 0), (500, 0), (510, 0), (520, 0), (530, 0), (540, 0), (550, 0), (560, 0), (570, 0), (580, 0), (590, 0), (600, 0), (610, 0), (620, 0), (630, 0), (640, 0), (650, 0), (660, 1), (670, 1), (680, 1), (690, 0), (700, 0), (710, 0), (720, 0), (730, 0), (740, 0), (750, 0), (760, 0), (770, 0), (780, 0), (790, 0), (800, 0), (810, 0), (820, 0), (830, 0), (840, 0), (850, 0), (860, 0), (870, 0), (880, 0), (890, 0), (900, 1), (910, 1), (920, 0), (930, 1), (940, 1), (950, 0), (960, 0), (970, 1), (980, 0), (990, 0), (1000, 0), (1010, 0), (1020, 0), (1030, 0), (1040, 0), (1050, 0), (1060, 0), (1070, 0), (1080, 0), (1090, 0), (1100, 0), (1110, 0), (1120, 0), (1130, 0), (1140, 0), (1150, 0), (1160, 0), (1170, 0), (1180, 0), (1190, 0), (1200, 0), (1210, 0), (1220, 0), (1230, 1), (1240, 0), (1250, 0), (1260, 0), (1270, 0), (1280, 0), (1290, 0), (1300, 0), (1310, 0), (1320, 0), (1330, 0), (1340, 0), (1350, 0), (1360, 0), (1370, 0), (1380, 0), (1390, 0), (1400, 0), (1410, 0), (1420, 0), (1430, 0), (1440, 0), (1450, 0), (1460, 0), (1470, 0), (1480, 0), (1490, 0), (1500, 0), (1510, 0), (1520, 0), (1530, 0), (1540, 0), (1550, 0), (1560, 0), (1570, 0), (1580, 0), (1590, 0), (1600, 0), (1610, 0), (1620, 0), (1630, 0), (1640, 0), (1650, 0), (1660, 0), (1670, 0), (1680, 0), (1690, 0), (1700, 0), (1710, 0), (1720, 0), (1730, 0), (1740, 0), (1750, 0), (1760, 0), (1770, 0), (1780, 0), (1790, 0), (1800, 0), (1810, 0), (1820, 0), (1830, 0), (1840, 0), (1850, 0), (1860, 0), (1870, 0), (1880, 0), (1890, 0), (1900, 0), (1910, 0), (1920, 0), (1930, 0), (1940, 0), (1950, 0), (1960, 0), (1970, 0), (1980, 0), (1990, 0), (2000, 0), (2010, 0), (2020, 0), (2030, 0), (2040, 0), (2050, 0)]
Va1_5  a1_5  0 PWL (0n 0.0v 9.495n 0.0v 9.505n 0.0v 19.495n 0.0v 19.505n 0.0v 29.495n 0.0v 29.505n 0.0v 39.495n 0.0v 39.505n 0.0v 49.495n 0.0v 49.505n 0.0v 59.495n 0.0v 59.505n 0.0v 69.495n 0.0v 69.505n 1.7v 79.495n 1.7v 79.505n 1.7v 89.495n 1.7v 89.505n 1.7v 99.495n 1.7v 99.505n 0.0v 109.495n 0.0v 109.505n 0.0v 119.495n 0.0v 119.505n 0.0v 129.495n 0.0v 129.505n 0.0v 139.495n 0.0v 139.505n 0.0v 149.495n 0.0v 149.505n 0.0v 159.495n 0.0v 159.505n 0.0v 169.495n 0.0v 169.505n 0.0v 179.495n 0.0v 179.505n 0.0v 189.495n 0.0v 189.505n 0.0v 199.495n 0.0v 199.505n 0.0v 209.495n 0.0v 209.505n 0.0v 219.495n 0.0v 219.505n 0.0v 229.495n 0.0v 229.505n 0.0v 239.495n 0.0v 239.505n 0.0v 249.495n 0.0v 249.505n 0.0v 259.495n 0.0v 259.505n 0.0v 269.495n 0.0v 269.505n 0.0v 279.495n 0.0v 279.505n 0.0v 289.495n 0.0v 289.505n 0.0v 299.495n 0.0v 299.505n 1.7v 309.495n 1.7v 309.505n 1.7v 319.495n 1.7v 319.505n 1.7v 329.495n 1.7v 329.505n 1.7v 339.495n 1.7v 339.505n 0.0v 349.495n 0.0v 349.505n 0.0v 359.495n 0.0v 359.505n 0.0v 369.495n 0.0v 369.505n 1.7v 379.495n 1.7v 379.505n 0.0v 389.495n 0.0v 389.505n 0.0v 399.495n 0.0v 399.505n 0.0v 409.495n 0.0v 409.505n 0.0v 419.495n 0.0v 419.505n 0.0v 429.495n 0.0v 429.505n 0.0v 439.495n 0.0v 439.505n 0.0v 449.495n 0.0v 449.505n 0.0v 459.495n 0.0v 459.505n 0.0v 469.495n 0.0v 469.505n 0.0v 479.495n 0.0v 479.505n 0.0v 489.495n 0.0v 489.505n 0.0v 499.495n 0.0v 499.505n 0.0v 509.495n 0.0v 509.505n 0.0v 519.495n 0.0v 519.505n 0.0v 529.495n 0.0v 529.505n 0.0v 539.495n 0.0v 539.505n 0.0v 549.495n 0.0v 549.505n 0.0v 559.495n 0.0v 559.505n 0.0v 569.495n 0.0v 569.505n 0.0v 579.495n 0.0v 579.505n 0.0v 589.495n 0.0v 589.505n 0.0v 599.495n 0.0v 599.505n 0.0v 609.495n 0.0v 609.505n 0.0v 619.495n 0.0v 619.505n 0.0v 629.495n 0.0v 629.505n 0.0v 639.495n 0.0v 639.505n 0.0v 649.495n 0.0v 649.505n 0.0v 659.495n 0.0v 659.505n 1.7v 669.495n 1.7v 669.505n 1.7v 679.495n 1.7v 679.505n 1.7v 689.495n 1.7v 689.505n 0.0v 699.495n 0.0v 699.505n 0.0v 709.495n 0.0v 709.505n 0.0v 719.495n 0.0v 719.505n 0.0v 729.495n 0.0v 729.505n 0.0v 739.495n 0.0v 739.505n 0.0v 749.495n 0.0v 749.505n 0.0v 759.495n 0.0v 759.505n 0.0v 769.495n 0.0v 769.505n 0.0v 779.495n 0.0v 779.505n 0.0v 789.495n 0.0v 789.505n 0.0v 799.495n 0.0v 799.505n 0.0v 809.495n 0.0v 809.505n 0.0v 819.495n 0.0v 819.505n 0.0v 829.495n 0.0v 829.505n 0.0v 839.495n 0.0v 839.505n 0.0v 849.495n 0.0v 849.505n 0.0v 859.495n 0.0v 859.505n 0.0v 869.495n 0.0v 869.505n 0.0v 879.495n 0.0v 879.505n 0.0v 889.495n 0.0v 889.505n 0.0v 899.495n 0.0v 899.505n 1.7v 909.495n 1.7v 909.505n 1.7v 919.495n 1.7v 919.505n 0.0v 929.495n 0.0v 929.505n 1.7v 939.495n 1.7v 939.505n 1.7v 949.495n 1.7v 949.505n 0.0v 959.495n 0.0v 959.505n 0.0v 969.495n 0.0v 969.505n 1.7v 979.495n 1.7v 979.505n 0.0v 989.495n 0.0v 989.505n 0.0v 999.495n 0.0v 999.505n 0.0v 1009.495n 0.0v 1009.505n 0.0v 1019.495n 0.0v 1019.505n 0.0v 1029.495n 0.0v 1029.505n 0.0v 1039.495n 0.0v 1039.505n 0.0v 1049.495n 0.0v 1049.505n 0.0v 1059.495n 0.0v 1059.505n 0.0v 1069.495n 0.0v 1069.505n 0.0v 1079.495n 0.0v 1079.505n 0.0v 1089.495n 0.0v 1089.505n 0.0v 1099.495n 0.0v 1099.505n 0.0v 1109.495n 0.0v 1109.505n 0.0v 1119.495n 0.0v 1119.505n 0.0v 1129.495n 0.0v 1129.505n 0.0v 1139.495n 0.0v 1139.505n 0.0v 1149.495n 0.0v 1149.505n 0.0v 1159.495n 0.0v 1159.505n 0.0v 1169.495n 0.0v 1169.505n 0.0v 1179.495n 0.0v 1179.505n 0.0v 1189.495n 0.0v 1189.505n 0.0v 1199.495n 0.0v 1199.505n 0.0v 1209.495n 0.0v 1209.505n 0.0v 1219.495n 0.0v 1219.505n 0.0v 1229.495n 0.0v 1229.505n 1.7v 1239.495n 1.7v 1239.505n 0.0v 1249.495n 0.0v 1249.505n 0.0v 1259.495n 0.0v 1259.505n 0.0v 1269.495n 0.0v 1269.505n 0.0v 1279.495n 0.0v 1279.505n 0.0v 1289.495n 0.0v 1289.505n 0.0v 1299.495n 0.0v 1299.505n 0.0v 1309.495n 0.0v 1309.505n 0.0v 1319.495n 0.0v 1319.505n 0.0v 1329.495n 0.0v 1329.505n 0.0v 1339.495n 0.0v 1339.505n 0.0v 1349.495n 0.0v 1349.505n 0.0v 1359.495n 0.0v 1359.505n 0.0v 1369.495n 0.0v 1369.505n 0.0v 1379.495n 0.0v 1379.505n 0.0v 1389.495n 0.0v 1389.505n 0.0v 1399.495n 0.0v 1399.505n 0.0v 1409.495n 0.0v 1409.505n 0.0v 1419.495n 0.0v 1419.505n 0.0v 1429.495n 0.0v 1429.505n 0.0v 1439.495n 0.0v 1439.505n 0.0v 1449.495n 0.0v 1449.505n 0.0v 1459.495n 0.0v 1459.505n 0.0v 1469.495n 0.0v 1469.505n 0.0v 1479.495n 0.0v 1479.505n 0.0v 1489.495n 0.0v 1489.505n 0.0v 1499.495n 0.0v 1499.505n 0.0v 1509.495n 0.0v 1509.505n 0.0v 1519.495n 0.0v 1519.505n 0.0v 1529.495n 0.0v 1529.505n 0.0v 1539.495n 0.0v 1539.505n 0.0v 1549.495n 0.0v 1549.505n 0.0v 1559.495n 0.0v 1559.505n 0.0v 1569.495n 0.0v 1569.505n 0.0v 1579.495n 0.0v 1579.505n 0.0v 1589.495n 0.0v 1589.505n 0.0v 1599.495n 0.0v 1599.505n 0.0v 1609.495n 0.0v 1609.505n 0.0v 1619.495n 0.0v 1619.505n 0.0v 1629.495n 0.0v 1629.505n 0.0v 1639.495n 0.0v 1639.505n 0.0v 1649.495n 0.0v 1649.505n 0.0v 1659.495n 0.0v 1659.505n 0.0v 1669.495n 0.0v 1669.505n 0.0v 1679.495n 0.0v 1679.505n 0.0v 1689.495n 0.0v 1689.505n 0.0v 1699.495n 0.0v 1699.505n 0.0v 1709.495n 0.0v 1709.505n 0.0v 1719.495n 0.0v 1719.505n 0.0v 1729.495n 0.0v 1729.505n 0.0v 1739.495n 0.0v 1739.505n 0.0v 1749.495n 0.0v 1749.505n 0.0v 1759.495n 0.0v 1759.505n 0.0v 1769.495n 0.0v 1769.505n 0.0v 1779.495n 0.0v 1779.505n 0.0v 1789.495n 0.0v 1789.505n 0.0v 1799.495n 0.0v 1799.505n 0.0v 1809.495n 0.0v 1809.505n 0.0v 1819.495n 0.0v 1819.505n 0.0v 1829.495n 0.0v 1829.505n 0.0v 1839.495n 0.0v 1839.505n 0.0v 1849.495n 0.0v 1849.505n 0.0v 1859.495n 0.0v 1859.505n 0.0v 1869.495n 0.0v 1869.505n 0.0v 1879.495n 0.0v 1879.505n 0.0v 1889.495n 0.0v 1889.505n 0.0v 1899.495n 0.0v 1899.505n 0.0v 1909.495n 0.0v 1909.505n 0.0v 1919.495n 0.0v 1919.505n 0.0v 1929.495n 0.0v 1929.505n 0.0v 1939.495n 0.0v 1939.505n 0.0v 1949.495n 0.0v 1949.505n 0.0v 1959.495n 0.0v 1959.505n 0.0v 1969.495n 0.0v 1969.505n 0.0v 1979.495n 0.0v 1979.505n 0.0v 1989.495n 0.0v 1989.505n 0.0v 1999.495n 0.0v 1999.505n 0.0v 2009.495n 0.0v 2009.505n 0.0v 2019.495n 0.0v 2019.505n 0.0v 2029.495n 0.0v 2029.505n 0.0v 2039.495n 0.0v 2039.505n 0.0v 2049.495n 0.0v 2049.505n 0.0v )
* (time, data): [(0, 0), (10, 0), (20, 0), (30, 0), (40, 0), (50, 0), (60, 0), (70, 1), (80, 1), (90, 1), (100, 0), (110, 0), (120, 0), (130, 0), (140, 0), (150, 0), (160, 0), (170, 0), (180, 0), (190, 0), (200, 0), (210, 0), (220, 0), (230, 0), (240, 0), (250, 0), (260, 0), (270, 0), (280, 0), (290, 0), (300, 1), (310, 1), (320, 1), (330, 1), (340, 0), (350, 0), (360, 0), (370, 1), (380, 0), (390, 0), (400, 0), (410, 0), (420, 0), (430, 0), (440, 0), (450, 0), (460, 0), (470, 0), (480, 0), (490, 0), (500, 0), (510, 0), (520, 0), (530, 0), (540, 0), (550, 0), (560, 0), (570, 0), (580, 0), (590, 0), (600, 0), (610, 0), (620, 0), (630, 0), (640, 0), (650, 0), (660, 1), (670, 1), (680, 1), (690, 0), (700, 0), (710, 0), (720, 0), (730, 0), (740, 0), (750, 0), (760, 0), (770, 0), (780, 0), (790, 0), (800, 0), (810, 0), (820, 0), (830, 0), (840, 0), (850, 0), (860, 0), (870, 0), (880, 0), (890, 0), (900, 1), (910, 1), (920, 0), (930, 1), (940, 1), (950, 0), (960, 0), (970, 1), (980, 0), (990, 0), (1000, 0), (1010, 0), (1020, 0), (1030, 0), (1040, 0), (1050, 0), (1060, 0), (1070, 0), (1080, 0), (1090, 0), (1100, 0), (1110, 0), (1120, 0), (1130, 0), (1140, 0), (1150, 0), (1160, 0), (1170, 0), (1180, 0), (1190, 0), (1200, 0), (1210, 0), (1220, 0), (1230, 1), (1240, 0), (1250, 0), (1260, 0), (1270, 0), (1280, 0), (1290, 0), (1300, 0), (1310, 0), (1320, 0), (1330, 0), (1340, 0), (1350, 0), (1360, 0), (1370, 0), (1380, 0), (1390, 0), (1400, 0), (1410, 0), (1420, 0), (1430, 0), (1440, 0), (1450, 0), (1460, 0), (1470, 0), (1480, 0), (1490, 0), (1500, 0), (1510, 0), (1520, 0), (1530, 0), (1540, 0), (1550, 0), (1560, 0), (1570, 0), (1580, 0), (1590, 0), (1600, 0), (1610, 0), (1620, 0), (1630, 0), (1640, 0), (1650, 0), (1660, 0), (1670, 0), (1680, 0), (1690, 0), (1700, 0), (1710, 0), (1720, 0), (1730, 0), (1740, 0), (1750, 0), (1760, 0), (1770, 0), (1780, 0), (1790, 0), (1800, 0), (1810, 0), (1820, 0), (1830, 0), (1840, 0), (1850, 0), (1860, 0), (1870, 0), (1880, 0), (1890, 0), (1900, 0), (1910, 0), (1920, 0), (1930, 0), (1940, 0), (1950, 0), (1960, 0), (1970, 0), (1980, 0), (1990, 0), (2000, 0), (2010, 0), (2020, 0), (2030, 0), (2040, 0), (2050, 0)]
Va1_6  a1_6  0 PWL (0n 0.0v 9.495n 0.0v 9.505n 0.0v 19.495n 0.0v 19.505n 0.0v 29.495n 0.0v 29.505n 0.0v 39.495n 0.0v 39.505n 0.0v 49.495n 0.0v 49.505n 0.0v 59.495n 0.0v 59.505n 0.0v 69.495n 0.0v 69.505n 1.7v 79.495n 1.7v 79.505n 1.7v 89.495n 1.7v 89.505n 1.7v 99.495n 1.7v 99.505n 0.0v 109.495n 0.0v 109.505n 0.0v 119.495n 0.0v 119.505n 0.0v 129.495n 0.0v 129.505n 0.0v 139.495n 0.0v 139.505n 0.0v 149.495n 0.0v 149.505n 0.0v 159.495n 0.0v 159.505n 0.0v 169.495n 0.0v 169.505n 0.0v 179.495n 0.0v 179.505n 0.0v 189.495n 0.0v 189.505n 0.0v 199.495n 0.0v 199.505n 0.0v 209.495n 0.0v 209.505n 0.0v 219.495n 0.0v 219.505n 0.0v 229.495n 0.0v 229.505n 0.0v 239.495n 0.0v 239.505n 0.0v 249.495n 0.0v 249.505n 0.0v 259.495n 0.0v 259.505n 0.0v 269.495n 0.0v 269.505n 0.0v 279.495n 0.0v 279.505n 0.0v 289.495n 0.0v 289.505n 0.0v 299.495n 0.0v 299.505n 1.7v 309.495n 1.7v 309.505n 1.7v 319.495n 1.7v 319.505n 1.7v 329.495n 1.7v 329.505n 1.7v 339.495n 1.7v 339.505n 0.0v 349.495n 0.0v 349.505n 0.0v 359.495n 0.0v 359.505n 0.0v 369.495n 0.0v 369.505n 1.7v 379.495n 1.7v 379.505n 0.0v 389.495n 0.0v 389.505n 0.0v 399.495n 0.0v 399.505n 0.0v 409.495n 0.0v 409.505n 0.0v 419.495n 0.0v 419.505n 0.0v 429.495n 0.0v 429.505n 0.0v 439.495n 0.0v 439.505n 0.0v 449.495n 0.0v 449.505n 0.0v 459.495n 0.0v 459.505n 0.0v 469.495n 0.0v 469.505n 0.0v 479.495n 0.0v 479.505n 0.0v 489.495n 0.0v 489.505n 0.0v 499.495n 0.0v 499.505n 0.0v 509.495n 0.0v 509.505n 0.0v 519.495n 0.0v 519.505n 0.0v 529.495n 0.0v 529.505n 0.0v 539.495n 0.0v 539.505n 0.0v 549.495n 0.0v 549.505n 0.0v 559.495n 0.0v 559.505n 0.0v 569.495n 0.0v 569.505n 0.0v 579.495n 0.0v 579.505n 0.0v 589.495n 0.0v 589.505n 0.0v 599.495n 0.0v 599.505n 0.0v 609.495n 0.0v 609.505n 0.0v 619.495n 0.0v 619.505n 0.0v 629.495n 0.0v 629.505n 0.0v 639.495n 0.0v 639.505n 0.0v 649.495n 0.0v 649.505n 0.0v 659.495n 0.0v 659.505n 1.7v 669.495n 1.7v 669.505n 1.7v 679.495n 1.7v 679.505n 1.7v 689.495n 1.7v 689.505n 0.0v 699.495n 0.0v 699.505n 0.0v 709.495n 0.0v 709.505n 0.0v 719.495n 0.0v 719.505n 0.0v 729.495n 0.0v 729.505n 0.0v 739.495n 0.0v 739.505n 0.0v 749.495n 0.0v 749.505n 0.0v 759.495n 0.0v 759.505n 0.0v 769.495n 0.0v 769.505n 0.0v 779.495n 0.0v 779.505n 0.0v 789.495n 0.0v 789.505n 0.0v 799.495n 0.0v 799.505n 0.0v 809.495n 0.0v 809.505n 0.0v 819.495n 0.0v 819.505n 0.0v 829.495n 0.0v 829.505n 0.0v 839.495n 0.0v 839.505n 0.0v 849.495n 0.0v 849.505n 0.0v 859.495n 0.0v 859.505n 0.0v 869.495n 0.0v 869.505n 0.0v 879.495n 0.0v 879.505n 0.0v 889.495n 0.0v 889.505n 0.0v 899.495n 0.0v 899.505n 1.7v 909.495n 1.7v 909.505n 1.7v 919.495n 1.7v 919.505n 0.0v 929.495n 0.0v 929.505n 1.7v 939.495n 1.7v 939.505n 1.7v 949.495n 1.7v 949.505n 0.0v 959.495n 0.0v 959.505n 0.0v 969.495n 0.0v 969.505n 1.7v 979.495n 1.7v 979.505n 0.0v 989.495n 0.0v 989.505n 0.0v 999.495n 0.0v 999.505n 0.0v 1009.495n 0.0v 1009.505n 0.0v 1019.495n 0.0v 1019.505n 0.0v 1029.495n 0.0v 1029.505n 0.0v 1039.495n 0.0v 1039.505n 0.0v 1049.495n 0.0v 1049.505n 0.0v 1059.495n 0.0v 1059.505n 0.0v 1069.495n 0.0v 1069.505n 0.0v 1079.495n 0.0v 1079.505n 0.0v 1089.495n 0.0v 1089.505n 0.0v 1099.495n 0.0v 1099.505n 0.0v 1109.495n 0.0v 1109.505n 0.0v 1119.495n 0.0v 1119.505n 0.0v 1129.495n 0.0v 1129.505n 0.0v 1139.495n 0.0v 1139.505n 0.0v 1149.495n 0.0v 1149.505n 0.0v 1159.495n 0.0v 1159.505n 0.0v 1169.495n 0.0v 1169.505n 0.0v 1179.495n 0.0v 1179.505n 0.0v 1189.495n 0.0v 1189.505n 0.0v 1199.495n 0.0v 1199.505n 0.0v 1209.495n 0.0v 1209.505n 0.0v 1219.495n 0.0v 1219.505n 0.0v 1229.495n 0.0v 1229.505n 1.7v 1239.495n 1.7v 1239.505n 0.0v 1249.495n 0.0v 1249.505n 0.0v 1259.495n 0.0v 1259.505n 0.0v 1269.495n 0.0v 1269.505n 0.0v 1279.495n 0.0v 1279.505n 0.0v 1289.495n 0.0v 1289.505n 0.0v 1299.495n 0.0v 1299.505n 0.0v 1309.495n 0.0v 1309.505n 0.0v 1319.495n 0.0v 1319.505n 0.0v 1329.495n 0.0v 1329.505n 0.0v 1339.495n 0.0v 1339.505n 0.0v 1349.495n 0.0v 1349.505n 0.0v 1359.495n 0.0v 1359.505n 0.0v 1369.495n 0.0v 1369.505n 0.0v 1379.495n 0.0v 1379.505n 0.0v 1389.495n 0.0v 1389.505n 0.0v 1399.495n 0.0v 1399.505n 0.0v 1409.495n 0.0v 1409.505n 0.0v 1419.495n 0.0v 1419.505n 0.0v 1429.495n 0.0v 1429.505n 0.0v 1439.495n 0.0v 1439.505n 0.0v 1449.495n 0.0v 1449.505n 0.0v 1459.495n 0.0v 1459.505n 0.0v 1469.495n 0.0v 1469.505n 0.0v 1479.495n 0.0v 1479.505n 0.0v 1489.495n 0.0v 1489.505n 0.0v 1499.495n 0.0v 1499.505n 0.0v 1509.495n 0.0v 1509.505n 0.0v 1519.495n 0.0v 1519.505n 0.0v 1529.495n 0.0v 1529.505n 0.0v 1539.495n 0.0v 1539.505n 0.0v 1549.495n 0.0v 1549.505n 0.0v 1559.495n 0.0v 1559.505n 0.0v 1569.495n 0.0v 1569.505n 0.0v 1579.495n 0.0v 1579.505n 0.0v 1589.495n 0.0v 1589.505n 0.0v 1599.495n 0.0v 1599.505n 0.0v 1609.495n 0.0v 1609.505n 0.0v 1619.495n 0.0v 1619.505n 0.0v 1629.495n 0.0v 1629.505n 0.0v 1639.495n 0.0v 1639.505n 0.0v 1649.495n 0.0v 1649.505n 0.0v 1659.495n 0.0v 1659.505n 0.0v 1669.495n 0.0v 1669.505n 0.0v 1679.495n 0.0v 1679.505n 0.0v 1689.495n 0.0v 1689.505n 0.0v 1699.495n 0.0v 1699.505n 0.0v 1709.495n 0.0v 1709.505n 0.0v 1719.495n 0.0v 1719.505n 0.0v 1729.495n 0.0v 1729.505n 0.0v 1739.495n 0.0v 1739.505n 0.0v 1749.495n 0.0v 1749.505n 0.0v 1759.495n 0.0v 1759.505n 0.0v 1769.495n 0.0v 1769.505n 0.0v 1779.495n 0.0v 1779.505n 0.0v 1789.495n 0.0v 1789.505n 0.0v 1799.495n 0.0v 1799.505n 0.0v 1809.495n 0.0v 1809.505n 0.0v 1819.495n 0.0v 1819.505n 0.0v 1829.495n 0.0v 1829.505n 0.0v 1839.495n 0.0v 1839.505n 0.0v 1849.495n 0.0v 1849.505n 0.0v 1859.495n 0.0v 1859.505n 0.0v 1869.495n 0.0v 1869.505n 0.0v 1879.495n 0.0v 1879.505n 0.0v 1889.495n 0.0v 1889.505n 0.0v 1899.495n 0.0v 1899.505n 0.0v 1909.495n 0.0v 1909.505n 0.0v 1919.495n 0.0v 1919.505n 0.0v 1929.495n 0.0v 1929.505n 0.0v 1939.495n 0.0v 1939.505n 0.0v 1949.495n 0.0v 1949.505n 0.0v 1959.495n 0.0v 1959.505n 0.0v 1969.495n 0.0v 1969.505n 0.0v 1979.495n 0.0v 1979.505n 0.0v 1989.495n 0.0v 1989.505n 0.0v 1999.495n 0.0v 1999.505n 0.0v 2009.495n 0.0v 2009.505n 0.0v 2019.495n 0.0v 2019.505n 0.0v 2029.495n 0.0v 2029.505n 0.0v 2039.495n 0.0v 2039.505n 0.0v 2049.495n 0.0v 2049.505n 0.0v )
* (time, data): [(0, 0), (10, 0), (20, 0), (30, 0), (40, 0), (50, 0), (60, 0), (70, 1), (80, 1), (90, 1), (100, 0), (110, 0), (120, 0), (130, 0), (140, 0), (150, 0), (160, 0), (170, 0), (180, 0), (190, 0), (200, 0), (210, 0), (220, 0), (230, 0), (240, 0), (250, 0), (260, 0), (270, 0), (280, 0), (290, 0), (300, 1), (310, 1), (320, 1), (330, 1), (340, 0), (350, 0), (360, 0), (370, 1), (380, 0), (390, 0), (400, 0), (410, 0), (420, 0), (430, 0), (440, 0), (450, 0), (460, 0), (470, 0), (480, 0), (490, 0), (500, 0), (510, 0), (520, 0), (530, 0), (540, 0), (550, 0), (560, 0), (570, 0), (580, 0), (590, 0), (600, 0), (610, 0), (620, 0), (630, 0), (640, 0), (650, 0), (660, 1), (670, 1), (680, 1), (690, 0), (700, 0), (710, 0), (720, 0), (730, 0), (740, 0), (750, 0), (760, 0), (770, 0), (780, 0), (790, 0), (800, 0), (810, 0), (820, 0), (830, 0), (840, 0), (850, 0), (860, 0), (870, 0), (880, 0), (890, 0), (900, 1), (910, 1), (920, 0), (930, 1), (940, 1), (950, 0), (960, 0), (970, 1), (980, 0), (990, 0), (1000, 0), (1010, 0), (1020, 0), (1030, 0), (1040, 0), (1050, 0), (1060, 0), (1070, 0), (1080, 0), (1090, 0), (1100, 0), (1110, 0), (1120, 0), (1130, 0), (1140, 0), (1150, 0), (1160, 0), (1170, 0), (1180, 0), (1190, 0), (1200, 0), (1210, 0), (1220, 0), (1230, 1), (1240, 0), (1250, 0), (1260, 0), (1270, 0), (1280, 0), (1290, 0), (1300, 0), (1310, 0), (1320, 0), (1330, 0), (1340, 0), (1350, 0), (1360, 0), (1370, 0), (1380, 0), (1390, 0), (1400, 0), (1410, 0), (1420, 0), (1430, 0), (1440, 0), (1450, 0), (1460, 0), (1470, 0), (1480, 0), (1490, 0), (1500, 0), (1510, 0), (1520, 0), (1530, 0), (1540, 0), (1550, 0), (1560, 0), (1570, 0), (1580, 0), (1590, 0), (1600, 0), (1610, 0), (1620, 0), (1630, 0), (1640, 0), (1650, 0), (1660, 0), (1670, 0), (1680, 0), (1690, 0), (1700, 0), (1710, 0), (1720, 0), (1730, 0), (1740, 0), (1750, 0), (1760, 0), (1770, 0), (1780, 0), (1790, 0), (1800, 0), (1810, 0), (1820, 0), (1830, 0), (1840, 0), (1850, 0), (1860, 0), (1870, 0), (1880, 0), (1890, 0), (1900, 0), (1910, 0), (1920, 0), (1930, 0), (1940, 0), (1950, 0), (1960, 0), (1970, 0), (1980, 0), (1990, 0), (2000, 0), (2010, 0), (2020, 0), (2030, 0), (2040, 0), (2050, 0)]
Va1_7  a1_7  0 PWL (0n 0.0v 9.495n 0.0v 9.505n 0.0v 19.495n 0.0v 19.505n 0.0v 29.495n 0.0v 29.505n 0.0v 39.495n 0.0v 39.505n 0.0v 49.495n 0.0v 49.505n 0.0v 59.495n 0.0v 59.505n 0.0v 69.495n 0.0v 69.505n 1.7v 79.495n 1.7v 79.505n 1.7v 89.495n 1.7v 89.505n 1.7v 99.495n 1.7v 99.505n 0.0v 109.495n 0.0v 109.505n 0.0v 119.495n 0.0v 119.505n 0.0v 129.495n 0.0v 129.505n 0.0v 139.495n 0.0v 139.505n 0.0v 149.495n 0.0v 149.505n 0.0v 159.495n 0.0v 159.505n 0.0v 169.495n 0.0v 169.505n 0.0v 179.495n 0.0v 179.505n 0.0v 189.495n 0.0v 189.505n 0.0v 199.495n 0.0v 199.505n 0.0v 209.495n 0.0v 209.505n 0.0v 219.495n 0.0v 219.505n 0.0v 229.495n 0.0v 229.505n 0.0v 239.495n 0.0v 239.505n 0.0v 249.495n 0.0v 249.505n 0.0v 259.495n 0.0v 259.505n 0.0v 269.495n 0.0v 269.505n 0.0v 279.495n 0.0v 279.505n 0.0v 289.495n 0.0v 289.505n 0.0v 299.495n 0.0v 299.505n 1.7v 309.495n 1.7v 309.505n 1.7v 319.495n 1.7v 319.505n 1.7v 329.495n 1.7v 329.505n 1.7v 339.495n 1.7v 339.505n 0.0v 349.495n 0.0v 349.505n 0.0v 359.495n 0.0v 359.505n 0.0v 369.495n 0.0v 369.505n 1.7v 379.495n 1.7v 379.505n 0.0v 389.495n 0.0v 389.505n 0.0v 399.495n 0.0v 399.505n 0.0v 409.495n 0.0v 409.505n 0.0v 419.495n 0.0v 419.505n 0.0v 429.495n 0.0v 429.505n 0.0v 439.495n 0.0v 439.505n 0.0v 449.495n 0.0v 449.505n 0.0v 459.495n 0.0v 459.505n 0.0v 469.495n 0.0v 469.505n 0.0v 479.495n 0.0v 479.505n 0.0v 489.495n 0.0v 489.505n 0.0v 499.495n 0.0v 499.505n 0.0v 509.495n 0.0v 509.505n 0.0v 519.495n 0.0v 519.505n 0.0v 529.495n 0.0v 529.505n 0.0v 539.495n 0.0v 539.505n 0.0v 549.495n 0.0v 549.505n 0.0v 559.495n 0.0v 559.505n 0.0v 569.495n 0.0v 569.505n 0.0v 579.495n 0.0v 579.505n 0.0v 589.495n 0.0v 589.505n 0.0v 599.495n 0.0v 599.505n 0.0v 609.495n 0.0v 609.505n 0.0v 619.495n 0.0v 619.505n 0.0v 629.495n 0.0v 629.505n 0.0v 639.495n 0.0v 639.505n 0.0v 649.495n 0.0v 649.505n 0.0v 659.495n 0.0v 659.505n 1.7v 669.495n 1.7v 669.505n 1.7v 679.495n 1.7v 679.505n 1.7v 689.495n 1.7v 689.505n 0.0v 699.495n 0.0v 699.505n 0.0v 709.495n 0.0v 709.505n 0.0v 719.495n 0.0v 719.505n 0.0v 729.495n 0.0v 729.505n 0.0v 739.495n 0.0v 739.505n 0.0v 749.495n 0.0v 749.505n 0.0v 759.495n 0.0v 759.505n 0.0v 769.495n 0.0v 769.505n 0.0v 779.495n 0.0v 779.505n 0.0v 789.495n 0.0v 789.505n 0.0v 799.495n 0.0v 799.505n 0.0v 809.495n 0.0v 809.505n 0.0v 819.495n 0.0v 819.505n 0.0v 829.495n 0.0v 829.505n 0.0v 839.495n 0.0v 839.505n 0.0v 849.495n 0.0v 849.505n 0.0v 859.495n 0.0v 859.505n 0.0v 869.495n 0.0v 869.505n 0.0v 879.495n 0.0v 879.505n 0.0v 889.495n 0.0v 889.505n 0.0v 899.495n 0.0v 899.505n 1.7v 909.495n 1.7v 909.505n 1.7v 919.495n 1.7v 919.505n 0.0v 929.495n 0.0v 929.505n 1.7v 939.495n 1.7v 939.505n 1.7v 949.495n 1.7v 949.505n 0.0v 959.495n 0.0v 959.505n 0.0v 969.495n 0.0v 969.505n 1.7v 979.495n 1.7v 979.505n 0.0v 989.495n 0.0v 989.505n 0.0v 999.495n 0.0v 999.505n 0.0v 1009.495n 0.0v 1009.505n 0.0v 1019.495n 0.0v 1019.505n 0.0v 1029.495n 0.0v 1029.505n 0.0v 1039.495n 0.0v 1039.505n 0.0v 1049.495n 0.0v 1049.505n 0.0v 1059.495n 0.0v 1059.505n 0.0v 1069.495n 0.0v 1069.505n 0.0v 1079.495n 0.0v 1079.505n 0.0v 1089.495n 0.0v 1089.505n 0.0v 1099.495n 0.0v 1099.505n 0.0v 1109.495n 0.0v 1109.505n 0.0v 1119.495n 0.0v 1119.505n 0.0v 1129.495n 0.0v 1129.505n 0.0v 1139.495n 0.0v 1139.505n 0.0v 1149.495n 0.0v 1149.505n 0.0v 1159.495n 0.0v 1159.505n 0.0v 1169.495n 0.0v 1169.505n 0.0v 1179.495n 0.0v 1179.505n 0.0v 1189.495n 0.0v 1189.505n 0.0v 1199.495n 0.0v 1199.505n 0.0v 1209.495n 0.0v 1209.505n 0.0v 1219.495n 0.0v 1219.505n 0.0v 1229.495n 0.0v 1229.505n 1.7v 1239.495n 1.7v 1239.505n 0.0v 1249.495n 0.0v 1249.505n 0.0v 1259.495n 0.0v 1259.505n 0.0v 1269.495n 0.0v 1269.505n 0.0v 1279.495n 0.0v 1279.505n 0.0v 1289.495n 0.0v 1289.505n 0.0v 1299.495n 0.0v 1299.505n 0.0v 1309.495n 0.0v 1309.505n 0.0v 1319.495n 0.0v 1319.505n 0.0v 1329.495n 0.0v 1329.505n 0.0v 1339.495n 0.0v 1339.505n 0.0v 1349.495n 0.0v 1349.505n 0.0v 1359.495n 0.0v 1359.505n 0.0v 1369.495n 0.0v 1369.505n 0.0v 1379.495n 0.0v 1379.505n 0.0v 1389.495n 0.0v 1389.505n 0.0v 1399.495n 0.0v 1399.505n 0.0v 1409.495n 0.0v 1409.505n 0.0v 1419.495n 0.0v 1419.505n 0.0v 1429.495n 0.0v 1429.505n 0.0v 1439.495n 0.0v 1439.505n 0.0v 1449.495n 0.0v 1449.505n 0.0v 1459.495n 0.0v 1459.505n 0.0v 1469.495n 0.0v 1469.505n 0.0v 1479.495n 0.0v 1479.505n 0.0v 1489.495n 0.0v 1489.505n 0.0v 1499.495n 0.0v 1499.505n 0.0v 1509.495n 0.0v 1509.505n 0.0v 1519.495n 0.0v 1519.505n 0.0v 1529.495n 0.0v 1529.505n 0.0v 1539.495n 0.0v 1539.505n 0.0v 1549.495n 0.0v 1549.505n 0.0v 1559.495n 0.0v 1559.505n 0.0v 1569.495n 0.0v 1569.505n 0.0v 1579.495n 0.0v 1579.505n 0.0v 1589.495n 0.0v 1589.505n 0.0v 1599.495n 0.0v 1599.505n 0.0v 1609.495n 0.0v 1609.505n 0.0v 1619.495n 0.0v 1619.505n 0.0v 1629.495n 0.0v 1629.505n 0.0v 1639.495n 0.0v 1639.505n 0.0v 1649.495n 0.0v 1649.505n 0.0v 1659.495n 0.0v 1659.505n 0.0v 1669.495n 0.0v 1669.505n 0.0v 1679.495n 0.0v 1679.505n 0.0v 1689.495n 0.0v 1689.505n 0.0v 1699.495n 0.0v 1699.505n 0.0v 1709.495n 0.0v 1709.505n 0.0v 1719.495n 0.0v 1719.505n 0.0v 1729.495n 0.0v 1729.505n 0.0v 1739.495n 0.0v 1739.505n 0.0v 1749.495n 0.0v 1749.505n 0.0v 1759.495n 0.0v 1759.505n 0.0v 1769.495n 0.0v 1769.505n 0.0v 1779.495n 0.0v 1779.505n 0.0v 1789.495n 0.0v 1789.505n 0.0v 1799.495n 0.0v 1799.505n 0.0v 1809.495n 0.0v 1809.505n 0.0v 1819.495n 0.0v 1819.505n 0.0v 1829.495n 0.0v 1829.505n 0.0v 1839.495n 0.0v 1839.505n 0.0v 1849.495n 0.0v 1849.505n 0.0v 1859.495n 0.0v 1859.505n 0.0v 1869.495n 0.0v 1869.505n 0.0v 1879.495n 0.0v 1879.505n 0.0v 1889.495n 0.0v 1889.505n 0.0v 1899.495n 0.0v 1899.505n 0.0v 1909.495n 0.0v 1909.505n 0.0v 1919.495n 0.0v 1919.505n 0.0v 1929.495n 0.0v 1929.505n 0.0v 1939.495n 0.0v 1939.505n 0.0v 1949.495n 0.0v 1949.505n 0.0v 1959.495n 0.0v 1959.505n 0.0v 1969.495n 0.0v 1969.505n 0.0v 1979.495n 0.0v 1979.505n 0.0v 1989.495n 0.0v 1989.505n 0.0v 1999.495n 0.0v 1999.505n 0.0v 2009.495n 0.0v 2009.505n 0.0v 2019.495n 0.0v 2019.505n 0.0v 2029.495n 0.0v 2029.505n 0.0v 2039.495n 0.0v 2039.505n 0.0v 2049.495n 0.0v 2049.505n 0.0v )
* (time, data): [(0, 0), (10, 0), (20, 0), (30, 0), (40, 0), (50, 0), (60, 0), (70, 0), (80, 0), (90, 0), (100, 1), (110, 1), (120, 1), (130, 1), (140, 1), (150, 0), (160, 0), (170, 1), (180, 0), (190, 0), (200, 0), (210, 0), (220, 0), (230, 0), (240, 0), (250, 1), (260, 1), (270, 1), (280, 0), (290, 0), (300, 0), (310, 0), (320, 0), (330, 0), (340, 1), (350, 1), (360, 0), (370, 0), (380, 1), (390, 1), (400, 1), (410, 1), (420, 1), (430, 0), (440, 0), (450, 0), (460, 0), (470, 0), (480, 1), (490, 0), (500, 0), (510, 1), (520, 1), (530, 1), (540, 1), (550, 1), (560, 0), (570, 0), (580, 1), (590, 1), (600, 1), (610, 1), (620, 1), (630, 1), (640, 1), (650, 1), (660, 0), (670, 0), (680, 0), (690, 1), (700, 1), (710, 1), (720, 1), (730, 0), (740, 0), (750, 1), (760, 1), (770, 1), (780, 0), (790, 0), (800, 0), (810, 0), (820, 0), (830, 0), (840, 0), (850, 0), (860, 0), (870, 0), (880, 1), (890, 0), (900, 0), (910, 0), (920, 1), (930, 0), (940, 0), (950, 1), (960, 0), (970, 0), (980, 1), (990, 1), (1000, 1), (1010, 1), (1020, 0), (1030, 0), (1040, 0), (1050, 0), (1060, 0), (1070, 0), (1080, 0), (1090, 0), (1100, 1), (1110, 1), (1120, 1), (1130, 1), (1140, 1), (1150, 1), (1160, 1), (1170, 1), (1180, 1), (1190, 0), (1200, 1), (1210, 1), (1220, 1), (1230, 0), (1240, 1), (1250, 1), (1260, 1), (1270, 1), (1280, 1), (1290, 0), (1300, 0), (1310, 0), (1320, 1), (1330, 1), (1340, 1), (1350, 1), (1360, 1), (1370, 0), (1380, 0), (1390, 1), (1400, 1), (1410, 1), (1420, 1), (1430, 1), (1440, 1), (1450, 1), (1460, 0), (1470, 0), (1480, 0), (1490, 0), (1500, 1), (1510, 1), (1520, 1), (1530, 0), (1540, 0), (1550, 0), (1560, 0), (1570, 0), (1580, 0), (1590, 0), (1600, 1), (1610, 0), (1620, 0), (1630, 0), (1640, 0), (1650, 1), (1660, 1), (1670, 1), (1680, 1), (1690, 1), (1700, 1), (1710, 1), (1720, 1), (1730, 1), (1740, 1), (1750, 1), (1760, 1), (1770, 0), (1780, 0), (1790, 0), (1800, 0), (1810, 0), (1820, 0), (1830, 0), (1840, 0), (1850, 0), (1860, 1), (1870, 1), (1880, 1), (1890, 1), (1900, 0), (1910, 0), (1920, 1), (1930, 1), (1940, 0), (1950, 0), (1960, 0), (1970, 0), (1980, 0), (1990, 0), (2000, 0), (2010, 0), (2020, 0), (2030, 0), (2040, 0), (2050, 0)]
Va1_8  a1_8  0 PWL (0n 0.0v 9.495n 0.0v 9.505n 0.0v 19.495n 0.0v 19.505n 0.0v 29.495n 0.0v 29.505n 0.0v 39.495n 0.0v 39.505n 0.0v 49.495n 0.0v 49.505n 0.0v 59.495n 0.0v 59.505n 0.0v 69.495n 0.0v 69.505n 0.0v 79.495n 0.0v 79.505n 0.0v 89.495n 0.0v 89.505n 0.0v 99.495n 0.0v 99.505n 1.7v 109.495n 1.7v 109.505n 1.7v 119.495n 1.7v 119.505n 1.7v 129.495n 1.7v 129.505n 1.7v 139.495n 1.7v 139.505n 1.7v 149.495n 1.7v 149.505n 0.0v 159.495n 0.0v 159.505n 0.0v 169.495n 0.0v 169.505n 1.7v 179.495n 1.7v 179.505n 0.0v 189.495n 0.0v 189.505n 0.0v 199.495n 0.0v 199.505n 0.0v 209.495n 0.0v 209.505n 0.0v 219.495n 0.0v 219.505n 0.0v 229.495n 0.0v 229.505n 0.0v 239.495n 0.0v 239.505n 0.0v 249.495n 0.0v 249.505n 1.7v 259.495n 1.7v 259.505n 1.7v 269.495n 1.7v 269.505n 1.7v 279.495n 1.7v 279.505n 0.0v 289.495n 0.0v 289.505n 0.0v 299.495n 0.0v 299.505n 0.0v 309.495n 0.0v 309.505n 0.0v 319.495n 0.0v 319.505n 0.0v 329.495n 0.0v 329.505n 0.0v 339.495n 0.0v 339.505n 1.7v 349.495n 1.7v 349.505n 1.7v 359.495n 1.7v 359.505n 0.0v 369.495n 0.0v 369.505n 0.0v 379.495n 0.0v 379.505n 1.7v 389.495n 1.7v 389.505n 1.7v 399.495n 1.7v 399.505n 1.7v 409.495n 1.7v 409.505n 1.7v 419.495n 1.7v 419.505n 1.7v 429.495n 1.7v 429.505n 0.0v 439.495n 0.0v 439.505n 0.0v 449.495n 0.0v 449.505n 0.0v 459.495n 0.0v 459.505n 0.0v 469.495n 0.0v 469.505n 0.0v 479.495n 0.0v 479.505n 1.7v 489.495n 1.7v 489.505n 0.0v 499.495n 0.0v 499.505n 0.0v 509.495n 0.0v 509.505n 1.7v 519.495n 1.7v 519.505n 1.7v 529.495n 1.7v 529.505n 1.7v 539.495n 1.7v 539.505n 1.7v 549.495n 1.7v 549.505n 1.7v 559.495n 1.7v 559.505n 0.0v 569.495n 0.0v 569.505n 0.0v 579.495n 0.0v 579.505n 1.7v 589.495n 1.7v 589.505n 1.7v 599.495n 1.7v 599.505n 1.7v 609.495n 1.7v 609.505n 1.7v 619.495n 1.7v 619.505n 1.7v 629.495n 1.7v 629.505n 1.7v 639.495n 1.7v 639.505n 1.7v 649.495n 1.7v 649.505n 1.7v 659.495n 1.7v 659.505n 0.0v 669.495n 0.0v 669.505n 0.0v 679.495n 0.0v 679.505n 0.0v 689.495n 0.0v 689.505n 1.7v 699.495n 1.7v 699.505n 1.7v 709.495n 1.7v 709.505n 1.7v 719.495n 1.7v 719.505n 1.7v 729.495n 1.7v 729.505n 0.0v 739.495n 0.0v 739.505n 0.0v 749.495n 0.0v 749.505n 1.7v 759.495n 1.7v 759.505n 1.7v 769.495n 1.7v 769.505n 1.7v 779.495n 1.7v 779.505n 0.0v 789.495n 0.0v 789.505n 0.0v 799.495n 0.0v 799.505n 0.0v 809.495n 0.0v 809.505n 0.0v 819.495n 0.0v 819.505n 0.0v 829.495n 0.0v 829.505n 0.0v 839.495n 0.0v 839.505n 0.0v 849.495n 0.0v 849.505n 0.0v 859.495n 0.0v 859.505n 0.0v 869.495n 0.0v 869.505n 0.0v 879.495n 0.0v 879.505n 1.7v 889.495n 1.7v 889.505n 0.0v 899.495n 0.0v 899.505n 0.0v 909.495n 0.0v 909.505n 0.0v 919.495n 0.0v 919.505n 1.7v 929.495n 1.7v 929.505n 0.0v 939.495n 0.0v 939.505n 0.0v 949.495n 0.0v 949.505n 1.7v 959.495n 1.7v 959.505n 0.0v 969.495n 0.0v 969.505n 0.0v 979.495n 0.0v 979.505n 1.7v 989.495n 1.7v 989.505n 1.7v 999.495n 1.7v 999.505n 1.7v 1009.495n 1.7v 1009.505n 1.7v 1019.495n 1.7v 1019.505n 0.0v 1029.495n 0.0v 1029.505n 0.0v 1039.495n 0.0v 1039.505n 0.0v 1049.495n 0.0v 1049.505n 0.0v 1059.495n 0.0v 1059.505n 0.0v 1069.495n 0.0v 1069.505n 0.0v 1079.495n 0.0v 1079.505n 0.0v 1089.495n 0.0v 1089.505n 0.0v 1099.495n 0.0v 1099.505n 1.7v 1109.495n 1.7v 1109.505n 1.7v 1119.495n 1.7v 1119.505n 1.7v 1129.495n 1.7v 1129.505n 1.7v 1139.495n 1.7v 1139.505n 1.7v 1149.495n 1.7v 1149.505n 1.7v 1159.495n 1.7v 1159.505n 1.7v 1169.495n 1.7v 1169.505n 1.7v 1179.495n 1.7v 1179.505n 1.7v 1189.495n 1.7v 1189.505n 0.0v 1199.495n 0.0v 1199.505n 1.7v 1209.495n 1.7v 1209.505n 1.7v 1219.495n 1.7v 1219.505n 1.7v 1229.495n 1.7v 1229.505n 0.0v 1239.495n 0.0v 1239.505n 1.7v 1249.495n 1.7v 1249.505n 1.7v 1259.495n 1.7v 1259.505n 1.7v 1269.495n 1.7v 1269.505n 1.7v 1279.495n 1.7v 1279.505n 1.7v 1289.495n 1.7v 1289.505n 0.0v 1299.495n 0.0v 1299.505n 0.0v 1309.495n 0.0v 1309.505n 0.0v 1319.495n 0.0v 1319.505n 1.7v 1329.495n 1.7v 1329.505n 1.7v 1339.495n 1.7v 1339.505n 1.7v 1349.495n 1.7v 1349.505n 1.7v 1359.495n 1.7v 1359.505n 1.7v 1369.495n 1.7v 1369.505n 0.0v 1379.495n 0.0v 1379.505n 0.0v 1389.495n 0.0v 1389.505n 1.7v 1399.495n 1.7v 1399.505n 1.7v 1409.495n 1.7v 1409.505n 1.7v 1419.495n 1.7v 1419.505n 1.7v 1429.495n 1.7v 1429.505n 1.7v 1439.495n 1.7v 1439.505n 1.7v 1449.495n 1.7v 1449.505n 1.7v 1459.495n 1.7v 1459.505n 0.0v 1469.495n 0.0v 1469.505n 0.0v 1479.495n 0.0v 1479.505n 0.0v 1489.495n 0.0v 1489.505n 0.0v 1499.495n 0.0v 1499.505n 1.7v 1509.495n 1.7v 1509.505n 1.7v 1519.495n 1.7v 1519.505n 1.7v 1529.495n 1.7v 1529.505n 0.0v 1539.495n 0.0v 1539.505n 0.0v 1549.495n 0.0v 1549.505n 0.0v 1559.495n 0.0v 1559.505n 0.0v 1569.495n 0.0v 1569.505n 0.0v 1579.495n 0.0v 1579.505n 0.0v 1589.495n 0.0v 1589.505n 0.0v 1599.495n 0.0v 1599.505n 1.7v 1609.495n 1.7v 1609.505n 0.0v 1619.495n 0.0v 1619.505n 0.0v 1629.495n 0.0v 1629.505n 0.0v 1639.495n 0.0v 1639.505n 0.0v 1649.495n 0.0v 1649.505n 1.7v 1659.495n 1.7v 1659.505n 1.7v 1669.495n 1.7v 1669.505n 1.7v 1679.495n 1.7v 1679.505n 1.7v 1689.495n 1.7v 1689.505n 1.7v 1699.495n 1.7v 1699.505n 1.7v 1709.495n 1.7v 1709.505n 1.7v 1719.495n 1.7v 1719.505n 1.7v 1729.495n 1.7v 1729.505n 1.7v 1739.495n 1.7v 1739.505n 1.7v 1749.495n 1.7v 1749.505n 1.7v 1759.495n 1.7v 1759.505n 1.7v 1769.495n 1.7v 1769.505n 0.0v 1779.495n 0.0v 1779.505n 0.0v 1789.495n 0.0v 1789.505n 0.0v 1799.495n 0.0v 1799.505n 0.0v 1809.495n 0.0v 1809.505n 0.0v 1819.495n 0.0v 1819.505n 0.0v 1829.495n 0.0v 1829.505n 0.0v 1839.495n 0.0v 1839.505n 0.0v 1849.495n 0.0v 1849.505n 0.0v 1859.495n 0.0v 1859.505n 1.7v 1869.495n 1.7v 1869.505n 1.7v 1879.495n 1.7v 1879.505n 1.7v 1889.495n 1.7v 1889.505n 1.7v 1899.495n 1.7v 1899.505n 0.0v 1909.495n 0.0v 1909.505n 0.0v 1919.495n 0.0v 1919.505n 1.7v 1929.495n 1.7v 1929.505n 1.7v 1939.495n 1.7v 1939.505n 0.0v 1949.495n 0.0v 1949.505n 0.0v 1959.495n 0.0v 1959.505n 0.0v 1969.495n 0.0v 1969.505n 0.0v 1979.495n 0.0v 1979.505n 0.0v 1989.495n 0.0v 1989.505n 0.0v 1999.495n 0.0v 1999.505n 0.0v 2009.495n 0.0v 2009.505n 0.0v 2019.495n 0.0v 2019.505n 0.0v 2029.495n 0.0v 2029.505n 0.0v 2039.495n 0.0v 2039.505n 0.0v 2049.495n 0.0v 2049.505n 0.0v )

 * Generation of control signals
* (time, data): [(0, 1), (10, 0), (20, 0), (30, 0), (40, 1), (50, 1), (60, 1), (70, 0), (80, 0), (90, 1), (100, 1), (110, 0), (120, 1), (130, 1), (140, 1), (150, 1), (160, 0), (170, 1), (180, 1), (190, 0), (200, 1), (210, 0), (220, 1), (230, 0), (240, 1), (250, 0), (260, 1), (270, 1), (280, 0), (290, 1), (300, 1), (310, 0), (320, 1), (330, 0), (340, 1), (350, 0), (360, 1), (370, 0), (380, 1), (390, 0), (400, 1), (410, 1), (420, 0), (430, 1), (440, 1), (450, 0), (460, 0), (470, 0), (480, 0), (490, 1), (500, 0), (510, 1), (520, 1), (530, 1), (540, 1), (550, 0), (560, 1), (570, 1), (580, 1), (590, 0), (600, 0), (610, 1), (620, 0), (630, 0), (640, 1), (650, 0), (660, 0), (670, 0), (680, 0), (690, 0), (700, 1), (710, 0), (720, 0), (730, 1), (740, 0), (750, 1), (760, 1), (770, 0), (780, 0), (790, 0), (800, 1), (810, 0), (820, 1), (830, 1), (840, 0), (850, 1), (860, 0), (870, 0), (880, 0), (890, 1), (900, 1), (910, 0), (920, 1), (930, 1), (940, 1), (950, 0), (960, 0), (970, 1), (980, 1), (990, 1), (1000, 0), (1010, 1), (1020, 0), (1030, 0), (1040, 1), (1050, 0), (1060, 1), (1070, 0), (1080, 1), (1090, 1), (1100, 0), (1110, 1), (1120, 1), (1130, 0), (1140, 1), (1150, 1), (1160, 0), (1170, 1), (1180, 0), (1190, 1), (1200, 1), (1210, 1), (1220, 1), (1230, 0), (1240, 1), (1250, 1), (1260, 1), (1270, 1), (1280, 0), (1290, 0), (1300, 0), (1310, 1), (1320, 1), (1330, 1), (1340, 1), (1350, 0), (1360, 1), (1370, 1), (1380, 1), (1390, 0), (1400, 0), (1410, 0), (1420, 1), (1430, 1), (1440, 0), (1450, 0), (1460, 1), (1470, 0), (1480, 1), (1490, 1), (1500, 0), (1510, 1), (1520, 0), (1530, 1), (1540, 1), (1550, 0), (1560, 0), (1570, 0), (1580, 0), (1590, 1), (1600, 1), (1610, 0), (1620, 1), (1630, 1), (1640, 0), (1650, 0), (1660, 1), (1670, 0), (1680, 0), (1690, 0), (1700, 0), (1710, 1), (1720, 0), (1730, 1), (1740, 0), (1750, 1), (1760, 0), (1770, 1), (1780, 0), (1790, 1), (1800, 1), (1810, 0), (1820, 0), (1830, 1), (1840, 1), (1850, 0), (1860, 0), (1870, 1), (1880, 0), (1890, 0), (1900, 0), (1910, 0), (1920, 0), (1930, 1), (1940, 1), (1950, 0), (1960, 1), (1970, 0), (1980, 0), (1990, 0), (2000, 0), (2010, 1), (2020, 0), (2030, 0), (2040, 0), (2050, 1)]
VCSB0 CSB0 0 PWL (0n 1.7v 9.495n 1.7v 9.505n 0.0v 19.495n 0.0v 19.505n 0.0v 29.495n 0.0v 29.505n 0.0v 39.495n 0.0v 39.505n 1.7v 49.495n 1.7v 49.505n 1.7v 59.495n 1.7v 59.505n 1.7v 69.495n 1.7v 69.505n 0.0v 79.495n 0.0v 79.505n 0.0v 89.495n 0.0v 89.505n 1.7v 99.495n 1.7v 99.505n 1.7v 109.495n 1.7v 109.505n 0.0v 119.495n 0.0v 119.505n 1.7v 129.495n 1.7v 129.505n 1.7v 139.495n 1.7v 139.505n 1.7v 149.495n 1.7v 149.505n 1.7v 159.495n 1.7v 159.505n 0.0v 169.495n 0.0v 169.505n 1.7v 179.495n 1.7v 179.505n 1.7v 189.495n 1.7v 189.505n 0.0v 199.495n 0.0v 199.505n 1.7v 209.495n 1.7v 209.505n 0.0v 219.495n 0.0v 219.505n 1.7v 229.495n 1.7v 229.505n 0.0v 239.495n 0.0v 239.505n 1.7v 249.495n 1.7v 249.505n 0.0v 259.495n 0.0v 259.505n 1.7v 269.495n 1.7v 269.505n 1.7v 279.495n 1.7v 279.505n 0.0v 289.495n 0.0v 289.505n 1.7v 299.495n 1.7v 299.505n 1.7v 309.495n 1.7v 309.505n 0.0v 319.495n 0.0v 319.505n 1.7v 329.495n 1.7v 329.505n 0.0v 339.495n 0.0v 339.505n 1.7v 349.495n 1.7v 349.505n 0.0v 359.495n 0.0v 359.505n 1.7v 369.495n 1.7v 369.505n 0.0v 379.495n 0.0v 379.505n 1.7v 389.495n 1.7v 389.505n 0.0v 399.495n 0.0v 399.505n 1.7v 409.495n 1.7v 409.505n 1.7v 419.495n 1.7v 419.505n 0.0v 429.495n 0.0v 429.505n 1.7v 439.495n 1.7v 439.505n 1.7v 449.495n 1.7v 449.505n 0.0v 459.495n 0.0v 459.505n 0.0v 469.495n 0.0v 469.505n 0.0v 479.495n 0.0v 479.505n 0.0v 489.495n 0.0v 489.505n 1.7v 499.495n 1.7v 499.505n 0.0v 509.495n 0.0v 509.505n 1.7v 519.495n 1.7v 519.505n 1.7v 529.495n 1.7v 529.505n 1.7v 539.495n 1.7v 539.505n 1.7v 549.495n 1.7v 549.505n 0.0v 559.495n 0.0v 559.505n 1.7v 569.495n 1.7v 569.505n 1.7v 579.495n 1.7v 579.505n 1.7v 589.495n 1.7v 589.505n 0.0v 599.495n 0.0v 599.505n 0.0v 609.495n 0.0v 609.505n 1.7v 619.495n 1.7v 619.505n 0.0v 629.495n 0.0v 629.505n 0.0v 639.495n 0.0v 639.505n 1.7v 649.495n 1.7v 649.505n 0.0v 659.495n 0.0v 659.505n 0.0v 669.495n 0.0v 669.505n 0.0v 679.495n 0.0v 679.505n 0.0v 689.495n 0.0v 689.505n 0.0v 699.495n 0.0v 699.505n 1.7v 709.495n 1.7v 709.505n 0.0v 719.495n 0.0v 719.505n 0.0v 729.495n 0.0v 729.505n 1.7v 739.495n 1.7v 739.505n 0.0v 749.495n 0.0v 749.505n 1.7v 759.495n 1.7v 759.505n 1.7v 769.495n 1.7v 769.505n 0.0v 779.495n 0.0v 779.505n 0.0v 789.495n 0.0v 789.505n 0.0v 799.495n 0.0v 799.505n 1.7v 809.495n 1.7v 809.505n 0.0v 819.495n 0.0v 819.505n 1.7v 829.495n 1.7v 829.505n 1.7v 839.495n 1.7v 839.505n 0.0v 849.495n 0.0v 849.505n 1.7v 859.495n 1.7v 859.505n 0.0v 869.495n 0.0v 869.505n 0.0v 879.495n 0.0v 879.505n 0.0v 889.495n 0.0v 889.505n 1.7v 899.495n 1.7v 899.505n 1.7v 909.495n 1.7v 909.505n 0.0v 919.495n 0.0v 919.505n 1.7v 929.495n 1.7v 929.505n 1.7v 939.495n 1.7v 939.505n 1.7v 949.495n 1.7v 949.505n 0.0v 959.495n 0.0v 959.505n 0.0v 969.495n 0.0v 969.505n 1.7v 979.495n 1.7v 979.505n 1.7v 989.495n 1.7v 989.505n 1.7v 999.495n 1.7v 999.505n 0.0v 1009.495n 0.0v 1009.505n 1.7v 1019.495n 1.7v 1019.505n 0.0v 1029.495n 0.0v 1029.505n 0.0v 1039.495n 0.0v 1039.505n 1.7v 1049.495n 1.7v 1049.505n 0.0v 1059.495n 0.0v 1059.505n 1.7v 1069.495n 1.7v 1069.505n 0.0v 1079.495n 0.0v 1079.505n 1.7v 1089.495n 1.7v 1089.505n 1.7v 1099.495n 1.7v 1099.505n 0.0v 1109.495n 0.0v 1109.505n 1.7v 1119.495n 1.7v 1119.505n 1.7v 1129.495n 1.7v 1129.505n 0.0v 1139.495n 0.0v 1139.505n 1.7v 1149.495n 1.7v 1149.505n 1.7v 1159.495n 1.7v 1159.505n 0.0v 1169.495n 0.0v 1169.505n 1.7v 1179.495n 1.7v 1179.505n 0.0v 1189.495n 0.0v 1189.505n 1.7v 1199.495n 1.7v 1199.505n 1.7v 1209.495n 1.7v 1209.505n 1.7v 1219.495n 1.7v 1219.505n 1.7v 1229.495n 1.7v 1229.505n 0.0v 1239.495n 0.0v 1239.505n 1.7v 1249.495n 1.7v 1249.505n 1.7v 1259.495n 1.7v 1259.505n 1.7v 1269.495n 1.7v 1269.505n 1.7v 1279.495n 1.7v 1279.505n 0.0v 1289.495n 0.0v 1289.505n 0.0v 1299.495n 0.0v 1299.505n 0.0v 1309.495n 0.0v 1309.505n 1.7v 1319.495n 1.7v 1319.505n 1.7v 1329.495n 1.7v 1329.505n 1.7v 1339.495n 1.7v 1339.505n 1.7v 1349.495n 1.7v 1349.505n 0.0v 1359.495n 0.0v 1359.505n 1.7v 1369.495n 1.7v 1369.505n 1.7v 1379.495n 1.7v 1379.505n 1.7v 1389.495n 1.7v 1389.505n 0.0v 1399.495n 0.0v 1399.505n 0.0v 1409.495n 0.0v 1409.505n 0.0v 1419.495n 0.0v 1419.505n 1.7v 1429.495n 1.7v 1429.505n 1.7v 1439.495n 1.7v 1439.505n 0.0v 1449.495n 0.0v 1449.505n 0.0v 1459.495n 0.0v 1459.505n 1.7v 1469.495n 1.7v 1469.505n 0.0v 1479.495n 0.0v 1479.505n 1.7v 1489.495n 1.7v 1489.505n 1.7v 1499.495n 1.7v 1499.505n 0.0v 1509.495n 0.0v 1509.505n 1.7v 1519.495n 1.7v 1519.505n 0.0v 1529.495n 0.0v 1529.505n 1.7v 1539.495n 1.7v 1539.505n 1.7v 1549.495n 1.7v 1549.505n 0.0v 1559.495n 0.0v 1559.505n 0.0v 1569.495n 0.0v 1569.505n 0.0v 1579.495n 0.0v 1579.505n 0.0v 1589.495n 0.0v 1589.505n 1.7v 1599.495n 1.7v 1599.505n 1.7v 1609.495n 1.7v 1609.505n 0.0v 1619.495n 0.0v 1619.505n 1.7v 1629.495n 1.7v 1629.505n 1.7v 1639.495n 1.7v 1639.505n 0.0v 1649.495n 0.0v 1649.505n 0.0v 1659.495n 0.0v 1659.505n 1.7v 1669.495n 1.7v 1669.505n 0.0v 1679.495n 0.0v 1679.505n 0.0v 1689.495n 0.0v 1689.505n 0.0v 1699.495n 0.0v 1699.505n 0.0v 1709.495n 0.0v 1709.505n 1.7v 1719.495n 1.7v 1719.505n 0.0v 1729.495n 0.0v 1729.505n 1.7v 1739.495n 1.7v 1739.505n 0.0v 1749.495n 0.0v 1749.505n 1.7v 1759.495n 1.7v 1759.505n 0.0v 1769.495n 0.0v 1769.505n 1.7v 1779.495n 1.7v 1779.505n 0.0v 1789.495n 0.0v 1789.505n 1.7v 1799.495n 1.7v 1799.505n 1.7v 1809.495n 1.7v 1809.505n 0.0v 1819.495n 0.0v 1819.505n 0.0v 1829.495n 0.0v 1829.505n 1.7v 1839.495n 1.7v 1839.505n 1.7v 1849.495n 1.7v 1849.505n 0.0v 1859.495n 0.0v 1859.505n 0.0v 1869.495n 0.0v 1869.505n 1.7v 1879.495n 1.7v 1879.505n 0.0v 1889.495n 0.0v 1889.505n 0.0v 1899.495n 0.0v 1899.505n 0.0v 1909.495n 0.0v 1909.505n 0.0v 1919.495n 0.0v 1919.505n 0.0v 1929.495n 0.0v 1929.505n 1.7v 1939.495n 1.7v 1939.505n 1.7v 1949.495n 1.7v 1949.505n 0.0v 1959.495n 0.0v 1959.505n 1.7v 1969.495n 1.7v 1969.505n 0.0v 1979.495n 0.0v 1979.505n 0.0v 1989.495n 0.0v 1989.505n 0.0v 1999.495n 0.0v 1999.505n 0.0v 2009.495n 0.0v 2009.505n 1.7v 2019.495n 1.7v 2019.505n 0.0v 2029.495n 0.0v 2029.505n 0.0v 2039.495n 0.0v 2039.505n 0.0v 2049.495n 0.0v 2049.505n 1.7v )
* (time, data): [(0, 1), (10, 1), (20, 1), (30, 1), (40, 0), (50, 1), (60, 1), (70, 0), (80, 1), (90, 1), (100, 0), (110, 1), (120, 1), (130, 1), (140, 1), (150, 0), (160, 1), (170, 0), (180, 0), (190, 1), (200, 1), (210, 1), (220, 1), (230, 1), (240, 1), (250, 0), (260, 1), (270, 0), (280, 0), (290, 0), (300, 0), (310, 1), (320, 1), (330, 1), (340, 0), (350, 0), (360, 0), (370, 0), (380, 0), (390, 1), (400, 1), (410, 0), (420, 1), (430, 0), (440, 1), (450, 1), (460, 1), (470, 1), (480, 0), (490, 0), (500, 1), (510, 0), (520, 1), (530, 1), (540, 0), (550, 1), (560, 0), (570, 1), (580, 0), (590, 0), (600, 0), (610, 1), (620, 0), (630, 1), (640, 1), (650, 0), (660, 0), (670, 1), (680, 1), (690, 0), (700, 1), (710, 1), (720, 1), (730, 0), (740, 0), (750, 0), (760, 1), (770, 0), (780, 0), (790, 1), (800, 1), (810, 1), (820, 1), (830, 1), (840, 1), (850, 1), (860, 0), (870, 0), (880, 0), (890, 0), (900, 0), (910, 1), (920, 0), (930, 0), (940, 0), (950, 0), (960, 0), (970, 0), (980, 0), (990, 1), (1000, 1), (1010, 1), (1020, 0), (1030, 1), (1040, 1), (1050, 1), (1060, 1), (1070, 1), (1080, 1), (1090, 1), (1100, 0), (1110, 1), (1120, 1), (1130, 0), (1140, 0), (1150, 0), (1160, 1), (1170, 1), (1180, 1), (1190, 0), (1200, 0), (1210, 1), (1220, 1), (1230, 0), (1240, 0), (1250, 1), (1260, 1), (1270, 1), (1280, 1), (1290, 0), (1300, 0), (1310, 1), (1320, 0), (1330, 1), (1340, 1), (1350, 1), (1360, 1), (1370, 0), (1380, 0), (1390, 0), (1400, 0), (1410, 1), (1420, 0), (1430, 0), (1440, 1), (1450, 1), (1460, 0), (1470, 1), (1480, 1), (1490, 1), (1500, 0), (1510, 0), (1520, 1), (1530, 0), (1540, 1), (1550, 1), (1560, 1), (1570, 1), (1580, 1), (1590, 1), (1600, 0), (1610, 0), (1620, 1), (1630, 1), (1640, 1), (1650, 0), (1660, 1), (1670, 1), (1680, 1), (1690, 1), (1700, 1), (1710, 1), (1720, 1), (1730, 1), (1740, 1), (1750, 1), (1760, 1), (1770, 0), (1780, 1), (1790, 1), (1800, 1), (1810, 0), (1820, 1), (1830, 0), (1840, 1), (1850, 1), (1860, 0), (1870, 1), (1880, 1), (1890, 1), (1900, 0), (1910, 1), (1920, 0), (1930, 1), (1940, 0), (1950, 1), (1960, 0), (1970, 1), (1980, 0), (1990, 1), (2000, 1), (2010, 0), (2020, 1), (2030, 1), (2040, 1), (2050, 1)]
VCSB1 CSB1 0 PWL (0n 1.7v 9.495n 1.7v 9.505n 1.7v 19.495n 1.7v 19.505n 1.7v 29.495n 1.7v 29.505n 1.7v 39.495n 1.7v 39.505n 0.0v 49.495n 0.0v 49.505n 1.7v 59.495n 1.7v 59.505n 1.7v 69.495n 1.7v 69.505n 0.0v 79.495n 0.0v 79.505n 1.7v 89.495n 1.7v 89.505n 1.7v 99.495n 1.7v 99.505n 0.0v 109.495n 0.0v 109.505n 1.7v 119.495n 1.7v 119.505n 1.7v 129.495n 1.7v 129.505n 1.7v 139.495n 1.7v 139.505n 1.7v 149.495n 1.7v 149.505n 0.0v 159.495n 0.0v 159.505n 1.7v 169.495n 1.7v 169.505n 0.0v 179.495n 0.0v 179.505n 0.0v 189.495n 0.0v 189.505n 1.7v 199.495n 1.7v 199.505n 1.7v 209.495n 1.7v 209.505n 1.7v 219.495n 1.7v 219.505n 1.7v 229.495n 1.7v 229.505n 1.7v 239.495n 1.7v 239.505n 1.7v 249.495n 1.7v 249.505n 0.0v 259.495n 0.0v 259.505n 1.7v 269.495n 1.7v 269.505n 0.0v 279.495n 0.0v 279.505n 0.0v 289.495n 0.0v 289.505n 0.0v 299.495n 0.0v 299.505n 0.0v 309.495n 0.0v 309.505n 1.7v 319.495n 1.7v 319.505n 1.7v 329.495n 1.7v 329.505n 1.7v 339.495n 1.7v 339.505n 0.0v 349.495n 0.0v 349.505n 0.0v 359.495n 0.0v 359.505n 0.0v 369.495n 0.0v 369.505n 0.0v 379.495n 0.0v 379.505n 0.0v 389.495n 0.0v 389.505n 1.7v 399.495n 1.7v 399.505n 1.7v 409.495n 1.7v 409.505n 0.0v 419.495n 0.0v 419.505n 1.7v 429.495n 1.7v 429.505n 0.0v 439.495n 0.0v 439.505n 1.7v 449.495n 1.7v 449.505n 1.7v 459.495n 1.7v 459.505n 1.7v 469.495n 1.7v 469.505n 1.7v 479.495n 1.7v 479.505n 0.0v 489.495n 0.0v 489.505n 0.0v 499.495n 0.0v 499.505n 1.7v 509.495n 1.7v 509.505n 0.0v 519.495n 0.0v 519.505n 1.7v 529.495n 1.7v 529.505n 1.7v 539.495n 1.7v 539.505n 0.0v 549.495n 0.0v 549.505n 1.7v 559.495n 1.7v 559.505n 0.0v 569.495n 0.0v 569.505n 1.7v 579.495n 1.7v 579.505n 0.0v 589.495n 0.0v 589.505n 0.0v 599.495n 0.0v 599.505n 0.0v 609.495n 0.0v 609.505n 1.7v 619.495n 1.7v 619.505n 0.0v 629.495n 0.0v 629.505n 1.7v 639.495n 1.7v 639.505n 1.7v 649.495n 1.7v 649.505n 0.0v 659.495n 0.0v 659.505n 0.0v 669.495n 0.0v 669.505n 1.7v 679.495n 1.7v 679.505n 1.7v 689.495n 1.7v 689.505n 0.0v 699.495n 0.0v 699.505n 1.7v 709.495n 1.7v 709.505n 1.7v 719.495n 1.7v 719.505n 1.7v 729.495n 1.7v 729.505n 0.0v 739.495n 0.0v 739.505n 0.0v 749.495n 0.0v 749.505n 0.0v 759.495n 0.0v 759.505n 1.7v 769.495n 1.7v 769.505n 0.0v 779.495n 0.0v 779.505n 0.0v 789.495n 0.0v 789.505n 1.7v 799.495n 1.7v 799.505n 1.7v 809.495n 1.7v 809.505n 1.7v 819.495n 1.7v 819.505n 1.7v 829.495n 1.7v 829.505n 1.7v 839.495n 1.7v 839.505n 1.7v 849.495n 1.7v 849.505n 1.7v 859.495n 1.7v 859.505n 0.0v 869.495n 0.0v 869.505n 0.0v 879.495n 0.0v 879.505n 0.0v 889.495n 0.0v 889.505n 0.0v 899.495n 0.0v 899.505n 0.0v 909.495n 0.0v 909.505n 1.7v 919.495n 1.7v 919.505n 0.0v 929.495n 0.0v 929.505n 0.0v 939.495n 0.0v 939.505n 0.0v 949.495n 0.0v 949.505n 0.0v 959.495n 0.0v 959.505n 0.0v 969.495n 0.0v 969.505n 0.0v 979.495n 0.0v 979.505n 0.0v 989.495n 0.0v 989.505n 1.7v 999.495n 1.7v 999.505n 1.7v 1009.495n 1.7v 1009.505n 1.7v 1019.495n 1.7v 1019.505n 0.0v 1029.495n 0.0v 1029.505n 1.7v 1039.495n 1.7v 1039.505n 1.7v 1049.495n 1.7v 1049.505n 1.7v 1059.495n 1.7v 1059.505n 1.7v 1069.495n 1.7v 1069.505n 1.7v 1079.495n 1.7v 1079.505n 1.7v 1089.495n 1.7v 1089.505n 1.7v 1099.495n 1.7v 1099.505n 0.0v 1109.495n 0.0v 1109.505n 1.7v 1119.495n 1.7v 1119.505n 1.7v 1129.495n 1.7v 1129.505n 0.0v 1139.495n 0.0v 1139.505n 0.0v 1149.495n 0.0v 1149.505n 0.0v 1159.495n 0.0v 1159.505n 1.7v 1169.495n 1.7v 1169.505n 1.7v 1179.495n 1.7v 1179.505n 1.7v 1189.495n 1.7v 1189.505n 0.0v 1199.495n 0.0v 1199.505n 0.0v 1209.495n 0.0v 1209.505n 1.7v 1219.495n 1.7v 1219.505n 1.7v 1229.495n 1.7v 1229.505n 0.0v 1239.495n 0.0v 1239.505n 0.0v 1249.495n 0.0v 1249.505n 1.7v 1259.495n 1.7v 1259.505n 1.7v 1269.495n 1.7v 1269.505n 1.7v 1279.495n 1.7v 1279.505n 1.7v 1289.495n 1.7v 1289.505n 0.0v 1299.495n 0.0v 1299.505n 0.0v 1309.495n 0.0v 1309.505n 1.7v 1319.495n 1.7v 1319.505n 0.0v 1329.495n 0.0v 1329.505n 1.7v 1339.495n 1.7v 1339.505n 1.7v 1349.495n 1.7v 1349.505n 1.7v 1359.495n 1.7v 1359.505n 1.7v 1369.495n 1.7v 1369.505n 0.0v 1379.495n 0.0v 1379.505n 0.0v 1389.495n 0.0v 1389.505n 0.0v 1399.495n 0.0v 1399.505n 0.0v 1409.495n 0.0v 1409.505n 1.7v 1419.495n 1.7v 1419.505n 0.0v 1429.495n 0.0v 1429.505n 0.0v 1439.495n 0.0v 1439.505n 1.7v 1449.495n 1.7v 1449.505n 1.7v 1459.495n 1.7v 1459.505n 0.0v 1469.495n 0.0v 1469.505n 1.7v 1479.495n 1.7v 1479.505n 1.7v 1489.495n 1.7v 1489.505n 1.7v 1499.495n 1.7v 1499.505n 0.0v 1509.495n 0.0v 1509.505n 0.0v 1519.495n 0.0v 1519.505n 1.7v 1529.495n 1.7v 1529.505n 0.0v 1539.495n 0.0v 1539.505n 1.7v 1549.495n 1.7v 1549.505n 1.7v 1559.495n 1.7v 1559.505n 1.7v 1569.495n 1.7v 1569.505n 1.7v 1579.495n 1.7v 1579.505n 1.7v 1589.495n 1.7v 1589.505n 1.7v 1599.495n 1.7v 1599.505n 0.0v 1609.495n 0.0v 1609.505n 0.0v 1619.495n 0.0v 1619.505n 1.7v 1629.495n 1.7v 1629.505n 1.7v 1639.495n 1.7v 1639.505n 1.7v 1649.495n 1.7v 1649.505n 0.0v 1659.495n 0.0v 1659.505n 1.7v 1669.495n 1.7v 1669.505n 1.7v 1679.495n 1.7v 1679.505n 1.7v 1689.495n 1.7v 1689.505n 1.7v 1699.495n 1.7v 1699.505n 1.7v 1709.495n 1.7v 1709.505n 1.7v 1719.495n 1.7v 1719.505n 1.7v 1729.495n 1.7v 1729.505n 1.7v 1739.495n 1.7v 1739.505n 1.7v 1749.495n 1.7v 1749.505n 1.7v 1759.495n 1.7v 1759.505n 1.7v 1769.495n 1.7v 1769.505n 0.0v 1779.495n 0.0v 1779.505n 1.7v 1789.495n 1.7v 1789.505n 1.7v 1799.495n 1.7v 1799.505n 1.7v 1809.495n 1.7v 1809.505n 0.0v 1819.495n 0.0v 1819.505n 1.7v 1829.495n 1.7v 1829.505n 0.0v 1839.495n 0.0v 1839.505n 1.7v 1849.495n 1.7v 1849.505n 1.7v 1859.495n 1.7v 1859.505n 0.0v 1869.495n 0.0v 1869.505n 1.7v 1879.495n 1.7v 1879.505n 1.7v 1889.495n 1.7v 1889.505n 1.7v 1899.495n 1.7v 1899.505n 0.0v 1909.495n 0.0v 1909.505n 1.7v 1919.495n 1.7v 1919.505n 0.0v 1929.495n 0.0v 1929.505n 1.7v 1939.495n 1.7v 1939.505n 0.0v 1949.495n 0.0v 1949.505n 1.7v 1959.495n 1.7v 1959.505n 0.0v 1969.495n 0.0v 1969.505n 1.7v 1979.495n 1.7v 1979.505n 0.0v 1989.495n 0.0v 1989.505n 1.7v 1999.495n 1.7v 1999.505n 1.7v 2009.495n 1.7v 2009.505n 0.0v 2019.495n 0.0v 2019.505n 1.7v 2029.495n 1.7v 2029.505n 1.7v 2039.495n 1.7v 2039.505n 1.7v 2049.495n 1.7v 2049.505n 1.7v )

* Generation of spare enable signals
* (time, data): [(0, 0), (10, 0), (20, 0), (30, 0), (40, 0), (50, 0), (60, 0), (70, 0), (80, 0), (90, 0), (100, 0), (110, 0), (120, 0), (130, 0), (140, 0), (150, 0), (160, 0), (170, 0), (180, 0), (190, 0), (200, 0), (210, 0), (220, 0), (230, 0), (240, 0), (250, 0), (260, 0), (270, 0), (280, 0), (290, 0), (300, 0), (310, 0), (320, 0), (330, 0), (340, 0), (350, 0), (360, 0), (370, 0), (380, 0), (390, 0), (400, 0), (410, 0), (420, 0), (430, 0), (440, 0), (450, 0), (460, 0), (470, 0), (480, 0), (490, 0), (500, 0), (510, 0), (520, 0), (530, 0), (540, 0), (550, 0), (560, 0), (570, 0), (580, 0), (590, 0), (600, 0), (610, 0), (620, 0), (630, 0), (640, 0), (650, 0), (660, 0), (670, 0), (680, 0), (690, 0), (700, 0), (710, 0), (720, 0), (730, 0), (740, 0), (750, 0), (760, 0), (770, 0), (780, 0), (790, 0), (800, 0), (810, 0), (820, 0), (830, 0), (840, 0), (850, 0), (860, 0), (870, 0), (880, 0), (890, 0), (900, 0), (910, 0), (920, 0), (930, 0), (940, 0), (950, 0), (960, 0), (970, 0), (980, 0), (990, 0), (1000, 0), (1010, 0), (1020, 0), (1030, 0), (1040, 0), (1050, 0), (1060, 0), (1070, 0), (1080, 0), (1090, 0), (1100, 0), (1110, 0), (1120, 0), (1130, 0), (1140, 0), (1150, 0), (1160, 0), (1170, 0), (1180, 0), (1190, 0), (1200, 0), (1210, 0), (1220, 0), (1230, 0), (1240, 0), (1250, 0), (1260, 0), (1270, 0), (1280, 0), (1290, 0), (1300, 0), (1310, 0), (1320, 0), (1330, 0), (1340, 0), (1350, 0), (1360, 0), (1370, 0), (1380, 0), (1390, 0), (1400, 0), (1410, 0), (1420, 0), (1430, 0), (1440, 0), (1450, 0), (1460, 0), (1470, 0), (1480, 0), (1490, 0), (1500, 0), (1510, 0), (1520, 0), (1530, 0), (1540, 0), (1550, 0), (1560, 0), (1570, 0), (1580, 0), (1590, 0), (1600, 0), (1610, 0), (1620, 0), (1630, 0), (1640, 0), (1650, 0), (1660, 0), (1670, 0), (1680, 0), (1690, 0), (1700, 0), (1710, 0), (1720, 0), (1730, 0), (1740, 0), (1750, 0), (1760, 0), (1770, 0), (1780, 0), (1790, 0), (1800, 0), (1810, 0), (1820, 0), (1830, 0), (1840, 0), (1850, 0), (1860, 0), (1870, 0), (1880, 0), (1890, 0), (1900, 0), (1910, 0), (1920, 0), (1930, 0), (1940, 0), (1950, 0), (1960, 0), (1970, 0), (1980, 0), (1990, 0), (2000, 0), (2010, 0), (2020, 0), (2030, 0), (2040, 0), (2050, 0)]
VSPARE_WEN0_0  SPARE_WEN0_0  0 PWL (0n 0.0v 9.495n 0.0v 9.505n 0.0v 19.495n 0.0v 19.505n 0.0v 29.495n 0.0v 29.505n 0.0v 39.495n 0.0v 39.505n 0.0v 49.495n 0.0v 49.505n 0.0v 59.495n 0.0v 59.505n 0.0v 69.495n 0.0v 69.505n 0.0v 79.495n 0.0v 79.505n 0.0v 89.495n 0.0v 89.505n 0.0v 99.495n 0.0v 99.505n 0.0v 109.495n 0.0v 109.505n 0.0v 119.495n 0.0v 119.505n 0.0v 129.495n 0.0v 129.505n 0.0v 139.495n 0.0v 139.505n 0.0v 149.495n 0.0v 149.505n 0.0v 159.495n 0.0v 159.505n 0.0v 169.495n 0.0v 169.505n 0.0v 179.495n 0.0v 179.505n 0.0v 189.495n 0.0v 189.505n 0.0v 199.495n 0.0v 199.505n 0.0v 209.495n 0.0v 209.505n 0.0v 219.495n 0.0v 219.505n 0.0v 229.495n 0.0v 229.505n 0.0v 239.495n 0.0v 239.505n 0.0v 249.495n 0.0v 249.505n 0.0v 259.495n 0.0v 259.505n 0.0v 269.495n 0.0v 269.505n 0.0v 279.495n 0.0v 279.505n 0.0v 289.495n 0.0v 289.505n 0.0v 299.495n 0.0v 299.505n 0.0v 309.495n 0.0v 309.505n 0.0v 319.495n 0.0v 319.505n 0.0v 329.495n 0.0v 329.505n 0.0v 339.495n 0.0v 339.505n 0.0v 349.495n 0.0v 349.505n 0.0v 359.495n 0.0v 359.505n 0.0v 369.495n 0.0v 369.505n 0.0v 379.495n 0.0v 379.505n 0.0v 389.495n 0.0v 389.505n 0.0v 399.495n 0.0v 399.505n 0.0v 409.495n 0.0v 409.505n 0.0v 419.495n 0.0v 419.505n 0.0v 429.495n 0.0v 429.505n 0.0v 439.495n 0.0v 439.505n 0.0v 449.495n 0.0v 449.505n 0.0v 459.495n 0.0v 459.505n 0.0v 469.495n 0.0v 469.505n 0.0v 479.495n 0.0v 479.505n 0.0v 489.495n 0.0v 489.505n 0.0v 499.495n 0.0v 499.505n 0.0v 509.495n 0.0v 509.505n 0.0v 519.495n 0.0v 519.505n 0.0v 529.495n 0.0v 529.505n 0.0v 539.495n 0.0v 539.505n 0.0v 549.495n 0.0v 549.505n 0.0v 559.495n 0.0v 559.505n 0.0v 569.495n 0.0v 569.505n 0.0v 579.495n 0.0v 579.505n 0.0v 589.495n 0.0v 589.505n 0.0v 599.495n 0.0v 599.505n 0.0v 609.495n 0.0v 609.505n 0.0v 619.495n 0.0v 619.505n 0.0v 629.495n 0.0v 629.505n 0.0v 639.495n 0.0v 639.505n 0.0v 649.495n 0.0v 649.505n 0.0v 659.495n 0.0v 659.505n 0.0v 669.495n 0.0v 669.505n 0.0v 679.495n 0.0v 679.505n 0.0v 689.495n 0.0v 689.505n 0.0v 699.495n 0.0v 699.505n 0.0v 709.495n 0.0v 709.505n 0.0v 719.495n 0.0v 719.505n 0.0v 729.495n 0.0v 729.505n 0.0v 739.495n 0.0v 739.505n 0.0v 749.495n 0.0v 749.505n 0.0v 759.495n 0.0v 759.505n 0.0v 769.495n 0.0v 769.505n 0.0v 779.495n 0.0v 779.505n 0.0v 789.495n 0.0v 789.505n 0.0v 799.495n 0.0v 799.505n 0.0v 809.495n 0.0v 809.505n 0.0v 819.495n 0.0v 819.505n 0.0v 829.495n 0.0v 829.505n 0.0v 839.495n 0.0v 839.505n 0.0v 849.495n 0.0v 849.505n 0.0v 859.495n 0.0v 859.505n 0.0v 869.495n 0.0v 869.505n 0.0v 879.495n 0.0v 879.505n 0.0v 889.495n 0.0v 889.505n 0.0v 899.495n 0.0v 899.505n 0.0v 909.495n 0.0v 909.505n 0.0v 919.495n 0.0v 919.505n 0.0v 929.495n 0.0v 929.505n 0.0v 939.495n 0.0v 939.505n 0.0v 949.495n 0.0v 949.505n 0.0v 959.495n 0.0v 959.505n 0.0v 969.495n 0.0v 969.505n 0.0v 979.495n 0.0v 979.505n 0.0v 989.495n 0.0v 989.505n 0.0v 999.495n 0.0v 999.505n 0.0v 1009.495n 0.0v 1009.505n 0.0v 1019.495n 0.0v 1019.505n 0.0v 1029.495n 0.0v 1029.505n 0.0v 1039.495n 0.0v 1039.505n 0.0v 1049.495n 0.0v 1049.505n 0.0v 1059.495n 0.0v 1059.505n 0.0v 1069.495n 0.0v 1069.505n 0.0v 1079.495n 0.0v 1079.505n 0.0v 1089.495n 0.0v 1089.505n 0.0v 1099.495n 0.0v 1099.505n 0.0v 1109.495n 0.0v 1109.505n 0.0v 1119.495n 0.0v 1119.505n 0.0v 1129.495n 0.0v 1129.505n 0.0v 1139.495n 0.0v 1139.505n 0.0v 1149.495n 0.0v 1149.505n 0.0v 1159.495n 0.0v 1159.505n 0.0v 1169.495n 0.0v 1169.505n 0.0v 1179.495n 0.0v 1179.505n 0.0v 1189.495n 0.0v 1189.505n 0.0v 1199.495n 0.0v 1199.505n 0.0v 1209.495n 0.0v 1209.505n 0.0v 1219.495n 0.0v 1219.505n 0.0v 1229.495n 0.0v 1229.505n 0.0v 1239.495n 0.0v 1239.505n 0.0v 1249.495n 0.0v 1249.505n 0.0v 1259.495n 0.0v 1259.505n 0.0v 1269.495n 0.0v 1269.505n 0.0v 1279.495n 0.0v 1279.505n 0.0v 1289.495n 0.0v 1289.505n 0.0v 1299.495n 0.0v 1299.505n 0.0v 1309.495n 0.0v 1309.505n 0.0v 1319.495n 0.0v 1319.505n 0.0v 1329.495n 0.0v 1329.505n 0.0v 1339.495n 0.0v 1339.505n 0.0v 1349.495n 0.0v 1349.505n 0.0v 1359.495n 0.0v 1359.505n 0.0v 1369.495n 0.0v 1369.505n 0.0v 1379.495n 0.0v 1379.505n 0.0v 1389.495n 0.0v 1389.505n 0.0v 1399.495n 0.0v 1399.505n 0.0v 1409.495n 0.0v 1409.505n 0.0v 1419.495n 0.0v 1419.505n 0.0v 1429.495n 0.0v 1429.505n 0.0v 1439.495n 0.0v 1439.505n 0.0v 1449.495n 0.0v 1449.505n 0.0v 1459.495n 0.0v 1459.505n 0.0v 1469.495n 0.0v 1469.505n 0.0v 1479.495n 0.0v 1479.505n 0.0v 1489.495n 0.0v 1489.505n 0.0v 1499.495n 0.0v 1499.505n 0.0v 1509.495n 0.0v 1509.505n 0.0v 1519.495n 0.0v 1519.505n 0.0v 1529.495n 0.0v 1529.505n 0.0v 1539.495n 0.0v 1539.505n 0.0v 1549.495n 0.0v 1549.505n 0.0v 1559.495n 0.0v 1559.505n 0.0v 1569.495n 0.0v 1569.505n 0.0v 1579.495n 0.0v 1579.505n 0.0v 1589.495n 0.0v 1589.505n 0.0v 1599.495n 0.0v 1599.505n 0.0v 1609.495n 0.0v 1609.505n 0.0v 1619.495n 0.0v 1619.505n 0.0v 1629.495n 0.0v 1629.505n 0.0v 1639.495n 0.0v 1639.505n 0.0v 1649.495n 0.0v 1649.505n 0.0v 1659.495n 0.0v 1659.505n 0.0v 1669.495n 0.0v 1669.505n 0.0v 1679.495n 0.0v 1679.505n 0.0v 1689.495n 0.0v 1689.505n 0.0v 1699.495n 0.0v 1699.505n 0.0v 1709.495n 0.0v 1709.505n 0.0v 1719.495n 0.0v 1719.505n 0.0v 1729.495n 0.0v 1729.505n 0.0v 1739.495n 0.0v 1739.505n 0.0v 1749.495n 0.0v 1749.505n 0.0v 1759.495n 0.0v 1759.505n 0.0v 1769.495n 0.0v 1769.505n 0.0v 1779.495n 0.0v 1779.505n 0.0v 1789.495n 0.0v 1789.505n 0.0v 1799.495n 0.0v 1799.505n 0.0v 1809.495n 0.0v 1809.505n 0.0v 1819.495n 0.0v 1819.505n 0.0v 1829.495n 0.0v 1829.505n 0.0v 1839.495n 0.0v 1839.505n 0.0v 1849.495n 0.0v 1849.505n 0.0v 1859.495n 0.0v 1859.505n 0.0v 1869.495n 0.0v 1869.505n 0.0v 1879.495n 0.0v 1879.505n 0.0v 1889.495n 0.0v 1889.505n 0.0v 1899.495n 0.0v 1899.505n 0.0v 1909.495n 0.0v 1909.505n 0.0v 1919.495n 0.0v 1919.505n 0.0v 1929.495n 0.0v 1929.505n 0.0v 1939.495n 0.0v 1939.505n 0.0v 1949.495n 0.0v 1949.505n 0.0v 1959.495n 0.0v 1959.505n 0.0v 1969.495n 0.0v 1969.505n 0.0v 1979.495n 0.0v 1979.505n 0.0v 1989.495n 0.0v 1989.505n 0.0v 1999.495n 0.0v 1999.505n 0.0v 2009.495n 0.0v 2009.505n 0.0v 2019.495n 0.0v 2019.505n 0.0v 2029.495n 0.0v 2029.505n 0.0v 2039.495n 0.0v 2039.505n 0.0v 2049.495n 0.0v 2049.505n 0.0v )
* PULSE: period=10
Vclk0 clk0 0 PULSE (0 1.7 9.995n 0.01n 0.01n 4.99n 10n)
* PULSE: period=10
Vclk1 clk1 0 PULSE (0 1.7 9.995n 0.01n 0.01n 4.99n 10n)

 * Generation of dout measurements
* CHECK dout1_0 vdout1_0ck4 = 0 time = 50
* CHECK dout1_1 vdout1_1ck4 = 0 time = 50
* CHECK dout1_2 vdout1_2ck4 = 0 time = 50
* CHECK dout1_3 vdout1_3ck4 = 1.7 time = 50
* CHECK dout1_4 vdout1_4ck4 = 1.7 time = 50
* CHECK dout1_5 vdout1_5ck4 = 1.7 time = 50
* CHECK dout1_6 vdout1_6ck4 = 1.7 time = 50
* CHECK dout1_7 vdout1_7ck4 = 0 time = 50
* CHECK dout1_8 vdout1_8ck4 = 1.7 time = 50
* CHECK dout1_9 vdout1_9ck4 = 0 time = 50
* CHECK dout1_10 vdout1_10ck4 = 0 time = 50
* CHECK dout1_11 vdout1_11ck4 = 1.7 time = 50
* CHECK dout1_12 vdout1_12ck4 = 1.7 time = 50
* CHECK dout1_13 vdout1_13ck4 = 0 time = 50
* CHECK dout1_14 vdout1_14ck4 = 0 time = 50
* CHECK dout1_15 vdout1_15ck4 = 1.7 time = 50
* CHECK dout1_16 vdout1_16ck4 = 0 time = 50
* CHECK dout1_0 vdout1_0ck7 = 0 time = 80
* CHECK dout1_1 vdout1_1ck7 = 0 time = 80
* CHECK dout1_2 vdout1_2ck7 = 1.7 time = 80
* CHECK dout1_3 vdout1_3ck7 = 0 time = 80
* CHECK dout1_4 vdout1_4ck7 = 1.7 time = 80
* CHECK dout1_5 vdout1_5ck7 = 0 time = 80
* CHECK dout1_6 vdout1_6ck7 = 0 time = 80
* CHECK dout1_7 vdout1_7ck7 = 0 time = 80
* CHECK dout1_8 vdout1_8ck7 = 1.7 time = 80
* CHECK dout1_9 vdout1_9ck7 = 0 time = 80
* CHECK dout1_10 vdout1_10ck7 = 1.7 time = 80
* CHECK dout1_11 vdout1_11ck7 = 1.7 time = 80
* CHECK dout1_12 vdout1_12ck7 = 1.7 time = 80
* CHECK dout1_13 vdout1_13ck7 = 1.7 time = 80
* CHECK dout1_14 vdout1_14ck7 = 1.7 time = 80
* CHECK dout1_15 vdout1_15ck7 = 1.7 time = 80
* CHECK dout1_16 vdout1_16ck7 = 0 time = 80
* CHECK dout1_0 vdout1_0ck10 = 0 time = 110
* CHECK dout1_1 vdout1_1ck10 = 0 time = 110
* CHECK dout1_2 vdout1_2ck10 = 1.7 time = 110
* CHECK dout1_3 vdout1_3ck10 = 0 time = 110
* CHECK dout1_4 vdout1_4ck10 = 0 time = 110
* CHECK dout1_5 vdout1_5ck10 = 1.7 time = 110
* CHECK dout1_6 vdout1_6ck10 = 1.7 time = 110
* CHECK dout1_7 vdout1_7ck10 = 0 time = 110
* CHECK dout1_8 vdout1_8ck10 = 0 time = 110
* CHECK dout1_9 vdout1_9ck10 = 0 time = 110
* CHECK dout1_10 vdout1_10ck10 = 0 time = 110
* CHECK dout1_11 vdout1_11ck10 = 1.7 time = 110
* CHECK dout1_12 vdout1_12ck10 = 1.7 time = 110
* CHECK dout1_13 vdout1_13ck10 = 1.7 time = 110
* CHECK dout1_14 vdout1_14ck10 = 1.7 time = 110
* CHECK dout1_15 vdout1_15ck10 = 0 time = 110
* CHECK dout1_16 vdout1_16ck10 = 0 time = 110
* CHECK dout1_0 vdout1_0ck15 = 0 time = 160
* CHECK dout1_1 vdout1_1ck15 = 0 time = 160
* CHECK dout1_2 vdout1_2ck15 = 0 time = 160
* CHECK dout1_3 vdout1_3ck15 = 1.7 time = 160
* CHECK dout1_4 vdout1_4ck15 = 1.7 time = 160
* CHECK dout1_5 vdout1_5ck15 = 1.7 time = 160
* CHECK dout1_6 vdout1_6ck15 = 1.7 time = 160
* CHECK dout1_7 vdout1_7ck15 = 0 time = 160
* CHECK dout1_8 vdout1_8ck15 = 1.7 time = 160
* CHECK dout1_9 vdout1_9ck15 = 0 time = 160
* CHECK dout1_10 vdout1_10ck15 = 0 time = 160
* CHECK dout1_11 vdout1_11ck15 = 1.7 time = 160
* CHECK dout1_12 vdout1_12ck15 = 1.7 time = 160
* CHECK dout1_13 vdout1_13ck15 = 0 time = 160
* CHECK dout1_14 vdout1_14ck15 = 0 time = 160
* CHECK dout1_15 vdout1_15ck15 = 1.7 time = 160
* CHECK dout1_16 vdout1_16ck15 = 0 time = 160
* CHECK dout1_0 vdout1_0ck17 = 0 time = 180
* CHECK dout1_1 vdout1_1ck17 = 0 time = 180
* CHECK dout1_2 vdout1_2ck17 = 1.7 time = 180
* CHECK dout1_3 vdout1_3ck17 = 0 time = 180
* CHECK dout1_4 vdout1_4ck17 = 0 time = 180
* CHECK dout1_5 vdout1_5ck17 = 1.7 time = 180
* CHECK dout1_6 vdout1_6ck17 = 1.7 time = 180
* CHECK dout1_7 vdout1_7ck17 = 0 time = 180
* CHECK dout1_8 vdout1_8ck17 = 0 time = 180
* CHECK dout1_9 vdout1_9ck17 = 0 time = 180
* CHECK dout1_10 vdout1_10ck17 = 0 time = 180
* CHECK dout1_11 vdout1_11ck17 = 1.7 time = 180
* CHECK dout1_12 vdout1_12ck17 = 1.7 time = 180
* CHECK dout1_13 vdout1_13ck17 = 1.7 time = 180
* CHECK dout1_14 vdout1_14ck17 = 1.7 time = 180
* CHECK dout1_15 vdout1_15ck17 = 0 time = 180
* CHECK dout1_16 vdout1_16ck17 = 0 time = 180
* CHECK dout1_0 vdout1_0ck18 = 1.7 time = 190
* CHECK dout1_1 vdout1_1ck18 = 1.7 time = 190
* CHECK dout1_2 vdout1_2ck18 = 0 time = 190
* CHECK dout1_3 vdout1_3ck18 = 0 time = 190
* CHECK dout1_4 vdout1_4ck18 = 1.7 time = 190
* CHECK dout1_5 vdout1_5ck18 = 0 time = 190
* CHECK dout1_6 vdout1_6ck18 = 1.7 time = 190
* CHECK dout1_7 vdout1_7ck18 = 1.7 time = 190
* CHECK dout1_8 vdout1_8ck18 = 1.7 time = 190
* CHECK dout1_9 vdout1_9ck18 = 0 time = 190
* CHECK dout1_10 vdout1_10ck18 = 1.7 time = 190
* CHECK dout1_11 vdout1_11ck18 = 0 time = 190
* CHECK dout1_12 vdout1_12ck18 = 0 time = 190
* CHECK dout1_13 vdout1_13ck18 = 0 time = 190
* CHECK dout1_14 vdout1_14ck18 = 0 time = 190
* CHECK dout1_15 vdout1_15ck18 = 1.7 time = 190
* CHECK dout1_16 vdout1_16ck18 = 0 time = 190
* CHECK dout1_0 vdout1_0ck25 = 0 time = 260
* CHECK dout1_1 vdout1_1ck25 = 0 time = 260
* CHECK dout1_2 vdout1_2ck25 = 1.7 time = 260
* CHECK dout1_3 vdout1_3ck25 = 0 time = 260
* CHECK dout1_4 vdout1_4ck25 = 0 time = 260
* CHECK dout1_5 vdout1_5ck25 = 1.7 time = 260
* CHECK dout1_6 vdout1_6ck25 = 1.7 time = 260
* CHECK dout1_7 vdout1_7ck25 = 0 time = 260
* CHECK dout1_8 vdout1_8ck25 = 0 time = 260
* CHECK dout1_9 vdout1_9ck25 = 0 time = 260
* CHECK dout1_10 vdout1_10ck25 = 0 time = 260
* CHECK dout1_11 vdout1_11ck25 = 1.7 time = 260
* CHECK dout1_12 vdout1_12ck25 = 1.7 time = 260
* CHECK dout1_13 vdout1_13ck25 = 1.7 time = 260
* CHECK dout1_14 vdout1_14ck25 = 1.7 time = 260
* CHECK dout1_15 vdout1_15ck25 = 0 time = 260
* CHECK dout1_16 vdout1_16ck25 = 0 time = 260
* CHECK dout1_0 vdout1_0ck27 = 0 time = 280
* CHECK dout1_1 vdout1_1ck27 = 0 time = 280
* CHECK dout1_2 vdout1_2ck27 = 1.7 time = 280
* CHECK dout1_3 vdout1_3ck27 = 0 time = 280
* CHECK dout1_4 vdout1_4ck27 = 0 time = 280
* CHECK dout1_5 vdout1_5ck27 = 1.7 time = 280
* CHECK dout1_6 vdout1_6ck27 = 1.7 time = 280
* CHECK dout1_7 vdout1_7ck27 = 0 time = 280
* CHECK dout1_8 vdout1_8ck27 = 0 time = 280
* CHECK dout1_9 vdout1_9ck27 = 0 time = 280
* CHECK dout1_10 vdout1_10ck27 = 0 time = 280
* CHECK dout1_11 vdout1_11ck27 = 1.7 time = 280
* CHECK dout1_12 vdout1_12ck27 = 1.7 time = 280
* CHECK dout1_13 vdout1_13ck27 = 1.7 time = 280
* CHECK dout1_14 vdout1_14ck27 = 1.7 time = 280
* CHECK dout1_15 vdout1_15ck27 = 0 time = 280
* CHECK dout1_16 vdout1_16ck27 = 0 time = 280
* CHECK dout1_0 vdout1_0ck28 = 1.7 time = 290
* CHECK dout1_1 vdout1_1ck28 = 1.7 time = 290
* CHECK dout1_2 vdout1_2ck28 = 1.7 time = 290
* CHECK dout1_3 vdout1_3ck28 = 1.7 time = 290
* CHECK dout1_4 vdout1_4ck28 = 0 time = 290
* CHECK dout1_5 vdout1_5ck28 = 0 time = 290
* CHECK dout1_6 vdout1_6ck28 = 1.7 time = 290
* CHECK dout1_7 vdout1_7ck28 = 0 time = 290
* CHECK dout1_8 vdout1_8ck28 = 1.7 time = 290
* CHECK dout1_9 vdout1_9ck28 = 0 time = 290
* CHECK dout1_10 vdout1_10ck28 = 0 time = 290
* CHECK dout1_11 vdout1_11ck28 = 1.7 time = 290
* CHECK dout1_12 vdout1_12ck28 = 1.7 time = 290
* CHECK dout1_13 vdout1_13ck28 = 1.7 time = 290
* CHECK dout1_14 vdout1_14ck28 = 0 time = 290
* CHECK dout1_15 vdout1_15ck28 = 1.7 time = 290
* CHECK dout1_16 vdout1_16ck28 = 0 time = 290
* CHECK dout1_0 vdout1_0ck29 = 1.7 time = 300
* CHECK dout1_1 vdout1_1ck29 = 1.7 time = 300
* CHECK dout1_2 vdout1_2ck29 = 1.7 time = 300
* CHECK dout1_3 vdout1_3ck29 = 1.7 time = 300
* CHECK dout1_4 vdout1_4ck29 = 0 time = 300
* CHECK dout1_5 vdout1_5ck29 = 0 time = 300
* CHECK dout1_6 vdout1_6ck29 = 1.7 time = 300
* CHECK dout1_7 vdout1_7ck29 = 0 time = 300
* CHECK dout1_8 vdout1_8ck29 = 1.7 time = 300
* CHECK dout1_9 vdout1_9ck29 = 0 time = 300
* CHECK dout1_10 vdout1_10ck29 = 0 time = 300
* CHECK dout1_11 vdout1_11ck29 = 1.7 time = 300
* CHECK dout1_12 vdout1_12ck29 = 1.7 time = 300
* CHECK dout1_13 vdout1_13ck29 = 1.7 time = 300
* CHECK dout1_14 vdout1_14ck29 = 0 time = 300
* CHECK dout1_15 vdout1_15ck29 = 1.7 time = 300
* CHECK dout1_16 vdout1_16ck29 = 0 time = 300
* CHECK dout1_0 vdout1_0ck30 = 1.7 time = 310
* CHECK dout1_1 vdout1_1ck30 = 1.7 time = 310
* CHECK dout1_2 vdout1_2ck30 = 1.7 time = 310
* CHECK dout1_3 vdout1_3ck30 = 0 time = 310
* CHECK dout1_4 vdout1_4ck30 = 0 time = 310
* CHECK dout1_5 vdout1_5ck30 = 0 time = 310
* CHECK dout1_6 vdout1_6ck30 = 0 time = 310
* CHECK dout1_7 vdout1_7ck30 = 1.7 time = 310
* CHECK dout1_8 vdout1_8ck30 = 1.7 time = 310
* CHECK dout1_9 vdout1_9ck30 = 0 time = 310
* CHECK dout1_10 vdout1_10ck30 = 0 time = 310
* CHECK dout1_11 vdout1_11ck30 = 0 time = 310
* CHECK dout1_12 vdout1_12ck30 = 0 time = 310
* CHECK dout1_13 vdout1_13ck30 = 0 time = 310
* CHECK dout1_14 vdout1_14ck30 = 0 time = 310
* CHECK dout1_15 vdout1_15ck30 = 1.7 time = 310
* CHECK dout1_16 vdout1_16ck30 = 0 time = 310
* CHECK dout1_0 vdout1_0ck34 = 1.7 time = 350
* CHECK dout1_1 vdout1_1ck34 = 1.7 time = 350
* CHECK dout1_2 vdout1_2ck34 = 0 time = 350
* CHECK dout1_3 vdout1_3ck34 = 0 time = 350
* CHECK dout1_4 vdout1_4ck34 = 1.7 time = 350
* CHECK dout1_5 vdout1_5ck34 = 0 time = 350
* CHECK dout1_6 vdout1_6ck34 = 1.7 time = 350
* CHECK dout1_7 vdout1_7ck34 = 1.7 time = 350
* CHECK dout1_8 vdout1_8ck34 = 1.7 time = 350
* CHECK dout1_9 vdout1_9ck34 = 1.7 time = 350
* CHECK dout1_10 vdout1_10ck34 = 1.7 time = 350
* CHECK dout1_11 vdout1_11ck34 = 0 time = 350
* CHECK dout1_12 vdout1_12ck34 = 1.7 time = 350
* CHECK dout1_13 vdout1_13ck34 = 0 time = 350
* CHECK dout1_14 vdout1_14ck34 = 0 time = 350
* CHECK dout1_15 vdout1_15ck34 = 0 time = 350
* CHECK dout1_16 vdout1_16ck34 = 0 time = 350
* CHECK dout1_0 vdout1_0ck35 = 0 time = 360
* CHECK dout1_1 vdout1_1ck35 = 0 time = 360
* CHECK dout1_2 vdout1_2ck35 = 1.7 time = 360
* CHECK dout1_3 vdout1_3ck35 = 0 time = 360
* CHECK dout1_4 vdout1_4ck35 = 0 time = 360
* CHECK dout1_5 vdout1_5ck35 = 1.7 time = 360
* CHECK dout1_6 vdout1_6ck35 = 1.7 time = 360
* CHECK dout1_7 vdout1_7ck35 = 0 time = 360
* CHECK dout1_8 vdout1_8ck35 = 0 time = 360
* CHECK dout1_9 vdout1_9ck35 = 0 time = 360
* CHECK dout1_10 vdout1_10ck35 = 0 time = 360
* CHECK dout1_11 vdout1_11ck35 = 1.7 time = 360
* CHECK dout1_12 vdout1_12ck35 = 1.7 time = 360
* CHECK dout1_13 vdout1_13ck35 = 1.7 time = 360
* CHECK dout1_14 vdout1_14ck35 = 1.7 time = 360
* CHECK dout1_15 vdout1_15ck35 = 0 time = 360
* CHECK dout1_16 vdout1_16ck35 = 0 time = 360
* CHECK dout1_0 vdout1_0ck36 = 1.7 time = 370
* CHECK dout1_1 vdout1_1ck36 = 1.7 time = 370
* CHECK dout1_2 vdout1_2ck36 = 1.7 time = 370
* CHECK dout1_3 vdout1_3ck36 = 1.7 time = 370
* CHECK dout1_4 vdout1_4ck36 = 0 time = 370
* CHECK dout1_5 vdout1_5ck36 = 0 time = 370
* CHECK dout1_6 vdout1_6ck36 = 1.7 time = 370
* CHECK dout1_7 vdout1_7ck36 = 0 time = 370
* CHECK dout1_8 vdout1_8ck36 = 1.7 time = 370
* CHECK dout1_9 vdout1_9ck36 = 0 time = 370
* CHECK dout1_10 vdout1_10ck36 = 0 time = 370
* CHECK dout1_11 vdout1_11ck36 = 1.7 time = 370
* CHECK dout1_12 vdout1_12ck36 = 1.7 time = 370
* CHECK dout1_13 vdout1_13ck36 = 1.7 time = 370
* CHECK dout1_14 vdout1_14ck36 = 0 time = 370
* CHECK dout1_15 vdout1_15ck36 = 1.7 time = 370
* CHECK dout1_16 vdout1_16ck36 = 0 time = 370
* CHECK dout1_0 vdout1_0ck37 = 1.7 time = 380
* CHECK dout1_1 vdout1_1ck37 = 1.7 time = 380
* CHECK dout1_2 vdout1_2ck37 = 1.7 time = 380
* CHECK dout1_3 vdout1_3ck37 = 0 time = 380
* CHECK dout1_4 vdout1_4ck37 = 0 time = 380
* CHECK dout1_5 vdout1_5ck37 = 0 time = 380
* CHECK dout1_6 vdout1_6ck37 = 0 time = 380
* CHECK dout1_7 vdout1_7ck37 = 1.7 time = 380
* CHECK dout1_8 vdout1_8ck37 = 1.7 time = 380
* CHECK dout1_9 vdout1_9ck37 = 0 time = 380
* CHECK dout1_10 vdout1_10ck37 = 0 time = 380
* CHECK dout1_11 vdout1_11ck37 = 0 time = 380
* CHECK dout1_12 vdout1_12ck37 = 0 time = 380
* CHECK dout1_13 vdout1_13ck37 = 0 time = 380
* CHECK dout1_14 vdout1_14ck37 = 0 time = 380
* CHECK dout1_15 vdout1_15ck37 = 1.7 time = 380
* CHECK dout1_16 vdout1_16ck37 = 0 time = 380
* CHECK dout1_0 vdout1_0ck38 = 0 time = 390
* CHECK dout1_1 vdout1_1ck38 = 0 time = 390
* CHECK dout1_2 vdout1_2ck38 = 1.7 time = 390
* CHECK dout1_3 vdout1_3ck38 = 0 time = 390
* CHECK dout1_4 vdout1_4ck38 = 0 time = 390
* CHECK dout1_5 vdout1_5ck38 = 1.7 time = 390
* CHECK dout1_6 vdout1_6ck38 = 1.7 time = 390
* CHECK dout1_7 vdout1_7ck38 = 0 time = 390
* CHECK dout1_8 vdout1_8ck38 = 0 time = 390
* CHECK dout1_9 vdout1_9ck38 = 0 time = 390
* CHECK dout1_10 vdout1_10ck38 = 0 time = 390
* CHECK dout1_11 vdout1_11ck38 = 1.7 time = 390
* CHECK dout1_12 vdout1_12ck38 = 1.7 time = 390
* CHECK dout1_13 vdout1_13ck38 = 1.7 time = 390
* CHECK dout1_14 vdout1_14ck38 = 1.7 time = 390
* CHECK dout1_15 vdout1_15ck38 = 0 time = 390
* CHECK dout1_16 vdout1_16ck38 = 0 time = 390
* CHECK dout1_0 vdout1_0ck41 = 0 time = 420
* CHECK dout1_1 vdout1_1ck41 = 0 time = 420
* CHECK dout1_2 vdout1_2ck41 = 1.7 time = 420
* CHECK dout1_3 vdout1_3ck41 = 0 time = 420
* CHECK dout1_4 vdout1_4ck41 = 0 time = 420
* CHECK dout1_5 vdout1_5ck41 = 1.7 time = 420
* CHECK dout1_6 vdout1_6ck41 = 1.7 time = 420
* CHECK dout1_7 vdout1_7ck41 = 0 time = 420
* CHECK dout1_8 vdout1_8ck41 = 0 time = 420
* CHECK dout1_9 vdout1_9ck41 = 0 time = 420
* CHECK dout1_10 vdout1_10ck41 = 0 time = 420
* CHECK dout1_11 vdout1_11ck41 = 1.7 time = 420
* CHECK dout1_12 vdout1_12ck41 = 1.7 time = 420
* CHECK dout1_13 vdout1_13ck41 = 1.7 time = 420
* CHECK dout1_14 vdout1_14ck41 = 1.7 time = 420
* CHECK dout1_15 vdout1_15ck41 = 0 time = 420
* CHECK dout1_16 vdout1_16ck41 = 0 time = 420
* CHECK dout1_0 vdout1_0ck43 = 1.7 time = 440
* CHECK dout1_1 vdout1_1ck43 = 1.7 time = 440
* CHECK dout1_2 vdout1_2ck43 = 0 time = 440
* CHECK dout1_3 vdout1_3ck43 = 1.7 time = 440
* CHECK dout1_4 vdout1_4ck43 = 1.7 time = 440
* CHECK dout1_5 vdout1_5ck43 = 0 time = 440
* CHECK dout1_6 vdout1_6ck43 = 1.7 time = 440
* CHECK dout1_7 vdout1_7ck43 = 1.7 time = 440
* CHECK dout1_8 vdout1_8ck43 = 0 time = 440
* CHECK dout1_9 vdout1_9ck43 = 0 time = 440
* CHECK dout1_10 vdout1_10ck43 = 0 time = 440
* CHECK dout1_11 vdout1_11ck43 = 0 time = 440
* CHECK dout1_12 vdout1_12ck43 = 1.7 time = 440
* CHECK dout1_13 vdout1_13ck43 = 1.7 time = 440
* CHECK dout1_14 vdout1_14ck43 = 1.7 time = 440
* CHECK dout1_15 vdout1_15ck43 = 1.7 time = 440
* CHECK dout1_16 vdout1_16ck43 = 0 time = 440
* CHECK dout1_0 vdout1_0ck48 = 1.7 time = 490
* CHECK dout1_1 vdout1_1ck48 = 0 time = 490
* CHECK dout1_2 vdout1_2ck48 = 1.7 time = 490
* CHECK dout1_3 vdout1_3ck48 = 0 time = 490
* CHECK dout1_4 vdout1_4ck48 = 0 time = 490
* CHECK dout1_5 vdout1_5ck48 = 0 time = 490
* CHECK dout1_6 vdout1_6ck48 = 0 time = 490
* CHECK dout1_7 vdout1_7ck48 = 1.7 time = 490
* CHECK dout1_8 vdout1_8ck48 = 0 time = 490
* CHECK dout1_9 vdout1_9ck48 = 1.7 time = 490
* CHECK dout1_10 vdout1_10ck48 = 1.7 time = 490
* CHECK dout1_11 vdout1_11ck48 = 0 time = 490
* CHECK dout1_12 vdout1_12ck48 = 0 time = 490
* CHECK dout1_13 vdout1_13ck48 = 0 time = 490
* CHECK dout1_14 vdout1_14ck48 = 1.7 time = 490
* CHECK dout1_15 vdout1_15ck48 = 1.7 time = 490
* CHECK dout1_16 vdout1_16ck48 = 0 time = 490
* CHECK dout1_0 vdout1_0ck49 = 0 time = 500
* CHECK dout1_1 vdout1_1ck49 = 0 time = 500
* CHECK dout1_2 vdout1_2ck49 = 0 time = 500
* CHECK dout1_3 vdout1_3ck49 = 1.7 time = 500
* CHECK dout1_4 vdout1_4ck49 = 0 time = 500
* CHECK dout1_5 vdout1_5ck49 = 1.7 time = 500
* CHECK dout1_6 vdout1_6ck49 = 1.7 time = 500
* CHECK dout1_7 vdout1_7ck49 = 1.7 time = 500
* CHECK dout1_8 vdout1_8ck49 = 1.7 time = 500
* CHECK dout1_9 vdout1_9ck49 = 0 time = 500
* CHECK dout1_10 vdout1_10ck49 = 1.7 time = 500
* CHECK dout1_11 vdout1_11ck49 = 1.7 time = 500
* CHECK dout1_12 vdout1_12ck49 = 0 time = 500
* CHECK dout1_13 vdout1_13ck49 = 0 time = 500
* CHECK dout1_14 vdout1_14ck49 = 1.7 time = 500
* CHECK dout1_15 vdout1_15ck49 = 1.7 time = 500
* CHECK dout1_16 vdout1_16ck49 = 0 time = 500
* CHECK dout1_0 vdout1_0ck51 = 1.7 time = 520
* CHECK dout1_1 vdout1_1ck51 = 1.7 time = 520
* CHECK dout1_2 vdout1_2ck51 = 0 time = 520
* CHECK dout1_3 vdout1_3ck51 = 0 time = 520
* CHECK dout1_4 vdout1_4ck51 = 1.7 time = 520
* CHECK dout1_5 vdout1_5ck51 = 0 time = 520
* CHECK dout1_6 vdout1_6ck51 = 1.7 time = 520
* CHECK dout1_7 vdout1_7ck51 = 1.7 time = 520
* CHECK dout1_8 vdout1_8ck51 = 1.7 time = 520
* CHECK dout1_9 vdout1_9ck51 = 1.7 time = 520
* CHECK dout1_10 vdout1_10ck51 = 1.7 time = 520
* CHECK dout1_11 vdout1_11ck51 = 0 time = 520
* CHECK dout1_12 vdout1_12ck51 = 1.7 time = 520
* CHECK dout1_13 vdout1_13ck51 = 0 time = 520
* CHECK dout1_14 vdout1_14ck51 = 0 time = 520
* CHECK dout1_15 vdout1_15ck51 = 0 time = 520
* CHECK dout1_16 vdout1_16ck51 = 0 time = 520
* CHECK dout1_0 vdout1_0ck54 = 1.7 time = 550
* CHECK dout1_1 vdout1_1ck54 = 0 time = 550
* CHECK dout1_2 vdout1_2ck54 = 1.7 time = 550
* CHECK dout1_3 vdout1_3ck54 = 0 time = 550
* CHECK dout1_4 vdout1_4ck54 = 0 time = 550
* CHECK dout1_5 vdout1_5ck54 = 0 time = 550
* CHECK dout1_6 vdout1_6ck54 = 0 time = 550
* CHECK dout1_7 vdout1_7ck54 = 1.7 time = 550
* CHECK dout1_8 vdout1_8ck54 = 0 time = 550
* CHECK dout1_9 vdout1_9ck54 = 1.7 time = 550
* CHECK dout1_10 vdout1_10ck54 = 1.7 time = 550
* CHECK dout1_11 vdout1_11ck54 = 0 time = 550
* CHECK dout1_12 vdout1_12ck54 = 0 time = 550
* CHECK dout1_13 vdout1_13ck54 = 0 time = 550
* CHECK dout1_14 vdout1_14ck54 = 1.7 time = 550
* CHECK dout1_15 vdout1_15ck54 = 1.7 time = 550
* CHECK dout1_16 vdout1_16ck54 = 0 time = 550
* CHECK dout1_0 vdout1_0ck56 = 1.7 time = 570
* CHECK dout1_1 vdout1_1ck56 = 0 time = 570
* CHECK dout1_2 vdout1_2ck56 = 1.7 time = 570
* CHECK dout1_3 vdout1_3ck56 = 1.7 time = 570
* CHECK dout1_4 vdout1_4ck56 = 1.7 time = 570
* CHECK dout1_5 vdout1_5ck56 = 0 time = 570
* CHECK dout1_6 vdout1_6ck56 = 0 time = 570
* CHECK dout1_7 vdout1_7ck56 = 1.7 time = 570
* CHECK dout1_8 vdout1_8ck56 = 0 time = 570
* CHECK dout1_9 vdout1_9ck56 = 0 time = 570
* CHECK dout1_10 vdout1_10ck56 = 1.7 time = 570
* CHECK dout1_11 vdout1_11ck56 = 0 time = 570
* CHECK dout1_12 vdout1_12ck56 = 0 time = 570
* CHECK dout1_13 vdout1_13ck56 = 1.7 time = 570
* CHECK dout1_14 vdout1_14ck56 = 1.7 time = 570
* CHECK dout1_15 vdout1_15ck56 = 0 time = 570
* CHECK dout1_16 vdout1_16ck56 = 0 time = 570
* CHECK dout1_0 vdout1_0ck58 = 1.7 time = 590
* CHECK dout1_1 vdout1_1ck58 = 0 time = 590
* CHECK dout1_2 vdout1_2ck58 = 0 time = 590
* CHECK dout1_3 vdout1_3ck58 = 1.7 time = 590
* CHECK dout1_4 vdout1_4ck58 = 1.7 time = 590
* CHECK dout1_5 vdout1_5ck58 = 0 time = 590
* CHECK dout1_6 vdout1_6ck58 = 1.7 time = 590
* CHECK dout1_7 vdout1_7ck58 = 1.7 time = 590
* CHECK dout1_8 vdout1_8ck58 = 0 time = 590
* CHECK dout1_9 vdout1_9ck58 = 1.7 time = 590
* CHECK dout1_10 vdout1_10ck58 = 0 time = 590
* CHECK dout1_11 vdout1_11ck58 = 0 time = 590
* CHECK dout1_12 vdout1_12ck58 = 0 time = 590
* CHECK dout1_13 vdout1_13ck58 = 1.7 time = 590
* CHECK dout1_14 vdout1_14ck58 = 1.7 time = 590
* CHECK dout1_15 vdout1_15ck58 = 1.7 time = 590
* CHECK dout1_16 vdout1_16ck58 = 0 time = 590
* CHECK dout1_0 vdout1_0ck59 = 1.7 time = 600
* CHECK dout1_1 vdout1_1ck59 = 0 time = 600
* CHECK dout1_2 vdout1_2ck59 = 0 time = 600
* CHECK dout1_3 vdout1_3ck59 = 1.7 time = 600
* CHECK dout1_4 vdout1_4ck59 = 1.7 time = 600
* CHECK dout1_5 vdout1_5ck59 = 0 time = 600
* CHECK dout1_6 vdout1_6ck59 = 1.7 time = 600
* CHECK dout1_7 vdout1_7ck59 = 1.7 time = 600
* CHECK dout1_8 vdout1_8ck59 = 0 time = 600
* CHECK dout1_9 vdout1_9ck59 = 1.7 time = 600
* CHECK dout1_10 vdout1_10ck59 = 0 time = 600
* CHECK dout1_11 vdout1_11ck59 = 0 time = 600
* CHECK dout1_12 vdout1_12ck59 = 0 time = 600
* CHECK dout1_13 vdout1_13ck59 = 1.7 time = 600
* CHECK dout1_14 vdout1_14ck59 = 1.7 time = 600
* CHECK dout1_15 vdout1_15ck59 = 1.7 time = 600
* CHECK dout1_16 vdout1_16ck59 = 0 time = 600
* CHECK dout1_0 vdout1_0ck60 = 1.7 time = 610
* CHECK dout1_1 vdout1_1ck60 = 0 time = 610
* CHECK dout1_2 vdout1_2ck60 = 1.7 time = 610
* CHECK dout1_3 vdout1_3ck60 = 0 time = 610
* CHECK dout1_4 vdout1_4ck60 = 0 time = 610
* CHECK dout1_5 vdout1_5ck60 = 0 time = 610
* CHECK dout1_6 vdout1_6ck60 = 0 time = 610
* CHECK dout1_7 vdout1_7ck60 = 1.7 time = 610
* CHECK dout1_8 vdout1_8ck60 = 0 time = 610
* CHECK dout1_9 vdout1_9ck60 = 1.7 time = 610
* CHECK dout1_10 vdout1_10ck60 = 1.7 time = 610
* CHECK dout1_11 vdout1_11ck60 = 0 time = 610
* CHECK dout1_12 vdout1_12ck60 = 0 time = 610
* CHECK dout1_13 vdout1_13ck60 = 0 time = 610
* CHECK dout1_14 vdout1_14ck60 = 1.7 time = 610
* CHECK dout1_15 vdout1_15ck60 = 1.7 time = 610
* CHECK dout1_16 vdout1_16ck60 = 0 time = 610
* CHECK dout1_0 vdout1_0ck62 = 1.7 time = 630
* CHECK dout1_1 vdout1_1ck62 = 0 time = 630
* CHECK dout1_2 vdout1_2ck62 = 1.7 time = 630
* CHECK dout1_3 vdout1_3ck62 = 0 time = 630
* CHECK dout1_4 vdout1_4ck62 = 0 time = 630
* CHECK dout1_5 vdout1_5ck62 = 0 time = 630
* CHECK dout1_6 vdout1_6ck62 = 0 time = 630
* CHECK dout1_7 vdout1_7ck62 = 1.7 time = 630
* CHECK dout1_8 vdout1_8ck62 = 0 time = 630
* CHECK dout1_9 vdout1_9ck62 = 1.7 time = 630
* CHECK dout1_10 vdout1_10ck62 = 1.7 time = 630
* CHECK dout1_11 vdout1_11ck62 = 0 time = 630
* CHECK dout1_12 vdout1_12ck62 = 0 time = 630
* CHECK dout1_13 vdout1_13ck62 = 0 time = 630
* CHECK dout1_14 vdout1_14ck62 = 1.7 time = 630
* CHECK dout1_15 vdout1_15ck62 = 1.7 time = 630
* CHECK dout1_16 vdout1_16ck62 = 0 time = 630
* CHECK dout1_0 vdout1_0ck65 = 1.7 time = 660
* CHECK dout1_1 vdout1_1ck65 = 0 time = 660
* CHECK dout1_2 vdout1_2ck65 = 0 time = 660
* CHECK dout1_3 vdout1_3ck65 = 1.7 time = 660
* CHECK dout1_4 vdout1_4ck65 = 1.7 time = 660
* CHECK dout1_5 vdout1_5ck65 = 0 time = 660
* CHECK dout1_6 vdout1_6ck65 = 1.7 time = 660
* CHECK dout1_7 vdout1_7ck65 = 1.7 time = 660
* CHECK dout1_8 vdout1_8ck65 = 0 time = 660
* CHECK dout1_9 vdout1_9ck65 = 1.7 time = 660
* CHECK dout1_10 vdout1_10ck65 = 0 time = 660
* CHECK dout1_11 vdout1_11ck65 = 0 time = 660
* CHECK dout1_12 vdout1_12ck65 = 0 time = 660
* CHECK dout1_13 vdout1_13ck65 = 1.7 time = 660
* CHECK dout1_14 vdout1_14ck65 = 1.7 time = 660
* CHECK dout1_15 vdout1_15ck65 = 1.7 time = 660
* CHECK dout1_16 vdout1_16ck65 = 0 time = 660
* CHECK dout1_0 vdout1_0ck66 = 1.7 time = 670
* CHECK dout1_1 vdout1_1ck66 = 0 time = 670
* CHECK dout1_2 vdout1_2ck66 = 0 time = 670
* CHECK dout1_3 vdout1_3ck66 = 1.7 time = 670
* CHECK dout1_4 vdout1_4ck66 = 1.7 time = 670
* CHECK dout1_5 vdout1_5ck66 = 1.7 time = 670
* CHECK dout1_6 vdout1_6ck66 = 1.7 time = 670
* CHECK dout1_7 vdout1_7ck66 = 0 time = 670
* CHECK dout1_8 vdout1_8ck66 = 1.7 time = 670
* CHECK dout1_9 vdout1_9ck66 = 1.7 time = 670
* CHECK dout1_10 vdout1_10ck66 = 0 time = 670
* CHECK dout1_11 vdout1_11ck66 = 0 time = 670
* CHECK dout1_12 vdout1_12ck66 = 1.7 time = 670
* CHECK dout1_13 vdout1_13ck66 = 0 time = 670
* CHECK dout1_14 vdout1_14ck66 = 0 time = 670
* CHECK dout1_15 vdout1_15ck66 = 1.7 time = 670
* CHECK dout1_16 vdout1_16ck66 = 0 time = 670
* CHECK dout1_0 vdout1_0ck69 = 1.7 time = 700
* CHECK dout1_1 vdout1_1ck69 = 0 time = 700
* CHECK dout1_2 vdout1_2ck69 = 1.7 time = 700
* CHECK dout1_3 vdout1_3ck69 = 0 time = 700
* CHECK dout1_4 vdout1_4ck69 = 1.7 time = 700
* CHECK dout1_5 vdout1_5ck69 = 1.7 time = 700
* CHECK dout1_6 vdout1_6ck69 = 0 time = 700
* CHECK dout1_7 vdout1_7ck69 = 0 time = 700
* CHECK dout1_8 vdout1_8ck69 = 0 time = 700
* CHECK dout1_9 vdout1_9ck69 = 1.7 time = 700
* CHECK dout1_10 vdout1_10ck69 = 1.7 time = 700
* CHECK dout1_11 vdout1_11ck69 = 1.7 time = 700
* CHECK dout1_12 vdout1_12ck69 = 1.7 time = 700
* CHECK dout1_13 vdout1_13ck69 = 1.7 time = 700
* CHECK dout1_14 vdout1_14ck69 = 1.7 time = 700
* CHECK dout1_15 vdout1_15ck69 = 0 time = 700
* CHECK dout1_16 vdout1_16ck69 = 0 time = 700
* CHECK dout1_0 vdout1_0ck73 = 1.7 time = 740
* CHECK dout1_1 vdout1_1ck73 = 1.7 time = 740
* CHECK dout1_2 vdout1_2ck73 = 1.7 time = 740
* CHECK dout1_3 vdout1_3ck73 = 1.7 time = 740
* CHECK dout1_4 vdout1_4ck73 = 0 time = 740
* CHECK dout1_5 vdout1_5ck73 = 0 time = 740
* CHECK dout1_6 vdout1_6ck73 = 0 time = 740
* CHECK dout1_7 vdout1_7ck73 = 0 time = 740
* CHECK dout1_8 vdout1_8ck73 = 0 time = 740
* CHECK dout1_9 vdout1_9ck73 = 0 time = 740
* CHECK dout1_10 vdout1_10ck73 = 0 time = 740
* CHECK dout1_11 vdout1_11ck73 = 0 time = 740
* CHECK dout1_12 vdout1_12ck73 = 0 time = 740
* CHECK dout1_13 vdout1_13ck73 = 0 time = 740
* CHECK dout1_14 vdout1_14ck73 = 0 time = 740
* CHECK dout1_15 vdout1_15ck73 = 0 time = 740
* CHECK dout1_16 vdout1_16ck73 = 0 time = 740
* CHECK dout1_0 vdout1_0ck74 = 1.7 time = 750
* CHECK dout1_1 vdout1_1ck74 = 1.7 time = 750
* CHECK dout1_2 vdout1_2ck74 = 0 time = 750
* CHECK dout1_3 vdout1_3ck74 = 1.7 time = 750
* CHECK dout1_4 vdout1_4ck74 = 1.7 time = 750
* CHECK dout1_5 vdout1_5ck74 = 0 time = 750
* CHECK dout1_6 vdout1_6ck74 = 1.7 time = 750
* CHECK dout1_7 vdout1_7ck74 = 1.7 time = 750
* CHECK dout1_8 vdout1_8ck74 = 0 time = 750
* CHECK dout1_9 vdout1_9ck74 = 0 time = 750
* CHECK dout1_10 vdout1_10ck74 = 0 time = 750
* CHECK dout1_11 vdout1_11ck74 = 0 time = 750
* CHECK dout1_12 vdout1_12ck74 = 1.7 time = 750
* CHECK dout1_13 vdout1_13ck74 = 1.7 time = 750
* CHECK dout1_14 vdout1_14ck74 = 1.7 time = 750
* CHECK dout1_15 vdout1_15ck74 = 1.7 time = 750
* CHECK dout1_16 vdout1_16ck74 = 0 time = 750
* CHECK dout1_0 vdout1_0ck75 = 1.7 time = 760
* CHECK dout1_1 vdout1_1ck75 = 1.7 time = 760
* CHECK dout1_2 vdout1_2ck75 = 0 time = 760
* CHECK dout1_3 vdout1_3ck75 = 1.7 time = 760
* CHECK dout1_4 vdout1_4ck75 = 0 time = 760
* CHECK dout1_5 vdout1_5ck75 = 0 time = 760
* CHECK dout1_6 vdout1_6ck75 = 0 time = 760
* CHECK dout1_7 vdout1_7ck75 = 0 time = 760
* CHECK dout1_8 vdout1_8ck75 = 1.7 time = 760
* CHECK dout1_9 vdout1_9ck75 = 0 time = 760
* CHECK dout1_10 vdout1_10ck75 = 0 time = 760
* CHECK dout1_11 vdout1_11ck75 = 1.7 time = 760
* CHECK dout1_12 vdout1_12ck75 = 0 time = 760
* CHECK dout1_13 vdout1_13ck75 = 1.7 time = 760
* CHECK dout1_14 vdout1_14ck75 = 0 time = 760
* CHECK dout1_15 vdout1_15ck75 = 1.7 time = 760
* CHECK dout1_16 vdout1_16ck75 = 0 time = 760
* CHECK dout1_0 vdout1_0ck77 = 1.7 time = 780
* CHECK dout1_1 vdout1_1ck77 = 0 time = 780
* CHECK dout1_2 vdout1_2ck77 = 0 time = 780
* CHECK dout1_3 vdout1_3ck77 = 1.7 time = 780
* CHECK dout1_4 vdout1_4ck77 = 1.7 time = 780
* CHECK dout1_5 vdout1_5ck77 = 0 time = 780
* CHECK dout1_6 vdout1_6ck77 = 1.7 time = 780
* CHECK dout1_7 vdout1_7ck77 = 1.7 time = 780
* CHECK dout1_8 vdout1_8ck77 = 0 time = 780
* CHECK dout1_9 vdout1_9ck77 = 1.7 time = 780
* CHECK dout1_10 vdout1_10ck77 = 0 time = 780
* CHECK dout1_11 vdout1_11ck77 = 0 time = 780
* CHECK dout1_12 vdout1_12ck77 = 0 time = 780
* CHECK dout1_13 vdout1_13ck77 = 1.7 time = 780
* CHECK dout1_14 vdout1_14ck77 = 1.7 time = 780
* CHECK dout1_15 vdout1_15ck77 = 1.7 time = 780
* CHECK dout1_16 vdout1_16ck77 = 0 time = 780
* CHECK dout1_0 vdout1_0ck78 = 1.7 time = 790
* CHECK dout1_1 vdout1_1ck78 = 1.7 time = 790
* CHECK dout1_2 vdout1_2ck78 = 1.7 time = 790
* CHECK dout1_3 vdout1_3ck78 = 1.7 time = 790
* CHECK dout1_4 vdout1_4ck78 = 0 time = 790
* CHECK dout1_5 vdout1_5ck78 = 0 time = 790
* CHECK dout1_6 vdout1_6ck78 = 0 time = 790
* CHECK dout1_7 vdout1_7ck78 = 0 time = 790
* CHECK dout1_8 vdout1_8ck78 = 0 time = 790
* CHECK dout1_9 vdout1_9ck78 = 0 time = 790
* CHECK dout1_10 vdout1_10ck78 = 0 time = 790
* CHECK dout1_11 vdout1_11ck78 = 0 time = 790
* CHECK dout1_12 vdout1_12ck78 = 0 time = 790
* CHECK dout1_13 vdout1_13ck78 = 0 time = 790
* CHECK dout1_14 vdout1_14ck78 = 0 time = 790
* CHECK dout1_15 vdout1_15ck78 = 0 time = 790
* CHECK dout1_16 vdout1_16ck78 = 0 time = 790
* CHECK dout1_0 vdout1_0ck86 = 0 time = 870
* CHECK dout1_1 vdout1_1ck86 = 0 time = 870
* CHECK dout1_2 vdout1_2ck86 = 0 time = 870
* CHECK dout1_3 vdout1_3ck86 = 1.7 time = 870
* CHECK dout1_4 vdout1_4ck86 = 0 time = 870
* CHECK dout1_5 vdout1_5ck86 = 1.7 time = 870
* CHECK dout1_6 vdout1_6ck86 = 1.7 time = 870
* CHECK dout1_7 vdout1_7ck86 = 1.7 time = 870
* CHECK dout1_8 vdout1_8ck86 = 1.7 time = 870
* CHECK dout1_9 vdout1_9ck86 = 0 time = 870
* CHECK dout1_10 vdout1_10ck86 = 1.7 time = 870
* CHECK dout1_11 vdout1_11ck86 = 1.7 time = 870
* CHECK dout1_12 vdout1_12ck86 = 0 time = 870
* CHECK dout1_13 vdout1_13ck86 = 0 time = 870
* CHECK dout1_14 vdout1_14ck86 = 1.7 time = 870
* CHECK dout1_15 vdout1_15ck86 = 1.7 time = 870
* CHECK dout1_16 vdout1_16ck86 = 0 time = 870
* CHECK dout1_0 vdout1_0ck87 = 0 time = 880
* CHECK dout1_1 vdout1_1ck87 = 0 time = 880
* CHECK dout1_2 vdout1_2ck87 = 0 time = 880
* CHECK dout1_3 vdout1_3ck87 = 1.7 time = 880
* CHECK dout1_4 vdout1_4ck87 = 0 time = 880
* CHECK dout1_5 vdout1_5ck87 = 1.7 time = 880
* CHECK dout1_6 vdout1_6ck87 = 1.7 time = 880
* CHECK dout1_7 vdout1_7ck87 = 1.7 time = 880
* CHECK dout1_8 vdout1_8ck87 = 1.7 time = 880
* CHECK dout1_9 vdout1_9ck87 = 0 time = 880
* CHECK dout1_10 vdout1_10ck87 = 1.7 time = 880
* CHECK dout1_11 vdout1_11ck87 = 1.7 time = 880
* CHECK dout1_12 vdout1_12ck87 = 0 time = 880
* CHECK dout1_13 vdout1_13ck87 = 0 time = 880
* CHECK dout1_14 vdout1_14ck87 = 1.7 time = 880
* CHECK dout1_15 vdout1_15ck87 = 1.7 time = 880
* CHECK dout1_16 vdout1_16ck87 = 0 time = 880
* CHECK dout1_0 vdout1_0ck88 = 0 time = 890
* CHECK dout1_1 vdout1_1ck88 = 1.7 time = 890
* CHECK dout1_2 vdout1_2ck88 = 0 time = 890
* CHECK dout1_3 vdout1_3ck88 = 0 time = 890
* CHECK dout1_4 vdout1_4ck88 = 1.7 time = 890
* CHECK dout1_5 vdout1_5ck88 = 0 time = 890
* CHECK dout1_6 vdout1_6ck88 = 0 time = 890
* CHECK dout1_7 vdout1_7ck88 = 0 time = 890
* CHECK dout1_8 vdout1_8ck88 = 1.7 time = 890
* CHECK dout1_9 vdout1_9ck88 = 0 time = 890
* CHECK dout1_10 vdout1_10ck88 = 1.7 time = 890
* CHECK dout1_11 vdout1_11ck88 = 0 time = 890
* CHECK dout1_12 vdout1_12ck88 = 0 time = 890
* CHECK dout1_13 vdout1_13ck88 = 0 time = 890
* CHECK dout1_14 vdout1_14ck88 = 0 time = 890
* CHECK dout1_15 vdout1_15ck88 = 1.7 time = 890
* CHECK dout1_16 vdout1_16ck88 = 0 time = 890
* CHECK dout1_0 vdout1_0ck89 = 1.7 time = 900
* CHECK dout1_1 vdout1_1ck89 = 0 time = 900
* CHECK dout1_2 vdout1_2ck89 = 0 time = 900
* CHECK dout1_3 vdout1_3ck89 = 1.7 time = 900
* CHECK dout1_4 vdout1_4ck89 = 1.7 time = 900
* CHECK dout1_5 vdout1_5ck89 = 1.7 time = 900
* CHECK dout1_6 vdout1_6ck89 = 0 time = 900
* CHECK dout1_7 vdout1_7ck89 = 0 time = 900
* CHECK dout1_8 vdout1_8ck89 = 1.7 time = 900
* CHECK dout1_9 vdout1_9ck89 = 0 time = 900
* CHECK dout1_10 vdout1_10ck89 = 1.7 time = 900
* CHECK dout1_11 vdout1_11ck89 = 0 time = 900
* CHECK dout1_12 vdout1_12ck89 = 1.7 time = 900
* CHECK dout1_13 vdout1_13ck89 = 1.7 time = 900
* CHECK dout1_14 vdout1_14ck89 = 0 time = 900
* CHECK dout1_15 vdout1_15ck89 = 1.7 time = 900
* CHECK dout1_16 vdout1_16ck89 = 0 time = 900
* CHECK dout1_0 vdout1_0ck90 = 1.7 time = 910
* CHECK dout1_1 vdout1_1ck90 = 0 time = 910
* CHECK dout1_2 vdout1_2ck90 = 0 time = 910
* CHECK dout1_3 vdout1_3ck90 = 1.7 time = 910
* CHECK dout1_4 vdout1_4ck90 = 1.7 time = 910
* CHECK dout1_5 vdout1_5ck90 = 1.7 time = 910
* CHECK dout1_6 vdout1_6ck90 = 1.7 time = 910
* CHECK dout1_7 vdout1_7ck90 = 0 time = 910
* CHECK dout1_8 vdout1_8ck90 = 1.7 time = 910
* CHECK dout1_9 vdout1_9ck90 = 1.7 time = 910
* CHECK dout1_10 vdout1_10ck90 = 0 time = 910
* CHECK dout1_11 vdout1_11ck90 = 0 time = 910
* CHECK dout1_12 vdout1_12ck90 = 1.7 time = 910
* CHECK dout1_13 vdout1_13ck90 = 0 time = 910
* CHECK dout1_14 vdout1_14ck90 = 0 time = 910
* CHECK dout1_15 vdout1_15ck90 = 1.7 time = 910
* CHECK dout1_16 vdout1_16ck90 = 0 time = 910
* CHECK dout1_0 vdout1_0ck92 = 0 time = 930
* CHECK dout1_1 vdout1_1ck92 = 1.7 time = 930
* CHECK dout1_2 vdout1_2ck92 = 0 time = 930
* CHECK dout1_3 vdout1_3ck92 = 1.7 time = 930
* CHECK dout1_4 vdout1_4ck92 = 1.7 time = 930
* CHECK dout1_5 vdout1_5ck92 = 1.7 time = 930
* CHECK dout1_6 vdout1_6ck92 = 0 time = 930
* CHECK dout1_7 vdout1_7ck92 = 1.7 time = 930
* CHECK dout1_8 vdout1_8ck92 = 1.7 time = 930
* CHECK dout1_9 vdout1_9ck92 = 1.7 time = 930
* CHECK dout1_10 vdout1_10ck92 = 0 time = 930
* CHECK dout1_11 vdout1_11ck92 = 0 time = 930
* CHECK dout1_12 vdout1_12ck92 = 1.7 time = 930
* CHECK dout1_13 vdout1_13ck92 = 1.7 time = 930
* CHECK dout1_14 vdout1_14ck92 = 0 time = 930
* CHECK dout1_15 vdout1_15ck92 = 1.7 time = 930
* CHECK dout1_16 vdout1_16ck92 = 0 time = 930
* CHECK dout1_0 vdout1_0ck93 = 1.7 time = 940
* CHECK dout1_1 vdout1_1ck93 = 0 time = 940
* CHECK dout1_2 vdout1_2ck93 = 0 time = 940
* CHECK dout1_3 vdout1_3ck93 = 1.7 time = 940
* CHECK dout1_4 vdout1_4ck93 = 1.7 time = 940
* CHECK dout1_5 vdout1_5ck93 = 1.7 time = 940
* CHECK dout1_6 vdout1_6ck93 = 1.7 time = 940
* CHECK dout1_7 vdout1_7ck93 = 0 time = 940
* CHECK dout1_8 vdout1_8ck93 = 1.7 time = 940
* CHECK dout1_9 vdout1_9ck93 = 1.7 time = 940
* CHECK dout1_10 vdout1_10ck93 = 0 time = 940
* CHECK dout1_11 vdout1_11ck93 = 0 time = 940
* CHECK dout1_12 vdout1_12ck93 = 1.7 time = 940
* CHECK dout1_13 vdout1_13ck93 = 0 time = 940
* CHECK dout1_14 vdout1_14ck93 = 0 time = 940
* CHECK dout1_15 vdout1_15ck93 = 1.7 time = 940
* CHECK dout1_16 vdout1_16ck93 = 0 time = 940
* CHECK dout1_0 vdout1_0ck94 = 1.7 time = 950
* CHECK dout1_1 vdout1_1ck94 = 0 time = 950
* CHECK dout1_2 vdout1_2ck94 = 0 time = 950
* CHECK dout1_3 vdout1_3ck94 = 1.7 time = 950
* CHECK dout1_4 vdout1_4ck94 = 1.7 time = 950
* CHECK dout1_5 vdout1_5ck94 = 1.7 time = 950
* CHECK dout1_6 vdout1_6ck94 = 1.7 time = 950
* CHECK dout1_7 vdout1_7ck94 = 0 time = 950
* CHECK dout1_8 vdout1_8ck94 = 1.7 time = 950
* CHECK dout1_9 vdout1_9ck94 = 1.7 time = 950
* CHECK dout1_10 vdout1_10ck94 = 0 time = 950
* CHECK dout1_11 vdout1_11ck94 = 0 time = 950
* CHECK dout1_12 vdout1_12ck94 = 1.7 time = 950
* CHECK dout1_13 vdout1_13ck94 = 0 time = 950
* CHECK dout1_14 vdout1_14ck94 = 0 time = 950
* CHECK dout1_15 vdout1_15ck94 = 1.7 time = 950
* CHECK dout1_16 vdout1_16ck94 = 0 time = 950
* CHECK dout1_0 vdout1_0ck95 = 1.7 time = 960
* CHECK dout1_1 vdout1_1ck95 = 0 time = 960
* CHECK dout1_2 vdout1_2ck95 = 1.7 time = 960
* CHECK dout1_3 vdout1_3ck95 = 0 time = 960
* CHECK dout1_4 vdout1_4ck95 = 0 time = 960
* CHECK dout1_5 vdout1_5ck95 = 1.7 time = 960
* CHECK dout1_6 vdout1_6ck95 = 1.7 time = 960
* CHECK dout1_7 vdout1_7ck95 = 1.7 time = 960
* CHECK dout1_8 vdout1_8ck95 = 0 time = 960
* CHECK dout1_9 vdout1_9ck95 = 1.7 time = 960
* CHECK dout1_10 vdout1_10ck95 = 0 time = 960
* CHECK dout1_11 vdout1_11ck95 = 1.7 time = 960
* CHECK dout1_12 vdout1_12ck95 = 1.7 time = 960
* CHECK dout1_13 vdout1_13ck95 = 0 time = 960
* CHECK dout1_14 vdout1_14ck95 = 0 time = 960
* CHECK dout1_15 vdout1_15ck95 = 1.7 time = 960
* CHECK dout1_16 vdout1_16ck95 = 0 time = 960
* CHECK dout1_0 vdout1_0ck96 = 1.7 time = 970
* CHECK dout1_1 vdout1_1ck96 = 0 time = 970
* CHECK dout1_2 vdout1_2ck96 = 0 time = 970
* CHECK dout1_3 vdout1_3ck96 = 0 time = 970
* CHECK dout1_4 vdout1_4ck96 = 1.7 time = 970
* CHECK dout1_5 vdout1_5ck96 = 1.7 time = 970
* CHECK dout1_6 vdout1_6ck96 = 0 time = 970
* CHECK dout1_7 vdout1_7ck96 = 1.7 time = 970
* CHECK dout1_8 vdout1_8ck96 = 0 time = 970
* CHECK dout1_9 vdout1_9ck96 = 1.7 time = 970
* CHECK dout1_10 vdout1_10ck96 = 0 time = 970
* CHECK dout1_11 vdout1_11ck96 = 1.7 time = 970
* CHECK dout1_12 vdout1_12ck96 = 1.7 time = 970
* CHECK dout1_13 vdout1_13ck96 = 1.7 time = 970
* CHECK dout1_14 vdout1_14ck96 = 1.7 time = 970
* CHECK dout1_15 vdout1_15ck96 = 1.7 time = 970
* CHECK dout1_16 vdout1_16ck96 = 0 time = 970
* CHECK dout1_0 vdout1_0ck97 = 1.7 time = 980
* CHECK dout1_1 vdout1_1ck97 = 0 time = 980
* CHECK dout1_2 vdout1_2ck97 = 0 time = 980
* CHECK dout1_3 vdout1_3ck97 = 1.7 time = 980
* CHECK dout1_4 vdout1_4ck97 = 1.7 time = 980
* CHECK dout1_5 vdout1_5ck97 = 1.7 time = 980
* CHECK dout1_6 vdout1_6ck97 = 1.7 time = 980
* CHECK dout1_7 vdout1_7ck97 = 0 time = 980
* CHECK dout1_8 vdout1_8ck97 = 1.7 time = 980
* CHECK dout1_9 vdout1_9ck97 = 1.7 time = 980
* CHECK dout1_10 vdout1_10ck97 = 0 time = 980
* CHECK dout1_11 vdout1_11ck97 = 0 time = 980
* CHECK dout1_12 vdout1_12ck97 = 1.7 time = 980
* CHECK dout1_13 vdout1_13ck97 = 0 time = 980
* CHECK dout1_14 vdout1_14ck97 = 0 time = 980
* CHECK dout1_15 vdout1_15ck97 = 1.7 time = 980
* CHECK dout1_16 vdout1_16ck97 = 0 time = 980
* CHECK dout1_0 vdout1_0ck98 = 1.7 time = 990
* CHECK dout1_1 vdout1_1ck98 = 0 time = 990
* CHECK dout1_2 vdout1_2ck98 = 1.7 time = 990
* CHECK dout1_3 vdout1_3ck98 = 0 time = 990
* CHECK dout1_4 vdout1_4ck98 = 0 time = 990
* CHECK dout1_5 vdout1_5ck98 = 1.7 time = 990
* CHECK dout1_6 vdout1_6ck98 = 1.7 time = 990
* CHECK dout1_7 vdout1_7ck98 = 1.7 time = 990
* CHECK dout1_8 vdout1_8ck98 = 0 time = 990
* CHECK dout1_9 vdout1_9ck98 = 1.7 time = 990
* CHECK dout1_10 vdout1_10ck98 = 0 time = 990
* CHECK dout1_11 vdout1_11ck98 = 1.7 time = 990
* CHECK dout1_12 vdout1_12ck98 = 1.7 time = 990
* CHECK dout1_13 vdout1_13ck98 = 0 time = 990
* CHECK dout1_14 vdout1_14ck98 = 0 time = 990
* CHECK dout1_15 vdout1_15ck98 = 1.7 time = 990
* CHECK dout1_16 vdout1_16ck98 = 0 time = 990
* CHECK dout1_0 vdout1_0ck102 = 0 time = 1030
* CHECK dout1_1 vdout1_1ck102 = 0 time = 1030
* CHECK dout1_2 vdout1_2ck102 = 0 time = 1030
* CHECK dout1_3 vdout1_3ck102 = 1.7 time = 1030
* CHECK dout1_4 vdout1_4ck102 = 0 time = 1030
* CHECK dout1_5 vdout1_5ck102 = 1.7 time = 1030
* CHECK dout1_6 vdout1_6ck102 = 0 time = 1030
* CHECK dout1_7 vdout1_7ck102 = 1.7 time = 1030
* CHECK dout1_8 vdout1_8ck102 = 0 time = 1030
* CHECK dout1_9 vdout1_9ck102 = 1.7 time = 1030
* CHECK dout1_10 vdout1_10ck102 = 0 time = 1030
* CHECK dout1_11 vdout1_11ck102 = 1.7 time = 1030
* CHECK dout1_12 vdout1_12ck102 = 1.7 time = 1030
* CHECK dout1_13 vdout1_13ck102 = 1.7 time = 1030
* CHECK dout1_14 vdout1_14ck102 = 0 time = 1030
* CHECK dout1_15 vdout1_15ck102 = 1.7 time = 1030
* CHECK dout1_16 vdout1_16ck102 = 0 time = 1030
* CHECK dout1_0 vdout1_0ck110 = 0 time = 1110
* CHECK dout1_1 vdout1_1ck110 = 0 time = 1110
* CHECK dout1_2 vdout1_2ck110 = 0 time = 1110
* CHECK dout1_3 vdout1_3ck110 = 1.7 time = 1110
* CHECK dout1_4 vdout1_4ck110 = 0 time = 1110
* CHECK dout1_5 vdout1_5ck110 = 0 time = 1110
* CHECK dout1_6 vdout1_6ck110 = 1.7 time = 1110
* CHECK dout1_7 vdout1_7ck110 = 0 time = 1110
* CHECK dout1_8 vdout1_8ck110 = 0 time = 1110
* CHECK dout1_9 vdout1_9ck110 = 0 time = 1110
* CHECK dout1_10 vdout1_10ck110 = 1.7 time = 1110
* CHECK dout1_11 vdout1_11ck110 = 0 time = 1110
* CHECK dout1_12 vdout1_12ck110 = 1.7 time = 1110
* CHECK dout1_13 vdout1_13ck110 = 0 time = 1110
* CHECK dout1_14 vdout1_14ck110 = 1.7 time = 1110
* CHECK dout1_15 vdout1_15ck110 = 1.7 time = 1110
* CHECK dout1_16 vdout1_16ck110 = 0 time = 1110
* CHECK dout1_0 vdout1_0ck113 = 0 time = 1140
* CHECK dout1_1 vdout1_1ck113 = 0 time = 1140
* CHECK dout1_2 vdout1_2ck113 = 0 time = 1140
* CHECK dout1_3 vdout1_3ck113 = 1.7 time = 1140
* CHECK dout1_4 vdout1_4ck113 = 0 time = 1140
* CHECK dout1_5 vdout1_5ck113 = 1.7 time = 1140
* CHECK dout1_6 vdout1_6ck113 = 1.7 time = 1140
* CHECK dout1_7 vdout1_7ck113 = 0 time = 1140
* CHECK dout1_8 vdout1_8ck113 = 0 time = 1140
* CHECK dout1_9 vdout1_9ck113 = 0 time = 1140
* CHECK dout1_10 vdout1_10ck113 = 1.7 time = 1140
* CHECK dout1_11 vdout1_11ck113 = 0 time = 1140
* CHECK dout1_12 vdout1_12ck113 = 1.7 time = 1140
* CHECK dout1_13 vdout1_13ck113 = 0 time = 1140
* CHECK dout1_14 vdout1_14ck113 = 0 time = 1140
* CHECK dout1_15 vdout1_15ck113 = 0 time = 1140
* CHECK dout1_16 vdout1_16ck113 = 0 time = 1140
* CHECK dout1_0 vdout1_0ck114 = 0 time = 1150
* CHECK dout1_1 vdout1_1ck114 = 0 time = 1150
* CHECK dout1_2 vdout1_2ck114 = 0 time = 1150
* CHECK dout1_3 vdout1_3ck114 = 0 time = 1150
* CHECK dout1_4 vdout1_4ck114 = 0 time = 1150
* CHECK dout1_5 vdout1_5ck114 = 1.7 time = 1150
* CHECK dout1_6 vdout1_6ck114 = 0 time = 1150
* CHECK dout1_7 vdout1_7ck114 = 0 time = 1150
* CHECK dout1_8 vdout1_8ck114 = 0 time = 1150
* CHECK dout1_9 vdout1_9ck114 = 0 time = 1150
* CHECK dout1_10 vdout1_10ck114 = 0 time = 1150
* CHECK dout1_11 vdout1_11ck114 = 0 time = 1150
* CHECK dout1_12 vdout1_12ck114 = 1.7 time = 1150
* CHECK dout1_13 vdout1_13ck114 = 0 time = 1150
* CHECK dout1_14 vdout1_14ck114 = 0 time = 1150
* CHECK dout1_15 vdout1_15ck114 = 1.7 time = 1150
* CHECK dout1_16 vdout1_16ck114 = 0 time = 1150
* CHECK dout1_0 vdout1_0ck115 = 0 time = 1160
* CHECK dout1_1 vdout1_1ck115 = 0 time = 1160
* CHECK dout1_2 vdout1_2ck115 = 0 time = 1160
* CHECK dout1_3 vdout1_3ck115 = 0 time = 1160
* CHECK dout1_4 vdout1_4ck115 = 0 time = 1160
* CHECK dout1_5 vdout1_5ck115 = 1.7 time = 1160
* CHECK dout1_6 vdout1_6ck115 = 0 time = 1160
* CHECK dout1_7 vdout1_7ck115 = 0 time = 1160
* CHECK dout1_8 vdout1_8ck115 = 0 time = 1160
* CHECK dout1_9 vdout1_9ck115 = 0 time = 1160
* CHECK dout1_10 vdout1_10ck115 = 0 time = 1160
* CHECK dout1_11 vdout1_11ck115 = 0 time = 1160
* CHECK dout1_12 vdout1_12ck115 = 1.7 time = 1160
* CHECK dout1_13 vdout1_13ck115 = 0 time = 1160
* CHECK dout1_14 vdout1_14ck115 = 0 time = 1160
* CHECK dout1_15 vdout1_15ck115 = 1.7 time = 1160
* CHECK dout1_16 vdout1_16ck115 = 0 time = 1160
* CHECK dout1_0 vdout1_0ck119 = 1.7 time = 1200
* CHECK dout1_1 vdout1_1ck119 = 0 time = 1200
* CHECK dout1_2 vdout1_2ck119 = 0 time = 1200
* CHECK dout1_3 vdout1_3ck119 = 0 time = 1200
* CHECK dout1_4 vdout1_4ck119 = 0 time = 1200
* CHECK dout1_5 vdout1_5ck119 = 1.7 time = 1200
* CHECK dout1_6 vdout1_6ck119 = 1.7 time = 1200
* CHECK dout1_7 vdout1_7ck119 = 1.7 time = 1200
* CHECK dout1_8 vdout1_8ck119 = 0 time = 1200
* CHECK dout1_9 vdout1_9ck119 = 0 time = 1200
* CHECK dout1_10 vdout1_10ck119 = 0 time = 1200
* CHECK dout1_11 vdout1_11ck119 = 1.7 time = 1200
* CHECK dout1_12 vdout1_12ck119 = 1.7 time = 1200
* CHECK dout1_13 vdout1_13ck119 = 1.7 time = 1200
* CHECK dout1_14 vdout1_14ck119 = 1.7 time = 1200
* CHECK dout1_15 vdout1_15ck119 = 0 time = 1200
* CHECK dout1_16 vdout1_16ck119 = 0 time = 1200
* CHECK dout1_0 vdout1_0ck120 = 0 time = 1210
* CHECK dout1_1 vdout1_1ck120 = 0 time = 1210
* CHECK dout1_2 vdout1_2ck120 = 0 time = 1210
* CHECK dout1_3 vdout1_3ck120 = 1.7 time = 1210
* CHECK dout1_4 vdout1_4ck120 = 0 time = 1210
* CHECK dout1_5 vdout1_5ck120 = 1.7 time = 1210
* CHECK dout1_6 vdout1_6ck120 = 1.7 time = 1210
* CHECK dout1_7 vdout1_7ck120 = 0 time = 1210
* CHECK dout1_8 vdout1_8ck120 = 0 time = 1210
* CHECK dout1_9 vdout1_9ck120 = 0 time = 1210
* CHECK dout1_10 vdout1_10ck120 = 1.7 time = 1210
* CHECK dout1_11 vdout1_11ck120 = 0 time = 1210
* CHECK dout1_12 vdout1_12ck120 = 1.7 time = 1210
* CHECK dout1_13 vdout1_13ck120 = 0 time = 1210
* CHECK dout1_14 vdout1_14ck120 = 0 time = 1210
* CHECK dout1_15 vdout1_15ck120 = 0 time = 1210
* CHECK dout1_16 vdout1_16ck120 = 0 time = 1210
* CHECK dout1_0 vdout1_0ck123 = 1.7 time = 1240
* CHECK dout1_1 vdout1_1ck123 = 0 time = 1240
* CHECK dout1_2 vdout1_2ck123 = 0 time = 1240
* CHECK dout1_3 vdout1_3ck123 = 1.7 time = 1240
* CHECK dout1_4 vdout1_4ck123 = 1.7 time = 1240
* CHECK dout1_5 vdout1_5ck123 = 1.7 time = 1240
* CHECK dout1_6 vdout1_6ck123 = 1.7 time = 1240
* CHECK dout1_7 vdout1_7ck123 = 0 time = 1240
* CHECK dout1_8 vdout1_8ck123 = 1.7 time = 1240
* CHECK dout1_9 vdout1_9ck123 = 1.7 time = 1240
* CHECK dout1_10 vdout1_10ck123 = 0 time = 1240
* CHECK dout1_11 vdout1_11ck123 = 0 time = 1240
* CHECK dout1_12 vdout1_12ck123 = 1.7 time = 1240
* CHECK dout1_13 vdout1_13ck123 = 0 time = 1240
* CHECK dout1_14 vdout1_14ck123 = 0 time = 1240
* CHECK dout1_15 vdout1_15ck123 = 1.7 time = 1240
* CHECK dout1_16 vdout1_16ck123 = 0 time = 1240
* CHECK dout1_0 vdout1_0ck124 = 0 time = 1250
* CHECK dout1_1 vdout1_1ck124 = 0 time = 1250
* CHECK dout1_2 vdout1_2ck124 = 0 time = 1250
* CHECK dout1_3 vdout1_3ck124 = 0 time = 1250
* CHECK dout1_4 vdout1_4ck124 = 0 time = 1250
* CHECK dout1_5 vdout1_5ck124 = 1.7 time = 1250
* CHECK dout1_6 vdout1_6ck124 = 0 time = 1250
* CHECK dout1_7 vdout1_7ck124 = 0 time = 1250
* CHECK dout1_8 vdout1_8ck124 = 0 time = 1250
* CHECK dout1_9 vdout1_9ck124 = 0 time = 1250
* CHECK dout1_10 vdout1_10ck124 = 0 time = 1250
* CHECK dout1_11 vdout1_11ck124 = 0 time = 1250
* CHECK dout1_12 vdout1_12ck124 = 1.7 time = 1250
* CHECK dout1_13 vdout1_13ck124 = 0 time = 1250
* CHECK dout1_14 vdout1_14ck124 = 0 time = 1250
* CHECK dout1_15 vdout1_15ck124 = 1.7 time = 1250
* CHECK dout1_16 vdout1_16ck124 = 0 time = 1250
* CHECK dout1_0 vdout1_0ck129 = 0 time = 1300
* CHECK dout1_1 vdout1_1ck129 = 1.7 time = 1300
* CHECK dout1_2 vdout1_2ck129 = 0 time = 1300
* CHECK dout1_3 vdout1_3ck129 = 0 time = 1300
* CHECK dout1_4 vdout1_4ck129 = 1.7 time = 1300
* CHECK dout1_5 vdout1_5ck129 = 1.7 time = 1300
* CHECK dout1_6 vdout1_6ck129 = 0 time = 1300
* CHECK dout1_7 vdout1_7ck129 = 0 time = 1300
* CHECK dout1_8 vdout1_8ck129 = 1.7 time = 1300
* CHECK dout1_9 vdout1_9ck129 = 0 time = 1300
* CHECK dout1_10 vdout1_10ck129 = 0 time = 1300
* CHECK dout1_11 vdout1_11ck129 = 1.7 time = 1300
* CHECK dout1_12 vdout1_12ck129 = 1.7 time = 1300
* CHECK dout1_13 vdout1_13ck129 = 1.7 time = 1300
* CHECK dout1_14 vdout1_14ck129 = 0 time = 1300
* CHECK dout1_15 vdout1_15ck129 = 1.7 time = 1300
* CHECK dout1_16 vdout1_16ck129 = 0 time = 1300
* CHECK dout1_0 vdout1_0ck130 = 0 time = 1310
* CHECK dout1_1 vdout1_1ck130 = 0 time = 1310
* CHECK dout1_2 vdout1_2ck130 = 0 time = 1310
* CHECK dout1_3 vdout1_3ck130 = 1.7 time = 1310
* CHECK dout1_4 vdout1_4ck130 = 0 time = 1310
* CHECK dout1_5 vdout1_5ck130 = 1.7 time = 1310
* CHECK dout1_6 vdout1_6ck130 = 0 time = 1310
* CHECK dout1_7 vdout1_7ck130 = 1.7 time = 1310
* CHECK dout1_8 vdout1_8ck130 = 0 time = 1310
* CHECK dout1_9 vdout1_9ck130 = 0 time = 1310
* CHECK dout1_10 vdout1_10ck130 = 1.7 time = 1310
* CHECK dout1_11 vdout1_11ck130 = 0 time = 1310
* CHECK dout1_12 vdout1_12ck130 = 0 time = 1310
* CHECK dout1_13 vdout1_13ck130 = 0 time = 1310
* CHECK dout1_14 vdout1_14ck130 = 1.7 time = 1310
* CHECK dout1_15 vdout1_15ck130 = 1.7 time = 1310
* CHECK dout1_16 vdout1_16ck130 = 0 time = 1310
* CHECK dout1_0 vdout1_0ck132 = 0 time = 1330
* CHECK dout1_1 vdout1_1ck132 = 0 time = 1330
* CHECK dout1_2 vdout1_2ck132 = 0 time = 1330
* CHECK dout1_3 vdout1_3ck132 = 1.7 time = 1330
* CHECK dout1_4 vdout1_4ck132 = 0 time = 1330
* CHECK dout1_5 vdout1_5ck132 = 0 time = 1330
* CHECK dout1_6 vdout1_6ck132 = 1.7 time = 1330
* CHECK dout1_7 vdout1_7ck132 = 0 time = 1330
* CHECK dout1_8 vdout1_8ck132 = 0 time = 1330
* CHECK dout1_9 vdout1_9ck132 = 0 time = 1330
* CHECK dout1_10 vdout1_10ck132 = 1.7 time = 1330
* CHECK dout1_11 vdout1_11ck132 = 0 time = 1330
* CHECK dout1_12 vdout1_12ck132 = 1.7 time = 1330
* CHECK dout1_13 vdout1_13ck132 = 0 time = 1330
* CHECK dout1_14 vdout1_14ck132 = 1.7 time = 1330
* CHECK dout1_15 vdout1_15ck132 = 1.7 time = 1330
* CHECK dout1_16 vdout1_16ck132 = 0 time = 1330
* CHECK dout1_0 vdout1_0ck137 = 0 time = 1380
* CHECK dout1_1 vdout1_1ck137 = 1.7 time = 1380
* CHECK dout1_2 vdout1_2ck137 = 1.7 time = 1380
* CHECK dout1_3 vdout1_3ck137 = 1.7 time = 1380
* CHECK dout1_4 vdout1_4ck137 = 1.7 time = 1380
* CHECK dout1_5 vdout1_5ck137 = 0 time = 1380
* CHECK dout1_6 vdout1_6ck137 = 1.7 time = 1380
* CHECK dout1_7 vdout1_7ck137 = 0 time = 1380
* CHECK dout1_8 vdout1_8ck137 = 1.7 time = 1380
* CHECK dout1_9 vdout1_9ck137 = 0 time = 1380
* CHECK dout1_10 vdout1_10ck137 = 0 time = 1380
* CHECK dout1_11 vdout1_11ck137 = 0 time = 1380
* CHECK dout1_12 vdout1_12ck137 = 0 time = 1380
* CHECK dout1_13 vdout1_13ck137 = 1.7 time = 1380
* CHECK dout1_14 vdout1_14ck137 = 0 time = 1380
* CHECK dout1_15 vdout1_15ck137 = 0 time = 1380
* CHECK dout1_16 vdout1_16ck137 = 0 time = 1380
* CHECK dout1_0 vdout1_0ck138 = 0 time = 1390
* CHECK dout1_1 vdout1_1ck138 = 1.7 time = 1390
* CHECK dout1_2 vdout1_2ck138 = 1.7 time = 1390
* CHECK dout1_3 vdout1_3ck138 = 1.7 time = 1390
* CHECK dout1_4 vdout1_4ck138 = 1.7 time = 1390
* CHECK dout1_5 vdout1_5ck138 = 0 time = 1390
* CHECK dout1_6 vdout1_6ck138 = 1.7 time = 1390
* CHECK dout1_7 vdout1_7ck138 = 0 time = 1390
* CHECK dout1_8 vdout1_8ck138 = 1.7 time = 1390
* CHECK dout1_9 vdout1_9ck138 = 0 time = 1390
* CHECK dout1_10 vdout1_10ck138 = 0 time = 1390
* CHECK dout1_11 vdout1_11ck138 = 0 time = 1390
* CHECK dout1_12 vdout1_12ck138 = 0 time = 1390
* CHECK dout1_13 vdout1_13ck138 = 1.7 time = 1390
* CHECK dout1_14 vdout1_14ck138 = 0 time = 1390
* CHECK dout1_15 vdout1_15ck138 = 0 time = 1390
* CHECK dout1_16 vdout1_16ck138 = 0 time = 1390
* CHECK dout1_0 vdout1_0ck139 = 1.7 time = 1400
* CHECK dout1_1 vdout1_1ck139 = 0 time = 1400
* CHECK dout1_2 vdout1_2ck139 = 1.7 time = 1400
* CHECK dout1_3 vdout1_3ck139 = 1.7 time = 1400
* CHECK dout1_4 vdout1_4ck139 = 0 time = 1400
* CHECK dout1_5 vdout1_5ck139 = 0 time = 1400
* CHECK dout1_6 vdout1_6ck139 = 0 time = 1400
* CHECK dout1_7 vdout1_7ck139 = 1.7 time = 1400
* CHECK dout1_8 vdout1_8ck139 = 1.7 time = 1400
* CHECK dout1_9 vdout1_9ck139 = 0 time = 1400
* CHECK dout1_10 vdout1_10ck139 = 1.7 time = 1400
* CHECK dout1_11 vdout1_11ck139 = 1.7 time = 1400
* CHECK dout1_12 vdout1_12ck139 = 0 time = 1400
* CHECK dout1_13 vdout1_13ck139 = 0 time = 1400
* CHECK dout1_14 vdout1_14ck139 = 0 time = 1400
* CHECK dout1_15 vdout1_15ck139 = 1.7 time = 1400
* CHECK dout1_16 vdout1_16ck139 = 0 time = 1400
* CHECK dout1_0 vdout1_0ck140 = 1.7 time = 1410
* CHECK dout1_1 vdout1_1ck140 = 0 time = 1410
* CHECK dout1_2 vdout1_2ck140 = 1.7 time = 1410
* CHECK dout1_3 vdout1_3ck140 = 1.7 time = 1410
* CHECK dout1_4 vdout1_4ck140 = 0 time = 1410
* CHECK dout1_5 vdout1_5ck140 = 0 time = 1410
* CHECK dout1_6 vdout1_6ck140 = 0 time = 1410
* CHECK dout1_7 vdout1_7ck140 = 1.7 time = 1410
* CHECK dout1_8 vdout1_8ck140 = 1.7 time = 1410
* CHECK dout1_9 vdout1_9ck140 = 0 time = 1410
* CHECK dout1_10 vdout1_10ck140 = 1.7 time = 1410
* CHECK dout1_11 vdout1_11ck140 = 1.7 time = 1410
* CHECK dout1_12 vdout1_12ck140 = 0 time = 1410
* CHECK dout1_13 vdout1_13ck140 = 0 time = 1410
* CHECK dout1_14 vdout1_14ck140 = 0 time = 1410
* CHECK dout1_15 vdout1_15ck140 = 1.7 time = 1410
* CHECK dout1_16 vdout1_16ck140 = 0 time = 1410
* CHECK dout1_0 vdout1_0ck142 = 0 time = 1430
* CHECK dout1_1 vdout1_1ck142 = 0 time = 1430
* CHECK dout1_2 vdout1_2ck142 = 1.7 time = 1430
* CHECK dout1_3 vdout1_3ck142 = 1.7 time = 1430
* CHECK dout1_4 vdout1_4ck142 = 0 time = 1430
* CHECK dout1_5 vdout1_5ck142 = 1.7 time = 1430
* CHECK dout1_6 vdout1_6ck142 = 0 time = 1430
* CHECK dout1_7 vdout1_7ck142 = 1.7 time = 1430
* CHECK dout1_8 vdout1_8ck142 = 0 time = 1430
* CHECK dout1_9 vdout1_9ck142 = 0 time = 1430
* CHECK dout1_10 vdout1_10ck142 = 1.7 time = 1430
* CHECK dout1_11 vdout1_11ck142 = 0 time = 1430
* CHECK dout1_12 vdout1_12ck142 = 1.7 time = 1430
* CHECK dout1_13 vdout1_13ck142 = 0 time = 1430
* CHECK dout1_14 vdout1_14ck142 = 1.7 time = 1430
* CHECK dout1_15 vdout1_15ck142 = 0 time = 1430
* CHECK dout1_16 vdout1_16ck142 = 0 time = 1430
* CHECK dout1_0 vdout1_0ck143 = 1.7 time = 1440
* CHECK dout1_1 vdout1_1ck143 = 0 time = 1440
* CHECK dout1_2 vdout1_2ck143 = 1.7 time = 1440
* CHECK dout1_3 vdout1_3ck143 = 1.7 time = 1440
* CHECK dout1_4 vdout1_4ck143 = 0 time = 1440
* CHECK dout1_5 vdout1_5ck143 = 0 time = 1440
* CHECK dout1_6 vdout1_6ck143 = 1.7 time = 1440
* CHECK dout1_7 vdout1_7ck143 = 1.7 time = 1440
* CHECK dout1_8 vdout1_8ck143 = 0 time = 1440
* CHECK dout1_9 vdout1_9ck143 = 1.7 time = 1440
* CHECK dout1_10 vdout1_10ck143 = 0 time = 1440
* CHECK dout1_11 vdout1_11ck143 = 1.7 time = 1440
* CHECK dout1_12 vdout1_12ck143 = 1.7 time = 1440
* CHECK dout1_13 vdout1_13ck143 = 0 time = 1440
* CHECK dout1_14 vdout1_14ck143 = 0 time = 1440
* CHECK dout1_15 vdout1_15ck143 = 0 time = 1440
* CHECK dout1_16 vdout1_16ck143 = 0 time = 1440
* CHECK dout1_0 vdout1_0ck146 = 1.7 time = 1470
* CHECK dout1_1 vdout1_1ck146 = 1.7 time = 1470
* CHECK dout1_2 vdout1_2ck146 = 0 time = 1470
* CHECK dout1_3 vdout1_3ck146 = 0 time = 1470
* CHECK dout1_4 vdout1_4ck146 = 1.7 time = 1470
* CHECK dout1_5 vdout1_5ck146 = 0 time = 1470
* CHECK dout1_6 vdout1_6ck146 = 1.7 time = 1470
* CHECK dout1_7 vdout1_7ck146 = 0 time = 1470
* CHECK dout1_8 vdout1_8ck146 = 1.7 time = 1470
* CHECK dout1_9 vdout1_9ck146 = 0 time = 1470
* CHECK dout1_10 vdout1_10ck146 = 1.7 time = 1470
* CHECK dout1_11 vdout1_11ck146 = 0 time = 1470
* CHECK dout1_12 vdout1_12ck146 = 1.7 time = 1470
* CHECK dout1_13 vdout1_13ck146 = 0 time = 1470
* CHECK dout1_14 vdout1_14ck146 = 0 time = 1470
* CHECK dout1_15 vdout1_15ck146 = 1.7 time = 1470
* CHECK dout1_16 vdout1_16ck146 = 0 time = 1470
* CHECK dout1_0 vdout1_0ck150 = 0 time = 1510
* CHECK dout1_1 vdout1_1ck150 = 0 time = 1510
* CHECK dout1_2 vdout1_2ck150 = 1.7 time = 1510
* CHECK dout1_3 vdout1_3ck150 = 1.7 time = 1510
* CHECK dout1_4 vdout1_4ck150 = 0 time = 1510
* CHECK dout1_5 vdout1_5ck150 = 1.7 time = 1510
* CHECK dout1_6 vdout1_6ck150 = 0 time = 1510
* CHECK dout1_7 vdout1_7ck150 = 1.7 time = 1510
* CHECK dout1_8 vdout1_8ck150 = 0 time = 1510
* CHECK dout1_9 vdout1_9ck150 = 0 time = 1510
* CHECK dout1_10 vdout1_10ck150 = 1.7 time = 1510
* CHECK dout1_11 vdout1_11ck150 = 0 time = 1510
* CHECK dout1_12 vdout1_12ck150 = 1.7 time = 1510
* CHECK dout1_13 vdout1_13ck150 = 0 time = 1510
* CHECK dout1_14 vdout1_14ck150 = 1.7 time = 1510
* CHECK dout1_15 vdout1_15ck150 = 0 time = 1510
* CHECK dout1_16 vdout1_16ck150 = 0 time = 1510
* CHECK dout1_0 vdout1_0ck151 = 0 time = 1520
* CHECK dout1_1 vdout1_1ck151 = 0 time = 1520
* CHECK dout1_2 vdout1_2ck151 = 1.7 time = 1520
* CHECK dout1_3 vdout1_3ck151 = 1.7 time = 1520
* CHECK dout1_4 vdout1_4ck151 = 0 time = 1520
* CHECK dout1_5 vdout1_5ck151 = 1.7 time = 1520
* CHECK dout1_6 vdout1_6ck151 = 0 time = 1520
* CHECK dout1_7 vdout1_7ck151 = 1.7 time = 1520
* CHECK dout1_8 vdout1_8ck151 = 0 time = 1520
* CHECK dout1_9 vdout1_9ck151 = 0 time = 1520
* CHECK dout1_10 vdout1_10ck151 = 1.7 time = 1520
* CHECK dout1_11 vdout1_11ck151 = 0 time = 1520
* CHECK dout1_12 vdout1_12ck151 = 1.7 time = 1520
* CHECK dout1_13 vdout1_13ck151 = 0 time = 1520
* CHECK dout1_14 vdout1_14ck151 = 1.7 time = 1520
* CHECK dout1_15 vdout1_15ck151 = 0 time = 1520
* CHECK dout1_16 vdout1_16ck151 = 0 time = 1520
* CHECK dout1_0 vdout1_0ck153 = 1.7 time = 1540
* CHECK dout1_1 vdout1_1ck153 = 1.7 time = 1540
* CHECK dout1_2 vdout1_2ck153 = 1.7 time = 1540
* CHECK dout1_3 vdout1_3ck153 = 0 time = 1540
* CHECK dout1_4 vdout1_4ck153 = 0 time = 1540
* CHECK dout1_5 vdout1_5ck153 = 1.7 time = 1540
* CHECK dout1_6 vdout1_6ck153 = 0 time = 1540
* CHECK dout1_7 vdout1_7ck153 = 1.7 time = 1540
* CHECK dout1_8 vdout1_8ck153 = 0 time = 1540
* CHECK dout1_9 vdout1_9ck153 = 1.7 time = 1540
* CHECK dout1_10 vdout1_10ck153 = 1.7 time = 1540
* CHECK dout1_11 vdout1_11ck153 = 0 time = 1540
* CHECK dout1_12 vdout1_12ck153 = 1.7 time = 1540
* CHECK dout1_13 vdout1_13ck153 = 1.7 time = 1540
* CHECK dout1_14 vdout1_14ck153 = 1.7 time = 1540
* CHECK dout1_15 vdout1_15ck153 = 0 time = 1540
* CHECK dout1_16 vdout1_16ck153 = 0 time = 1540
* CHECK dout1_0 vdout1_0ck160 = 0 time = 1610
* CHECK dout1_1 vdout1_1ck160 = 0 time = 1610
* CHECK dout1_2 vdout1_2ck160 = 1.7 time = 1610
* CHECK dout1_3 vdout1_3ck160 = 1.7 time = 1610
* CHECK dout1_4 vdout1_4ck160 = 0 time = 1610
* CHECK dout1_5 vdout1_5ck160 = 1.7 time = 1610
* CHECK dout1_6 vdout1_6ck160 = 0 time = 1610
* CHECK dout1_7 vdout1_7ck160 = 1.7 time = 1610
* CHECK dout1_8 vdout1_8ck160 = 0 time = 1610
* CHECK dout1_9 vdout1_9ck160 = 0 time = 1610
* CHECK dout1_10 vdout1_10ck160 = 1.7 time = 1610
* CHECK dout1_11 vdout1_11ck160 = 0 time = 1610
* CHECK dout1_12 vdout1_12ck160 = 1.7 time = 1610
* CHECK dout1_13 vdout1_13ck160 = 0 time = 1610
* CHECK dout1_14 vdout1_14ck160 = 1.7 time = 1610
* CHECK dout1_15 vdout1_15ck160 = 0 time = 1610
* CHECK dout1_16 vdout1_16ck160 = 0 time = 1610
* CHECK dout1_0 vdout1_0ck161 = 0 time = 1620
* CHECK dout1_1 vdout1_1ck161 = 1.7 time = 1620
* CHECK dout1_2 vdout1_2ck161 = 1.7 time = 1620
* CHECK dout1_3 vdout1_3ck161 = 1.7 time = 1620
* CHECK dout1_4 vdout1_4ck161 = 1.7 time = 1620
* CHECK dout1_5 vdout1_5ck161 = 0 time = 1620
* CHECK dout1_6 vdout1_6ck161 = 1.7 time = 1620
* CHECK dout1_7 vdout1_7ck161 = 0 time = 1620
* CHECK dout1_8 vdout1_8ck161 = 1.7 time = 1620
* CHECK dout1_9 vdout1_9ck161 = 0 time = 1620
* CHECK dout1_10 vdout1_10ck161 = 0 time = 1620
* CHECK dout1_11 vdout1_11ck161 = 0 time = 1620
* CHECK dout1_12 vdout1_12ck161 = 0 time = 1620
* CHECK dout1_13 vdout1_13ck161 = 1.7 time = 1620
* CHECK dout1_14 vdout1_14ck161 = 0 time = 1620
* CHECK dout1_15 vdout1_15ck161 = 0 time = 1620
* CHECK dout1_16 vdout1_16ck161 = 0 time = 1620
* CHECK dout1_0 vdout1_0ck165 = 0 time = 1660
* CHECK dout1_1 vdout1_1ck165 = 0 time = 1660
* CHECK dout1_2 vdout1_2ck165 = 0 time = 1660
* CHECK dout1_3 vdout1_3ck165 = 0 time = 1660
* CHECK dout1_4 vdout1_4ck165 = 0 time = 1660
* CHECK dout1_5 vdout1_5ck165 = 0 time = 1660
* CHECK dout1_6 vdout1_6ck165 = 1.7 time = 1660
* CHECK dout1_7 vdout1_7ck165 = 1.7 time = 1660
* CHECK dout1_8 vdout1_8ck165 = 1.7 time = 1660
* CHECK dout1_9 vdout1_9ck165 = 0 time = 1660
* CHECK dout1_10 vdout1_10ck165 = 1.7 time = 1660
* CHECK dout1_11 vdout1_11ck165 = 1.7 time = 1660
* CHECK dout1_12 vdout1_12ck165 = 0 time = 1660
* CHECK dout1_13 vdout1_13ck165 = 1.7 time = 1660
* CHECK dout1_14 vdout1_14ck165 = 0 time = 1660
* CHECK dout1_15 vdout1_15ck165 = 1.7 time = 1660
* CHECK dout1_16 vdout1_16ck165 = 0 time = 1660
* CHECK dout1_0 vdout1_0ck177 = 0 time = 1780
* CHECK dout1_1 vdout1_1ck177 = 1.7 time = 1780
* CHECK dout1_2 vdout1_2ck177 = 0 time = 1780
* CHECK dout1_3 vdout1_3ck177 = 0 time = 1780
* CHECK dout1_4 vdout1_4ck177 = 0 time = 1780
* CHECK dout1_5 vdout1_5ck177 = 1.7 time = 1780
* CHECK dout1_6 vdout1_6ck177 = 0 time = 1780
* CHECK dout1_7 vdout1_7ck177 = 1.7 time = 1780
* CHECK dout1_8 vdout1_8ck177 = 1.7 time = 1780
* CHECK dout1_9 vdout1_9ck177 = 1.7 time = 1780
* CHECK dout1_10 vdout1_10ck177 = 1.7 time = 1780
* CHECK dout1_11 vdout1_11ck177 = 0 time = 1780
* CHECK dout1_12 vdout1_12ck177 = 0 time = 1780
* CHECK dout1_13 vdout1_13ck177 = 1.7 time = 1780
* CHECK dout1_14 vdout1_14ck177 = 0 time = 1780
* CHECK dout1_15 vdout1_15ck177 = 1.7 time = 1780
* CHECK dout1_16 vdout1_16ck177 = 0 time = 1780
* CHECK dout1_0 vdout1_0ck181 = 0 time = 1820
* CHECK dout1_1 vdout1_1ck181 = 1.7 time = 1820
* CHECK dout1_2 vdout1_2ck181 = 1.7 time = 1820
* CHECK dout1_3 vdout1_3ck181 = 0 time = 1820
* CHECK dout1_4 vdout1_4ck181 = 0 time = 1820
* CHECK dout1_5 vdout1_5ck181 = 0 time = 1820
* CHECK dout1_6 vdout1_6ck181 = 0 time = 1820
* CHECK dout1_7 vdout1_7ck181 = 0 time = 1820
* CHECK dout1_8 vdout1_8ck181 = 1.7 time = 1820
* CHECK dout1_9 vdout1_9ck181 = 0 time = 1820
* CHECK dout1_10 vdout1_10ck181 = 1.7 time = 1820
* CHECK dout1_11 vdout1_11ck181 = 1.7 time = 1820
* CHECK dout1_12 vdout1_12ck181 = 0 time = 1820
* CHECK dout1_13 vdout1_13ck181 = 0 time = 1820
* CHECK dout1_14 vdout1_14ck181 = 1.7 time = 1820
* CHECK dout1_15 vdout1_15ck181 = 0 time = 1820
* CHECK dout1_16 vdout1_16ck181 = 0 time = 1820
* CHECK dout1_0 vdout1_0ck183 = 1.7 time = 1840
* CHECK dout1_1 vdout1_1ck183 = 1.7 time = 1840
* CHECK dout1_2 vdout1_2ck183 = 0 time = 1840
* CHECK dout1_3 vdout1_3ck183 = 0 time = 1840
* CHECK dout1_4 vdout1_4ck183 = 1.7 time = 1840
* CHECK dout1_5 vdout1_5ck183 = 1.7 time = 1840
* CHECK dout1_6 vdout1_6ck183 = 1.7 time = 1840
* CHECK dout1_7 vdout1_7ck183 = 1.7 time = 1840
* CHECK dout1_8 vdout1_8ck183 = 0 time = 1840
* CHECK dout1_9 vdout1_9ck183 = 1.7 time = 1840
* CHECK dout1_10 vdout1_10ck183 = 0 time = 1840
* CHECK dout1_11 vdout1_11ck183 = 1.7 time = 1840
* CHECK dout1_12 vdout1_12ck183 = 0 time = 1840
* CHECK dout1_13 vdout1_13ck183 = 1.7 time = 1840
* CHECK dout1_14 vdout1_14ck183 = 0 time = 1840
* CHECK dout1_15 vdout1_15ck183 = 1.7 time = 1840
* CHECK dout1_16 vdout1_16ck183 = 0 time = 1840
* CHECK dout1_0 vdout1_0ck186 = 1.7 time = 1870
* CHECK dout1_1 vdout1_1ck186 = 1.7 time = 1870
* CHECK dout1_2 vdout1_2ck186 = 1.7 time = 1870
* CHECK dout1_3 vdout1_3ck186 = 0 time = 1870
* CHECK dout1_4 vdout1_4ck186 = 1.7 time = 1870
* CHECK dout1_5 vdout1_5ck186 = 0 time = 1870
* CHECK dout1_6 vdout1_6ck186 = 0 time = 1870
* CHECK dout1_7 vdout1_7ck186 = 0 time = 1870
* CHECK dout1_8 vdout1_8ck186 = 1.7 time = 1870
* CHECK dout1_9 vdout1_9ck186 = 0 time = 1870
* CHECK dout1_10 vdout1_10ck186 = 1.7 time = 1870
* CHECK dout1_11 vdout1_11ck186 = 1.7 time = 1870
* CHECK dout1_12 vdout1_12ck186 = 0 time = 1870
* CHECK dout1_13 vdout1_13ck186 = 0 time = 1870
* CHECK dout1_14 vdout1_14ck186 = 0 time = 1870
* CHECK dout1_15 vdout1_15ck186 = 0 time = 1870
* CHECK dout1_16 vdout1_16ck186 = 0 time = 1870
* CHECK dout1_0 vdout1_0ck190 = 0 time = 1910
* CHECK dout1_1 vdout1_1ck190 = 0 time = 1910
* CHECK dout1_2 vdout1_2ck190 = 0 time = 1910
* CHECK dout1_3 vdout1_3ck190 = 1.7 time = 1910
* CHECK dout1_4 vdout1_4ck190 = 1.7 time = 1910
* CHECK dout1_5 vdout1_5ck190 = 1.7 time = 1910
* CHECK dout1_6 vdout1_6ck190 = 0 time = 1910
* CHECK dout1_7 vdout1_7ck190 = 1.7 time = 1910
* CHECK dout1_8 vdout1_8ck190 = 0 time = 1910
* CHECK dout1_9 vdout1_9ck190 = 1.7 time = 1910
* CHECK dout1_10 vdout1_10ck190 = 0 time = 1910
* CHECK dout1_11 vdout1_11ck190 = 0 time = 1910
* CHECK dout1_12 vdout1_12ck190 = 1.7 time = 1910
* CHECK dout1_13 vdout1_13ck190 = 1.7 time = 1910
* CHECK dout1_14 vdout1_14ck190 = 1.7 time = 1910
* CHECK dout1_15 vdout1_15ck190 = 0 time = 1910
* CHECK dout1_16 vdout1_16ck190 = 0 time = 1910
* CHECK dout1_0 vdout1_0ck192 = 1.7 time = 1930
* CHECK dout1_1 vdout1_1ck192 = 0 time = 1930
* CHECK dout1_2 vdout1_2ck192 = 0 time = 1930
* CHECK dout1_3 vdout1_3ck192 = 1.7 time = 1930
* CHECK dout1_4 vdout1_4ck192 = 1.7 time = 1930
* CHECK dout1_5 vdout1_5ck192 = 1.7 time = 1930
* CHECK dout1_6 vdout1_6ck192 = 0 time = 1930
* CHECK dout1_7 vdout1_7ck192 = 0 time = 1930
* CHECK dout1_8 vdout1_8ck192 = 1.7 time = 1930
* CHECK dout1_9 vdout1_9ck192 = 0 time = 1930
* CHECK dout1_10 vdout1_10ck192 = 0 time = 1930
* CHECK dout1_11 vdout1_11ck192 = 0 time = 1930
* CHECK dout1_12 vdout1_12ck192 = 0 time = 1930
* CHECK dout1_13 vdout1_13ck192 = 1.7 time = 1930
* CHECK dout1_14 vdout1_14ck192 = 1.7 time = 1930
* CHECK dout1_15 vdout1_15ck192 = 0 time = 1930
* CHECK dout1_16 vdout1_16ck192 = 0 time = 1930
* CHECK dout1_0 vdout1_0ck194 = 1.7 time = 1950
* CHECK dout1_1 vdout1_1ck194 = 0 time = 1950
* CHECK dout1_2 vdout1_2ck194 = 0 time = 1950
* CHECK dout1_3 vdout1_3ck194 = 1.7 time = 1950
* CHECK dout1_4 vdout1_4ck194 = 1.7 time = 1950
* CHECK dout1_5 vdout1_5ck194 = 0 time = 1950
* CHECK dout1_6 vdout1_6ck194 = 1.7 time = 1950
* CHECK dout1_7 vdout1_7ck194 = 1.7 time = 1950
* CHECK dout1_8 vdout1_8ck194 = 0 time = 1950
* CHECK dout1_9 vdout1_9ck194 = 0 time = 1950
* CHECK dout1_10 vdout1_10ck194 = 0 time = 1950
* CHECK dout1_11 vdout1_11ck194 = 1.7 time = 1950
* CHECK dout1_12 vdout1_12ck194 = 0 time = 1950
* CHECK dout1_13 vdout1_13ck194 = 0 time = 1950
* CHECK dout1_14 vdout1_14ck194 = 1.7 time = 1950
* CHECK dout1_15 vdout1_15ck194 = 0 time = 1950
* CHECK dout1_16 vdout1_16ck194 = 0 time = 1950
* CHECK dout1_0 vdout1_0ck196 = 1.7 time = 1970
* CHECK dout1_1 vdout1_1ck196 = 1.7 time = 1970
* CHECK dout1_2 vdout1_2ck196 = 0 time = 1970
* CHECK dout1_3 vdout1_3ck196 = 0 time = 1970
* CHECK dout1_4 vdout1_4ck196 = 0 time = 1970
* CHECK dout1_5 vdout1_5ck196 = 0 time = 1970
* CHECK dout1_6 vdout1_6ck196 = 1.7 time = 1970
* CHECK dout1_7 vdout1_7ck196 = 0 time = 1970
* CHECK dout1_8 vdout1_8ck196 = 1.7 time = 1970
* CHECK dout1_9 vdout1_9ck196 = 1.7 time = 1970
* CHECK dout1_10 vdout1_10ck196 = 1.7 time = 1970
* CHECK dout1_11 vdout1_11ck196 = 0 time = 1970
* CHECK dout1_12 vdout1_12ck196 = 0 time = 1970
* CHECK dout1_13 vdout1_13ck196 = 0 time = 1970
* CHECK dout1_14 vdout1_14ck196 = 0 time = 1970
* CHECK dout1_15 vdout1_15ck196 = 1.7 time = 1970
* CHECK dout1_16 vdout1_16ck196 = 0 time = 1970
* CHECK dout1_0 vdout1_0ck198 = 1.7 time = 1990
* CHECK dout1_1 vdout1_1ck198 = 0 time = 1990
* CHECK dout1_2 vdout1_2ck198 = 0 time = 1990
* CHECK dout1_3 vdout1_3ck198 = 1.7 time = 1990
* CHECK dout1_4 vdout1_4ck198 = 1.7 time = 1990
* CHECK dout1_5 vdout1_5ck198 = 0 time = 1990
* CHECK dout1_6 vdout1_6ck198 = 1.7 time = 1990
* CHECK dout1_7 vdout1_7ck198 = 1.7 time = 1990
* CHECK dout1_8 vdout1_8ck198 = 0 time = 1990
* CHECK dout1_9 vdout1_9ck198 = 0 time = 1990
* CHECK dout1_10 vdout1_10ck198 = 0 time = 1990
* CHECK dout1_11 vdout1_11ck198 = 1.7 time = 1990
* CHECK dout1_12 vdout1_12ck198 = 0 time = 1990
* CHECK dout1_13 vdout1_13ck198 = 0 time = 1990
* CHECK dout1_14 vdout1_14ck198 = 1.7 time = 1990
* CHECK dout1_15 vdout1_15ck198 = 0 time = 1990
* CHECK dout1_16 vdout1_16ck198 = 0 time = 1990
* CHECK dout1_0 vdout1_0ck201 = 1.7 time = 2020
* CHECK dout1_1 vdout1_1ck201 = 0 time = 2020
* CHECK dout1_2 vdout1_2ck201 = 0 time = 2020
* CHECK dout1_3 vdout1_3ck201 = 1.7 time = 2020
* CHECK dout1_4 vdout1_4ck201 = 1.7 time = 2020
* CHECK dout1_5 vdout1_5ck201 = 0 time = 2020
* CHECK dout1_6 vdout1_6ck201 = 1.7 time = 2020
* CHECK dout1_7 vdout1_7ck201 = 1.7 time = 2020
* CHECK dout1_8 vdout1_8ck201 = 0 time = 2020
* CHECK dout1_9 vdout1_9ck201 = 0 time = 2020
* CHECK dout1_10 vdout1_10ck201 = 0 time = 2020
* CHECK dout1_11 vdout1_11ck201 = 1.7 time = 2020
* CHECK dout1_12 vdout1_12ck201 = 0 time = 2020
* CHECK dout1_13 vdout1_13ck201 = 0 time = 2020
* CHECK dout1_14 vdout1_14ck201 = 1.7 time = 2020
* CHECK dout1_15 vdout1_15ck201 = 0 time = 2020
* CHECK dout1_16 vdout1_16ck201 = 0 time = 2020
.include /Sky130_memory/work/openram_builds/v20260612_1r1w_full/sky130_sram_512bytes_1r1w_16x256/functional_meas.sp
.TEMP 0
.TRAN 10p 2060n 0n 10p UIC
.OPTIONS POST=1 RELTOL=0.001 PROBE method=gear ACCT
* probe is used for hspice/xa, while plot is used in ngspice
*.probe V(*)
*.plot V(*)
.end
