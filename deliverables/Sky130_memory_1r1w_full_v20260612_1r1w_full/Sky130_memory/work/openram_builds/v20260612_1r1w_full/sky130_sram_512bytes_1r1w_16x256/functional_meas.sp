.meas tran vdout1_0ck40 FIND v(dout1_0) AT=50.05n

.meas tran vdout1_1ck40 FIND v(dout1_1) AT=50.05n

.meas tran vdout1_2ck40 FIND v(dout1_2) AT=50.05n

.meas tran vdout1_3ck40 FIND v(dout1_3) AT=50.05n

.meas tran vdout1_4ck40 FIND v(dout1_4) AT=50.05n

.meas tran vdout1_5ck40 FIND v(dout1_5) AT=50.05n

.meas tran vdout1_6ck40 FIND v(dout1_6) AT=50.05n

.meas tran vdout1_7ck40 FIND v(dout1_7) AT=50.05n

.meas tran vdout1_8ck40 FIND v(dout1_8) AT=50.05n

.meas tran vdout1_9ck40 FIND v(dout1_9) AT=50.05n

.meas tran vdout1_10ck40 FIND v(dout1_10) AT=50.05n

.meas tran vdout1_11ck40 FIND v(dout1_11) AT=50.05n

.meas tran vdout1_12ck40 FIND v(dout1_12) AT=50.05n

.meas tran vdout1_13ck40 FIND v(dout1_13) AT=50.05n

.meas tran vdout1_14ck40 FIND v(dout1_14) AT=50.05n

.meas tran vdout1_15ck40 FIND v(dout1_15) AT=50.05n

.meas tran vdout1_16ck40 FIND v(dout1_16) AT=50.05n

.meas tran vdout1_0ck70 FIND v(dout1_0) AT=80.05n

.meas tran vdout1_1ck70 FIND v(dout1_1) AT=80.05n

.meas tran vdout1_2ck70 FIND v(dout1_2) AT=80.05n

.meas tran vdout1_3ck70 FIND v(dout1_3) AT=80.05n

.meas tran vdout1_4ck70 FIND v(dout1_4) AT=80.05n

.meas tran vdout1_5ck70 FIND v(dout1_5) AT=80.05n

.meas tran vdout1_6ck70 FIND v(dout1_6) AT=80.05n

.meas tran vdout1_7ck70 FIND v(dout1_7) AT=80.05n

.meas tran vdout1_8ck70 FIND v(dout1_8) AT=80.05n

.meas tran vdout1_9ck70 FIND v(dout1_9) AT=80.05n

.meas tran vdout1_10ck70 FIND v(dout1_10) AT=80.05n

.meas tran vdout1_11ck70 FIND v(dout1_11) AT=80.05n

.meas tran vdout1_12ck70 FIND v(dout1_12) AT=80.05n

.meas tran vdout1_13ck70 FIND v(dout1_13) AT=80.05n

.meas tran vdout1_14ck70 FIND v(dout1_14) AT=80.05n

.meas tran vdout1_15ck70 FIND v(dout1_15) AT=80.05n

.meas tran vdout1_16ck70 FIND v(dout1_16) AT=80.05n

.meas tran vdout1_0ck100 FIND v(dout1_0) AT=110.05n

.meas tran vdout1_1ck100 FIND v(dout1_1) AT=110.05n

.meas tran vdout1_2ck100 FIND v(dout1_2) AT=110.05n

.meas tran vdout1_3ck100 FIND v(dout1_3) AT=110.05n

.meas tran vdout1_4ck100 FIND v(dout1_4) AT=110.05n

.meas tran vdout1_5ck100 FIND v(dout1_5) AT=110.05n

.meas tran vdout1_6ck100 FIND v(dout1_6) AT=110.05n

.meas tran vdout1_7ck100 FIND v(dout1_7) AT=110.05n

.meas tran vdout1_8ck100 FIND v(dout1_8) AT=110.05n

.meas tran vdout1_9ck100 FIND v(dout1_9) AT=110.05n

.meas tran vdout1_10ck100 FIND v(dout1_10) AT=110.05n

.meas tran vdout1_11ck100 FIND v(dout1_11) AT=110.05n

.meas tran vdout1_12ck100 FIND v(dout1_12) AT=110.05n

.meas tran vdout1_13ck100 FIND v(dout1_13) AT=110.05n

.meas tran vdout1_14ck100 FIND v(dout1_14) AT=110.05n

.meas tran vdout1_15ck100 FIND v(dout1_15) AT=110.05n

.meas tran vdout1_16ck100 FIND v(dout1_16) AT=110.05n

.meas tran vdout1_0ck150 FIND v(dout1_0) AT=160.05n

.meas tran vdout1_1ck150 FIND v(dout1_1) AT=160.05n

.meas tran vdout1_2ck150 FIND v(dout1_2) AT=160.05n

.meas tran vdout1_3ck150 FIND v(dout1_3) AT=160.05n

.meas tran vdout1_4ck150 FIND v(dout1_4) AT=160.05n

.meas tran vdout1_5ck150 FIND v(dout1_5) AT=160.05n

.meas tran vdout1_6ck150 FIND v(dout1_6) AT=160.05n

.meas tran vdout1_7ck150 FIND v(dout1_7) AT=160.05n

.meas tran vdout1_8ck150 FIND v(dout1_8) AT=160.05n

.meas tran vdout1_9ck150 FIND v(dout1_9) AT=160.05n

.meas tran vdout1_10ck150 FIND v(dout1_10) AT=160.05n

.meas tran vdout1_11ck150 FIND v(dout1_11) AT=160.05n

.meas tran vdout1_12ck150 FIND v(dout1_12) AT=160.05n

.meas tran vdout1_13ck150 FIND v(dout1_13) AT=160.05n

.meas tran vdout1_14ck150 FIND v(dout1_14) AT=160.05n

.meas tran vdout1_15ck150 FIND v(dout1_15) AT=160.05n

.meas tran vdout1_16ck150 FIND v(dout1_16) AT=160.05n

.meas tran vdout1_0ck170 FIND v(dout1_0) AT=180.05n

.meas tran vdout1_1ck170 FIND v(dout1_1) AT=180.05n

.meas tran vdout1_2ck170 FIND v(dout1_2) AT=180.05n

.meas tran vdout1_3ck170 FIND v(dout1_3) AT=180.05n

.meas tran vdout1_4ck170 FIND v(dout1_4) AT=180.05n

.meas tran vdout1_5ck170 FIND v(dout1_5) AT=180.05n

.meas tran vdout1_6ck170 FIND v(dout1_6) AT=180.05n

.meas tran vdout1_7ck170 FIND v(dout1_7) AT=180.05n

.meas tran vdout1_8ck170 FIND v(dout1_8) AT=180.05n

.meas tran vdout1_9ck170 FIND v(dout1_9) AT=180.05n

.meas tran vdout1_10ck170 FIND v(dout1_10) AT=180.05n

.meas tran vdout1_11ck170 FIND v(dout1_11) AT=180.05n

.meas tran vdout1_12ck170 FIND v(dout1_12) AT=180.05n

.meas tran vdout1_13ck170 FIND v(dout1_13) AT=180.05n

.meas tran vdout1_14ck170 FIND v(dout1_14) AT=180.05n

.meas tran vdout1_15ck170 FIND v(dout1_15) AT=180.05n

.meas tran vdout1_16ck170 FIND v(dout1_16) AT=180.05n

.meas tran vdout1_0ck180 FIND v(dout1_0) AT=190.05n

.meas tran vdout1_1ck180 FIND v(dout1_1) AT=190.05n

.meas tran vdout1_2ck180 FIND v(dout1_2) AT=190.05n

.meas tran vdout1_3ck180 FIND v(dout1_3) AT=190.05n

.meas tran vdout1_4ck180 FIND v(dout1_4) AT=190.05n

.meas tran vdout1_5ck180 FIND v(dout1_5) AT=190.05n

.meas tran vdout1_6ck180 FIND v(dout1_6) AT=190.05n

.meas tran vdout1_7ck180 FIND v(dout1_7) AT=190.05n

.meas tran vdout1_8ck180 FIND v(dout1_8) AT=190.05n

.meas tran vdout1_9ck180 FIND v(dout1_9) AT=190.05n

.meas tran vdout1_10ck180 FIND v(dout1_10) AT=190.05n

.meas tran vdout1_11ck180 FIND v(dout1_11) AT=190.05n

.meas tran vdout1_12ck180 FIND v(dout1_12) AT=190.05n

.meas tran vdout1_13ck180 FIND v(dout1_13) AT=190.05n

.meas tran vdout1_14ck180 FIND v(dout1_14) AT=190.05n

.meas tran vdout1_15ck180 FIND v(dout1_15) AT=190.05n

.meas tran vdout1_16ck180 FIND v(dout1_16) AT=190.05n

.meas tran vdout1_0ck250 FIND v(dout1_0) AT=260.05n

.meas tran vdout1_1ck250 FIND v(dout1_1) AT=260.05n

.meas tran vdout1_2ck250 FIND v(dout1_2) AT=260.05n

.meas tran vdout1_3ck250 FIND v(dout1_3) AT=260.05n

.meas tran vdout1_4ck250 FIND v(dout1_4) AT=260.05n

.meas tran vdout1_5ck250 FIND v(dout1_5) AT=260.05n

.meas tran vdout1_6ck250 FIND v(dout1_6) AT=260.05n

.meas tran vdout1_7ck250 FIND v(dout1_7) AT=260.05n

.meas tran vdout1_8ck250 FIND v(dout1_8) AT=260.05n

.meas tran vdout1_9ck250 FIND v(dout1_9) AT=260.05n

.meas tran vdout1_10ck250 FIND v(dout1_10) AT=260.05n

.meas tran vdout1_11ck250 FIND v(dout1_11) AT=260.05n

.meas tran vdout1_12ck250 FIND v(dout1_12) AT=260.05n

.meas tran vdout1_13ck250 FIND v(dout1_13) AT=260.05n

.meas tran vdout1_14ck250 FIND v(dout1_14) AT=260.05n

.meas tran vdout1_15ck250 FIND v(dout1_15) AT=260.05n

.meas tran vdout1_16ck250 FIND v(dout1_16) AT=260.05n

.meas tran vdout1_0ck270 FIND v(dout1_0) AT=280.05n

.meas tran vdout1_1ck270 FIND v(dout1_1) AT=280.05n

.meas tran vdout1_2ck270 FIND v(dout1_2) AT=280.05n

.meas tran vdout1_3ck270 FIND v(dout1_3) AT=280.05n

.meas tran vdout1_4ck270 FIND v(dout1_4) AT=280.05n

.meas tran vdout1_5ck270 FIND v(dout1_5) AT=280.05n

.meas tran vdout1_6ck270 FIND v(dout1_6) AT=280.05n

.meas tran vdout1_7ck270 FIND v(dout1_7) AT=280.05n

.meas tran vdout1_8ck270 FIND v(dout1_8) AT=280.05n

.meas tran vdout1_9ck270 FIND v(dout1_9) AT=280.05n

.meas tran vdout1_10ck270 FIND v(dout1_10) AT=280.05n

.meas tran vdout1_11ck270 FIND v(dout1_11) AT=280.05n

.meas tran vdout1_12ck270 FIND v(dout1_12) AT=280.05n

.meas tran vdout1_13ck270 FIND v(dout1_13) AT=280.05n

.meas tran vdout1_14ck270 FIND v(dout1_14) AT=280.05n

.meas tran vdout1_15ck270 FIND v(dout1_15) AT=280.05n

.meas tran vdout1_16ck270 FIND v(dout1_16) AT=280.05n

.meas tran vdout1_0ck280 FIND v(dout1_0) AT=290.05n

.meas tran vdout1_1ck280 FIND v(dout1_1) AT=290.05n

.meas tran vdout1_2ck280 FIND v(dout1_2) AT=290.05n

.meas tran vdout1_3ck280 FIND v(dout1_3) AT=290.05n

.meas tran vdout1_4ck280 FIND v(dout1_4) AT=290.05n

.meas tran vdout1_5ck280 FIND v(dout1_5) AT=290.05n

.meas tran vdout1_6ck280 FIND v(dout1_6) AT=290.05n

.meas tran vdout1_7ck280 FIND v(dout1_7) AT=290.05n

.meas tran vdout1_8ck280 FIND v(dout1_8) AT=290.05n

.meas tran vdout1_9ck280 FIND v(dout1_9) AT=290.05n

.meas tran vdout1_10ck280 FIND v(dout1_10) AT=290.05n

.meas tran vdout1_11ck280 FIND v(dout1_11) AT=290.05n

.meas tran vdout1_12ck280 FIND v(dout1_12) AT=290.05n

.meas tran vdout1_13ck280 FIND v(dout1_13) AT=290.05n

.meas tran vdout1_14ck280 FIND v(dout1_14) AT=290.05n

.meas tran vdout1_15ck280 FIND v(dout1_15) AT=290.05n

.meas tran vdout1_16ck280 FIND v(dout1_16) AT=290.05n

.meas tran vdout1_0ck290 FIND v(dout1_0) AT=300.05n

.meas tran vdout1_1ck290 FIND v(dout1_1) AT=300.05n

.meas tran vdout1_2ck290 FIND v(dout1_2) AT=300.05n

.meas tran vdout1_3ck290 FIND v(dout1_3) AT=300.05n

.meas tran vdout1_4ck290 FIND v(dout1_4) AT=300.05n

.meas tran vdout1_5ck290 FIND v(dout1_5) AT=300.05n

.meas tran vdout1_6ck290 FIND v(dout1_6) AT=300.05n

.meas tran vdout1_7ck290 FIND v(dout1_7) AT=300.05n

.meas tran vdout1_8ck290 FIND v(dout1_8) AT=300.05n

.meas tran vdout1_9ck290 FIND v(dout1_9) AT=300.05n

.meas tran vdout1_10ck290 FIND v(dout1_10) AT=300.05n

.meas tran vdout1_11ck290 FIND v(dout1_11) AT=300.05n

.meas tran vdout1_12ck290 FIND v(dout1_12) AT=300.05n

.meas tran vdout1_13ck290 FIND v(dout1_13) AT=300.05n

.meas tran vdout1_14ck290 FIND v(dout1_14) AT=300.05n

.meas tran vdout1_15ck290 FIND v(dout1_15) AT=300.05n

.meas tran vdout1_16ck290 FIND v(dout1_16) AT=300.05n

.meas tran vdout1_0ck300 FIND v(dout1_0) AT=310.05n

.meas tran vdout1_1ck300 FIND v(dout1_1) AT=310.05n

.meas tran vdout1_2ck300 FIND v(dout1_2) AT=310.05n

.meas tran vdout1_3ck300 FIND v(dout1_3) AT=310.05n

.meas tran vdout1_4ck300 FIND v(dout1_4) AT=310.05n

.meas tran vdout1_5ck300 FIND v(dout1_5) AT=310.05n

.meas tran vdout1_6ck300 FIND v(dout1_6) AT=310.05n

.meas tran vdout1_7ck300 FIND v(dout1_7) AT=310.05n

.meas tran vdout1_8ck300 FIND v(dout1_8) AT=310.05n

.meas tran vdout1_9ck300 FIND v(dout1_9) AT=310.05n

.meas tran vdout1_10ck300 FIND v(dout1_10) AT=310.05n

.meas tran vdout1_11ck300 FIND v(dout1_11) AT=310.05n

.meas tran vdout1_12ck300 FIND v(dout1_12) AT=310.05n

.meas tran vdout1_13ck300 FIND v(dout1_13) AT=310.05n

.meas tran vdout1_14ck300 FIND v(dout1_14) AT=310.05n

.meas tran vdout1_15ck300 FIND v(dout1_15) AT=310.05n

.meas tran vdout1_16ck300 FIND v(dout1_16) AT=310.05n

.meas tran vdout1_0ck340 FIND v(dout1_0) AT=350.05n

.meas tran vdout1_1ck340 FIND v(dout1_1) AT=350.05n

.meas tran vdout1_2ck340 FIND v(dout1_2) AT=350.05n

.meas tran vdout1_3ck340 FIND v(dout1_3) AT=350.05n

.meas tran vdout1_4ck340 FIND v(dout1_4) AT=350.05n

.meas tran vdout1_5ck340 FIND v(dout1_5) AT=350.05n

.meas tran vdout1_6ck340 FIND v(dout1_6) AT=350.05n

.meas tran vdout1_7ck340 FIND v(dout1_7) AT=350.05n

.meas tran vdout1_8ck340 FIND v(dout1_8) AT=350.05n

.meas tran vdout1_9ck340 FIND v(dout1_9) AT=350.05n

.meas tran vdout1_10ck340 FIND v(dout1_10) AT=350.05n

.meas tran vdout1_11ck340 FIND v(dout1_11) AT=350.05n

.meas tran vdout1_12ck340 FIND v(dout1_12) AT=350.05n

.meas tran vdout1_13ck340 FIND v(dout1_13) AT=350.05n

.meas tran vdout1_14ck340 FIND v(dout1_14) AT=350.05n

.meas tran vdout1_15ck340 FIND v(dout1_15) AT=350.05n

.meas tran vdout1_16ck340 FIND v(dout1_16) AT=350.05n

.meas tran vdout1_0ck350 FIND v(dout1_0) AT=360.05n

.meas tran vdout1_1ck350 FIND v(dout1_1) AT=360.05n

.meas tran vdout1_2ck350 FIND v(dout1_2) AT=360.05n

.meas tran vdout1_3ck350 FIND v(dout1_3) AT=360.05n

.meas tran vdout1_4ck350 FIND v(dout1_4) AT=360.05n

.meas tran vdout1_5ck350 FIND v(dout1_5) AT=360.05n

.meas tran vdout1_6ck350 FIND v(dout1_6) AT=360.05n

.meas tran vdout1_7ck350 FIND v(dout1_7) AT=360.05n

.meas tran vdout1_8ck350 FIND v(dout1_8) AT=360.05n

.meas tran vdout1_9ck350 FIND v(dout1_9) AT=360.05n

.meas tran vdout1_10ck350 FIND v(dout1_10) AT=360.05n

.meas tran vdout1_11ck350 FIND v(dout1_11) AT=360.05n

.meas tran vdout1_12ck350 FIND v(dout1_12) AT=360.05n

.meas tran vdout1_13ck350 FIND v(dout1_13) AT=360.05n

.meas tran vdout1_14ck350 FIND v(dout1_14) AT=360.05n

.meas tran vdout1_15ck350 FIND v(dout1_15) AT=360.05n

.meas tran vdout1_16ck350 FIND v(dout1_16) AT=360.05n

.meas tran vdout1_0ck360 FIND v(dout1_0) AT=370.05n

.meas tran vdout1_1ck360 FIND v(dout1_1) AT=370.05n

.meas tran vdout1_2ck360 FIND v(dout1_2) AT=370.05n

.meas tran vdout1_3ck360 FIND v(dout1_3) AT=370.05n

.meas tran vdout1_4ck360 FIND v(dout1_4) AT=370.05n

.meas tran vdout1_5ck360 FIND v(dout1_5) AT=370.05n

.meas tran vdout1_6ck360 FIND v(dout1_6) AT=370.05n

.meas tran vdout1_7ck360 FIND v(dout1_7) AT=370.05n

.meas tran vdout1_8ck360 FIND v(dout1_8) AT=370.05n

.meas tran vdout1_9ck360 FIND v(dout1_9) AT=370.05n

.meas tran vdout1_10ck360 FIND v(dout1_10) AT=370.05n

.meas tran vdout1_11ck360 FIND v(dout1_11) AT=370.05n

.meas tran vdout1_12ck360 FIND v(dout1_12) AT=370.05n

.meas tran vdout1_13ck360 FIND v(dout1_13) AT=370.05n

.meas tran vdout1_14ck360 FIND v(dout1_14) AT=370.05n

.meas tran vdout1_15ck360 FIND v(dout1_15) AT=370.05n

.meas tran vdout1_16ck360 FIND v(dout1_16) AT=370.05n

.meas tran vdout1_0ck370 FIND v(dout1_0) AT=380.05n

.meas tran vdout1_1ck370 FIND v(dout1_1) AT=380.05n

.meas tran vdout1_2ck370 FIND v(dout1_2) AT=380.05n

.meas tran vdout1_3ck370 FIND v(dout1_3) AT=380.05n

.meas tran vdout1_4ck370 FIND v(dout1_4) AT=380.05n

.meas tran vdout1_5ck370 FIND v(dout1_5) AT=380.05n

.meas tran vdout1_6ck370 FIND v(dout1_6) AT=380.05n

.meas tran vdout1_7ck370 FIND v(dout1_7) AT=380.05n

.meas tran vdout1_8ck370 FIND v(dout1_8) AT=380.05n

.meas tran vdout1_9ck370 FIND v(dout1_9) AT=380.05n

.meas tran vdout1_10ck370 FIND v(dout1_10) AT=380.05n

.meas tran vdout1_11ck370 FIND v(dout1_11) AT=380.05n

.meas tran vdout1_12ck370 FIND v(dout1_12) AT=380.05n

.meas tran vdout1_13ck370 FIND v(dout1_13) AT=380.05n

.meas tran vdout1_14ck370 FIND v(dout1_14) AT=380.05n

.meas tran vdout1_15ck370 FIND v(dout1_15) AT=380.05n

.meas tran vdout1_16ck370 FIND v(dout1_16) AT=380.05n

.meas tran vdout1_0ck380 FIND v(dout1_0) AT=390.05n

.meas tran vdout1_1ck380 FIND v(dout1_1) AT=390.05n

.meas tran vdout1_2ck380 FIND v(dout1_2) AT=390.05n

.meas tran vdout1_3ck380 FIND v(dout1_3) AT=390.05n

.meas tran vdout1_4ck380 FIND v(dout1_4) AT=390.05n

.meas tran vdout1_5ck380 FIND v(dout1_5) AT=390.05n

.meas tran vdout1_6ck380 FIND v(dout1_6) AT=390.05n

.meas tran vdout1_7ck380 FIND v(dout1_7) AT=390.05n

.meas tran vdout1_8ck380 FIND v(dout1_8) AT=390.05n

.meas tran vdout1_9ck380 FIND v(dout1_9) AT=390.05n

.meas tran vdout1_10ck380 FIND v(dout1_10) AT=390.05n

.meas tran vdout1_11ck380 FIND v(dout1_11) AT=390.05n

.meas tran vdout1_12ck380 FIND v(dout1_12) AT=390.05n

.meas tran vdout1_13ck380 FIND v(dout1_13) AT=390.05n

.meas tran vdout1_14ck380 FIND v(dout1_14) AT=390.05n

.meas tran vdout1_15ck380 FIND v(dout1_15) AT=390.05n

.meas tran vdout1_16ck380 FIND v(dout1_16) AT=390.05n

.meas tran vdout1_0ck410 FIND v(dout1_0) AT=420.05n

.meas tran vdout1_1ck410 FIND v(dout1_1) AT=420.05n

.meas tran vdout1_2ck410 FIND v(dout1_2) AT=420.05n

.meas tran vdout1_3ck410 FIND v(dout1_3) AT=420.05n

.meas tran vdout1_4ck410 FIND v(dout1_4) AT=420.05n

.meas tran vdout1_5ck410 FIND v(dout1_5) AT=420.05n

.meas tran vdout1_6ck410 FIND v(dout1_6) AT=420.05n

.meas tran vdout1_7ck410 FIND v(dout1_7) AT=420.05n

.meas tran vdout1_8ck410 FIND v(dout1_8) AT=420.05n

.meas tran vdout1_9ck410 FIND v(dout1_9) AT=420.05n

.meas tran vdout1_10ck410 FIND v(dout1_10) AT=420.05n

.meas tran vdout1_11ck410 FIND v(dout1_11) AT=420.05n

.meas tran vdout1_12ck410 FIND v(dout1_12) AT=420.05n

.meas tran vdout1_13ck410 FIND v(dout1_13) AT=420.05n

.meas tran vdout1_14ck410 FIND v(dout1_14) AT=420.05n

.meas tran vdout1_15ck410 FIND v(dout1_15) AT=420.05n

.meas tran vdout1_16ck410 FIND v(dout1_16) AT=420.05n

.meas tran vdout1_0ck430 FIND v(dout1_0) AT=440.05n

.meas tran vdout1_1ck430 FIND v(dout1_1) AT=440.05n

.meas tran vdout1_2ck430 FIND v(dout1_2) AT=440.05n

.meas tran vdout1_3ck430 FIND v(dout1_3) AT=440.05n

.meas tran vdout1_4ck430 FIND v(dout1_4) AT=440.05n

.meas tran vdout1_5ck430 FIND v(dout1_5) AT=440.05n

.meas tran vdout1_6ck430 FIND v(dout1_6) AT=440.05n

.meas tran vdout1_7ck430 FIND v(dout1_7) AT=440.05n

.meas tran vdout1_8ck430 FIND v(dout1_8) AT=440.05n

.meas tran vdout1_9ck430 FIND v(dout1_9) AT=440.05n

.meas tran vdout1_10ck430 FIND v(dout1_10) AT=440.05n

.meas tran vdout1_11ck430 FIND v(dout1_11) AT=440.05n

.meas tran vdout1_12ck430 FIND v(dout1_12) AT=440.05n

.meas tran vdout1_13ck430 FIND v(dout1_13) AT=440.05n

.meas tran vdout1_14ck430 FIND v(dout1_14) AT=440.05n

.meas tran vdout1_15ck430 FIND v(dout1_15) AT=440.05n

.meas tran vdout1_16ck430 FIND v(dout1_16) AT=440.05n

.meas tran vdout1_0ck480 FIND v(dout1_0) AT=490.05n

.meas tran vdout1_1ck480 FIND v(dout1_1) AT=490.05n

.meas tran vdout1_2ck480 FIND v(dout1_2) AT=490.05n

.meas tran vdout1_3ck480 FIND v(dout1_3) AT=490.05n

.meas tran vdout1_4ck480 FIND v(dout1_4) AT=490.05n

.meas tran vdout1_5ck480 FIND v(dout1_5) AT=490.05n

.meas tran vdout1_6ck480 FIND v(dout1_6) AT=490.05n

.meas tran vdout1_7ck480 FIND v(dout1_7) AT=490.05n

.meas tran vdout1_8ck480 FIND v(dout1_8) AT=490.05n

.meas tran vdout1_9ck480 FIND v(dout1_9) AT=490.05n

.meas tran vdout1_10ck480 FIND v(dout1_10) AT=490.05n

.meas tran vdout1_11ck480 FIND v(dout1_11) AT=490.05n

.meas tran vdout1_12ck480 FIND v(dout1_12) AT=490.05n

.meas tran vdout1_13ck480 FIND v(dout1_13) AT=490.05n

.meas tran vdout1_14ck480 FIND v(dout1_14) AT=490.05n

.meas tran vdout1_15ck480 FIND v(dout1_15) AT=490.05n

.meas tran vdout1_16ck480 FIND v(dout1_16) AT=490.05n

.meas tran vdout1_0ck490 FIND v(dout1_0) AT=500.05n

.meas tran vdout1_1ck490 FIND v(dout1_1) AT=500.05n

.meas tran vdout1_2ck490 FIND v(dout1_2) AT=500.05n

.meas tran vdout1_3ck490 FIND v(dout1_3) AT=500.05n

.meas tran vdout1_4ck490 FIND v(dout1_4) AT=500.05n

.meas tran vdout1_5ck490 FIND v(dout1_5) AT=500.05n

.meas tran vdout1_6ck490 FIND v(dout1_6) AT=500.05n

.meas tran vdout1_7ck490 FIND v(dout1_7) AT=500.05n

.meas tran vdout1_8ck490 FIND v(dout1_8) AT=500.05n

.meas tran vdout1_9ck490 FIND v(dout1_9) AT=500.05n

.meas tran vdout1_10ck490 FIND v(dout1_10) AT=500.05n

.meas tran vdout1_11ck490 FIND v(dout1_11) AT=500.05n

.meas tran vdout1_12ck490 FIND v(dout1_12) AT=500.05n

.meas tran vdout1_13ck490 FIND v(dout1_13) AT=500.05n

.meas tran vdout1_14ck490 FIND v(dout1_14) AT=500.05n

.meas tran vdout1_15ck490 FIND v(dout1_15) AT=500.05n

.meas tran vdout1_16ck490 FIND v(dout1_16) AT=500.05n

.meas tran vdout1_0ck510 FIND v(dout1_0) AT=520.05n

.meas tran vdout1_1ck510 FIND v(dout1_1) AT=520.05n

.meas tran vdout1_2ck510 FIND v(dout1_2) AT=520.05n

.meas tran vdout1_3ck510 FIND v(dout1_3) AT=520.05n

.meas tran vdout1_4ck510 FIND v(dout1_4) AT=520.05n

.meas tran vdout1_5ck510 FIND v(dout1_5) AT=520.05n

.meas tran vdout1_6ck510 FIND v(dout1_6) AT=520.05n

.meas tran vdout1_7ck510 FIND v(dout1_7) AT=520.05n

.meas tran vdout1_8ck510 FIND v(dout1_8) AT=520.05n

.meas tran vdout1_9ck510 FIND v(dout1_9) AT=520.05n

.meas tran vdout1_10ck510 FIND v(dout1_10) AT=520.05n

.meas tran vdout1_11ck510 FIND v(dout1_11) AT=520.05n

.meas tran vdout1_12ck510 FIND v(dout1_12) AT=520.05n

.meas tran vdout1_13ck510 FIND v(dout1_13) AT=520.05n

.meas tran vdout1_14ck510 FIND v(dout1_14) AT=520.05n

.meas tran vdout1_15ck510 FIND v(dout1_15) AT=520.05n

.meas tran vdout1_16ck510 FIND v(dout1_16) AT=520.05n

.meas tran vdout1_0ck540 FIND v(dout1_0) AT=550.05n

.meas tran vdout1_1ck540 FIND v(dout1_1) AT=550.05n

.meas tran vdout1_2ck540 FIND v(dout1_2) AT=550.05n

.meas tran vdout1_3ck540 FIND v(dout1_3) AT=550.05n

.meas tran vdout1_4ck540 FIND v(dout1_4) AT=550.05n

.meas tran vdout1_5ck540 FIND v(dout1_5) AT=550.05n

.meas tran vdout1_6ck540 FIND v(dout1_6) AT=550.05n

.meas tran vdout1_7ck540 FIND v(dout1_7) AT=550.05n

.meas tran vdout1_8ck540 FIND v(dout1_8) AT=550.05n

.meas tran vdout1_9ck540 FIND v(dout1_9) AT=550.05n

.meas tran vdout1_10ck540 FIND v(dout1_10) AT=550.05n

.meas tran vdout1_11ck540 FIND v(dout1_11) AT=550.05n

.meas tran vdout1_12ck540 FIND v(dout1_12) AT=550.05n

.meas tran vdout1_13ck540 FIND v(dout1_13) AT=550.05n

.meas tran vdout1_14ck540 FIND v(dout1_14) AT=550.05n

.meas tran vdout1_15ck540 FIND v(dout1_15) AT=550.05n

.meas tran vdout1_16ck540 FIND v(dout1_16) AT=550.05n

.meas tran vdout1_0ck560 FIND v(dout1_0) AT=570.05n

.meas tran vdout1_1ck560 FIND v(dout1_1) AT=570.05n

.meas tran vdout1_2ck560 FIND v(dout1_2) AT=570.05n

.meas tran vdout1_3ck560 FIND v(dout1_3) AT=570.05n

.meas tran vdout1_4ck560 FIND v(dout1_4) AT=570.05n

.meas tran vdout1_5ck560 FIND v(dout1_5) AT=570.05n

.meas tran vdout1_6ck560 FIND v(dout1_6) AT=570.05n

.meas tran vdout1_7ck560 FIND v(dout1_7) AT=570.05n

.meas tran vdout1_8ck560 FIND v(dout1_8) AT=570.05n

.meas tran vdout1_9ck560 FIND v(dout1_9) AT=570.05n

.meas tran vdout1_10ck560 FIND v(dout1_10) AT=570.05n

.meas tran vdout1_11ck560 FIND v(dout1_11) AT=570.05n

.meas tran vdout1_12ck560 FIND v(dout1_12) AT=570.05n

.meas tran vdout1_13ck560 FIND v(dout1_13) AT=570.05n

.meas tran vdout1_14ck560 FIND v(dout1_14) AT=570.05n

.meas tran vdout1_15ck560 FIND v(dout1_15) AT=570.05n

.meas tran vdout1_16ck560 FIND v(dout1_16) AT=570.05n

.meas tran vdout1_0ck580 FIND v(dout1_0) AT=590.05n

.meas tran vdout1_1ck580 FIND v(dout1_1) AT=590.05n

.meas tran vdout1_2ck580 FIND v(dout1_2) AT=590.05n

.meas tran vdout1_3ck580 FIND v(dout1_3) AT=590.05n

.meas tran vdout1_4ck580 FIND v(dout1_4) AT=590.05n

.meas tran vdout1_5ck580 FIND v(dout1_5) AT=590.05n

.meas tran vdout1_6ck580 FIND v(dout1_6) AT=590.05n

.meas tran vdout1_7ck580 FIND v(dout1_7) AT=590.05n

.meas tran vdout1_8ck580 FIND v(dout1_8) AT=590.05n

.meas tran vdout1_9ck580 FIND v(dout1_9) AT=590.05n

.meas tran vdout1_10ck580 FIND v(dout1_10) AT=590.05n

.meas tran vdout1_11ck580 FIND v(dout1_11) AT=590.05n

.meas tran vdout1_12ck580 FIND v(dout1_12) AT=590.05n

.meas tran vdout1_13ck580 FIND v(dout1_13) AT=590.05n

.meas tran vdout1_14ck580 FIND v(dout1_14) AT=590.05n

.meas tran vdout1_15ck580 FIND v(dout1_15) AT=590.05n

.meas tran vdout1_16ck580 FIND v(dout1_16) AT=590.05n

.meas tran vdout1_0ck590 FIND v(dout1_0) AT=600.05n

.meas tran vdout1_1ck590 FIND v(dout1_1) AT=600.05n

.meas tran vdout1_2ck590 FIND v(dout1_2) AT=600.05n

.meas tran vdout1_3ck590 FIND v(dout1_3) AT=600.05n

.meas tran vdout1_4ck590 FIND v(dout1_4) AT=600.05n

.meas tran vdout1_5ck590 FIND v(dout1_5) AT=600.05n

.meas tran vdout1_6ck590 FIND v(dout1_6) AT=600.05n

.meas tran vdout1_7ck590 FIND v(dout1_7) AT=600.05n

.meas tran vdout1_8ck590 FIND v(dout1_8) AT=600.05n

.meas tran vdout1_9ck590 FIND v(dout1_9) AT=600.05n

.meas tran vdout1_10ck590 FIND v(dout1_10) AT=600.05n

.meas tran vdout1_11ck590 FIND v(dout1_11) AT=600.05n

.meas tran vdout1_12ck590 FIND v(dout1_12) AT=600.05n

.meas tran vdout1_13ck590 FIND v(dout1_13) AT=600.05n

.meas tran vdout1_14ck590 FIND v(dout1_14) AT=600.05n

.meas tran vdout1_15ck590 FIND v(dout1_15) AT=600.05n

.meas tran vdout1_16ck590 FIND v(dout1_16) AT=600.05n

.meas tran vdout1_0ck600 FIND v(dout1_0) AT=610.05n

.meas tran vdout1_1ck600 FIND v(dout1_1) AT=610.05n

.meas tran vdout1_2ck600 FIND v(dout1_2) AT=610.05n

.meas tran vdout1_3ck600 FIND v(dout1_3) AT=610.05n

.meas tran vdout1_4ck600 FIND v(dout1_4) AT=610.05n

.meas tran vdout1_5ck600 FIND v(dout1_5) AT=610.05n

.meas tran vdout1_6ck600 FIND v(dout1_6) AT=610.05n

.meas tran vdout1_7ck600 FIND v(dout1_7) AT=610.05n

.meas tran vdout1_8ck600 FIND v(dout1_8) AT=610.05n

.meas tran vdout1_9ck600 FIND v(dout1_9) AT=610.05n

.meas tran vdout1_10ck600 FIND v(dout1_10) AT=610.05n

.meas tran vdout1_11ck600 FIND v(dout1_11) AT=610.05n

.meas tran vdout1_12ck600 FIND v(dout1_12) AT=610.05n

.meas tran vdout1_13ck600 FIND v(dout1_13) AT=610.05n

.meas tran vdout1_14ck600 FIND v(dout1_14) AT=610.05n

.meas tran vdout1_15ck600 FIND v(dout1_15) AT=610.05n

.meas tran vdout1_16ck600 FIND v(dout1_16) AT=610.05n

.meas tran vdout1_0ck620 FIND v(dout1_0) AT=630.05n

.meas tran vdout1_1ck620 FIND v(dout1_1) AT=630.05n

.meas tran vdout1_2ck620 FIND v(dout1_2) AT=630.05n

.meas tran vdout1_3ck620 FIND v(dout1_3) AT=630.05n

.meas tran vdout1_4ck620 FIND v(dout1_4) AT=630.05n

.meas tran vdout1_5ck620 FIND v(dout1_5) AT=630.05n

.meas tran vdout1_6ck620 FIND v(dout1_6) AT=630.05n

.meas tran vdout1_7ck620 FIND v(dout1_7) AT=630.05n

.meas tran vdout1_8ck620 FIND v(dout1_8) AT=630.05n

.meas tran vdout1_9ck620 FIND v(dout1_9) AT=630.05n

.meas tran vdout1_10ck620 FIND v(dout1_10) AT=630.05n

.meas tran vdout1_11ck620 FIND v(dout1_11) AT=630.05n

.meas tran vdout1_12ck620 FIND v(dout1_12) AT=630.05n

.meas tran vdout1_13ck620 FIND v(dout1_13) AT=630.05n

.meas tran vdout1_14ck620 FIND v(dout1_14) AT=630.05n

.meas tran vdout1_15ck620 FIND v(dout1_15) AT=630.05n

.meas tran vdout1_16ck620 FIND v(dout1_16) AT=630.05n

.meas tran vdout1_0ck650 FIND v(dout1_0) AT=660.05n

.meas tran vdout1_1ck650 FIND v(dout1_1) AT=660.05n

.meas tran vdout1_2ck650 FIND v(dout1_2) AT=660.05n

.meas tran vdout1_3ck650 FIND v(dout1_3) AT=660.05n

.meas tran vdout1_4ck650 FIND v(dout1_4) AT=660.05n

.meas tran vdout1_5ck650 FIND v(dout1_5) AT=660.05n

.meas tran vdout1_6ck650 FIND v(dout1_6) AT=660.05n

.meas tran vdout1_7ck650 FIND v(dout1_7) AT=660.05n

.meas tran vdout1_8ck650 FIND v(dout1_8) AT=660.05n

.meas tran vdout1_9ck650 FIND v(dout1_9) AT=660.05n

.meas tran vdout1_10ck650 FIND v(dout1_10) AT=660.05n

.meas tran vdout1_11ck650 FIND v(dout1_11) AT=660.05n

.meas tran vdout1_12ck650 FIND v(dout1_12) AT=660.05n

.meas tran vdout1_13ck650 FIND v(dout1_13) AT=660.05n

.meas tran vdout1_14ck650 FIND v(dout1_14) AT=660.05n

.meas tran vdout1_15ck650 FIND v(dout1_15) AT=660.05n

.meas tran vdout1_16ck650 FIND v(dout1_16) AT=660.05n

.meas tran vdout1_0ck660 FIND v(dout1_0) AT=670.05n

.meas tran vdout1_1ck660 FIND v(dout1_1) AT=670.05n

.meas tran vdout1_2ck660 FIND v(dout1_2) AT=670.05n

.meas tran vdout1_3ck660 FIND v(dout1_3) AT=670.05n

.meas tran vdout1_4ck660 FIND v(dout1_4) AT=670.05n

.meas tran vdout1_5ck660 FIND v(dout1_5) AT=670.05n

.meas tran vdout1_6ck660 FIND v(dout1_6) AT=670.05n

.meas tran vdout1_7ck660 FIND v(dout1_7) AT=670.05n

.meas tran vdout1_8ck660 FIND v(dout1_8) AT=670.05n

.meas tran vdout1_9ck660 FIND v(dout1_9) AT=670.05n

.meas tran vdout1_10ck660 FIND v(dout1_10) AT=670.05n

.meas tran vdout1_11ck660 FIND v(dout1_11) AT=670.05n

.meas tran vdout1_12ck660 FIND v(dout1_12) AT=670.05n

.meas tran vdout1_13ck660 FIND v(dout1_13) AT=670.05n

.meas tran vdout1_14ck660 FIND v(dout1_14) AT=670.05n

.meas tran vdout1_15ck660 FIND v(dout1_15) AT=670.05n

.meas tran vdout1_16ck660 FIND v(dout1_16) AT=670.05n

.meas tran vdout1_0ck690 FIND v(dout1_0) AT=700.05n

.meas tran vdout1_1ck690 FIND v(dout1_1) AT=700.05n

.meas tran vdout1_2ck690 FIND v(dout1_2) AT=700.05n

.meas tran vdout1_3ck690 FIND v(dout1_3) AT=700.05n

.meas tran vdout1_4ck690 FIND v(dout1_4) AT=700.05n

.meas tran vdout1_5ck690 FIND v(dout1_5) AT=700.05n

.meas tran vdout1_6ck690 FIND v(dout1_6) AT=700.05n

.meas tran vdout1_7ck690 FIND v(dout1_7) AT=700.05n

.meas tran vdout1_8ck690 FIND v(dout1_8) AT=700.05n

.meas tran vdout1_9ck690 FIND v(dout1_9) AT=700.05n

.meas tran vdout1_10ck690 FIND v(dout1_10) AT=700.05n

.meas tran vdout1_11ck690 FIND v(dout1_11) AT=700.05n

.meas tran vdout1_12ck690 FIND v(dout1_12) AT=700.05n

.meas tran vdout1_13ck690 FIND v(dout1_13) AT=700.05n

.meas tran vdout1_14ck690 FIND v(dout1_14) AT=700.05n

.meas tran vdout1_15ck690 FIND v(dout1_15) AT=700.05n

.meas tran vdout1_16ck690 FIND v(dout1_16) AT=700.05n

.meas tran vdout1_0ck730 FIND v(dout1_0) AT=740.05n

.meas tran vdout1_1ck730 FIND v(dout1_1) AT=740.05n

.meas tran vdout1_2ck730 FIND v(dout1_2) AT=740.05n

.meas tran vdout1_3ck730 FIND v(dout1_3) AT=740.05n

.meas tran vdout1_4ck730 FIND v(dout1_4) AT=740.05n

.meas tran vdout1_5ck730 FIND v(dout1_5) AT=740.05n

.meas tran vdout1_6ck730 FIND v(dout1_6) AT=740.05n

.meas tran vdout1_7ck730 FIND v(dout1_7) AT=740.05n

.meas tran vdout1_8ck730 FIND v(dout1_8) AT=740.05n

.meas tran vdout1_9ck730 FIND v(dout1_9) AT=740.05n

.meas tran vdout1_10ck730 FIND v(dout1_10) AT=740.05n

.meas tran vdout1_11ck730 FIND v(dout1_11) AT=740.05n

.meas tran vdout1_12ck730 FIND v(dout1_12) AT=740.05n

.meas tran vdout1_13ck730 FIND v(dout1_13) AT=740.05n

.meas tran vdout1_14ck730 FIND v(dout1_14) AT=740.05n

.meas tran vdout1_15ck730 FIND v(dout1_15) AT=740.05n

.meas tran vdout1_16ck730 FIND v(dout1_16) AT=740.05n

.meas tran vdout1_0ck740 FIND v(dout1_0) AT=750.05n

.meas tran vdout1_1ck740 FIND v(dout1_1) AT=750.05n

.meas tran vdout1_2ck740 FIND v(dout1_2) AT=750.05n

.meas tran vdout1_3ck740 FIND v(dout1_3) AT=750.05n

.meas tran vdout1_4ck740 FIND v(dout1_4) AT=750.05n

.meas tran vdout1_5ck740 FIND v(dout1_5) AT=750.05n

.meas tran vdout1_6ck740 FIND v(dout1_6) AT=750.05n

.meas tran vdout1_7ck740 FIND v(dout1_7) AT=750.05n

.meas tran vdout1_8ck740 FIND v(dout1_8) AT=750.05n

.meas tran vdout1_9ck740 FIND v(dout1_9) AT=750.05n

.meas tran vdout1_10ck740 FIND v(dout1_10) AT=750.05n

.meas tran vdout1_11ck740 FIND v(dout1_11) AT=750.05n

.meas tran vdout1_12ck740 FIND v(dout1_12) AT=750.05n

.meas tran vdout1_13ck740 FIND v(dout1_13) AT=750.05n

.meas tran vdout1_14ck740 FIND v(dout1_14) AT=750.05n

.meas tran vdout1_15ck740 FIND v(dout1_15) AT=750.05n

.meas tran vdout1_16ck740 FIND v(dout1_16) AT=750.05n

.meas tran vdout1_0ck750 FIND v(dout1_0) AT=760.05n

.meas tran vdout1_1ck750 FIND v(dout1_1) AT=760.05n

.meas tran vdout1_2ck750 FIND v(dout1_2) AT=760.05n

.meas tran vdout1_3ck750 FIND v(dout1_3) AT=760.05n

.meas tran vdout1_4ck750 FIND v(dout1_4) AT=760.05n

.meas tran vdout1_5ck750 FIND v(dout1_5) AT=760.05n

.meas tran vdout1_6ck750 FIND v(dout1_6) AT=760.05n

.meas tran vdout1_7ck750 FIND v(dout1_7) AT=760.05n

.meas tran vdout1_8ck750 FIND v(dout1_8) AT=760.05n

.meas tran vdout1_9ck750 FIND v(dout1_9) AT=760.05n

.meas tran vdout1_10ck750 FIND v(dout1_10) AT=760.05n

.meas tran vdout1_11ck750 FIND v(dout1_11) AT=760.05n

.meas tran vdout1_12ck750 FIND v(dout1_12) AT=760.05n

.meas tran vdout1_13ck750 FIND v(dout1_13) AT=760.05n

.meas tran vdout1_14ck750 FIND v(dout1_14) AT=760.05n

.meas tran vdout1_15ck750 FIND v(dout1_15) AT=760.05n

.meas tran vdout1_16ck750 FIND v(dout1_16) AT=760.05n

.meas tran vdout1_0ck770 FIND v(dout1_0) AT=780.05n

.meas tran vdout1_1ck770 FIND v(dout1_1) AT=780.05n

.meas tran vdout1_2ck770 FIND v(dout1_2) AT=780.05n

.meas tran vdout1_3ck770 FIND v(dout1_3) AT=780.05n

.meas tran vdout1_4ck770 FIND v(dout1_4) AT=780.05n

.meas tran vdout1_5ck770 FIND v(dout1_5) AT=780.05n

.meas tran vdout1_6ck770 FIND v(dout1_6) AT=780.05n

.meas tran vdout1_7ck770 FIND v(dout1_7) AT=780.05n

.meas tran vdout1_8ck770 FIND v(dout1_8) AT=780.05n

.meas tran vdout1_9ck770 FIND v(dout1_9) AT=780.05n

.meas tran vdout1_10ck770 FIND v(dout1_10) AT=780.05n

.meas tran vdout1_11ck770 FIND v(dout1_11) AT=780.05n

.meas tran vdout1_12ck770 FIND v(dout1_12) AT=780.05n

.meas tran vdout1_13ck770 FIND v(dout1_13) AT=780.05n

.meas tran vdout1_14ck770 FIND v(dout1_14) AT=780.05n

.meas tran vdout1_15ck770 FIND v(dout1_15) AT=780.05n

.meas tran vdout1_16ck770 FIND v(dout1_16) AT=780.05n

.meas tran vdout1_0ck780 FIND v(dout1_0) AT=790.05n

.meas tran vdout1_1ck780 FIND v(dout1_1) AT=790.05n

.meas tran vdout1_2ck780 FIND v(dout1_2) AT=790.05n

.meas tran vdout1_3ck780 FIND v(dout1_3) AT=790.05n

.meas tran vdout1_4ck780 FIND v(dout1_4) AT=790.05n

.meas tran vdout1_5ck780 FIND v(dout1_5) AT=790.05n

.meas tran vdout1_6ck780 FIND v(dout1_6) AT=790.05n

.meas tran vdout1_7ck780 FIND v(dout1_7) AT=790.05n

.meas tran vdout1_8ck780 FIND v(dout1_8) AT=790.05n

.meas tran vdout1_9ck780 FIND v(dout1_9) AT=790.05n

.meas tran vdout1_10ck780 FIND v(dout1_10) AT=790.05n

.meas tran vdout1_11ck780 FIND v(dout1_11) AT=790.05n

.meas tran vdout1_12ck780 FIND v(dout1_12) AT=790.05n

.meas tran vdout1_13ck780 FIND v(dout1_13) AT=790.05n

.meas tran vdout1_14ck780 FIND v(dout1_14) AT=790.05n

.meas tran vdout1_15ck780 FIND v(dout1_15) AT=790.05n

.meas tran vdout1_16ck780 FIND v(dout1_16) AT=790.05n

.meas tran vdout1_0ck860 FIND v(dout1_0) AT=870.05n

.meas tran vdout1_1ck860 FIND v(dout1_1) AT=870.05n

.meas tran vdout1_2ck860 FIND v(dout1_2) AT=870.05n

.meas tran vdout1_3ck860 FIND v(dout1_3) AT=870.05n

.meas tran vdout1_4ck860 FIND v(dout1_4) AT=870.05n

.meas tran vdout1_5ck860 FIND v(dout1_5) AT=870.05n

.meas tran vdout1_6ck860 FIND v(dout1_6) AT=870.05n

.meas tran vdout1_7ck860 FIND v(dout1_7) AT=870.05n

.meas tran vdout1_8ck860 FIND v(dout1_8) AT=870.05n

.meas tran vdout1_9ck860 FIND v(dout1_9) AT=870.05n

.meas tran vdout1_10ck860 FIND v(dout1_10) AT=870.05n

.meas tran vdout1_11ck860 FIND v(dout1_11) AT=870.05n

.meas tran vdout1_12ck860 FIND v(dout1_12) AT=870.05n

.meas tran vdout1_13ck860 FIND v(dout1_13) AT=870.05n

.meas tran vdout1_14ck860 FIND v(dout1_14) AT=870.05n

.meas tran vdout1_15ck860 FIND v(dout1_15) AT=870.05n

.meas tran vdout1_16ck860 FIND v(dout1_16) AT=870.05n

.meas tran vdout1_0ck870 FIND v(dout1_0) AT=880.05n

.meas tran vdout1_1ck870 FIND v(dout1_1) AT=880.05n

.meas tran vdout1_2ck870 FIND v(dout1_2) AT=880.05n

.meas tran vdout1_3ck870 FIND v(dout1_3) AT=880.05n

.meas tran vdout1_4ck870 FIND v(dout1_4) AT=880.05n

.meas tran vdout1_5ck870 FIND v(dout1_5) AT=880.05n

.meas tran vdout1_6ck870 FIND v(dout1_6) AT=880.05n

.meas tran vdout1_7ck870 FIND v(dout1_7) AT=880.05n

.meas tran vdout1_8ck870 FIND v(dout1_8) AT=880.05n

.meas tran vdout1_9ck870 FIND v(dout1_9) AT=880.05n

.meas tran vdout1_10ck870 FIND v(dout1_10) AT=880.05n

.meas tran vdout1_11ck870 FIND v(dout1_11) AT=880.05n

.meas tran vdout1_12ck870 FIND v(dout1_12) AT=880.05n

.meas tran vdout1_13ck870 FIND v(dout1_13) AT=880.05n

.meas tran vdout1_14ck870 FIND v(dout1_14) AT=880.05n

.meas tran vdout1_15ck870 FIND v(dout1_15) AT=880.05n

.meas tran vdout1_16ck870 FIND v(dout1_16) AT=880.05n

.meas tran vdout1_0ck880 FIND v(dout1_0) AT=890.05n

.meas tran vdout1_1ck880 FIND v(dout1_1) AT=890.05n

.meas tran vdout1_2ck880 FIND v(dout1_2) AT=890.05n

.meas tran vdout1_3ck880 FIND v(dout1_3) AT=890.05n

.meas tran vdout1_4ck880 FIND v(dout1_4) AT=890.05n

.meas tran vdout1_5ck880 FIND v(dout1_5) AT=890.05n

.meas tran vdout1_6ck880 FIND v(dout1_6) AT=890.05n

.meas tran vdout1_7ck880 FIND v(dout1_7) AT=890.05n

.meas tran vdout1_8ck880 FIND v(dout1_8) AT=890.05n

.meas tran vdout1_9ck880 FIND v(dout1_9) AT=890.05n

.meas tran vdout1_10ck880 FIND v(dout1_10) AT=890.05n

.meas tran vdout1_11ck880 FIND v(dout1_11) AT=890.05n

.meas tran vdout1_12ck880 FIND v(dout1_12) AT=890.05n

.meas tran vdout1_13ck880 FIND v(dout1_13) AT=890.05n

.meas tran vdout1_14ck880 FIND v(dout1_14) AT=890.05n

.meas tran vdout1_15ck880 FIND v(dout1_15) AT=890.05n

.meas tran vdout1_16ck880 FIND v(dout1_16) AT=890.05n

.meas tran vdout1_0ck890 FIND v(dout1_0) AT=900.05n

.meas tran vdout1_1ck890 FIND v(dout1_1) AT=900.05n

.meas tran vdout1_2ck890 FIND v(dout1_2) AT=900.05n

.meas tran vdout1_3ck890 FIND v(dout1_3) AT=900.05n

.meas tran vdout1_4ck890 FIND v(dout1_4) AT=900.05n

.meas tran vdout1_5ck890 FIND v(dout1_5) AT=900.05n

.meas tran vdout1_6ck890 FIND v(dout1_6) AT=900.05n

.meas tran vdout1_7ck890 FIND v(dout1_7) AT=900.05n

.meas tran vdout1_8ck890 FIND v(dout1_8) AT=900.05n

.meas tran vdout1_9ck890 FIND v(dout1_9) AT=900.05n

.meas tran vdout1_10ck890 FIND v(dout1_10) AT=900.05n

.meas tran vdout1_11ck890 FIND v(dout1_11) AT=900.05n

.meas tran vdout1_12ck890 FIND v(dout1_12) AT=900.05n

.meas tran vdout1_13ck890 FIND v(dout1_13) AT=900.05n

.meas tran vdout1_14ck890 FIND v(dout1_14) AT=900.05n

.meas tran vdout1_15ck890 FIND v(dout1_15) AT=900.05n

.meas tran vdout1_16ck890 FIND v(dout1_16) AT=900.05n

.meas tran vdout1_0ck900 FIND v(dout1_0) AT=910.05n

.meas tran vdout1_1ck900 FIND v(dout1_1) AT=910.05n

.meas tran vdout1_2ck900 FIND v(dout1_2) AT=910.05n

.meas tran vdout1_3ck900 FIND v(dout1_3) AT=910.05n

.meas tran vdout1_4ck900 FIND v(dout1_4) AT=910.05n

.meas tran vdout1_5ck900 FIND v(dout1_5) AT=910.05n

.meas tran vdout1_6ck900 FIND v(dout1_6) AT=910.05n

.meas tran vdout1_7ck900 FIND v(dout1_7) AT=910.05n

.meas tran vdout1_8ck900 FIND v(dout1_8) AT=910.05n

.meas tran vdout1_9ck900 FIND v(dout1_9) AT=910.05n

.meas tran vdout1_10ck900 FIND v(dout1_10) AT=910.05n

.meas tran vdout1_11ck900 FIND v(dout1_11) AT=910.05n

.meas tran vdout1_12ck900 FIND v(dout1_12) AT=910.05n

.meas tran vdout1_13ck900 FIND v(dout1_13) AT=910.05n

.meas tran vdout1_14ck900 FIND v(dout1_14) AT=910.05n

.meas tran vdout1_15ck900 FIND v(dout1_15) AT=910.05n

.meas tran vdout1_16ck900 FIND v(dout1_16) AT=910.05n

.meas tran vdout1_0ck920 FIND v(dout1_0) AT=930.05n

.meas tran vdout1_1ck920 FIND v(dout1_1) AT=930.05n

.meas tran vdout1_2ck920 FIND v(dout1_2) AT=930.05n

.meas tran vdout1_3ck920 FIND v(dout1_3) AT=930.05n

.meas tran vdout1_4ck920 FIND v(dout1_4) AT=930.05n

.meas tran vdout1_5ck920 FIND v(dout1_5) AT=930.05n

.meas tran vdout1_6ck920 FIND v(dout1_6) AT=930.05n

.meas tran vdout1_7ck920 FIND v(dout1_7) AT=930.05n

.meas tran vdout1_8ck920 FIND v(dout1_8) AT=930.05n

.meas tran vdout1_9ck920 FIND v(dout1_9) AT=930.05n

.meas tran vdout1_10ck920 FIND v(dout1_10) AT=930.05n

.meas tran vdout1_11ck920 FIND v(dout1_11) AT=930.05n

.meas tran vdout1_12ck920 FIND v(dout1_12) AT=930.05n

.meas tran vdout1_13ck920 FIND v(dout1_13) AT=930.05n

.meas tran vdout1_14ck920 FIND v(dout1_14) AT=930.05n

.meas tran vdout1_15ck920 FIND v(dout1_15) AT=930.05n

.meas tran vdout1_16ck920 FIND v(dout1_16) AT=930.05n

.meas tran vdout1_0ck930 FIND v(dout1_0) AT=940.05n

.meas tran vdout1_1ck930 FIND v(dout1_1) AT=940.05n

.meas tran vdout1_2ck930 FIND v(dout1_2) AT=940.05n

.meas tran vdout1_3ck930 FIND v(dout1_3) AT=940.05n

.meas tran vdout1_4ck930 FIND v(dout1_4) AT=940.05n

.meas tran vdout1_5ck930 FIND v(dout1_5) AT=940.05n

.meas tran vdout1_6ck930 FIND v(dout1_6) AT=940.05n

.meas tran vdout1_7ck930 FIND v(dout1_7) AT=940.05n

.meas tran vdout1_8ck930 FIND v(dout1_8) AT=940.05n

.meas tran vdout1_9ck930 FIND v(dout1_9) AT=940.05n

.meas tran vdout1_10ck930 FIND v(dout1_10) AT=940.05n

.meas tran vdout1_11ck930 FIND v(dout1_11) AT=940.05n

.meas tran vdout1_12ck930 FIND v(dout1_12) AT=940.05n

.meas tran vdout1_13ck930 FIND v(dout1_13) AT=940.05n

.meas tran vdout1_14ck930 FIND v(dout1_14) AT=940.05n

.meas tran vdout1_15ck930 FIND v(dout1_15) AT=940.05n

.meas tran vdout1_16ck930 FIND v(dout1_16) AT=940.05n

.meas tran vdout1_0ck940 FIND v(dout1_0) AT=950.05n

.meas tran vdout1_1ck940 FIND v(dout1_1) AT=950.05n

.meas tran vdout1_2ck940 FIND v(dout1_2) AT=950.05n

.meas tran vdout1_3ck940 FIND v(dout1_3) AT=950.05n

.meas tran vdout1_4ck940 FIND v(dout1_4) AT=950.05n

.meas tran vdout1_5ck940 FIND v(dout1_5) AT=950.05n

.meas tran vdout1_6ck940 FIND v(dout1_6) AT=950.05n

.meas tran vdout1_7ck940 FIND v(dout1_7) AT=950.05n

.meas tran vdout1_8ck940 FIND v(dout1_8) AT=950.05n

.meas tran vdout1_9ck940 FIND v(dout1_9) AT=950.05n

.meas tran vdout1_10ck940 FIND v(dout1_10) AT=950.05n

.meas tran vdout1_11ck940 FIND v(dout1_11) AT=950.05n

.meas tran vdout1_12ck940 FIND v(dout1_12) AT=950.05n

.meas tran vdout1_13ck940 FIND v(dout1_13) AT=950.05n

.meas tran vdout1_14ck940 FIND v(dout1_14) AT=950.05n

.meas tran vdout1_15ck940 FIND v(dout1_15) AT=950.05n

.meas tran vdout1_16ck940 FIND v(dout1_16) AT=950.05n

.meas tran vdout1_0ck950 FIND v(dout1_0) AT=960.05n

.meas tran vdout1_1ck950 FIND v(dout1_1) AT=960.05n

.meas tran vdout1_2ck950 FIND v(dout1_2) AT=960.05n

.meas tran vdout1_3ck950 FIND v(dout1_3) AT=960.05n

.meas tran vdout1_4ck950 FIND v(dout1_4) AT=960.05n

.meas tran vdout1_5ck950 FIND v(dout1_5) AT=960.05n

.meas tran vdout1_6ck950 FIND v(dout1_6) AT=960.05n

.meas tran vdout1_7ck950 FIND v(dout1_7) AT=960.05n

.meas tran vdout1_8ck950 FIND v(dout1_8) AT=960.05n

.meas tran vdout1_9ck950 FIND v(dout1_9) AT=960.05n

.meas tran vdout1_10ck950 FIND v(dout1_10) AT=960.05n

.meas tran vdout1_11ck950 FIND v(dout1_11) AT=960.05n

.meas tran vdout1_12ck950 FIND v(dout1_12) AT=960.05n

.meas tran vdout1_13ck950 FIND v(dout1_13) AT=960.05n

.meas tran vdout1_14ck950 FIND v(dout1_14) AT=960.05n

.meas tran vdout1_15ck950 FIND v(dout1_15) AT=960.05n

.meas tran vdout1_16ck950 FIND v(dout1_16) AT=960.05n

.meas tran vdout1_0ck960 FIND v(dout1_0) AT=970.05n

.meas tran vdout1_1ck960 FIND v(dout1_1) AT=970.05n

.meas tran vdout1_2ck960 FIND v(dout1_2) AT=970.05n

.meas tran vdout1_3ck960 FIND v(dout1_3) AT=970.05n

.meas tran vdout1_4ck960 FIND v(dout1_4) AT=970.05n

.meas tran vdout1_5ck960 FIND v(dout1_5) AT=970.05n

.meas tran vdout1_6ck960 FIND v(dout1_6) AT=970.05n

.meas tran vdout1_7ck960 FIND v(dout1_7) AT=970.05n

.meas tran vdout1_8ck960 FIND v(dout1_8) AT=970.05n

.meas tran vdout1_9ck960 FIND v(dout1_9) AT=970.05n

.meas tran vdout1_10ck960 FIND v(dout1_10) AT=970.05n

.meas tran vdout1_11ck960 FIND v(dout1_11) AT=970.05n

.meas tran vdout1_12ck960 FIND v(dout1_12) AT=970.05n

.meas tran vdout1_13ck960 FIND v(dout1_13) AT=970.05n

.meas tran vdout1_14ck960 FIND v(dout1_14) AT=970.05n

.meas tran vdout1_15ck960 FIND v(dout1_15) AT=970.05n

.meas tran vdout1_16ck960 FIND v(dout1_16) AT=970.05n

.meas tran vdout1_0ck970 FIND v(dout1_0) AT=980.05n

.meas tran vdout1_1ck970 FIND v(dout1_1) AT=980.05n

.meas tran vdout1_2ck970 FIND v(dout1_2) AT=980.05n

.meas tran vdout1_3ck970 FIND v(dout1_3) AT=980.05n

.meas tran vdout1_4ck970 FIND v(dout1_4) AT=980.05n

.meas tran vdout1_5ck970 FIND v(dout1_5) AT=980.05n

.meas tran vdout1_6ck970 FIND v(dout1_6) AT=980.05n

.meas tran vdout1_7ck970 FIND v(dout1_7) AT=980.05n

.meas tran vdout1_8ck970 FIND v(dout1_8) AT=980.05n

.meas tran vdout1_9ck970 FIND v(dout1_9) AT=980.05n

.meas tran vdout1_10ck970 FIND v(dout1_10) AT=980.05n

.meas tran vdout1_11ck970 FIND v(dout1_11) AT=980.05n

.meas tran vdout1_12ck970 FIND v(dout1_12) AT=980.05n

.meas tran vdout1_13ck970 FIND v(dout1_13) AT=980.05n

.meas tran vdout1_14ck970 FIND v(dout1_14) AT=980.05n

.meas tran vdout1_15ck970 FIND v(dout1_15) AT=980.05n

.meas tran vdout1_16ck970 FIND v(dout1_16) AT=980.05n

.meas tran vdout1_0ck980 FIND v(dout1_0) AT=990.05n

.meas tran vdout1_1ck980 FIND v(dout1_1) AT=990.05n

.meas tran vdout1_2ck980 FIND v(dout1_2) AT=990.05n

.meas tran vdout1_3ck980 FIND v(dout1_3) AT=990.05n

.meas tran vdout1_4ck980 FIND v(dout1_4) AT=990.05n

.meas tran vdout1_5ck980 FIND v(dout1_5) AT=990.05n

.meas tran vdout1_6ck980 FIND v(dout1_6) AT=990.05n

.meas tran vdout1_7ck980 FIND v(dout1_7) AT=990.05n

.meas tran vdout1_8ck980 FIND v(dout1_8) AT=990.05n

.meas tran vdout1_9ck980 FIND v(dout1_9) AT=990.05n

.meas tran vdout1_10ck980 FIND v(dout1_10) AT=990.05n

.meas tran vdout1_11ck980 FIND v(dout1_11) AT=990.05n

.meas tran vdout1_12ck980 FIND v(dout1_12) AT=990.05n

.meas tran vdout1_13ck980 FIND v(dout1_13) AT=990.05n

.meas tran vdout1_14ck980 FIND v(dout1_14) AT=990.05n

.meas tran vdout1_15ck980 FIND v(dout1_15) AT=990.05n

.meas tran vdout1_16ck980 FIND v(dout1_16) AT=990.05n

.meas tran vdout1_0ck1020 FIND v(dout1_0) AT=1030.05n

.meas tran vdout1_1ck1020 FIND v(dout1_1) AT=1030.05n

.meas tran vdout1_2ck1020 FIND v(dout1_2) AT=1030.05n

.meas tran vdout1_3ck1020 FIND v(dout1_3) AT=1030.05n

.meas tran vdout1_4ck1020 FIND v(dout1_4) AT=1030.05n

.meas tran vdout1_5ck1020 FIND v(dout1_5) AT=1030.05n

.meas tran vdout1_6ck1020 FIND v(dout1_6) AT=1030.05n

.meas tran vdout1_7ck1020 FIND v(dout1_7) AT=1030.05n

.meas tran vdout1_8ck1020 FIND v(dout1_8) AT=1030.05n

.meas tran vdout1_9ck1020 FIND v(dout1_9) AT=1030.05n

.meas tran vdout1_10ck1020 FIND v(dout1_10) AT=1030.05n

.meas tran vdout1_11ck1020 FIND v(dout1_11) AT=1030.05n

.meas tran vdout1_12ck1020 FIND v(dout1_12) AT=1030.05n

.meas tran vdout1_13ck1020 FIND v(dout1_13) AT=1030.05n

.meas tran vdout1_14ck1020 FIND v(dout1_14) AT=1030.05n

.meas tran vdout1_15ck1020 FIND v(dout1_15) AT=1030.05n

.meas tran vdout1_16ck1020 FIND v(dout1_16) AT=1030.05n

.meas tran vdout1_0ck1100 FIND v(dout1_0) AT=1110.05n

.meas tran vdout1_1ck1100 FIND v(dout1_1) AT=1110.05n

.meas tran vdout1_2ck1100 FIND v(dout1_2) AT=1110.05n

.meas tran vdout1_3ck1100 FIND v(dout1_3) AT=1110.05n

.meas tran vdout1_4ck1100 FIND v(dout1_4) AT=1110.05n

.meas tran vdout1_5ck1100 FIND v(dout1_5) AT=1110.05n

.meas tran vdout1_6ck1100 FIND v(dout1_6) AT=1110.05n

.meas tran vdout1_7ck1100 FIND v(dout1_7) AT=1110.05n

.meas tran vdout1_8ck1100 FIND v(dout1_8) AT=1110.05n

.meas tran vdout1_9ck1100 FIND v(dout1_9) AT=1110.05n

.meas tran vdout1_10ck1100 FIND v(dout1_10) AT=1110.05n

.meas tran vdout1_11ck1100 FIND v(dout1_11) AT=1110.05n

.meas tran vdout1_12ck1100 FIND v(dout1_12) AT=1110.05n

.meas tran vdout1_13ck1100 FIND v(dout1_13) AT=1110.05n

.meas tran vdout1_14ck1100 FIND v(dout1_14) AT=1110.05n

.meas tran vdout1_15ck1100 FIND v(dout1_15) AT=1110.05n

.meas tran vdout1_16ck1100 FIND v(dout1_16) AT=1110.05n

.meas tran vdout1_0ck1130 FIND v(dout1_0) AT=1140.05n

.meas tran vdout1_1ck1130 FIND v(dout1_1) AT=1140.05n

.meas tran vdout1_2ck1130 FIND v(dout1_2) AT=1140.05n

.meas tran vdout1_3ck1130 FIND v(dout1_3) AT=1140.05n

.meas tran vdout1_4ck1130 FIND v(dout1_4) AT=1140.05n

.meas tran vdout1_5ck1130 FIND v(dout1_5) AT=1140.05n

.meas tran vdout1_6ck1130 FIND v(dout1_6) AT=1140.05n

.meas tran vdout1_7ck1130 FIND v(dout1_7) AT=1140.05n

.meas tran vdout1_8ck1130 FIND v(dout1_8) AT=1140.05n

.meas tran vdout1_9ck1130 FIND v(dout1_9) AT=1140.05n

.meas tran vdout1_10ck1130 FIND v(dout1_10) AT=1140.05n

.meas tran vdout1_11ck1130 FIND v(dout1_11) AT=1140.05n

.meas tran vdout1_12ck1130 FIND v(dout1_12) AT=1140.05n

.meas tran vdout1_13ck1130 FIND v(dout1_13) AT=1140.05n

.meas tran vdout1_14ck1130 FIND v(dout1_14) AT=1140.05n

.meas tran vdout1_15ck1130 FIND v(dout1_15) AT=1140.05n

.meas tran vdout1_16ck1130 FIND v(dout1_16) AT=1140.05n

.meas tran vdout1_0ck1140 FIND v(dout1_0) AT=1150.05n

.meas tran vdout1_1ck1140 FIND v(dout1_1) AT=1150.05n

.meas tran vdout1_2ck1140 FIND v(dout1_2) AT=1150.05n

.meas tran vdout1_3ck1140 FIND v(dout1_3) AT=1150.05n

.meas tran vdout1_4ck1140 FIND v(dout1_4) AT=1150.05n

.meas tran vdout1_5ck1140 FIND v(dout1_5) AT=1150.05n

.meas tran vdout1_6ck1140 FIND v(dout1_6) AT=1150.05n

.meas tran vdout1_7ck1140 FIND v(dout1_7) AT=1150.05n

.meas tran vdout1_8ck1140 FIND v(dout1_8) AT=1150.05n

.meas tran vdout1_9ck1140 FIND v(dout1_9) AT=1150.05n

.meas tran vdout1_10ck1140 FIND v(dout1_10) AT=1150.05n

.meas tran vdout1_11ck1140 FIND v(dout1_11) AT=1150.05n

.meas tran vdout1_12ck1140 FIND v(dout1_12) AT=1150.05n

.meas tran vdout1_13ck1140 FIND v(dout1_13) AT=1150.05n

.meas tran vdout1_14ck1140 FIND v(dout1_14) AT=1150.05n

.meas tran vdout1_15ck1140 FIND v(dout1_15) AT=1150.05n

.meas tran vdout1_16ck1140 FIND v(dout1_16) AT=1150.05n

.meas tran vdout1_0ck1150 FIND v(dout1_0) AT=1160.05n

.meas tran vdout1_1ck1150 FIND v(dout1_1) AT=1160.05n

.meas tran vdout1_2ck1150 FIND v(dout1_2) AT=1160.05n

.meas tran vdout1_3ck1150 FIND v(dout1_3) AT=1160.05n

.meas tran vdout1_4ck1150 FIND v(dout1_4) AT=1160.05n

.meas tran vdout1_5ck1150 FIND v(dout1_5) AT=1160.05n

.meas tran vdout1_6ck1150 FIND v(dout1_6) AT=1160.05n

.meas tran vdout1_7ck1150 FIND v(dout1_7) AT=1160.05n

.meas tran vdout1_8ck1150 FIND v(dout1_8) AT=1160.05n

.meas tran vdout1_9ck1150 FIND v(dout1_9) AT=1160.05n

.meas tran vdout1_10ck1150 FIND v(dout1_10) AT=1160.05n

.meas tran vdout1_11ck1150 FIND v(dout1_11) AT=1160.05n

.meas tran vdout1_12ck1150 FIND v(dout1_12) AT=1160.05n

.meas tran vdout1_13ck1150 FIND v(dout1_13) AT=1160.05n

.meas tran vdout1_14ck1150 FIND v(dout1_14) AT=1160.05n

.meas tran vdout1_15ck1150 FIND v(dout1_15) AT=1160.05n

.meas tran vdout1_16ck1150 FIND v(dout1_16) AT=1160.05n

.meas tran vdout1_0ck1190 FIND v(dout1_0) AT=1200.05n

.meas tran vdout1_1ck1190 FIND v(dout1_1) AT=1200.05n

.meas tran vdout1_2ck1190 FIND v(dout1_2) AT=1200.05n

.meas tran vdout1_3ck1190 FIND v(dout1_3) AT=1200.05n

.meas tran vdout1_4ck1190 FIND v(dout1_4) AT=1200.05n

.meas tran vdout1_5ck1190 FIND v(dout1_5) AT=1200.05n

.meas tran vdout1_6ck1190 FIND v(dout1_6) AT=1200.05n

.meas tran vdout1_7ck1190 FIND v(dout1_7) AT=1200.05n

.meas tran vdout1_8ck1190 FIND v(dout1_8) AT=1200.05n

.meas tran vdout1_9ck1190 FIND v(dout1_9) AT=1200.05n

.meas tran vdout1_10ck1190 FIND v(dout1_10) AT=1200.05n

.meas tran vdout1_11ck1190 FIND v(dout1_11) AT=1200.05n

.meas tran vdout1_12ck1190 FIND v(dout1_12) AT=1200.05n

.meas tran vdout1_13ck1190 FIND v(dout1_13) AT=1200.05n

.meas tran vdout1_14ck1190 FIND v(dout1_14) AT=1200.05n

.meas tran vdout1_15ck1190 FIND v(dout1_15) AT=1200.05n

.meas tran vdout1_16ck1190 FIND v(dout1_16) AT=1200.05n

.meas tran vdout1_0ck1200 FIND v(dout1_0) AT=1210.05n

.meas tran vdout1_1ck1200 FIND v(dout1_1) AT=1210.05n

.meas tran vdout1_2ck1200 FIND v(dout1_2) AT=1210.05n

.meas tran vdout1_3ck1200 FIND v(dout1_3) AT=1210.05n

.meas tran vdout1_4ck1200 FIND v(dout1_4) AT=1210.05n

.meas tran vdout1_5ck1200 FIND v(dout1_5) AT=1210.05n

.meas tran vdout1_6ck1200 FIND v(dout1_6) AT=1210.05n

.meas tran vdout1_7ck1200 FIND v(dout1_7) AT=1210.05n

.meas tran vdout1_8ck1200 FIND v(dout1_8) AT=1210.05n

.meas tran vdout1_9ck1200 FIND v(dout1_9) AT=1210.05n

.meas tran vdout1_10ck1200 FIND v(dout1_10) AT=1210.05n

.meas tran vdout1_11ck1200 FIND v(dout1_11) AT=1210.05n

.meas tran vdout1_12ck1200 FIND v(dout1_12) AT=1210.05n

.meas tran vdout1_13ck1200 FIND v(dout1_13) AT=1210.05n

.meas tran vdout1_14ck1200 FIND v(dout1_14) AT=1210.05n

.meas tran vdout1_15ck1200 FIND v(dout1_15) AT=1210.05n

.meas tran vdout1_16ck1200 FIND v(dout1_16) AT=1210.05n

.meas tran vdout1_0ck1230 FIND v(dout1_0) AT=1240.05n

.meas tran vdout1_1ck1230 FIND v(dout1_1) AT=1240.05n

.meas tran vdout1_2ck1230 FIND v(dout1_2) AT=1240.05n

.meas tran vdout1_3ck1230 FIND v(dout1_3) AT=1240.05n

.meas tran vdout1_4ck1230 FIND v(dout1_4) AT=1240.05n

.meas tran vdout1_5ck1230 FIND v(dout1_5) AT=1240.05n

.meas tran vdout1_6ck1230 FIND v(dout1_6) AT=1240.05n

.meas tran vdout1_7ck1230 FIND v(dout1_7) AT=1240.05n

.meas tran vdout1_8ck1230 FIND v(dout1_8) AT=1240.05n

.meas tran vdout1_9ck1230 FIND v(dout1_9) AT=1240.05n

.meas tran vdout1_10ck1230 FIND v(dout1_10) AT=1240.05n

.meas tran vdout1_11ck1230 FIND v(dout1_11) AT=1240.05n

.meas tran vdout1_12ck1230 FIND v(dout1_12) AT=1240.05n

.meas tran vdout1_13ck1230 FIND v(dout1_13) AT=1240.05n

.meas tran vdout1_14ck1230 FIND v(dout1_14) AT=1240.05n

.meas tran vdout1_15ck1230 FIND v(dout1_15) AT=1240.05n

.meas tran vdout1_16ck1230 FIND v(dout1_16) AT=1240.05n

.meas tran vdout1_0ck1240 FIND v(dout1_0) AT=1250.05n

.meas tran vdout1_1ck1240 FIND v(dout1_1) AT=1250.05n

.meas tran vdout1_2ck1240 FIND v(dout1_2) AT=1250.05n

.meas tran vdout1_3ck1240 FIND v(dout1_3) AT=1250.05n

.meas tran vdout1_4ck1240 FIND v(dout1_4) AT=1250.05n

.meas tran vdout1_5ck1240 FIND v(dout1_5) AT=1250.05n

.meas tran vdout1_6ck1240 FIND v(dout1_6) AT=1250.05n

.meas tran vdout1_7ck1240 FIND v(dout1_7) AT=1250.05n

.meas tran vdout1_8ck1240 FIND v(dout1_8) AT=1250.05n

.meas tran vdout1_9ck1240 FIND v(dout1_9) AT=1250.05n

.meas tran vdout1_10ck1240 FIND v(dout1_10) AT=1250.05n

.meas tran vdout1_11ck1240 FIND v(dout1_11) AT=1250.05n

.meas tran vdout1_12ck1240 FIND v(dout1_12) AT=1250.05n

.meas tran vdout1_13ck1240 FIND v(dout1_13) AT=1250.05n

.meas tran vdout1_14ck1240 FIND v(dout1_14) AT=1250.05n

.meas tran vdout1_15ck1240 FIND v(dout1_15) AT=1250.05n

.meas tran vdout1_16ck1240 FIND v(dout1_16) AT=1250.05n

.meas tran vdout1_0ck1290 FIND v(dout1_0) AT=1300.05n

.meas tran vdout1_1ck1290 FIND v(dout1_1) AT=1300.05n

.meas tran vdout1_2ck1290 FIND v(dout1_2) AT=1300.05n

.meas tran vdout1_3ck1290 FIND v(dout1_3) AT=1300.05n

.meas tran vdout1_4ck1290 FIND v(dout1_4) AT=1300.05n

.meas tran vdout1_5ck1290 FIND v(dout1_5) AT=1300.05n

.meas tran vdout1_6ck1290 FIND v(dout1_6) AT=1300.05n

.meas tran vdout1_7ck1290 FIND v(dout1_7) AT=1300.05n

.meas tran vdout1_8ck1290 FIND v(dout1_8) AT=1300.05n

.meas tran vdout1_9ck1290 FIND v(dout1_9) AT=1300.05n

.meas tran vdout1_10ck1290 FIND v(dout1_10) AT=1300.05n

.meas tran vdout1_11ck1290 FIND v(dout1_11) AT=1300.05n

.meas tran vdout1_12ck1290 FIND v(dout1_12) AT=1300.05n

.meas tran vdout1_13ck1290 FIND v(dout1_13) AT=1300.05n

.meas tran vdout1_14ck1290 FIND v(dout1_14) AT=1300.05n

.meas tran vdout1_15ck1290 FIND v(dout1_15) AT=1300.05n

.meas tran vdout1_16ck1290 FIND v(dout1_16) AT=1300.05n

.meas tran vdout1_0ck1300 FIND v(dout1_0) AT=1310.05n

.meas tran vdout1_1ck1300 FIND v(dout1_1) AT=1310.05n

.meas tran vdout1_2ck1300 FIND v(dout1_2) AT=1310.05n

.meas tran vdout1_3ck1300 FIND v(dout1_3) AT=1310.05n

.meas tran vdout1_4ck1300 FIND v(dout1_4) AT=1310.05n

.meas tran vdout1_5ck1300 FIND v(dout1_5) AT=1310.05n

.meas tran vdout1_6ck1300 FIND v(dout1_6) AT=1310.05n

.meas tran vdout1_7ck1300 FIND v(dout1_7) AT=1310.05n

.meas tran vdout1_8ck1300 FIND v(dout1_8) AT=1310.05n

.meas tran vdout1_9ck1300 FIND v(dout1_9) AT=1310.05n

.meas tran vdout1_10ck1300 FIND v(dout1_10) AT=1310.05n

.meas tran vdout1_11ck1300 FIND v(dout1_11) AT=1310.05n

.meas tran vdout1_12ck1300 FIND v(dout1_12) AT=1310.05n

.meas tran vdout1_13ck1300 FIND v(dout1_13) AT=1310.05n

.meas tran vdout1_14ck1300 FIND v(dout1_14) AT=1310.05n

.meas tran vdout1_15ck1300 FIND v(dout1_15) AT=1310.05n

.meas tran vdout1_16ck1300 FIND v(dout1_16) AT=1310.05n

.meas tran vdout1_0ck1320 FIND v(dout1_0) AT=1330.05n

.meas tran vdout1_1ck1320 FIND v(dout1_1) AT=1330.05n

.meas tran vdout1_2ck1320 FIND v(dout1_2) AT=1330.05n

.meas tran vdout1_3ck1320 FIND v(dout1_3) AT=1330.05n

.meas tran vdout1_4ck1320 FIND v(dout1_4) AT=1330.05n

.meas tran vdout1_5ck1320 FIND v(dout1_5) AT=1330.05n

.meas tran vdout1_6ck1320 FIND v(dout1_6) AT=1330.05n

.meas tran vdout1_7ck1320 FIND v(dout1_7) AT=1330.05n

.meas tran vdout1_8ck1320 FIND v(dout1_8) AT=1330.05n

.meas tran vdout1_9ck1320 FIND v(dout1_9) AT=1330.05n

.meas tran vdout1_10ck1320 FIND v(dout1_10) AT=1330.05n

.meas tran vdout1_11ck1320 FIND v(dout1_11) AT=1330.05n

.meas tran vdout1_12ck1320 FIND v(dout1_12) AT=1330.05n

.meas tran vdout1_13ck1320 FIND v(dout1_13) AT=1330.05n

.meas tran vdout1_14ck1320 FIND v(dout1_14) AT=1330.05n

.meas tran vdout1_15ck1320 FIND v(dout1_15) AT=1330.05n

.meas tran vdout1_16ck1320 FIND v(dout1_16) AT=1330.05n

.meas tran vdout1_0ck1370 FIND v(dout1_0) AT=1380.05n

.meas tran vdout1_1ck1370 FIND v(dout1_1) AT=1380.05n

.meas tran vdout1_2ck1370 FIND v(dout1_2) AT=1380.05n

.meas tran vdout1_3ck1370 FIND v(dout1_3) AT=1380.05n

.meas tran vdout1_4ck1370 FIND v(dout1_4) AT=1380.05n

.meas tran vdout1_5ck1370 FIND v(dout1_5) AT=1380.05n

.meas tran vdout1_6ck1370 FIND v(dout1_6) AT=1380.05n

.meas tran vdout1_7ck1370 FIND v(dout1_7) AT=1380.05n

.meas tran vdout1_8ck1370 FIND v(dout1_8) AT=1380.05n

.meas tran vdout1_9ck1370 FIND v(dout1_9) AT=1380.05n

.meas tran vdout1_10ck1370 FIND v(dout1_10) AT=1380.05n

.meas tran vdout1_11ck1370 FIND v(dout1_11) AT=1380.05n

.meas tran vdout1_12ck1370 FIND v(dout1_12) AT=1380.05n

.meas tran vdout1_13ck1370 FIND v(dout1_13) AT=1380.05n

.meas tran vdout1_14ck1370 FIND v(dout1_14) AT=1380.05n

.meas tran vdout1_15ck1370 FIND v(dout1_15) AT=1380.05n

.meas tran vdout1_16ck1370 FIND v(dout1_16) AT=1380.05n

.meas tran vdout1_0ck1380 FIND v(dout1_0) AT=1390.05n

.meas tran vdout1_1ck1380 FIND v(dout1_1) AT=1390.05n

.meas tran vdout1_2ck1380 FIND v(dout1_2) AT=1390.05n

.meas tran vdout1_3ck1380 FIND v(dout1_3) AT=1390.05n

.meas tran vdout1_4ck1380 FIND v(dout1_4) AT=1390.05n

.meas tran vdout1_5ck1380 FIND v(dout1_5) AT=1390.05n

.meas tran vdout1_6ck1380 FIND v(dout1_6) AT=1390.05n

.meas tran vdout1_7ck1380 FIND v(dout1_7) AT=1390.05n

.meas tran vdout1_8ck1380 FIND v(dout1_8) AT=1390.05n

.meas tran vdout1_9ck1380 FIND v(dout1_9) AT=1390.05n

.meas tran vdout1_10ck1380 FIND v(dout1_10) AT=1390.05n

.meas tran vdout1_11ck1380 FIND v(dout1_11) AT=1390.05n

.meas tran vdout1_12ck1380 FIND v(dout1_12) AT=1390.05n

.meas tran vdout1_13ck1380 FIND v(dout1_13) AT=1390.05n

.meas tran vdout1_14ck1380 FIND v(dout1_14) AT=1390.05n

.meas tran vdout1_15ck1380 FIND v(dout1_15) AT=1390.05n

.meas tran vdout1_16ck1380 FIND v(dout1_16) AT=1390.05n

.meas tran vdout1_0ck1390 FIND v(dout1_0) AT=1400.05n

.meas tran vdout1_1ck1390 FIND v(dout1_1) AT=1400.05n

.meas tran vdout1_2ck1390 FIND v(dout1_2) AT=1400.05n

.meas tran vdout1_3ck1390 FIND v(dout1_3) AT=1400.05n

.meas tran vdout1_4ck1390 FIND v(dout1_4) AT=1400.05n

.meas tran vdout1_5ck1390 FIND v(dout1_5) AT=1400.05n

.meas tran vdout1_6ck1390 FIND v(dout1_6) AT=1400.05n

.meas tran vdout1_7ck1390 FIND v(dout1_7) AT=1400.05n

.meas tran vdout1_8ck1390 FIND v(dout1_8) AT=1400.05n

.meas tran vdout1_9ck1390 FIND v(dout1_9) AT=1400.05n

.meas tran vdout1_10ck1390 FIND v(dout1_10) AT=1400.05n

.meas tran vdout1_11ck1390 FIND v(dout1_11) AT=1400.05n

.meas tran vdout1_12ck1390 FIND v(dout1_12) AT=1400.05n

.meas tran vdout1_13ck1390 FIND v(dout1_13) AT=1400.05n

.meas tran vdout1_14ck1390 FIND v(dout1_14) AT=1400.05n

.meas tran vdout1_15ck1390 FIND v(dout1_15) AT=1400.05n

.meas tran vdout1_16ck1390 FIND v(dout1_16) AT=1400.05n

.meas tran vdout1_0ck1400 FIND v(dout1_0) AT=1410.05n

.meas tran vdout1_1ck1400 FIND v(dout1_1) AT=1410.05n

.meas tran vdout1_2ck1400 FIND v(dout1_2) AT=1410.05n

.meas tran vdout1_3ck1400 FIND v(dout1_3) AT=1410.05n

.meas tran vdout1_4ck1400 FIND v(dout1_4) AT=1410.05n

.meas tran vdout1_5ck1400 FIND v(dout1_5) AT=1410.05n

.meas tran vdout1_6ck1400 FIND v(dout1_6) AT=1410.05n

.meas tran vdout1_7ck1400 FIND v(dout1_7) AT=1410.05n

.meas tran vdout1_8ck1400 FIND v(dout1_8) AT=1410.05n

.meas tran vdout1_9ck1400 FIND v(dout1_9) AT=1410.05n

.meas tran vdout1_10ck1400 FIND v(dout1_10) AT=1410.05n

.meas tran vdout1_11ck1400 FIND v(dout1_11) AT=1410.05n

.meas tran vdout1_12ck1400 FIND v(dout1_12) AT=1410.05n

.meas tran vdout1_13ck1400 FIND v(dout1_13) AT=1410.05n

.meas tran vdout1_14ck1400 FIND v(dout1_14) AT=1410.05n

.meas tran vdout1_15ck1400 FIND v(dout1_15) AT=1410.05n

.meas tran vdout1_16ck1400 FIND v(dout1_16) AT=1410.05n

.meas tran vdout1_0ck1420 FIND v(dout1_0) AT=1430.05n

.meas tran vdout1_1ck1420 FIND v(dout1_1) AT=1430.05n

.meas tran vdout1_2ck1420 FIND v(dout1_2) AT=1430.05n

.meas tran vdout1_3ck1420 FIND v(dout1_3) AT=1430.05n

.meas tran vdout1_4ck1420 FIND v(dout1_4) AT=1430.05n

.meas tran vdout1_5ck1420 FIND v(dout1_5) AT=1430.05n

.meas tran vdout1_6ck1420 FIND v(dout1_6) AT=1430.05n

.meas tran vdout1_7ck1420 FIND v(dout1_7) AT=1430.05n

.meas tran vdout1_8ck1420 FIND v(dout1_8) AT=1430.05n

.meas tran vdout1_9ck1420 FIND v(dout1_9) AT=1430.05n

.meas tran vdout1_10ck1420 FIND v(dout1_10) AT=1430.05n

.meas tran vdout1_11ck1420 FIND v(dout1_11) AT=1430.05n

.meas tran vdout1_12ck1420 FIND v(dout1_12) AT=1430.05n

.meas tran vdout1_13ck1420 FIND v(dout1_13) AT=1430.05n

.meas tran vdout1_14ck1420 FIND v(dout1_14) AT=1430.05n

.meas tran vdout1_15ck1420 FIND v(dout1_15) AT=1430.05n

.meas tran vdout1_16ck1420 FIND v(dout1_16) AT=1430.05n

.meas tran vdout1_0ck1430 FIND v(dout1_0) AT=1440.05n

.meas tran vdout1_1ck1430 FIND v(dout1_1) AT=1440.05n

.meas tran vdout1_2ck1430 FIND v(dout1_2) AT=1440.05n

.meas tran vdout1_3ck1430 FIND v(dout1_3) AT=1440.05n

.meas tran vdout1_4ck1430 FIND v(dout1_4) AT=1440.05n

.meas tran vdout1_5ck1430 FIND v(dout1_5) AT=1440.05n

.meas tran vdout1_6ck1430 FIND v(dout1_6) AT=1440.05n

.meas tran vdout1_7ck1430 FIND v(dout1_7) AT=1440.05n

.meas tran vdout1_8ck1430 FIND v(dout1_8) AT=1440.05n

.meas tran vdout1_9ck1430 FIND v(dout1_9) AT=1440.05n

.meas tran vdout1_10ck1430 FIND v(dout1_10) AT=1440.05n

.meas tran vdout1_11ck1430 FIND v(dout1_11) AT=1440.05n

.meas tran vdout1_12ck1430 FIND v(dout1_12) AT=1440.05n

.meas tran vdout1_13ck1430 FIND v(dout1_13) AT=1440.05n

.meas tran vdout1_14ck1430 FIND v(dout1_14) AT=1440.05n

.meas tran vdout1_15ck1430 FIND v(dout1_15) AT=1440.05n

.meas tran vdout1_16ck1430 FIND v(dout1_16) AT=1440.05n

.meas tran vdout1_0ck1460 FIND v(dout1_0) AT=1470.05n

.meas tran vdout1_1ck1460 FIND v(dout1_1) AT=1470.05n

.meas tran vdout1_2ck1460 FIND v(dout1_2) AT=1470.05n

.meas tran vdout1_3ck1460 FIND v(dout1_3) AT=1470.05n

.meas tran vdout1_4ck1460 FIND v(dout1_4) AT=1470.05n

.meas tran vdout1_5ck1460 FIND v(dout1_5) AT=1470.05n

.meas tran vdout1_6ck1460 FIND v(dout1_6) AT=1470.05n

.meas tran vdout1_7ck1460 FIND v(dout1_7) AT=1470.05n

.meas tran vdout1_8ck1460 FIND v(dout1_8) AT=1470.05n

.meas tran vdout1_9ck1460 FIND v(dout1_9) AT=1470.05n

.meas tran vdout1_10ck1460 FIND v(dout1_10) AT=1470.05n

.meas tran vdout1_11ck1460 FIND v(dout1_11) AT=1470.05n

.meas tran vdout1_12ck1460 FIND v(dout1_12) AT=1470.05n

.meas tran vdout1_13ck1460 FIND v(dout1_13) AT=1470.05n

.meas tran vdout1_14ck1460 FIND v(dout1_14) AT=1470.05n

.meas tran vdout1_15ck1460 FIND v(dout1_15) AT=1470.05n

.meas tran vdout1_16ck1460 FIND v(dout1_16) AT=1470.05n

.meas tran vdout1_0ck1500 FIND v(dout1_0) AT=1510.05n

.meas tran vdout1_1ck1500 FIND v(dout1_1) AT=1510.05n

.meas tran vdout1_2ck1500 FIND v(dout1_2) AT=1510.05n

.meas tran vdout1_3ck1500 FIND v(dout1_3) AT=1510.05n

.meas tran vdout1_4ck1500 FIND v(dout1_4) AT=1510.05n

.meas tran vdout1_5ck1500 FIND v(dout1_5) AT=1510.05n

.meas tran vdout1_6ck1500 FIND v(dout1_6) AT=1510.05n

.meas tran vdout1_7ck1500 FIND v(dout1_7) AT=1510.05n

.meas tran vdout1_8ck1500 FIND v(dout1_8) AT=1510.05n

.meas tran vdout1_9ck1500 FIND v(dout1_9) AT=1510.05n

.meas tran vdout1_10ck1500 FIND v(dout1_10) AT=1510.05n

.meas tran vdout1_11ck1500 FIND v(dout1_11) AT=1510.05n

.meas tran vdout1_12ck1500 FIND v(dout1_12) AT=1510.05n

.meas tran vdout1_13ck1500 FIND v(dout1_13) AT=1510.05n

.meas tran vdout1_14ck1500 FIND v(dout1_14) AT=1510.05n

.meas tran vdout1_15ck1500 FIND v(dout1_15) AT=1510.05n

.meas tran vdout1_16ck1500 FIND v(dout1_16) AT=1510.05n

.meas tran vdout1_0ck1510 FIND v(dout1_0) AT=1520.05n

.meas tran vdout1_1ck1510 FIND v(dout1_1) AT=1520.05n

.meas tran vdout1_2ck1510 FIND v(dout1_2) AT=1520.05n

.meas tran vdout1_3ck1510 FIND v(dout1_3) AT=1520.05n

.meas tran vdout1_4ck1510 FIND v(dout1_4) AT=1520.05n

.meas tran vdout1_5ck1510 FIND v(dout1_5) AT=1520.05n

.meas tran vdout1_6ck1510 FIND v(dout1_6) AT=1520.05n

.meas tran vdout1_7ck1510 FIND v(dout1_7) AT=1520.05n

.meas tran vdout1_8ck1510 FIND v(dout1_8) AT=1520.05n

.meas tran vdout1_9ck1510 FIND v(dout1_9) AT=1520.05n

.meas tran vdout1_10ck1510 FIND v(dout1_10) AT=1520.05n

.meas tran vdout1_11ck1510 FIND v(dout1_11) AT=1520.05n

.meas tran vdout1_12ck1510 FIND v(dout1_12) AT=1520.05n

.meas tran vdout1_13ck1510 FIND v(dout1_13) AT=1520.05n

.meas tran vdout1_14ck1510 FIND v(dout1_14) AT=1520.05n

.meas tran vdout1_15ck1510 FIND v(dout1_15) AT=1520.05n

.meas tran vdout1_16ck1510 FIND v(dout1_16) AT=1520.05n

.meas tran vdout1_0ck1530 FIND v(dout1_0) AT=1540.05n

.meas tran vdout1_1ck1530 FIND v(dout1_1) AT=1540.05n

.meas tran vdout1_2ck1530 FIND v(dout1_2) AT=1540.05n

.meas tran vdout1_3ck1530 FIND v(dout1_3) AT=1540.05n

.meas tran vdout1_4ck1530 FIND v(dout1_4) AT=1540.05n

.meas tran vdout1_5ck1530 FIND v(dout1_5) AT=1540.05n

.meas tran vdout1_6ck1530 FIND v(dout1_6) AT=1540.05n

.meas tran vdout1_7ck1530 FIND v(dout1_7) AT=1540.05n

.meas tran vdout1_8ck1530 FIND v(dout1_8) AT=1540.05n

.meas tran vdout1_9ck1530 FIND v(dout1_9) AT=1540.05n

.meas tran vdout1_10ck1530 FIND v(dout1_10) AT=1540.05n

.meas tran vdout1_11ck1530 FIND v(dout1_11) AT=1540.05n

.meas tran vdout1_12ck1530 FIND v(dout1_12) AT=1540.05n

.meas tran vdout1_13ck1530 FIND v(dout1_13) AT=1540.05n

.meas tran vdout1_14ck1530 FIND v(dout1_14) AT=1540.05n

.meas tran vdout1_15ck1530 FIND v(dout1_15) AT=1540.05n

.meas tran vdout1_16ck1530 FIND v(dout1_16) AT=1540.05n

.meas tran vdout1_0ck1600 FIND v(dout1_0) AT=1610.05n

.meas tran vdout1_1ck1600 FIND v(dout1_1) AT=1610.05n

.meas tran vdout1_2ck1600 FIND v(dout1_2) AT=1610.05n

.meas tran vdout1_3ck1600 FIND v(dout1_3) AT=1610.05n

.meas tran vdout1_4ck1600 FIND v(dout1_4) AT=1610.05n

.meas tran vdout1_5ck1600 FIND v(dout1_5) AT=1610.05n

.meas tran vdout1_6ck1600 FIND v(dout1_6) AT=1610.05n

.meas tran vdout1_7ck1600 FIND v(dout1_7) AT=1610.05n

.meas tran vdout1_8ck1600 FIND v(dout1_8) AT=1610.05n

.meas tran vdout1_9ck1600 FIND v(dout1_9) AT=1610.05n

.meas tran vdout1_10ck1600 FIND v(dout1_10) AT=1610.05n

.meas tran vdout1_11ck1600 FIND v(dout1_11) AT=1610.05n

.meas tran vdout1_12ck1600 FIND v(dout1_12) AT=1610.05n

.meas tran vdout1_13ck1600 FIND v(dout1_13) AT=1610.05n

.meas tran vdout1_14ck1600 FIND v(dout1_14) AT=1610.05n

.meas tran vdout1_15ck1600 FIND v(dout1_15) AT=1610.05n

.meas tran vdout1_16ck1600 FIND v(dout1_16) AT=1610.05n

.meas tran vdout1_0ck1610 FIND v(dout1_0) AT=1620.05n

.meas tran vdout1_1ck1610 FIND v(dout1_1) AT=1620.05n

.meas tran vdout1_2ck1610 FIND v(dout1_2) AT=1620.05n

.meas tran vdout1_3ck1610 FIND v(dout1_3) AT=1620.05n

.meas tran vdout1_4ck1610 FIND v(dout1_4) AT=1620.05n

.meas tran vdout1_5ck1610 FIND v(dout1_5) AT=1620.05n

.meas tran vdout1_6ck1610 FIND v(dout1_6) AT=1620.05n

.meas tran vdout1_7ck1610 FIND v(dout1_7) AT=1620.05n

.meas tran vdout1_8ck1610 FIND v(dout1_8) AT=1620.05n

.meas tran vdout1_9ck1610 FIND v(dout1_9) AT=1620.05n

.meas tran vdout1_10ck1610 FIND v(dout1_10) AT=1620.05n

.meas tran vdout1_11ck1610 FIND v(dout1_11) AT=1620.05n

.meas tran vdout1_12ck1610 FIND v(dout1_12) AT=1620.05n

.meas tran vdout1_13ck1610 FIND v(dout1_13) AT=1620.05n

.meas tran vdout1_14ck1610 FIND v(dout1_14) AT=1620.05n

.meas tran vdout1_15ck1610 FIND v(dout1_15) AT=1620.05n

.meas tran vdout1_16ck1610 FIND v(dout1_16) AT=1620.05n

.meas tran vdout1_0ck1650 FIND v(dout1_0) AT=1660.05n

.meas tran vdout1_1ck1650 FIND v(dout1_1) AT=1660.05n

.meas tran vdout1_2ck1650 FIND v(dout1_2) AT=1660.05n

.meas tran vdout1_3ck1650 FIND v(dout1_3) AT=1660.05n

.meas tran vdout1_4ck1650 FIND v(dout1_4) AT=1660.05n

.meas tran vdout1_5ck1650 FIND v(dout1_5) AT=1660.05n

.meas tran vdout1_6ck1650 FIND v(dout1_6) AT=1660.05n

.meas tran vdout1_7ck1650 FIND v(dout1_7) AT=1660.05n

.meas tran vdout1_8ck1650 FIND v(dout1_8) AT=1660.05n

.meas tran vdout1_9ck1650 FIND v(dout1_9) AT=1660.05n

.meas tran vdout1_10ck1650 FIND v(dout1_10) AT=1660.05n

.meas tran vdout1_11ck1650 FIND v(dout1_11) AT=1660.05n

.meas tran vdout1_12ck1650 FIND v(dout1_12) AT=1660.05n

.meas tran vdout1_13ck1650 FIND v(dout1_13) AT=1660.05n

.meas tran vdout1_14ck1650 FIND v(dout1_14) AT=1660.05n

.meas tran vdout1_15ck1650 FIND v(dout1_15) AT=1660.05n

.meas tran vdout1_16ck1650 FIND v(dout1_16) AT=1660.05n

.meas tran vdout1_0ck1770 FIND v(dout1_0) AT=1780.05n

.meas tran vdout1_1ck1770 FIND v(dout1_1) AT=1780.05n

.meas tran vdout1_2ck1770 FIND v(dout1_2) AT=1780.05n

.meas tran vdout1_3ck1770 FIND v(dout1_3) AT=1780.05n

.meas tran vdout1_4ck1770 FIND v(dout1_4) AT=1780.05n

.meas tran vdout1_5ck1770 FIND v(dout1_5) AT=1780.05n

.meas tran vdout1_6ck1770 FIND v(dout1_6) AT=1780.05n

.meas tran vdout1_7ck1770 FIND v(dout1_7) AT=1780.05n

.meas tran vdout1_8ck1770 FIND v(dout1_8) AT=1780.05n

.meas tran vdout1_9ck1770 FIND v(dout1_9) AT=1780.05n

.meas tran vdout1_10ck1770 FIND v(dout1_10) AT=1780.05n

.meas tran vdout1_11ck1770 FIND v(dout1_11) AT=1780.05n

.meas tran vdout1_12ck1770 FIND v(dout1_12) AT=1780.05n

.meas tran vdout1_13ck1770 FIND v(dout1_13) AT=1780.05n

.meas tran vdout1_14ck1770 FIND v(dout1_14) AT=1780.05n

.meas tran vdout1_15ck1770 FIND v(dout1_15) AT=1780.05n

.meas tran vdout1_16ck1770 FIND v(dout1_16) AT=1780.05n

.meas tran vdout1_0ck1810 FIND v(dout1_0) AT=1820.05n

.meas tran vdout1_1ck1810 FIND v(dout1_1) AT=1820.05n

.meas tran vdout1_2ck1810 FIND v(dout1_2) AT=1820.05n

.meas tran vdout1_3ck1810 FIND v(dout1_3) AT=1820.05n

.meas tran vdout1_4ck1810 FIND v(dout1_4) AT=1820.05n

.meas tran vdout1_5ck1810 FIND v(dout1_5) AT=1820.05n

.meas tran vdout1_6ck1810 FIND v(dout1_6) AT=1820.05n

.meas tran vdout1_7ck1810 FIND v(dout1_7) AT=1820.05n

.meas tran vdout1_8ck1810 FIND v(dout1_8) AT=1820.05n

.meas tran vdout1_9ck1810 FIND v(dout1_9) AT=1820.05n

.meas tran vdout1_10ck1810 FIND v(dout1_10) AT=1820.05n

.meas tran vdout1_11ck1810 FIND v(dout1_11) AT=1820.05n

.meas tran vdout1_12ck1810 FIND v(dout1_12) AT=1820.05n

.meas tran vdout1_13ck1810 FIND v(dout1_13) AT=1820.05n

.meas tran vdout1_14ck1810 FIND v(dout1_14) AT=1820.05n

.meas tran vdout1_15ck1810 FIND v(dout1_15) AT=1820.05n

.meas tran vdout1_16ck1810 FIND v(dout1_16) AT=1820.05n

.meas tran vdout1_0ck1830 FIND v(dout1_0) AT=1840.05n

.meas tran vdout1_1ck1830 FIND v(dout1_1) AT=1840.05n

.meas tran vdout1_2ck1830 FIND v(dout1_2) AT=1840.05n

.meas tran vdout1_3ck1830 FIND v(dout1_3) AT=1840.05n

.meas tran vdout1_4ck1830 FIND v(dout1_4) AT=1840.05n

.meas tran vdout1_5ck1830 FIND v(dout1_5) AT=1840.05n

.meas tran vdout1_6ck1830 FIND v(dout1_6) AT=1840.05n

.meas tran vdout1_7ck1830 FIND v(dout1_7) AT=1840.05n

.meas tran vdout1_8ck1830 FIND v(dout1_8) AT=1840.05n

.meas tran vdout1_9ck1830 FIND v(dout1_9) AT=1840.05n

.meas tran vdout1_10ck1830 FIND v(dout1_10) AT=1840.05n

.meas tran vdout1_11ck1830 FIND v(dout1_11) AT=1840.05n

.meas tran vdout1_12ck1830 FIND v(dout1_12) AT=1840.05n

.meas tran vdout1_13ck1830 FIND v(dout1_13) AT=1840.05n

.meas tran vdout1_14ck1830 FIND v(dout1_14) AT=1840.05n

.meas tran vdout1_15ck1830 FIND v(dout1_15) AT=1840.05n

.meas tran vdout1_16ck1830 FIND v(dout1_16) AT=1840.05n

.meas tran vdout1_0ck1860 FIND v(dout1_0) AT=1870.05n

.meas tran vdout1_1ck1860 FIND v(dout1_1) AT=1870.05n

.meas tran vdout1_2ck1860 FIND v(dout1_2) AT=1870.05n

.meas tran vdout1_3ck1860 FIND v(dout1_3) AT=1870.05n

.meas tran vdout1_4ck1860 FIND v(dout1_4) AT=1870.05n

.meas tran vdout1_5ck1860 FIND v(dout1_5) AT=1870.05n

.meas tran vdout1_6ck1860 FIND v(dout1_6) AT=1870.05n

.meas tran vdout1_7ck1860 FIND v(dout1_7) AT=1870.05n

.meas tran vdout1_8ck1860 FIND v(dout1_8) AT=1870.05n

.meas tran vdout1_9ck1860 FIND v(dout1_9) AT=1870.05n

.meas tran vdout1_10ck1860 FIND v(dout1_10) AT=1870.05n

.meas tran vdout1_11ck1860 FIND v(dout1_11) AT=1870.05n

.meas tran vdout1_12ck1860 FIND v(dout1_12) AT=1870.05n

.meas tran vdout1_13ck1860 FIND v(dout1_13) AT=1870.05n

.meas tran vdout1_14ck1860 FIND v(dout1_14) AT=1870.05n

.meas tran vdout1_15ck1860 FIND v(dout1_15) AT=1870.05n

.meas tran vdout1_16ck1860 FIND v(dout1_16) AT=1870.05n

.meas tran vdout1_0ck1900 FIND v(dout1_0) AT=1910.05n

.meas tran vdout1_1ck1900 FIND v(dout1_1) AT=1910.05n

.meas tran vdout1_2ck1900 FIND v(dout1_2) AT=1910.05n

.meas tran vdout1_3ck1900 FIND v(dout1_3) AT=1910.05n

.meas tran vdout1_4ck1900 FIND v(dout1_4) AT=1910.05n

.meas tran vdout1_5ck1900 FIND v(dout1_5) AT=1910.05n

.meas tran vdout1_6ck1900 FIND v(dout1_6) AT=1910.05n

.meas tran vdout1_7ck1900 FIND v(dout1_7) AT=1910.05n

.meas tran vdout1_8ck1900 FIND v(dout1_8) AT=1910.05n

.meas tran vdout1_9ck1900 FIND v(dout1_9) AT=1910.05n

.meas tran vdout1_10ck1900 FIND v(dout1_10) AT=1910.05n

.meas tran vdout1_11ck1900 FIND v(dout1_11) AT=1910.05n

.meas tran vdout1_12ck1900 FIND v(dout1_12) AT=1910.05n

.meas tran vdout1_13ck1900 FIND v(dout1_13) AT=1910.05n

.meas tran vdout1_14ck1900 FIND v(dout1_14) AT=1910.05n

.meas tran vdout1_15ck1900 FIND v(dout1_15) AT=1910.05n

.meas tran vdout1_16ck1900 FIND v(dout1_16) AT=1910.05n

.meas tran vdout1_0ck1920 FIND v(dout1_0) AT=1930.05n

.meas tran vdout1_1ck1920 FIND v(dout1_1) AT=1930.05n

.meas tran vdout1_2ck1920 FIND v(dout1_2) AT=1930.05n

.meas tran vdout1_3ck1920 FIND v(dout1_3) AT=1930.05n

.meas tran vdout1_4ck1920 FIND v(dout1_4) AT=1930.05n

.meas tran vdout1_5ck1920 FIND v(dout1_5) AT=1930.05n

.meas tran vdout1_6ck1920 FIND v(dout1_6) AT=1930.05n

.meas tran vdout1_7ck1920 FIND v(dout1_7) AT=1930.05n

.meas tran vdout1_8ck1920 FIND v(dout1_8) AT=1930.05n

.meas tran vdout1_9ck1920 FIND v(dout1_9) AT=1930.05n

.meas tran vdout1_10ck1920 FIND v(dout1_10) AT=1930.05n

.meas tran vdout1_11ck1920 FIND v(dout1_11) AT=1930.05n

.meas tran vdout1_12ck1920 FIND v(dout1_12) AT=1930.05n

.meas tran vdout1_13ck1920 FIND v(dout1_13) AT=1930.05n

.meas tran vdout1_14ck1920 FIND v(dout1_14) AT=1930.05n

.meas tran vdout1_15ck1920 FIND v(dout1_15) AT=1930.05n

.meas tran vdout1_16ck1920 FIND v(dout1_16) AT=1930.05n

.meas tran vdout1_0ck1940 FIND v(dout1_0) AT=1950.05n

.meas tran vdout1_1ck1940 FIND v(dout1_1) AT=1950.05n

.meas tran vdout1_2ck1940 FIND v(dout1_2) AT=1950.05n

.meas tran vdout1_3ck1940 FIND v(dout1_3) AT=1950.05n

.meas tran vdout1_4ck1940 FIND v(dout1_4) AT=1950.05n

.meas tran vdout1_5ck1940 FIND v(dout1_5) AT=1950.05n

.meas tran vdout1_6ck1940 FIND v(dout1_6) AT=1950.05n

.meas tran vdout1_7ck1940 FIND v(dout1_7) AT=1950.05n

.meas tran vdout1_8ck1940 FIND v(dout1_8) AT=1950.05n

.meas tran vdout1_9ck1940 FIND v(dout1_9) AT=1950.05n

.meas tran vdout1_10ck1940 FIND v(dout1_10) AT=1950.05n

.meas tran vdout1_11ck1940 FIND v(dout1_11) AT=1950.05n

.meas tran vdout1_12ck1940 FIND v(dout1_12) AT=1950.05n

.meas tran vdout1_13ck1940 FIND v(dout1_13) AT=1950.05n

.meas tran vdout1_14ck1940 FIND v(dout1_14) AT=1950.05n

.meas tran vdout1_15ck1940 FIND v(dout1_15) AT=1950.05n

.meas tran vdout1_16ck1940 FIND v(dout1_16) AT=1950.05n

.meas tran vdout1_0ck1960 FIND v(dout1_0) AT=1970.05n

.meas tran vdout1_1ck1960 FIND v(dout1_1) AT=1970.05n

.meas tran vdout1_2ck1960 FIND v(dout1_2) AT=1970.05n

.meas tran vdout1_3ck1960 FIND v(dout1_3) AT=1970.05n

.meas tran vdout1_4ck1960 FIND v(dout1_4) AT=1970.05n

.meas tran vdout1_5ck1960 FIND v(dout1_5) AT=1970.05n

.meas tran vdout1_6ck1960 FIND v(dout1_6) AT=1970.05n

.meas tran vdout1_7ck1960 FIND v(dout1_7) AT=1970.05n

.meas tran vdout1_8ck1960 FIND v(dout1_8) AT=1970.05n

.meas tran vdout1_9ck1960 FIND v(dout1_9) AT=1970.05n

.meas tran vdout1_10ck1960 FIND v(dout1_10) AT=1970.05n

.meas tran vdout1_11ck1960 FIND v(dout1_11) AT=1970.05n

.meas tran vdout1_12ck1960 FIND v(dout1_12) AT=1970.05n

.meas tran vdout1_13ck1960 FIND v(dout1_13) AT=1970.05n

.meas tran vdout1_14ck1960 FIND v(dout1_14) AT=1970.05n

.meas tran vdout1_15ck1960 FIND v(dout1_15) AT=1970.05n

.meas tran vdout1_16ck1960 FIND v(dout1_16) AT=1970.05n

.meas tran vdout1_0ck1980 FIND v(dout1_0) AT=1990.05n

.meas tran vdout1_1ck1980 FIND v(dout1_1) AT=1990.05n

.meas tran vdout1_2ck1980 FIND v(dout1_2) AT=1990.05n

.meas tran vdout1_3ck1980 FIND v(dout1_3) AT=1990.05n

.meas tran vdout1_4ck1980 FIND v(dout1_4) AT=1990.05n

.meas tran vdout1_5ck1980 FIND v(dout1_5) AT=1990.05n

.meas tran vdout1_6ck1980 FIND v(dout1_6) AT=1990.05n

.meas tran vdout1_7ck1980 FIND v(dout1_7) AT=1990.05n

.meas tran vdout1_8ck1980 FIND v(dout1_8) AT=1990.05n

.meas tran vdout1_9ck1980 FIND v(dout1_9) AT=1990.05n

.meas tran vdout1_10ck1980 FIND v(dout1_10) AT=1990.05n

.meas tran vdout1_11ck1980 FIND v(dout1_11) AT=1990.05n

.meas tran vdout1_12ck1980 FIND v(dout1_12) AT=1990.05n

.meas tran vdout1_13ck1980 FIND v(dout1_13) AT=1990.05n

.meas tran vdout1_14ck1980 FIND v(dout1_14) AT=1990.05n

.meas tran vdout1_15ck1980 FIND v(dout1_15) AT=1990.05n

.meas tran vdout1_16ck1980 FIND v(dout1_16) AT=1990.05n

.meas tran vdout1_0ck2010 FIND v(dout1_0) AT=2020.05n

.meas tran vdout1_1ck2010 FIND v(dout1_1) AT=2020.05n

.meas tran vdout1_2ck2010 FIND v(dout1_2) AT=2020.05n

.meas tran vdout1_3ck2010 FIND v(dout1_3) AT=2020.05n

.meas tran vdout1_4ck2010 FIND v(dout1_4) AT=2020.05n

.meas tran vdout1_5ck2010 FIND v(dout1_5) AT=2020.05n

.meas tran vdout1_6ck2010 FIND v(dout1_6) AT=2020.05n

.meas tran vdout1_7ck2010 FIND v(dout1_7) AT=2020.05n

.meas tran vdout1_8ck2010 FIND v(dout1_8) AT=2020.05n

.meas tran vdout1_9ck2010 FIND v(dout1_9) AT=2020.05n

.meas tran vdout1_10ck2010 FIND v(dout1_10) AT=2020.05n

.meas tran vdout1_11ck2010 FIND v(dout1_11) AT=2020.05n

.meas tran vdout1_12ck2010 FIND v(dout1_12) AT=2020.05n

.meas tran vdout1_13ck2010 FIND v(dout1_13) AT=2020.05n

.meas tran vdout1_14ck2010 FIND v(dout1_14) AT=2020.05n

.meas tran vdout1_15ck2010 FIND v(dout1_15) AT=2020.05n

.meas tran vdout1_16ck2010 FIND v(dout1_16) AT=2020.05n
