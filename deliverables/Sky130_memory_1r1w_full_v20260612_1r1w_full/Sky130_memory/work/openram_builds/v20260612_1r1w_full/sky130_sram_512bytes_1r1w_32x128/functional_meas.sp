.meas tran vdout1_0ck40 FIND v(dout1_0) AT=50.05n

.meas tran vdout1_1ck40 FIND v(dout1_1) AT=50.05n

.meas tran vdout1_2ck40 FIND v(dout1_2) AT=50.05n

.meas tran vdout1_3ck40 FIND v(dout1_3) AT=50.05n

.meas tran vdout1_4ck40 FIND v(dout1_4) AT=50.05n

.meas tran vdout1_5ck40 FIND v(dout1_5) AT=50.05n

.meas tran vdout1_6ck40 FIND v(dout1_6) AT=50.05n

.meas tran vdout1_7ck40 FIND v(dout1_7) AT=50.05n

.meas tran vdout1_8ck40 FIND v(dout1_8) AT=50.05n

.meas tran vdout1_9ck40 FIND v(dout1_9) AT=50.05n

.meas tran vdout1_10ck40 FIND v(dout1_10) AT=50.05n

.meas tran vdout1_11ck40 FIND v(dout1_11) AT=50.05n

.meas tran vdout1_12ck40 FIND v(dout1_12) AT=50.05n

.meas tran vdout1_13ck40 FIND v(dout1_13) AT=50.05n

.meas tran vdout1_14ck40 FIND v(dout1_14) AT=50.05n

.meas tran vdout1_15ck40 FIND v(dout1_15) AT=50.05n

.meas tran vdout1_16ck40 FIND v(dout1_16) AT=50.05n

.meas tran vdout1_17ck40 FIND v(dout1_17) AT=50.05n

.meas tran vdout1_18ck40 FIND v(dout1_18) AT=50.05n

.meas tran vdout1_19ck40 FIND v(dout1_19) AT=50.05n

.meas tran vdout1_20ck40 FIND v(dout1_20) AT=50.05n

.meas tran vdout1_21ck40 FIND v(dout1_21) AT=50.05n

.meas tran vdout1_22ck40 FIND v(dout1_22) AT=50.05n

.meas tran vdout1_23ck40 FIND v(dout1_23) AT=50.05n

.meas tran vdout1_24ck40 FIND v(dout1_24) AT=50.05n

.meas tran vdout1_25ck40 FIND v(dout1_25) AT=50.05n

.meas tran vdout1_26ck40 FIND v(dout1_26) AT=50.05n

.meas tran vdout1_27ck40 FIND v(dout1_27) AT=50.05n

.meas tran vdout1_28ck40 FIND v(dout1_28) AT=50.05n

.meas tran vdout1_29ck40 FIND v(dout1_29) AT=50.05n

.meas tran vdout1_30ck40 FIND v(dout1_30) AT=50.05n

.meas tran vdout1_31ck40 FIND v(dout1_31) AT=50.05n

.meas tran vdout1_32ck40 FIND v(dout1_32) AT=50.05n

.meas tran vdout1_0ck50 FIND v(dout1_0) AT=60.05n

.meas tran vdout1_1ck50 FIND v(dout1_1) AT=60.05n

.meas tran vdout1_2ck50 FIND v(dout1_2) AT=60.05n

.meas tran vdout1_3ck50 FIND v(dout1_3) AT=60.05n

.meas tran vdout1_4ck50 FIND v(dout1_4) AT=60.05n

.meas tran vdout1_5ck50 FIND v(dout1_5) AT=60.05n

.meas tran vdout1_6ck50 FIND v(dout1_6) AT=60.05n

.meas tran vdout1_7ck50 FIND v(dout1_7) AT=60.05n

.meas tran vdout1_8ck50 FIND v(dout1_8) AT=60.05n

.meas tran vdout1_9ck50 FIND v(dout1_9) AT=60.05n

.meas tran vdout1_10ck50 FIND v(dout1_10) AT=60.05n

.meas tran vdout1_11ck50 FIND v(dout1_11) AT=60.05n

.meas tran vdout1_12ck50 FIND v(dout1_12) AT=60.05n

.meas tran vdout1_13ck50 FIND v(dout1_13) AT=60.05n

.meas tran vdout1_14ck50 FIND v(dout1_14) AT=60.05n

.meas tran vdout1_15ck50 FIND v(dout1_15) AT=60.05n

.meas tran vdout1_16ck50 FIND v(dout1_16) AT=60.05n

.meas tran vdout1_17ck50 FIND v(dout1_17) AT=60.05n

.meas tran vdout1_18ck50 FIND v(dout1_18) AT=60.05n

.meas tran vdout1_19ck50 FIND v(dout1_19) AT=60.05n

.meas tran vdout1_20ck50 FIND v(dout1_20) AT=60.05n

.meas tran vdout1_21ck50 FIND v(dout1_21) AT=60.05n

.meas tran vdout1_22ck50 FIND v(dout1_22) AT=60.05n

.meas tran vdout1_23ck50 FIND v(dout1_23) AT=60.05n

.meas tran vdout1_24ck50 FIND v(dout1_24) AT=60.05n

.meas tran vdout1_25ck50 FIND v(dout1_25) AT=60.05n

.meas tran vdout1_26ck50 FIND v(dout1_26) AT=60.05n

.meas tran vdout1_27ck50 FIND v(dout1_27) AT=60.05n

.meas tran vdout1_28ck50 FIND v(dout1_28) AT=60.05n

.meas tran vdout1_29ck50 FIND v(dout1_29) AT=60.05n

.meas tran vdout1_30ck50 FIND v(dout1_30) AT=60.05n

.meas tran vdout1_31ck50 FIND v(dout1_31) AT=60.05n

.meas tran vdout1_32ck50 FIND v(dout1_32) AT=60.05n

.meas tran vdout1_0ck100 FIND v(dout1_0) AT=110.05n

.meas tran vdout1_1ck100 FIND v(dout1_1) AT=110.05n

.meas tran vdout1_2ck100 FIND v(dout1_2) AT=110.05n

.meas tran vdout1_3ck100 FIND v(dout1_3) AT=110.05n

.meas tran vdout1_4ck100 FIND v(dout1_4) AT=110.05n

.meas tran vdout1_5ck100 FIND v(dout1_5) AT=110.05n

.meas tran vdout1_6ck100 FIND v(dout1_6) AT=110.05n

.meas tran vdout1_7ck100 FIND v(dout1_7) AT=110.05n

.meas tran vdout1_8ck100 FIND v(dout1_8) AT=110.05n

.meas tran vdout1_9ck100 FIND v(dout1_9) AT=110.05n

.meas tran vdout1_10ck100 FIND v(dout1_10) AT=110.05n

.meas tran vdout1_11ck100 FIND v(dout1_11) AT=110.05n

.meas tran vdout1_12ck100 FIND v(dout1_12) AT=110.05n

.meas tran vdout1_13ck100 FIND v(dout1_13) AT=110.05n

.meas tran vdout1_14ck100 FIND v(dout1_14) AT=110.05n

.meas tran vdout1_15ck100 FIND v(dout1_15) AT=110.05n

.meas tran vdout1_16ck100 FIND v(dout1_16) AT=110.05n

.meas tran vdout1_17ck100 FIND v(dout1_17) AT=110.05n

.meas tran vdout1_18ck100 FIND v(dout1_18) AT=110.05n

.meas tran vdout1_19ck100 FIND v(dout1_19) AT=110.05n

.meas tran vdout1_20ck100 FIND v(dout1_20) AT=110.05n

.meas tran vdout1_21ck100 FIND v(dout1_21) AT=110.05n

.meas tran vdout1_22ck100 FIND v(dout1_22) AT=110.05n

.meas tran vdout1_23ck100 FIND v(dout1_23) AT=110.05n

.meas tran vdout1_24ck100 FIND v(dout1_24) AT=110.05n

.meas tran vdout1_25ck100 FIND v(dout1_25) AT=110.05n

.meas tran vdout1_26ck100 FIND v(dout1_26) AT=110.05n

.meas tran vdout1_27ck100 FIND v(dout1_27) AT=110.05n

.meas tran vdout1_28ck100 FIND v(dout1_28) AT=110.05n

.meas tran vdout1_29ck100 FIND v(dout1_29) AT=110.05n

.meas tran vdout1_30ck100 FIND v(dout1_30) AT=110.05n

.meas tran vdout1_31ck100 FIND v(dout1_31) AT=110.05n

.meas tran vdout1_32ck100 FIND v(dout1_32) AT=110.05n

.meas tran vdout1_0ck130 FIND v(dout1_0) AT=140.05n

.meas tran vdout1_1ck130 FIND v(dout1_1) AT=140.05n

.meas tran vdout1_2ck130 FIND v(dout1_2) AT=140.05n

.meas tran vdout1_3ck130 FIND v(dout1_3) AT=140.05n

.meas tran vdout1_4ck130 FIND v(dout1_4) AT=140.05n

.meas tran vdout1_5ck130 FIND v(dout1_5) AT=140.05n

.meas tran vdout1_6ck130 FIND v(dout1_6) AT=140.05n

.meas tran vdout1_7ck130 FIND v(dout1_7) AT=140.05n

.meas tran vdout1_8ck130 FIND v(dout1_8) AT=140.05n

.meas tran vdout1_9ck130 FIND v(dout1_9) AT=140.05n

.meas tran vdout1_10ck130 FIND v(dout1_10) AT=140.05n

.meas tran vdout1_11ck130 FIND v(dout1_11) AT=140.05n

.meas tran vdout1_12ck130 FIND v(dout1_12) AT=140.05n

.meas tran vdout1_13ck130 FIND v(dout1_13) AT=140.05n

.meas tran vdout1_14ck130 FIND v(dout1_14) AT=140.05n

.meas tran vdout1_15ck130 FIND v(dout1_15) AT=140.05n

.meas tran vdout1_16ck130 FIND v(dout1_16) AT=140.05n

.meas tran vdout1_17ck130 FIND v(dout1_17) AT=140.05n

.meas tran vdout1_18ck130 FIND v(dout1_18) AT=140.05n

.meas tran vdout1_19ck130 FIND v(dout1_19) AT=140.05n

.meas tran vdout1_20ck130 FIND v(dout1_20) AT=140.05n

.meas tran vdout1_21ck130 FIND v(dout1_21) AT=140.05n

.meas tran vdout1_22ck130 FIND v(dout1_22) AT=140.05n

.meas tran vdout1_23ck130 FIND v(dout1_23) AT=140.05n

.meas tran vdout1_24ck130 FIND v(dout1_24) AT=140.05n

.meas tran vdout1_25ck130 FIND v(dout1_25) AT=140.05n

.meas tran vdout1_26ck130 FIND v(dout1_26) AT=140.05n

.meas tran vdout1_27ck130 FIND v(dout1_27) AT=140.05n

.meas tran vdout1_28ck130 FIND v(dout1_28) AT=140.05n

.meas tran vdout1_29ck130 FIND v(dout1_29) AT=140.05n

.meas tran vdout1_30ck130 FIND v(dout1_30) AT=140.05n

.meas tran vdout1_31ck130 FIND v(dout1_31) AT=140.05n

.meas tran vdout1_32ck130 FIND v(dout1_32) AT=140.05n

.meas tran vdout1_0ck140 FIND v(dout1_0) AT=150.05n

.meas tran vdout1_1ck140 FIND v(dout1_1) AT=150.05n

.meas tran vdout1_2ck140 FIND v(dout1_2) AT=150.05n

.meas tran vdout1_3ck140 FIND v(dout1_3) AT=150.05n

.meas tran vdout1_4ck140 FIND v(dout1_4) AT=150.05n

.meas tran vdout1_5ck140 FIND v(dout1_5) AT=150.05n

.meas tran vdout1_6ck140 FIND v(dout1_6) AT=150.05n

.meas tran vdout1_7ck140 FIND v(dout1_7) AT=150.05n

.meas tran vdout1_8ck140 FIND v(dout1_8) AT=150.05n

.meas tran vdout1_9ck140 FIND v(dout1_9) AT=150.05n

.meas tran vdout1_10ck140 FIND v(dout1_10) AT=150.05n

.meas tran vdout1_11ck140 FIND v(dout1_11) AT=150.05n

.meas tran vdout1_12ck140 FIND v(dout1_12) AT=150.05n

.meas tran vdout1_13ck140 FIND v(dout1_13) AT=150.05n

.meas tran vdout1_14ck140 FIND v(dout1_14) AT=150.05n

.meas tran vdout1_15ck140 FIND v(dout1_15) AT=150.05n

.meas tran vdout1_16ck140 FIND v(dout1_16) AT=150.05n

.meas tran vdout1_17ck140 FIND v(dout1_17) AT=150.05n

.meas tran vdout1_18ck140 FIND v(dout1_18) AT=150.05n

.meas tran vdout1_19ck140 FIND v(dout1_19) AT=150.05n

.meas tran vdout1_20ck140 FIND v(dout1_20) AT=150.05n

.meas tran vdout1_21ck140 FIND v(dout1_21) AT=150.05n

.meas tran vdout1_22ck140 FIND v(dout1_22) AT=150.05n

.meas tran vdout1_23ck140 FIND v(dout1_23) AT=150.05n

.meas tran vdout1_24ck140 FIND v(dout1_24) AT=150.05n

.meas tran vdout1_25ck140 FIND v(dout1_25) AT=150.05n

.meas tran vdout1_26ck140 FIND v(dout1_26) AT=150.05n

.meas tran vdout1_27ck140 FIND v(dout1_27) AT=150.05n

.meas tran vdout1_28ck140 FIND v(dout1_28) AT=150.05n

.meas tran vdout1_29ck140 FIND v(dout1_29) AT=150.05n

.meas tran vdout1_30ck140 FIND v(dout1_30) AT=150.05n

.meas tran vdout1_31ck140 FIND v(dout1_31) AT=150.05n

.meas tran vdout1_32ck140 FIND v(dout1_32) AT=150.05n

.meas tran vdout1_0ck150 FIND v(dout1_0) AT=160.05n

.meas tran vdout1_1ck150 FIND v(dout1_1) AT=160.05n

.meas tran vdout1_2ck150 FIND v(dout1_2) AT=160.05n

.meas tran vdout1_3ck150 FIND v(dout1_3) AT=160.05n

.meas tran vdout1_4ck150 FIND v(dout1_4) AT=160.05n

.meas tran vdout1_5ck150 FIND v(dout1_5) AT=160.05n

.meas tran vdout1_6ck150 FIND v(dout1_6) AT=160.05n

.meas tran vdout1_7ck150 FIND v(dout1_7) AT=160.05n

.meas tran vdout1_8ck150 FIND v(dout1_8) AT=160.05n

.meas tran vdout1_9ck150 FIND v(dout1_9) AT=160.05n

.meas tran vdout1_10ck150 FIND v(dout1_10) AT=160.05n

.meas tran vdout1_11ck150 FIND v(dout1_11) AT=160.05n

.meas tran vdout1_12ck150 FIND v(dout1_12) AT=160.05n

.meas tran vdout1_13ck150 FIND v(dout1_13) AT=160.05n

.meas tran vdout1_14ck150 FIND v(dout1_14) AT=160.05n

.meas tran vdout1_15ck150 FIND v(dout1_15) AT=160.05n

.meas tran vdout1_16ck150 FIND v(dout1_16) AT=160.05n

.meas tran vdout1_17ck150 FIND v(dout1_17) AT=160.05n

.meas tran vdout1_18ck150 FIND v(dout1_18) AT=160.05n

.meas tran vdout1_19ck150 FIND v(dout1_19) AT=160.05n

.meas tran vdout1_20ck150 FIND v(dout1_20) AT=160.05n

.meas tran vdout1_21ck150 FIND v(dout1_21) AT=160.05n

.meas tran vdout1_22ck150 FIND v(dout1_22) AT=160.05n

.meas tran vdout1_23ck150 FIND v(dout1_23) AT=160.05n

.meas tran vdout1_24ck150 FIND v(dout1_24) AT=160.05n

.meas tran vdout1_25ck150 FIND v(dout1_25) AT=160.05n

.meas tran vdout1_26ck150 FIND v(dout1_26) AT=160.05n

.meas tran vdout1_27ck150 FIND v(dout1_27) AT=160.05n

.meas tran vdout1_28ck150 FIND v(dout1_28) AT=160.05n

.meas tran vdout1_29ck150 FIND v(dout1_29) AT=160.05n

.meas tran vdout1_30ck150 FIND v(dout1_30) AT=160.05n

.meas tran vdout1_31ck150 FIND v(dout1_31) AT=160.05n

.meas tran vdout1_32ck150 FIND v(dout1_32) AT=160.05n

.meas tran vdout1_0ck180 FIND v(dout1_0) AT=190.05n

.meas tran vdout1_1ck180 FIND v(dout1_1) AT=190.05n

.meas tran vdout1_2ck180 FIND v(dout1_2) AT=190.05n

.meas tran vdout1_3ck180 FIND v(dout1_3) AT=190.05n

.meas tran vdout1_4ck180 FIND v(dout1_4) AT=190.05n

.meas tran vdout1_5ck180 FIND v(dout1_5) AT=190.05n

.meas tran vdout1_6ck180 FIND v(dout1_6) AT=190.05n

.meas tran vdout1_7ck180 FIND v(dout1_7) AT=190.05n

.meas tran vdout1_8ck180 FIND v(dout1_8) AT=190.05n

.meas tran vdout1_9ck180 FIND v(dout1_9) AT=190.05n

.meas tran vdout1_10ck180 FIND v(dout1_10) AT=190.05n

.meas tran vdout1_11ck180 FIND v(dout1_11) AT=190.05n

.meas tran vdout1_12ck180 FIND v(dout1_12) AT=190.05n

.meas tran vdout1_13ck180 FIND v(dout1_13) AT=190.05n

.meas tran vdout1_14ck180 FIND v(dout1_14) AT=190.05n

.meas tran vdout1_15ck180 FIND v(dout1_15) AT=190.05n

.meas tran vdout1_16ck180 FIND v(dout1_16) AT=190.05n

.meas tran vdout1_17ck180 FIND v(dout1_17) AT=190.05n

.meas tran vdout1_18ck180 FIND v(dout1_18) AT=190.05n

.meas tran vdout1_19ck180 FIND v(dout1_19) AT=190.05n

.meas tran vdout1_20ck180 FIND v(dout1_20) AT=190.05n

.meas tran vdout1_21ck180 FIND v(dout1_21) AT=190.05n

.meas tran vdout1_22ck180 FIND v(dout1_22) AT=190.05n

.meas tran vdout1_23ck180 FIND v(dout1_23) AT=190.05n

.meas tran vdout1_24ck180 FIND v(dout1_24) AT=190.05n

.meas tran vdout1_25ck180 FIND v(dout1_25) AT=190.05n

.meas tran vdout1_26ck180 FIND v(dout1_26) AT=190.05n

.meas tran vdout1_27ck180 FIND v(dout1_27) AT=190.05n

.meas tran vdout1_28ck180 FIND v(dout1_28) AT=190.05n

.meas tran vdout1_29ck180 FIND v(dout1_29) AT=190.05n

.meas tran vdout1_30ck180 FIND v(dout1_30) AT=190.05n

.meas tran vdout1_31ck180 FIND v(dout1_31) AT=190.05n

.meas tran vdout1_32ck180 FIND v(dout1_32) AT=190.05n

.meas tran vdout1_0ck190 FIND v(dout1_0) AT=200.05n

.meas tran vdout1_1ck190 FIND v(dout1_1) AT=200.05n

.meas tran vdout1_2ck190 FIND v(dout1_2) AT=200.05n

.meas tran vdout1_3ck190 FIND v(dout1_3) AT=200.05n

.meas tran vdout1_4ck190 FIND v(dout1_4) AT=200.05n

.meas tran vdout1_5ck190 FIND v(dout1_5) AT=200.05n

.meas tran vdout1_6ck190 FIND v(dout1_6) AT=200.05n

.meas tran vdout1_7ck190 FIND v(dout1_7) AT=200.05n

.meas tran vdout1_8ck190 FIND v(dout1_8) AT=200.05n

.meas tran vdout1_9ck190 FIND v(dout1_9) AT=200.05n

.meas tran vdout1_10ck190 FIND v(dout1_10) AT=200.05n

.meas tran vdout1_11ck190 FIND v(dout1_11) AT=200.05n

.meas tran vdout1_12ck190 FIND v(dout1_12) AT=200.05n

.meas tran vdout1_13ck190 FIND v(dout1_13) AT=200.05n

.meas tran vdout1_14ck190 FIND v(dout1_14) AT=200.05n

.meas tran vdout1_15ck190 FIND v(dout1_15) AT=200.05n

.meas tran vdout1_16ck190 FIND v(dout1_16) AT=200.05n

.meas tran vdout1_17ck190 FIND v(dout1_17) AT=200.05n

.meas tran vdout1_18ck190 FIND v(dout1_18) AT=200.05n

.meas tran vdout1_19ck190 FIND v(dout1_19) AT=200.05n

.meas tran vdout1_20ck190 FIND v(dout1_20) AT=200.05n

.meas tran vdout1_21ck190 FIND v(dout1_21) AT=200.05n

.meas tran vdout1_22ck190 FIND v(dout1_22) AT=200.05n

.meas tran vdout1_23ck190 FIND v(dout1_23) AT=200.05n

.meas tran vdout1_24ck190 FIND v(dout1_24) AT=200.05n

.meas tran vdout1_25ck190 FIND v(dout1_25) AT=200.05n

.meas tran vdout1_26ck190 FIND v(dout1_26) AT=200.05n

.meas tran vdout1_27ck190 FIND v(dout1_27) AT=200.05n

.meas tran vdout1_28ck190 FIND v(dout1_28) AT=200.05n

.meas tran vdout1_29ck190 FIND v(dout1_29) AT=200.05n

.meas tran vdout1_30ck190 FIND v(dout1_30) AT=200.05n

.meas tran vdout1_31ck190 FIND v(dout1_31) AT=200.05n

.meas tran vdout1_32ck190 FIND v(dout1_32) AT=200.05n

.meas tran vdout1_0ck200 FIND v(dout1_0) AT=210.05n

.meas tran vdout1_1ck200 FIND v(dout1_1) AT=210.05n

.meas tran vdout1_2ck200 FIND v(dout1_2) AT=210.05n

.meas tran vdout1_3ck200 FIND v(dout1_3) AT=210.05n

.meas tran vdout1_4ck200 FIND v(dout1_4) AT=210.05n

.meas tran vdout1_5ck200 FIND v(dout1_5) AT=210.05n

.meas tran vdout1_6ck200 FIND v(dout1_6) AT=210.05n

.meas tran vdout1_7ck200 FIND v(dout1_7) AT=210.05n

.meas tran vdout1_8ck200 FIND v(dout1_8) AT=210.05n

.meas tran vdout1_9ck200 FIND v(dout1_9) AT=210.05n

.meas tran vdout1_10ck200 FIND v(dout1_10) AT=210.05n

.meas tran vdout1_11ck200 FIND v(dout1_11) AT=210.05n

.meas tran vdout1_12ck200 FIND v(dout1_12) AT=210.05n

.meas tran vdout1_13ck200 FIND v(dout1_13) AT=210.05n

.meas tran vdout1_14ck200 FIND v(dout1_14) AT=210.05n

.meas tran vdout1_15ck200 FIND v(dout1_15) AT=210.05n

.meas tran vdout1_16ck200 FIND v(dout1_16) AT=210.05n

.meas tran vdout1_17ck200 FIND v(dout1_17) AT=210.05n

.meas tran vdout1_18ck200 FIND v(dout1_18) AT=210.05n

.meas tran vdout1_19ck200 FIND v(dout1_19) AT=210.05n

.meas tran vdout1_20ck200 FIND v(dout1_20) AT=210.05n

.meas tran vdout1_21ck200 FIND v(dout1_21) AT=210.05n

.meas tran vdout1_22ck200 FIND v(dout1_22) AT=210.05n

.meas tran vdout1_23ck200 FIND v(dout1_23) AT=210.05n

.meas tran vdout1_24ck200 FIND v(dout1_24) AT=210.05n

.meas tran vdout1_25ck200 FIND v(dout1_25) AT=210.05n

.meas tran vdout1_26ck200 FIND v(dout1_26) AT=210.05n

.meas tran vdout1_27ck200 FIND v(dout1_27) AT=210.05n

.meas tran vdout1_28ck200 FIND v(dout1_28) AT=210.05n

.meas tran vdout1_29ck200 FIND v(dout1_29) AT=210.05n

.meas tran vdout1_30ck200 FIND v(dout1_30) AT=210.05n

.meas tran vdout1_31ck200 FIND v(dout1_31) AT=210.05n

.meas tran vdout1_32ck200 FIND v(dout1_32) AT=210.05n

.meas tran vdout1_0ck220 FIND v(dout1_0) AT=230.05n

.meas tran vdout1_1ck220 FIND v(dout1_1) AT=230.05n

.meas tran vdout1_2ck220 FIND v(dout1_2) AT=230.05n

.meas tran vdout1_3ck220 FIND v(dout1_3) AT=230.05n

.meas tran vdout1_4ck220 FIND v(dout1_4) AT=230.05n

.meas tran vdout1_5ck220 FIND v(dout1_5) AT=230.05n

.meas tran vdout1_6ck220 FIND v(dout1_6) AT=230.05n

.meas tran vdout1_7ck220 FIND v(dout1_7) AT=230.05n

.meas tran vdout1_8ck220 FIND v(dout1_8) AT=230.05n

.meas tran vdout1_9ck220 FIND v(dout1_9) AT=230.05n

.meas tran vdout1_10ck220 FIND v(dout1_10) AT=230.05n

.meas tran vdout1_11ck220 FIND v(dout1_11) AT=230.05n

.meas tran vdout1_12ck220 FIND v(dout1_12) AT=230.05n

.meas tran vdout1_13ck220 FIND v(dout1_13) AT=230.05n

.meas tran vdout1_14ck220 FIND v(dout1_14) AT=230.05n

.meas tran vdout1_15ck220 FIND v(dout1_15) AT=230.05n

.meas tran vdout1_16ck220 FIND v(dout1_16) AT=230.05n

.meas tran vdout1_17ck220 FIND v(dout1_17) AT=230.05n

.meas tran vdout1_18ck220 FIND v(dout1_18) AT=230.05n

.meas tran vdout1_19ck220 FIND v(dout1_19) AT=230.05n

.meas tran vdout1_20ck220 FIND v(dout1_20) AT=230.05n

.meas tran vdout1_21ck220 FIND v(dout1_21) AT=230.05n

.meas tran vdout1_22ck220 FIND v(dout1_22) AT=230.05n

.meas tran vdout1_23ck220 FIND v(dout1_23) AT=230.05n

.meas tran vdout1_24ck220 FIND v(dout1_24) AT=230.05n

.meas tran vdout1_25ck220 FIND v(dout1_25) AT=230.05n

.meas tran vdout1_26ck220 FIND v(dout1_26) AT=230.05n

.meas tran vdout1_27ck220 FIND v(dout1_27) AT=230.05n

.meas tran vdout1_28ck220 FIND v(dout1_28) AT=230.05n

.meas tran vdout1_29ck220 FIND v(dout1_29) AT=230.05n

.meas tran vdout1_30ck220 FIND v(dout1_30) AT=230.05n

.meas tran vdout1_31ck220 FIND v(dout1_31) AT=230.05n

.meas tran vdout1_32ck220 FIND v(dout1_32) AT=230.05n

.meas tran vdout1_0ck240 FIND v(dout1_0) AT=250.05n

.meas tran vdout1_1ck240 FIND v(dout1_1) AT=250.05n

.meas tran vdout1_2ck240 FIND v(dout1_2) AT=250.05n

.meas tran vdout1_3ck240 FIND v(dout1_3) AT=250.05n

.meas tran vdout1_4ck240 FIND v(dout1_4) AT=250.05n

.meas tran vdout1_5ck240 FIND v(dout1_5) AT=250.05n

.meas tran vdout1_6ck240 FIND v(dout1_6) AT=250.05n

.meas tran vdout1_7ck240 FIND v(dout1_7) AT=250.05n

.meas tran vdout1_8ck240 FIND v(dout1_8) AT=250.05n

.meas tran vdout1_9ck240 FIND v(dout1_9) AT=250.05n

.meas tran vdout1_10ck240 FIND v(dout1_10) AT=250.05n

.meas tran vdout1_11ck240 FIND v(dout1_11) AT=250.05n

.meas tran vdout1_12ck240 FIND v(dout1_12) AT=250.05n

.meas tran vdout1_13ck240 FIND v(dout1_13) AT=250.05n

.meas tran vdout1_14ck240 FIND v(dout1_14) AT=250.05n

.meas tran vdout1_15ck240 FIND v(dout1_15) AT=250.05n

.meas tran vdout1_16ck240 FIND v(dout1_16) AT=250.05n

.meas tran vdout1_17ck240 FIND v(dout1_17) AT=250.05n

.meas tran vdout1_18ck240 FIND v(dout1_18) AT=250.05n

.meas tran vdout1_19ck240 FIND v(dout1_19) AT=250.05n

.meas tran vdout1_20ck240 FIND v(dout1_20) AT=250.05n

.meas tran vdout1_21ck240 FIND v(dout1_21) AT=250.05n

.meas tran vdout1_22ck240 FIND v(dout1_22) AT=250.05n

.meas tran vdout1_23ck240 FIND v(dout1_23) AT=250.05n

.meas tran vdout1_24ck240 FIND v(dout1_24) AT=250.05n

.meas tran vdout1_25ck240 FIND v(dout1_25) AT=250.05n

.meas tran vdout1_26ck240 FIND v(dout1_26) AT=250.05n

.meas tran vdout1_27ck240 FIND v(dout1_27) AT=250.05n

.meas tran vdout1_28ck240 FIND v(dout1_28) AT=250.05n

.meas tran vdout1_29ck240 FIND v(dout1_29) AT=250.05n

.meas tran vdout1_30ck240 FIND v(dout1_30) AT=250.05n

.meas tran vdout1_31ck240 FIND v(dout1_31) AT=250.05n

.meas tran vdout1_32ck240 FIND v(dout1_32) AT=250.05n

.meas tran vdout1_0ck250 FIND v(dout1_0) AT=260.05n

.meas tran vdout1_1ck250 FIND v(dout1_1) AT=260.05n

.meas tran vdout1_2ck250 FIND v(dout1_2) AT=260.05n

.meas tran vdout1_3ck250 FIND v(dout1_3) AT=260.05n

.meas tran vdout1_4ck250 FIND v(dout1_4) AT=260.05n

.meas tran vdout1_5ck250 FIND v(dout1_5) AT=260.05n

.meas tran vdout1_6ck250 FIND v(dout1_6) AT=260.05n

.meas tran vdout1_7ck250 FIND v(dout1_7) AT=260.05n

.meas tran vdout1_8ck250 FIND v(dout1_8) AT=260.05n

.meas tran vdout1_9ck250 FIND v(dout1_9) AT=260.05n

.meas tran vdout1_10ck250 FIND v(dout1_10) AT=260.05n

.meas tran vdout1_11ck250 FIND v(dout1_11) AT=260.05n

.meas tran vdout1_12ck250 FIND v(dout1_12) AT=260.05n

.meas tran vdout1_13ck250 FIND v(dout1_13) AT=260.05n

.meas tran vdout1_14ck250 FIND v(dout1_14) AT=260.05n

.meas tran vdout1_15ck250 FIND v(dout1_15) AT=260.05n

.meas tran vdout1_16ck250 FIND v(dout1_16) AT=260.05n

.meas tran vdout1_17ck250 FIND v(dout1_17) AT=260.05n

.meas tran vdout1_18ck250 FIND v(dout1_18) AT=260.05n

.meas tran vdout1_19ck250 FIND v(dout1_19) AT=260.05n

.meas tran vdout1_20ck250 FIND v(dout1_20) AT=260.05n

.meas tran vdout1_21ck250 FIND v(dout1_21) AT=260.05n

.meas tran vdout1_22ck250 FIND v(dout1_22) AT=260.05n

.meas tran vdout1_23ck250 FIND v(dout1_23) AT=260.05n

.meas tran vdout1_24ck250 FIND v(dout1_24) AT=260.05n

.meas tran vdout1_25ck250 FIND v(dout1_25) AT=260.05n

.meas tran vdout1_26ck250 FIND v(dout1_26) AT=260.05n

.meas tran vdout1_27ck250 FIND v(dout1_27) AT=260.05n

.meas tran vdout1_28ck250 FIND v(dout1_28) AT=260.05n

.meas tran vdout1_29ck250 FIND v(dout1_29) AT=260.05n

.meas tran vdout1_30ck250 FIND v(dout1_30) AT=260.05n

.meas tran vdout1_31ck250 FIND v(dout1_31) AT=260.05n

.meas tran vdout1_32ck250 FIND v(dout1_32) AT=260.05n

.meas tran vdout1_0ck270 FIND v(dout1_0) AT=280.05n

.meas tran vdout1_1ck270 FIND v(dout1_1) AT=280.05n

.meas tran vdout1_2ck270 FIND v(dout1_2) AT=280.05n

.meas tran vdout1_3ck270 FIND v(dout1_3) AT=280.05n

.meas tran vdout1_4ck270 FIND v(dout1_4) AT=280.05n

.meas tran vdout1_5ck270 FIND v(dout1_5) AT=280.05n

.meas tran vdout1_6ck270 FIND v(dout1_6) AT=280.05n

.meas tran vdout1_7ck270 FIND v(dout1_7) AT=280.05n

.meas tran vdout1_8ck270 FIND v(dout1_8) AT=280.05n

.meas tran vdout1_9ck270 FIND v(dout1_9) AT=280.05n

.meas tran vdout1_10ck270 FIND v(dout1_10) AT=280.05n

.meas tran vdout1_11ck270 FIND v(dout1_11) AT=280.05n

.meas tran vdout1_12ck270 FIND v(dout1_12) AT=280.05n

.meas tran vdout1_13ck270 FIND v(dout1_13) AT=280.05n

.meas tran vdout1_14ck270 FIND v(dout1_14) AT=280.05n

.meas tran vdout1_15ck270 FIND v(dout1_15) AT=280.05n

.meas tran vdout1_16ck270 FIND v(dout1_16) AT=280.05n

.meas tran vdout1_17ck270 FIND v(dout1_17) AT=280.05n

.meas tran vdout1_18ck270 FIND v(dout1_18) AT=280.05n

.meas tran vdout1_19ck270 FIND v(dout1_19) AT=280.05n

.meas tran vdout1_20ck270 FIND v(dout1_20) AT=280.05n

.meas tran vdout1_21ck270 FIND v(dout1_21) AT=280.05n

.meas tran vdout1_22ck270 FIND v(dout1_22) AT=280.05n

.meas tran vdout1_23ck270 FIND v(dout1_23) AT=280.05n

.meas tran vdout1_24ck270 FIND v(dout1_24) AT=280.05n

.meas tran vdout1_25ck270 FIND v(dout1_25) AT=280.05n

.meas tran vdout1_26ck270 FIND v(dout1_26) AT=280.05n

.meas tran vdout1_27ck270 FIND v(dout1_27) AT=280.05n

.meas tran vdout1_28ck270 FIND v(dout1_28) AT=280.05n

.meas tran vdout1_29ck270 FIND v(dout1_29) AT=280.05n

.meas tran vdout1_30ck270 FIND v(dout1_30) AT=280.05n

.meas tran vdout1_31ck270 FIND v(dout1_31) AT=280.05n

.meas tran vdout1_32ck270 FIND v(dout1_32) AT=280.05n

.meas tran vdout1_0ck300 FIND v(dout1_0) AT=310.05n

.meas tran vdout1_1ck300 FIND v(dout1_1) AT=310.05n

.meas tran vdout1_2ck300 FIND v(dout1_2) AT=310.05n

.meas tran vdout1_3ck300 FIND v(dout1_3) AT=310.05n

.meas tran vdout1_4ck300 FIND v(dout1_4) AT=310.05n

.meas tran vdout1_5ck300 FIND v(dout1_5) AT=310.05n

.meas tran vdout1_6ck300 FIND v(dout1_6) AT=310.05n

.meas tran vdout1_7ck300 FIND v(dout1_7) AT=310.05n

.meas tran vdout1_8ck300 FIND v(dout1_8) AT=310.05n

.meas tran vdout1_9ck300 FIND v(dout1_9) AT=310.05n

.meas tran vdout1_10ck300 FIND v(dout1_10) AT=310.05n

.meas tran vdout1_11ck300 FIND v(dout1_11) AT=310.05n

.meas tran vdout1_12ck300 FIND v(dout1_12) AT=310.05n

.meas tran vdout1_13ck300 FIND v(dout1_13) AT=310.05n

.meas tran vdout1_14ck300 FIND v(dout1_14) AT=310.05n

.meas tran vdout1_15ck300 FIND v(dout1_15) AT=310.05n

.meas tran vdout1_16ck300 FIND v(dout1_16) AT=310.05n

.meas tran vdout1_17ck300 FIND v(dout1_17) AT=310.05n

.meas tran vdout1_18ck300 FIND v(dout1_18) AT=310.05n

.meas tran vdout1_19ck300 FIND v(dout1_19) AT=310.05n

.meas tran vdout1_20ck300 FIND v(dout1_20) AT=310.05n

.meas tran vdout1_21ck300 FIND v(dout1_21) AT=310.05n

.meas tran vdout1_22ck300 FIND v(dout1_22) AT=310.05n

.meas tran vdout1_23ck300 FIND v(dout1_23) AT=310.05n

.meas tran vdout1_24ck300 FIND v(dout1_24) AT=310.05n

.meas tran vdout1_25ck300 FIND v(dout1_25) AT=310.05n

.meas tran vdout1_26ck300 FIND v(dout1_26) AT=310.05n

.meas tran vdout1_27ck300 FIND v(dout1_27) AT=310.05n

.meas tran vdout1_28ck300 FIND v(dout1_28) AT=310.05n

.meas tran vdout1_29ck300 FIND v(dout1_29) AT=310.05n

.meas tran vdout1_30ck300 FIND v(dout1_30) AT=310.05n

.meas tran vdout1_31ck300 FIND v(dout1_31) AT=310.05n

.meas tran vdout1_32ck300 FIND v(dout1_32) AT=310.05n

.meas tran vdout1_0ck330 FIND v(dout1_0) AT=340.05n

.meas tran vdout1_1ck330 FIND v(dout1_1) AT=340.05n

.meas tran vdout1_2ck330 FIND v(dout1_2) AT=340.05n

.meas tran vdout1_3ck330 FIND v(dout1_3) AT=340.05n

.meas tran vdout1_4ck330 FIND v(dout1_4) AT=340.05n

.meas tran vdout1_5ck330 FIND v(dout1_5) AT=340.05n

.meas tran vdout1_6ck330 FIND v(dout1_6) AT=340.05n

.meas tran vdout1_7ck330 FIND v(dout1_7) AT=340.05n

.meas tran vdout1_8ck330 FIND v(dout1_8) AT=340.05n

.meas tran vdout1_9ck330 FIND v(dout1_9) AT=340.05n

.meas tran vdout1_10ck330 FIND v(dout1_10) AT=340.05n

.meas tran vdout1_11ck330 FIND v(dout1_11) AT=340.05n

.meas tran vdout1_12ck330 FIND v(dout1_12) AT=340.05n

.meas tran vdout1_13ck330 FIND v(dout1_13) AT=340.05n

.meas tran vdout1_14ck330 FIND v(dout1_14) AT=340.05n

.meas tran vdout1_15ck330 FIND v(dout1_15) AT=340.05n

.meas tran vdout1_16ck330 FIND v(dout1_16) AT=340.05n

.meas tran vdout1_17ck330 FIND v(dout1_17) AT=340.05n

.meas tran vdout1_18ck330 FIND v(dout1_18) AT=340.05n

.meas tran vdout1_19ck330 FIND v(dout1_19) AT=340.05n

.meas tran vdout1_20ck330 FIND v(dout1_20) AT=340.05n

.meas tran vdout1_21ck330 FIND v(dout1_21) AT=340.05n

.meas tran vdout1_22ck330 FIND v(dout1_22) AT=340.05n

.meas tran vdout1_23ck330 FIND v(dout1_23) AT=340.05n

.meas tran vdout1_24ck330 FIND v(dout1_24) AT=340.05n

.meas tran vdout1_25ck330 FIND v(dout1_25) AT=340.05n

.meas tran vdout1_26ck330 FIND v(dout1_26) AT=340.05n

.meas tran vdout1_27ck330 FIND v(dout1_27) AT=340.05n

.meas tran vdout1_28ck330 FIND v(dout1_28) AT=340.05n

.meas tran vdout1_29ck330 FIND v(dout1_29) AT=340.05n

.meas tran vdout1_30ck330 FIND v(dout1_30) AT=340.05n

.meas tran vdout1_31ck330 FIND v(dout1_31) AT=340.05n

.meas tran vdout1_32ck330 FIND v(dout1_32) AT=340.05n

.meas tran vdout1_0ck340 FIND v(dout1_0) AT=350.05n

.meas tran vdout1_1ck340 FIND v(dout1_1) AT=350.05n

.meas tran vdout1_2ck340 FIND v(dout1_2) AT=350.05n

.meas tran vdout1_3ck340 FIND v(dout1_3) AT=350.05n

.meas tran vdout1_4ck340 FIND v(dout1_4) AT=350.05n

.meas tran vdout1_5ck340 FIND v(dout1_5) AT=350.05n

.meas tran vdout1_6ck340 FIND v(dout1_6) AT=350.05n

.meas tran vdout1_7ck340 FIND v(dout1_7) AT=350.05n

.meas tran vdout1_8ck340 FIND v(dout1_8) AT=350.05n

.meas tran vdout1_9ck340 FIND v(dout1_9) AT=350.05n

.meas tran vdout1_10ck340 FIND v(dout1_10) AT=350.05n

.meas tran vdout1_11ck340 FIND v(dout1_11) AT=350.05n

.meas tran vdout1_12ck340 FIND v(dout1_12) AT=350.05n

.meas tran vdout1_13ck340 FIND v(dout1_13) AT=350.05n

.meas tran vdout1_14ck340 FIND v(dout1_14) AT=350.05n

.meas tran vdout1_15ck340 FIND v(dout1_15) AT=350.05n

.meas tran vdout1_16ck340 FIND v(dout1_16) AT=350.05n

.meas tran vdout1_17ck340 FIND v(dout1_17) AT=350.05n

.meas tran vdout1_18ck340 FIND v(dout1_18) AT=350.05n

.meas tran vdout1_19ck340 FIND v(dout1_19) AT=350.05n

.meas tran vdout1_20ck340 FIND v(dout1_20) AT=350.05n

.meas tran vdout1_21ck340 FIND v(dout1_21) AT=350.05n

.meas tran vdout1_22ck340 FIND v(dout1_22) AT=350.05n

.meas tran vdout1_23ck340 FIND v(dout1_23) AT=350.05n

.meas tran vdout1_24ck340 FIND v(dout1_24) AT=350.05n

.meas tran vdout1_25ck340 FIND v(dout1_25) AT=350.05n

.meas tran vdout1_26ck340 FIND v(dout1_26) AT=350.05n

.meas tran vdout1_27ck340 FIND v(dout1_27) AT=350.05n

.meas tran vdout1_28ck340 FIND v(dout1_28) AT=350.05n

.meas tran vdout1_29ck340 FIND v(dout1_29) AT=350.05n

.meas tran vdout1_30ck340 FIND v(dout1_30) AT=350.05n

.meas tran vdout1_31ck340 FIND v(dout1_31) AT=350.05n

.meas tran vdout1_32ck340 FIND v(dout1_32) AT=350.05n

.meas tran vdout1_0ck370 FIND v(dout1_0) AT=380.05n

.meas tran vdout1_1ck370 FIND v(dout1_1) AT=380.05n

.meas tran vdout1_2ck370 FIND v(dout1_2) AT=380.05n

.meas tran vdout1_3ck370 FIND v(dout1_3) AT=380.05n

.meas tran vdout1_4ck370 FIND v(dout1_4) AT=380.05n

.meas tran vdout1_5ck370 FIND v(dout1_5) AT=380.05n

.meas tran vdout1_6ck370 FIND v(dout1_6) AT=380.05n

.meas tran vdout1_7ck370 FIND v(dout1_7) AT=380.05n

.meas tran vdout1_8ck370 FIND v(dout1_8) AT=380.05n

.meas tran vdout1_9ck370 FIND v(dout1_9) AT=380.05n

.meas tran vdout1_10ck370 FIND v(dout1_10) AT=380.05n

.meas tran vdout1_11ck370 FIND v(dout1_11) AT=380.05n

.meas tran vdout1_12ck370 FIND v(dout1_12) AT=380.05n

.meas tran vdout1_13ck370 FIND v(dout1_13) AT=380.05n

.meas tran vdout1_14ck370 FIND v(dout1_14) AT=380.05n

.meas tran vdout1_15ck370 FIND v(dout1_15) AT=380.05n

.meas tran vdout1_16ck370 FIND v(dout1_16) AT=380.05n

.meas tran vdout1_17ck370 FIND v(dout1_17) AT=380.05n

.meas tran vdout1_18ck370 FIND v(dout1_18) AT=380.05n

.meas tran vdout1_19ck370 FIND v(dout1_19) AT=380.05n

.meas tran vdout1_20ck370 FIND v(dout1_20) AT=380.05n

.meas tran vdout1_21ck370 FIND v(dout1_21) AT=380.05n

.meas tran vdout1_22ck370 FIND v(dout1_22) AT=380.05n

.meas tran vdout1_23ck370 FIND v(dout1_23) AT=380.05n

.meas tran vdout1_24ck370 FIND v(dout1_24) AT=380.05n

.meas tran vdout1_25ck370 FIND v(dout1_25) AT=380.05n

.meas tran vdout1_26ck370 FIND v(dout1_26) AT=380.05n

.meas tran vdout1_27ck370 FIND v(dout1_27) AT=380.05n

.meas tran vdout1_28ck370 FIND v(dout1_28) AT=380.05n

.meas tran vdout1_29ck370 FIND v(dout1_29) AT=380.05n

.meas tran vdout1_30ck370 FIND v(dout1_30) AT=380.05n

.meas tran vdout1_31ck370 FIND v(dout1_31) AT=380.05n

.meas tran vdout1_32ck370 FIND v(dout1_32) AT=380.05n

.meas tran vdout1_0ck390 FIND v(dout1_0) AT=400.05n

.meas tran vdout1_1ck390 FIND v(dout1_1) AT=400.05n

.meas tran vdout1_2ck390 FIND v(dout1_2) AT=400.05n

.meas tran vdout1_3ck390 FIND v(dout1_3) AT=400.05n

.meas tran vdout1_4ck390 FIND v(dout1_4) AT=400.05n

.meas tran vdout1_5ck390 FIND v(dout1_5) AT=400.05n

.meas tran vdout1_6ck390 FIND v(dout1_6) AT=400.05n

.meas tran vdout1_7ck390 FIND v(dout1_7) AT=400.05n

.meas tran vdout1_8ck390 FIND v(dout1_8) AT=400.05n

.meas tran vdout1_9ck390 FIND v(dout1_9) AT=400.05n

.meas tran vdout1_10ck390 FIND v(dout1_10) AT=400.05n

.meas tran vdout1_11ck390 FIND v(dout1_11) AT=400.05n

.meas tran vdout1_12ck390 FIND v(dout1_12) AT=400.05n

.meas tran vdout1_13ck390 FIND v(dout1_13) AT=400.05n

.meas tran vdout1_14ck390 FIND v(dout1_14) AT=400.05n

.meas tran vdout1_15ck390 FIND v(dout1_15) AT=400.05n

.meas tran vdout1_16ck390 FIND v(dout1_16) AT=400.05n

.meas tran vdout1_17ck390 FIND v(dout1_17) AT=400.05n

.meas tran vdout1_18ck390 FIND v(dout1_18) AT=400.05n

.meas tran vdout1_19ck390 FIND v(dout1_19) AT=400.05n

.meas tran vdout1_20ck390 FIND v(dout1_20) AT=400.05n

.meas tran vdout1_21ck390 FIND v(dout1_21) AT=400.05n

.meas tran vdout1_22ck390 FIND v(dout1_22) AT=400.05n

.meas tran vdout1_23ck390 FIND v(dout1_23) AT=400.05n

.meas tran vdout1_24ck390 FIND v(dout1_24) AT=400.05n

.meas tran vdout1_25ck390 FIND v(dout1_25) AT=400.05n

.meas tran vdout1_26ck390 FIND v(dout1_26) AT=400.05n

.meas tran vdout1_27ck390 FIND v(dout1_27) AT=400.05n

.meas tran vdout1_28ck390 FIND v(dout1_28) AT=400.05n

.meas tran vdout1_29ck390 FIND v(dout1_29) AT=400.05n

.meas tran vdout1_30ck390 FIND v(dout1_30) AT=400.05n

.meas tran vdout1_31ck390 FIND v(dout1_31) AT=400.05n

.meas tran vdout1_32ck390 FIND v(dout1_32) AT=400.05n

.meas tran vdout1_0ck410 FIND v(dout1_0) AT=420.05n

.meas tran vdout1_1ck410 FIND v(dout1_1) AT=420.05n

.meas tran vdout1_2ck410 FIND v(dout1_2) AT=420.05n

.meas tran vdout1_3ck410 FIND v(dout1_3) AT=420.05n

.meas tran vdout1_4ck410 FIND v(dout1_4) AT=420.05n

.meas tran vdout1_5ck410 FIND v(dout1_5) AT=420.05n

.meas tran vdout1_6ck410 FIND v(dout1_6) AT=420.05n

.meas tran vdout1_7ck410 FIND v(dout1_7) AT=420.05n

.meas tran vdout1_8ck410 FIND v(dout1_8) AT=420.05n

.meas tran vdout1_9ck410 FIND v(dout1_9) AT=420.05n

.meas tran vdout1_10ck410 FIND v(dout1_10) AT=420.05n

.meas tran vdout1_11ck410 FIND v(dout1_11) AT=420.05n

.meas tran vdout1_12ck410 FIND v(dout1_12) AT=420.05n

.meas tran vdout1_13ck410 FIND v(dout1_13) AT=420.05n

.meas tran vdout1_14ck410 FIND v(dout1_14) AT=420.05n

.meas tran vdout1_15ck410 FIND v(dout1_15) AT=420.05n

.meas tran vdout1_16ck410 FIND v(dout1_16) AT=420.05n

.meas tran vdout1_17ck410 FIND v(dout1_17) AT=420.05n

.meas tran vdout1_18ck410 FIND v(dout1_18) AT=420.05n

.meas tran vdout1_19ck410 FIND v(dout1_19) AT=420.05n

.meas tran vdout1_20ck410 FIND v(dout1_20) AT=420.05n

.meas tran vdout1_21ck410 FIND v(dout1_21) AT=420.05n

.meas tran vdout1_22ck410 FIND v(dout1_22) AT=420.05n

.meas tran vdout1_23ck410 FIND v(dout1_23) AT=420.05n

.meas tran vdout1_24ck410 FIND v(dout1_24) AT=420.05n

.meas tran vdout1_25ck410 FIND v(dout1_25) AT=420.05n

.meas tran vdout1_26ck410 FIND v(dout1_26) AT=420.05n

.meas tran vdout1_27ck410 FIND v(dout1_27) AT=420.05n

.meas tran vdout1_28ck410 FIND v(dout1_28) AT=420.05n

.meas tran vdout1_29ck410 FIND v(dout1_29) AT=420.05n

.meas tran vdout1_30ck410 FIND v(dout1_30) AT=420.05n

.meas tran vdout1_31ck410 FIND v(dout1_31) AT=420.05n

.meas tran vdout1_32ck410 FIND v(dout1_32) AT=420.05n

.meas tran vdout1_0ck430 FIND v(dout1_0) AT=440.05n

.meas tran vdout1_1ck430 FIND v(dout1_1) AT=440.05n

.meas tran vdout1_2ck430 FIND v(dout1_2) AT=440.05n

.meas tran vdout1_3ck430 FIND v(dout1_3) AT=440.05n

.meas tran vdout1_4ck430 FIND v(dout1_4) AT=440.05n

.meas tran vdout1_5ck430 FIND v(dout1_5) AT=440.05n

.meas tran vdout1_6ck430 FIND v(dout1_6) AT=440.05n

.meas tran vdout1_7ck430 FIND v(dout1_7) AT=440.05n

.meas tran vdout1_8ck430 FIND v(dout1_8) AT=440.05n

.meas tran vdout1_9ck430 FIND v(dout1_9) AT=440.05n

.meas tran vdout1_10ck430 FIND v(dout1_10) AT=440.05n

.meas tran vdout1_11ck430 FIND v(dout1_11) AT=440.05n

.meas tran vdout1_12ck430 FIND v(dout1_12) AT=440.05n

.meas tran vdout1_13ck430 FIND v(dout1_13) AT=440.05n

.meas tran vdout1_14ck430 FIND v(dout1_14) AT=440.05n

.meas tran vdout1_15ck430 FIND v(dout1_15) AT=440.05n

.meas tran vdout1_16ck430 FIND v(dout1_16) AT=440.05n

.meas tran vdout1_17ck430 FIND v(dout1_17) AT=440.05n

.meas tran vdout1_18ck430 FIND v(dout1_18) AT=440.05n

.meas tran vdout1_19ck430 FIND v(dout1_19) AT=440.05n

.meas tran vdout1_20ck430 FIND v(dout1_20) AT=440.05n

.meas tran vdout1_21ck430 FIND v(dout1_21) AT=440.05n

.meas tran vdout1_22ck430 FIND v(dout1_22) AT=440.05n

.meas tran vdout1_23ck430 FIND v(dout1_23) AT=440.05n

.meas tran vdout1_24ck430 FIND v(dout1_24) AT=440.05n

.meas tran vdout1_25ck430 FIND v(dout1_25) AT=440.05n

.meas tran vdout1_26ck430 FIND v(dout1_26) AT=440.05n

.meas tran vdout1_27ck430 FIND v(dout1_27) AT=440.05n

.meas tran vdout1_28ck430 FIND v(dout1_28) AT=440.05n

.meas tran vdout1_29ck430 FIND v(dout1_29) AT=440.05n

.meas tran vdout1_30ck430 FIND v(dout1_30) AT=440.05n

.meas tran vdout1_31ck430 FIND v(dout1_31) AT=440.05n

.meas tran vdout1_32ck430 FIND v(dout1_32) AT=440.05n

.meas tran vdout1_0ck470 FIND v(dout1_0) AT=480.05n

.meas tran vdout1_1ck470 FIND v(dout1_1) AT=480.05n

.meas tran vdout1_2ck470 FIND v(dout1_2) AT=480.05n

.meas tran vdout1_3ck470 FIND v(dout1_3) AT=480.05n

.meas tran vdout1_4ck470 FIND v(dout1_4) AT=480.05n

.meas tran vdout1_5ck470 FIND v(dout1_5) AT=480.05n

.meas tran vdout1_6ck470 FIND v(dout1_6) AT=480.05n

.meas tran vdout1_7ck470 FIND v(dout1_7) AT=480.05n

.meas tran vdout1_8ck470 FIND v(dout1_8) AT=480.05n

.meas tran vdout1_9ck470 FIND v(dout1_9) AT=480.05n

.meas tran vdout1_10ck470 FIND v(dout1_10) AT=480.05n

.meas tran vdout1_11ck470 FIND v(dout1_11) AT=480.05n

.meas tran vdout1_12ck470 FIND v(dout1_12) AT=480.05n

.meas tran vdout1_13ck470 FIND v(dout1_13) AT=480.05n

.meas tran vdout1_14ck470 FIND v(dout1_14) AT=480.05n

.meas tran vdout1_15ck470 FIND v(dout1_15) AT=480.05n

.meas tran vdout1_16ck470 FIND v(dout1_16) AT=480.05n

.meas tran vdout1_17ck470 FIND v(dout1_17) AT=480.05n

.meas tran vdout1_18ck470 FIND v(dout1_18) AT=480.05n

.meas tran vdout1_19ck470 FIND v(dout1_19) AT=480.05n

.meas tran vdout1_20ck470 FIND v(dout1_20) AT=480.05n

.meas tran vdout1_21ck470 FIND v(dout1_21) AT=480.05n

.meas tran vdout1_22ck470 FIND v(dout1_22) AT=480.05n

.meas tran vdout1_23ck470 FIND v(dout1_23) AT=480.05n

.meas tran vdout1_24ck470 FIND v(dout1_24) AT=480.05n

.meas tran vdout1_25ck470 FIND v(dout1_25) AT=480.05n

.meas tran vdout1_26ck470 FIND v(dout1_26) AT=480.05n

.meas tran vdout1_27ck470 FIND v(dout1_27) AT=480.05n

.meas tran vdout1_28ck470 FIND v(dout1_28) AT=480.05n

.meas tran vdout1_29ck470 FIND v(dout1_29) AT=480.05n

.meas tran vdout1_30ck470 FIND v(dout1_30) AT=480.05n

.meas tran vdout1_31ck470 FIND v(dout1_31) AT=480.05n

.meas tran vdout1_32ck470 FIND v(dout1_32) AT=480.05n

.meas tran vdout1_0ck480 FIND v(dout1_0) AT=490.05n

.meas tran vdout1_1ck480 FIND v(dout1_1) AT=490.05n

.meas tran vdout1_2ck480 FIND v(dout1_2) AT=490.05n

.meas tran vdout1_3ck480 FIND v(dout1_3) AT=490.05n

.meas tran vdout1_4ck480 FIND v(dout1_4) AT=490.05n

.meas tran vdout1_5ck480 FIND v(dout1_5) AT=490.05n

.meas tran vdout1_6ck480 FIND v(dout1_6) AT=490.05n

.meas tran vdout1_7ck480 FIND v(dout1_7) AT=490.05n

.meas tran vdout1_8ck480 FIND v(dout1_8) AT=490.05n

.meas tran vdout1_9ck480 FIND v(dout1_9) AT=490.05n

.meas tran vdout1_10ck480 FIND v(dout1_10) AT=490.05n

.meas tran vdout1_11ck480 FIND v(dout1_11) AT=490.05n

.meas tran vdout1_12ck480 FIND v(dout1_12) AT=490.05n

.meas tran vdout1_13ck480 FIND v(dout1_13) AT=490.05n

.meas tran vdout1_14ck480 FIND v(dout1_14) AT=490.05n

.meas tran vdout1_15ck480 FIND v(dout1_15) AT=490.05n

.meas tran vdout1_16ck480 FIND v(dout1_16) AT=490.05n

.meas tran vdout1_17ck480 FIND v(dout1_17) AT=490.05n

.meas tran vdout1_18ck480 FIND v(dout1_18) AT=490.05n

.meas tran vdout1_19ck480 FIND v(dout1_19) AT=490.05n

.meas tran vdout1_20ck480 FIND v(dout1_20) AT=490.05n

.meas tran vdout1_21ck480 FIND v(dout1_21) AT=490.05n

.meas tran vdout1_22ck480 FIND v(dout1_22) AT=490.05n

.meas tran vdout1_23ck480 FIND v(dout1_23) AT=490.05n

.meas tran vdout1_24ck480 FIND v(dout1_24) AT=490.05n

.meas tran vdout1_25ck480 FIND v(dout1_25) AT=490.05n

.meas tran vdout1_26ck480 FIND v(dout1_26) AT=490.05n

.meas tran vdout1_27ck480 FIND v(dout1_27) AT=490.05n

.meas tran vdout1_28ck480 FIND v(dout1_28) AT=490.05n

.meas tran vdout1_29ck480 FIND v(dout1_29) AT=490.05n

.meas tran vdout1_30ck480 FIND v(dout1_30) AT=490.05n

.meas tran vdout1_31ck480 FIND v(dout1_31) AT=490.05n

.meas tran vdout1_32ck480 FIND v(dout1_32) AT=490.05n

.meas tran vdout1_0ck490 FIND v(dout1_0) AT=500.05n

.meas tran vdout1_1ck490 FIND v(dout1_1) AT=500.05n

.meas tran vdout1_2ck490 FIND v(dout1_2) AT=500.05n

.meas tran vdout1_3ck490 FIND v(dout1_3) AT=500.05n

.meas tran vdout1_4ck490 FIND v(dout1_4) AT=500.05n

.meas tran vdout1_5ck490 FIND v(dout1_5) AT=500.05n

.meas tran vdout1_6ck490 FIND v(dout1_6) AT=500.05n

.meas tran vdout1_7ck490 FIND v(dout1_7) AT=500.05n

.meas tran vdout1_8ck490 FIND v(dout1_8) AT=500.05n

.meas tran vdout1_9ck490 FIND v(dout1_9) AT=500.05n

.meas tran vdout1_10ck490 FIND v(dout1_10) AT=500.05n

.meas tran vdout1_11ck490 FIND v(dout1_11) AT=500.05n

.meas tran vdout1_12ck490 FIND v(dout1_12) AT=500.05n

.meas tran vdout1_13ck490 FIND v(dout1_13) AT=500.05n

.meas tran vdout1_14ck490 FIND v(dout1_14) AT=500.05n

.meas tran vdout1_15ck490 FIND v(dout1_15) AT=500.05n

.meas tran vdout1_16ck490 FIND v(dout1_16) AT=500.05n

.meas tran vdout1_17ck490 FIND v(dout1_17) AT=500.05n

.meas tran vdout1_18ck490 FIND v(dout1_18) AT=500.05n

.meas tran vdout1_19ck490 FIND v(dout1_19) AT=500.05n

.meas tran vdout1_20ck490 FIND v(dout1_20) AT=500.05n

.meas tran vdout1_21ck490 FIND v(dout1_21) AT=500.05n

.meas tran vdout1_22ck490 FIND v(dout1_22) AT=500.05n

.meas tran vdout1_23ck490 FIND v(dout1_23) AT=500.05n

.meas tran vdout1_24ck490 FIND v(dout1_24) AT=500.05n

.meas tran vdout1_25ck490 FIND v(dout1_25) AT=500.05n

.meas tran vdout1_26ck490 FIND v(dout1_26) AT=500.05n

.meas tran vdout1_27ck490 FIND v(dout1_27) AT=500.05n

.meas tran vdout1_28ck490 FIND v(dout1_28) AT=500.05n

.meas tran vdout1_29ck490 FIND v(dout1_29) AT=500.05n

.meas tran vdout1_30ck490 FIND v(dout1_30) AT=500.05n

.meas tran vdout1_31ck490 FIND v(dout1_31) AT=500.05n

.meas tran vdout1_32ck490 FIND v(dout1_32) AT=500.05n

.meas tran vdout1_0ck510 FIND v(dout1_0) AT=520.05n

.meas tran vdout1_1ck510 FIND v(dout1_1) AT=520.05n

.meas tran vdout1_2ck510 FIND v(dout1_2) AT=520.05n

.meas tran vdout1_3ck510 FIND v(dout1_3) AT=520.05n

.meas tran vdout1_4ck510 FIND v(dout1_4) AT=520.05n

.meas tran vdout1_5ck510 FIND v(dout1_5) AT=520.05n

.meas tran vdout1_6ck510 FIND v(dout1_6) AT=520.05n

.meas tran vdout1_7ck510 FIND v(dout1_7) AT=520.05n

.meas tran vdout1_8ck510 FIND v(dout1_8) AT=520.05n

.meas tran vdout1_9ck510 FIND v(dout1_9) AT=520.05n

.meas tran vdout1_10ck510 FIND v(dout1_10) AT=520.05n

.meas tran vdout1_11ck510 FIND v(dout1_11) AT=520.05n

.meas tran vdout1_12ck510 FIND v(dout1_12) AT=520.05n

.meas tran vdout1_13ck510 FIND v(dout1_13) AT=520.05n

.meas tran vdout1_14ck510 FIND v(dout1_14) AT=520.05n

.meas tran vdout1_15ck510 FIND v(dout1_15) AT=520.05n

.meas tran vdout1_16ck510 FIND v(dout1_16) AT=520.05n

.meas tran vdout1_17ck510 FIND v(dout1_17) AT=520.05n

.meas tran vdout1_18ck510 FIND v(dout1_18) AT=520.05n

.meas tran vdout1_19ck510 FIND v(dout1_19) AT=520.05n

.meas tran vdout1_20ck510 FIND v(dout1_20) AT=520.05n

.meas tran vdout1_21ck510 FIND v(dout1_21) AT=520.05n

.meas tran vdout1_22ck510 FIND v(dout1_22) AT=520.05n

.meas tran vdout1_23ck510 FIND v(dout1_23) AT=520.05n

.meas tran vdout1_24ck510 FIND v(dout1_24) AT=520.05n

.meas tran vdout1_25ck510 FIND v(dout1_25) AT=520.05n

.meas tran vdout1_26ck510 FIND v(dout1_26) AT=520.05n

.meas tran vdout1_27ck510 FIND v(dout1_27) AT=520.05n

.meas tran vdout1_28ck510 FIND v(dout1_28) AT=520.05n

.meas tran vdout1_29ck510 FIND v(dout1_29) AT=520.05n

.meas tran vdout1_30ck510 FIND v(dout1_30) AT=520.05n

.meas tran vdout1_31ck510 FIND v(dout1_31) AT=520.05n

.meas tran vdout1_32ck510 FIND v(dout1_32) AT=520.05n

.meas tran vdout1_0ck570 FIND v(dout1_0) AT=580.05n

.meas tran vdout1_1ck570 FIND v(dout1_1) AT=580.05n

.meas tran vdout1_2ck570 FIND v(dout1_2) AT=580.05n

.meas tran vdout1_3ck570 FIND v(dout1_3) AT=580.05n

.meas tran vdout1_4ck570 FIND v(dout1_4) AT=580.05n

.meas tran vdout1_5ck570 FIND v(dout1_5) AT=580.05n

.meas tran vdout1_6ck570 FIND v(dout1_6) AT=580.05n

.meas tran vdout1_7ck570 FIND v(dout1_7) AT=580.05n

.meas tran vdout1_8ck570 FIND v(dout1_8) AT=580.05n

.meas tran vdout1_9ck570 FIND v(dout1_9) AT=580.05n

.meas tran vdout1_10ck570 FIND v(dout1_10) AT=580.05n

.meas tran vdout1_11ck570 FIND v(dout1_11) AT=580.05n

.meas tran vdout1_12ck570 FIND v(dout1_12) AT=580.05n

.meas tran vdout1_13ck570 FIND v(dout1_13) AT=580.05n

.meas tran vdout1_14ck570 FIND v(dout1_14) AT=580.05n

.meas tran vdout1_15ck570 FIND v(dout1_15) AT=580.05n

.meas tran vdout1_16ck570 FIND v(dout1_16) AT=580.05n

.meas tran vdout1_17ck570 FIND v(dout1_17) AT=580.05n

.meas tran vdout1_18ck570 FIND v(dout1_18) AT=580.05n

.meas tran vdout1_19ck570 FIND v(dout1_19) AT=580.05n

.meas tran vdout1_20ck570 FIND v(dout1_20) AT=580.05n

.meas tran vdout1_21ck570 FIND v(dout1_21) AT=580.05n

.meas tran vdout1_22ck570 FIND v(dout1_22) AT=580.05n

.meas tran vdout1_23ck570 FIND v(dout1_23) AT=580.05n

.meas tran vdout1_24ck570 FIND v(dout1_24) AT=580.05n

.meas tran vdout1_25ck570 FIND v(dout1_25) AT=580.05n

.meas tran vdout1_26ck570 FIND v(dout1_26) AT=580.05n

.meas tran vdout1_27ck570 FIND v(dout1_27) AT=580.05n

.meas tran vdout1_28ck570 FIND v(dout1_28) AT=580.05n

.meas tran vdout1_29ck570 FIND v(dout1_29) AT=580.05n

.meas tran vdout1_30ck570 FIND v(dout1_30) AT=580.05n

.meas tran vdout1_31ck570 FIND v(dout1_31) AT=580.05n

.meas tran vdout1_32ck570 FIND v(dout1_32) AT=580.05n

.meas tran vdout1_0ck600 FIND v(dout1_0) AT=610.05n

.meas tran vdout1_1ck600 FIND v(dout1_1) AT=610.05n

.meas tran vdout1_2ck600 FIND v(dout1_2) AT=610.05n

.meas tran vdout1_3ck600 FIND v(dout1_3) AT=610.05n

.meas tran vdout1_4ck600 FIND v(dout1_4) AT=610.05n

.meas tran vdout1_5ck600 FIND v(dout1_5) AT=610.05n

.meas tran vdout1_6ck600 FIND v(dout1_6) AT=610.05n

.meas tran vdout1_7ck600 FIND v(dout1_7) AT=610.05n

.meas tran vdout1_8ck600 FIND v(dout1_8) AT=610.05n

.meas tran vdout1_9ck600 FIND v(dout1_9) AT=610.05n

.meas tran vdout1_10ck600 FIND v(dout1_10) AT=610.05n

.meas tran vdout1_11ck600 FIND v(dout1_11) AT=610.05n

.meas tran vdout1_12ck600 FIND v(dout1_12) AT=610.05n

.meas tran vdout1_13ck600 FIND v(dout1_13) AT=610.05n

.meas tran vdout1_14ck600 FIND v(dout1_14) AT=610.05n

.meas tran vdout1_15ck600 FIND v(dout1_15) AT=610.05n

.meas tran vdout1_16ck600 FIND v(dout1_16) AT=610.05n

.meas tran vdout1_17ck600 FIND v(dout1_17) AT=610.05n

.meas tran vdout1_18ck600 FIND v(dout1_18) AT=610.05n

.meas tran vdout1_19ck600 FIND v(dout1_19) AT=610.05n

.meas tran vdout1_20ck600 FIND v(dout1_20) AT=610.05n

.meas tran vdout1_21ck600 FIND v(dout1_21) AT=610.05n

.meas tran vdout1_22ck600 FIND v(dout1_22) AT=610.05n

.meas tran vdout1_23ck600 FIND v(dout1_23) AT=610.05n

.meas tran vdout1_24ck600 FIND v(dout1_24) AT=610.05n

.meas tran vdout1_25ck600 FIND v(dout1_25) AT=610.05n

.meas tran vdout1_26ck600 FIND v(dout1_26) AT=610.05n

.meas tran vdout1_27ck600 FIND v(dout1_27) AT=610.05n

.meas tran vdout1_28ck600 FIND v(dout1_28) AT=610.05n

.meas tran vdout1_29ck600 FIND v(dout1_29) AT=610.05n

.meas tran vdout1_30ck600 FIND v(dout1_30) AT=610.05n

.meas tran vdout1_31ck600 FIND v(dout1_31) AT=610.05n

.meas tran vdout1_32ck600 FIND v(dout1_32) AT=610.05n

.meas tran vdout1_0ck620 FIND v(dout1_0) AT=630.05n

.meas tran vdout1_1ck620 FIND v(dout1_1) AT=630.05n

.meas tran vdout1_2ck620 FIND v(dout1_2) AT=630.05n

.meas tran vdout1_3ck620 FIND v(dout1_3) AT=630.05n

.meas tran vdout1_4ck620 FIND v(dout1_4) AT=630.05n

.meas tran vdout1_5ck620 FIND v(dout1_5) AT=630.05n

.meas tran vdout1_6ck620 FIND v(dout1_6) AT=630.05n

.meas tran vdout1_7ck620 FIND v(dout1_7) AT=630.05n

.meas tran vdout1_8ck620 FIND v(dout1_8) AT=630.05n

.meas tran vdout1_9ck620 FIND v(dout1_9) AT=630.05n

.meas tran vdout1_10ck620 FIND v(dout1_10) AT=630.05n

.meas tran vdout1_11ck620 FIND v(dout1_11) AT=630.05n

.meas tran vdout1_12ck620 FIND v(dout1_12) AT=630.05n

.meas tran vdout1_13ck620 FIND v(dout1_13) AT=630.05n

.meas tran vdout1_14ck620 FIND v(dout1_14) AT=630.05n

.meas tran vdout1_15ck620 FIND v(dout1_15) AT=630.05n

.meas tran vdout1_16ck620 FIND v(dout1_16) AT=630.05n

.meas tran vdout1_17ck620 FIND v(dout1_17) AT=630.05n

.meas tran vdout1_18ck620 FIND v(dout1_18) AT=630.05n

.meas tran vdout1_19ck620 FIND v(dout1_19) AT=630.05n

.meas tran vdout1_20ck620 FIND v(dout1_20) AT=630.05n

.meas tran vdout1_21ck620 FIND v(dout1_21) AT=630.05n

.meas tran vdout1_22ck620 FIND v(dout1_22) AT=630.05n

.meas tran vdout1_23ck620 FIND v(dout1_23) AT=630.05n

.meas tran vdout1_24ck620 FIND v(dout1_24) AT=630.05n

.meas tran vdout1_25ck620 FIND v(dout1_25) AT=630.05n

.meas tran vdout1_26ck620 FIND v(dout1_26) AT=630.05n

.meas tran vdout1_27ck620 FIND v(dout1_27) AT=630.05n

.meas tran vdout1_28ck620 FIND v(dout1_28) AT=630.05n

.meas tran vdout1_29ck620 FIND v(dout1_29) AT=630.05n

.meas tran vdout1_30ck620 FIND v(dout1_30) AT=630.05n

.meas tran vdout1_31ck620 FIND v(dout1_31) AT=630.05n

.meas tran vdout1_32ck620 FIND v(dout1_32) AT=630.05n

.meas tran vdout1_0ck630 FIND v(dout1_0) AT=640.05n

.meas tran vdout1_1ck630 FIND v(dout1_1) AT=640.05n

.meas tran vdout1_2ck630 FIND v(dout1_2) AT=640.05n

.meas tran vdout1_3ck630 FIND v(dout1_3) AT=640.05n

.meas tran vdout1_4ck630 FIND v(dout1_4) AT=640.05n

.meas tran vdout1_5ck630 FIND v(dout1_5) AT=640.05n

.meas tran vdout1_6ck630 FIND v(dout1_6) AT=640.05n

.meas tran vdout1_7ck630 FIND v(dout1_7) AT=640.05n

.meas tran vdout1_8ck630 FIND v(dout1_8) AT=640.05n

.meas tran vdout1_9ck630 FIND v(dout1_9) AT=640.05n

.meas tran vdout1_10ck630 FIND v(dout1_10) AT=640.05n

.meas tran vdout1_11ck630 FIND v(dout1_11) AT=640.05n

.meas tran vdout1_12ck630 FIND v(dout1_12) AT=640.05n

.meas tran vdout1_13ck630 FIND v(dout1_13) AT=640.05n

.meas tran vdout1_14ck630 FIND v(dout1_14) AT=640.05n

.meas tran vdout1_15ck630 FIND v(dout1_15) AT=640.05n

.meas tran vdout1_16ck630 FIND v(dout1_16) AT=640.05n

.meas tran vdout1_17ck630 FIND v(dout1_17) AT=640.05n

.meas tran vdout1_18ck630 FIND v(dout1_18) AT=640.05n

.meas tran vdout1_19ck630 FIND v(dout1_19) AT=640.05n

.meas tran vdout1_20ck630 FIND v(dout1_20) AT=640.05n

.meas tran vdout1_21ck630 FIND v(dout1_21) AT=640.05n

.meas tran vdout1_22ck630 FIND v(dout1_22) AT=640.05n

.meas tran vdout1_23ck630 FIND v(dout1_23) AT=640.05n

.meas tran vdout1_24ck630 FIND v(dout1_24) AT=640.05n

.meas tran vdout1_25ck630 FIND v(dout1_25) AT=640.05n

.meas tran vdout1_26ck630 FIND v(dout1_26) AT=640.05n

.meas tran vdout1_27ck630 FIND v(dout1_27) AT=640.05n

.meas tran vdout1_28ck630 FIND v(dout1_28) AT=640.05n

.meas tran vdout1_29ck630 FIND v(dout1_29) AT=640.05n

.meas tran vdout1_30ck630 FIND v(dout1_30) AT=640.05n

.meas tran vdout1_31ck630 FIND v(dout1_31) AT=640.05n

.meas tran vdout1_32ck630 FIND v(dout1_32) AT=640.05n

.meas tran vdout1_0ck660 FIND v(dout1_0) AT=670.05n

.meas tran vdout1_1ck660 FIND v(dout1_1) AT=670.05n

.meas tran vdout1_2ck660 FIND v(dout1_2) AT=670.05n

.meas tran vdout1_3ck660 FIND v(dout1_3) AT=670.05n

.meas tran vdout1_4ck660 FIND v(dout1_4) AT=670.05n

.meas tran vdout1_5ck660 FIND v(dout1_5) AT=670.05n

.meas tran vdout1_6ck660 FIND v(dout1_6) AT=670.05n

.meas tran vdout1_7ck660 FIND v(dout1_7) AT=670.05n

.meas tran vdout1_8ck660 FIND v(dout1_8) AT=670.05n

.meas tran vdout1_9ck660 FIND v(dout1_9) AT=670.05n

.meas tran vdout1_10ck660 FIND v(dout1_10) AT=670.05n

.meas tran vdout1_11ck660 FIND v(dout1_11) AT=670.05n

.meas tran vdout1_12ck660 FIND v(dout1_12) AT=670.05n

.meas tran vdout1_13ck660 FIND v(dout1_13) AT=670.05n

.meas tran vdout1_14ck660 FIND v(dout1_14) AT=670.05n

.meas tran vdout1_15ck660 FIND v(dout1_15) AT=670.05n

.meas tran vdout1_16ck660 FIND v(dout1_16) AT=670.05n

.meas tran vdout1_17ck660 FIND v(dout1_17) AT=670.05n

.meas tran vdout1_18ck660 FIND v(dout1_18) AT=670.05n

.meas tran vdout1_19ck660 FIND v(dout1_19) AT=670.05n

.meas tran vdout1_20ck660 FIND v(dout1_20) AT=670.05n

.meas tran vdout1_21ck660 FIND v(dout1_21) AT=670.05n

.meas tran vdout1_22ck660 FIND v(dout1_22) AT=670.05n

.meas tran vdout1_23ck660 FIND v(dout1_23) AT=670.05n

.meas tran vdout1_24ck660 FIND v(dout1_24) AT=670.05n

.meas tran vdout1_25ck660 FIND v(dout1_25) AT=670.05n

.meas tran vdout1_26ck660 FIND v(dout1_26) AT=670.05n

.meas tran vdout1_27ck660 FIND v(dout1_27) AT=670.05n

.meas tran vdout1_28ck660 FIND v(dout1_28) AT=670.05n

.meas tran vdout1_29ck660 FIND v(dout1_29) AT=670.05n

.meas tran vdout1_30ck660 FIND v(dout1_30) AT=670.05n

.meas tran vdout1_31ck660 FIND v(dout1_31) AT=670.05n

.meas tran vdout1_32ck660 FIND v(dout1_32) AT=670.05n

.meas tran vdout1_0ck670 FIND v(dout1_0) AT=680.05n

.meas tran vdout1_1ck670 FIND v(dout1_1) AT=680.05n

.meas tran vdout1_2ck670 FIND v(dout1_2) AT=680.05n

.meas tran vdout1_3ck670 FIND v(dout1_3) AT=680.05n

.meas tran vdout1_4ck670 FIND v(dout1_4) AT=680.05n

.meas tran vdout1_5ck670 FIND v(dout1_5) AT=680.05n

.meas tran vdout1_6ck670 FIND v(dout1_6) AT=680.05n

.meas tran vdout1_7ck670 FIND v(dout1_7) AT=680.05n

.meas tran vdout1_8ck670 FIND v(dout1_8) AT=680.05n

.meas tran vdout1_9ck670 FIND v(dout1_9) AT=680.05n

.meas tran vdout1_10ck670 FIND v(dout1_10) AT=680.05n

.meas tran vdout1_11ck670 FIND v(dout1_11) AT=680.05n

.meas tran vdout1_12ck670 FIND v(dout1_12) AT=680.05n

.meas tran vdout1_13ck670 FIND v(dout1_13) AT=680.05n

.meas tran vdout1_14ck670 FIND v(dout1_14) AT=680.05n

.meas tran vdout1_15ck670 FIND v(dout1_15) AT=680.05n

.meas tran vdout1_16ck670 FIND v(dout1_16) AT=680.05n

.meas tran vdout1_17ck670 FIND v(dout1_17) AT=680.05n

.meas tran vdout1_18ck670 FIND v(dout1_18) AT=680.05n

.meas tran vdout1_19ck670 FIND v(dout1_19) AT=680.05n

.meas tran vdout1_20ck670 FIND v(dout1_20) AT=680.05n

.meas tran vdout1_21ck670 FIND v(dout1_21) AT=680.05n

.meas tran vdout1_22ck670 FIND v(dout1_22) AT=680.05n

.meas tran vdout1_23ck670 FIND v(dout1_23) AT=680.05n

.meas tran vdout1_24ck670 FIND v(dout1_24) AT=680.05n

.meas tran vdout1_25ck670 FIND v(dout1_25) AT=680.05n

.meas tran vdout1_26ck670 FIND v(dout1_26) AT=680.05n

.meas tran vdout1_27ck670 FIND v(dout1_27) AT=680.05n

.meas tran vdout1_28ck670 FIND v(dout1_28) AT=680.05n

.meas tran vdout1_29ck670 FIND v(dout1_29) AT=680.05n

.meas tran vdout1_30ck670 FIND v(dout1_30) AT=680.05n

.meas tran vdout1_31ck670 FIND v(dout1_31) AT=680.05n

.meas tran vdout1_32ck670 FIND v(dout1_32) AT=680.05n

.meas tran vdout1_0ck680 FIND v(dout1_0) AT=690.05n

.meas tran vdout1_1ck680 FIND v(dout1_1) AT=690.05n

.meas tran vdout1_2ck680 FIND v(dout1_2) AT=690.05n

.meas tran vdout1_3ck680 FIND v(dout1_3) AT=690.05n

.meas tran vdout1_4ck680 FIND v(dout1_4) AT=690.05n

.meas tran vdout1_5ck680 FIND v(dout1_5) AT=690.05n

.meas tran vdout1_6ck680 FIND v(dout1_6) AT=690.05n

.meas tran vdout1_7ck680 FIND v(dout1_7) AT=690.05n

.meas tran vdout1_8ck680 FIND v(dout1_8) AT=690.05n

.meas tran vdout1_9ck680 FIND v(dout1_9) AT=690.05n

.meas tran vdout1_10ck680 FIND v(dout1_10) AT=690.05n

.meas tran vdout1_11ck680 FIND v(dout1_11) AT=690.05n

.meas tran vdout1_12ck680 FIND v(dout1_12) AT=690.05n

.meas tran vdout1_13ck680 FIND v(dout1_13) AT=690.05n

.meas tran vdout1_14ck680 FIND v(dout1_14) AT=690.05n

.meas tran vdout1_15ck680 FIND v(dout1_15) AT=690.05n

.meas tran vdout1_16ck680 FIND v(dout1_16) AT=690.05n

.meas tran vdout1_17ck680 FIND v(dout1_17) AT=690.05n

.meas tran vdout1_18ck680 FIND v(dout1_18) AT=690.05n

.meas tran vdout1_19ck680 FIND v(dout1_19) AT=690.05n

.meas tran vdout1_20ck680 FIND v(dout1_20) AT=690.05n

.meas tran vdout1_21ck680 FIND v(dout1_21) AT=690.05n

.meas tran vdout1_22ck680 FIND v(dout1_22) AT=690.05n

.meas tran vdout1_23ck680 FIND v(dout1_23) AT=690.05n

.meas tran vdout1_24ck680 FIND v(dout1_24) AT=690.05n

.meas tran vdout1_25ck680 FIND v(dout1_25) AT=690.05n

.meas tran vdout1_26ck680 FIND v(dout1_26) AT=690.05n

.meas tran vdout1_27ck680 FIND v(dout1_27) AT=690.05n

.meas tran vdout1_28ck680 FIND v(dout1_28) AT=690.05n

.meas tran vdout1_29ck680 FIND v(dout1_29) AT=690.05n

.meas tran vdout1_30ck680 FIND v(dout1_30) AT=690.05n

.meas tran vdout1_31ck680 FIND v(dout1_31) AT=690.05n

.meas tran vdout1_32ck680 FIND v(dout1_32) AT=690.05n

.meas tran vdout1_0ck690 FIND v(dout1_0) AT=700.05n

.meas tran vdout1_1ck690 FIND v(dout1_1) AT=700.05n

.meas tran vdout1_2ck690 FIND v(dout1_2) AT=700.05n

.meas tran vdout1_3ck690 FIND v(dout1_3) AT=700.05n

.meas tran vdout1_4ck690 FIND v(dout1_4) AT=700.05n

.meas tran vdout1_5ck690 FIND v(dout1_5) AT=700.05n

.meas tran vdout1_6ck690 FIND v(dout1_6) AT=700.05n

.meas tran vdout1_7ck690 FIND v(dout1_7) AT=700.05n

.meas tran vdout1_8ck690 FIND v(dout1_8) AT=700.05n

.meas tran vdout1_9ck690 FIND v(dout1_9) AT=700.05n

.meas tran vdout1_10ck690 FIND v(dout1_10) AT=700.05n

.meas tran vdout1_11ck690 FIND v(dout1_11) AT=700.05n

.meas tran vdout1_12ck690 FIND v(dout1_12) AT=700.05n

.meas tran vdout1_13ck690 FIND v(dout1_13) AT=700.05n

.meas tran vdout1_14ck690 FIND v(dout1_14) AT=700.05n

.meas tran vdout1_15ck690 FIND v(dout1_15) AT=700.05n

.meas tran vdout1_16ck690 FIND v(dout1_16) AT=700.05n

.meas tran vdout1_17ck690 FIND v(dout1_17) AT=700.05n

.meas tran vdout1_18ck690 FIND v(dout1_18) AT=700.05n

.meas tran vdout1_19ck690 FIND v(dout1_19) AT=700.05n

.meas tran vdout1_20ck690 FIND v(dout1_20) AT=700.05n

.meas tran vdout1_21ck690 FIND v(dout1_21) AT=700.05n

.meas tran vdout1_22ck690 FIND v(dout1_22) AT=700.05n

.meas tran vdout1_23ck690 FIND v(dout1_23) AT=700.05n

.meas tran vdout1_24ck690 FIND v(dout1_24) AT=700.05n

.meas tran vdout1_25ck690 FIND v(dout1_25) AT=700.05n

.meas tran vdout1_26ck690 FIND v(dout1_26) AT=700.05n

.meas tran vdout1_27ck690 FIND v(dout1_27) AT=700.05n

.meas tran vdout1_28ck690 FIND v(dout1_28) AT=700.05n

.meas tran vdout1_29ck690 FIND v(dout1_29) AT=700.05n

.meas tran vdout1_30ck690 FIND v(dout1_30) AT=700.05n

.meas tran vdout1_31ck690 FIND v(dout1_31) AT=700.05n

.meas tran vdout1_32ck690 FIND v(dout1_32) AT=700.05n

.meas tran vdout1_0ck740 FIND v(dout1_0) AT=750.05n

.meas tran vdout1_1ck740 FIND v(dout1_1) AT=750.05n

.meas tran vdout1_2ck740 FIND v(dout1_2) AT=750.05n

.meas tran vdout1_3ck740 FIND v(dout1_3) AT=750.05n

.meas tran vdout1_4ck740 FIND v(dout1_4) AT=750.05n

.meas tran vdout1_5ck740 FIND v(dout1_5) AT=750.05n

.meas tran vdout1_6ck740 FIND v(dout1_6) AT=750.05n

.meas tran vdout1_7ck740 FIND v(dout1_7) AT=750.05n

.meas tran vdout1_8ck740 FIND v(dout1_8) AT=750.05n

.meas tran vdout1_9ck740 FIND v(dout1_9) AT=750.05n

.meas tran vdout1_10ck740 FIND v(dout1_10) AT=750.05n

.meas tran vdout1_11ck740 FIND v(dout1_11) AT=750.05n

.meas tran vdout1_12ck740 FIND v(dout1_12) AT=750.05n

.meas tran vdout1_13ck740 FIND v(dout1_13) AT=750.05n

.meas tran vdout1_14ck740 FIND v(dout1_14) AT=750.05n

.meas tran vdout1_15ck740 FIND v(dout1_15) AT=750.05n

.meas tran vdout1_16ck740 FIND v(dout1_16) AT=750.05n

.meas tran vdout1_17ck740 FIND v(dout1_17) AT=750.05n

.meas tran vdout1_18ck740 FIND v(dout1_18) AT=750.05n

.meas tran vdout1_19ck740 FIND v(dout1_19) AT=750.05n

.meas tran vdout1_20ck740 FIND v(dout1_20) AT=750.05n

.meas tran vdout1_21ck740 FIND v(dout1_21) AT=750.05n

.meas tran vdout1_22ck740 FIND v(dout1_22) AT=750.05n

.meas tran vdout1_23ck740 FIND v(dout1_23) AT=750.05n

.meas tran vdout1_24ck740 FIND v(dout1_24) AT=750.05n

.meas tran vdout1_25ck740 FIND v(dout1_25) AT=750.05n

.meas tran vdout1_26ck740 FIND v(dout1_26) AT=750.05n

.meas tran vdout1_27ck740 FIND v(dout1_27) AT=750.05n

.meas tran vdout1_28ck740 FIND v(dout1_28) AT=750.05n

.meas tran vdout1_29ck740 FIND v(dout1_29) AT=750.05n

.meas tran vdout1_30ck740 FIND v(dout1_30) AT=750.05n

.meas tran vdout1_31ck740 FIND v(dout1_31) AT=750.05n

.meas tran vdout1_32ck740 FIND v(dout1_32) AT=750.05n

.meas tran vdout1_0ck750 FIND v(dout1_0) AT=760.05n

.meas tran vdout1_1ck750 FIND v(dout1_1) AT=760.05n

.meas tran vdout1_2ck750 FIND v(dout1_2) AT=760.05n

.meas tran vdout1_3ck750 FIND v(dout1_3) AT=760.05n

.meas tran vdout1_4ck750 FIND v(dout1_4) AT=760.05n

.meas tran vdout1_5ck750 FIND v(dout1_5) AT=760.05n

.meas tran vdout1_6ck750 FIND v(dout1_6) AT=760.05n

.meas tran vdout1_7ck750 FIND v(dout1_7) AT=760.05n

.meas tran vdout1_8ck750 FIND v(dout1_8) AT=760.05n

.meas tran vdout1_9ck750 FIND v(dout1_9) AT=760.05n

.meas tran vdout1_10ck750 FIND v(dout1_10) AT=760.05n

.meas tran vdout1_11ck750 FIND v(dout1_11) AT=760.05n

.meas tran vdout1_12ck750 FIND v(dout1_12) AT=760.05n

.meas tran vdout1_13ck750 FIND v(dout1_13) AT=760.05n

.meas tran vdout1_14ck750 FIND v(dout1_14) AT=760.05n

.meas tran vdout1_15ck750 FIND v(dout1_15) AT=760.05n

.meas tran vdout1_16ck750 FIND v(dout1_16) AT=760.05n

.meas tran vdout1_17ck750 FIND v(dout1_17) AT=760.05n

.meas tran vdout1_18ck750 FIND v(dout1_18) AT=760.05n

.meas tran vdout1_19ck750 FIND v(dout1_19) AT=760.05n

.meas tran vdout1_20ck750 FIND v(dout1_20) AT=760.05n

.meas tran vdout1_21ck750 FIND v(dout1_21) AT=760.05n

.meas tran vdout1_22ck750 FIND v(dout1_22) AT=760.05n

.meas tran vdout1_23ck750 FIND v(dout1_23) AT=760.05n

.meas tran vdout1_24ck750 FIND v(dout1_24) AT=760.05n

.meas tran vdout1_25ck750 FIND v(dout1_25) AT=760.05n

.meas tran vdout1_26ck750 FIND v(dout1_26) AT=760.05n

.meas tran vdout1_27ck750 FIND v(dout1_27) AT=760.05n

.meas tran vdout1_28ck750 FIND v(dout1_28) AT=760.05n

.meas tran vdout1_29ck750 FIND v(dout1_29) AT=760.05n

.meas tran vdout1_30ck750 FIND v(dout1_30) AT=760.05n

.meas tran vdout1_31ck750 FIND v(dout1_31) AT=760.05n

.meas tran vdout1_32ck750 FIND v(dout1_32) AT=760.05n

.meas tran vdout1_0ck760 FIND v(dout1_0) AT=770.05n

.meas tran vdout1_1ck760 FIND v(dout1_1) AT=770.05n

.meas tran vdout1_2ck760 FIND v(dout1_2) AT=770.05n

.meas tran vdout1_3ck760 FIND v(dout1_3) AT=770.05n

.meas tran vdout1_4ck760 FIND v(dout1_4) AT=770.05n

.meas tran vdout1_5ck760 FIND v(dout1_5) AT=770.05n

.meas tran vdout1_6ck760 FIND v(dout1_6) AT=770.05n

.meas tran vdout1_7ck760 FIND v(dout1_7) AT=770.05n

.meas tran vdout1_8ck760 FIND v(dout1_8) AT=770.05n

.meas tran vdout1_9ck760 FIND v(dout1_9) AT=770.05n

.meas tran vdout1_10ck760 FIND v(dout1_10) AT=770.05n

.meas tran vdout1_11ck760 FIND v(dout1_11) AT=770.05n

.meas tran vdout1_12ck760 FIND v(dout1_12) AT=770.05n

.meas tran vdout1_13ck760 FIND v(dout1_13) AT=770.05n

.meas tran vdout1_14ck760 FIND v(dout1_14) AT=770.05n

.meas tran vdout1_15ck760 FIND v(dout1_15) AT=770.05n

.meas tran vdout1_16ck760 FIND v(dout1_16) AT=770.05n

.meas tran vdout1_17ck760 FIND v(dout1_17) AT=770.05n

.meas tran vdout1_18ck760 FIND v(dout1_18) AT=770.05n

.meas tran vdout1_19ck760 FIND v(dout1_19) AT=770.05n

.meas tran vdout1_20ck760 FIND v(dout1_20) AT=770.05n

.meas tran vdout1_21ck760 FIND v(dout1_21) AT=770.05n

.meas tran vdout1_22ck760 FIND v(dout1_22) AT=770.05n

.meas tran vdout1_23ck760 FIND v(dout1_23) AT=770.05n

.meas tran vdout1_24ck760 FIND v(dout1_24) AT=770.05n

.meas tran vdout1_25ck760 FIND v(dout1_25) AT=770.05n

.meas tran vdout1_26ck760 FIND v(dout1_26) AT=770.05n

.meas tran vdout1_27ck760 FIND v(dout1_27) AT=770.05n

.meas tran vdout1_28ck760 FIND v(dout1_28) AT=770.05n

.meas tran vdout1_29ck760 FIND v(dout1_29) AT=770.05n

.meas tran vdout1_30ck760 FIND v(dout1_30) AT=770.05n

.meas tran vdout1_31ck760 FIND v(dout1_31) AT=770.05n

.meas tran vdout1_32ck760 FIND v(dout1_32) AT=770.05n

.meas tran vdout1_0ck770 FIND v(dout1_0) AT=780.05n

.meas tran vdout1_1ck770 FIND v(dout1_1) AT=780.05n

.meas tran vdout1_2ck770 FIND v(dout1_2) AT=780.05n

.meas tran vdout1_3ck770 FIND v(dout1_3) AT=780.05n

.meas tran vdout1_4ck770 FIND v(dout1_4) AT=780.05n

.meas tran vdout1_5ck770 FIND v(dout1_5) AT=780.05n

.meas tran vdout1_6ck770 FIND v(dout1_6) AT=780.05n

.meas tran vdout1_7ck770 FIND v(dout1_7) AT=780.05n

.meas tran vdout1_8ck770 FIND v(dout1_8) AT=780.05n

.meas tran vdout1_9ck770 FIND v(dout1_9) AT=780.05n

.meas tran vdout1_10ck770 FIND v(dout1_10) AT=780.05n

.meas tran vdout1_11ck770 FIND v(dout1_11) AT=780.05n

.meas tran vdout1_12ck770 FIND v(dout1_12) AT=780.05n

.meas tran vdout1_13ck770 FIND v(dout1_13) AT=780.05n

.meas tran vdout1_14ck770 FIND v(dout1_14) AT=780.05n

.meas tran vdout1_15ck770 FIND v(dout1_15) AT=780.05n

.meas tran vdout1_16ck770 FIND v(dout1_16) AT=780.05n

.meas tran vdout1_17ck770 FIND v(dout1_17) AT=780.05n

.meas tran vdout1_18ck770 FIND v(dout1_18) AT=780.05n

.meas tran vdout1_19ck770 FIND v(dout1_19) AT=780.05n

.meas tran vdout1_20ck770 FIND v(dout1_20) AT=780.05n

.meas tran vdout1_21ck770 FIND v(dout1_21) AT=780.05n

.meas tran vdout1_22ck770 FIND v(dout1_22) AT=780.05n

.meas tran vdout1_23ck770 FIND v(dout1_23) AT=780.05n

.meas tran vdout1_24ck770 FIND v(dout1_24) AT=780.05n

.meas tran vdout1_25ck770 FIND v(dout1_25) AT=780.05n

.meas tran vdout1_26ck770 FIND v(dout1_26) AT=780.05n

.meas tran vdout1_27ck770 FIND v(dout1_27) AT=780.05n

.meas tran vdout1_28ck770 FIND v(dout1_28) AT=780.05n

.meas tran vdout1_29ck770 FIND v(dout1_29) AT=780.05n

.meas tran vdout1_30ck770 FIND v(dout1_30) AT=780.05n

.meas tran vdout1_31ck770 FIND v(dout1_31) AT=780.05n

.meas tran vdout1_32ck770 FIND v(dout1_32) AT=780.05n

.meas tran vdout1_0ck800 FIND v(dout1_0) AT=810.05n

.meas tran vdout1_1ck800 FIND v(dout1_1) AT=810.05n

.meas tran vdout1_2ck800 FIND v(dout1_2) AT=810.05n

.meas tran vdout1_3ck800 FIND v(dout1_3) AT=810.05n

.meas tran vdout1_4ck800 FIND v(dout1_4) AT=810.05n

.meas tran vdout1_5ck800 FIND v(dout1_5) AT=810.05n

.meas tran vdout1_6ck800 FIND v(dout1_6) AT=810.05n

.meas tran vdout1_7ck800 FIND v(dout1_7) AT=810.05n

.meas tran vdout1_8ck800 FIND v(dout1_8) AT=810.05n

.meas tran vdout1_9ck800 FIND v(dout1_9) AT=810.05n

.meas tran vdout1_10ck800 FIND v(dout1_10) AT=810.05n

.meas tran vdout1_11ck800 FIND v(dout1_11) AT=810.05n

.meas tran vdout1_12ck800 FIND v(dout1_12) AT=810.05n

.meas tran vdout1_13ck800 FIND v(dout1_13) AT=810.05n

.meas tran vdout1_14ck800 FIND v(dout1_14) AT=810.05n

.meas tran vdout1_15ck800 FIND v(dout1_15) AT=810.05n

.meas tran vdout1_16ck800 FIND v(dout1_16) AT=810.05n

.meas tran vdout1_17ck800 FIND v(dout1_17) AT=810.05n

.meas tran vdout1_18ck800 FIND v(dout1_18) AT=810.05n

.meas tran vdout1_19ck800 FIND v(dout1_19) AT=810.05n

.meas tran vdout1_20ck800 FIND v(dout1_20) AT=810.05n

.meas tran vdout1_21ck800 FIND v(dout1_21) AT=810.05n

.meas tran vdout1_22ck800 FIND v(dout1_22) AT=810.05n

.meas tran vdout1_23ck800 FIND v(dout1_23) AT=810.05n

.meas tran vdout1_24ck800 FIND v(dout1_24) AT=810.05n

.meas tran vdout1_25ck800 FIND v(dout1_25) AT=810.05n

.meas tran vdout1_26ck800 FIND v(dout1_26) AT=810.05n

.meas tran vdout1_27ck800 FIND v(dout1_27) AT=810.05n

.meas tran vdout1_28ck800 FIND v(dout1_28) AT=810.05n

.meas tran vdout1_29ck800 FIND v(dout1_29) AT=810.05n

.meas tran vdout1_30ck800 FIND v(dout1_30) AT=810.05n

.meas tran vdout1_31ck800 FIND v(dout1_31) AT=810.05n

.meas tran vdout1_32ck800 FIND v(dout1_32) AT=810.05n

.meas tran vdout1_0ck810 FIND v(dout1_0) AT=820.05n

.meas tran vdout1_1ck810 FIND v(dout1_1) AT=820.05n

.meas tran vdout1_2ck810 FIND v(dout1_2) AT=820.05n

.meas tran vdout1_3ck810 FIND v(dout1_3) AT=820.05n

.meas tran vdout1_4ck810 FIND v(dout1_4) AT=820.05n

.meas tran vdout1_5ck810 FIND v(dout1_5) AT=820.05n

.meas tran vdout1_6ck810 FIND v(dout1_6) AT=820.05n

.meas tran vdout1_7ck810 FIND v(dout1_7) AT=820.05n

.meas tran vdout1_8ck810 FIND v(dout1_8) AT=820.05n

.meas tran vdout1_9ck810 FIND v(dout1_9) AT=820.05n

.meas tran vdout1_10ck810 FIND v(dout1_10) AT=820.05n

.meas tran vdout1_11ck810 FIND v(dout1_11) AT=820.05n

.meas tran vdout1_12ck810 FIND v(dout1_12) AT=820.05n

.meas tran vdout1_13ck810 FIND v(dout1_13) AT=820.05n

.meas tran vdout1_14ck810 FIND v(dout1_14) AT=820.05n

.meas tran vdout1_15ck810 FIND v(dout1_15) AT=820.05n

.meas tran vdout1_16ck810 FIND v(dout1_16) AT=820.05n

.meas tran vdout1_17ck810 FIND v(dout1_17) AT=820.05n

.meas tran vdout1_18ck810 FIND v(dout1_18) AT=820.05n

.meas tran vdout1_19ck810 FIND v(dout1_19) AT=820.05n

.meas tran vdout1_20ck810 FIND v(dout1_20) AT=820.05n

.meas tran vdout1_21ck810 FIND v(dout1_21) AT=820.05n

.meas tran vdout1_22ck810 FIND v(dout1_22) AT=820.05n

.meas tran vdout1_23ck810 FIND v(dout1_23) AT=820.05n

.meas tran vdout1_24ck810 FIND v(dout1_24) AT=820.05n

.meas tran vdout1_25ck810 FIND v(dout1_25) AT=820.05n

.meas tran vdout1_26ck810 FIND v(dout1_26) AT=820.05n

.meas tran vdout1_27ck810 FIND v(dout1_27) AT=820.05n

.meas tran vdout1_28ck810 FIND v(dout1_28) AT=820.05n

.meas tran vdout1_29ck810 FIND v(dout1_29) AT=820.05n

.meas tran vdout1_30ck810 FIND v(dout1_30) AT=820.05n

.meas tran vdout1_31ck810 FIND v(dout1_31) AT=820.05n

.meas tran vdout1_32ck810 FIND v(dout1_32) AT=820.05n

.meas tran vdout1_0ck820 FIND v(dout1_0) AT=830.05n

.meas tran vdout1_1ck820 FIND v(dout1_1) AT=830.05n

.meas tran vdout1_2ck820 FIND v(dout1_2) AT=830.05n

.meas tran vdout1_3ck820 FIND v(dout1_3) AT=830.05n

.meas tran vdout1_4ck820 FIND v(dout1_4) AT=830.05n

.meas tran vdout1_5ck820 FIND v(dout1_5) AT=830.05n

.meas tran vdout1_6ck820 FIND v(dout1_6) AT=830.05n

.meas tran vdout1_7ck820 FIND v(dout1_7) AT=830.05n

.meas tran vdout1_8ck820 FIND v(dout1_8) AT=830.05n

.meas tran vdout1_9ck820 FIND v(dout1_9) AT=830.05n

.meas tran vdout1_10ck820 FIND v(dout1_10) AT=830.05n

.meas tran vdout1_11ck820 FIND v(dout1_11) AT=830.05n

.meas tran vdout1_12ck820 FIND v(dout1_12) AT=830.05n

.meas tran vdout1_13ck820 FIND v(dout1_13) AT=830.05n

.meas tran vdout1_14ck820 FIND v(dout1_14) AT=830.05n

.meas tran vdout1_15ck820 FIND v(dout1_15) AT=830.05n

.meas tran vdout1_16ck820 FIND v(dout1_16) AT=830.05n

.meas tran vdout1_17ck820 FIND v(dout1_17) AT=830.05n

.meas tran vdout1_18ck820 FIND v(dout1_18) AT=830.05n

.meas tran vdout1_19ck820 FIND v(dout1_19) AT=830.05n

.meas tran vdout1_20ck820 FIND v(dout1_20) AT=830.05n

.meas tran vdout1_21ck820 FIND v(dout1_21) AT=830.05n

.meas tran vdout1_22ck820 FIND v(dout1_22) AT=830.05n

.meas tran vdout1_23ck820 FIND v(dout1_23) AT=830.05n

.meas tran vdout1_24ck820 FIND v(dout1_24) AT=830.05n

.meas tran vdout1_25ck820 FIND v(dout1_25) AT=830.05n

.meas tran vdout1_26ck820 FIND v(dout1_26) AT=830.05n

.meas tran vdout1_27ck820 FIND v(dout1_27) AT=830.05n

.meas tran vdout1_28ck820 FIND v(dout1_28) AT=830.05n

.meas tran vdout1_29ck820 FIND v(dout1_29) AT=830.05n

.meas tran vdout1_30ck820 FIND v(dout1_30) AT=830.05n

.meas tran vdout1_31ck820 FIND v(dout1_31) AT=830.05n

.meas tran vdout1_32ck820 FIND v(dout1_32) AT=830.05n

.meas tran vdout1_0ck860 FIND v(dout1_0) AT=870.05n

.meas tran vdout1_1ck860 FIND v(dout1_1) AT=870.05n

.meas tran vdout1_2ck860 FIND v(dout1_2) AT=870.05n

.meas tran vdout1_3ck860 FIND v(dout1_3) AT=870.05n

.meas tran vdout1_4ck860 FIND v(dout1_4) AT=870.05n

.meas tran vdout1_5ck860 FIND v(dout1_5) AT=870.05n

.meas tran vdout1_6ck860 FIND v(dout1_6) AT=870.05n

.meas tran vdout1_7ck860 FIND v(dout1_7) AT=870.05n

.meas tran vdout1_8ck860 FIND v(dout1_8) AT=870.05n

.meas tran vdout1_9ck860 FIND v(dout1_9) AT=870.05n

.meas tran vdout1_10ck860 FIND v(dout1_10) AT=870.05n

.meas tran vdout1_11ck860 FIND v(dout1_11) AT=870.05n

.meas tran vdout1_12ck860 FIND v(dout1_12) AT=870.05n

.meas tran vdout1_13ck860 FIND v(dout1_13) AT=870.05n

.meas tran vdout1_14ck860 FIND v(dout1_14) AT=870.05n

.meas tran vdout1_15ck860 FIND v(dout1_15) AT=870.05n

.meas tran vdout1_16ck860 FIND v(dout1_16) AT=870.05n

.meas tran vdout1_17ck860 FIND v(dout1_17) AT=870.05n

.meas tran vdout1_18ck860 FIND v(dout1_18) AT=870.05n

.meas tran vdout1_19ck860 FIND v(dout1_19) AT=870.05n

.meas tran vdout1_20ck860 FIND v(dout1_20) AT=870.05n

.meas tran vdout1_21ck860 FIND v(dout1_21) AT=870.05n

.meas tran vdout1_22ck860 FIND v(dout1_22) AT=870.05n

.meas tran vdout1_23ck860 FIND v(dout1_23) AT=870.05n

.meas tran vdout1_24ck860 FIND v(dout1_24) AT=870.05n

.meas tran vdout1_25ck860 FIND v(dout1_25) AT=870.05n

.meas tran vdout1_26ck860 FIND v(dout1_26) AT=870.05n

.meas tran vdout1_27ck860 FIND v(dout1_27) AT=870.05n

.meas tran vdout1_28ck860 FIND v(dout1_28) AT=870.05n

.meas tran vdout1_29ck860 FIND v(dout1_29) AT=870.05n

.meas tran vdout1_30ck860 FIND v(dout1_30) AT=870.05n

.meas tran vdout1_31ck860 FIND v(dout1_31) AT=870.05n

.meas tran vdout1_32ck860 FIND v(dout1_32) AT=870.05n

.meas tran vdout1_0ck870 FIND v(dout1_0) AT=880.05n

.meas tran vdout1_1ck870 FIND v(dout1_1) AT=880.05n

.meas tran vdout1_2ck870 FIND v(dout1_2) AT=880.05n

.meas tran vdout1_3ck870 FIND v(dout1_3) AT=880.05n

.meas tran vdout1_4ck870 FIND v(dout1_4) AT=880.05n

.meas tran vdout1_5ck870 FIND v(dout1_5) AT=880.05n

.meas tran vdout1_6ck870 FIND v(dout1_6) AT=880.05n

.meas tran vdout1_7ck870 FIND v(dout1_7) AT=880.05n

.meas tran vdout1_8ck870 FIND v(dout1_8) AT=880.05n

.meas tran vdout1_9ck870 FIND v(dout1_9) AT=880.05n

.meas tran vdout1_10ck870 FIND v(dout1_10) AT=880.05n

.meas tran vdout1_11ck870 FIND v(dout1_11) AT=880.05n

.meas tran vdout1_12ck870 FIND v(dout1_12) AT=880.05n

.meas tran vdout1_13ck870 FIND v(dout1_13) AT=880.05n

.meas tran vdout1_14ck870 FIND v(dout1_14) AT=880.05n

.meas tran vdout1_15ck870 FIND v(dout1_15) AT=880.05n

.meas tran vdout1_16ck870 FIND v(dout1_16) AT=880.05n

.meas tran vdout1_17ck870 FIND v(dout1_17) AT=880.05n

.meas tran vdout1_18ck870 FIND v(dout1_18) AT=880.05n

.meas tran vdout1_19ck870 FIND v(dout1_19) AT=880.05n

.meas tran vdout1_20ck870 FIND v(dout1_20) AT=880.05n

.meas tran vdout1_21ck870 FIND v(dout1_21) AT=880.05n

.meas tran vdout1_22ck870 FIND v(dout1_22) AT=880.05n

.meas tran vdout1_23ck870 FIND v(dout1_23) AT=880.05n

.meas tran vdout1_24ck870 FIND v(dout1_24) AT=880.05n

.meas tran vdout1_25ck870 FIND v(dout1_25) AT=880.05n

.meas tran vdout1_26ck870 FIND v(dout1_26) AT=880.05n

.meas tran vdout1_27ck870 FIND v(dout1_27) AT=880.05n

.meas tran vdout1_28ck870 FIND v(dout1_28) AT=880.05n

.meas tran vdout1_29ck870 FIND v(dout1_29) AT=880.05n

.meas tran vdout1_30ck870 FIND v(dout1_30) AT=880.05n

.meas tran vdout1_31ck870 FIND v(dout1_31) AT=880.05n

.meas tran vdout1_32ck870 FIND v(dout1_32) AT=880.05n

.meas tran vdout1_0ck910 FIND v(dout1_0) AT=920.05n

.meas tran vdout1_1ck910 FIND v(dout1_1) AT=920.05n

.meas tran vdout1_2ck910 FIND v(dout1_2) AT=920.05n

.meas tran vdout1_3ck910 FIND v(dout1_3) AT=920.05n

.meas tran vdout1_4ck910 FIND v(dout1_4) AT=920.05n

.meas tran vdout1_5ck910 FIND v(dout1_5) AT=920.05n

.meas tran vdout1_6ck910 FIND v(dout1_6) AT=920.05n

.meas tran vdout1_7ck910 FIND v(dout1_7) AT=920.05n

.meas tran vdout1_8ck910 FIND v(dout1_8) AT=920.05n

.meas tran vdout1_9ck910 FIND v(dout1_9) AT=920.05n

.meas tran vdout1_10ck910 FIND v(dout1_10) AT=920.05n

.meas tran vdout1_11ck910 FIND v(dout1_11) AT=920.05n

.meas tran vdout1_12ck910 FIND v(dout1_12) AT=920.05n

.meas tran vdout1_13ck910 FIND v(dout1_13) AT=920.05n

.meas tran vdout1_14ck910 FIND v(dout1_14) AT=920.05n

.meas tran vdout1_15ck910 FIND v(dout1_15) AT=920.05n

.meas tran vdout1_16ck910 FIND v(dout1_16) AT=920.05n

.meas tran vdout1_17ck910 FIND v(dout1_17) AT=920.05n

.meas tran vdout1_18ck910 FIND v(dout1_18) AT=920.05n

.meas tran vdout1_19ck910 FIND v(dout1_19) AT=920.05n

.meas tran vdout1_20ck910 FIND v(dout1_20) AT=920.05n

.meas tran vdout1_21ck910 FIND v(dout1_21) AT=920.05n

.meas tran vdout1_22ck910 FIND v(dout1_22) AT=920.05n

.meas tran vdout1_23ck910 FIND v(dout1_23) AT=920.05n

.meas tran vdout1_24ck910 FIND v(dout1_24) AT=920.05n

.meas tran vdout1_25ck910 FIND v(dout1_25) AT=920.05n

.meas tran vdout1_26ck910 FIND v(dout1_26) AT=920.05n

.meas tran vdout1_27ck910 FIND v(dout1_27) AT=920.05n

.meas tran vdout1_28ck910 FIND v(dout1_28) AT=920.05n

.meas tran vdout1_29ck910 FIND v(dout1_29) AT=920.05n

.meas tran vdout1_30ck910 FIND v(dout1_30) AT=920.05n

.meas tran vdout1_31ck910 FIND v(dout1_31) AT=920.05n

.meas tran vdout1_32ck910 FIND v(dout1_32) AT=920.05n

.meas tran vdout1_0ck940 FIND v(dout1_0) AT=950.05n

.meas tran vdout1_1ck940 FIND v(dout1_1) AT=950.05n

.meas tran vdout1_2ck940 FIND v(dout1_2) AT=950.05n

.meas tran vdout1_3ck940 FIND v(dout1_3) AT=950.05n

.meas tran vdout1_4ck940 FIND v(dout1_4) AT=950.05n

.meas tran vdout1_5ck940 FIND v(dout1_5) AT=950.05n

.meas tran vdout1_6ck940 FIND v(dout1_6) AT=950.05n

.meas tran vdout1_7ck940 FIND v(dout1_7) AT=950.05n

.meas tran vdout1_8ck940 FIND v(dout1_8) AT=950.05n

.meas tran vdout1_9ck940 FIND v(dout1_9) AT=950.05n

.meas tran vdout1_10ck940 FIND v(dout1_10) AT=950.05n

.meas tran vdout1_11ck940 FIND v(dout1_11) AT=950.05n

.meas tran vdout1_12ck940 FIND v(dout1_12) AT=950.05n

.meas tran vdout1_13ck940 FIND v(dout1_13) AT=950.05n

.meas tran vdout1_14ck940 FIND v(dout1_14) AT=950.05n

.meas tran vdout1_15ck940 FIND v(dout1_15) AT=950.05n

.meas tran vdout1_16ck940 FIND v(dout1_16) AT=950.05n

.meas tran vdout1_17ck940 FIND v(dout1_17) AT=950.05n

.meas tran vdout1_18ck940 FIND v(dout1_18) AT=950.05n

.meas tran vdout1_19ck940 FIND v(dout1_19) AT=950.05n

.meas tran vdout1_20ck940 FIND v(dout1_20) AT=950.05n

.meas tran vdout1_21ck940 FIND v(dout1_21) AT=950.05n

.meas tran vdout1_22ck940 FIND v(dout1_22) AT=950.05n

.meas tran vdout1_23ck940 FIND v(dout1_23) AT=950.05n

.meas tran vdout1_24ck940 FIND v(dout1_24) AT=950.05n

.meas tran vdout1_25ck940 FIND v(dout1_25) AT=950.05n

.meas tran vdout1_26ck940 FIND v(dout1_26) AT=950.05n

.meas tran vdout1_27ck940 FIND v(dout1_27) AT=950.05n

.meas tran vdout1_28ck940 FIND v(dout1_28) AT=950.05n

.meas tran vdout1_29ck940 FIND v(dout1_29) AT=950.05n

.meas tran vdout1_30ck940 FIND v(dout1_30) AT=950.05n

.meas tran vdout1_31ck940 FIND v(dout1_31) AT=950.05n

.meas tran vdout1_32ck940 FIND v(dout1_32) AT=950.05n

.meas tran vdout1_0ck950 FIND v(dout1_0) AT=960.05n

.meas tran vdout1_1ck950 FIND v(dout1_1) AT=960.05n

.meas tran vdout1_2ck950 FIND v(dout1_2) AT=960.05n

.meas tran vdout1_3ck950 FIND v(dout1_3) AT=960.05n

.meas tran vdout1_4ck950 FIND v(dout1_4) AT=960.05n

.meas tran vdout1_5ck950 FIND v(dout1_5) AT=960.05n

.meas tran vdout1_6ck950 FIND v(dout1_6) AT=960.05n

.meas tran vdout1_7ck950 FIND v(dout1_7) AT=960.05n

.meas tran vdout1_8ck950 FIND v(dout1_8) AT=960.05n

.meas tran vdout1_9ck950 FIND v(dout1_9) AT=960.05n

.meas tran vdout1_10ck950 FIND v(dout1_10) AT=960.05n

.meas tran vdout1_11ck950 FIND v(dout1_11) AT=960.05n

.meas tran vdout1_12ck950 FIND v(dout1_12) AT=960.05n

.meas tran vdout1_13ck950 FIND v(dout1_13) AT=960.05n

.meas tran vdout1_14ck950 FIND v(dout1_14) AT=960.05n

.meas tran vdout1_15ck950 FIND v(dout1_15) AT=960.05n

.meas tran vdout1_16ck950 FIND v(dout1_16) AT=960.05n

.meas tran vdout1_17ck950 FIND v(dout1_17) AT=960.05n

.meas tran vdout1_18ck950 FIND v(dout1_18) AT=960.05n

.meas tran vdout1_19ck950 FIND v(dout1_19) AT=960.05n

.meas tran vdout1_20ck950 FIND v(dout1_20) AT=960.05n

.meas tran vdout1_21ck950 FIND v(dout1_21) AT=960.05n

.meas tran vdout1_22ck950 FIND v(dout1_22) AT=960.05n

.meas tran vdout1_23ck950 FIND v(dout1_23) AT=960.05n

.meas tran vdout1_24ck950 FIND v(dout1_24) AT=960.05n

.meas tran vdout1_25ck950 FIND v(dout1_25) AT=960.05n

.meas tran vdout1_26ck950 FIND v(dout1_26) AT=960.05n

.meas tran vdout1_27ck950 FIND v(dout1_27) AT=960.05n

.meas tran vdout1_28ck950 FIND v(dout1_28) AT=960.05n

.meas tran vdout1_29ck950 FIND v(dout1_29) AT=960.05n

.meas tran vdout1_30ck950 FIND v(dout1_30) AT=960.05n

.meas tran vdout1_31ck950 FIND v(dout1_31) AT=960.05n

.meas tran vdout1_32ck950 FIND v(dout1_32) AT=960.05n

.meas tran vdout1_0ck980 FIND v(dout1_0) AT=990.05n

.meas tran vdout1_1ck980 FIND v(dout1_1) AT=990.05n

.meas tran vdout1_2ck980 FIND v(dout1_2) AT=990.05n

.meas tran vdout1_3ck980 FIND v(dout1_3) AT=990.05n

.meas tran vdout1_4ck980 FIND v(dout1_4) AT=990.05n

.meas tran vdout1_5ck980 FIND v(dout1_5) AT=990.05n

.meas tran vdout1_6ck980 FIND v(dout1_6) AT=990.05n

.meas tran vdout1_7ck980 FIND v(dout1_7) AT=990.05n

.meas tran vdout1_8ck980 FIND v(dout1_8) AT=990.05n

.meas tran vdout1_9ck980 FIND v(dout1_9) AT=990.05n

.meas tran vdout1_10ck980 FIND v(dout1_10) AT=990.05n

.meas tran vdout1_11ck980 FIND v(dout1_11) AT=990.05n

.meas tran vdout1_12ck980 FIND v(dout1_12) AT=990.05n

.meas tran vdout1_13ck980 FIND v(dout1_13) AT=990.05n

.meas tran vdout1_14ck980 FIND v(dout1_14) AT=990.05n

.meas tran vdout1_15ck980 FIND v(dout1_15) AT=990.05n

.meas tran vdout1_16ck980 FIND v(dout1_16) AT=990.05n

.meas tran vdout1_17ck980 FIND v(dout1_17) AT=990.05n

.meas tran vdout1_18ck980 FIND v(dout1_18) AT=990.05n

.meas tran vdout1_19ck980 FIND v(dout1_19) AT=990.05n

.meas tran vdout1_20ck980 FIND v(dout1_20) AT=990.05n

.meas tran vdout1_21ck980 FIND v(dout1_21) AT=990.05n

.meas tran vdout1_22ck980 FIND v(dout1_22) AT=990.05n

.meas tran vdout1_23ck980 FIND v(dout1_23) AT=990.05n

.meas tran vdout1_24ck980 FIND v(dout1_24) AT=990.05n

.meas tran vdout1_25ck980 FIND v(dout1_25) AT=990.05n

.meas tran vdout1_26ck980 FIND v(dout1_26) AT=990.05n

.meas tran vdout1_27ck980 FIND v(dout1_27) AT=990.05n

.meas tran vdout1_28ck980 FIND v(dout1_28) AT=990.05n

.meas tran vdout1_29ck980 FIND v(dout1_29) AT=990.05n

.meas tran vdout1_30ck980 FIND v(dout1_30) AT=990.05n

.meas tran vdout1_31ck980 FIND v(dout1_31) AT=990.05n

.meas tran vdout1_32ck980 FIND v(dout1_32) AT=990.05n

.meas tran vdout1_0ck990 FIND v(dout1_0) AT=1000.05n

.meas tran vdout1_1ck990 FIND v(dout1_1) AT=1000.05n

.meas tran vdout1_2ck990 FIND v(dout1_2) AT=1000.05n

.meas tran vdout1_3ck990 FIND v(dout1_3) AT=1000.05n

.meas tran vdout1_4ck990 FIND v(dout1_4) AT=1000.05n

.meas tran vdout1_5ck990 FIND v(dout1_5) AT=1000.05n

.meas tran vdout1_6ck990 FIND v(dout1_6) AT=1000.05n

.meas tran vdout1_7ck990 FIND v(dout1_7) AT=1000.05n

.meas tran vdout1_8ck990 FIND v(dout1_8) AT=1000.05n

.meas tran vdout1_9ck990 FIND v(dout1_9) AT=1000.05n

.meas tran vdout1_10ck990 FIND v(dout1_10) AT=1000.05n

.meas tran vdout1_11ck990 FIND v(dout1_11) AT=1000.05n

.meas tran vdout1_12ck990 FIND v(dout1_12) AT=1000.05n

.meas tran vdout1_13ck990 FIND v(dout1_13) AT=1000.05n

.meas tran vdout1_14ck990 FIND v(dout1_14) AT=1000.05n

.meas tran vdout1_15ck990 FIND v(dout1_15) AT=1000.05n

.meas tran vdout1_16ck990 FIND v(dout1_16) AT=1000.05n

.meas tran vdout1_17ck990 FIND v(dout1_17) AT=1000.05n

.meas tran vdout1_18ck990 FIND v(dout1_18) AT=1000.05n

.meas tran vdout1_19ck990 FIND v(dout1_19) AT=1000.05n

.meas tran vdout1_20ck990 FIND v(dout1_20) AT=1000.05n

.meas tran vdout1_21ck990 FIND v(dout1_21) AT=1000.05n

.meas tran vdout1_22ck990 FIND v(dout1_22) AT=1000.05n

.meas tran vdout1_23ck990 FIND v(dout1_23) AT=1000.05n

.meas tran vdout1_24ck990 FIND v(dout1_24) AT=1000.05n

.meas tran vdout1_25ck990 FIND v(dout1_25) AT=1000.05n

.meas tran vdout1_26ck990 FIND v(dout1_26) AT=1000.05n

.meas tran vdout1_27ck990 FIND v(dout1_27) AT=1000.05n

.meas tran vdout1_28ck990 FIND v(dout1_28) AT=1000.05n

.meas tran vdout1_29ck990 FIND v(dout1_29) AT=1000.05n

.meas tran vdout1_30ck990 FIND v(dout1_30) AT=1000.05n

.meas tran vdout1_31ck990 FIND v(dout1_31) AT=1000.05n

.meas tran vdout1_32ck990 FIND v(dout1_32) AT=1000.05n

.meas tran vdout1_0ck1030 FIND v(dout1_0) AT=1040.05n

.meas tran vdout1_1ck1030 FIND v(dout1_1) AT=1040.05n

.meas tran vdout1_2ck1030 FIND v(dout1_2) AT=1040.05n

.meas tran vdout1_3ck1030 FIND v(dout1_3) AT=1040.05n

.meas tran vdout1_4ck1030 FIND v(dout1_4) AT=1040.05n

.meas tran vdout1_5ck1030 FIND v(dout1_5) AT=1040.05n

.meas tran vdout1_6ck1030 FIND v(dout1_6) AT=1040.05n

.meas tran vdout1_7ck1030 FIND v(dout1_7) AT=1040.05n

.meas tran vdout1_8ck1030 FIND v(dout1_8) AT=1040.05n

.meas tran vdout1_9ck1030 FIND v(dout1_9) AT=1040.05n

.meas tran vdout1_10ck1030 FIND v(dout1_10) AT=1040.05n

.meas tran vdout1_11ck1030 FIND v(dout1_11) AT=1040.05n

.meas tran vdout1_12ck1030 FIND v(dout1_12) AT=1040.05n

.meas tran vdout1_13ck1030 FIND v(dout1_13) AT=1040.05n

.meas tran vdout1_14ck1030 FIND v(dout1_14) AT=1040.05n

.meas tran vdout1_15ck1030 FIND v(dout1_15) AT=1040.05n

.meas tran vdout1_16ck1030 FIND v(dout1_16) AT=1040.05n

.meas tran vdout1_17ck1030 FIND v(dout1_17) AT=1040.05n

.meas tran vdout1_18ck1030 FIND v(dout1_18) AT=1040.05n

.meas tran vdout1_19ck1030 FIND v(dout1_19) AT=1040.05n

.meas tran vdout1_20ck1030 FIND v(dout1_20) AT=1040.05n

.meas tran vdout1_21ck1030 FIND v(dout1_21) AT=1040.05n

.meas tran vdout1_22ck1030 FIND v(dout1_22) AT=1040.05n

.meas tran vdout1_23ck1030 FIND v(dout1_23) AT=1040.05n

.meas tran vdout1_24ck1030 FIND v(dout1_24) AT=1040.05n

.meas tran vdout1_25ck1030 FIND v(dout1_25) AT=1040.05n

.meas tran vdout1_26ck1030 FIND v(dout1_26) AT=1040.05n

.meas tran vdout1_27ck1030 FIND v(dout1_27) AT=1040.05n

.meas tran vdout1_28ck1030 FIND v(dout1_28) AT=1040.05n

.meas tran vdout1_29ck1030 FIND v(dout1_29) AT=1040.05n

.meas tran vdout1_30ck1030 FIND v(dout1_30) AT=1040.05n

.meas tran vdout1_31ck1030 FIND v(dout1_31) AT=1040.05n

.meas tran vdout1_32ck1030 FIND v(dout1_32) AT=1040.05n

.meas tran vdout1_0ck1060 FIND v(dout1_0) AT=1070.05n

.meas tran vdout1_1ck1060 FIND v(dout1_1) AT=1070.05n

.meas tran vdout1_2ck1060 FIND v(dout1_2) AT=1070.05n

.meas tran vdout1_3ck1060 FIND v(dout1_3) AT=1070.05n

.meas tran vdout1_4ck1060 FIND v(dout1_4) AT=1070.05n

.meas tran vdout1_5ck1060 FIND v(dout1_5) AT=1070.05n

.meas tran vdout1_6ck1060 FIND v(dout1_6) AT=1070.05n

.meas tran vdout1_7ck1060 FIND v(dout1_7) AT=1070.05n

.meas tran vdout1_8ck1060 FIND v(dout1_8) AT=1070.05n

.meas tran vdout1_9ck1060 FIND v(dout1_9) AT=1070.05n

.meas tran vdout1_10ck1060 FIND v(dout1_10) AT=1070.05n

.meas tran vdout1_11ck1060 FIND v(dout1_11) AT=1070.05n

.meas tran vdout1_12ck1060 FIND v(dout1_12) AT=1070.05n

.meas tran vdout1_13ck1060 FIND v(dout1_13) AT=1070.05n

.meas tran vdout1_14ck1060 FIND v(dout1_14) AT=1070.05n

.meas tran vdout1_15ck1060 FIND v(dout1_15) AT=1070.05n

.meas tran vdout1_16ck1060 FIND v(dout1_16) AT=1070.05n

.meas tran vdout1_17ck1060 FIND v(dout1_17) AT=1070.05n

.meas tran vdout1_18ck1060 FIND v(dout1_18) AT=1070.05n

.meas tran vdout1_19ck1060 FIND v(dout1_19) AT=1070.05n

.meas tran vdout1_20ck1060 FIND v(dout1_20) AT=1070.05n

.meas tran vdout1_21ck1060 FIND v(dout1_21) AT=1070.05n

.meas tran vdout1_22ck1060 FIND v(dout1_22) AT=1070.05n

.meas tran vdout1_23ck1060 FIND v(dout1_23) AT=1070.05n

.meas tran vdout1_24ck1060 FIND v(dout1_24) AT=1070.05n

.meas tran vdout1_25ck1060 FIND v(dout1_25) AT=1070.05n

.meas tran vdout1_26ck1060 FIND v(dout1_26) AT=1070.05n

.meas tran vdout1_27ck1060 FIND v(dout1_27) AT=1070.05n

.meas tran vdout1_28ck1060 FIND v(dout1_28) AT=1070.05n

.meas tran vdout1_29ck1060 FIND v(dout1_29) AT=1070.05n

.meas tran vdout1_30ck1060 FIND v(dout1_30) AT=1070.05n

.meas tran vdout1_31ck1060 FIND v(dout1_31) AT=1070.05n

.meas tran vdout1_32ck1060 FIND v(dout1_32) AT=1070.05n

.meas tran vdout1_0ck1070 FIND v(dout1_0) AT=1080.05n

.meas tran vdout1_1ck1070 FIND v(dout1_1) AT=1080.05n

.meas tran vdout1_2ck1070 FIND v(dout1_2) AT=1080.05n

.meas tran vdout1_3ck1070 FIND v(dout1_3) AT=1080.05n

.meas tran vdout1_4ck1070 FIND v(dout1_4) AT=1080.05n

.meas tran vdout1_5ck1070 FIND v(dout1_5) AT=1080.05n

.meas tran vdout1_6ck1070 FIND v(dout1_6) AT=1080.05n

.meas tran vdout1_7ck1070 FIND v(dout1_7) AT=1080.05n

.meas tran vdout1_8ck1070 FIND v(dout1_8) AT=1080.05n

.meas tran vdout1_9ck1070 FIND v(dout1_9) AT=1080.05n

.meas tran vdout1_10ck1070 FIND v(dout1_10) AT=1080.05n

.meas tran vdout1_11ck1070 FIND v(dout1_11) AT=1080.05n

.meas tran vdout1_12ck1070 FIND v(dout1_12) AT=1080.05n

.meas tran vdout1_13ck1070 FIND v(dout1_13) AT=1080.05n

.meas tran vdout1_14ck1070 FIND v(dout1_14) AT=1080.05n

.meas tran vdout1_15ck1070 FIND v(dout1_15) AT=1080.05n

.meas tran vdout1_16ck1070 FIND v(dout1_16) AT=1080.05n

.meas tran vdout1_17ck1070 FIND v(dout1_17) AT=1080.05n

.meas tran vdout1_18ck1070 FIND v(dout1_18) AT=1080.05n

.meas tran vdout1_19ck1070 FIND v(dout1_19) AT=1080.05n

.meas tran vdout1_20ck1070 FIND v(dout1_20) AT=1080.05n

.meas tran vdout1_21ck1070 FIND v(dout1_21) AT=1080.05n

.meas tran vdout1_22ck1070 FIND v(dout1_22) AT=1080.05n

.meas tran vdout1_23ck1070 FIND v(dout1_23) AT=1080.05n

.meas tran vdout1_24ck1070 FIND v(dout1_24) AT=1080.05n

.meas tran vdout1_25ck1070 FIND v(dout1_25) AT=1080.05n

.meas tran vdout1_26ck1070 FIND v(dout1_26) AT=1080.05n

.meas tran vdout1_27ck1070 FIND v(dout1_27) AT=1080.05n

.meas tran vdout1_28ck1070 FIND v(dout1_28) AT=1080.05n

.meas tran vdout1_29ck1070 FIND v(dout1_29) AT=1080.05n

.meas tran vdout1_30ck1070 FIND v(dout1_30) AT=1080.05n

.meas tran vdout1_31ck1070 FIND v(dout1_31) AT=1080.05n

.meas tran vdout1_32ck1070 FIND v(dout1_32) AT=1080.05n

.meas tran vdout1_0ck1120 FIND v(dout1_0) AT=1130.05n

.meas tran vdout1_1ck1120 FIND v(dout1_1) AT=1130.05n

.meas tran vdout1_2ck1120 FIND v(dout1_2) AT=1130.05n

.meas tran vdout1_3ck1120 FIND v(dout1_3) AT=1130.05n

.meas tran vdout1_4ck1120 FIND v(dout1_4) AT=1130.05n

.meas tran vdout1_5ck1120 FIND v(dout1_5) AT=1130.05n

.meas tran vdout1_6ck1120 FIND v(dout1_6) AT=1130.05n

.meas tran vdout1_7ck1120 FIND v(dout1_7) AT=1130.05n

.meas tran vdout1_8ck1120 FIND v(dout1_8) AT=1130.05n

.meas tran vdout1_9ck1120 FIND v(dout1_9) AT=1130.05n

.meas tran vdout1_10ck1120 FIND v(dout1_10) AT=1130.05n

.meas tran vdout1_11ck1120 FIND v(dout1_11) AT=1130.05n

.meas tran vdout1_12ck1120 FIND v(dout1_12) AT=1130.05n

.meas tran vdout1_13ck1120 FIND v(dout1_13) AT=1130.05n

.meas tran vdout1_14ck1120 FIND v(dout1_14) AT=1130.05n

.meas tran vdout1_15ck1120 FIND v(dout1_15) AT=1130.05n

.meas tran vdout1_16ck1120 FIND v(dout1_16) AT=1130.05n

.meas tran vdout1_17ck1120 FIND v(dout1_17) AT=1130.05n

.meas tran vdout1_18ck1120 FIND v(dout1_18) AT=1130.05n

.meas tran vdout1_19ck1120 FIND v(dout1_19) AT=1130.05n

.meas tran vdout1_20ck1120 FIND v(dout1_20) AT=1130.05n

.meas tran vdout1_21ck1120 FIND v(dout1_21) AT=1130.05n

.meas tran vdout1_22ck1120 FIND v(dout1_22) AT=1130.05n

.meas tran vdout1_23ck1120 FIND v(dout1_23) AT=1130.05n

.meas tran vdout1_24ck1120 FIND v(dout1_24) AT=1130.05n

.meas tran vdout1_25ck1120 FIND v(dout1_25) AT=1130.05n

.meas tran vdout1_26ck1120 FIND v(dout1_26) AT=1130.05n

.meas tran vdout1_27ck1120 FIND v(dout1_27) AT=1130.05n

.meas tran vdout1_28ck1120 FIND v(dout1_28) AT=1130.05n

.meas tran vdout1_29ck1120 FIND v(dout1_29) AT=1130.05n

.meas tran vdout1_30ck1120 FIND v(dout1_30) AT=1130.05n

.meas tran vdout1_31ck1120 FIND v(dout1_31) AT=1130.05n

.meas tran vdout1_32ck1120 FIND v(dout1_32) AT=1130.05n

.meas tran vdout1_0ck1140 FIND v(dout1_0) AT=1150.05n

.meas tran vdout1_1ck1140 FIND v(dout1_1) AT=1150.05n

.meas tran vdout1_2ck1140 FIND v(dout1_2) AT=1150.05n

.meas tran vdout1_3ck1140 FIND v(dout1_3) AT=1150.05n

.meas tran vdout1_4ck1140 FIND v(dout1_4) AT=1150.05n

.meas tran vdout1_5ck1140 FIND v(dout1_5) AT=1150.05n

.meas tran vdout1_6ck1140 FIND v(dout1_6) AT=1150.05n

.meas tran vdout1_7ck1140 FIND v(dout1_7) AT=1150.05n

.meas tran vdout1_8ck1140 FIND v(dout1_8) AT=1150.05n

.meas tran vdout1_9ck1140 FIND v(dout1_9) AT=1150.05n

.meas tran vdout1_10ck1140 FIND v(dout1_10) AT=1150.05n

.meas tran vdout1_11ck1140 FIND v(dout1_11) AT=1150.05n

.meas tran vdout1_12ck1140 FIND v(dout1_12) AT=1150.05n

.meas tran vdout1_13ck1140 FIND v(dout1_13) AT=1150.05n

.meas tran vdout1_14ck1140 FIND v(dout1_14) AT=1150.05n

.meas tran vdout1_15ck1140 FIND v(dout1_15) AT=1150.05n

.meas tran vdout1_16ck1140 FIND v(dout1_16) AT=1150.05n

.meas tran vdout1_17ck1140 FIND v(dout1_17) AT=1150.05n

.meas tran vdout1_18ck1140 FIND v(dout1_18) AT=1150.05n

.meas tran vdout1_19ck1140 FIND v(dout1_19) AT=1150.05n

.meas tran vdout1_20ck1140 FIND v(dout1_20) AT=1150.05n

.meas tran vdout1_21ck1140 FIND v(dout1_21) AT=1150.05n

.meas tran vdout1_22ck1140 FIND v(dout1_22) AT=1150.05n

.meas tran vdout1_23ck1140 FIND v(dout1_23) AT=1150.05n

.meas tran vdout1_24ck1140 FIND v(dout1_24) AT=1150.05n

.meas tran vdout1_25ck1140 FIND v(dout1_25) AT=1150.05n

.meas tran vdout1_26ck1140 FIND v(dout1_26) AT=1150.05n

.meas tran vdout1_27ck1140 FIND v(dout1_27) AT=1150.05n

.meas tran vdout1_28ck1140 FIND v(dout1_28) AT=1150.05n

.meas tran vdout1_29ck1140 FIND v(dout1_29) AT=1150.05n

.meas tran vdout1_30ck1140 FIND v(dout1_30) AT=1150.05n

.meas tran vdout1_31ck1140 FIND v(dout1_31) AT=1150.05n

.meas tran vdout1_32ck1140 FIND v(dout1_32) AT=1150.05n

.meas tran vdout1_0ck1150 FIND v(dout1_0) AT=1160.05n

.meas tran vdout1_1ck1150 FIND v(dout1_1) AT=1160.05n

.meas tran vdout1_2ck1150 FIND v(dout1_2) AT=1160.05n

.meas tran vdout1_3ck1150 FIND v(dout1_3) AT=1160.05n

.meas tran vdout1_4ck1150 FIND v(dout1_4) AT=1160.05n

.meas tran vdout1_5ck1150 FIND v(dout1_5) AT=1160.05n

.meas tran vdout1_6ck1150 FIND v(dout1_6) AT=1160.05n

.meas tran vdout1_7ck1150 FIND v(dout1_7) AT=1160.05n

.meas tran vdout1_8ck1150 FIND v(dout1_8) AT=1160.05n

.meas tran vdout1_9ck1150 FIND v(dout1_9) AT=1160.05n

.meas tran vdout1_10ck1150 FIND v(dout1_10) AT=1160.05n

.meas tran vdout1_11ck1150 FIND v(dout1_11) AT=1160.05n

.meas tran vdout1_12ck1150 FIND v(dout1_12) AT=1160.05n

.meas tran vdout1_13ck1150 FIND v(dout1_13) AT=1160.05n

.meas tran vdout1_14ck1150 FIND v(dout1_14) AT=1160.05n

.meas tran vdout1_15ck1150 FIND v(dout1_15) AT=1160.05n

.meas tran vdout1_16ck1150 FIND v(dout1_16) AT=1160.05n

.meas tran vdout1_17ck1150 FIND v(dout1_17) AT=1160.05n

.meas tran vdout1_18ck1150 FIND v(dout1_18) AT=1160.05n

.meas tran vdout1_19ck1150 FIND v(dout1_19) AT=1160.05n

.meas tran vdout1_20ck1150 FIND v(dout1_20) AT=1160.05n

.meas tran vdout1_21ck1150 FIND v(dout1_21) AT=1160.05n

.meas tran vdout1_22ck1150 FIND v(dout1_22) AT=1160.05n

.meas tran vdout1_23ck1150 FIND v(dout1_23) AT=1160.05n

.meas tran vdout1_24ck1150 FIND v(dout1_24) AT=1160.05n

.meas tran vdout1_25ck1150 FIND v(dout1_25) AT=1160.05n

.meas tran vdout1_26ck1150 FIND v(dout1_26) AT=1160.05n

.meas tran vdout1_27ck1150 FIND v(dout1_27) AT=1160.05n

.meas tran vdout1_28ck1150 FIND v(dout1_28) AT=1160.05n

.meas tran vdout1_29ck1150 FIND v(dout1_29) AT=1160.05n

.meas tran vdout1_30ck1150 FIND v(dout1_30) AT=1160.05n

.meas tran vdout1_31ck1150 FIND v(dout1_31) AT=1160.05n

.meas tran vdout1_32ck1150 FIND v(dout1_32) AT=1160.05n

.meas tran vdout1_0ck1160 FIND v(dout1_0) AT=1170.05n

.meas tran vdout1_1ck1160 FIND v(dout1_1) AT=1170.05n

.meas tran vdout1_2ck1160 FIND v(dout1_2) AT=1170.05n

.meas tran vdout1_3ck1160 FIND v(dout1_3) AT=1170.05n

.meas tran vdout1_4ck1160 FIND v(dout1_4) AT=1170.05n

.meas tran vdout1_5ck1160 FIND v(dout1_5) AT=1170.05n

.meas tran vdout1_6ck1160 FIND v(dout1_6) AT=1170.05n

.meas tran vdout1_7ck1160 FIND v(dout1_7) AT=1170.05n

.meas tran vdout1_8ck1160 FIND v(dout1_8) AT=1170.05n

.meas tran vdout1_9ck1160 FIND v(dout1_9) AT=1170.05n

.meas tran vdout1_10ck1160 FIND v(dout1_10) AT=1170.05n

.meas tran vdout1_11ck1160 FIND v(dout1_11) AT=1170.05n

.meas tran vdout1_12ck1160 FIND v(dout1_12) AT=1170.05n

.meas tran vdout1_13ck1160 FIND v(dout1_13) AT=1170.05n

.meas tran vdout1_14ck1160 FIND v(dout1_14) AT=1170.05n

.meas tran vdout1_15ck1160 FIND v(dout1_15) AT=1170.05n

.meas tran vdout1_16ck1160 FIND v(dout1_16) AT=1170.05n

.meas tran vdout1_17ck1160 FIND v(dout1_17) AT=1170.05n

.meas tran vdout1_18ck1160 FIND v(dout1_18) AT=1170.05n

.meas tran vdout1_19ck1160 FIND v(dout1_19) AT=1170.05n

.meas tran vdout1_20ck1160 FIND v(dout1_20) AT=1170.05n

.meas tran vdout1_21ck1160 FIND v(dout1_21) AT=1170.05n

.meas tran vdout1_22ck1160 FIND v(dout1_22) AT=1170.05n

.meas tran vdout1_23ck1160 FIND v(dout1_23) AT=1170.05n

.meas tran vdout1_24ck1160 FIND v(dout1_24) AT=1170.05n

.meas tran vdout1_25ck1160 FIND v(dout1_25) AT=1170.05n

.meas tran vdout1_26ck1160 FIND v(dout1_26) AT=1170.05n

.meas tran vdout1_27ck1160 FIND v(dout1_27) AT=1170.05n

.meas tran vdout1_28ck1160 FIND v(dout1_28) AT=1170.05n

.meas tran vdout1_29ck1160 FIND v(dout1_29) AT=1170.05n

.meas tran vdout1_30ck1160 FIND v(dout1_30) AT=1170.05n

.meas tran vdout1_31ck1160 FIND v(dout1_31) AT=1170.05n

.meas tran vdout1_32ck1160 FIND v(dout1_32) AT=1170.05n

.meas tran vdout1_0ck1190 FIND v(dout1_0) AT=1200.05n

.meas tran vdout1_1ck1190 FIND v(dout1_1) AT=1200.05n

.meas tran vdout1_2ck1190 FIND v(dout1_2) AT=1200.05n

.meas tran vdout1_3ck1190 FIND v(dout1_3) AT=1200.05n

.meas tran vdout1_4ck1190 FIND v(dout1_4) AT=1200.05n

.meas tran vdout1_5ck1190 FIND v(dout1_5) AT=1200.05n

.meas tran vdout1_6ck1190 FIND v(dout1_6) AT=1200.05n

.meas tran vdout1_7ck1190 FIND v(dout1_7) AT=1200.05n

.meas tran vdout1_8ck1190 FIND v(dout1_8) AT=1200.05n

.meas tran vdout1_9ck1190 FIND v(dout1_9) AT=1200.05n

.meas tran vdout1_10ck1190 FIND v(dout1_10) AT=1200.05n

.meas tran vdout1_11ck1190 FIND v(dout1_11) AT=1200.05n

.meas tran vdout1_12ck1190 FIND v(dout1_12) AT=1200.05n

.meas tran vdout1_13ck1190 FIND v(dout1_13) AT=1200.05n

.meas tran vdout1_14ck1190 FIND v(dout1_14) AT=1200.05n

.meas tran vdout1_15ck1190 FIND v(dout1_15) AT=1200.05n

.meas tran vdout1_16ck1190 FIND v(dout1_16) AT=1200.05n

.meas tran vdout1_17ck1190 FIND v(dout1_17) AT=1200.05n

.meas tran vdout1_18ck1190 FIND v(dout1_18) AT=1200.05n

.meas tran vdout1_19ck1190 FIND v(dout1_19) AT=1200.05n

.meas tran vdout1_20ck1190 FIND v(dout1_20) AT=1200.05n

.meas tran vdout1_21ck1190 FIND v(dout1_21) AT=1200.05n

.meas tran vdout1_22ck1190 FIND v(dout1_22) AT=1200.05n

.meas tran vdout1_23ck1190 FIND v(dout1_23) AT=1200.05n

.meas tran vdout1_24ck1190 FIND v(dout1_24) AT=1200.05n

.meas tran vdout1_25ck1190 FIND v(dout1_25) AT=1200.05n

.meas tran vdout1_26ck1190 FIND v(dout1_26) AT=1200.05n

.meas tran vdout1_27ck1190 FIND v(dout1_27) AT=1200.05n

.meas tran vdout1_28ck1190 FIND v(dout1_28) AT=1200.05n

.meas tran vdout1_29ck1190 FIND v(dout1_29) AT=1200.05n

.meas tran vdout1_30ck1190 FIND v(dout1_30) AT=1200.05n

.meas tran vdout1_31ck1190 FIND v(dout1_31) AT=1200.05n

.meas tran vdout1_32ck1190 FIND v(dout1_32) AT=1200.05n

.meas tran vdout1_0ck1220 FIND v(dout1_0) AT=1230.05n

.meas tran vdout1_1ck1220 FIND v(dout1_1) AT=1230.05n

.meas tran vdout1_2ck1220 FIND v(dout1_2) AT=1230.05n

.meas tran vdout1_3ck1220 FIND v(dout1_3) AT=1230.05n

.meas tran vdout1_4ck1220 FIND v(dout1_4) AT=1230.05n

.meas tran vdout1_5ck1220 FIND v(dout1_5) AT=1230.05n

.meas tran vdout1_6ck1220 FIND v(dout1_6) AT=1230.05n

.meas tran vdout1_7ck1220 FIND v(dout1_7) AT=1230.05n

.meas tran vdout1_8ck1220 FIND v(dout1_8) AT=1230.05n

.meas tran vdout1_9ck1220 FIND v(dout1_9) AT=1230.05n

.meas tran vdout1_10ck1220 FIND v(dout1_10) AT=1230.05n

.meas tran vdout1_11ck1220 FIND v(dout1_11) AT=1230.05n

.meas tran vdout1_12ck1220 FIND v(dout1_12) AT=1230.05n

.meas tran vdout1_13ck1220 FIND v(dout1_13) AT=1230.05n

.meas tran vdout1_14ck1220 FIND v(dout1_14) AT=1230.05n

.meas tran vdout1_15ck1220 FIND v(dout1_15) AT=1230.05n

.meas tran vdout1_16ck1220 FIND v(dout1_16) AT=1230.05n

.meas tran vdout1_17ck1220 FIND v(dout1_17) AT=1230.05n

.meas tran vdout1_18ck1220 FIND v(dout1_18) AT=1230.05n

.meas tran vdout1_19ck1220 FIND v(dout1_19) AT=1230.05n

.meas tran vdout1_20ck1220 FIND v(dout1_20) AT=1230.05n

.meas tran vdout1_21ck1220 FIND v(dout1_21) AT=1230.05n

.meas tran vdout1_22ck1220 FIND v(dout1_22) AT=1230.05n

.meas tran vdout1_23ck1220 FIND v(dout1_23) AT=1230.05n

.meas tran vdout1_24ck1220 FIND v(dout1_24) AT=1230.05n

.meas tran vdout1_25ck1220 FIND v(dout1_25) AT=1230.05n

.meas tran vdout1_26ck1220 FIND v(dout1_26) AT=1230.05n

.meas tran vdout1_27ck1220 FIND v(dout1_27) AT=1230.05n

.meas tran vdout1_28ck1220 FIND v(dout1_28) AT=1230.05n

.meas tran vdout1_29ck1220 FIND v(dout1_29) AT=1230.05n

.meas tran vdout1_30ck1220 FIND v(dout1_30) AT=1230.05n

.meas tran vdout1_31ck1220 FIND v(dout1_31) AT=1230.05n

.meas tran vdout1_32ck1220 FIND v(dout1_32) AT=1230.05n

.meas tran vdout1_0ck1230 FIND v(dout1_0) AT=1240.05n

.meas tran vdout1_1ck1230 FIND v(dout1_1) AT=1240.05n

.meas tran vdout1_2ck1230 FIND v(dout1_2) AT=1240.05n

.meas tran vdout1_3ck1230 FIND v(dout1_3) AT=1240.05n

.meas tran vdout1_4ck1230 FIND v(dout1_4) AT=1240.05n

.meas tran vdout1_5ck1230 FIND v(dout1_5) AT=1240.05n

.meas tran vdout1_6ck1230 FIND v(dout1_6) AT=1240.05n

.meas tran vdout1_7ck1230 FIND v(dout1_7) AT=1240.05n

.meas tran vdout1_8ck1230 FIND v(dout1_8) AT=1240.05n

.meas tran vdout1_9ck1230 FIND v(dout1_9) AT=1240.05n

.meas tran vdout1_10ck1230 FIND v(dout1_10) AT=1240.05n

.meas tran vdout1_11ck1230 FIND v(dout1_11) AT=1240.05n

.meas tran vdout1_12ck1230 FIND v(dout1_12) AT=1240.05n

.meas tran vdout1_13ck1230 FIND v(dout1_13) AT=1240.05n

.meas tran vdout1_14ck1230 FIND v(dout1_14) AT=1240.05n

.meas tran vdout1_15ck1230 FIND v(dout1_15) AT=1240.05n

.meas tran vdout1_16ck1230 FIND v(dout1_16) AT=1240.05n

.meas tran vdout1_17ck1230 FIND v(dout1_17) AT=1240.05n

.meas tran vdout1_18ck1230 FIND v(dout1_18) AT=1240.05n

.meas tran vdout1_19ck1230 FIND v(dout1_19) AT=1240.05n

.meas tran vdout1_20ck1230 FIND v(dout1_20) AT=1240.05n

.meas tran vdout1_21ck1230 FIND v(dout1_21) AT=1240.05n

.meas tran vdout1_22ck1230 FIND v(dout1_22) AT=1240.05n

.meas tran vdout1_23ck1230 FIND v(dout1_23) AT=1240.05n

.meas tran vdout1_24ck1230 FIND v(dout1_24) AT=1240.05n

.meas tran vdout1_25ck1230 FIND v(dout1_25) AT=1240.05n

.meas tran vdout1_26ck1230 FIND v(dout1_26) AT=1240.05n

.meas tran vdout1_27ck1230 FIND v(dout1_27) AT=1240.05n

.meas tran vdout1_28ck1230 FIND v(dout1_28) AT=1240.05n

.meas tran vdout1_29ck1230 FIND v(dout1_29) AT=1240.05n

.meas tran vdout1_30ck1230 FIND v(dout1_30) AT=1240.05n

.meas tran vdout1_31ck1230 FIND v(dout1_31) AT=1240.05n

.meas tran vdout1_32ck1230 FIND v(dout1_32) AT=1240.05n

.meas tran vdout1_0ck1260 FIND v(dout1_0) AT=1270.05n

.meas tran vdout1_1ck1260 FIND v(dout1_1) AT=1270.05n

.meas tran vdout1_2ck1260 FIND v(dout1_2) AT=1270.05n

.meas tran vdout1_3ck1260 FIND v(dout1_3) AT=1270.05n

.meas tran vdout1_4ck1260 FIND v(dout1_4) AT=1270.05n

.meas tran vdout1_5ck1260 FIND v(dout1_5) AT=1270.05n

.meas tran vdout1_6ck1260 FIND v(dout1_6) AT=1270.05n

.meas tran vdout1_7ck1260 FIND v(dout1_7) AT=1270.05n

.meas tran vdout1_8ck1260 FIND v(dout1_8) AT=1270.05n

.meas tran vdout1_9ck1260 FIND v(dout1_9) AT=1270.05n

.meas tran vdout1_10ck1260 FIND v(dout1_10) AT=1270.05n

.meas tran vdout1_11ck1260 FIND v(dout1_11) AT=1270.05n

.meas tran vdout1_12ck1260 FIND v(dout1_12) AT=1270.05n

.meas tran vdout1_13ck1260 FIND v(dout1_13) AT=1270.05n

.meas tran vdout1_14ck1260 FIND v(dout1_14) AT=1270.05n

.meas tran vdout1_15ck1260 FIND v(dout1_15) AT=1270.05n

.meas tran vdout1_16ck1260 FIND v(dout1_16) AT=1270.05n

.meas tran vdout1_17ck1260 FIND v(dout1_17) AT=1270.05n

.meas tran vdout1_18ck1260 FIND v(dout1_18) AT=1270.05n

.meas tran vdout1_19ck1260 FIND v(dout1_19) AT=1270.05n

.meas tran vdout1_20ck1260 FIND v(dout1_20) AT=1270.05n

.meas tran vdout1_21ck1260 FIND v(dout1_21) AT=1270.05n

.meas tran vdout1_22ck1260 FIND v(dout1_22) AT=1270.05n

.meas tran vdout1_23ck1260 FIND v(dout1_23) AT=1270.05n

.meas tran vdout1_24ck1260 FIND v(dout1_24) AT=1270.05n

.meas tran vdout1_25ck1260 FIND v(dout1_25) AT=1270.05n

.meas tran vdout1_26ck1260 FIND v(dout1_26) AT=1270.05n

.meas tran vdout1_27ck1260 FIND v(dout1_27) AT=1270.05n

.meas tran vdout1_28ck1260 FIND v(dout1_28) AT=1270.05n

.meas tran vdout1_29ck1260 FIND v(dout1_29) AT=1270.05n

.meas tran vdout1_30ck1260 FIND v(dout1_30) AT=1270.05n

.meas tran vdout1_31ck1260 FIND v(dout1_31) AT=1270.05n

.meas tran vdout1_32ck1260 FIND v(dout1_32) AT=1270.05n

.meas tran vdout1_0ck1270 FIND v(dout1_0) AT=1280.05n

.meas tran vdout1_1ck1270 FIND v(dout1_1) AT=1280.05n

.meas tran vdout1_2ck1270 FIND v(dout1_2) AT=1280.05n

.meas tran vdout1_3ck1270 FIND v(dout1_3) AT=1280.05n

.meas tran vdout1_4ck1270 FIND v(dout1_4) AT=1280.05n

.meas tran vdout1_5ck1270 FIND v(dout1_5) AT=1280.05n

.meas tran vdout1_6ck1270 FIND v(dout1_6) AT=1280.05n

.meas tran vdout1_7ck1270 FIND v(dout1_7) AT=1280.05n

.meas tran vdout1_8ck1270 FIND v(dout1_8) AT=1280.05n

.meas tran vdout1_9ck1270 FIND v(dout1_9) AT=1280.05n

.meas tran vdout1_10ck1270 FIND v(dout1_10) AT=1280.05n

.meas tran vdout1_11ck1270 FIND v(dout1_11) AT=1280.05n

.meas tran vdout1_12ck1270 FIND v(dout1_12) AT=1280.05n

.meas tran vdout1_13ck1270 FIND v(dout1_13) AT=1280.05n

.meas tran vdout1_14ck1270 FIND v(dout1_14) AT=1280.05n

.meas tran vdout1_15ck1270 FIND v(dout1_15) AT=1280.05n

.meas tran vdout1_16ck1270 FIND v(dout1_16) AT=1280.05n

.meas tran vdout1_17ck1270 FIND v(dout1_17) AT=1280.05n

.meas tran vdout1_18ck1270 FIND v(dout1_18) AT=1280.05n

.meas tran vdout1_19ck1270 FIND v(dout1_19) AT=1280.05n

.meas tran vdout1_20ck1270 FIND v(dout1_20) AT=1280.05n

.meas tran vdout1_21ck1270 FIND v(dout1_21) AT=1280.05n

.meas tran vdout1_22ck1270 FIND v(dout1_22) AT=1280.05n

.meas tran vdout1_23ck1270 FIND v(dout1_23) AT=1280.05n

.meas tran vdout1_24ck1270 FIND v(dout1_24) AT=1280.05n

.meas tran vdout1_25ck1270 FIND v(dout1_25) AT=1280.05n

.meas tran vdout1_26ck1270 FIND v(dout1_26) AT=1280.05n

.meas tran vdout1_27ck1270 FIND v(dout1_27) AT=1280.05n

.meas tran vdout1_28ck1270 FIND v(dout1_28) AT=1280.05n

.meas tran vdout1_29ck1270 FIND v(dout1_29) AT=1280.05n

.meas tran vdout1_30ck1270 FIND v(dout1_30) AT=1280.05n

.meas tran vdout1_31ck1270 FIND v(dout1_31) AT=1280.05n

.meas tran vdout1_32ck1270 FIND v(dout1_32) AT=1280.05n

.meas tran vdout1_0ck1280 FIND v(dout1_0) AT=1290.05n

.meas tran vdout1_1ck1280 FIND v(dout1_1) AT=1290.05n

.meas tran vdout1_2ck1280 FIND v(dout1_2) AT=1290.05n

.meas tran vdout1_3ck1280 FIND v(dout1_3) AT=1290.05n

.meas tran vdout1_4ck1280 FIND v(dout1_4) AT=1290.05n

.meas tran vdout1_5ck1280 FIND v(dout1_5) AT=1290.05n

.meas tran vdout1_6ck1280 FIND v(dout1_6) AT=1290.05n

.meas tran vdout1_7ck1280 FIND v(dout1_7) AT=1290.05n

.meas tran vdout1_8ck1280 FIND v(dout1_8) AT=1290.05n

.meas tran vdout1_9ck1280 FIND v(dout1_9) AT=1290.05n

.meas tran vdout1_10ck1280 FIND v(dout1_10) AT=1290.05n

.meas tran vdout1_11ck1280 FIND v(dout1_11) AT=1290.05n

.meas tran vdout1_12ck1280 FIND v(dout1_12) AT=1290.05n

.meas tran vdout1_13ck1280 FIND v(dout1_13) AT=1290.05n

.meas tran vdout1_14ck1280 FIND v(dout1_14) AT=1290.05n

.meas tran vdout1_15ck1280 FIND v(dout1_15) AT=1290.05n

.meas tran vdout1_16ck1280 FIND v(dout1_16) AT=1290.05n

.meas tran vdout1_17ck1280 FIND v(dout1_17) AT=1290.05n

.meas tran vdout1_18ck1280 FIND v(dout1_18) AT=1290.05n

.meas tran vdout1_19ck1280 FIND v(dout1_19) AT=1290.05n

.meas tran vdout1_20ck1280 FIND v(dout1_20) AT=1290.05n

.meas tran vdout1_21ck1280 FIND v(dout1_21) AT=1290.05n

.meas tran vdout1_22ck1280 FIND v(dout1_22) AT=1290.05n

.meas tran vdout1_23ck1280 FIND v(dout1_23) AT=1290.05n

.meas tran vdout1_24ck1280 FIND v(dout1_24) AT=1290.05n

.meas tran vdout1_25ck1280 FIND v(dout1_25) AT=1290.05n

.meas tran vdout1_26ck1280 FIND v(dout1_26) AT=1290.05n

.meas tran vdout1_27ck1280 FIND v(dout1_27) AT=1290.05n

.meas tran vdout1_28ck1280 FIND v(dout1_28) AT=1290.05n

.meas tran vdout1_29ck1280 FIND v(dout1_29) AT=1290.05n

.meas tran vdout1_30ck1280 FIND v(dout1_30) AT=1290.05n

.meas tran vdout1_31ck1280 FIND v(dout1_31) AT=1290.05n

.meas tran vdout1_32ck1280 FIND v(dout1_32) AT=1290.05n

.meas tran vdout1_0ck1300 FIND v(dout1_0) AT=1310.05n

.meas tran vdout1_1ck1300 FIND v(dout1_1) AT=1310.05n

.meas tran vdout1_2ck1300 FIND v(dout1_2) AT=1310.05n

.meas tran vdout1_3ck1300 FIND v(dout1_3) AT=1310.05n

.meas tran vdout1_4ck1300 FIND v(dout1_4) AT=1310.05n

.meas tran vdout1_5ck1300 FIND v(dout1_5) AT=1310.05n

.meas tran vdout1_6ck1300 FIND v(dout1_6) AT=1310.05n

.meas tran vdout1_7ck1300 FIND v(dout1_7) AT=1310.05n

.meas tran vdout1_8ck1300 FIND v(dout1_8) AT=1310.05n

.meas tran vdout1_9ck1300 FIND v(dout1_9) AT=1310.05n

.meas tran vdout1_10ck1300 FIND v(dout1_10) AT=1310.05n

.meas tran vdout1_11ck1300 FIND v(dout1_11) AT=1310.05n

.meas tran vdout1_12ck1300 FIND v(dout1_12) AT=1310.05n

.meas tran vdout1_13ck1300 FIND v(dout1_13) AT=1310.05n

.meas tran vdout1_14ck1300 FIND v(dout1_14) AT=1310.05n

.meas tran vdout1_15ck1300 FIND v(dout1_15) AT=1310.05n

.meas tran vdout1_16ck1300 FIND v(dout1_16) AT=1310.05n

.meas tran vdout1_17ck1300 FIND v(dout1_17) AT=1310.05n

.meas tran vdout1_18ck1300 FIND v(dout1_18) AT=1310.05n

.meas tran vdout1_19ck1300 FIND v(dout1_19) AT=1310.05n

.meas tran vdout1_20ck1300 FIND v(dout1_20) AT=1310.05n

.meas tran vdout1_21ck1300 FIND v(dout1_21) AT=1310.05n

.meas tran vdout1_22ck1300 FIND v(dout1_22) AT=1310.05n

.meas tran vdout1_23ck1300 FIND v(dout1_23) AT=1310.05n

.meas tran vdout1_24ck1300 FIND v(dout1_24) AT=1310.05n

.meas tran vdout1_25ck1300 FIND v(dout1_25) AT=1310.05n

.meas tran vdout1_26ck1300 FIND v(dout1_26) AT=1310.05n

.meas tran vdout1_27ck1300 FIND v(dout1_27) AT=1310.05n

.meas tran vdout1_28ck1300 FIND v(dout1_28) AT=1310.05n

.meas tran vdout1_29ck1300 FIND v(dout1_29) AT=1310.05n

.meas tran vdout1_30ck1300 FIND v(dout1_30) AT=1310.05n

.meas tran vdout1_31ck1300 FIND v(dout1_31) AT=1310.05n

.meas tran vdout1_32ck1300 FIND v(dout1_32) AT=1310.05n

.meas tran vdout1_0ck1310 FIND v(dout1_0) AT=1320.05n

.meas tran vdout1_1ck1310 FIND v(dout1_1) AT=1320.05n

.meas tran vdout1_2ck1310 FIND v(dout1_2) AT=1320.05n

.meas tran vdout1_3ck1310 FIND v(dout1_3) AT=1320.05n

.meas tran vdout1_4ck1310 FIND v(dout1_4) AT=1320.05n

.meas tran vdout1_5ck1310 FIND v(dout1_5) AT=1320.05n

.meas tran vdout1_6ck1310 FIND v(dout1_6) AT=1320.05n

.meas tran vdout1_7ck1310 FIND v(dout1_7) AT=1320.05n

.meas tran vdout1_8ck1310 FIND v(dout1_8) AT=1320.05n

.meas tran vdout1_9ck1310 FIND v(dout1_9) AT=1320.05n

.meas tran vdout1_10ck1310 FIND v(dout1_10) AT=1320.05n

.meas tran vdout1_11ck1310 FIND v(dout1_11) AT=1320.05n

.meas tran vdout1_12ck1310 FIND v(dout1_12) AT=1320.05n

.meas tran vdout1_13ck1310 FIND v(dout1_13) AT=1320.05n

.meas tran vdout1_14ck1310 FIND v(dout1_14) AT=1320.05n

.meas tran vdout1_15ck1310 FIND v(dout1_15) AT=1320.05n

.meas tran vdout1_16ck1310 FIND v(dout1_16) AT=1320.05n

.meas tran vdout1_17ck1310 FIND v(dout1_17) AT=1320.05n

.meas tran vdout1_18ck1310 FIND v(dout1_18) AT=1320.05n

.meas tran vdout1_19ck1310 FIND v(dout1_19) AT=1320.05n

.meas tran vdout1_20ck1310 FIND v(dout1_20) AT=1320.05n

.meas tran vdout1_21ck1310 FIND v(dout1_21) AT=1320.05n

.meas tran vdout1_22ck1310 FIND v(dout1_22) AT=1320.05n

.meas tran vdout1_23ck1310 FIND v(dout1_23) AT=1320.05n

.meas tran vdout1_24ck1310 FIND v(dout1_24) AT=1320.05n

.meas tran vdout1_25ck1310 FIND v(dout1_25) AT=1320.05n

.meas tran vdout1_26ck1310 FIND v(dout1_26) AT=1320.05n

.meas tran vdout1_27ck1310 FIND v(dout1_27) AT=1320.05n

.meas tran vdout1_28ck1310 FIND v(dout1_28) AT=1320.05n

.meas tran vdout1_29ck1310 FIND v(dout1_29) AT=1320.05n

.meas tran vdout1_30ck1310 FIND v(dout1_30) AT=1320.05n

.meas tran vdout1_31ck1310 FIND v(dout1_31) AT=1320.05n

.meas tran vdout1_32ck1310 FIND v(dout1_32) AT=1320.05n

.meas tran vdout1_0ck1320 FIND v(dout1_0) AT=1330.05n

.meas tran vdout1_1ck1320 FIND v(dout1_1) AT=1330.05n

.meas tran vdout1_2ck1320 FIND v(dout1_2) AT=1330.05n

.meas tran vdout1_3ck1320 FIND v(dout1_3) AT=1330.05n

.meas tran vdout1_4ck1320 FIND v(dout1_4) AT=1330.05n

.meas tran vdout1_5ck1320 FIND v(dout1_5) AT=1330.05n

.meas tran vdout1_6ck1320 FIND v(dout1_6) AT=1330.05n

.meas tran vdout1_7ck1320 FIND v(dout1_7) AT=1330.05n

.meas tran vdout1_8ck1320 FIND v(dout1_8) AT=1330.05n

.meas tran vdout1_9ck1320 FIND v(dout1_9) AT=1330.05n

.meas tran vdout1_10ck1320 FIND v(dout1_10) AT=1330.05n

.meas tran vdout1_11ck1320 FIND v(dout1_11) AT=1330.05n

.meas tran vdout1_12ck1320 FIND v(dout1_12) AT=1330.05n

.meas tran vdout1_13ck1320 FIND v(dout1_13) AT=1330.05n

.meas tran vdout1_14ck1320 FIND v(dout1_14) AT=1330.05n

.meas tran vdout1_15ck1320 FIND v(dout1_15) AT=1330.05n

.meas tran vdout1_16ck1320 FIND v(dout1_16) AT=1330.05n

.meas tran vdout1_17ck1320 FIND v(dout1_17) AT=1330.05n

.meas tran vdout1_18ck1320 FIND v(dout1_18) AT=1330.05n

.meas tran vdout1_19ck1320 FIND v(dout1_19) AT=1330.05n

.meas tran vdout1_20ck1320 FIND v(dout1_20) AT=1330.05n

.meas tran vdout1_21ck1320 FIND v(dout1_21) AT=1330.05n

.meas tran vdout1_22ck1320 FIND v(dout1_22) AT=1330.05n

.meas tran vdout1_23ck1320 FIND v(dout1_23) AT=1330.05n

.meas tran vdout1_24ck1320 FIND v(dout1_24) AT=1330.05n

.meas tran vdout1_25ck1320 FIND v(dout1_25) AT=1330.05n

.meas tran vdout1_26ck1320 FIND v(dout1_26) AT=1330.05n

.meas tran vdout1_27ck1320 FIND v(dout1_27) AT=1330.05n

.meas tran vdout1_28ck1320 FIND v(dout1_28) AT=1330.05n

.meas tran vdout1_29ck1320 FIND v(dout1_29) AT=1330.05n

.meas tran vdout1_30ck1320 FIND v(dout1_30) AT=1330.05n

.meas tran vdout1_31ck1320 FIND v(dout1_31) AT=1330.05n

.meas tran vdout1_32ck1320 FIND v(dout1_32) AT=1330.05n

.meas tran vdout1_0ck1350 FIND v(dout1_0) AT=1360.05n

.meas tran vdout1_1ck1350 FIND v(dout1_1) AT=1360.05n

.meas tran vdout1_2ck1350 FIND v(dout1_2) AT=1360.05n

.meas tran vdout1_3ck1350 FIND v(dout1_3) AT=1360.05n

.meas tran vdout1_4ck1350 FIND v(dout1_4) AT=1360.05n

.meas tran vdout1_5ck1350 FIND v(dout1_5) AT=1360.05n

.meas tran vdout1_6ck1350 FIND v(dout1_6) AT=1360.05n

.meas tran vdout1_7ck1350 FIND v(dout1_7) AT=1360.05n

.meas tran vdout1_8ck1350 FIND v(dout1_8) AT=1360.05n

.meas tran vdout1_9ck1350 FIND v(dout1_9) AT=1360.05n

.meas tran vdout1_10ck1350 FIND v(dout1_10) AT=1360.05n

.meas tran vdout1_11ck1350 FIND v(dout1_11) AT=1360.05n

.meas tran vdout1_12ck1350 FIND v(dout1_12) AT=1360.05n

.meas tran vdout1_13ck1350 FIND v(dout1_13) AT=1360.05n

.meas tran vdout1_14ck1350 FIND v(dout1_14) AT=1360.05n

.meas tran vdout1_15ck1350 FIND v(dout1_15) AT=1360.05n

.meas tran vdout1_16ck1350 FIND v(dout1_16) AT=1360.05n

.meas tran vdout1_17ck1350 FIND v(dout1_17) AT=1360.05n

.meas tran vdout1_18ck1350 FIND v(dout1_18) AT=1360.05n

.meas tran vdout1_19ck1350 FIND v(dout1_19) AT=1360.05n

.meas tran vdout1_20ck1350 FIND v(dout1_20) AT=1360.05n

.meas tran vdout1_21ck1350 FIND v(dout1_21) AT=1360.05n

.meas tran vdout1_22ck1350 FIND v(dout1_22) AT=1360.05n

.meas tran vdout1_23ck1350 FIND v(dout1_23) AT=1360.05n

.meas tran vdout1_24ck1350 FIND v(dout1_24) AT=1360.05n

.meas tran vdout1_25ck1350 FIND v(dout1_25) AT=1360.05n

.meas tran vdout1_26ck1350 FIND v(dout1_26) AT=1360.05n

.meas tran vdout1_27ck1350 FIND v(dout1_27) AT=1360.05n

.meas tran vdout1_28ck1350 FIND v(dout1_28) AT=1360.05n

.meas tran vdout1_29ck1350 FIND v(dout1_29) AT=1360.05n

.meas tran vdout1_30ck1350 FIND v(dout1_30) AT=1360.05n

.meas tran vdout1_31ck1350 FIND v(dout1_31) AT=1360.05n

.meas tran vdout1_32ck1350 FIND v(dout1_32) AT=1360.05n

.meas tran vdout1_0ck1360 FIND v(dout1_0) AT=1370.05n

.meas tran vdout1_1ck1360 FIND v(dout1_1) AT=1370.05n

.meas tran vdout1_2ck1360 FIND v(dout1_2) AT=1370.05n

.meas tran vdout1_3ck1360 FIND v(dout1_3) AT=1370.05n

.meas tran vdout1_4ck1360 FIND v(dout1_4) AT=1370.05n

.meas tran vdout1_5ck1360 FIND v(dout1_5) AT=1370.05n

.meas tran vdout1_6ck1360 FIND v(dout1_6) AT=1370.05n

.meas tran vdout1_7ck1360 FIND v(dout1_7) AT=1370.05n

.meas tran vdout1_8ck1360 FIND v(dout1_8) AT=1370.05n

.meas tran vdout1_9ck1360 FIND v(dout1_9) AT=1370.05n

.meas tran vdout1_10ck1360 FIND v(dout1_10) AT=1370.05n

.meas tran vdout1_11ck1360 FIND v(dout1_11) AT=1370.05n

.meas tran vdout1_12ck1360 FIND v(dout1_12) AT=1370.05n

.meas tran vdout1_13ck1360 FIND v(dout1_13) AT=1370.05n

.meas tran vdout1_14ck1360 FIND v(dout1_14) AT=1370.05n

.meas tran vdout1_15ck1360 FIND v(dout1_15) AT=1370.05n

.meas tran vdout1_16ck1360 FIND v(dout1_16) AT=1370.05n

.meas tran vdout1_17ck1360 FIND v(dout1_17) AT=1370.05n

.meas tran vdout1_18ck1360 FIND v(dout1_18) AT=1370.05n

.meas tran vdout1_19ck1360 FIND v(dout1_19) AT=1370.05n

.meas tran vdout1_20ck1360 FIND v(dout1_20) AT=1370.05n

.meas tran vdout1_21ck1360 FIND v(dout1_21) AT=1370.05n

.meas tran vdout1_22ck1360 FIND v(dout1_22) AT=1370.05n

.meas tran vdout1_23ck1360 FIND v(dout1_23) AT=1370.05n

.meas tran vdout1_24ck1360 FIND v(dout1_24) AT=1370.05n

.meas tran vdout1_25ck1360 FIND v(dout1_25) AT=1370.05n

.meas tran vdout1_26ck1360 FIND v(dout1_26) AT=1370.05n

.meas tran vdout1_27ck1360 FIND v(dout1_27) AT=1370.05n

.meas tran vdout1_28ck1360 FIND v(dout1_28) AT=1370.05n

.meas tran vdout1_29ck1360 FIND v(dout1_29) AT=1370.05n

.meas tran vdout1_30ck1360 FIND v(dout1_30) AT=1370.05n

.meas tran vdout1_31ck1360 FIND v(dout1_31) AT=1370.05n

.meas tran vdout1_32ck1360 FIND v(dout1_32) AT=1370.05n

.meas tran vdout1_0ck1370 FIND v(dout1_0) AT=1380.05n

.meas tran vdout1_1ck1370 FIND v(dout1_1) AT=1380.05n

.meas tran vdout1_2ck1370 FIND v(dout1_2) AT=1380.05n

.meas tran vdout1_3ck1370 FIND v(dout1_3) AT=1380.05n

.meas tran vdout1_4ck1370 FIND v(dout1_4) AT=1380.05n

.meas tran vdout1_5ck1370 FIND v(dout1_5) AT=1380.05n

.meas tran vdout1_6ck1370 FIND v(dout1_6) AT=1380.05n

.meas tran vdout1_7ck1370 FIND v(dout1_7) AT=1380.05n

.meas tran vdout1_8ck1370 FIND v(dout1_8) AT=1380.05n

.meas tran vdout1_9ck1370 FIND v(dout1_9) AT=1380.05n

.meas tran vdout1_10ck1370 FIND v(dout1_10) AT=1380.05n

.meas tran vdout1_11ck1370 FIND v(dout1_11) AT=1380.05n

.meas tran vdout1_12ck1370 FIND v(dout1_12) AT=1380.05n

.meas tran vdout1_13ck1370 FIND v(dout1_13) AT=1380.05n

.meas tran vdout1_14ck1370 FIND v(dout1_14) AT=1380.05n

.meas tran vdout1_15ck1370 FIND v(dout1_15) AT=1380.05n

.meas tran vdout1_16ck1370 FIND v(dout1_16) AT=1380.05n

.meas tran vdout1_17ck1370 FIND v(dout1_17) AT=1380.05n

.meas tran vdout1_18ck1370 FIND v(dout1_18) AT=1380.05n

.meas tran vdout1_19ck1370 FIND v(dout1_19) AT=1380.05n

.meas tran vdout1_20ck1370 FIND v(dout1_20) AT=1380.05n

.meas tran vdout1_21ck1370 FIND v(dout1_21) AT=1380.05n

.meas tran vdout1_22ck1370 FIND v(dout1_22) AT=1380.05n

.meas tran vdout1_23ck1370 FIND v(dout1_23) AT=1380.05n

.meas tran vdout1_24ck1370 FIND v(dout1_24) AT=1380.05n

.meas tran vdout1_25ck1370 FIND v(dout1_25) AT=1380.05n

.meas tran vdout1_26ck1370 FIND v(dout1_26) AT=1380.05n

.meas tran vdout1_27ck1370 FIND v(dout1_27) AT=1380.05n

.meas tran vdout1_28ck1370 FIND v(dout1_28) AT=1380.05n

.meas tran vdout1_29ck1370 FIND v(dout1_29) AT=1380.05n

.meas tran vdout1_30ck1370 FIND v(dout1_30) AT=1380.05n

.meas tran vdout1_31ck1370 FIND v(dout1_31) AT=1380.05n

.meas tran vdout1_32ck1370 FIND v(dout1_32) AT=1380.05n

.meas tran vdout1_0ck1390 FIND v(dout1_0) AT=1400.05n

.meas tran vdout1_1ck1390 FIND v(dout1_1) AT=1400.05n

.meas tran vdout1_2ck1390 FIND v(dout1_2) AT=1400.05n

.meas tran vdout1_3ck1390 FIND v(dout1_3) AT=1400.05n

.meas tran vdout1_4ck1390 FIND v(dout1_4) AT=1400.05n

.meas tran vdout1_5ck1390 FIND v(dout1_5) AT=1400.05n

.meas tran vdout1_6ck1390 FIND v(dout1_6) AT=1400.05n

.meas tran vdout1_7ck1390 FIND v(dout1_7) AT=1400.05n

.meas tran vdout1_8ck1390 FIND v(dout1_8) AT=1400.05n

.meas tran vdout1_9ck1390 FIND v(dout1_9) AT=1400.05n

.meas tran vdout1_10ck1390 FIND v(dout1_10) AT=1400.05n

.meas tran vdout1_11ck1390 FIND v(dout1_11) AT=1400.05n

.meas tran vdout1_12ck1390 FIND v(dout1_12) AT=1400.05n

.meas tran vdout1_13ck1390 FIND v(dout1_13) AT=1400.05n

.meas tran vdout1_14ck1390 FIND v(dout1_14) AT=1400.05n

.meas tran vdout1_15ck1390 FIND v(dout1_15) AT=1400.05n

.meas tran vdout1_16ck1390 FIND v(dout1_16) AT=1400.05n

.meas tran vdout1_17ck1390 FIND v(dout1_17) AT=1400.05n

.meas tran vdout1_18ck1390 FIND v(dout1_18) AT=1400.05n

.meas tran vdout1_19ck1390 FIND v(dout1_19) AT=1400.05n

.meas tran vdout1_20ck1390 FIND v(dout1_20) AT=1400.05n

.meas tran vdout1_21ck1390 FIND v(dout1_21) AT=1400.05n

.meas tran vdout1_22ck1390 FIND v(dout1_22) AT=1400.05n

.meas tran vdout1_23ck1390 FIND v(dout1_23) AT=1400.05n

.meas tran vdout1_24ck1390 FIND v(dout1_24) AT=1400.05n

.meas tran vdout1_25ck1390 FIND v(dout1_25) AT=1400.05n

.meas tran vdout1_26ck1390 FIND v(dout1_26) AT=1400.05n

.meas tran vdout1_27ck1390 FIND v(dout1_27) AT=1400.05n

.meas tran vdout1_28ck1390 FIND v(dout1_28) AT=1400.05n

.meas tran vdout1_29ck1390 FIND v(dout1_29) AT=1400.05n

.meas tran vdout1_30ck1390 FIND v(dout1_30) AT=1400.05n

.meas tran vdout1_31ck1390 FIND v(dout1_31) AT=1400.05n

.meas tran vdout1_32ck1390 FIND v(dout1_32) AT=1400.05n

.meas tran vdout1_0ck1420 FIND v(dout1_0) AT=1430.05n

.meas tran vdout1_1ck1420 FIND v(dout1_1) AT=1430.05n

.meas tran vdout1_2ck1420 FIND v(dout1_2) AT=1430.05n

.meas tran vdout1_3ck1420 FIND v(dout1_3) AT=1430.05n

.meas tran vdout1_4ck1420 FIND v(dout1_4) AT=1430.05n

.meas tran vdout1_5ck1420 FIND v(dout1_5) AT=1430.05n

.meas tran vdout1_6ck1420 FIND v(dout1_6) AT=1430.05n

.meas tran vdout1_7ck1420 FIND v(dout1_7) AT=1430.05n

.meas tran vdout1_8ck1420 FIND v(dout1_8) AT=1430.05n

.meas tran vdout1_9ck1420 FIND v(dout1_9) AT=1430.05n

.meas tran vdout1_10ck1420 FIND v(dout1_10) AT=1430.05n

.meas tran vdout1_11ck1420 FIND v(dout1_11) AT=1430.05n

.meas tran vdout1_12ck1420 FIND v(dout1_12) AT=1430.05n

.meas tran vdout1_13ck1420 FIND v(dout1_13) AT=1430.05n

.meas tran vdout1_14ck1420 FIND v(dout1_14) AT=1430.05n

.meas tran vdout1_15ck1420 FIND v(dout1_15) AT=1430.05n

.meas tran vdout1_16ck1420 FIND v(dout1_16) AT=1430.05n

.meas tran vdout1_17ck1420 FIND v(dout1_17) AT=1430.05n

.meas tran vdout1_18ck1420 FIND v(dout1_18) AT=1430.05n

.meas tran vdout1_19ck1420 FIND v(dout1_19) AT=1430.05n

.meas tran vdout1_20ck1420 FIND v(dout1_20) AT=1430.05n

.meas tran vdout1_21ck1420 FIND v(dout1_21) AT=1430.05n

.meas tran vdout1_22ck1420 FIND v(dout1_22) AT=1430.05n

.meas tran vdout1_23ck1420 FIND v(dout1_23) AT=1430.05n

.meas tran vdout1_24ck1420 FIND v(dout1_24) AT=1430.05n

.meas tran vdout1_25ck1420 FIND v(dout1_25) AT=1430.05n

.meas tran vdout1_26ck1420 FIND v(dout1_26) AT=1430.05n

.meas tran vdout1_27ck1420 FIND v(dout1_27) AT=1430.05n

.meas tran vdout1_28ck1420 FIND v(dout1_28) AT=1430.05n

.meas tran vdout1_29ck1420 FIND v(dout1_29) AT=1430.05n

.meas tran vdout1_30ck1420 FIND v(dout1_30) AT=1430.05n

.meas tran vdout1_31ck1420 FIND v(dout1_31) AT=1430.05n

.meas tran vdout1_32ck1420 FIND v(dout1_32) AT=1430.05n

.meas tran vdout1_0ck1450 FIND v(dout1_0) AT=1460.05n

.meas tran vdout1_1ck1450 FIND v(dout1_1) AT=1460.05n

.meas tran vdout1_2ck1450 FIND v(dout1_2) AT=1460.05n

.meas tran vdout1_3ck1450 FIND v(dout1_3) AT=1460.05n

.meas tran vdout1_4ck1450 FIND v(dout1_4) AT=1460.05n

.meas tran vdout1_5ck1450 FIND v(dout1_5) AT=1460.05n

.meas tran vdout1_6ck1450 FIND v(dout1_6) AT=1460.05n

.meas tran vdout1_7ck1450 FIND v(dout1_7) AT=1460.05n

.meas tran vdout1_8ck1450 FIND v(dout1_8) AT=1460.05n

.meas tran vdout1_9ck1450 FIND v(dout1_9) AT=1460.05n

.meas tran vdout1_10ck1450 FIND v(dout1_10) AT=1460.05n

.meas tran vdout1_11ck1450 FIND v(dout1_11) AT=1460.05n

.meas tran vdout1_12ck1450 FIND v(dout1_12) AT=1460.05n

.meas tran vdout1_13ck1450 FIND v(dout1_13) AT=1460.05n

.meas tran vdout1_14ck1450 FIND v(dout1_14) AT=1460.05n

.meas tran vdout1_15ck1450 FIND v(dout1_15) AT=1460.05n

.meas tran vdout1_16ck1450 FIND v(dout1_16) AT=1460.05n

.meas tran vdout1_17ck1450 FIND v(dout1_17) AT=1460.05n

.meas tran vdout1_18ck1450 FIND v(dout1_18) AT=1460.05n

.meas tran vdout1_19ck1450 FIND v(dout1_19) AT=1460.05n

.meas tran vdout1_20ck1450 FIND v(dout1_20) AT=1460.05n

.meas tran vdout1_21ck1450 FIND v(dout1_21) AT=1460.05n

.meas tran vdout1_22ck1450 FIND v(dout1_22) AT=1460.05n

.meas tran vdout1_23ck1450 FIND v(dout1_23) AT=1460.05n

.meas tran vdout1_24ck1450 FIND v(dout1_24) AT=1460.05n

.meas tran vdout1_25ck1450 FIND v(dout1_25) AT=1460.05n

.meas tran vdout1_26ck1450 FIND v(dout1_26) AT=1460.05n

.meas tran vdout1_27ck1450 FIND v(dout1_27) AT=1460.05n

.meas tran vdout1_28ck1450 FIND v(dout1_28) AT=1460.05n

.meas tran vdout1_29ck1450 FIND v(dout1_29) AT=1460.05n

.meas tran vdout1_30ck1450 FIND v(dout1_30) AT=1460.05n

.meas tran vdout1_31ck1450 FIND v(dout1_31) AT=1460.05n

.meas tran vdout1_32ck1450 FIND v(dout1_32) AT=1460.05n

.meas tran vdout1_0ck1460 FIND v(dout1_0) AT=1470.05n

.meas tran vdout1_1ck1460 FIND v(dout1_1) AT=1470.05n

.meas tran vdout1_2ck1460 FIND v(dout1_2) AT=1470.05n

.meas tran vdout1_3ck1460 FIND v(dout1_3) AT=1470.05n

.meas tran vdout1_4ck1460 FIND v(dout1_4) AT=1470.05n

.meas tran vdout1_5ck1460 FIND v(dout1_5) AT=1470.05n

.meas tran vdout1_6ck1460 FIND v(dout1_6) AT=1470.05n

.meas tran vdout1_7ck1460 FIND v(dout1_7) AT=1470.05n

.meas tran vdout1_8ck1460 FIND v(dout1_8) AT=1470.05n

.meas tran vdout1_9ck1460 FIND v(dout1_9) AT=1470.05n

.meas tran vdout1_10ck1460 FIND v(dout1_10) AT=1470.05n

.meas tran vdout1_11ck1460 FIND v(dout1_11) AT=1470.05n

.meas tran vdout1_12ck1460 FIND v(dout1_12) AT=1470.05n

.meas tran vdout1_13ck1460 FIND v(dout1_13) AT=1470.05n

.meas tran vdout1_14ck1460 FIND v(dout1_14) AT=1470.05n

.meas tran vdout1_15ck1460 FIND v(dout1_15) AT=1470.05n

.meas tran vdout1_16ck1460 FIND v(dout1_16) AT=1470.05n

.meas tran vdout1_17ck1460 FIND v(dout1_17) AT=1470.05n

.meas tran vdout1_18ck1460 FIND v(dout1_18) AT=1470.05n

.meas tran vdout1_19ck1460 FIND v(dout1_19) AT=1470.05n

.meas tran vdout1_20ck1460 FIND v(dout1_20) AT=1470.05n

.meas tran vdout1_21ck1460 FIND v(dout1_21) AT=1470.05n

.meas tran vdout1_22ck1460 FIND v(dout1_22) AT=1470.05n

.meas tran vdout1_23ck1460 FIND v(dout1_23) AT=1470.05n

.meas tran vdout1_24ck1460 FIND v(dout1_24) AT=1470.05n

.meas tran vdout1_25ck1460 FIND v(dout1_25) AT=1470.05n

.meas tran vdout1_26ck1460 FIND v(dout1_26) AT=1470.05n

.meas tran vdout1_27ck1460 FIND v(dout1_27) AT=1470.05n

.meas tran vdout1_28ck1460 FIND v(dout1_28) AT=1470.05n

.meas tran vdout1_29ck1460 FIND v(dout1_29) AT=1470.05n

.meas tran vdout1_30ck1460 FIND v(dout1_30) AT=1470.05n

.meas tran vdout1_31ck1460 FIND v(dout1_31) AT=1470.05n

.meas tran vdout1_32ck1460 FIND v(dout1_32) AT=1470.05n

.meas tran vdout1_0ck1490 FIND v(dout1_0) AT=1500.05n

.meas tran vdout1_1ck1490 FIND v(dout1_1) AT=1500.05n

.meas tran vdout1_2ck1490 FIND v(dout1_2) AT=1500.05n

.meas tran vdout1_3ck1490 FIND v(dout1_3) AT=1500.05n

.meas tran vdout1_4ck1490 FIND v(dout1_4) AT=1500.05n

.meas tran vdout1_5ck1490 FIND v(dout1_5) AT=1500.05n

.meas tran vdout1_6ck1490 FIND v(dout1_6) AT=1500.05n

.meas tran vdout1_7ck1490 FIND v(dout1_7) AT=1500.05n

.meas tran vdout1_8ck1490 FIND v(dout1_8) AT=1500.05n

.meas tran vdout1_9ck1490 FIND v(dout1_9) AT=1500.05n

.meas tran vdout1_10ck1490 FIND v(dout1_10) AT=1500.05n

.meas tran vdout1_11ck1490 FIND v(dout1_11) AT=1500.05n

.meas tran vdout1_12ck1490 FIND v(dout1_12) AT=1500.05n

.meas tran vdout1_13ck1490 FIND v(dout1_13) AT=1500.05n

.meas tran vdout1_14ck1490 FIND v(dout1_14) AT=1500.05n

.meas tran vdout1_15ck1490 FIND v(dout1_15) AT=1500.05n

.meas tran vdout1_16ck1490 FIND v(dout1_16) AT=1500.05n

.meas tran vdout1_17ck1490 FIND v(dout1_17) AT=1500.05n

.meas tran vdout1_18ck1490 FIND v(dout1_18) AT=1500.05n

.meas tran vdout1_19ck1490 FIND v(dout1_19) AT=1500.05n

.meas tran vdout1_20ck1490 FIND v(dout1_20) AT=1500.05n

.meas tran vdout1_21ck1490 FIND v(dout1_21) AT=1500.05n

.meas tran vdout1_22ck1490 FIND v(dout1_22) AT=1500.05n

.meas tran vdout1_23ck1490 FIND v(dout1_23) AT=1500.05n

.meas tran vdout1_24ck1490 FIND v(dout1_24) AT=1500.05n

.meas tran vdout1_25ck1490 FIND v(dout1_25) AT=1500.05n

.meas tran vdout1_26ck1490 FIND v(dout1_26) AT=1500.05n

.meas tran vdout1_27ck1490 FIND v(dout1_27) AT=1500.05n

.meas tran vdout1_28ck1490 FIND v(dout1_28) AT=1500.05n

.meas tran vdout1_29ck1490 FIND v(dout1_29) AT=1500.05n

.meas tran vdout1_30ck1490 FIND v(dout1_30) AT=1500.05n

.meas tran vdout1_31ck1490 FIND v(dout1_31) AT=1500.05n

.meas tran vdout1_32ck1490 FIND v(dout1_32) AT=1500.05n

.meas tran vdout1_0ck1520 FIND v(dout1_0) AT=1530.05n

.meas tran vdout1_1ck1520 FIND v(dout1_1) AT=1530.05n

.meas tran vdout1_2ck1520 FIND v(dout1_2) AT=1530.05n

.meas tran vdout1_3ck1520 FIND v(dout1_3) AT=1530.05n

.meas tran vdout1_4ck1520 FIND v(dout1_4) AT=1530.05n

.meas tran vdout1_5ck1520 FIND v(dout1_5) AT=1530.05n

.meas tran vdout1_6ck1520 FIND v(dout1_6) AT=1530.05n

.meas tran vdout1_7ck1520 FIND v(dout1_7) AT=1530.05n

.meas tran vdout1_8ck1520 FIND v(dout1_8) AT=1530.05n

.meas tran vdout1_9ck1520 FIND v(dout1_9) AT=1530.05n

.meas tran vdout1_10ck1520 FIND v(dout1_10) AT=1530.05n

.meas tran vdout1_11ck1520 FIND v(dout1_11) AT=1530.05n

.meas tran vdout1_12ck1520 FIND v(dout1_12) AT=1530.05n

.meas tran vdout1_13ck1520 FIND v(dout1_13) AT=1530.05n

.meas tran vdout1_14ck1520 FIND v(dout1_14) AT=1530.05n

.meas tran vdout1_15ck1520 FIND v(dout1_15) AT=1530.05n

.meas tran vdout1_16ck1520 FIND v(dout1_16) AT=1530.05n

.meas tran vdout1_17ck1520 FIND v(dout1_17) AT=1530.05n

.meas tran vdout1_18ck1520 FIND v(dout1_18) AT=1530.05n

.meas tran vdout1_19ck1520 FIND v(dout1_19) AT=1530.05n

.meas tran vdout1_20ck1520 FIND v(dout1_20) AT=1530.05n

.meas tran vdout1_21ck1520 FIND v(dout1_21) AT=1530.05n

.meas tran vdout1_22ck1520 FIND v(dout1_22) AT=1530.05n

.meas tran vdout1_23ck1520 FIND v(dout1_23) AT=1530.05n

.meas tran vdout1_24ck1520 FIND v(dout1_24) AT=1530.05n

.meas tran vdout1_25ck1520 FIND v(dout1_25) AT=1530.05n

.meas tran vdout1_26ck1520 FIND v(dout1_26) AT=1530.05n

.meas tran vdout1_27ck1520 FIND v(dout1_27) AT=1530.05n

.meas tran vdout1_28ck1520 FIND v(dout1_28) AT=1530.05n

.meas tran vdout1_29ck1520 FIND v(dout1_29) AT=1530.05n

.meas tran vdout1_30ck1520 FIND v(dout1_30) AT=1530.05n

.meas tran vdout1_31ck1520 FIND v(dout1_31) AT=1530.05n

.meas tran vdout1_32ck1520 FIND v(dout1_32) AT=1530.05n

.meas tran vdout1_0ck1550 FIND v(dout1_0) AT=1560.05n

.meas tran vdout1_1ck1550 FIND v(dout1_1) AT=1560.05n

.meas tran vdout1_2ck1550 FIND v(dout1_2) AT=1560.05n

.meas tran vdout1_3ck1550 FIND v(dout1_3) AT=1560.05n

.meas tran vdout1_4ck1550 FIND v(dout1_4) AT=1560.05n

.meas tran vdout1_5ck1550 FIND v(dout1_5) AT=1560.05n

.meas tran vdout1_6ck1550 FIND v(dout1_6) AT=1560.05n

.meas tran vdout1_7ck1550 FIND v(dout1_7) AT=1560.05n

.meas tran vdout1_8ck1550 FIND v(dout1_8) AT=1560.05n

.meas tran vdout1_9ck1550 FIND v(dout1_9) AT=1560.05n

.meas tran vdout1_10ck1550 FIND v(dout1_10) AT=1560.05n

.meas tran vdout1_11ck1550 FIND v(dout1_11) AT=1560.05n

.meas tran vdout1_12ck1550 FIND v(dout1_12) AT=1560.05n

.meas tran vdout1_13ck1550 FIND v(dout1_13) AT=1560.05n

.meas tran vdout1_14ck1550 FIND v(dout1_14) AT=1560.05n

.meas tran vdout1_15ck1550 FIND v(dout1_15) AT=1560.05n

.meas tran vdout1_16ck1550 FIND v(dout1_16) AT=1560.05n

.meas tran vdout1_17ck1550 FIND v(dout1_17) AT=1560.05n

.meas tran vdout1_18ck1550 FIND v(dout1_18) AT=1560.05n

.meas tran vdout1_19ck1550 FIND v(dout1_19) AT=1560.05n

.meas tran vdout1_20ck1550 FIND v(dout1_20) AT=1560.05n

.meas tran vdout1_21ck1550 FIND v(dout1_21) AT=1560.05n

.meas tran vdout1_22ck1550 FIND v(dout1_22) AT=1560.05n

.meas tran vdout1_23ck1550 FIND v(dout1_23) AT=1560.05n

.meas tran vdout1_24ck1550 FIND v(dout1_24) AT=1560.05n

.meas tran vdout1_25ck1550 FIND v(dout1_25) AT=1560.05n

.meas tran vdout1_26ck1550 FIND v(dout1_26) AT=1560.05n

.meas tran vdout1_27ck1550 FIND v(dout1_27) AT=1560.05n

.meas tran vdout1_28ck1550 FIND v(dout1_28) AT=1560.05n

.meas tran vdout1_29ck1550 FIND v(dout1_29) AT=1560.05n

.meas tran vdout1_30ck1550 FIND v(dout1_30) AT=1560.05n

.meas tran vdout1_31ck1550 FIND v(dout1_31) AT=1560.05n

.meas tran vdout1_32ck1550 FIND v(dout1_32) AT=1560.05n

.meas tran vdout1_0ck1570 FIND v(dout1_0) AT=1580.05n

.meas tran vdout1_1ck1570 FIND v(dout1_1) AT=1580.05n

.meas tran vdout1_2ck1570 FIND v(dout1_2) AT=1580.05n

.meas tran vdout1_3ck1570 FIND v(dout1_3) AT=1580.05n

.meas tran vdout1_4ck1570 FIND v(dout1_4) AT=1580.05n

.meas tran vdout1_5ck1570 FIND v(dout1_5) AT=1580.05n

.meas tran vdout1_6ck1570 FIND v(dout1_6) AT=1580.05n

.meas tran vdout1_7ck1570 FIND v(dout1_7) AT=1580.05n

.meas tran vdout1_8ck1570 FIND v(dout1_8) AT=1580.05n

.meas tran vdout1_9ck1570 FIND v(dout1_9) AT=1580.05n

.meas tran vdout1_10ck1570 FIND v(dout1_10) AT=1580.05n

.meas tran vdout1_11ck1570 FIND v(dout1_11) AT=1580.05n

.meas tran vdout1_12ck1570 FIND v(dout1_12) AT=1580.05n

.meas tran vdout1_13ck1570 FIND v(dout1_13) AT=1580.05n

.meas tran vdout1_14ck1570 FIND v(dout1_14) AT=1580.05n

.meas tran vdout1_15ck1570 FIND v(dout1_15) AT=1580.05n

.meas tran vdout1_16ck1570 FIND v(dout1_16) AT=1580.05n

.meas tran vdout1_17ck1570 FIND v(dout1_17) AT=1580.05n

.meas tran vdout1_18ck1570 FIND v(dout1_18) AT=1580.05n

.meas tran vdout1_19ck1570 FIND v(dout1_19) AT=1580.05n

.meas tran vdout1_20ck1570 FIND v(dout1_20) AT=1580.05n

.meas tran vdout1_21ck1570 FIND v(dout1_21) AT=1580.05n

.meas tran vdout1_22ck1570 FIND v(dout1_22) AT=1580.05n

.meas tran vdout1_23ck1570 FIND v(dout1_23) AT=1580.05n

.meas tran vdout1_24ck1570 FIND v(dout1_24) AT=1580.05n

.meas tran vdout1_25ck1570 FIND v(dout1_25) AT=1580.05n

.meas tran vdout1_26ck1570 FIND v(dout1_26) AT=1580.05n

.meas tran vdout1_27ck1570 FIND v(dout1_27) AT=1580.05n

.meas tran vdout1_28ck1570 FIND v(dout1_28) AT=1580.05n

.meas tran vdout1_29ck1570 FIND v(dout1_29) AT=1580.05n

.meas tran vdout1_30ck1570 FIND v(dout1_30) AT=1580.05n

.meas tran vdout1_31ck1570 FIND v(dout1_31) AT=1580.05n

.meas tran vdout1_32ck1570 FIND v(dout1_32) AT=1580.05n

.meas tran vdout1_0ck1590 FIND v(dout1_0) AT=1600.05n

.meas tran vdout1_1ck1590 FIND v(dout1_1) AT=1600.05n

.meas tran vdout1_2ck1590 FIND v(dout1_2) AT=1600.05n

.meas tran vdout1_3ck1590 FIND v(dout1_3) AT=1600.05n

.meas tran vdout1_4ck1590 FIND v(dout1_4) AT=1600.05n

.meas tran vdout1_5ck1590 FIND v(dout1_5) AT=1600.05n

.meas tran vdout1_6ck1590 FIND v(dout1_6) AT=1600.05n

.meas tran vdout1_7ck1590 FIND v(dout1_7) AT=1600.05n

.meas tran vdout1_8ck1590 FIND v(dout1_8) AT=1600.05n

.meas tran vdout1_9ck1590 FIND v(dout1_9) AT=1600.05n

.meas tran vdout1_10ck1590 FIND v(dout1_10) AT=1600.05n

.meas tran vdout1_11ck1590 FIND v(dout1_11) AT=1600.05n

.meas tran vdout1_12ck1590 FIND v(dout1_12) AT=1600.05n

.meas tran vdout1_13ck1590 FIND v(dout1_13) AT=1600.05n

.meas tran vdout1_14ck1590 FIND v(dout1_14) AT=1600.05n

.meas tran vdout1_15ck1590 FIND v(dout1_15) AT=1600.05n

.meas tran vdout1_16ck1590 FIND v(dout1_16) AT=1600.05n

.meas tran vdout1_17ck1590 FIND v(dout1_17) AT=1600.05n

.meas tran vdout1_18ck1590 FIND v(dout1_18) AT=1600.05n

.meas tran vdout1_19ck1590 FIND v(dout1_19) AT=1600.05n

.meas tran vdout1_20ck1590 FIND v(dout1_20) AT=1600.05n

.meas tran vdout1_21ck1590 FIND v(dout1_21) AT=1600.05n

.meas tran vdout1_22ck1590 FIND v(dout1_22) AT=1600.05n

.meas tran vdout1_23ck1590 FIND v(dout1_23) AT=1600.05n

.meas tran vdout1_24ck1590 FIND v(dout1_24) AT=1600.05n

.meas tran vdout1_25ck1590 FIND v(dout1_25) AT=1600.05n

.meas tran vdout1_26ck1590 FIND v(dout1_26) AT=1600.05n

.meas tran vdout1_27ck1590 FIND v(dout1_27) AT=1600.05n

.meas tran vdout1_28ck1590 FIND v(dout1_28) AT=1600.05n

.meas tran vdout1_29ck1590 FIND v(dout1_29) AT=1600.05n

.meas tran vdout1_30ck1590 FIND v(dout1_30) AT=1600.05n

.meas tran vdout1_31ck1590 FIND v(dout1_31) AT=1600.05n

.meas tran vdout1_32ck1590 FIND v(dout1_32) AT=1600.05n

.meas tran vdout1_0ck1600 FIND v(dout1_0) AT=1610.05n

.meas tran vdout1_1ck1600 FIND v(dout1_1) AT=1610.05n

.meas tran vdout1_2ck1600 FIND v(dout1_2) AT=1610.05n

.meas tran vdout1_3ck1600 FIND v(dout1_3) AT=1610.05n

.meas tran vdout1_4ck1600 FIND v(dout1_4) AT=1610.05n

.meas tran vdout1_5ck1600 FIND v(dout1_5) AT=1610.05n

.meas tran vdout1_6ck1600 FIND v(dout1_6) AT=1610.05n

.meas tran vdout1_7ck1600 FIND v(dout1_7) AT=1610.05n

.meas tran vdout1_8ck1600 FIND v(dout1_8) AT=1610.05n

.meas tran vdout1_9ck1600 FIND v(dout1_9) AT=1610.05n

.meas tran vdout1_10ck1600 FIND v(dout1_10) AT=1610.05n

.meas tran vdout1_11ck1600 FIND v(dout1_11) AT=1610.05n

.meas tran vdout1_12ck1600 FIND v(dout1_12) AT=1610.05n

.meas tran vdout1_13ck1600 FIND v(dout1_13) AT=1610.05n

.meas tran vdout1_14ck1600 FIND v(dout1_14) AT=1610.05n

.meas tran vdout1_15ck1600 FIND v(dout1_15) AT=1610.05n

.meas tran vdout1_16ck1600 FIND v(dout1_16) AT=1610.05n

.meas tran vdout1_17ck1600 FIND v(dout1_17) AT=1610.05n

.meas tran vdout1_18ck1600 FIND v(dout1_18) AT=1610.05n

.meas tran vdout1_19ck1600 FIND v(dout1_19) AT=1610.05n

.meas tran vdout1_20ck1600 FIND v(dout1_20) AT=1610.05n

.meas tran vdout1_21ck1600 FIND v(dout1_21) AT=1610.05n

.meas tran vdout1_22ck1600 FIND v(dout1_22) AT=1610.05n

.meas tran vdout1_23ck1600 FIND v(dout1_23) AT=1610.05n

.meas tran vdout1_24ck1600 FIND v(dout1_24) AT=1610.05n

.meas tran vdout1_25ck1600 FIND v(dout1_25) AT=1610.05n

.meas tran vdout1_26ck1600 FIND v(dout1_26) AT=1610.05n

.meas tran vdout1_27ck1600 FIND v(dout1_27) AT=1610.05n

.meas tran vdout1_28ck1600 FIND v(dout1_28) AT=1610.05n

.meas tran vdout1_29ck1600 FIND v(dout1_29) AT=1610.05n

.meas tran vdout1_30ck1600 FIND v(dout1_30) AT=1610.05n

.meas tran vdout1_31ck1600 FIND v(dout1_31) AT=1610.05n

.meas tran vdout1_32ck1600 FIND v(dout1_32) AT=1610.05n

.meas tran vdout1_0ck1610 FIND v(dout1_0) AT=1620.05n

.meas tran vdout1_1ck1610 FIND v(dout1_1) AT=1620.05n

.meas tran vdout1_2ck1610 FIND v(dout1_2) AT=1620.05n

.meas tran vdout1_3ck1610 FIND v(dout1_3) AT=1620.05n

.meas tran vdout1_4ck1610 FIND v(dout1_4) AT=1620.05n

.meas tran vdout1_5ck1610 FIND v(dout1_5) AT=1620.05n

.meas tran vdout1_6ck1610 FIND v(dout1_6) AT=1620.05n

.meas tran vdout1_7ck1610 FIND v(dout1_7) AT=1620.05n

.meas tran vdout1_8ck1610 FIND v(dout1_8) AT=1620.05n

.meas tran vdout1_9ck1610 FIND v(dout1_9) AT=1620.05n

.meas tran vdout1_10ck1610 FIND v(dout1_10) AT=1620.05n

.meas tran vdout1_11ck1610 FIND v(dout1_11) AT=1620.05n

.meas tran vdout1_12ck1610 FIND v(dout1_12) AT=1620.05n

.meas tran vdout1_13ck1610 FIND v(dout1_13) AT=1620.05n

.meas tran vdout1_14ck1610 FIND v(dout1_14) AT=1620.05n

.meas tran vdout1_15ck1610 FIND v(dout1_15) AT=1620.05n

.meas tran vdout1_16ck1610 FIND v(dout1_16) AT=1620.05n

.meas tran vdout1_17ck1610 FIND v(dout1_17) AT=1620.05n

.meas tran vdout1_18ck1610 FIND v(dout1_18) AT=1620.05n

.meas tran vdout1_19ck1610 FIND v(dout1_19) AT=1620.05n

.meas tran vdout1_20ck1610 FIND v(dout1_20) AT=1620.05n

.meas tran vdout1_21ck1610 FIND v(dout1_21) AT=1620.05n

.meas tran vdout1_22ck1610 FIND v(dout1_22) AT=1620.05n

.meas tran vdout1_23ck1610 FIND v(dout1_23) AT=1620.05n

.meas tran vdout1_24ck1610 FIND v(dout1_24) AT=1620.05n

.meas tran vdout1_25ck1610 FIND v(dout1_25) AT=1620.05n

.meas tran vdout1_26ck1610 FIND v(dout1_26) AT=1620.05n

.meas tran vdout1_27ck1610 FIND v(dout1_27) AT=1620.05n

.meas tran vdout1_28ck1610 FIND v(dout1_28) AT=1620.05n

.meas tran vdout1_29ck1610 FIND v(dout1_29) AT=1620.05n

.meas tran vdout1_30ck1610 FIND v(dout1_30) AT=1620.05n

.meas tran vdout1_31ck1610 FIND v(dout1_31) AT=1620.05n

.meas tran vdout1_32ck1610 FIND v(dout1_32) AT=1620.05n

.meas tran vdout1_0ck1630 FIND v(dout1_0) AT=1640.05n

.meas tran vdout1_1ck1630 FIND v(dout1_1) AT=1640.05n

.meas tran vdout1_2ck1630 FIND v(dout1_2) AT=1640.05n

.meas tran vdout1_3ck1630 FIND v(dout1_3) AT=1640.05n

.meas tran vdout1_4ck1630 FIND v(dout1_4) AT=1640.05n

.meas tran vdout1_5ck1630 FIND v(dout1_5) AT=1640.05n

.meas tran vdout1_6ck1630 FIND v(dout1_6) AT=1640.05n

.meas tran vdout1_7ck1630 FIND v(dout1_7) AT=1640.05n

.meas tran vdout1_8ck1630 FIND v(dout1_8) AT=1640.05n

.meas tran vdout1_9ck1630 FIND v(dout1_9) AT=1640.05n

.meas tran vdout1_10ck1630 FIND v(dout1_10) AT=1640.05n

.meas tran vdout1_11ck1630 FIND v(dout1_11) AT=1640.05n

.meas tran vdout1_12ck1630 FIND v(dout1_12) AT=1640.05n

.meas tran vdout1_13ck1630 FIND v(dout1_13) AT=1640.05n

.meas tran vdout1_14ck1630 FIND v(dout1_14) AT=1640.05n

.meas tran vdout1_15ck1630 FIND v(dout1_15) AT=1640.05n

.meas tran vdout1_16ck1630 FIND v(dout1_16) AT=1640.05n

.meas tran vdout1_17ck1630 FIND v(dout1_17) AT=1640.05n

.meas tran vdout1_18ck1630 FIND v(dout1_18) AT=1640.05n

.meas tran vdout1_19ck1630 FIND v(dout1_19) AT=1640.05n

.meas tran vdout1_20ck1630 FIND v(dout1_20) AT=1640.05n

.meas tran vdout1_21ck1630 FIND v(dout1_21) AT=1640.05n

.meas tran vdout1_22ck1630 FIND v(dout1_22) AT=1640.05n

.meas tran vdout1_23ck1630 FIND v(dout1_23) AT=1640.05n

.meas tran vdout1_24ck1630 FIND v(dout1_24) AT=1640.05n

.meas tran vdout1_25ck1630 FIND v(dout1_25) AT=1640.05n

.meas tran vdout1_26ck1630 FIND v(dout1_26) AT=1640.05n

.meas tran vdout1_27ck1630 FIND v(dout1_27) AT=1640.05n

.meas tran vdout1_28ck1630 FIND v(dout1_28) AT=1640.05n

.meas tran vdout1_29ck1630 FIND v(dout1_29) AT=1640.05n

.meas tran vdout1_30ck1630 FIND v(dout1_30) AT=1640.05n

.meas tran vdout1_31ck1630 FIND v(dout1_31) AT=1640.05n

.meas tran vdout1_32ck1630 FIND v(dout1_32) AT=1640.05n

.meas tran vdout1_0ck1640 FIND v(dout1_0) AT=1650.05n

.meas tran vdout1_1ck1640 FIND v(dout1_1) AT=1650.05n

.meas tran vdout1_2ck1640 FIND v(dout1_2) AT=1650.05n

.meas tran vdout1_3ck1640 FIND v(dout1_3) AT=1650.05n

.meas tran vdout1_4ck1640 FIND v(dout1_4) AT=1650.05n

.meas tran vdout1_5ck1640 FIND v(dout1_5) AT=1650.05n

.meas tran vdout1_6ck1640 FIND v(dout1_6) AT=1650.05n

.meas tran vdout1_7ck1640 FIND v(dout1_7) AT=1650.05n

.meas tran vdout1_8ck1640 FIND v(dout1_8) AT=1650.05n

.meas tran vdout1_9ck1640 FIND v(dout1_9) AT=1650.05n

.meas tran vdout1_10ck1640 FIND v(dout1_10) AT=1650.05n

.meas tran vdout1_11ck1640 FIND v(dout1_11) AT=1650.05n

.meas tran vdout1_12ck1640 FIND v(dout1_12) AT=1650.05n

.meas tran vdout1_13ck1640 FIND v(dout1_13) AT=1650.05n

.meas tran vdout1_14ck1640 FIND v(dout1_14) AT=1650.05n

.meas tran vdout1_15ck1640 FIND v(dout1_15) AT=1650.05n

.meas tran vdout1_16ck1640 FIND v(dout1_16) AT=1650.05n

.meas tran vdout1_17ck1640 FIND v(dout1_17) AT=1650.05n

.meas tran vdout1_18ck1640 FIND v(dout1_18) AT=1650.05n

.meas tran vdout1_19ck1640 FIND v(dout1_19) AT=1650.05n

.meas tran vdout1_20ck1640 FIND v(dout1_20) AT=1650.05n

.meas tran vdout1_21ck1640 FIND v(dout1_21) AT=1650.05n

.meas tran vdout1_22ck1640 FIND v(dout1_22) AT=1650.05n

.meas tran vdout1_23ck1640 FIND v(dout1_23) AT=1650.05n

.meas tran vdout1_24ck1640 FIND v(dout1_24) AT=1650.05n

.meas tran vdout1_25ck1640 FIND v(dout1_25) AT=1650.05n

.meas tran vdout1_26ck1640 FIND v(dout1_26) AT=1650.05n

.meas tran vdout1_27ck1640 FIND v(dout1_27) AT=1650.05n

.meas tran vdout1_28ck1640 FIND v(dout1_28) AT=1650.05n

.meas tran vdout1_29ck1640 FIND v(dout1_29) AT=1650.05n

.meas tran vdout1_30ck1640 FIND v(dout1_30) AT=1650.05n

.meas tran vdout1_31ck1640 FIND v(dout1_31) AT=1650.05n

.meas tran vdout1_32ck1640 FIND v(dout1_32) AT=1650.05n

.meas tran vdout1_0ck1650 FIND v(dout1_0) AT=1660.05n

.meas tran vdout1_1ck1650 FIND v(dout1_1) AT=1660.05n

.meas tran vdout1_2ck1650 FIND v(dout1_2) AT=1660.05n

.meas tran vdout1_3ck1650 FIND v(dout1_3) AT=1660.05n

.meas tran vdout1_4ck1650 FIND v(dout1_4) AT=1660.05n

.meas tran vdout1_5ck1650 FIND v(dout1_5) AT=1660.05n

.meas tran vdout1_6ck1650 FIND v(dout1_6) AT=1660.05n

.meas tran vdout1_7ck1650 FIND v(dout1_7) AT=1660.05n

.meas tran vdout1_8ck1650 FIND v(dout1_8) AT=1660.05n

.meas tran vdout1_9ck1650 FIND v(dout1_9) AT=1660.05n

.meas tran vdout1_10ck1650 FIND v(dout1_10) AT=1660.05n

.meas tran vdout1_11ck1650 FIND v(dout1_11) AT=1660.05n

.meas tran vdout1_12ck1650 FIND v(dout1_12) AT=1660.05n

.meas tran vdout1_13ck1650 FIND v(dout1_13) AT=1660.05n

.meas tran vdout1_14ck1650 FIND v(dout1_14) AT=1660.05n

.meas tran vdout1_15ck1650 FIND v(dout1_15) AT=1660.05n

.meas tran vdout1_16ck1650 FIND v(dout1_16) AT=1660.05n

.meas tran vdout1_17ck1650 FIND v(dout1_17) AT=1660.05n

.meas tran vdout1_18ck1650 FIND v(dout1_18) AT=1660.05n

.meas tran vdout1_19ck1650 FIND v(dout1_19) AT=1660.05n

.meas tran vdout1_20ck1650 FIND v(dout1_20) AT=1660.05n

.meas tran vdout1_21ck1650 FIND v(dout1_21) AT=1660.05n

.meas tran vdout1_22ck1650 FIND v(dout1_22) AT=1660.05n

.meas tran vdout1_23ck1650 FIND v(dout1_23) AT=1660.05n

.meas tran vdout1_24ck1650 FIND v(dout1_24) AT=1660.05n

.meas tran vdout1_25ck1650 FIND v(dout1_25) AT=1660.05n

.meas tran vdout1_26ck1650 FIND v(dout1_26) AT=1660.05n

.meas tran vdout1_27ck1650 FIND v(dout1_27) AT=1660.05n

.meas tran vdout1_28ck1650 FIND v(dout1_28) AT=1660.05n

.meas tran vdout1_29ck1650 FIND v(dout1_29) AT=1660.05n

.meas tran vdout1_30ck1650 FIND v(dout1_30) AT=1660.05n

.meas tran vdout1_31ck1650 FIND v(dout1_31) AT=1660.05n

.meas tran vdout1_32ck1650 FIND v(dout1_32) AT=1660.05n

.meas tran vdout1_0ck1660 FIND v(dout1_0) AT=1670.05n

.meas tran vdout1_1ck1660 FIND v(dout1_1) AT=1670.05n

.meas tran vdout1_2ck1660 FIND v(dout1_2) AT=1670.05n

.meas tran vdout1_3ck1660 FIND v(dout1_3) AT=1670.05n

.meas tran vdout1_4ck1660 FIND v(dout1_4) AT=1670.05n

.meas tran vdout1_5ck1660 FIND v(dout1_5) AT=1670.05n

.meas tran vdout1_6ck1660 FIND v(dout1_6) AT=1670.05n

.meas tran vdout1_7ck1660 FIND v(dout1_7) AT=1670.05n

.meas tran vdout1_8ck1660 FIND v(dout1_8) AT=1670.05n

.meas tran vdout1_9ck1660 FIND v(dout1_9) AT=1670.05n

.meas tran vdout1_10ck1660 FIND v(dout1_10) AT=1670.05n

.meas tran vdout1_11ck1660 FIND v(dout1_11) AT=1670.05n

.meas tran vdout1_12ck1660 FIND v(dout1_12) AT=1670.05n

.meas tran vdout1_13ck1660 FIND v(dout1_13) AT=1670.05n

.meas tran vdout1_14ck1660 FIND v(dout1_14) AT=1670.05n

.meas tran vdout1_15ck1660 FIND v(dout1_15) AT=1670.05n

.meas tran vdout1_16ck1660 FIND v(dout1_16) AT=1670.05n

.meas tran vdout1_17ck1660 FIND v(dout1_17) AT=1670.05n

.meas tran vdout1_18ck1660 FIND v(dout1_18) AT=1670.05n

.meas tran vdout1_19ck1660 FIND v(dout1_19) AT=1670.05n

.meas tran vdout1_20ck1660 FIND v(dout1_20) AT=1670.05n

.meas tran vdout1_21ck1660 FIND v(dout1_21) AT=1670.05n

.meas tran vdout1_22ck1660 FIND v(dout1_22) AT=1670.05n

.meas tran vdout1_23ck1660 FIND v(dout1_23) AT=1670.05n

.meas tran vdout1_24ck1660 FIND v(dout1_24) AT=1670.05n

.meas tran vdout1_25ck1660 FIND v(dout1_25) AT=1670.05n

.meas tran vdout1_26ck1660 FIND v(dout1_26) AT=1670.05n

.meas tran vdout1_27ck1660 FIND v(dout1_27) AT=1670.05n

.meas tran vdout1_28ck1660 FIND v(dout1_28) AT=1670.05n

.meas tran vdout1_29ck1660 FIND v(dout1_29) AT=1670.05n

.meas tran vdout1_30ck1660 FIND v(dout1_30) AT=1670.05n

.meas tran vdout1_31ck1660 FIND v(dout1_31) AT=1670.05n

.meas tran vdout1_32ck1660 FIND v(dout1_32) AT=1670.05n

.meas tran vdout1_0ck1670 FIND v(dout1_0) AT=1680.05n

.meas tran vdout1_1ck1670 FIND v(dout1_1) AT=1680.05n

.meas tran vdout1_2ck1670 FIND v(dout1_2) AT=1680.05n

.meas tran vdout1_3ck1670 FIND v(dout1_3) AT=1680.05n

.meas tran vdout1_4ck1670 FIND v(dout1_4) AT=1680.05n

.meas tran vdout1_5ck1670 FIND v(dout1_5) AT=1680.05n

.meas tran vdout1_6ck1670 FIND v(dout1_6) AT=1680.05n

.meas tran vdout1_7ck1670 FIND v(dout1_7) AT=1680.05n

.meas tran vdout1_8ck1670 FIND v(dout1_8) AT=1680.05n

.meas tran vdout1_9ck1670 FIND v(dout1_9) AT=1680.05n

.meas tran vdout1_10ck1670 FIND v(dout1_10) AT=1680.05n

.meas tran vdout1_11ck1670 FIND v(dout1_11) AT=1680.05n

.meas tran vdout1_12ck1670 FIND v(dout1_12) AT=1680.05n

.meas tran vdout1_13ck1670 FIND v(dout1_13) AT=1680.05n

.meas tran vdout1_14ck1670 FIND v(dout1_14) AT=1680.05n

.meas tran vdout1_15ck1670 FIND v(dout1_15) AT=1680.05n

.meas tran vdout1_16ck1670 FIND v(dout1_16) AT=1680.05n

.meas tran vdout1_17ck1670 FIND v(dout1_17) AT=1680.05n

.meas tran vdout1_18ck1670 FIND v(dout1_18) AT=1680.05n

.meas tran vdout1_19ck1670 FIND v(dout1_19) AT=1680.05n

.meas tran vdout1_20ck1670 FIND v(dout1_20) AT=1680.05n

.meas tran vdout1_21ck1670 FIND v(dout1_21) AT=1680.05n

.meas tran vdout1_22ck1670 FIND v(dout1_22) AT=1680.05n

.meas tran vdout1_23ck1670 FIND v(dout1_23) AT=1680.05n

.meas tran vdout1_24ck1670 FIND v(dout1_24) AT=1680.05n

.meas tran vdout1_25ck1670 FIND v(dout1_25) AT=1680.05n

.meas tran vdout1_26ck1670 FIND v(dout1_26) AT=1680.05n

.meas tran vdout1_27ck1670 FIND v(dout1_27) AT=1680.05n

.meas tran vdout1_28ck1670 FIND v(dout1_28) AT=1680.05n

.meas tran vdout1_29ck1670 FIND v(dout1_29) AT=1680.05n

.meas tran vdout1_30ck1670 FIND v(dout1_30) AT=1680.05n

.meas tran vdout1_31ck1670 FIND v(dout1_31) AT=1680.05n

.meas tran vdout1_32ck1670 FIND v(dout1_32) AT=1680.05n

.meas tran vdout1_0ck1680 FIND v(dout1_0) AT=1690.05n

.meas tran vdout1_1ck1680 FIND v(dout1_1) AT=1690.05n

.meas tran vdout1_2ck1680 FIND v(dout1_2) AT=1690.05n

.meas tran vdout1_3ck1680 FIND v(dout1_3) AT=1690.05n

.meas tran vdout1_4ck1680 FIND v(dout1_4) AT=1690.05n

.meas tran vdout1_5ck1680 FIND v(dout1_5) AT=1690.05n

.meas tran vdout1_6ck1680 FIND v(dout1_6) AT=1690.05n

.meas tran vdout1_7ck1680 FIND v(dout1_7) AT=1690.05n

.meas tran vdout1_8ck1680 FIND v(dout1_8) AT=1690.05n

.meas tran vdout1_9ck1680 FIND v(dout1_9) AT=1690.05n

.meas tran vdout1_10ck1680 FIND v(dout1_10) AT=1690.05n

.meas tran vdout1_11ck1680 FIND v(dout1_11) AT=1690.05n

.meas tran vdout1_12ck1680 FIND v(dout1_12) AT=1690.05n

.meas tran vdout1_13ck1680 FIND v(dout1_13) AT=1690.05n

.meas tran vdout1_14ck1680 FIND v(dout1_14) AT=1690.05n

.meas tran vdout1_15ck1680 FIND v(dout1_15) AT=1690.05n

.meas tran vdout1_16ck1680 FIND v(dout1_16) AT=1690.05n

.meas tran vdout1_17ck1680 FIND v(dout1_17) AT=1690.05n

.meas tran vdout1_18ck1680 FIND v(dout1_18) AT=1690.05n

.meas tran vdout1_19ck1680 FIND v(dout1_19) AT=1690.05n

.meas tran vdout1_20ck1680 FIND v(dout1_20) AT=1690.05n

.meas tran vdout1_21ck1680 FIND v(dout1_21) AT=1690.05n

.meas tran vdout1_22ck1680 FIND v(dout1_22) AT=1690.05n

.meas tran vdout1_23ck1680 FIND v(dout1_23) AT=1690.05n

.meas tran vdout1_24ck1680 FIND v(dout1_24) AT=1690.05n

.meas tran vdout1_25ck1680 FIND v(dout1_25) AT=1690.05n

.meas tran vdout1_26ck1680 FIND v(dout1_26) AT=1690.05n

.meas tran vdout1_27ck1680 FIND v(dout1_27) AT=1690.05n

.meas tran vdout1_28ck1680 FIND v(dout1_28) AT=1690.05n

.meas tran vdout1_29ck1680 FIND v(dout1_29) AT=1690.05n

.meas tran vdout1_30ck1680 FIND v(dout1_30) AT=1690.05n

.meas tran vdout1_31ck1680 FIND v(dout1_31) AT=1690.05n

.meas tran vdout1_32ck1680 FIND v(dout1_32) AT=1690.05n

.meas tran vdout1_0ck1700 FIND v(dout1_0) AT=1710.05n

.meas tran vdout1_1ck1700 FIND v(dout1_1) AT=1710.05n

.meas tran vdout1_2ck1700 FIND v(dout1_2) AT=1710.05n

.meas tran vdout1_3ck1700 FIND v(dout1_3) AT=1710.05n

.meas tran vdout1_4ck1700 FIND v(dout1_4) AT=1710.05n

.meas tran vdout1_5ck1700 FIND v(dout1_5) AT=1710.05n

.meas tran vdout1_6ck1700 FIND v(dout1_6) AT=1710.05n

.meas tran vdout1_7ck1700 FIND v(dout1_7) AT=1710.05n

.meas tran vdout1_8ck1700 FIND v(dout1_8) AT=1710.05n

.meas tran vdout1_9ck1700 FIND v(dout1_9) AT=1710.05n

.meas tran vdout1_10ck1700 FIND v(dout1_10) AT=1710.05n

.meas tran vdout1_11ck1700 FIND v(dout1_11) AT=1710.05n

.meas tran vdout1_12ck1700 FIND v(dout1_12) AT=1710.05n

.meas tran vdout1_13ck1700 FIND v(dout1_13) AT=1710.05n

.meas tran vdout1_14ck1700 FIND v(dout1_14) AT=1710.05n

.meas tran vdout1_15ck1700 FIND v(dout1_15) AT=1710.05n

.meas tran vdout1_16ck1700 FIND v(dout1_16) AT=1710.05n

.meas tran vdout1_17ck1700 FIND v(dout1_17) AT=1710.05n

.meas tran vdout1_18ck1700 FIND v(dout1_18) AT=1710.05n

.meas tran vdout1_19ck1700 FIND v(dout1_19) AT=1710.05n

.meas tran vdout1_20ck1700 FIND v(dout1_20) AT=1710.05n

.meas tran vdout1_21ck1700 FIND v(dout1_21) AT=1710.05n

.meas tran vdout1_22ck1700 FIND v(dout1_22) AT=1710.05n

.meas tran vdout1_23ck1700 FIND v(dout1_23) AT=1710.05n

.meas tran vdout1_24ck1700 FIND v(dout1_24) AT=1710.05n

.meas tran vdout1_25ck1700 FIND v(dout1_25) AT=1710.05n

.meas tran vdout1_26ck1700 FIND v(dout1_26) AT=1710.05n

.meas tran vdout1_27ck1700 FIND v(dout1_27) AT=1710.05n

.meas tran vdout1_28ck1700 FIND v(dout1_28) AT=1710.05n

.meas tran vdout1_29ck1700 FIND v(dout1_29) AT=1710.05n

.meas tran vdout1_30ck1700 FIND v(dout1_30) AT=1710.05n

.meas tran vdout1_31ck1700 FIND v(dout1_31) AT=1710.05n

.meas tran vdout1_32ck1700 FIND v(dout1_32) AT=1710.05n

.meas tran vdout1_0ck1760 FIND v(dout1_0) AT=1770.05n

.meas tran vdout1_1ck1760 FIND v(dout1_1) AT=1770.05n

.meas tran vdout1_2ck1760 FIND v(dout1_2) AT=1770.05n

.meas tran vdout1_3ck1760 FIND v(dout1_3) AT=1770.05n

.meas tran vdout1_4ck1760 FIND v(dout1_4) AT=1770.05n

.meas tran vdout1_5ck1760 FIND v(dout1_5) AT=1770.05n

.meas tran vdout1_6ck1760 FIND v(dout1_6) AT=1770.05n

.meas tran vdout1_7ck1760 FIND v(dout1_7) AT=1770.05n

.meas tran vdout1_8ck1760 FIND v(dout1_8) AT=1770.05n

.meas tran vdout1_9ck1760 FIND v(dout1_9) AT=1770.05n

.meas tran vdout1_10ck1760 FIND v(dout1_10) AT=1770.05n

.meas tran vdout1_11ck1760 FIND v(dout1_11) AT=1770.05n

.meas tran vdout1_12ck1760 FIND v(dout1_12) AT=1770.05n

.meas tran vdout1_13ck1760 FIND v(dout1_13) AT=1770.05n

.meas tran vdout1_14ck1760 FIND v(dout1_14) AT=1770.05n

.meas tran vdout1_15ck1760 FIND v(dout1_15) AT=1770.05n

.meas tran vdout1_16ck1760 FIND v(dout1_16) AT=1770.05n

.meas tran vdout1_17ck1760 FIND v(dout1_17) AT=1770.05n

.meas tran vdout1_18ck1760 FIND v(dout1_18) AT=1770.05n

.meas tran vdout1_19ck1760 FIND v(dout1_19) AT=1770.05n

.meas tran vdout1_20ck1760 FIND v(dout1_20) AT=1770.05n

.meas tran vdout1_21ck1760 FIND v(dout1_21) AT=1770.05n

.meas tran vdout1_22ck1760 FIND v(dout1_22) AT=1770.05n

.meas tran vdout1_23ck1760 FIND v(dout1_23) AT=1770.05n

.meas tran vdout1_24ck1760 FIND v(dout1_24) AT=1770.05n

.meas tran vdout1_25ck1760 FIND v(dout1_25) AT=1770.05n

.meas tran vdout1_26ck1760 FIND v(dout1_26) AT=1770.05n

.meas tran vdout1_27ck1760 FIND v(dout1_27) AT=1770.05n

.meas tran vdout1_28ck1760 FIND v(dout1_28) AT=1770.05n

.meas tran vdout1_29ck1760 FIND v(dout1_29) AT=1770.05n

.meas tran vdout1_30ck1760 FIND v(dout1_30) AT=1770.05n

.meas tran vdout1_31ck1760 FIND v(dout1_31) AT=1770.05n

.meas tran vdout1_32ck1760 FIND v(dout1_32) AT=1770.05n

.meas tran vdout1_0ck1770 FIND v(dout1_0) AT=1780.05n

.meas tran vdout1_1ck1770 FIND v(dout1_1) AT=1780.05n

.meas tran vdout1_2ck1770 FIND v(dout1_2) AT=1780.05n

.meas tran vdout1_3ck1770 FIND v(dout1_3) AT=1780.05n

.meas tran vdout1_4ck1770 FIND v(dout1_4) AT=1780.05n

.meas tran vdout1_5ck1770 FIND v(dout1_5) AT=1780.05n

.meas tran vdout1_6ck1770 FIND v(dout1_6) AT=1780.05n

.meas tran vdout1_7ck1770 FIND v(dout1_7) AT=1780.05n

.meas tran vdout1_8ck1770 FIND v(dout1_8) AT=1780.05n

.meas tran vdout1_9ck1770 FIND v(dout1_9) AT=1780.05n

.meas tran vdout1_10ck1770 FIND v(dout1_10) AT=1780.05n

.meas tran vdout1_11ck1770 FIND v(dout1_11) AT=1780.05n

.meas tran vdout1_12ck1770 FIND v(dout1_12) AT=1780.05n

.meas tran vdout1_13ck1770 FIND v(dout1_13) AT=1780.05n

.meas tran vdout1_14ck1770 FIND v(dout1_14) AT=1780.05n

.meas tran vdout1_15ck1770 FIND v(dout1_15) AT=1780.05n

.meas tran vdout1_16ck1770 FIND v(dout1_16) AT=1780.05n

.meas tran vdout1_17ck1770 FIND v(dout1_17) AT=1780.05n

.meas tran vdout1_18ck1770 FIND v(dout1_18) AT=1780.05n

.meas tran vdout1_19ck1770 FIND v(dout1_19) AT=1780.05n

.meas tran vdout1_20ck1770 FIND v(dout1_20) AT=1780.05n

.meas tran vdout1_21ck1770 FIND v(dout1_21) AT=1780.05n

.meas tran vdout1_22ck1770 FIND v(dout1_22) AT=1780.05n

.meas tran vdout1_23ck1770 FIND v(dout1_23) AT=1780.05n

.meas tran vdout1_24ck1770 FIND v(dout1_24) AT=1780.05n

.meas tran vdout1_25ck1770 FIND v(dout1_25) AT=1780.05n

.meas tran vdout1_26ck1770 FIND v(dout1_26) AT=1780.05n

.meas tran vdout1_27ck1770 FIND v(dout1_27) AT=1780.05n

.meas tran vdout1_28ck1770 FIND v(dout1_28) AT=1780.05n

.meas tran vdout1_29ck1770 FIND v(dout1_29) AT=1780.05n

.meas tran vdout1_30ck1770 FIND v(dout1_30) AT=1780.05n

.meas tran vdout1_31ck1770 FIND v(dout1_31) AT=1780.05n

.meas tran vdout1_32ck1770 FIND v(dout1_32) AT=1780.05n

.meas tran vdout1_0ck1780 FIND v(dout1_0) AT=1790.05n

.meas tran vdout1_1ck1780 FIND v(dout1_1) AT=1790.05n

.meas tran vdout1_2ck1780 FIND v(dout1_2) AT=1790.05n

.meas tran vdout1_3ck1780 FIND v(dout1_3) AT=1790.05n

.meas tran vdout1_4ck1780 FIND v(dout1_4) AT=1790.05n

.meas tran vdout1_5ck1780 FIND v(dout1_5) AT=1790.05n

.meas tran vdout1_6ck1780 FIND v(dout1_6) AT=1790.05n

.meas tran vdout1_7ck1780 FIND v(dout1_7) AT=1790.05n

.meas tran vdout1_8ck1780 FIND v(dout1_8) AT=1790.05n

.meas tran vdout1_9ck1780 FIND v(dout1_9) AT=1790.05n

.meas tran vdout1_10ck1780 FIND v(dout1_10) AT=1790.05n

.meas tran vdout1_11ck1780 FIND v(dout1_11) AT=1790.05n

.meas tran vdout1_12ck1780 FIND v(dout1_12) AT=1790.05n

.meas tran vdout1_13ck1780 FIND v(dout1_13) AT=1790.05n

.meas tran vdout1_14ck1780 FIND v(dout1_14) AT=1790.05n

.meas tran vdout1_15ck1780 FIND v(dout1_15) AT=1790.05n

.meas tran vdout1_16ck1780 FIND v(dout1_16) AT=1790.05n

.meas tran vdout1_17ck1780 FIND v(dout1_17) AT=1790.05n

.meas tran vdout1_18ck1780 FIND v(dout1_18) AT=1790.05n

.meas tran vdout1_19ck1780 FIND v(dout1_19) AT=1790.05n

.meas tran vdout1_20ck1780 FIND v(dout1_20) AT=1790.05n

.meas tran vdout1_21ck1780 FIND v(dout1_21) AT=1790.05n

.meas tran vdout1_22ck1780 FIND v(dout1_22) AT=1790.05n

.meas tran vdout1_23ck1780 FIND v(dout1_23) AT=1790.05n

.meas tran vdout1_24ck1780 FIND v(dout1_24) AT=1790.05n

.meas tran vdout1_25ck1780 FIND v(dout1_25) AT=1790.05n

.meas tran vdout1_26ck1780 FIND v(dout1_26) AT=1790.05n

.meas tran vdout1_27ck1780 FIND v(dout1_27) AT=1790.05n

.meas tran vdout1_28ck1780 FIND v(dout1_28) AT=1790.05n

.meas tran vdout1_29ck1780 FIND v(dout1_29) AT=1790.05n

.meas tran vdout1_30ck1780 FIND v(dout1_30) AT=1790.05n

.meas tran vdout1_31ck1780 FIND v(dout1_31) AT=1790.05n

.meas tran vdout1_32ck1780 FIND v(dout1_32) AT=1790.05n

.meas tran vdout1_0ck1830 FIND v(dout1_0) AT=1840.05n

.meas tran vdout1_1ck1830 FIND v(dout1_1) AT=1840.05n

.meas tran vdout1_2ck1830 FIND v(dout1_2) AT=1840.05n

.meas tran vdout1_3ck1830 FIND v(dout1_3) AT=1840.05n

.meas tran vdout1_4ck1830 FIND v(dout1_4) AT=1840.05n

.meas tran vdout1_5ck1830 FIND v(dout1_5) AT=1840.05n

.meas tran vdout1_6ck1830 FIND v(dout1_6) AT=1840.05n

.meas tran vdout1_7ck1830 FIND v(dout1_7) AT=1840.05n

.meas tran vdout1_8ck1830 FIND v(dout1_8) AT=1840.05n

.meas tran vdout1_9ck1830 FIND v(dout1_9) AT=1840.05n

.meas tran vdout1_10ck1830 FIND v(dout1_10) AT=1840.05n

.meas tran vdout1_11ck1830 FIND v(dout1_11) AT=1840.05n

.meas tran vdout1_12ck1830 FIND v(dout1_12) AT=1840.05n

.meas tran vdout1_13ck1830 FIND v(dout1_13) AT=1840.05n

.meas tran vdout1_14ck1830 FIND v(dout1_14) AT=1840.05n

.meas tran vdout1_15ck1830 FIND v(dout1_15) AT=1840.05n

.meas tran vdout1_16ck1830 FIND v(dout1_16) AT=1840.05n

.meas tran vdout1_17ck1830 FIND v(dout1_17) AT=1840.05n

.meas tran vdout1_18ck1830 FIND v(dout1_18) AT=1840.05n

.meas tran vdout1_19ck1830 FIND v(dout1_19) AT=1840.05n

.meas tran vdout1_20ck1830 FIND v(dout1_20) AT=1840.05n

.meas tran vdout1_21ck1830 FIND v(dout1_21) AT=1840.05n

.meas tran vdout1_22ck1830 FIND v(dout1_22) AT=1840.05n

.meas tran vdout1_23ck1830 FIND v(dout1_23) AT=1840.05n

.meas tran vdout1_24ck1830 FIND v(dout1_24) AT=1840.05n

.meas tran vdout1_25ck1830 FIND v(dout1_25) AT=1840.05n

.meas tran vdout1_26ck1830 FIND v(dout1_26) AT=1840.05n

.meas tran vdout1_27ck1830 FIND v(dout1_27) AT=1840.05n

.meas tran vdout1_28ck1830 FIND v(dout1_28) AT=1840.05n

.meas tran vdout1_29ck1830 FIND v(dout1_29) AT=1840.05n

.meas tran vdout1_30ck1830 FIND v(dout1_30) AT=1840.05n

.meas tran vdout1_31ck1830 FIND v(dout1_31) AT=1840.05n

.meas tran vdout1_32ck1830 FIND v(dout1_32) AT=1840.05n

.meas tran vdout1_0ck1880 FIND v(dout1_0) AT=1890.05n

.meas tran vdout1_1ck1880 FIND v(dout1_1) AT=1890.05n

.meas tran vdout1_2ck1880 FIND v(dout1_2) AT=1890.05n

.meas tran vdout1_3ck1880 FIND v(dout1_3) AT=1890.05n

.meas tran vdout1_4ck1880 FIND v(dout1_4) AT=1890.05n

.meas tran vdout1_5ck1880 FIND v(dout1_5) AT=1890.05n

.meas tran vdout1_6ck1880 FIND v(dout1_6) AT=1890.05n

.meas tran vdout1_7ck1880 FIND v(dout1_7) AT=1890.05n

.meas tran vdout1_8ck1880 FIND v(dout1_8) AT=1890.05n

.meas tran vdout1_9ck1880 FIND v(dout1_9) AT=1890.05n

.meas tran vdout1_10ck1880 FIND v(dout1_10) AT=1890.05n

.meas tran vdout1_11ck1880 FIND v(dout1_11) AT=1890.05n

.meas tran vdout1_12ck1880 FIND v(dout1_12) AT=1890.05n

.meas tran vdout1_13ck1880 FIND v(dout1_13) AT=1890.05n

.meas tran vdout1_14ck1880 FIND v(dout1_14) AT=1890.05n

.meas tran vdout1_15ck1880 FIND v(dout1_15) AT=1890.05n

.meas tran vdout1_16ck1880 FIND v(dout1_16) AT=1890.05n

.meas tran vdout1_17ck1880 FIND v(dout1_17) AT=1890.05n

.meas tran vdout1_18ck1880 FIND v(dout1_18) AT=1890.05n

.meas tran vdout1_19ck1880 FIND v(dout1_19) AT=1890.05n

.meas tran vdout1_20ck1880 FIND v(dout1_20) AT=1890.05n

.meas tran vdout1_21ck1880 FIND v(dout1_21) AT=1890.05n

.meas tran vdout1_22ck1880 FIND v(dout1_22) AT=1890.05n

.meas tran vdout1_23ck1880 FIND v(dout1_23) AT=1890.05n

.meas tran vdout1_24ck1880 FIND v(dout1_24) AT=1890.05n

.meas tran vdout1_25ck1880 FIND v(dout1_25) AT=1890.05n

.meas tran vdout1_26ck1880 FIND v(dout1_26) AT=1890.05n

.meas tran vdout1_27ck1880 FIND v(dout1_27) AT=1890.05n

.meas tran vdout1_28ck1880 FIND v(dout1_28) AT=1890.05n

.meas tran vdout1_29ck1880 FIND v(dout1_29) AT=1890.05n

.meas tran vdout1_30ck1880 FIND v(dout1_30) AT=1890.05n

.meas tran vdout1_31ck1880 FIND v(dout1_31) AT=1890.05n

.meas tran vdout1_32ck1880 FIND v(dout1_32) AT=1890.05n

.meas tran vdout1_0ck1940 FIND v(dout1_0) AT=1950.05n

.meas tran vdout1_1ck1940 FIND v(dout1_1) AT=1950.05n

.meas tran vdout1_2ck1940 FIND v(dout1_2) AT=1950.05n

.meas tran vdout1_3ck1940 FIND v(dout1_3) AT=1950.05n

.meas tran vdout1_4ck1940 FIND v(dout1_4) AT=1950.05n

.meas tran vdout1_5ck1940 FIND v(dout1_5) AT=1950.05n

.meas tran vdout1_6ck1940 FIND v(dout1_6) AT=1950.05n

.meas tran vdout1_7ck1940 FIND v(dout1_7) AT=1950.05n

.meas tran vdout1_8ck1940 FIND v(dout1_8) AT=1950.05n

.meas tran vdout1_9ck1940 FIND v(dout1_9) AT=1950.05n

.meas tran vdout1_10ck1940 FIND v(dout1_10) AT=1950.05n

.meas tran vdout1_11ck1940 FIND v(dout1_11) AT=1950.05n

.meas tran vdout1_12ck1940 FIND v(dout1_12) AT=1950.05n

.meas tran vdout1_13ck1940 FIND v(dout1_13) AT=1950.05n

.meas tran vdout1_14ck1940 FIND v(dout1_14) AT=1950.05n

.meas tran vdout1_15ck1940 FIND v(dout1_15) AT=1950.05n

.meas tran vdout1_16ck1940 FIND v(dout1_16) AT=1950.05n

.meas tran vdout1_17ck1940 FIND v(dout1_17) AT=1950.05n

.meas tran vdout1_18ck1940 FIND v(dout1_18) AT=1950.05n

.meas tran vdout1_19ck1940 FIND v(dout1_19) AT=1950.05n

.meas tran vdout1_20ck1940 FIND v(dout1_20) AT=1950.05n

.meas tran vdout1_21ck1940 FIND v(dout1_21) AT=1950.05n

.meas tran vdout1_22ck1940 FIND v(dout1_22) AT=1950.05n

.meas tran vdout1_23ck1940 FIND v(dout1_23) AT=1950.05n

.meas tran vdout1_24ck1940 FIND v(dout1_24) AT=1950.05n

.meas tran vdout1_25ck1940 FIND v(dout1_25) AT=1950.05n

.meas tran vdout1_26ck1940 FIND v(dout1_26) AT=1950.05n

.meas tran vdout1_27ck1940 FIND v(dout1_27) AT=1950.05n

.meas tran vdout1_28ck1940 FIND v(dout1_28) AT=1950.05n

.meas tran vdout1_29ck1940 FIND v(dout1_29) AT=1950.05n

.meas tran vdout1_30ck1940 FIND v(dout1_30) AT=1950.05n

.meas tran vdout1_31ck1940 FIND v(dout1_31) AT=1950.05n

.meas tran vdout1_32ck1940 FIND v(dout1_32) AT=1950.05n

.meas tran vdout1_0ck1960 FIND v(dout1_0) AT=1970.05n

.meas tran vdout1_1ck1960 FIND v(dout1_1) AT=1970.05n

.meas tran vdout1_2ck1960 FIND v(dout1_2) AT=1970.05n

.meas tran vdout1_3ck1960 FIND v(dout1_3) AT=1970.05n

.meas tran vdout1_4ck1960 FIND v(dout1_4) AT=1970.05n

.meas tran vdout1_5ck1960 FIND v(dout1_5) AT=1970.05n

.meas tran vdout1_6ck1960 FIND v(dout1_6) AT=1970.05n

.meas tran vdout1_7ck1960 FIND v(dout1_7) AT=1970.05n

.meas tran vdout1_8ck1960 FIND v(dout1_8) AT=1970.05n

.meas tran vdout1_9ck1960 FIND v(dout1_9) AT=1970.05n

.meas tran vdout1_10ck1960 FIND v(dout1_10) AT=1970.05n

.meas tran vdout1_11ck1960 FIND v(dout1_11) AT=1970.05n

.meas tran vdout1_12ck1960 FIND v(dout1_12) AT=1970.05n

.meas tran vdout1_13ck1960 FIND v(dout1_13) AT=1970.05n

.meas tran vdout1_14ck1960 FIND v(dout1_14) AT=1970.05n

.meas tran vdout1_15ck1960 FIND v(dout1_15) AT=1970.05n

.meas tran vdout1_16ck1960 FIND v(dout1_16) AT=1970.05n

.meas tran vdout1_17ck1960 FIND v(dout1_17) AT=1970.05n

.meas tran vdout1_18ck1960 FIND v(dout1_18) AT=1970.05n

.meas tran vdout1_19ck1960 FIND v(dout1_19) AT=1970.05n

.meas tran vdout1_20ck1960 FIND v(dout1_20) AT=1970.05n

.meas tran vdout1_21ck1960 FIND v(dout1_21) AT=1970.05n

.meas tran vdout1_22ck1960 FIND v(dout1_22) AT=1970.05n

.meas tran vdout1_23ck1960 FIND v(dout1_23) AT=1970.05n

.meas tran vdout1_24ck1960 FIND v(dout1_24) AT=1970.05n

.meas tran vdout1_25ck1960 FIND v(dout1_25) AT=1970.05n

.meas tran vdout1_26ck1960 FIND v(dout1_26) AT=1970.05n

.meas tran vdout1_27ck1960 FIND v(dout1_27) AT=1970.05n

.meas tran vdout1_28ck1960 FIND v(dout1_28) AT=1970.05n

.meas tran vdout1_29ck1960 FIND v(dout1_29) AT=1970.05n

.meas tran vdout1_30ck1960 FIND v(dout1_30) AT=1970.05n

.meas tran vdout1_31ck1960 FIND v(dout1_31) AT=1970.05n

.meas tran vdout1_32ck1960 FIND v(dout1_32) AT=1970.05n

.meas tran vdout1_0ck1990 FIND v(dout1_0) AT=2000.05n

.meas tran vdout1_1ck1990 FIND v(dout1_1) AT=2000.05n

.meas tran vdout1_2ck1990 FIND v(dout1_2) AT=2000.05n

.meas tran vdout1_3ck1990 FIND v(dout1_3) AT=2000.05n

.meas tran vdout1_4ck1990 FIND v(dout1_4) AT=2000.05n

.meas tran vdout1_5ck1990 FIND v(dout1_5) AT=2000.05n

.meas tran vdout1_6ck1990 FIND v(dout1_6) AT=2000.05n

.meas tran vdout1_7ck1990 FIND v(dout1_7) AT=2000.05n

.meas tran vdout1_8ck1990 FIND v(dout1_8) AT=2000.05n

.meas tran vdout1_9ck1990 FIND v(dout1_9) AT=2000.05n

.meas tran vdout1_10ck1990 FIND v(dout1_10) AT=2000.05n

.meas tran vdout1_11ck1990 FIND v(dout1_11) AT=2000.05n

.meas tran vdout1_12ck1990 FIND v(dout1_12) AT=2000.05n

.meas tran vdout1_13ck1990 FIND v(dout1_13) AT=2000.05n

.meas tran vdout1_14ck1990 FIND v(dout1_14) AT=2000.05n

.meas tran vdout1_15ck1990 FIND v(dout1_15) AT=2000.05n

.meas tran vdout1_16ck1990 FIND v(dout1_16) AT=2000.05n

.meas tran vdout1_17ck1990 FIND v(dout1_17) AT=2000.05n

.meas tran vdout1_18ck1990 FIND v(dout1_18) AT=2000.05n

.meas tran vdout1_19ck1990 FIND v(dout1_19) AT=2000.05n

.meas tran vdout1_20ck1990 FIND v(dout1_20) AT=2000.05n

.meas tran vdout1_21ck1990 FIND v(dout1_21) AT=2000.05n

.meas tran vdout1_22ck1990 FIND v(dout1_22) AT=2000.05n

.meas tran vdout1_23ck1990 FIND v(dout1_23) AT=2000.05n

.meas tran vdout1_24ck1990 FIND v(dout1_24) AT=2000.05n

.meas tran vdout1_25ck1990 FIND v(dout1_25) AT=2000.05n

.meas tran vdout1_26ck1990 FIND v(dout1_26) AT=2000.05n

.meas tran vdout1_27ck1990 FIND v(dout1_27) AT=2000.05n

.meas tran vdout1_28ck1990 FIND v(dout1_28) AT=2000.05n

.meas tran vdout1_29ck1990 FIND v(dout1_29) AT=2000.05n

.meas tran vdout1_30ck1990 FIND v(dout1_30) AT=2000.05n

.meas tran vdout1_31ck1990 FIND v(dout1_31) AT=2000.05n

.meas tran vdout1_32ck1990 FIND v(dout1_32) AT=2000.05n
