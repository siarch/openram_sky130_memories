* Functional test stimulus file for 10ns period

* SS process corner
.lib "/Sky130_memory/pdk/sky130A/libs.tech/ngspice/sky130.lib.spice" ss
.include "/tmp/openram_ryan_48087_temp/sram.sp"

* Global Power Supplies
Vvdd vdd 0 1.7

*Nodes gnd and 0 are the same global ground node in ngspice/hspice/xa. Otherwise, this source may be needed.
*Vgnd gnd 0 0.0

* Instantiation of the SRAM
Xsky130_sram_512bytes_1r1w_32x128 din0_0 din0_1 din0_2 din0_3 din0_4 din0_5 din0_6 din0_7 din0_8 din0_9 din0_10 din0_11 din0_12 din0_13 din0_14 din0_15 din0_16 din0_17 din0_18 din0_19 din0_20 din0_21 din0_22 din0_23 din0_24 din0_25 din0_26 din0_27 din0_28 din0_29 din0_30 din0_31 din0_32 a0_0 a0_1 a0_2 a0_3 a0_4 a0_5 a0_6 a0_7 a1_0 a1_1 a1_2 a1_3 a1_4 a1_5 a1_6 a1_7 CSB0 CSB1 clk0 clk1 SPARE_WEN0_0 dout1_0 dout1_1 dout1_2 dout1_3 dout1_4 dout1_5 dout1_6 dout1_7 dout1_8 dout1_9 dout1_10 dout1_11 dout1_12 dout1_13 dout1_14 dout1_15 dout1_16 dout1_17 dout1_18 dout1_19 dout1_20 dout1_21 dout1_22 dout1_23 dout1_24 dout1_25 dout1_26 dout1_27 dout1_28 dout1_29 dout1_30 dout1_31 dout1_32 vdd gnd sky130_sram_512bytes_1r1w_32x128

* SRAM output loads
CD10 dout1_0  0 27.56f
CD11 dout1_1  0 27.56f
CD12 dout1_2  0 27.56f
CD13 dout1_3  0 27.56f
CD14 dout1_4  0 27.56f
CD15 dout1_5  0 27.56f
CD16 dout1_6  0 27.56f
CD17 dout1_7  0 27.56f
CD18 dout1_8  0 27.56f
CD19 dout1_9  0 27.56f
CD110 dout1_10  0 27.56f
CD111 dout1_11  0 27.56f
CD112 dout1_12  0 27.56f
CD113 dout1_13  0 27.56f
CD114 dout1_14  0 27.56f
CD115 dout1_15  0 27.56f
CD116 dout1_16  0 27.56f
CD117 dout1_17  0 27.56f
CD118 dout1_18  0 27.56f
CD119 dout1_19  0 27.56f
CD120 dout1_20  0 27.56f
CD121 dout1_21  0 27.56f
CD122 dout1_22  0 27.56f
CD123 dout1_23  0 27.56f
CD124 dout1_24  0 27.56f
CD125 dout1_25  0 27.56f
CD126 dout1_26  0 27.56f
CD127 dout1_27  0 27.56f
CD128 dout1_28  0 27.56f
CD129 dout1_29  0 27.56f
CD130 dout1_30  0 27.56f
CD131 dout1_31  0 27.56f
CD132 dout1_32  0 27.56f

* Important signals for debug
* bl:	xsram:xbank0:bl_0_1
* br:	xsram:xbank0:br_0_1
* s_en:	xsram:s_en
* q:	xsram:xbank0:xbitcell_array:xbitcell_array:xbit_r0_c0.Q
* qbar:	xsram:xbank0:xbitcell_array:xbitcell_array:xbit_r0_c0.Q_bar

* Sequence of operations
*	Idle during cycle 0 (0ns - 10ns)
*	Writing 0+00110011010101001111010101111100  to  address 01111111 (from port 0) during cycle 1 (10ns - 20ns)
*	Writing 0+11100001101001010110010101000100  to  address 10000000 (from port 0) during cycle 2 (20ns - 30ns)
*	Writing 0+00000000000110111000011011101001  to  address 00000001 (from port 0) during cycle 3 (30ns - 40ns)
*	Reading 0+11100001101001010110010101000100 from address 10000000 (from port 1) during cycle 4 (40ns - 50ns)
*	Reading 0+00000000000110111000011011101001 from address 00000001 (from port 1) during cycle 5 (50ns - 60ns)
*	Writing 0+10000111001101000100111000100111  to  address 10000000 (from port 0) during cycle 6 (60ns - 70ns)
*	Writing 0+01110011100000011101111000011101  to  address 10000000 (from port 0) during cycle 9 (90ns - 100ns)
*	Writing 0+11010110100001100000011010100010  to  address 01111111 (from port 0) during cycle 10 (100ns - 110ns)
*	Reading 0+01110011100000011101111000011101 from address 10000000 (from port 1) during cycle 10 (100ns - 110ns)
*	Writing 0+01100000010001010000110110111000  to  address 00000000 (from port 0) during cycle 11 (110ns - 120ns)
*	Reading 0+00000000000110111000011011101001 from address 00000001 (from port 1) during cycle 13 (130ns - 140ns)
*	Reading 0+01100000010001010000110110111000 from address 00000000 (from port 1) during cycle 14 (140ns - 150ns)
*	Writing 0+11001100011111001111010111111110  to  address 10000000 (from port 0) during cycle 15 (150ns - 160ns)
*	Reading 0+11010110100001100000011010100010 from address 01111111 (from port 1) during cycle 15 (150ns - 160ns)
*	Reading 0+11010110100001100000011010100010 from address 01111111 (from port 1) during cycle 18 (180ns - 190ns)
*	Writing 0+01001111011001011100001011010101  to  address 00000000 (from port 0) during cycle 19 (190ns - 200ns)
*	Reading 0+11001100011111001111010111111110 from address 10000000 (from port 1) during cycle 19 (190ns - 200ns)
*	Writing 0+10111111000000001011001101111110  to  address 00000001 (from port 0) during cycle 20 (200ns - 210ns)
*	Reading 0+11010110100001100000011010100010 from address 01111111 (from port 1) during cycle 20 (200ns - 210ns)
*	Writing 0+00100100011010001011000010111110  to  address 10000000 (from port 0) during cycle 21 (210ns - 220ns)
*	Reading 0+11010110100001100000011010100010 from address 01111111 (from port 1) during cycle 22 (220ns - 230ns)
*	Reading 0+10111111000000001011001101111110 from address 00000001 (from port 1) during cycle 24 (240ns - 250ns)
*	Reading 0+11010110100001100000011010100010 from address 01111111 (from port 1) during cycle 25 (250ns - 260ns)
*	Reading 0+00100100011010001011000010111110 from address 10000000 (from port 1) during cycle 27 (270ns - 280ns)
*	Writing 0+01110111001011110001100000111111  to  address 00000000 (from port 0) during cycle 28 (280ns - 290ns)
*	Reading 0+10111111000000001011001101111110 from address 00000001 (from port 1) during cycle 30 (300ns - 310ns)
*	Writing 0+00101001000100110010111001010001  to  address 00000000 (from port 0) during cycle 31 (310ns - 320ns)
*	Writing 0+11110110001000011010111111010100  to  address 00000001 (from port 0) during cycle 32 (320ns - 330ns)
*	Writing 0+11001011001111111011001100111111  to  address 00000001 (from port 0) during cycle 33 (330ns - 340ns)
*	Reading 0+00101001000100110010111001010001 from address 00000000 (from port 1) during cycle 33 (330ns - 340ns)
*	Reading 0+11001011001111111011001100111111 from address 00000001 (from port 1) during cycle 34 (340ns - 350ns)
*	Reading 0+00101001000100110010111001010001 from address 00000000 (from port 1) during cycle 37 (370ns - 380ns)
*	Reading 0+00100100011010001011000010111110 from address 10000000 (from port 1) during cycle 39 (390ns - 400ns)
*	Reading 0+11001011001111111011001100111111 from address 00000001 (from port 1) during cycle 41 (410ns - 420ns)
*	Writing 0+00000000010010010111001010100101  to  address 00000001 (from port 0) during cycle 42 (420ns - 430ns)
*	Reading 0+11010110100001100000011010100010 from address 01111111 (from port 1) during cycle 43 (430ns - 440ns)
*	Writing 0+10000001010110100111111001101100  to  address 10000000 (from port 0) during cycle 44 (440ns - 450ns)
*	Writing 0+10101010101101101111010110100010  to  address 00000001 (from port 0) during cycle 46 (460ns - 470ns)
*	Writing 0+11000100111100001000001011010001  to  address 00000000 (from port 0) during cycle 47 (470ns - 480ns)
*	Reading 0+10000001010110100111111001101100 from address 10000000 (from port 1) during cycle 47 (470ns - 480ns)
*	Reading 0+11000100111100001000001011010001 from address 00000000 (from port 1) during cycle 48 (480ns - 490ns)
*	Reading 0+10101010101101101111010110100010 from address 00000001 (from port 1) during cycle 49 (490ns - 500ns)
*	Writing 0+01110001101011011001001111011111  to  address 00000000 (from port 0) during cycle 50 (500ns - 510ns)
*	Writing 0+01011100101000000011011110100001  to  address 00000001 (from port 0) during cycle 51 (510ns - 520ns)
*	Reading 0+01110001101011011001001111011111 from address 00000000 (from port 1) during cycle 51 (510ns - 520ns)
*	Writing 0+11100101110110000011011011100011  to  address 00000000 (from port 0) during cycle 52 (520ns - 530ns)
*	Writing 0+10110010110001010110000101111100  to  address 01111111 (from port 0) during cycle 55 (550ns - 560ns)
*	Writing 0+10000010101001000101110001000010  to  address 01111111 (from port 0) during cycle 56 (560ns - 570ns)
*	Reading 0+01011100101000000011011110100001 from address 00000001 (from port 1) during cycle 57 (570ns - 580ns)
*	Writing 0+01101001100100101100010011001001  to  address 10000000 (from port 0) during cycle 60 (600ns - 610ns)
*	Reading 0+10000010101001000101110001000010 from address 01111111 (from port 1) during cycle 60 (600ns - 610ns)
*	Writing 0+01000000001100000011100101111001  to  address 00000001 (from port 0) during cycle 61 (610ns - 620ns)
*	Writing 0+01101111110110101001010101110101  to  address 10000000 (from port 0) during cycle 62 (620ns - 630ns)
*	Reading 0+10000010101001000101110001000010 from address 01111111 (from port 1) during cycle 62 (620ns - 630ns)
*	Writing 0+10011110010010011110110011101110  to  address 00000000 (from port 0) during cycle 63 (630ns - 640ns)
*	Reading 0+01101111110110101001010101110101 from address 10000000 (from port 1) during cycle 63 (630ns - 640ns)
*	Writing 0+10110010001010111001001111010110  to  address 00000000 (from port 0) during cycle 65 (650ns - 660ns)
*	Reading 0+01000000001100000011100101111001 from address 00000001 (from port 1) during cycle 66 (660ns - 670ns)
*	Writing 0+01000010000011110100011010000101  to  address 00000001 (from port 0) during cycle 67 (670ns - 680ns)
*	Reading 0+10110010001010111001001111010110 from address 00000000 (from port 1) during cycle 67 (670ns - 680ns)
*	Writing 0+00000111101000101001010010100110  to  address 00000001 (from port 0) during cycle 68 (680ns - 690ns)
*	Reading 0+01101111110110101001010101110101 from address 10000000 (from port 1) during cycle 68 (680ns - 690ns)
*	Reading 0+00000111101000101001010010100110 from address 00000001 (from port 1) during cycle 69 (690ns - 700ns)
*	Writing 0+11100110111001110111010010000100  to  address 00000001 (from port 0) during cycle 70 (700ns - 710ns)
*	Writing 0+00011100100101101101111001011100  to  address 00000001 (from port 0) during cycle 71 (710ns - 720ns)
*	Writing 0+10011100110100010111011010000101  to  address 00000000 (from port 0) during cycle 74 (740ns - 750ns)
*	Reading 0+01101111110110101001010101110101 from address 10000000 (from port 1) during cycle 74 (740ns - 750ns)
*	Reading 0+10000010101001000101110001000010 from address 01111111 (from port 1) during cycle 75 (750ns - 760ns)
*	Reading 0+10011100110100010111011010000101 from address 00000000 (from port 1) during cycle 76 (760ns - 770ns)
*	Writing 0+11110001101011001000001000011001  to  address 00000001 (from port 0) during cycle 77 (770ns - 780ns)
*	Reading 0+01101111110110101001010101110101 from address 10000000 (from port 1) during cycle 77 (770ns - 780ns)
*	Writing 0+01000000011101000101010100110001  to  address 10000000 (from port 0) during cycle 78 (780ns - 790ns)
*	Writing 0+10100010001110100101000000100111  to  address 00000000 (from port 0) during cycle 79 (790ns - 800ns)
*	Writing 0+10110111110110100100110011010100  to  address 01111111 (from port 0) during cycle 80 (800ns - 810ns)
*	Reading 0+10100010001110100101000000100111 from address 00000000 (from port 1) during cycle 80 (800ns - 810ns)
*	Reading 0+01000000011101000101010100110001 from address 10000000 (from port 1) during cycle 81 (810ns - 820ns)
*	Writing 0+01001001010101001101001110100100  to  address 10000000 (from port 0) during cycle 82 (820ns - 830ns)
*	Reading 0+10110111110110100100110011010100 from address 01111111 (from port 1) during cycle 82 (820ns - 830ns)
*	Writing 0+01100110000101001001001111000010  to  address 00000000 (from port 0) during cycle 83 (830ns - 840ns)
*	Writing 0+10100101001110110101111100000100  to  address 00000001 (from port 0) during cycle 84 (840ns - 850ns)
*	Writing 0+11001010110111010100110100010110  to  address 10000000 (from port 0) during cycle 86 (860ns - 870ns)
*	Reading 0+10100101001110110101111100000100 from address 00000001 (from port 1) during cycle 86 (860ns - 870ns)
*	Writing 0+01100011000110101100011101000101  to  address 00000001 (from port 0) during cycle 87 (870ns - 880ns)
*	Reading 0+11001010110111010100110100010110 from address 10000000 (from port 1) during cycle 87 (870ns - 880ns)
*	Writing 0+11111110001000101100100010001111  to  address 00000001 (from port 0) during cycle 88 (880ns - 890ns)
*	Writing 0+10100000111000011111010111110111  to  address 00000001 (from port 0) during cycle 90 (900ns - 910ns)
*	Reading 0+10100000111000011111010111110111 from address 00000001 (from port 1) during cycle 91 (910ns - 920ns)
*	Writing 0+00110100010100010010100010010000  to  address 00000001 (from port 0) during cycle 92 (920ns - 930ns)
*	Reading 0+00110100010100010010100010010000 from address 00000001 (from port 1) during cycle 94 (940ns - 950ns)
*	Reading 0+01100110000101001001001111000010 from address 00000000 (from port 1) during cycle 95 (950ns - 960ns)
*	Writing 0+11010000000000011001100001101111  to  address 00000000 (from port 0) during cycle 96 (960ns - 970ns)
*	Writing 0+11011101000101100011101100011011  to  address 01111111 (from port 0) during cycle 97 (970ns - 980ns)
*	Writing 0+01011001101111110100011000110111  to  address 01111111 (from port 0) during cycle 98 (980ns - 990ns)
*	Reading 0+11010000000000011001100001101111 from address 00000000 (from port 1) during cycle 98 (980ns - 990ns)
*	Writing 0+11011001100110001110100101100100  to  address 10000000 (from port 0) during cycle 99 (990ns - 1000ns)
*	Reading 0+01011001101111110100011000110111 from address 01111111 (from port 1) during cycle 99 (990ns - 1000ns)
*	Writing 0+10010101001111111001100010111100  to  address 01111111 (from port 0) during cycle 100 (1000ns - 1010ns)
*	Writing 0+10111101111011101011001101011010  to  address 00000000 (from port 0) during cycle 101 (1010ns - 1020ns)
*	Writing 0+11010011001110001101010110110011  to  address 00000000 (from port 0) during cycle 102 (1020ns - 1030ns)
*	Writing 0+00001101101111100111000000011011  to  address 00000001 (from port 0) during cycle 103 (1030ns - 1040ns)
*	Reading 0+10010101001111111001100010111100 from address 01111111 (from port 1) during cycle 103 (1030ns - 1040ns)
*	Reading 0+10010101001111111001100010111100 from address 01111111 (from port 1) during cycle 106 (1060ns - 1070ns)
*	Writing 0+10101110100101101001101011100100  to  address 01111111 (from port 0) during cycle 107 (1070ns - 1080ns)
*	Reading 0+11011001100110001110100101100100 from address 10000000 (from port 1) during cycle 107 (1070ns - 1080ns)
*	Writing 0+11111011101111000011001010000101  to  address 01111111 (from port 0) during cycle 108 (1080ns - 1090ns)
*	Writing 0+00100011111100011110010110110010  to  address 01111111 (from port 0) during cycle 109 (1090ns - 1100ns)
*	Writing 0+00001111101010011110001110010111  to  address 10000000 (from port 0) during cycle 110 (1100ns - 1110ns)
*	Writing 0+11001010101001011011100110100100  to  address 01111111 (from port 0) during cycle 111 (1110ns - 1120ns)
*	Reading 0+11001010101001011011100110100100 from address 01111111 (from port 1) during cycle 112 (1120ns - 1130ns)
*	Writing 0+11010100101010000110001010110100  to  address 10000000 (from port 0) during cycle 113 (1130ns - 1140ns)
*	Writing 0+00111110100001110101001101011101  to  address 00000001 (from port 0) during cycle 114 (1140ns - 1150ns)
*	Reading 0+11010100101010000110001010110100 from address 10000000 (from port 1) during cycle 114 (1140ns - 1150ns)
*	Writing 0+10010111100001110101101010101001  to  address 10000000 (from port 0) during cycle 115 (1150ns - 1160ns)
*	Reading 0+00111110100001110101001101011101 from address 00000001 (from port 1) during cycle 115 (1150ns - 1160ns)
*	Reading 0+11010011001110001101010110110011 from address 00000000 (from port 1) during cycle 116 (1160ns - 1170ns)
*	Writing 0+01010110011100011110110110011100  to  address 00000001 (from port 0) during cycle 117 (1170ns - 1180ns)
*	Writing 0+11010101110100010100110010011111  to  address 00000000 (from port 0) during cycle 118 (1180ns - 1190ns)
*	Reading 0+10010111100001110101101010101001 from address 10000000 (from port 1) during cycle 119 (1190ns - 1200ns)
*	Writing 0+01010000010111111010111110011011  to  address 00000001 (from port 0) during cycle 122 (1220ns - 1230ns)
*	Reading 0+11010101110100010100110010011111 from address 00000000 (from port 1) during cycle 122 (1220ns - 1230ns)
*	Writing 0+00001101000000010001100100111000  to  address 00000001 (from port 0) during cycle 123 (1230ns - 1240ns)
*	Reading 0+10010111100001110101101010101001 from address 10000000 (from port 1) during cycle 123 (1230ns - 1240ns)
*	Writing 0+00001110100111101000110110010101  to  address 00000000 (from port 0) during cycle 124 (1240ns - 1250ns)
*	Writing 0+10011001110001110100111011110011  to  address 10000000 (from port 0) during cycle 125 (1250ns - 1260ns)
*	Reading 0+00001101000000010001100100111000 from address 00000001 (from port 1) during cycle 126 (1260ns - 1270ns)
*	Reading 0+10011001110001110100111011110011 from address 10000000 (from port 1) during cycle 127 (1270ns - 1280ns)
*	Reading 0+00001101000000010001100100111000 from address 00000001 (from port 1) during cycle 128 (1280ns - 1290ns)
*	Writing 0+11110100000101101111101011111001  to  address 00000000 (from port 0) during cycle 129 (1290ns - 1300ns)
*	Writing 0+11001010101000100100100001011010  to  address 00000000 (from port 0) during cycle 130 (1300ns - 1310ns)
*	Reading 0+11001010101001011011100110100100 from address 01111111 (from port 1) during cycle 130 (1300ns - 1310ns)
*	Reading 0+11001010101001011011100110100100 from address 01111111 (from port 1) during cycle 131 (1310ns - 1320ns)
*	Reading 0+11001010101001011011100110100100 from address 01111111 (from port 1) during cycle 132 (1320ns - 1330ns)
*	Writing 0+10001011010110011001010001110011  to  address 00000001 (from port 0) during cycle 134 (1340ns - 1350ns)
*	Reading 0+10011001110001110100111011110011 from address 10000000 (from port 1) during cycle 135 (1350ns - 1360ns)
*	Writing 0+11000111010111111110111011111000  to  address 01111111 (from port 0) during cycle 136 (1360ns - 1370ns)
*	Reading 0+10011001110001110100111011110011 from address 10000000 (from port 1) during cycle 136 (1360ns - 1370ns)
*	Writing 0+01110000001010010010110110011010  to  address 00000001 (from port 0) during cycle 137 (1370ns - 1380ns)
*	Reading 0+11001010101000100100100001011010 from address 00000000 (from port 1) during cycle 137 (1370ns - 1380ns)
*	Reading 0+11000111010111111110111011111000 from address 01111111 (from port 1) during cycle 139 (1390ns - 1400ns)
*	Writing 0+10101100111001000111100111100111  to  address 10000000 (from port 0) during cycle 140 (1400ns - 1410ns)
*	Reading 0+01110000001010010010110110011010 from address 00000001 (from port 1) during cycle 142 (1420ns - 1430ns)
*	Reading 0+10101100111001000111100111100111 from address 10000000 (from port 1) during cycle 145 (1450ns - 1460ns)
*	Reading 0+10101100111001000111100111100111 from address 10000000 (from port 1) during cycle 146 (1460ns - 1470ns)
*	Writing 0+11111011100000001101100010000010  to  address 10000000 (from port 0) during cycle 148 (1480ns - 1490ns)
*	Reading 0+11000111010111111110111011111000 from address 01111111 (from port 1) during cycle 149 (1490ns - 1500ns)
*	Writing 0+11100001010110101100100001001110  to  address 00000000 (from port 0) during cycle 150 (1500ns - 1510ns)
*	Writing 0+00000111100110100110110100101011  to  address 00000000 (from port 0) during cycle 151 (1510ns - 1520ns)
*	Reading 0+11111011100000001101100010000010 from address 10000000 (from port 1) during cycle 152 (1520ns - 1530ns)
*	Writing 0+10011110010111001101111100101101  to  address 00000001 (from port 0) during cycle 154 (1540ns - 1550ns)
*	Writing 0+00001100110010111101101111100001  to  address 00000001 (from port 0) during cycle 155 (1550ns - 1560ns)
*	Reading 0+11000111010111111110111011111000 from address 01111111 (from port 1) during cycle 155 (1550ns - 1560ns)
*	Writing 0+10110010000100111111111000000001  to  address 01111111 (from port 0) during cycle 156 (1560ns - 1570ns)
*	Reading 0+10110010000100111111111000000001 from address 01111111 (from port 1) during cycle 157 (1570ns - 1580ns)
*	Writing 0+01011000010110111011000110101100  to  address 00000000 (from port 0) during cycle 158 (1580ns - 1590ns)
*	Reading 0+11111011100000001101100010000010 from address 10000000 (from port 1) during cycle 159 (1590ns - 1600ns)
*	Reading 0+00001100110010111101101111100001 from address 00000001 (from port 1) during cycle 160 (1600ns - 1610ns)
*	Reading 0+11111011100000001101100010000010 from address 10000000 (from port 1) during cycle 161 (1610ns - 1620ns)
*	Writing 0+00110110000111111010101010001110  to  address 10000000 (from port 0) during cycle 162 (1620ns - 1630ns)
*	Writing 0+00110111010010110111000010111100  to  address 01111111 (from port 0) during cycle 163 (1630ns - 1640ns)
*	Reading 0+01011000010110111011000110101100 from address 00000000 (from port 1) during cycle 163 (1630ns - 1640ns)
*	Reading 0+01011000010110111011000110101100 from address 00000000 (from port 1) during cycle 164 (1640ns - 1650ns)
*	Writing 0+01010000110100110100010100111111  to  address 10000000 (from port 0) during cycle 165 (1650ns - 1660ns)
*	Reading 0+00001100110010111101101111100001 from address 00000001 (from port 1) during cycle 165 (1650ns - 1660ns)
*	Writing 0+01101000010101001010001110000100  to  address 10000000 (from port 0) during cycle 166 (1660ns - 1670ns)
*	Reading 0+00001100110010111101101111100001 from address 00000001 (from port 1) during cycle 166 (1660ns - 1670ns)
*	Reading 0+00110111010010110111000010111100 from address 01111111 (from port 1) during cycle 167 (1670ns - 1680ns)
*	Reading 0+00001100110010111101101111100001 from address 00000001 (from port 1) during cycle 168 (1680ns - 1690ns)
*	Reading 0+01011000010110111011000110101100 from address 00000000 (from port 1) during cycle 170 (1700ns - 1710ns)
*	Writing 0+01001000011101110101010000010001  to  address 00000001 (from port 0) during cycle 171 (1710ns - 1720ns)
*	Writing 0+10101101110100101111110110000000  to  address 00000001 (from port 0) during cycle 173 (1730ns - 1740ns)
*	Writing 0+10111110110010100100000111011110  to  address 10000000 (from port 0) during cycle 175 (1750ns - 1760ns)
*	Reading 0+00110111010010110111000010111100 from address 01111111 (from port 1) during cycle 176 (1760ns - 1770ns)
*	Writing 0+10000001010000110101000011101000  to  address 10000000 (from port 0) during cycle 177 (1770ns - 1780ns)
*	Reading 0+00110111010010110111000010111100 from address 01111111 (from port 1) during cycle 177 (1770ns - 1780ns)
*	Writing 0+11101101111100100110000100011101  to  address 00000000 (from port 0) during cycle 178 (1780ns - 1790ns)
*	Reading 0+10101101110100101111110110000000 from address 00000001 (from port 1) during cycle 178 (1780ns - 1790ns)
*	Writing 0+00010001011011000100101111011111  to  address 10000000 (from port 0) during cycle 180 (1800ns - 1810ns)
*	Reading 0+00010001011011000100101111011111 from address 10000000 (from port 1) during cycle 183 (1830ns - 1840ns)
*	Writing 0+11100111111101111001100101000000  to  address 00000001 (from port 0) during cycle 184 (1840ns - 1850ns)
*	Writing 0+00011100000000111111011001101100  to  address 00000001 (from port 0) during cycle 186 (1860ns - 1870ns)
*	Reading 0+00011100000000111111011001101100 from address 00000001 (from port 1) during cycle 188 (1880ns - 1890ns)
*	Writing 0+10110011000011000010110111110010  to  address 00000000 (from port 0) during cycle 191 (1910ns - 1920ns)
*	Writing 0+10100111011010101011100000010101  to  address 10000000 (from port 0) during cycle 192 (1920ns - 1930ns)
*	Writing 0+01101011101101110101100010010111  to  address 10000000 (from port 0) during cycle 193 (1930ns - 1940ns)
*	Writing 0+11000110100100111000000100001001  to  address 00000000 (from port 0) during cycle 194 (1940ns - 1950ns)
*	Reading 0+00110111010010110111000010111100 from address 01111111 (from port 1) during cycle 194 (1940ns - 1950ns)
*	Writing 0+11000111110000000100000000000101  to  address 00000000 (from port 0) during cycle 195 (1950ns - 1960ns)
*	Reading 0+00110111010010110111000010111100 from address 01111111 (from port 1) during cycle 196 (1960ns - 1970ns)
*	Writing 0+00001110010101011101101100011010  to  address 10000000 (from port 0) during cycle 197 (1970ns - 1980ns)
*	Writing 0+01011010100000001011101000100100  to  address 00000000 (from port 0) during cycle 198 (1980ns - 1990ns)
*	Reading 0+00001110010101011101101100011010 from address 10000000 (from port 1) during cycle 199 (1990ns - 2000ns)
*	Writing 0+00000011011001010001110111010111  to  address 00000000 (from port 0) during cycle 200 (2000ns - 2010ns)
*	Writing 0+11001101110010011101111000111001  to  address 01111111 (from port 0) during cycle 201 (2010ns - 2020ns)
*	Writing 0+00111001011011101010000111011101  to  address 00000001 (from port 0) during cycle 202 (2020ns - 2030ns)
*	Idle during cycle 205 (2050ns - 2060ns)

* Generation of data and address signals
* (time, data): [(0, 0), (10, 0), (20, 0), (30, 1), (40, 1), (50, 1), (60, 1), (70, 1), (80, 1), (90, 1), (100, 0), (110, 0), (120, 0), (130, 0), (140, 0), (150, 0), (160, 0), (170, 0), (180, 0), (190, 1), (200, 0), (210, 0), (220, 0), (230, 0), (240, 0), (250, 0), (260, 0), (270, 0), (280, 1), (290, 1), (300, 1), (310, 1), (320, 0), (330, 1), (340, 1), (350, 1), (360, 1), (370, 1), (380, 1), (390, 1), (400, 1), (410, 1), (420, 1), (430, 1), (440, 0), (450, 0), (460, 0), (470, 1), (480, 1), (490, 1), (500, 1), (510, 1), (520, 1), (530, 1), (540, 1), (550, 0), (560, 0), (570, 0), (580, 0), (590, 0), (600, 1), (610, 1), (620, 1), (630, 0), (640, 0), (650, 0), (660, 0), (670, 1), (680, 0), (690, 0), (700, 0), (710, 0), (720, 0), (730, 0), (740, 1), (750, 1), (760, 1), (770, 1), (780, 1), (790, 1), (800, 0), (810, 0), (820, 0), (830, 0), (840, 0), (850, 0), (860, 0), (870, 1), (880, 1), (890, 1), (900, 1), (910, 1), (920, 0), (930, 0), (940, 0), (950, 0), (960, 1), (970, 1), (980, 1), (990, 0), (1000, 0), (1010, 0), (1020, 1), (1030, 1), (1040, 1), (1050, 1), (1060, 1), (1070, 0), (1080, 1), (1090, 0), (1100, 1), (1110, 0), (1120, 0), (1130, 0), (1140, 1), (1150, 1), (1160, 1), (1170, 0), (1180, 1), (1190, 1), (1200, 1), (1210, 1), (1220, 1), (1230, 0), (1240, 1), (1250, 1), (1260, 1), (1270, 1), (1280, 1), (1290, 1), (1300, 0), (1310, 0), (1320, 0), (1330, 0), (1340, 1), (1350, 1), (1360, 0), (1370, 0), (1380, 0), (1390, 0), (1400, 1), (1410, 1), (1420, 1), (1430, 1), (1440, 1), (1450, 1), (1460, 1), (1470, 1), (1480, 0), (1490, 0), (1500, 0), (1510, 1), (1520, 1), (1530, 1), (1540, 1), (1550, 1), (1560, 1), (1570, 1), (1580, 0), (1590, 0), (1600, 0), (1610, 0), (1620, 0), (1630, 0), (1640, 0), (1650, 1), (1660, 0), (1670, 0), (1680, 0), (1690, 0), (1700, 0), (1710, 1), (1720, 1), (1730, 0), (1740, 0), (1750, 0), (1760, 0), (1770, 0), (1780, 1), (1790, 1), (1800, 1), (1810, 1), (1820, 1), (1830, 1), (1840, 0), (1850, 0), (1860, 0), (1870, 0), (1880, 0), (1890, 0), (1900, 0), (1910, 0), (1920, 1), (1930, 1), (1940, 1), (1950, 1), (1960, 1), (1970, 0), (1980, 0), (1990, 0), (2000, 1), (2010, 1), (2020, 1), (2030, 1), (2040, 1), (2050, 1)]
Vdin0_0  din0_0  0 PWL (0n 0.0v 9.495n 0.0v 9.505n 0.0v 19.495n 0.0v 19.505n 0.0v 29.495n 0.0v 29.505n 1.7v 39.495n 1.7v 39.505n 1.7v 49.495n 1.7v 49.505n 1.7v 59.495n 1.7v 59.505n 1.7v 69.495n 1.7v 69.505n 1.7v 79.495n 1.7v 79.505n 1.7v 89.495n 1.7v 89.505n 1.7v 99.495n 1.7v 99.505n 0.0v 109.495n 0.0v 109.505n 0.0v 119.495n 0.0v 119.505n 0.0v 129.495n 0.0v 129.505n 0.0v 139.495n 0.0v 139.505n 0.0v 149.495n 0.0v 149.505n 0.0v 159.495n 0.0v 159.505n 0.0v 169.495n 0.0v 169.505n 0.0v 179.495n 0.0v 179.505n 0.0v 189.495n 0.0v 189.505n 1.7v 199.495n 1.7v 199.505n 0.0v 209.495n 0.0v 209.505n 0.0v 219.495n 0.0v 219.505n 0.0v 229.495n 0.0v 229.505n 0.0v 239.495n 0.0v 239.505n 0.0v 249.495n 0.0v 249.505n 0.0v 259.495n 0.0v 259.505n 0.0v 269.495n 0.0v 269.505n 0.0v 279.495n 0.0v 279.505n 1.7v 289.495n 1.7v 289.505n 1.7v 299.495n 1.7v 299.505n 1.7v 309.495n 1.7v 309.505n 1.7v 319.495n 1.7v 319.505n 0.0v 329.495n 0.0v 329.505n 1.7v 339.495n 1.7v 339.505n 1.7v 349.495n 1.7v 349.505n 1.7v 359.495n 1.7v 359.505n 1.7v 369.495n 1.7v 369.505n 1.7v 379.495n 1.7v 379.505n 1.7v 389.495n 1.7v 389.505n 1.7v 399.495n 1.7v 399.505n 1.7v 409.495n 1.7v 409.505n 1.7v 419.495n 1.7v 419.505n 1.7v 429.495n 1.7v 429.505n 1.7v 439.495n 1.7v 439.505n 0.0v 449.495n 0.0v 449.505n 0.0v 459.495n 0.0v 459.505n 0.0v 469.495n 0.0v 469.505n 1.7v 479.495n 1.7v 479.505n 1.7v 489.495n 1.7v 489.505n 1.7v 499.495n 1.7v 499.505n 1.7v 509.495n 1.7v 509.505n 1.7v 519.495n 1.7v 519.505n 1.7v 529.495n 1.7v 529.505n 1.7v 539.495n 1.7v 539.505n 1.7v 549.495n 1.7v 549.505n 0.0v 559.495n 0.0v 559.505n 0.0v 569.495n 0.0v 569.505n 0.0v 579.495n 0.0v 579.505n 0.0v 589.495n 0.0v 589.505n 0.0v 599.495n 0.0v 599.505n 1.7v 609.495n 1.7v 609.505n 1.7v 619.495n 1.7v 619.505n 1.7v 629.495n 1.7v 629.505n 0.0v 639.495n 0.0v 639.505n 0.0v 649.495n 0.0v 649.505n 0.0v 659.495n 0.0v 659.505n 0.0v 669.495n 0.0v 669.505n 1.7v 679.495n 1.7v 679.505n 0.0v 689.495n 0.0v 689.505n 0.0v 699.495n 0.0v 699.505n 0.0v 709.495n 0.0v 709.505n 0.0v 719.495n 0.0v 719.505n 0.0v 729.495n 0.0v 729.505n 0.0v 739.495n 0.0v 739.505n 1.7v 749.495n 1.7v 749.505n 1.7v 759.495n 1.7v 759.505n 1.7v 769.495n 1.7v 769.505n 1.7v 779.495n 1.7v 779.505n 1.7v 789.495n 1.7v 789.505n 1.7v 799.495n 1.7v 799.505n 0.0v 809.495n 0.0v 809.505n 0.0v 819.495n 0.0v 819.505n 0.0v 829.495n 0.0v 829.505n 0.0v 839.495n 0.0v 839.505n 0.0v 849.495n 0.0v 849.505n 0.0v 859.495n 0.0v 859.505n 0.0v 869.495n 0.0v 869.505n 1.7v 879.495n 1.7v 879.505n 1.7v 889.495n 1.7v 889.505n 1.7v 899.495n 1.7v 899.505n 1.7v 909.495n 1.7v 909.505n 1.7v 919.495n 1.7v 919.505n 0.0v 929.495n 0.0v 929.505n 0.0v 939.495n 0.0v 939.505n 0.0v 949.495n 0.0v 949.505n 0.0v 959.495n 0.0v 959.505n 1.7v 969.495n 1.7v 969.505n 1.7v 979.495n 1.7v 979.505n 1.7v 989.495n 1.7v 989.505n 0.0v 999.495n 0.0v 999.505n 0.0v 1009.495n 0.0v 1009.505n 0.0v 1019.495n 0.0v 1019.505n 1.7v 1029.495n 1.7v 1029.505n 1.7v 1039.495n 1.7v 1039.505n 1.7v 1049.495n 1.7v 1049.505n 1.7v 1059.495n 1.7v 1059.505n 1.7v 1069.495n 1.7v 1069.505n 0.0v 1079.495n 0.0v 1079.505n 1.7v 1089.495n 1.7v 1089.505n 0.0v 1099.495n 0.0v 1099.505n 1.7v 1109.495n 1.7v 1109.505n 0.0v 1119.495n 0.0v 1119.505n 0.0v 1129.495n 0.0v 1129.505n 0.0v 1139.495n 0.0v 1139.505n 1.7v 1149.495n 1.7v 1149.505n 1.7v 1159.495n 1.7v 1159.505n 1.7v 1169.495n 1.7v 1169.505n 0.0v 1179.495n 0.0v 1179.505n 1.7v 1189.495n 1.7v 1189.505n 1.7v 1199.495n 1.7v 1199.505n 1.7v 1209.495n 1.7v 1209.505n 1.7v 1219.495n 1.7v 1219.505n 1.7v 1229.495n 1.7v 1229.505n 0.0v 1239.495n 0.0v 1239.505n 1.7v 1249.495n 1.7v 1249.505n 1.7v 1259.495n 1.7v 1259.505n 1.7v 1269.495n 1.7v 1269.505n 1.7v 1279.495n 1.7v 1279.505n 1.7v 1289.495n 1.7v 1289.505n 1.7v 1299.495n 1.7v 1299.505n 0.0v 1309.495n 0.0v 1309.505n 0.0v 1319.495n 0.0v 1319.505n 0.0v 1329.495n 0.0v 1329.505n 0.0v 1339.495n 0.0v 1339.505n 1.7v 1349.495n 1.7v 1349.505n 1.7v 1359.495n 1.7v 1359.505n 0.0v 1369.495n 0.0v 1369.505n 0.0v 1379.495n 0.0v 1379.505n 0.0v 1389.495n 0.0v 1389.505n 0.0v 1399.495n 0.0v 1399.505n 1.7v 1409.495n 1.7v 1409.505n 1.7v 1419.495n 1.7v 1419.505n 1.7v 1429.495n 1.7v 1429.505n 1.7v 1439.495n 1.7v 1439.505n 1.7v 1449.495n 1.7v 1449.505n 1.7v 1459.495n 1.7v 1459.505n 1.7v 1469.495n 1.7v 1469.505n 1.7v 1479.495n 1.7v 1479.505n 0.0v 1489.495n 0.0v 1489.505n 0.0v 1499.495n 0.0v 1499.505n 0.0v 1509.495n 0.0v 1509.505n 1.7v 1519.495n 1.7v 1519.505n 1.7v 1529.495n 1.7v 1529.505n 1.7v 1539.495n 1.7v 1539.505n 1.7v 1549.495n 1.7v 1549.505n 1.7v 1559.495n 1.7v 1559.505n 1.7v 1569.495n 1.7v 1569.505n 1.7v 1579.495n 1.7v 1579.505n 0.0v 1589.495n 0.0v 1589.505n 0.0v 1599.495n 0.0v 1599.505n 0.0v 1609.495n 0.0v 1609.505n 0.0v 1619.495n 0.0v 1619.505n 0.0v 1629.495n 0.0v 1629.505n 0.0v 1639.495n 0.0v 1639.505n 0.0v 1649.495n 0.0v 1649.505n 1.7v 1659.495n 1.7v 1659.505n 0.0v 1669.495n 0.0v 1669.505n 0.0v 1679.495n 0.0v 1679.505n 0.0v 1689.495n 0.0v 1689.505n 0.0v 1699.495n 0.0v 1699.505n 0.0v 1709.495n 0.0v 1709.505n 1.7v 1719.495n 1.7v 1719.505n 1.7v 1729.495n 1.7v 1729.505n 0.0v 1739.495n 0.0v 1739.505n 0.0v 1749.495n 0.0v 1749.505n 0.0v 1759.495n 0.0v 1759.505n 0.0v 1769.495n 0.0v 1769.505n 0.0v 1779.495n 0.0v 1779.505n 1.7v 1789.495n 1.7v 1789.505n 1.7v 1799.495n 1.7v 1799.505n 1.7v 1809.495n 1.7v 1809.505n 1.7v 1819.495n 1.7v 1819.505n 1.7v 1829.495n 1.7v 1829.505n 1.7v 1839.495n 1.7v 1839.505n 0.0v 1849.495n 0.0v 1849.505n 0.0v 1859.495n 0.0v 1859.505n 0.0v 1869.495n 0.0v 1869.505n 0.0v 1879.495n 0.0v 1879.505n 0.0v 1889.495n 0.0v 1889.505n 0.0v 1899.495n 0.0v 1899.505n 0.0v 1909.495n 0.0v 1909.505n 0.0v 1919.495n 0.0v 1919.505n 1.7v 1929.495n 1.7v 1929.505n 1.7v 1939.495n 1.7v 1939.505n 1.7v 1949.495n 1.7v 1949.505n 1.7v 1959.495n 1.7v 1959.505n 1.7v 1969.495n 1.7v 1969.505n 0.0v 1979.495n 0.0v 1979.505n 0.0v 1989.495n 0.0v 1989.505n 0.0v 1999.495n 0.0v 1999.505n 1.7v 2009.495n 1.7v 2009.505n 1.7v 2019.495n 1.7v 2019.505n 1.7v 2029.495n 1.7v 2029.505n 1.7v 2039.495n 1.7v 2039.505n 1.7v 2049.495n 1.7v 2049.505n 1.7v )
* (time, data): [(0, 0), (10, 0), (20, 0), (30, 0), (40, 0), (50, 0), (60, 1), (70, 1), (80, 1), (90, 0), (100, 1), (110, 0), (120, 0), (130, 0), (140, 0), (150, 1), (160, 1), (170, 1), (180, 1), (190, 0), (200, 1), (210, 1), (220, 1), (230, 1), (240, 1), (250, 1), (260, 1), (270, 1), (280, 1), (290, 1), (300, 1), (310, 0), (320, 0), (330, 1), (340, 1), (350, 1), (360, 1), (370, 1), (380, 1), (390, 1), (400, 1), (410, 1), (420, 0), (430, 0), (440, 0), (450, 0), (460, 1), (470, 0), (480, 0), (490, 0), (500, 1), (510, 0), (520, 1), (530, 1), (540, 1), (550, 0), (560, 1), (570, 1), (580, 1), (590, 1), (600, 0), (610, 0), (620, 0), (630, 1), (640, 1), (650, 1), (660, 1), (670, 0), (680, 1), (690, 1), (700, 0), (710, 0), (720, 0), (730, 0), (740, 0), (750, 0), (760, 0), (770, 0), (780, 0), (790, 1), (800, 0), (810, 0), (820, 0), (830, 1), (840, 0), (850, 0), (860, 1), (870, 0), (880, 1), (890, 1), (900, 1), (910, 1), (920, 0), (930, 0), (940, 0), (950, 0), (960, 1), (970, 1), (980, 1), (990, 0), (1000, 0), (1010, 1), (1020, 1), (1030, 1), (1040, 1), (1050, 1), (1060, 1), (1070, 0), (1080, 0), (1090, 1), (1100, 1), (1110, 0), (1120, 0), (1130, 0), (1140, 0), (1150, 0), (1160, 0), (1170, 0), (1180, 1), (1190, 1), (1200, 1), (1210, 1), (1220, 1), (1230, 0), (1240, 0), (1250, 1), (1260, 1), (1270, 1), (1280, 1), (1290, 0), (1300, 1), (1310, 1), (1320, 1), (1330, 1), (1340, 1), (1350, 1), (1360, 0), (1370, 1), (1380, 1), (1390, 1), (1400, 1), (1410, 1), (1420, 1), (1430, 1), (1440, 1), (1450, 1), (1460, 1), (1470, 1), (1480, 1), (1490, 1), (1500, 1), (1510, 1), (1520, 1), (1530, 1), (1540, 0), (1550, 0), (1560, 0), (1570, 0), (1580, 0), (1590, 0), (1600, 0), (1610, 0), (1620, 1), (1630, 0), (1640, 0), (1650, 1), (1660, 0), (1670, 0), (1680, 0), (1690, 0), (1700, 0), (1710, 0), (1720, 0), (1730, 0), (1740, 0), (1750, 1), (1760, 1), (1770, 0), (1780, 0), (1790, 0), (1800, 1), (1810, 1), (1820, 1), (1830, 1), (1840, 0), (1850, 0), (1860, 0), (1870, 0), (1880, 0), (1890, 0), (1900, 0), (1910, 1), (1920, 0), (1930, 1), (1940, 0), (1950, 0), (1960, 0), (1970, 1), (1980, 0), (1990, 0), (2000, 1), (2010, 0), (2020, 0), (2030, 0), (2040, 0), (2050, 0)]
Vdin0_1  din0_1  0 PWL (0n 0.0v 9.495n 0.0v 9.505n 0.0v 19.495n 0.0v 19.505n 0.0v 29.495n 0.0v 29.505n 0.0v 39.495n 0.0v 39.505n 0.0v 49.495n 0.0v 49.505n 0.0v 59.495n 0.0v 59.505n 1.7v 69.495n 1.7v 69.505n 1.7v 79.495n 1.7v 79.505n 1.7v 89.495n 1.7v 89.505n 0.0v 99.495n 0.0v 99.505n 1.7v 109.495n 1.7v 109.505n 0.0v 119.495n 0.0v 119.505n 0.0v 129.495n 0.0v 129.505n 0.0v 139.495n 0.0v 139.505n 0.0v 149.495n 0.0v 149.505n 1.7v 159.495n 1.7v 159.505n 1.7v 169.495n 1.7v 169.505n 1.7v 179.495n 1.7v 179.505n 1.7v 189.495n 1.7v 189.505n 0.0v 199.495n 0.0v 199.505n 1.7v 209.495n 1.7v 209.505n 1.7v 219.495n 1.7v 219.505n 1.7v 229.495n 1.7v 229.505n 1.7v 239.495n 1.7v 239.505n 1.7v 249.495n 1.7v 249.505n 1.7v 259.495n 1.7v 259.505n 1.7v 269.495n 1.7v 269.505n 1.7v 279.495n 1.7v 279.505n 1.7v 289.495n 1.7v 289.505n 1.7v 299.495n 1.7v 299.505n 1.7v 309.495n 1.7v 309.505n 0.0v 319.495n 0.0v 319.505n 0.0v 329.495n 0.0v 329.505n 1.7v 339.495n 1.7v 339.505n 1.7v 349.495n 1.7v 349.505n 1.7v 359.495n 1.7v 359.505n 1.7v 369.495n 1.7v 369.505n 1.7v 379.495n 1.7v 379.505n 1.7v 389.495n 1.7v 389.505n 1.7v 399.495n 1.7v 399.505n 1.7v 409.495n 1.7v 409.505n 1.7v 419.495n 1.7v 419.505n 0.0v 429.495n 0.0v 429.505n 0.0v 439.495n 0.0v 439.505n 0.0v 449.495n 0.0v 449.505n 0.0v 459.495n 0.0v 459.505n 1.7v 469.495n 1.7v 469.505n 0.0v 479.495n 0.0v 479.505n 0.0v 489.495n 0.0v 489.505n 0.0v 499.495n 0.0v 499.505n 1.7v 509.495n 1.7v 509.505n 0.0v 519.495n 0.0v 519.505n 1.7v 529.495n 1.7v 529.505n 1.7v 539.495n 1.7v 539.505n 1.7v 549.495n 1.7v 549.505n 0.0v 559.495n 0.0v 559.505n 1.7v 569.495n 1.7v 569.505n 1.7v 579.495n 1.7v 579.505n 1.7v 589.495n 1.7v 589.505n 1.7v 599.495n 1.7v 599.505n 0.0v 609.495n 0.0v 609.505n 0.0v 619.495n 0.0v 619.505n 0.0v 629.495n 0.0v 629.505n 1.7v 639.495n 1.7v 639.505n 1.7v 649.495n 1.7v 649.505n 1.7v 659.495n 1.7v 659.505n 1.7v 669.495n 1.7v 669.505n 0.0v 679.495n 0.0v 679.505n 1.7v 689.495n 1.7v 689.505n 1.7v 699.495n 1.7v 699.505n 0.0v 709.495n 0.0v 709.505n 0.0v 719.495n 0.0v 719.505n 0.0v 729.495n 0.0v 729.505n 0.0v 739.495n 0.0v 739.505n 0.0v 749.495n 0.0v 749.505n 0.0v 759.495n 0.0v 759.505n 0.0v 769.495n 0.0v 769.505n 0.0v 779.495n 0.0v 779.505n 0.0v 789.495n 0.0v 789.505n 1.7v 799.495n 1.7v 799.505n 0.0v 809.495n 0.0v 809.505n 0.0v 819.495n 0.0v 819.505n 0.0v 829.495n 0.0v 829.505n 1.7v 839.495n 1.7v 839.505n 0.0v 849.495n 0.0v 849.505n 0.0v 859.495n 0.0v 859.505n 1.7v 869.495n 1.7v 869.505n 0.0v 879.495n 0.0v 879.505n 1.7v 889.495n 1.7v 889.505n 1.7v 899.495n 1.7v 899.505n 1.7v 909.495n 1.7v 909.505n 1.7v 919.495n 1.7v 919.505n 0.0v 929.495n 0.0v 929.505n 0.0v 939.495n 0.0v 939.505n 0.0v 949.495n 0.0v 949.505n 0.0v 959.495n 0.0v 959.505n 1.7v 969.495n 1.7v 969.505n 1.7v 979.495n 1.7v 979.505n 1.7v 989.495n 1.7v 989.505n 0.0v 999.495n 0.0v 999.505n 0.0v 1009.495n 0.0v 1009.505n 1.7v 1019.495n 1.7v 1019.505n 1.7v 1029.495n 1.7v 1029.505n 1.7v 1039.495n 1.7v 1039.505n 1.7v 1049.495n 1.7v 1049.505n 1.7v 1059.495n 1.7v 1059.505n 1.7v 1069.495n 1.7v 1069.505n 0.0v 1079.495n 0.0v 1079.505n 0.0v 1089.495n 0.0v 1089.505n 1.7v 1099.495n 1.7v 1099.505n 1.7v 1109.495n 1.7v 1109.505n 0.0v 1119.495n 0.0v 1119.505n 0.0v 1129.495n 0.0v 1129.505n 0.0v 1139.495n 0.0v 1139.505n 0.0v 1149.495n 0.0v 1149.505n 0.0v 1159.495n 0.0v 1159.505n 0.0v 1169.495n 0.0v 1169.505n 0.0v 1179.495n 0.0v 1179.505n 1.7v 1189.495n 1.7v 1189.505n 1.7v 1199.495n 1.7v 1199.505n 1.7v 1209.495n 1.7v 1209.505n 1.7v 1219.495n 1.7v 1219.505n 1.7v 1229.495n 1.7v 1229.505n 0.0v 1239.495n 0.0v 1239.505n 0.0v 1249.495n 0.0v 1249.505n 1.7v 1259.495n 1.7v 1259.505n 1.7v 1269.495n 1.7v 1269.505n 1.7v 1279.495n 1.7v 1279.505n 1.7v 1289.495n 1.7v 1289.505n 0.0v 1299.495n 0.0v 1299.505n 1.7v 1309.495n 1.7v 1309.505n 1.7v 1319.495n 1.7v 1319.505n 1.7v 1329.495n 1.7v 1329.505n 1.7v 1339.495n 1.7v 1339.505n 1.7v 1349.495n 1.7v 1349.505n 1.7v 1359.495n 1.7v 1359.505n 0.0v 1369.495n 0.0v 1369.505n 1.7v 1379.495n 1.7v 1379.505n 1.7v 1389.495n 1.7v 1389.505n 1.7v 1399.495n 1.7v 1399.505n 1.7v 1409.495n 1.7v 1409.505n 1.7v 1419.495n 1.7v 1419.505n 1.7v 1429.495n 1.7v 1429.505n 1.7v 1439.495n 1.7v 1439.505n 1.7v 1449.495n 1.7v 1449.505n 1.7v 1459.495n 1.7v 1459.505n 1.7v 1469.495n 1.7v 1469.505n 1.7v 1479.495n 1.7v 1479.505n 1.7v 1489.495n 1.7v 1489.505n 1.7v 1499.495n 1.7v 1499.505n 1.7v 1509.495n 1.7v 1509.505n 1.7v 1519.495n 1.7v 1519.505n 1.7v 1529.495n 1.7v 1529.505n 1.7v 1539.495n 1.7v 1539.505n 0.0v 1549.495n 0.0v 1549.505n 0.0v 1559.495n 0.0v 1559.505n 0.0v 1569.495n 0.0v 1569.505n 0.0v 1579.495n 0.0v 1579.505n 0.0v 1589.495n 0.0v 1589.505n 0.0v 1599.495n 0.0v 1599.505n 0.0v 1609.495n 0.0v 1609.505n 0.0v 1619.495n 0.0v 1619.505n 1.7v 1629.495n 1.7v 1629.505n 0.0v 1639.495n 0.0v 1639.505n 0.0v 1649.495n 0.0v 1649.505n 1.7v 1659.495n 1.7v 1659.505n 0.0v 1669.495n 0.0v 1669.505n 0.0v 1679.495n 0.0v 1679.505n 0.0v 1689.495n 0.0v 1689.505n 0.0v 1699.495n 0.0v 1699.505n 0.0v 1709.495n 0.0v 1709.505n 0.0v 1719.495n 0.0v 1719.505n 0.0v 1729.495n 0.0v 1729.505n 0.0v 1739.495n 0.0v 1739.505n 0.0v 1749.495n 0.0v 1749.505n 1.7v 1759.495n 1.7v 1759.505n 1.7v 1769.495n 1.7v 1769.505n 0.0v 1779.495n 0.0v 1779.505n 0.0v 1789.495n 0.0v 1789.505n 0.0v 1799.495n 0.0v 1799.505n 1.7v 1809.495n 1.7v 1809.505n 1.7v 1819.495n 1.7v 1819.505n 1.7v 1829.495n 1.7v 1829.505n 1.7v 1839.495n 1.7v 1839.505n 0.0v 1849.495n 0.0v 1849.505n 0.0v 1859.495n 0.0v 1859.505n 0.0v 1869.495n 0.0v 1869.505n 0.0v 1879.495n 0.0v 1879.505n 0.0v 1889.495n 0.0v 1889.505n 0.0v 1899.495n 0.0v 1899.505n 0.0v 1909.495n 0.0v 1909.505n 1.7v 1919.495n 1.7v 1919.505n 0.0v 1929.495n 0.0v 1929.505n 1.7v 1939.495n 1.7v 1939.505n 0.0v 1949.495n 0.0v 1949.505n 0.0v 1959.495n 0.0v 1959.505n 0.0v 1969.495n 0.0v 1969.505n 1.7v 1979.495n 1.7v 1979.505n 0.0v 1989.495n 0.0v 1989.505n 0.0v 1999.495n 0.0v 1999.505n 1.7v 2009.495n 1.7v 2009.505n 0.0v 2019.495n 0.0v 2019.505n 0.0v 2029.495n 0.0v 2029.505n 0.0v 2039.495n 0.0v 2039.505n 0.0v 2049.495n 0.0v 2049.505n 0.0v )
* (time, data): [(0, 0), (10, 1), (20, 1), (30, 0), (40, 0), (50, 0), (60, 1), (70, 1), (80, 1), (90, 1), (100, 0), (110, 0), (120, 0), (130, 0), (140, 0), (150, 1), (160, 1), (170, 1), (180, 1), (190, 1), (200, 1), (210, 1), (220, 1), (230, 1), (240, 1), (250, 1), (260, 1), (270, 1), (280, 1), (290, 1), (300, 1), (310, 0), (320, 1), (330, 1), (340, 1), (350, 1), (360, 1), (370, 1), (380, 1), (390, 1), (400, 1), (410, 1), (420, 1), (430, 1), (440, 1), (450, 1), (460, 0), (470, 0), (480, 0), (490, 0), (500, 1), (510, 0), (520, 0), (530, 0), (540, 0), (550, 1), (560, 0), (570, 0), (580, 0), (590, 0), (600, 0), (610, 0), (620, 1), (630, 1), (640, 1), (650, 1), (660, 1), (670, 1), (680, 1), (690, 1), (700, 1), (710, 1), (720, 1), (730, 1), (740, 1), (750, 1), (760, 1), (770, 0), (780, 0), (790, 1), (800, 1), (810, 1), (820, 1), (830, 0), (840, 1), (850, 1), (860, 1), (870, 1), (880, 1), (890, 1), (900, 1), (910, 1), (920, 0), (930, 0), (940, 0), (950, 0), (960, 1), (970, 0), (980, 1), (990, 1), (1000, 1), (1010, 0), (1020, 0), (1030, 0), (1040, 0), (1050, 0), (1060, 0), (1070, 1), (1080, 1), (1090, 0), (1100, 1), (1110, 1), (1120, 1), (1130, 1), (1140, 1), (1150, 0), (1160, 0), (1170, 1), (1180, 1), (1190, 1), (1200, 1), (1210, 1), (1220, 0), (1230, 0), (1240, 1), (1250, 0), (1260, 0), (1270, 0), (1280, 0), (1290, 0), (1300, 0), (1310, 0), (1320, 0), (1330, 0), (1340, 0), (1350, 0), (1360, 0), (1370, 0), (1380, 0), (1390, 0), (1400, 1), (1410, 1), (1420, 1), (1430, 1), (1440, 1), (1450, 1), (1460, 1), (1470, 1), (1480, 0), (1490, 0), (1500, 1), (1510, 0), (1520, 0), (1530, 0), (1540, 1), (1550, 0), (1560, 0), (1570, 0), (1580, 1), (1590, 1), (1600, 1), (1610, 1), (1620, 1), (1630, 1), (1640, 1), (1650, 1), (1660, 1), (1670, 1), (1680, 1), (1690, 1), (1700, 1), (1710, 0), (1720, 0), (1730, 0), (1740, 0), (1750, 1), (1760, 1), (1770, 0), (1780, 1), (1790, 1), (1800, 1), (1810, 1), (1820, 1), (1830, 1), (1840, 0), (1850, 0), (1860, 1), (1870, 1), (1880, 1), (1890, 1), (1900, 1), (1910, 0), (1920, 1), (1930, 1), (1940, 0), (1950, 1), (1960, 1), (1970, 0), (1980, 1), (1990, 1), (2000, 1), (2010, 0), (2020, 1), (2030, 1), (2040, 1), (2050, 1)]
Vdin0_2  din0_2  0 PWL (0n 0.0v 9.495n 0.0v 9.505n 1.7v 19.495n 1.7v 19.505n 1.7v 29.495n 1.7v 29.505n 0.0v 39.495n 0.0v 39.505n 0.0v 49.495n 0.0v 49.505n 0.0v 59.495n 0.0v 59.505n 1.7v 69.495n 1.7v 69.505n 1.7v 79.495n 1.7v 79.505n 1.7v 89.495n 1.7v 89.505n 1.7v 99.495n 1.7v 99.505n 0.0v 109.495n 0.0v 109.505n 0.0v 119.495n 0.0v 119.505n 0.0v 129.495n 0.0v 129.505n 0.0v 139.495n 0.0v 139.505n 0.0v 149.495n 0.0v 149.505n 1.7v 159.495n 1.7v 159.505n 1.7v 169.495n 1.7v 169.505n 1.7v 179.495n 1.7v 179.505n 1.7v 189.495n 1.7v 189.505n 1.7v 199.495n 1.7v 199.505n 1.7v 209.495n 1.7v 209.505n 1.7v 219.495n 1.7v 219.505n 1.7v 229.495n 1.7v 229.505n 1.7v 239.495n 1.7v 239.505n 1.7v 249.495n 1.7v 249.505n 1.7v 259.495n 1.7v 259.505n 1.7v 269.495n 1.7v 269.505n 1.7v 279.495n 1.7v 279.505n 1.7v 289.495n 1.7v 289.505n 1.7v 299.495n 1.7v 299.505n 1.7v 309.495n 1.7v 309.505n 0.0v 319.495n 0.0v 319.505n 1.7v 329.495n 1.7v 329.505n 1.7v 339.495n 1.7v 339.505n 1.7v 349.495n 1.7v 349.505n 1.7v 359.495n 1.7v 359.505n 1.7v 369.495n 1.7v 369.505n 1.7v 379.495n 1.7v 379.505n 1.7v 389.495n 1.7v 389.505n 1.7v 399.495n 1.7v 399.505n 1.7v 409.495n 1.7v 409.505n 1.7v 419.495n 1.7v 419.505n 1.7v 429.495n 1.7v 429.505n 1.7v 439.495n 1.7v 439.505n 1.7v 449.495n 1.7v 449.505n 1.7v 459.495n 1.7v 459.505n 0.0v 469.495n 0.0v 469.505n 0.0v 479.495n 0.0v 479.505n 0.0v 489.495n 0.0v 489.505n 0.0v 499.495n 0.0v 499.505n 1.7v 509.495n 1.7v 509.505n 0.0v 519.495n 0.0v 519.505n 0.0v 529.495n 0.0v 529.505n 0.0v 539.495n 0.0v 539.505n 0.0v 549.495n 0.0v 549.505n 1.7v 559.495n 1.7v 559.505n 0.0v 569.495n 0.0v 569.505n 0.0v 579.495n 0.0v 579.505n 0.0v 589.495n 0.0v 589.505n 0.0v 599.495n 0.0v 599.505n 0.0v 609.495n 0.0v 609.505n 0.0v 619.495n 0.0v 619.505n 1.7v 629.495n 1.7v 629.505n 1.7v 639.495n 1.7v 639.505n 1.7v 649.495n 1.7v 649.505n 1.7v 659.495n 1.7v 659.505n 1.7v 669.495n 1.7v 669.505n 1.7v 679.495n 1.7v 679.505n 1.7v 689.495n 1.7v 689.505n 1.7v 699.495n 1.7v 699.505n 1.7v 709.495n 1.7v 709.505n 1.7v 719.495n 1.7v 719.505n 1.7v 729.495n 1.7v 729.505n 1.7v 739.495n 1.7v 739.505n 1.7v 749.495n 1.7v 749.505n 1.7v 759.495n 1.7v 759.505n 1.7v 769.495n 1.7v 769.505n 0.0v 779.495n 0.0v 779.505n 0.0v 789.495n 0.0v 789.505n 1.7v 799.495n 1.7v 799.505n 1.7v 809.495n 1.7v 809.505n 1.7v 819.495n 1.7v 819.505n 1.7v 829.495n 1.7v 829.505n 0.0v 839.495n 0.0v 839.505n 1.7v 849.495n 1.7v 849.505n 1.7v 859.495n 1.7v 859.505n 1.7v 869.495n 1.7v 869.505n 1.7v 879.495n 1.7v 879.505n 1.7v 889.495n 1.7v 889.505n 1.7v 899.495n 1.7v 899.505n 1.7v 909.495n 1.7v 909.505n 1.7v 919.495n 1.7v 919.505n 0.0v 929.495n 0.0v 929.505n 0.0v 939.495n 0.0v 939.505n 0.0v 949.495n 0.0v 949.505n 0.0v 959.495n 0.0v 959.505n 1.7v 969.495n 1.7v 969.505n 0.0v 979.495n 0.0v 979.505n 1.7v 989.495n 1.7v 989.505n 1.7v 999.495n 1.7v 999.505n 1.7v 1009.495n 1.7v 1009.505n 0.0v 1019.495n 0.0v 1019.505n 0.0v 1029.495n 0.0v 1029.505n 0.0v 1039.495n 0.0v 1039.505n 0.0v 1049.495n 0.0v 1049.505n 0.0v 1059.495n 0.0v 1059.505n 0.0v 1069.495n 0.0v 1069.505n 1.7v 1079.495n 1.7v 1079.505n 1.7v 1089.495n 1.7v 1089.505n 0.0v 1099.495n 0.0v 1099.505n 1.7v 1109.495n 1.7v 1109.505n 1.7v 1119.495n 1.7v 1119.505n 1.7v 1129.495n 1.7v 1129.505n 1.7v 1139.495n 1.7v 1139.505n 1.7v 1149.495n 1.7v 1149.505n 0.0v 1159.495n 0.0v 1159.505n 0.0v 1169.495n 0.0v 1169.505n 1.7v 1179.495n 1.7v 1179.505n 1.7v 1189.495n 1.7v 1189.505n 1.7v 1199.495n 1.7v 1199.505n 1.7v 1209.495n 1.7v 1209.505n 1.7v 1219.495n 1.7v 1219.505n 0.0v 1229.495n 0.0v 1229.505n 0.0v 1239.495n 0.0v 1239.505n 1.7v 1249.495n 1.7v 1249.505n 0.0v 1259.495n 0.0v 1259.505n 0.0v 1269.495n 0.0v 1269.505n 0.0v 1279.495n 0.0v 1279.505n 0.0v 1289.495n 0.0v 1289.505n 0.0v 1299.495n 0.0v 1299.505n 0.0v 1309.495n 0.0v 1309.505n 0.0v 1319.495n 0.0v 1319.505n 0.0v 1329.495n 0.0v 1329.505n 0.0v 1339.495n 0.0v 1339.505n 0.0v 1349.495n 0.0v 1349.505n 0.0v 1359.495n 0.0v 1359.505n 0.0v 1369.495n 0.0v 1369.505n 0.0v 1379.495n 0.0v 1379.505n 0.0v 1389.495n 0.0v 1389.505n 0.0v 1399.495n 0.0v 1399.505n 1.7v 1409.495n 1.7v 1409.505n 1.7v 1419.495n 1.7v 1419.505n 1.7v 1429.495n 1.7v 1429.505n 1.7v 1439.495n 1.7v 1439.505n 1.7v 1449.495n 1.7v 1449.505n 1.7v 1459.495n 1.7v 1459.505n 1.7v 1469.495n 1.7v 1469.505n 1.7v 1479.495n 1.7v 1479.505n 0.0v 1489.495n 0.0v 1489.505n 0.0v 1499.495n 0.0v 1499.505n 1.7v 1509.495n 1.7v 1509.505n 0.0v 1519.495n 0.0v 1519.505n 0.0v 1529.495n 0.0v 1529.505n 0.0v 1539.495n 0.0v 1539.505n 1.7v 1549.495n 1.7v 1549.505n 0.0v 1559.495n 0.0v 1559.505n 0.0v 1569.495n 0.0v 1569.505n 0.0v 1579.495n 0.0v 1579.505n 1.7v 1589.495n 1.7v 1589.505n 1.7v 1599.495n 1.7v 1599.505n 1.7v 1609.495n 1.7v 1609.505n 1.7v 1619.495n 1.7v 1619.505n 1.7v 1629.495n 1.7v 1629.505n 1.7v 1639.495n 1.7v 1639.505n 1.7v 1649.495n 1.7v 1649.505n 1.7v 1659.495n 1.7v 1659.505n 1.7v 1669.495n 1.7v 1669.505n 1.7v 1679.495n 1.7v 1679.505n 1.7v 1689.495n 1.7v 1689.505n 1.7v 1699.495n 1.7v 1699.505n 1.7v 1709.495n 1.7v 1709.505n 0.0v 1719.495n 0.0v 1719.505n 0.0v 1729.495n 0.0v 1729.505n 0.0v 1739.495n 0.0v 1739.505n 0.0v 1749.495n 0.0v 1749.505n 1.7v 1759.495n 1.7v 1759.505n 1.7v 1769.495n 1.7v 1769.505n 0.0v 1779.495n 0.0v 1779.505n 1.7v 1789.495n 1.7v 1789.505n 1.7v 1799.495n 1.7v 1799.505n 1.7v 1809.495n 1.7v 1809.505n 1.7v 1819.495n 1.7v 1819.505n 1.7v 1829.495n 1.7v 1829.505n 1.7v 1839.495n 1.7v 1839.505n 0.0v 1849.495n 0.0v 1849.505n 0.0v 1859.495n 0.0v 1859.505n 1.7v 1869.495n 1.7v 1869.505n 1.7v 1879.495n 1.7v 1879.505n 1.7v 1889.495n 1.7v 1889.505n 1.7v 1899.495n 1.7v 1899.505n 1.7v 1909.495n 1.7v 1909.505n 0.0v 1919.495n 0.0v 1919.505n 1.7v 1929.495n 1.7v 1929.505n 1.7v 1939.495n 1.7v 1939.505n 0.0v 1949.495n 0.0v 1949.505n 1.7v 1959.495n 1.7v 1959.505n 1.7v 1969.495n 1.7v 1969.505n 0.0v 1979.495n 0.0v 1979.505n 1.7v 1989.495n 1.7v 1989.505n 1.7v 1999.495n 1.7v 1999.505n 1.7v 2009.495n 1.7v 2009.505n 0.0v 2019.495n 0.0v 2019.505n 1.7v 2029.495n 1.7v 2029.505n 1.7v 2039.495n 1.7v 2039.505n 1.7v 2049.495n 1.7v 2049.505n 1.7v )
* (time, data): [(0, 0), (10, 1), (20, 0), (30, 1), (40, 1), (50, 1), (60, 0), (70, 0), (80, 0), (90, 1), (100, 0), (110, 1), (120, 1), (130, 1), (140, 1), (150, 1), (160, 1), (170, 1), (180, 1), (190, 0), (200, 1), (210, 1), (220, 1), (230, 1), (240, 1), (250, 1), (260, 1), (270, 1), (280, 1), (290, 1), (300, 1), (310, 0), (320, 0), (330, 1), (340, 1), (350, 1), (360, 1), (370, 1), (380, 1), (390, 1), (400, 1), (410, 1), (420, 0), (430, 0), (440, 1), (450, 1), (460, 0), (470, 0), (480, 0), (490, 0), (500, 1), (510, 0), (520, 0), (530, 0), (540, 0), (550, 1), (560, 0), (570, 0), (580, 0), (590, 0), (600, 1), (610, 1), (620, 0), (630, 1), (640, 1), (650, 0), (660, 0), (670, 0), (680, 0), (690, 0), (700, 0), (710, 1), (720, 1), (730, 1), (740, 0), (750, 0), (760, 0), (770, 1), (780, 0), (790, 0), (800, 0), (810, 0), (820, 0), (830, 0), (840, 0), (850, 0), (860, 0), (870, 0), (880, 1), (890, 1), (900, 0), (910, 0), (920, 0), (930, 0), (940, 0), (950, 0), (960, 1), (970, 1), (980, 0), (990, 0), (1000, 1), (1010, 1), (1020, 0), (1030, 1), (1040, 1), (1050, 1), (1060, 1), (1070, 0), (1080, 0), (1090, 0), (1100, 0), (1110, 0), (1120, 0), (1130, 0), (1140, 1), (1150, 1), (1160, 1), (1170, 1), (1180, 1), (1190, 1), (1200, 1), (1210, 1), (1220, 1), (1230, 1), (1240, 0), (1250, 0), (1260, 0), (1270, 0), (1280, 0), (1290, 1), (1300, 1), (1310, 1), (1320, 1), (1330, 1), (1340, 0), (1350, 0), (1360, 1), (1370, 1), (1380, 1), (1390, 1), (1400, 0), (1410, 0), (1420, 0), (1430, 0), (1440, 0), (1450, 0), (1460, 0), (1470, 0), (1480, 0), (1490, 0), (1500, 1), (1510, 1), (1520, 1), (1530, 1), (1540, 1), (1550, 0), (1560, 0), (1570, 0), (1580, 1), (1590, 1), (1600, 1), (1610, 1), (1620, 1), (1630, 1), (1640, 1), (1650, 1), (1660, 0), (1670, 0), (1680, 0), (1690, 0), (1700, 0), (1710, 0), (1720, 0), (1730, 0), (1740, 0), (1750, 1), (1760, 1), (1770, 1), (1780, 1), (1790, 1), (1800, 1), (1810, 1), (1820, 1), (1830, 1), (1840, 0), (1850, 0), (1860, 1), (1870, 1), (1880, 1), (1890, 1), (1900, 1), (1910, 0), (1920, 0), (1930, 0), (1940, 1), (1950, 0), (1960, 0), (1970, 1), (1980, 0), (1990, 0), (2000, 0), (2010, 1), (2020, 1), (2030, 1), (2040, 1), (2050, 1)]
Vdin0_3  din0_3  0 PWL (0n 0.0v 9.495n 0.0v 9.505n 1.7v 19.495n 1.7v 19.505n 0.0v 29.495n 0.0v 29.505n 1.7v 39.495n 1.7v 39.505n 1.7v 49.495n 1.7v 49.505n 1.7v 59.495n 1.7v 59.505n 0.0v 69.495n 0.0v 69.505n 0.0v 79.495n 0.0v 79.505n 0.0v 89.495n 0.0v 89.505n 1.7v 99.495n 1.7v 99.505n 0.0v 109.495n 0.0v 109.505n 1.7v 119.495n 1.7v 119.505n 1.7v 129.495n 1.7v 129.505n 1.7v 139.495n 1.7v 139.505n 1.7v 149.495n 1.7v 149.505n 1.7v 159.495n 1.7v 159.505n 1.7v 169.495n 1.7v 169.505n 1.7v 179.495n 1.7v 179.505n 1.7v 189.495n 1.7v 189.505n 0.0v 199.495n 0.0v 199.505n 1.7v 209.495n 1.7v 209.505n 1.7v 219.495n 1.7v 219.505n 1.7v 229.495n 1.7v 229.505n 1.7v 239.495n 1.7v 239.505n 1.7v 249.495n 1.7v 249.505n 1.7v 259.495n 1.7v 259.505n 1.7v 269.495n 1.7v 269.505n 1.7v 279.495n 1.7v 279.505n 1.7v 289.495n 1.7v 289.505n 1.7v 299.495n 1.7v 299.505n 1.7v 309.495n 1.7v 309.505n 0.0v 319.495n 0.0v 319.505n 0.0v 329.495n 0.0v 329.505n 1.7v 339.495n 1.7v 339.505n 1.7v 349.495n 1.7v 349.505n 1.7v 359.495n 1.7v 359.505n 1.7v 369.495n 1.7v 369.505n 1.7v 379.495n 1.7v 379.505n 1.7v 389.495n 1.7v 389.505n 1.7v 399.495n 1.7v 399.505n 1.7v 409.495n 1.7v 409.505n 1.7v 419.495n 1.7v 419.505n 0.0v 429.495n 0.0v 429.505n 0.0v 439.495n 0.0v 439.505n 1.7v 449.495n 1.7v 449.505n 1.7v 459.495n 1.7v 459.505n 0.0v 469.495n 0.0v 469.505n 0.0v 479.495n 0.0v 479.505n 0.0v 489.495n 0.0v 489.505n 0.0v 499.495n 0.0v 499.505n 1.7v 509.495n 1.7v 509.505n 0.0v 519.495n 0.0v 519.505n 0.0v 529.495n 0.0v 529.505n 0.0v 539.495n 0.0v 539.505n 0.0v 549.495n 0.0v 549.505n 1.7v 559.495n 1.7v 559.505n 0.0v 569.495n 0.0v 569.505n 0.0v 579.495n 0.0v 579.505n 0.0v 589.495n 0.0v 589.505n 0.0v 599.495n 0.0v 599.505n 1.7v 609.495n 1.7v 609.505n 1.7v 619.495n 1.7v 619.505n 0.0v 629.495n 0.0v 629.505n 1.7v 639.495n 1.7v 639.505n 1.7v 649.495n 1.7v 649.505n 0.0v 659.495n 0.0v 659.505n 0.0v 669.495n 0.0v 669.505n 0.0v 679.495n 0.0v 679.505n 0.0v 689.495n 0.0v 689.505n 0.0v 699.495n 0.0v 699.505n 0.0v 709.495n 0.0v 709.505n 1.7v 719.495n 1.7v 719.505n 1.7v 729.495n 1.7v 729.505n 1.7v 739.495n 1.7v 739.505n 0.0v 749.495n 0.0v 749.505n 0.0v 759.495n 0.0v 759.505n 0.0v 769.495n 0.0v 769.505n 1.7v 779.495n 1.7v 779.505n 0.0v 789.495n 0.0v 789.505n 0.0v 799.495n 0.0v 799.505n 0.0v 809.495n 0.0v 809.505n 0.0v 819.495n 0.0v 819.505n 0.0v 829.495n 0.0v 829.505n 0.0v 839.495n 0.0v 839.505n 0.0v 849.495n 0.0v 849.505n 0.0v 859.495n 0.0v 859.505n 0.0v 869.495n 0.0v 869.505n 0.0v 879.495n 0.0v 879.505n 1.7v 889.495n 1.7v 889.505n 1.7v 899.495n 1.7v 899.505n 0.0v 909.495n 0.0v 909.505n 0.0v 919.495n 0.0v 919.505n 0.0v 929.495n 0.0v 929.505n 0.0v 939.495n 0.0v 939.505n 0.0v 949.495n 0.0v 949.505n 0.0v 959.495n 0.0v 959.505n 1.7v 969.495n 1.7v 969.505n 1.7v 979.495n 1.7v 979.505n 0.0v 989.495n 0.0v 989.505n 0.0v 999.495n 0.0v 999.505n 1.7v 1009.495n 1.7v 1009.505n 1.7v 1019.495n 1.7v 1019.505n 0.0v 1029.495n 0.0v 1029.505n 1.7v 1039.495n 1.7v 1039.505n 1.7v 1049.495n 1.7v 1049.505n 1.7v 1059.495n 1.7v 1059.505n 1.7v 1069.495n 1.7v 1069.505n 0.0v 1079.495n 0.0v 1079.505n 0.0v 1089.495n 0.0v 1089.505n 0.0v 1099.495n 0.0v 1099.505n 0.0v 1109.495n 0.0v 1109.505n 0.0v 1119.495n 0.0v 1119.505n 0.0v 1129.495n 0.0v 1129.505n 0.0v 1139.495n 0.0v 1139.505n 1.7v 1149.495n 1.7v 1149.505n 1.7v 1159.495n 1.7v 1159.505n 1.7v 1169.495n 1.7v 1169.505n 1.7v 1179.495n 1.7v 1179.505n 1.7v 1189.495n 1.7v 1189.505n 1.7v 1199.495n 1.7v 1199.505n 1.7v 1209.495n 1.7v 1209.505n 1.7v 1219.495n 1.7v 1219.505n 1.7v 1229.495n 1.7v 1229.505n 1.7v 1239.495n 1.7v 1239.505n 0.0v 1249.495n 0.0v 1249.505n 0.0v 1259.495n 0.0v 1259.505n 0.0v 1269.495n 0.0v 1269.505n 0.0v 1279.495n 0.0v 1279.505n 0.0v 1289.495n 0.0v 1289.505n 1.7v 1299.495n 1.7v 1299.505n 1.7v 1309.495n 1.7v 1309.505n 1.7v 1319.495n 1.7v 1319.505n 1.7v 1329.495n 1.7v 1329.505n 1.7v 1339.495n 1.7v 1339.505n 0.0v 1349.495n 0.0v 1349.505n 0.0v 1359.495n 0.0v 1359.505n 1.7v 1369.495n 1.7v 1369.505n 1.7v 1379.495n 1.7v 1379.505n 1.7v 1389.495n 1.7v 1389.505n 1.7v 1399.495n 1.7v 1399.505n 0.0v 1409.495n 0.0v 1409.505n 0.0v 1419.495n 0.0v 1419.505n 0.0v 1429.495n 0.0v 1429.505n 0.0v 1439.495n 0.0v 1439.505n 0.0v 1449.495n 0.0v 1449.505n 0.0v 1459.495n 0.0v 1459.505n 0.0v 1469.495n 0.0v 1469.505n 0.0v 1479.495n 0.0v 1479.505n 0.0v 1489.495n 0.0v 1489.505n 0.0v 1499.495n 0.0v 1499.505n 1.7v 1509.495n 1.7v 1509.505n 1.7v 1519.495n 1.7v 1519.505n 1.7v 1529.495n 1.7v 1529.505n 1.7v 1539.495n 1.7v 1539.505n 1.7v 1549.495n 1.7v 1549.505n 0.0v 1559.495n 0.0v 1559.505n 0.0v 1569.495n 0.0v 1569.505n 0.0v 1579.495n 0.0v 1579.505n 1.7v 1589.495n 1.7v 1589.505n 1.7v 1599.495n 1.7v 1599.505n 1.7v 1609.495n 1.7v 1609.505n 1.7v 1619.495n 1.7v 1619.505n 1.7v 1629.495n 1.7v 1629.505n 1.7v 1639.495n 1.7v 1639.505n 1.7v 1649.495n 1.7v 1649.505n 1.7v 1659.495n 1.7v 1659.505n 0.0v 1669.495n 0.0v 1669.505n 0.0v 1679.495n 0.0v 1679.505n 0.0v 1689.495n 0.0v 1689.505n 0.0v 1699.495n 0.0v 1699.505n 0.0v 1709.495n 0.0v 1709.505n 0.0v 1719.495n 0.0v 1719.505n 0.0v 1729.495n 0.0v 1729.505n 0.0v 1739.495n 0.0v 1739.505n 0.0v 1749.495n 0.0v 1749.505n 1.7v 1759.495n 1.7v 1759.505n 1.7v 1769.495n 1.7v 1769.505n 1.7v 1779.495n 1.7v 1779.505n 1.7v 1789.495n 1.7v 1789.505n 1.7v 1799.495n 1.7v 1799.505n 1.7v 1809.495n 1.7v 1809.505n 1.7v 1819.495n 1.7v 1819.505n 1.7v 1829.495n 1.7v 1829.505n 1.7v 1839.495n 1.7v 1839.505n 0.0v 1849.495n 0.0v 1849.505n 0.0v 1859.495n 0.0v 1859.505n 1.7v 1869.495n 1.7v 1869.505n 1.7v 1879.495n 1.7v 1879.505n 1.7v 1889.495n 1.7v 1889.505n 1.7v 1899.495n 1.7v 1899.505n 1.7v 1909.495n 1.7v 1909.505n 0.0v 1919.495n 0.0v 1919.505n 0.0v 1929.495n 0.0v 1929.505n 0.0v 1939.495n 0.0v 1939.505n 1.7v 1949.495n 1.7v 1949.505n 0.0v 1959.495n 0.0v 1959.505n 0.0v 1969.495n 0.0v 1969.505n 1.7v 1979.495n 1.7v 1979.505n 0.0v 1989.495n 0.0v 1989.505n 0.0v 1999.495n 0.0v 1999.505n 0.0v 2009.495n 0.0v 2009.505n 1.7v 2019.495n 1.7v 2019.505n 1.7v 2029.495n 1.7v 2029.505n 1.7v 2039.495n 1.7v 2039.505n 1.7v 2049.495n 1.7v 2049.505n 1.7v )
* (time, data): [(0, 0), (10, 1), (20, 0), (30, 0), (40, 0), (50, 0), (60, 0), (70, 0), (80, 0), (90, 1), (100, 0), (110, 1), (120, 1), (130, 1), (140, 1), (150, 1), (160, 1), (170, 1), (180, 1), (190, 1), (200, 1), (210, 1), (220, 1), (230, 1), (240, 1), (250, 1), (260, 1), (270, 1), (280, 1), (290, 1), (300, 1), (310, 1), (320, 1), (330, 1), (340, 1), (350, 1), (360, 1), (370, 1), (380, 1), (390, 1), (400, 1), (410, 1), (420, 0), (430, 0), (440, 0), (450, 0), (460, 0), (470, 1), (480, 1), (490, 1), (500, 1), (510, 0), (520, 0), (530, 0), (540, 0), (550, 1), (560, 0), (570, 0), (580, 0), (590, 0), (600, 0), (610, 1), (620, 1), (630, 0), (640, 0), (650, 1), (660, 1), (670, 0), (680, 0), (690, 0), (700, 0), (710, 1), (720, 1), (730, 1), (740, 0), (750, 0), (760, 0), (770, 1), (780, 1), (790, 0), (800, 1), (810, 1), (820, 0), (830, 0), (840, 0), (850, 0), (860, 1), (870, 0), (880, 0), (890, 0), (900, 1), (910, 1), (920, 1), (930, 1), (940, 1), (950, 1), (960, 0), (970, 1), (980, 1), (990, 0), (1000, 1), (1010, 1), (1020, 1), (1030, 1), (1040, 1), (1050, 1), (1060, 1), (1070, 0), (1080, 0), (1090, 1), (1100, 1), (1110, 0), (1120, 0), (1130, 1), (1140, 1), (1150, 0), (1160, 0), (1170, 1), (1180, 1), (1190, 1), (1200, 1), (1210, 1), (1220, 1), (1230, 1), (1240, 1), (1250, 1), (1260, 1), (1270, 1), (1280, 1), (1290, 1), (1300, 1), (1310, 1), (1320, 1), (1330, 1), (1340, 1), (1350, 1), (1360, 1), (1370, 1), (1380, 1), (1390, 1), (1400, 0), (1410, 0), (1420, 0), (1430, 0), (1440, 0), (1450, 0), (1460, 0), (1470, 0), (1480, 0), (1490, 0), (1500, 0), (1510, 0), (1520, 0), (1530, 0), (1540, 0), (1550, 0), (1560, 0), (1570, 0), (1580, 0), (1590, 0), (1600, 0), (1610, 0), (1620, 0), (1630, 1), (1640, 1), (1650, 1), (1660, 0), (1670, 0), (1680, 0), (1690, 0), (1700, 0), (1710, 1), (1720, 1), (1730, 0), (1740, 0), (1750, 1), (1760, 1), (1770, 0), (1780, 1), (1790, 1), (1800, 1), (1810, 1), (1820, 1), (1830, 1), (1840, 0), (1850, 0), (1860, 0), (1870, 0), (1880, 0), (1890, 0), (1900, 0), (1910, 1), (1920, 1), (1930, 1), (1940, 0), (1950, 0), (1960, 0), (1970, 1), (1980, 0), (1990, 0), (2000, 1), (2010, 1), (2020, 1), (2030, 1), (2040, 1), (2050, 1)]
Vdin0_4  din0_4  0 PWL (0n 0.0v 9.495n 0.0v 9.505n 1.7v 19.495n 1.7v 19.505n 0.0v 29.495n 0.0v 29.505n 0.0v 39.495n 0.0v 39.505n 0.0v 49.495n 0.0v 49.505n 0.0v 59.495n 0.0v 59.505n 0.0v 69.495n 0.0v 69.505n 0.0v 79.495n 0.0v 79.505n 0.0v 89.495n 0.0v 89.505n 1.7v 99.495n 1.7v 99.505n 0.0v 109.495n 0.0v 109.505n 1.7v 119.495n 1.7v 119.505n 1.7v 129.495n 1.7v 129.505n 1.7v 139.495n 1.7v 139.505n 1.7v 149.495n 1.7v 149.505n 1.7v 159.495n 1.7v 159.505n 1.7v 169.495n 1.7v 169.505n 1.7v 179.495n 1.7v 179.505n 1.7v 189.495n 1.7v 189.505n 1.7v 199.495n 1.7v 199.505n 1.7v 209.495n 1.7v 209.505n 1.7v 219.495n 1.7v 219.505n 1.7v 229.495n 1.7v 229.505n 1.7v 239.495n 1.7v 239.505n 1.7v 249.495n 1.7v 249.505n 1.7v 259.495n 1.7v 259.505n 1.7v 269.495n 1.7v 269.505n 1.7v 279.495n 1.7v 279.505n 1.7v 289.495n 1.7v 289.505n 1.7v 299.495n 1.7v 299.505n 1.7v 309.495n 1.7v 309.505n 1.7v 319.495n 1.7v 319.505n 1.7v 329.495n 1.7v 329.505n 1.7v 339.495n 1.7v 339.505n 1.7v 349.495n 1.7v 349.505n 1.7v 359.495n 1.7v 359.505n 1.7v 369.495n 1.7v 369.505n 1.7v 379.495n 1.7v 379.505n 1.7v 389.495n 1.7v 389.505n 1.7v 399.495n 1.7v 399.505n 1.7v 409.495n 1.7v 409.505n 1.7v 419.495n 1.7v 419.505n 0.0v 429.495n 0.0v 429.505n 0.0v 439.495n 0.0v 439.505n 0.0v 449.495n 0.0v 449.505n 0.0v 459.495n 0.0v 459.505n 0.0v 469.495n 0.0v 469.505n 1.7v 479.495n 1.7v 479.505n 1.7v 489.495n 1.7v 489.505n 1.7v 499.495n 1.7v 499.505n 1.7v 509.495n 1.7v 509.505n 0.0v 519.495n 0.0v 519.505n 0.0v 529.495n 0.0v 529.505n 0.0v 539.495n 0.0v 539.505n 0.0v 549.495n 0.0v 549.505n 1.7v 559.495n 1.7v 559.505n 0.0v 569.495n 0.0v 569.505n 0.0v 579.495n 0.0v 579.505n 0.0v 589.495n 0.0v 589.505n 0.0v 599.495n 0.0v 599.505n 0.0v 609.495n 0.0v 609.505n 1.7v 619.495n 1.7v 619.505n 1.7v 629.495n 1.7v 629.505n 0.0v 639.495n 0.0v 639.505n 0.0v 649.495n 0.0v 649.505n 1.7v 659.495n 1.7v 659.505n 1.7v 669.495n 1.7v 669.505n 0.0v 679.495n 0.0v 679.505n 0.0v 689.495n 0.0v 689.505n 0.0v 699.495n 0.0v 699.505n 0.0v 709.495n 0.0v 709.505n 1.7v 719.495n 1.7v 719.505n 1.7v 729.495n 1.7v 729.505n 1.7v 739.495n 1.7v 739.505n 0.0v 749.495n 0.0v 749.505n 0.0v 759.495n 0.0v 759.505n 0.0v 769.495n 0.0v 769.505n 1.7v 779.495n 1.7v 779.505n 1.7v 789.495n 1.7v 789.505n 0.0v 799.495n 0.0v 799.505n 1.7v 809.495n 1.7v 809.505n 1.7v 819.495n 1.7v 819.505n 0.0v 829.495n 0.0v 829.505n 0.0v 839.495n 0.0v 839.505n 0.0v 849.495n 0.0v 849.505n 0.0v 859.495n 0.0v 859.505n 1.7v 869.495n 1.7v 869.505n 0.0v 879.495n 0.0v 879.505n 0.0v 889.495n 0.0v 889.505n 0.0v 899.495n 0.0v 899.505n 1.7v 909.495n 1.7v 909.505n 1.7v 919.495n 1.7v 919.505n 1.7v 929.495n 1.7v 929.505n 1.7v 939.495n 1.7v 939.505n 1.7v 949.495n 1.7v 949.505n 1.7v 959.495n 1.7v 959.505n 0.0v 969.495n 0.0v 969.505n 1.7v 979.495n 1.7v 979.505n 1.7v 989.495n 1.7v 989.505n 0.0v 999.495n 0.0v 999.505n 1.7v 1009.495n 1.7v 1009.505n 1.7v 1019.495n 1.7v 1019.505n 1.7v 1029.495n 1.7v 1029.505n 1.7v 1039.495n 1.7v 1039.505n 1.7v 1049.495n 1.7v 1049.505n 1.7v 1059.495n 1.7v 1059.505n 1.7v 1069.495n 1.7v 1069.505n 0.0v 1079.495n 0.0v 1079.505n 0.0v 1089.495n 0.0v 1089.505n 1.7v 1099.495n 1.7v 1099.505n 1.7v 1109.495n 1.7v 1109.505n 0.0v 1119.495n 0.0v 1119.505n 0.0v 1129.495n 0.0v 1129.505n 1.7v 1139.495n 1.7v 1139.505n 1.7v 1149.495n 1.7v 1149.505n 0.0v 1159.495n 0.0v 1159.505n 0.0v 1169.495n 0.0v 1169.505n 1.7v 1179.495n 1.7v 1179.505n 1.7v 1189.495n 1.7v 1189.505n 1.7v 1199.495n 1.7v 1199.505n 1.7v 1209.495n 1.7v 1209.505n 1.7v 1219.495n 1.7v 1219.505n 1.7v 1229.495n 1.7v 1229.505n 1.7v 1239.495n 1.7v 1239.505n 1.7v 1249.495n 1.7v 1249.505n 1.7v 1259.495n 1.7v 1259.505n 1.7v 1269.495n 1.7v 1269.505n 1.7v 1279.495n 1.7v 1279.505n 1.7v 1289.495n 1.7v 1289.505n 1.7v 1299.495n 1.7v 1299.505n 1.7v 1309.495n 1.7v 1309.505n 1.7v 1319.495n 1.7v 1319.505n 1.7v 1329.495n 1.7v 1329.505n 1.7v 1339.495n 1.7v 1339.505n 1.7v 1349.495n 1.7v 1349.505n 1.7v 1359.495n 1.7v 1359.505n 1.7v 1369.495n 1.7v 1369.505n 1.7v 1379.495n 1.7v 1379.505n 1.7v 1389.495n 1.7v 1389.505n 1.7v 1399.495n 1.7v 1399.505n 0.0v 1409.495n 0.0v 1409.505n 0.0v 1419.495n 0.0v 1419.505n 0.0v 1429.495n 0.0v 1429.505n 0.0v 1439.495n 0.0v 1439.505n 0.0v 1449.495n 0.0v 1449.505n 0.0v 1459.495n 0.0v 1459.505n 0.0v 1469.495n 0.0v 1469.505n 0.0v 1479.495n 0.0v 1479.505n 0.0v 1489.495n 0.0v 1489.505n 0.0v 1499.495n 0.0v 1499.505n 0.0v 1509.495n 0.0v 1509.505n 0.0v 1519.495n 0.0v 1519.505n 0.0v 1529.495n 0.0v 1529.505n 0.0v 1539.495n 0.0v 1539.505n 0.0v 1549.495n 0.0v 1549.505n 0.0v 1559.495n 0.0v 1559.505n 0.0v 1569.495n 0.0v 1569.505n 0.0v 1579.495n 0.0v 1579.505n 0.0v 1589.495n 0.0v 1589.505n 0.0v 1599.495n 0.0v 1599.505n 0.0v 1609.495n 0.0v 1609.505n 0.0v 1619.495n 0.0v 1619.505n 0.0v 1629.495n 0.0v 1629.505n 1.7v 1639.495n 1.7v 1639.505n 1.7v 1649.495n 1.7v 1649.505n 1.7v 1659.495n 1.7v 1659.505n 0.0v 1669.495n 0.0v 1669.505n 0.0v 1679.495n 0.0v 1679.505n 0.0v 1689.495n 0.0v 1689.505n 0.0v 1699.495n 0.0v 1699.505n 0.0v 1709.495n 0.0v 1709.505n 1.7v 1719.495n 1.7v 1719.505n 1.7v 1729.495n 1.7v 1729.505n 0.0v 1739.495n 0.0v 1739.505n 0.0v 1749.495n 0.0v 1749.505n 1.7v 1759.495n 1.7v 1759.505n 1.7v 1769.495n 1.7v 1769.505n 0.0v 1779.495n 0.0v 1779.505n 1.7v 1789.495n 1.7v 1789.505n 1.7v 1799.495n 1.7v 1799.505n 1.7v 1809.495n 1.7v 1809.505n 1.7v 1819.495n 1.7v 1819.505n 1.7v 1829.495n 1.7v 1829.505n 1.7v 1839.495n 1.7v 1839.505n 0.0v 1849.495n 0.0v 1849.505n 0.0v 1859.495n 0.0v 1859.505n 0.0v 1869.495n 0.0v 1869.505n 0.0v 1879.495n 0.0v 1879.505n 0.0v 1889.495n 0.0v 1889.505n 0.0v 1899.495n 0.0v 1899.505n 0.0v 1909.495n 0.0v 1909.505n 1.7v 1919.495n 1.7v 1919.505n 1.7v 1929.495n 1.7v 1929.505n 1.7v 1939.495n 1.7v 1939.505n 0.0v 1949.495n 0.0v 1949.505n 0.0v 1959.495n 0.0v 1959.505n 0.0v 1969.495n 0.0v 1969.505n 1.7v 1979.495n 1.7v 1979.505n 0.0v 1989.495n 0.0v 1989.505n 0.0v 1999.495n 0.0v 1999.505n 1.7v 2009.495n 1.7v 2009.505n 1.7v 2019.495n 1.7v 2019.505n 1.7v 2029.495n 1.7v 2029.505n 1.7v 2039.495n 1.7v 2039.505n 1.7v 2049.495n 1.7v 2049.505n 1.7v )
* (time, data): [(0, 0), (10, 1), (20, 0), (30, 1), (40, 1), (50, 1), (60, 1), (70, 1), (80, 1), (90, 0), (100, 1), (110, 1), (120, 1), (130, 1), (140, 1), (150, 1), (160, 1), (170, 1), (180, 1), (190, 0), (200, 1), (210, 1), (220, 1), (230, 1), (240, 1), (250, 1), (260, 1), (270, 1), (280, 1), (290, 1), (300, 1), (310, 0), (320, 0), (330, 1), (340, 1), (350, 1), (360, 1), (370, 1), (380, 1), (390, 1), (400, 1), (410, 1), (420, 1), (430, 1), (440, 1), (450, 1), (460, 1), (470, 0), (480, 0), (490, 0), (500, 0), (510, 1), (520, 1), (530, 1), (540, 1), (550, 1), (560, 0), (570, 0), (580, 0), (590, 0), (600, 0), (610, 1), (620, 1), (630, 1), (640, 1), (650, 0), (660, 0), (670, 0), (680, 1), (690, 1), (700, 0), (710, 0), (720, 0), (730, 0), (740, 0), (750, 0), (760, 0), (770, 0), (780, 1), (790, 1), (800, 0), (810, 0), (820, 1), (830, 0), (840, 0), (850, 0), (860, 0), (870, 0), (880, 0), (890, 0), (900, 1), (910, 1), (920, 0), (930, 0), (940, 0), (950, 0), (960, 1), (970, 0), (980, 1), (990, 1), (1000, 1), (1010, 0), (1020, 1), (1030, 0), (1040, 0), (1050, 0), (1060, 0), (1070, 1), (1080, 0), (1090, 1), (1100, 0), (1110, 1), (1120, 1), (1130, 1), (1140, 0), (1150, 1), (1160, 1), (1170, 0), (1180, 0), (1190, 0), (1200, 0), (1210, 0), (1220, 0), (1230, 1), (1240, 0), (1250, 1), (1260, 1), (1270, 1), (1280, 1), (1290, 1), (1300, 0), (1310, 0), (1320, 0), (1330, 0), (1340, 1), (1350, 1), (1360, 1), (1370, 0), (1380, 0), (1390, 0), (1400, 1), (1410, 1), (1420, 1), (1430, 1), (1440, 1), (1450, 1), (1460, 1), (1470, 1), (1480, 0), (1490, 0), (1500, 0), (1510, 1), (1520, 1), (1530, 1), (1540, 1), (1550, 1), (1560, 0), (1570, 0), (1580, 1), (1590, 1), (1600, 1), (1610, 1), (1620, 0), (1630, 1), (1640, 1), (1650, 1), (1660, 0), (1670, 0), (1680, 0), (1690, 0), (1700, 0), (1710, 0), (1720, 0), (1730, 0), (1740, 0), (1750, 0), (1760, 0), (1770, 1), (1780, 0), (1790, 0), (1800, 0), (1810, 0), (1820, 0), (1830, 0), (1840, 0), (1850, 0), (1860, 1), (1870, 1), (1880, 1), (1890, 1), (1900, 1), (1910, 1), (1920, 0), (1930, 0), (1940, 0), (1950, 0), (1960, 0), (1970, 0), (1980, 1), (1990, 1), (2000, 0), (2010, 1), (2020, 0), (2030, 0), (2040, 0), (2050, 0)]
Vdin0_5  din0_5  0 PWL (0n 0.0v 9.495n 0.0v 9.505n 1.7v 19.495n 1.7v 19.505n 0.0v 29.495n 0.0v 29.505n 1.7v 39.495n 1.7v 39.505n 1.7v 49.495n 1.7v 49.505n 1.7v 59.495n 1.7v 59.505n 1.7v 69.495n 1.7v 69.505n 1.7v 79.495n 1.7v 79.505n 1.7v 89.495n 1.7v 89.505n 0.0v 99.495n 0.0v 99.505n 1.7v 109.495n 1.7v 109.505n 1.7v 119.495n 1.7v 119.505n 1.7v 129.495n 1.7v 129.505n 1.7v 139.495n 1.7v 139.505n 1.7v 149.495n 1.7v 149.505n 1.7v 159.495n 1.7v 159.505n 1.7v 169.495n 1.7v 169.505n 1.7v 179.495n 1.7v 179.505n 1.7v 189.495n 1.7v 189.505n 0.0v 199.495n 0.0v 199.505n 1.7v 209.495n 1.7v 209.505n 1.7v 219.495n 1.7v 219.505n 1.7v 229.495n 1.7v 229.505n 1.7v 239.495n 1.7v 239.505n 1.7v 249.495n 1.7v 249.505n 1.7v 259.495n 1.7v 259.505n 1.7v 269.495n 1.7v 269.505n 1.7v 279.495n 1.7v 279.505n 1.7v 289.495n 1.7v 289.505n 1.7v 299.495n 1.7v 299.505n 1.7v 309.495n 1.7v 309.505n 0.0v 319.495n 0.0v 319.505n 0.0v 329.495n 0.0v 329.505n 1.7v 339.495n 1.7v 339.505n 1.7v 349.495n 1.7v 349.505n 1.7v 359.495n 1.7v 359.505n 1.7v 369.495n 1.7v 369.505n 1.7v 379.495n 1.7v 379.505n 1.7v 389.495n 1.7v 389.505n 1.7v 399.495n 1.7v 399.505n 1.7v 409.495n 1.7v 409.505n 1.7v 419.495n 1.7v 419.505n 1.7v 429.495n 1.7v 429.505n 1.7v 439.495n 1.7v 439.505n 1.7v 449.495n 1.7v 449.505n 1.7v 459.495n 1.7v 459.505n 1.7v 469.495n 1.7v 469.505n 0.0v 479.495n 0.0v 479.505n 0.0v 489.495n 0.0v 489.505n 0.0v 499.495n 0.0v 499.505n 0.0v 509.495n 0.0v 509.505n 1.7v 519.495n 1.7v 519.505n 1.7v 529.495n 1.7v 529.505n 1.7v 539.495n 1.7v 539.505n 1.7v 549.495n 1.7v 549.505n 1.7v 559.495n 1.7v 559.505n 0.0v 569.495n 0.0v 569.505n 0.0v 579.495n 0.0v 579.505n 0.0v 589.495n 0.0v 589.505n 0.0v 599.495n 0.0v 599.505n 0.0v 609.495n 0.0v 609.505n 1.7v 619.495n 1.7v 619.505n 1.7v 629.495n 1.7v 629.505n 1.7v 639.495n 1.7v 639.505n 1.7v 649.495n 1.7v 649.505n 0.0v 659.495n 0.0v 659.505n 0.0v 669.495n 0.0v 669.505n 0.0v 679.495n 0.0v 679.505n 1.7v 689.495n 1.7v 689.505n 1.7v 699.495n 1.7v 699.505n 0.0v 709.495n 0.0v 709.505n 0.0v 719.495n 0.0v 719.505n 0.0v 729.495n 0.0v 729.505n 0.0v 739.495n 0.0v 739.505n 0.0v 749.495n 0.0v 749.505n 0.0v 759.495n 0.0v 759.505n 0.0v 769.495n 0.0v 769.505n 0.0v 779.495n 0.0v 779.505n 1.7v 789.495n 1.7v 789.505n 1.7v 799.495n 1.7v 799.505n 0.0v 809.495n 0.0v 809.505n 0.0v 819.495n 0.0v 819.505n 1.7v 829.495n 1.7v 829.505n 0.0v 839.495n 0.0v 839.505n 0.0v 849.495n 0.0v 849.505n 0.0v 859.495n 0.0v 859.505n 0.0v 869.495n 0.0v 869.505n 0.0v 879.495n 0.0v 879.505n 0.0v 889.495n 0.0v 889.505n 0.0v 899.495n 0.0v 899.505n 1.7v 909.495n 1.7v 909.505n 1.7v 919.495n 1.7v 919.505n 0.0v 929.495n 0.0v 929.505n 0.0v 939.495n 0.0v 939.505n 0.0v 949.495n 0.0v 949.505n 0.0v 959.495n 0.0v 959.505n 1.7v 969.495n 1.7v 969.505n 0.0v 979.495n 0.0v 979.505n 1.7v 989.495n 1.7v 989.505n 1.7v 999.495n 1.7v 999.505n 1.7v 1009.495n 1.7v 1009.505n 0.0v 1019.495n 0.0v 1019.505n 1.7v 1029.495n 1.7v 1029.505n 0.0v 1039.495n 0.0v 1039.505n 0.0v 1049.495n 0.0v 1049.505n 0.0v 1059.495n 0.0v 1059.505n 0.0v 1069.495n 0.0v 1069.505n 1.7v 1079.495n 1.7v 1079.505n 0.0v 1089.495n 0.0v 1089.505n 1.7v 1099.495n 1.7v 1099.505n 0.0v 1109.495n 0.0v 1109.505n 1.7v 1119.495n 1.7v 1119.505n 1.7v 1129.495n 1.7v 1129.505n 1.7v 1139.495n 1.7v 1139.505n 0.0v 1149.495n 0.0v 1149.505n 1.7v 1159.495n 1.7v 1159.505n 1.7v 1169.495n 1.7v 1169.505n 0.0v 1179.495n 0.0v 1179.505n 0.0v 1189.495n 0.0v 1189.505n 0.0v 1199.495n 0.0v 1199.505n 0.0v 1209.495n 0.0v 1209.505n 0.0v 1219.495n 0.0v 1219.505n 0.0v 1229.495n 0.0v 1229.505n 1.7v 1239.495n 1.7v 1239.505n 0.0v 1249.495n 0.0v 1249.505n 1.7v 1259.495n 1.7v 1259.505n 1.7v 1269.495n 1.7v 1269.505n 1.7v 1279.495n 1.7v 1279.505n 1.7v 1289.495n 1.7v 1289.505n 1.7v 1299.495n 1.7v 1299.505n 0.0v 1309.495n 0.0v 1309.505n 0.0v 1319.495n 0.0v 1319.505n 0.0v 1329.495n 0.0v 1329.505n 0.0v 1339.495n 0.0v 1339.505n 1.7v 1349.495n 1.7v 1349.505n 1.7v 1359.495n 1.7v 1359.505n 1.7v 1369.495n 1.7v 1369.505n 0.0v 1379.495n 0.0v 1379.505n 0.0v 1389.495n 0.0v 1389.505n 0.0v 1399.495n 0.0v 1399.505n 1.7v 1409.495n 1.7v 1409.505n 1.7v 1419.495n 1.7v 1419.505n 1.7v 1429.495n 1.7v 1429.505n 1.7v 1439.495n 1.7v 1439.505n 1.7v 1449.495n 1.7v 1449.505n 1.7v 1459.495n 1.7v 1459.505n 1.7v 1469.495n 1.7v 1469.505n 1.7v 1479.495n 1.7v 1479.505n 0.0v 1489.495n 0.0v 1489.505n 0.0v 1499.495n 0.0v 1499.505n 0.0v 1509.495n 0.0v 1509.505n 1.7v 1519.495n 1.7v 1519.505n 1.7v 1529.495n 1.7v 1529.505n 1.7v 1539.495n 1.7v 1539.505n 1.7v 1549.495n 1.7v 1549.505n 1.7v 1559.495n 1.7v 1559.505n 0.0v 1569.495n 0.0v 1569.505n 0.0v 1579.495n 0.0v 1579.505n 1.7v 1589.495n 1.7v 1589.505n 1.7v 1599.495n 1.7v 1599.505n 1.7v 1609.495n 1.7v 1609.505n 1.7v 1619.495n 1.7v 1619.505n 0.0v 1629.495n 0.0v 1629.505n 1.7v 1639.495n 1.7v 1639.505n 1.7v 1649.495n 1.7v 1649.505n 1.7v 1659.495n 1.7v 1659.505n 0.0v 1669.495n 0.0v 1669.505n 0.0v 1679.495n 0.0v 1679.505n 0.0v 1689.495n 0.0v 1689.505n 0.0v 1699.495n 0.0v 1699.505n 0.0v 1709.495n 0.0v 1709.505n 0.0v 1719.495n 0.0v 1719.505n 0.0v 1729.495n 0.0v 1729.505n 0.0v 1739.495n 0.0v 1739.505n 0.0v 1749.495n 0.0v 1749.505n 0.0v 1759.495n 0.0v 1759.505n 0.0v 1769.495n 0.0v 1769.505n 1.7v 1779.495n 1.7v 1779.505n 0.0v 1789.495n 0.0v 1789.505n 0.0v 1799.495n 0.0v 1799.505n 0.0v 1809.495n 0.0v 1809.505n 0.0v 1819.495n 0.0v 1819.505n 0.0v 1829.495n 0.0v 1829.505n 0.0v 1839.495n 0.0v 1839.505n 0.0v 1849.495n 0.0v 1849.505n 0.0v 1859.495n 0.0v 1859.505n 1.7v 1869.495n 1.7v 1869.505n 1.7v 1879.495n 1.7v 1879.505n 1.7v 1889.495n 1.7v 1889.505n 1.7v 1899.495n 1.7v 1899.505n 1.7v 1909.495n 1.7v 1909.505n 1.7v 1919.495n 1.7v 1919.505n 0.0v 1929.495n 0.0v 1929.505n 0.0v 1939.495n 0.0v 1939.505n 0.0v 1949.495n 0.0v 1949.505n 0.0v 1959.495n 0.0v 1959.505n 0.0v 1969.495n 0.0v 1969.505n 0.0v 1979.495n 0.0v 1979.505n 1.7v 1989.495n 1.7v 1989.505n 1.7v 1999.495n 1.7v 1999.505n 0.0v 2009.495n 0.0v 2009.505n 1.7v 2019.495n 1.7v 2019.505n 0.0v 2029.495n 0.0v 2029.505n 0.0v 2039.495n 0.0v 2039.505n 0.0v 2049.495n 0.0v 2049.505n 0.0v )
* (time, data): [(0, 0), (10, 1), (20, 1), (30, 1), (40, 1), (50, 1), (60, 0), (70, 0), (80, 0), (90, 0), (100, 0), (110, 0), (120, 0), (130, 0), (140, 0), (150, 1), (160, 1), (170, 1), (180, 1), (190, 1), (200, 1), (210, 0), (220, 0), (230, 0), (240, 0), (250, 0), (260, 0), (270, 0), (280, 0), (290, 0), (300, 0), (310, 1), (320, 1), (330, 0), (340, 0), (350, 0), (360, 0), (370, 0), (380, 0), (390, 0), (400, 0), (410, 0), (420, 0), (430, 0), (440, 1), (450, 1), (460, 0), (470, 1), (480, 1), (490, 1), (500, 1), (510, 0), (520, 1), (530, 1), (540, 1), (550, 1), (560, 1), (570, 1), (580, 1), (590, 1), (600, 1), (610, 1), (620, 1), (630, 1), (640, 1), (650, 1), (660, 1), (670, 0), (680, 0), (690, 0), (700, 0), (710, 1), (720, 1), (730, 1), (740, 0), (750, 0), (760, 0), (770, 0), (780, 0), (790, 0), (800, 1), (810, 1), (820, 0), (830, 1), (840, 0), (850, 0), (860, 0), (870, 1), (880, 0), (890, 0), (900, 1), (910, 1), (920, 0), (930, 0), (940, 0), (950, 0), (960, 1), (970, 0), (980, 0), (990, 1), (1000, 0), (1010, 1), (1020, 0), (1030, 0), (1040, 0), (1050, 0), (1060, 0), (1070, 1), (1080, 0), (1090, 0), (1100, 0), (1110, 0), (1120, 0), (1130, 0), (1140, 1), (1150, 0), (1160, 0), (1170, 0), (1180, 0), (1190, 0), (1200, 0), (1210, 0), (1220, 0), (1230, 0), (1240, 0), (1250, 1), (1260, 1), (1270, 1), (1280, 1), (1290, 1), (1300, 1), (1310, 1), (1320, 1), (1330, 1), (1340, 1), (1350, 1), (1360, 1), (1370, 0), (1380, 0), (1390, 0), (1400, 1), (1410, 1), (1420, 1), (1430, 1), (1440, 1), (1450, 1), (1460, 1), (1470, 1), (1480, 0), (1490, 0), (1500, 1), (1510, 0), (1520, 0), (1530, 0), (1540, 0), (1550, 1), (1560, 0), (1570, 0), (1580, 0), (1590, 0), (1600, 0), (1610, 0), (1620, 0), (1630, 0), (1640, 0), (1650, 0), (1660, 0), (1670, 0), (1680, 0), (1690, 0), (1700, 0), (1710, 0), (1720, 0), (1730, 0), (1740, 0), (1750, 1), (1760, 1), (1770, 1), (1780, 0), (1790, 0), (1800, 1), (1810, 1), (1820, 1), (1830, 1), (1840, 1), (1850, 1), (1860, 1), (1870, 1), (1880, 1), (1890, 1), (1900, 1), (1910, 1), (1920, 0), (1930, 0), (1940, 0), (1950, 0), (1960, 0), (1970, 0), (1980, 0), (1990, 0), (2000, 1), (2010, 0), (2020, 1), (2030, 1), (2040, 1), (2050, 1)]
Vdin0_6  din0_6  0 PWL (0n 0.0v 9.495n 0.0v 9.505n 1.7v 19.495n 1.7v 19.505n 1.7v 29.495n 1.7v 29.505n 1.7v 39.495n 1.7v 39.505n 1.7v 49.495n 1.7v 49.505n 1.7v 59.495n 1.7v 59.505n 0.0v 69.495n 0.0v 69.505n 0.0v 79.495n 0.0v 79.505n 0.0v 89.495n 0.0v 89.505n 0.0v 99.495n 0.0v 99.505n 0.0v 109.495n 0.0v 109.505n 0.0v 119.495n 0.0v 119.505n 0.0v 129.495n 0.0v 129.505n 0.0v 139.495n 0.0v 139.505n 0.0v 149.495n 0.0v 149.505n 1.7v 159.495n 1.7v 159.505n 1.7v 169.495n 1.7v 169.505n 1.7v 179.495n 1.7v 179.505n 1.7v 189.495n 1.7v 189.505n 1.7v 199.495n 1.7v 199.505n 1.7v 209.495n 1.7v 209.505n 0.0v 219.495n 0.0v 219.505n 0.0v 229.495n 0.0v 229.505n 0.0v 239.495n 0.0v 239.505n 0.0v 249.495n 0.0v 249.505n 0.0v 259.495n 0.0v 259.505n 0.0v 269.495n 0.0v 269.505n 0.0v 279.495n 0.0v 279.505n 0.0v 289.495n 0.0v 289.505n 0.0v 299.495n 0.0v 299.505n 0.0v 309.495n 0.0v 309.505n 1.7v 319.495n 1.7v 319.505n 1.7v 329.495n 1.7v 329.505n 0.0v 339.495n 0.0v 339.505n 0.0v 349.495n 0.0v 349.505n 0.0v 359.495n 0.0v 359.505n 0.0v 369.495n 0.0v 369.505n 0.0v 379.495n 0.0v 379.505n 0.0v 389.495n 0.0v 389.505n 0.0v 399.495n 0.0v 399.505n 0.0v 409.495n 0.0v 409.505n 0.0v 419.495n 0.0v 419.505n 0.0v 429.495n 0.0v 429.505n 0.0v 439.495n 0.0v 439.505n 1.7v 449.495n 1.7v 449.505n 1.7v 459.495n 1.7v 459.505n 0.0v 469.495n 0.0v 469.505n 1.7v 479.495n 1.7v 479.505n 1.7v 489.495n 1.7v 489.505n 1.7v 499.495n 1.7v 499.505n 1.7v 509.495n 1.7v 509.505n 0.0v 519.495n 0.0v 519.505n 1.7v 529.495n 1.7v 529.505n 1.7v 539.495n 1.7v 539.505n 1.7v 549.495n 1.7v 549.505n 1.7v 559.495n 1.7v 559.505n 1.7v 569.495n 1.7v 569.505n 1.7v 579.495n 1.7v 579.505n 1.7v 589.495n 1.7v 589.505n 1.7v 599.495n 1.7v 599.505n 1.7v 609.495n 1.7v 609.505n 1.7v 619.495n 1.7v 619.505n 1.7v 629.495n 1.7v 629.505n 1.7v 639.495n 1.7v 639.505n 1.7v 649.495n 1.7v 649.505n 1.7v 659.495n 1.7v 659.505n 1.7v 669.495n 1.7v 669.505n 0.0v 679.495n 0.0v 679.505n 0.0v 689.495n 0.0v 689.505n 0.0v 699.495n 0.0v 699.505n 0.0v 709.495n 0.0v 709.505n 1.7v 719.495n 1.7v 719.505n 1.7v 729.495n 1.7v 729.505n 1.7v 739.495n 1.7v 739.505n 0.0v 749.495n 0.0v 749.505n 0.0v 759.495n 0.0v 759.505n 0.0v 769.495n 0.0v 769.505n 0.0v 779.495n 0.0v 779.505n 0.0v 789.495n 0.0v 789.505n 0.0v 799.495n 0.0v 799.505n 1.7v 809.495n 1.7v 809.505n 1.7v 819.495n 1.7v 819.505n 0.0v 829.495n 0.0v 829.505n 1.7v 839.495n 1.7v 839.505n 0.0v 849.495n 0.0v 849.505n 0.0v 859.495n 0.0v 859.505n 0.0v 869.495n 0.0v 869.505n 1.7v 879.495n 1.7v 879.505n 0.0v 889.495n 0.0v 889.505n 0.0v 899.495n 0.0v 899.505n 1.7v 909.495n 1.7v 909.505n 1.7v 919.495n 1.7v 919.505n 0.0v 929.495n 0.0v 929.505n 0.0v 939.495n 0.0v 939.505n 0.0v 949.495n 0.0v 949.505n 0.0v 959.495n 0.0v 959.505n 1.7v 969.495n 1.7v 969.505n 0.0v 979.495n 0.0v 979.505n 0.0v 989.495n 0.0v 989.505n 1.7v 999.495n 1.7v 999.505n 0.0v 1009.495n 0.0v 1009.505n 1.7v 1019.495n 1.7v 1019.505n 0.0v 1029.495n 0.0v 1029.505n 0.0v 1039.495n 0.0v 1039.505n 0.0v 1049.495n 0.0v 1049.505n 0.0v 1059.495n 0.0v 1059.505n 0.0v 1069.495n 0.0v 1069.505n 1.7v 1079.495n 1.7v 1079.505n 0.0v 1089.495n 0.0v 1089.505n 0.0v 1099.495n 0.0v 1099.505n 0.0v 1109.495n 0.0v 1109.505n 0.0v 1119.495n 0.0v 1119.505n 0.0v 1129.495n 0.0v 1129.505n 0.0v 1139.495n 0.0v 1139.505n 1.7v 1149.495n 1.7v 1149.505n 0.0v 1159.495n 0.0v 1159.505n 0.0v 1169.495n 0.0v 1169.505n 0.0v 1179.495n 0.0v 1179.505n 0.0v 1189.495n 0.0v 1189.505n 0.0v 1199.495n 0.0v 1199.505n 0.0v 1209.495n 0.0v 1209.505n 0.0v 1219.495n 0.0v 1219.505n 0.0v 1229.495n 0.0v 1229.505n 0.0v 1239.495n 0.0v 1239.505n 0.0v 1249.495n 0.0v 1249.505n 1.7v 1259.495n 1.7v 1259.505n 1.7v 1269.495n 1.7v 1269.505n 1.7v 1279.495n 1.7v 1279.505n 1.7v 1289.495n 1.7v 1289.505n 1.7v 1299.495n 1.7v 1299.505n 1.7v 1309.495n 1.7v 1309.505n 1.7v 1319.495n 1.7v 1319.505n 1.7v 1329.495n 1.7v 1329.505n 1.7v 1339.495n 1.7v 1339.505n 1.7v 1349.495n 1.7v 1349.505n 1.7v 1359.495n 1.7v 1359.505n 1.7v 1369.495n 1.7v 1369.505n 0.0v 1379.495n 0.0v 1379.505n 0.0v 1389.495n 0.0v 1389.505n 0.0v 1399.495n 0.0v 1399.505n 1.7v 1409.495n 1.7v 1409.505n 1.7v 1419.495n 1.7v 1419.505n 1.7v 1429.495n 1.7v 1429.505n 1.7v 1439.495n 1.7v 1439.505n 1.7v 1449.495n 1.7v 1449.505n 1.7v 1459.495n 1.7v 1459.505n 1.7v 1469.495n 1.7v 1469.505n 1.7v 1479.495n 1.7v 1479.505n 0.0v 1489.495n 0.0v 1489.505n 0.0v 1499.495n 0.0v 1499.505n 1.7v 1509.495n 1.7v 1509.505n 0.0v 1519.495n 0.0v 1519.505n 0.0v 1529.495n 0.0v 1529.505n 0.0v 1539.495n 0.0v 1539.505n 0.0v 1549.495n 0.0v 1549.505n 1.7v 1559.495n 1.7v 1559.505n 0.0v 1569.495n 0.0v 1569.505n 0.0v 1579.495n 0.0v 1579.505n 0.0v 1589.495n 0.0v 1589.505n 0.0v 1599.495n 0.0v 1599.505n 0.0v 1609.495n 0.0v 1609.505n 0.0v 1619.495n 0.0v 1619.505n 0.0v 1629.495n 0.0v 1629.505n 0.0v 1639.495n 0.0v 1639.505n 0.0v 1649.495n 0.0v 1649.505n 0.0v 1659.495n 0.0v 1659.505n 0.0v 1669.495n 0.0v 1669.505n 0.0v 1679.495n 0.0v 1679.505n 0.0v 1689.495n 0.0v 1689.505n 0.0v 1699.495n 0.0v 1699.505n 0.0v 1709.495n 0.0v 1709.505n 0.0v 1719.495n 0.0v 1719.505n 0.0v 1729.495n 0.0v 1729.505n 0.0v 1739.495n 0.0v 1739.505n 0.0v 1749.495n 0.0v 1749.505n 1.7v 1759.495n 1.7v 1759.505n 1.7v 1769.495n 1.7v 1769.505n 1.7v 1779.495n 1.7v 1779.505n 0.0v 1789.495n 0.0v 1789.505n 0.0v 1799.495n 0.0v 1799.505n 1.7v 1809.495n 1.7v 1809.505n 1.7v 1819.495n 1.7v 1819.505n 1.7v 1829.495n 1.7v 1829.505n 1.7v 1839.495n 1.7v 1839.505n 1.7v 1849.495n 1.7v 1849.505n 1.7v 1859.495n 1.7v 1859.505n 1.7v 1869.495n 1.7v 1869.505n 1.7v 1879.495n 1.7v 1879.505n 1.7v 1889.495n 1.7v 1889.505n 1.7v 1899.495n 1.7v 1899.505n 1.7v 1909.495n 1.7v 1909.505n 1.7v 1919.495n 1.7v 1919.505n 0.0v 1929.495n 0.0v 1929.505n 0.0v 1939.495n 0.0v 1939.505n 0.0v 1949.495n 0.0v 1949.505n 0.0v 1959.495n 0.0v 1959.505n 0.0v 1969.495n 0.0v 1969.505n 0.0v 1979.495n 0.0v 1979.505n 0.0v 1989.495n 0.0v 1989.505n 0.0v 1999.495n 0.0v 1999.505n 1.7v 2009.495n 1.7v 2009.505n 0.0v 2019.495n 0.0v 2019.505n 1.7v 2029.495n 1.7v 2029.505n 1.7v 2039.495n 1.7v 2039.505n 1.7v 2049.495n 1.7v 2049.505n 1.7v )
* (time, data): [(0, 0), (10, 0), (20, 0), (30, 1), (40, 1), (50, 1), (60, 0), (70, 0), (80, 0), (90, 0), (100, 1), (110, 1), (120, 1), (130, 1), (140, 1), (150, 1), (160, 1), (170, 1), (180, 1), (190, 1), (200, 0), (210, 1), (220, 1), (230, 1), (240, 1), (250, 1), (260, 1), (270, 1), (280, 0), (290, 0), (300, 0), (310, 0), (320, 1), (330, 0), (340, 0), (350, 0), (360, 0), (370, 0), (380, 0), (390, 0), (400, 0), (410, 0), (420, 1), (430, 1), (440, 0), (450, 0), (460, 1), (470, 1), (480, 1), (490, 1), (500, 1), (510, 1), (520, 1), (530, 1), (540, 1), (550, 0), (560, 0), (570, 0), (580, 0), (590, 0), (600, 1), (610, 0), (620, 0), (630, 1), (640, 1), (650, 1), (660, 1), (670, 1), (680, 1), (690, 1), (700, 1), (710, 0), (720, 0), (730, 0), (740, 1), (750, 1), (760, 1), (770, 0), (780, 0), (790, 0), (800, 1), (810, 1), (820, 1), (830, 1), (840, 0), (850, 0), (860, 0), (870, 0), (880, 1), (890, 1), (900, 1), (910, 1), (920, 1), (930, 1), (940, 1), (950, 1), (960, 0), (970, 0), (980, 0), (990, 0), (1000, 1), (1010, 0), (1020, 1), (1030, 0), (1040, 0), (1050, 0), (1060, 0), (1070, 1), (1080, 1), (1090, 1), (1100, 1), (1110, 1), (1120, 1), (1130, 1), (1140, 0), (1150, 1), (1160, 1), (1170, 1), (1180, 1), (1190, 1), (1200, 1), (1210, 1), (1220, 1), (1230, 0), (1240, 1), (1250, 1), (1260, 1), (1270, 1), (1280, 1), (1290, 1), (1300, 0), (1310, 0), (1320, 0), (1330, 0), (1340, 0), (1350, 0), (1360, 1), (1370, 1), (1380, 1), (1390, 1), (1400, 1), (1410, 1), (1420, 1), (1430, 1), (1440, 1), (1450, 1), (1460, 1), (1470, 1), (1480, 1), (1490, 1), (1500, 0), (1510, 0), (1520, 0), (1530, 0), (1540, 0), (1550, 1), (1560, 0), (1570, 0), (1580, 1), (1590, 1), (1600, 1), (1610, 1), (1620, 1), (1630, 1), (1640, 1), (1650, 0), (1660, 1), (1670, 1), (1680, 1), (1690, 1), (1700, 1), (1710, 0), (1720, 0), (1730, 1), (1740, 1), (1750, 1), (1760, 1), (1770, 1), (1780, 0), (1790, 0), (1800, 1), (1810, 1), (1820, 1), (1830, 1), (1840, 0), (1850, 0), (1860, 0), (1870, 0), (1880, 0), (1890, 0), (1900, 0), (1910, 1), (1920, 0), (1930, 1), (1940, 0), (1950, 0), (1960, 0), (1970, 0), (1980, 0), (1990, 0), (2000, 1), (2010, 0), (2020, 1), (2030, 1), (2040, 1), (2050, 1)]
Vdin0_7  din0_7  0 PWL (0n 0.0v 9.495n 0.0v 9.505n 0.0v 19.495n 0.0v 19.505n 0.0v 29.495n 0.0v 29.505n 1.7v 39.495n 1.7v 39.505n 1.7v 49.495n 1.7v 49.505n 1.7v 59.495n 1.7v 59.505n 0.0v 69.495n 0.0v 69.505n 0.0v 79.495n 0.0v 79.505n 0.0v 89.495n 0.0v 89.505n 0.0v 99.495n 0.0v 99.505n 1.7v 109.495n 1.7v 109.505n 1.7v 119.495n 1.7v 119.505n 1.7v 129.495n 1.7v 129.505n 1.7v 139.495n 1.7v 139.505n 1.7v 149.495n 1.7v 149.505n 1.7v 159.495n 1.7v 159.505n 1.7v 169.495n 1.7v 169.505n 1.7v 179.495n 1.7v 179.505n 1.7v 189.495n 1.7v 189.505n 1.7v 199.495n 1.7v 199.505n 0.0v 209.495n 0.0v 209.505n 1.7v 219.495n 1.7v 219.505n 1.7v 229.495n 1.7v 229.505n 1.7v 239.495n 1.7v 239.505n 1.7v 249.495n 1.7v 249.505n 1.7v 259.495n 1.7v 259.505n 1.7v 269.495n 1.7v 269.505n 1.7v 279.495n 1.7v 279.505n 0.0v 289.495n 0.0v 289.505n 0.0v 299.495n 0.0v 299.505n 0.0v 309.495n 0.0v 309.505n 0.0v 319.495n 0.0v 319.505n 1.7v 329.495n 1.7v 329.505n 0.0v 339.495n 0.0v 339.505n 0.0v 349.495n 0.0v 349.505n 0.0v 359.495n 0.0v 359.505n 0.0v 369.495n 0.0v 369.505n 0.0v 379.495n 0.0v 379.505n 0.0v 389.495n 0.0v 389.505n 0.0v 399.495n 0.0v 399.505n 0.0v 409.495n 0.0v 409.505n 0.0v 419.495n 0.0v 419.505n 1.7v 429.495n 1.7v 429.505n 1.7v 439.495n 1.7v 439.505n 0.0v 449.495n 0.0v 449.505n 0.0v 459.495n 0.0v 459.505n 1.7v 469.495n 1.7v 469.505n 1.7v 479.495n 1.7v 479.505n 1.7v 489.495n 1.7v 489.505n 1.7v 499.495n 1.7v 499.505n 1.7v 509.495n 1.7v 509.505n 1.7v 519.495n 1.7v 519.505n 1.7v 529.495n 1.7v 529.505n 1.7v 539.495n 1.7v 539.505n 1.7v 549.495n 1.7v 549.505n 0.0v 559.495n 0.0v 559.505n 0.0v 569.495n 0.0v 569.505n 0.0v 579.495n 0.0v 579.505n 0.0v 589.495n 0.0v 589.505n 0.0v 599.495n 0.0v 599.505n 1.7v 609.495n 1.7v 609.505n 0.0v 619.495n 0.0v 619.505n 0.0v 629.495n 0.0v 629.505n 1.7v 639.495n 1.7v 639.505n 1.7v 649.495n 1.7v 649.505n 1.7v 659.495n 1.7v 659.505n 1.7v 669.495n 1.7v 669.505n 1.7v 679.495n 1.7v 679.505n 1.7v 689.495n 1.7v 689.505n 1.7v 699.495n 1.7v 699.505n 1.7v 709.495n 1.7v 709.505n 0.0v 719.495n 0.0v 719.505n 0.0v 729.495n 0.0v 729.505n 0.0v 739.495n 0.0v 739.505n 1.7v 749.495n 1.7v 749.505n 1.7v 759.495n 1.7v 759.505n 1.7v 769.495n 1.7v 769.505n 0.0v 779.495n 0.0v 779.505n 0.0v 789.495n 0.0v 789.505n 0.0v 799.495n 0.0v 799.505n 1.7v 809.495n 1.7v 809.505n 1.7v 819.495n 1.7v 819.505n 1.7v 829.495n 1.7v 829.505n 1.7v 839.495n 1.7v 839.505n 0.0v 849.495n 0.0v 849.505n 0.0v 859.495n 0.0v 859.505n 0.0v 869.495n 0.0v 869.505n 0.0v 879.495n 0.0v 879.505n 1.7v 889.495n 1.7v 889.505n 1.7v 899.495n 1.7v 899.505n 1.7v 909.495n 1.7v 909.505n 1.7v 919.495n 1.7v 919.505n 1.7v 929.495n 1.7v 929.505n 1.7v 939.495n 1.7v 939.505n 1.7v 949.495n 1.7v 949.505n 1.7v 959.495n 1.7v 959.505n 0.0v 969.495n 0.0v 969.505n 0.0v 979.495n 0.0v 979.505n 0.0v 989.495n 0.0v 989.505n 0.0v 999.495n 0.0v 999.505n 1.7v 1009.495n 1.7v 1009.505n 0.0v 1019.495n 0.0v 1019.505n 1.7v 1029.495n 1.7v 1029.505n 0.0v 1039.495n 0.0v 1039.505n 0.0v 1049.495n 0.0v 1049.505n 0.0v 1059.495n 0.0v 1059.505n 0.0v 1069.495n 0.0v 1069.505n 1.7v 1079.495n 1.7v 1079.505n 1.7v 1089.495n 1.7v 1089.505n 1.7v 1099.495n 1.7v 1099.505n 1.7v 1109.495n 1.7v 1109.505n 1.7v 1119.495n 1.7v 1119.505n 1.7v 1129.495n 1.7v 1129.505n 1.7v 1139.495n 1.7v 1139.505n 0.0v 1149.495n 0.0v 1149.505n 1.7v 1159.495n 1.7v 1159.505n 1.7v 1169.495n 1.7v 1169.505n 1.7v 1179.495n 1.7v 1179.505n 1.7v 1189.495n 1.7v 1189.505n 1.7v 1199.495n 1.7v 1199.505n 1.7v 1209.495n 1.7v 1209.505n 1.7v 1219.495n 1.7v 1219.505n 1.7v 1229.495n 1.7v 1229.505n 0.0v 1239.495n 0.0v 1239.505n 1.7v 1249.495n 1.7v 1249.505n 1.7v 1259.495n 1.7v 1259.505n 1.7v 1269.495n 1.7v 1269.505n 1.7v 1279.495n 1.7v 1279.505n 1.7v 1289.495n 1.7v 1289.505n 1.7v 1299.495n 1.7v 1299.505n 0.0v 1309.495n 0.0v 1309.505n 0.0v 1319.495n 0.0v 1319.505n 0.0v 1329.495n 0.0v 1329.505n 0.0v 1339.495n 0.0v 1339.505n 0.0v 1349.495n 0.0v 1349.505n 0.0v 1359.495n 0.0v 1359.505n 1.7v 1369.495n 1.7v 1369.505n 1.7v 1379.495n 1.7v 1379.505n 1.7v 1389.495n 1.7v 1389.505n 1.7v 1399.495n 1.7v 1399.505n 1.7v 1409.495n 1.7v 1409.505n 1.7v 1419.495n 1.7v 1419.505n 1.7v 1429.495n 1.7v 1429.505n 1.7v 1439.495n 1.7v 1439.505n 1.7v 1449.495n 1.7v 1449.505n 1.7v 1459.495n 1.7v 1459.505n 1.7v 1469.495n 1.7v 1469.505n 1.7v 1479.495n 1.7v 1479.505n 1.7v 1489.495n 1.7v 1489.505n 1.7v 1499.495n 1.7v 1499.505n 0.0v 1509.495n 0.0v 1509.505n 0.0v 1519.495n 0.0v 1519.505n 0.0v 1529.495n 0.0v 1529.505n 0.0v 1539.495n 0.0v 1539.505n 0.0v 1549.495n 0.0v 1549.505n 1.7v 1559.495n 1.7v 1559.505n 0.0v 1569.495n 0.0v 1569.505n 0.0v 1579.495n 0.0v 1579.505n 1.7v 1589.495n 1.7v 1589.505n 1.7v 1599.495n 1.7v 1599.505n 1.7v 1609.495n 1.7v 1609.505n 1.7v 1619.495n 1.7v 1619.505n 1.7v 1629.495n 1.7v 1629.505n 1.7v 1639.495n 1.7v 1639.505n 1.7v 1649.495n 1.7v 1649.505n 0.0v 1659.495n 0.0v 1659.505n 1.7v 1669.495n 1.7v 1669.505n 1.7v 1679.495n 1.7v 1679.505n 1.7v 1689.495n 1.7v 1689.505n 1.7v 1699.495n 1.7v 1699.505n 1.7v 1709.495n 1.7v 1709.505n 0.0v 1719.495n 0.0v 1719.505n 0.0v 1729.495n 0.0v 1729.505n 1.7v 1739.495n 1.7v 1739.505n 1.7v 1749.495n 1.7v 1749.505n 1.7v 1759.495n 1.7v 1759.505n 1.7v 1769.495n 1.7v 1769.505n 1.7v 1779.495n 1.7v 1779.505n 0.0v 1789.495n 0.0v 1789.505n 0.0v 1799.495n 0.0v 1799.505n 1.7v 1809.495n 1.7v 1809.505n 1.7v 1819.495n 1.7v 1819.505n 1.7v 1829.495n 1.7v 1829.505n 1.7v 1839.495n 1.7v 1839.505n 0.0v 1849.495n 0.0v 1849.505n 0.0v 1859.495n 0.0v 1859.505n 0.0v 1869.495n 0.0v 1869.505n 0.0v 1879.495n 0.0v 1879.505n 0.0v 1889.495n 0.0v 1889.505n 0.0v 1899.495n 0.0v 1899.505n 0.0v 1909.495n 0.0v 1909.505n 1.7v 1919.495n 1.7v 1919.505n 0.0v 1929.495n 0.0v 1929.505n 1.7v 1939.495n 1.7v 1939.505n 0.0v 1949.495n 0.0v 1949.505n 0.0v 1959.495n 0.0v 1959.505n 0.0v 1969.495n 0.0v 1969.505n 0.0v 1979.495n 0.0v 1979.505n 0.0v 1989.495n 0.0v 1989.505n 0.0v 1999.495n 0.0v 1999.505n 1.7v 2009.495n 1.7v 2009.505n 0.0v 2019.495n 0.0v 2019.505n 1.7v 2029.495n 1.7v 2029.505n 1.7v 2039.495n 1.7v 2039.505n 1.7v 2049.495n 1.7v 2049.505n 1.7v )
* (time, data): [(0, 0), (10, 1), (20, 1), (30, 0), (40, 0), (50, 0), (60, 0), (70, 0), (80, 0), (90, 0), (100, 0), (110, 1), (120, 1), (130, 1), (140, 1), (150, 1), (160, 1), (170, 1), (180, 1), (190, 0), (200, 1), (210, 0), (220, 0), (230, 0), (240, 0), (250, 0), (260, 0), (270, 0), (280, 0), (290, 0), (300, 0), (310, 0), (320, 1), (330, 1), (340, 1), (350, 1), (360, 1), (370, 1), (380, 1), (390, 1), (400, 1), (410, 1), (420, 0), (430, 0), (440, 0), (450, 0), (460, 1), (470, 0), (480, 0), (490, 0), (500, 1), (510, 1), (520, 0), (530, 0), (540, 0), (550, 1), (560, 0), (570, 0), (580, 0), (590, 0), (600, 0), (610, 1), (620, 1), (630, 0), (640, 0), (650, 1), (660, 1), (670, 0), (680, 0), (690, 0), (700, 0), (710, 0), (720, 0), (730, 0), (740, 0), (750, 0), (760, 0), (770, 0), (780, 1), (790, 0), (800, 0), (810, 0), (820, 1), (830, 1), (840, 1), (850, 1), (860, 1), (870, 1), (880, 0), (890, 0), (900, 1), (910, 1), (920, 0), (930, 0), (940, 0), (950, 0), (960, 0), (970, 1), (980, 0), (990, 1), (1000, 0), (1010, 1), (1020, 1), (1030, 0), (1040, 0), (1050, 0), (1060, 0), (1070, 0), (1080, 0), (1090, 1), (1100, 1), (1110, 1), (1120, 1), (1130, 0), (1140, 1), (1150, 0), (1160, 0), (1170, 1), (1180, 0), (1190, 0), (1200, 0), (1210, 0), (1220, 1), (1230, 1), (1240, 1), (1250, 0), (1260, 0), (1270, 0), (1280, 0), (1290, 0), (1300, 0), (1310, 0), (1320, 0), (1330, 0), (1340, 0), (1350, 0), (1360, 0), (1370, 1), (1380, 1), (1390, 1), (1400, 1), (1410, 1), (1420, 1), (1430, 1), (1440, 1), (1450, 1), (1460, 1), (1470, 1), (1480, 0), (1490, 0), (1500, 0), (1510, 1), (1520, 1), (1530, 1), (1540, 1), (1550, 1), (1560, 0), (1570, 0), (1580, 1), (1590, 1), (1600, 1), (1610, 1), (1620, 0), (1630, 0), (1640, 0), (1650, 1), (1660, 1), (1670, 1), (1680, 1), (1690, 1), (1700, 1), (1710, 0), (1720, 0), (1730, 1), (1740, 1), (1750, 1), (1760, 1), (1770, 0), (1780, 1), (1790, 1), (1800, 1), (1810, 1), (1820, 1), (1830, 1), (1840, 1), (1850, 1), (1860, 0), (1870, 0), (1880, 0), (1890, 0), (1900, 0), (1910, 1), (1920, 0), (1930, 0), (1940, 1), (1950, 0), (1960, 0), (1970, 1), (1980, 0), (1990, 0), (2000, 1), (2010, 0), (2020, 1), (2030, 1), (2040, 1), (2050, 1)]
Vdin0_8  din0_8  0 PWL (0n 0.0v 9.495n 0.0v 9.505n 1.7v 19.495n 1.7v 19.505n 1.7v 29.495n 1.7v 29.505n 0.0v 39.495n 0.0v 39.505n 0.0v 49.495n 0.0v 49.505n 0.0v 59.495n 0.0v 59.505n 0.0v 69.495n 0.0v 69.505n 0.0v 79.495n 0.0v 79.505n 0.0v 89.495n 0.0v 89.505n 0.0v 99.495n 0.0v 99.505n 0.0v 109.495n 0.0v 109.505n 1.7v 119.495n 1.7v 119.505n 1.7v 129.495n 1.7v 129.505n 1.7v 139.495n 1.7v 139.505n 1.7v 149.495n 1.7v 149.505n 1.7v 159.495n 1.7v 159.505n 1.7v 169.495n 1.7v 169.505n 1.7v 179.495n 1.7v 179.505n 1.7v 189.495n 1.7v 189.505n 0.0v 199.495n 0.0v 199.505n 1.7v 209.495n 1.7v 209.505n 0.0v 219.495n 0.0v 219.505n 0.0v 229.495n 0.0v 229.505n 0.0v 239.495n 0.0v 239.505n 0.0v 249.495n 0.0v 249.505n 0.0v 259.495n 0.0v 259.505n 0.0v 269.495n 0.0v 269.505n 0.0v 279.495n 0.0v 279.505n 0.0v 289.495n 0.0v 289.505n 0.0v 299.495n 0.0v 299.505n 0.0v 309.495n 0.0v 309.505n 0.0v 319.495n 0.0v 319.505n 1.7v 329.495n 1.7v 329.505n 1.7v 339.495n 1.7v 339.505n 1.7v 349.495n 1.7v 349.505n 1.7v 359.495n 1.7v 359.505n 1.7v 369.495n 1.7v 369.505n 1.7v 379.495n 1.7v 379.505n 1.7v 389.495n 1.7v 389.505n 1.7v 399.495n 1.7v 399.505n 1.7v 409.495n 1.7v 409.505n 1.7v 419.495n 1.7v 419.505n 0.0v 429.495n 0.0v 429.505n 0.0v 439.495n 0.0v 439.505n 0.0v 449.495n 0.0v 449.505n 0.0v 459.495n 0.0v 459.505n 1.7v 469.495n 1.7v 469.505n 0.0v 479.495n 0.0v 479.505n 0.0v 489.495n 0.0v 489.505n 0.0v 499.495n 0.0v 499.505n 1.7v 509.495n 1.7v 509.505n 1.7v 519.495n 1.7v 519.505n 0.0v 529.495n 0.0v 529.505n 0.0v 539.495n 0.0v 539.505n 0.0v 549.495n 0.0v 549.505n 1.7v 559.495n 1.7v 559.505n 0.0v 569.495n 0.0v 569.505n 0.0v 579.495n 0.0v 579.505n 0.0v 589.495n 0.0v 589.505n 0.0v 599.495n 0.0v 599.505n 0.0v 609.495n 0.0v 609.505n 1.7v 619.495n 1.7v 619.505n 1.7v 629.495n 1.7v 629.505n 0.0v 639.495n 0.0v 639.505n 0.0v 649.495n 0.0v 649.505n 1.7v 659.495n 1.7v 659.505n 1.7v 669.495n 1.7v 669.505n 0.0v 679.495n 0.0v 679.505n 0.0v 689.495n 0.0v 689.505n 0.0v 699.495n 0.0v 699.505n 0.0v 709.495n 0.0v 709.505n 0.0v 719.495n 0.0v 719.505n 0.0v 729.495n 0.0v 729.505n 0.0v 739.495n 0.0v 739.505n 0.0v 749.495n 0.0v 749.505n 0.0v 759.495n 0.0v 759.505n 0.0v 769.495n 0.0v 769.505n 0.0v 779.495n 0.0v 779.505n 1.7v 789.495n 1.7v 789.505n 0.0v 799.495n 0.0v 799.505n 0.0v 809.495n 0.0v 809.505n 0.0v 819.495n 0.0v 819.505n 1.7v 829.495n 1.7v 829.505n 1.7v 839.495n 1.7v 839.505n 1.7v 849.495n 1.7v 849.505n 1.7v 859.495n 1.7v 859.505n 1.7v 869.495n 1.7v 869.505n 1.7v 879.495n 1.7v 879.505n 0.0v 889.495n 0.0v 889.505n 0.0v 899.495n 0.0v 899.505n 1.7v 909.495n 1.7v 909.505n 1.7v 919.495n 1.7v 919.505n 0.0v 929.495n 0.0v 929.505n 0.0v 939.495n 0.0v 939.505n 0.0v 949.495n 0.0v 949.505n 0.0v 959.495n 0.0v 959.505n 0.0v 969.495n 0.0v 969.505n 1.7v 979.495n 1.7v 979.505n 0.0v 989.495n 0.0v 989.505n 1.7v 999.495n 1.7v 999.505n 0.0v 1009.495n 0.0v 1009.505n 1.7v 1019.495n 1.7v 1019.505n 1.7v 1029.495n 1.7v 1029.505n 0.0v 1039.495n 0.0v 1039.505n 0.0v 1049.495n 0.0v 1049.505n 0.0v 1059.495n 0.0v 1059.505n 0.0v 1069.495n 0.0v 1069.505n 0.0v 1079.495n 0.0v 1079.505n 0.0v 1089.495n 0.0v 1089.505n 1.7v 1099.495n 1.7v 1099.505n 1.7v 1109.495n 1.7v 1109.505n 1.7v 1119.495n 1.7v 1119.505n 1.7v 1129.495n 1.7v 1129.505n 0.0v 1139.495n 0.0v 1139.505n 1.7v 1149.495n 1.7v 1149.505n 0.0v 1159.495n 0.0v 1159.505n 0.0v 1169.495n 0.0v 1169.505n 1.7v 1179.495n 1.7v 1179.505n 0.0v 1189.495n 0.0v 1189.505n 0.0v 1199.495n 0.0v 1199.505n 0.0v 1209.495n 0.0v 1209.505n 0.0v 1219.495n 0.0v 1219.505n 1.7v 1229.495n 1.7v 1229.505n 1.7v 1239.495n 1.7v 1239.505n 1.7v 1249.495n 1.7v 1249.505n 0.0v 1259.495n 0.0v 1259.505n 0.0v 1269.495n 0.0v 1269.505n 0.0v 1279.495n 0.0v 1279.505n 0.0v 1289.495n 0.0v 1289.505n 0.0v 1299.495n 0.0v 1299.505n 0.0v 1309.495n 0.0v 1309.505n 0.0v 1319.495n 0.0v 1319.505n 0.0v 1329.495n 0.0v 1329.505n 0.0v 1339.495n 0.0v 1339.505n 0.0v 1349.495n 0.0v 1349.505n 0.0v 1359.495n 0.0v 1359.505n 0.0v 1369.495n 0.0v 1369.505n 1.7v 1379.495n 1.7v 1379.505n 1.7v 1389.495n 1.7v 1389.505n 1.7v 1399.495n 1.7v 1399.505n 1.7v 1409.495n 1.7v 1409.505n 1.7v 1419.495n 1.7v 1419.505n 1.7v 1429.495n 1.7v 1429.505n 1.7v 1439.495n 1.7v 1439.505n 1.7v 1449.495n 1.7v 1449.505n 1.7v 1459.495n 1.7v 1459.505n 1.7v 1469.495n 1.7v 1469.505n 1.7v 1479.495n 1.7v 1479.505n 0.0v 1489.495n 0.0v 1489.505n 0.0v 1499.495n 0.0v 1499.505n 0.0v 1509.495n 0.0v 1509.505n 1.7v 1519.495n 1.7v 1519.505n 1.7v 1529.495n 1.7v 1529.505n 1.7v 1539.495n 1.7v 1539.505n 1.7v 1549.495n 1.7v 1549.505n 1.7v 1559.495n 1.7v 1559.505n 0.0v 1569.495n 0.0v 1569.505n 0.0v 1579.495n 0.0v 1579.505n 1.7v 1589.495n 1.7v 1589.505n 1.7v 1599.495n 1.7v 1599.505n 1.7v 1609.495n 1.7v 1609.505n 1.7v 1619.495n 1.7v 1619.505n 0.0v 1629.495n 0.0v 1629.505n 0.0v 1639.495n 0.0v 1639.505n 0.0v 1649.495n 0.0v 1649.505n 1.7v 1659.495n 1.7v 1659.505n 1.7v 1669.495n 1.7v 1669.505n 1.7v 1679.495n 1.7v 1679.505n 1.7v 1689.495n 1.7v 1689.505n 1.7v 1699.495n 1.7v 1699.505n 1.7v 1709.495n 1.7v 1709.505n 0.0v 1719.495n 0.0v 1719.505n 0.0v 1729.495n 0.0v 1729.505n 1.7v 1739.495n 1.7v 1739.505n 1.7v 1749.495n 1.7v 1749.505n 1.7v 1759.495n 1.7v 1759.505n 1.7v 1769.495n 1.7v 1769.505n 0.0v 1779.495n 0.0v 1779.505n 1.7v 1789.495n 1.7v 1789.505n 1.7v 1799.495n 1.7v 1799.505n 1.7v 1809.495n 1.7v 1809.505n 1.7v 1819.495n 1.7v 1819.505n 1.7v 1829.495n 1.7v 1829.505n 1.7v 1839.495n 1.7v 1839.505n 1.7v 1849.495n 1.7v 1849.505n 1.7v 1859.495n 1.7v 1859.505n 0.0v 1869.495n 0.0v 1869.505n 0.0v 1879.495n 0.0v 1879.505n 0.0v 1889.495n 0.0v 1889.505n 0.0v 1899.495n 0.0v 1899.505n 0.0v 1909.495n 0.0v 1909.505n 1.7v 1919.495n 1.7v 1919.505n 0.0v 1929.495n 0.0v 1929.505n 0.0v 1939.495n 0.0v 1939.505n 1.7v 1949.495n 1.7v 1949.505n 0.0v 1959.495n 0.0v 1959.505n 0.0v 1969.495n 0.0v 1969.505n 1.7v 1979.495n 1.7v 1979.505n 0.0v 1989.495n 0.0v 1989.505n 0.0v 1999.495n 0.0v 1999.505n 1.7v 2009.495n 1.7v 2009.505n 0.0v 2019.495n 0.0v 2019.505n 1.7v 2029.495n 1.7v 2029.505n 1.7v 2039.495n 1.7v 2039.505n 1.7v 2049.495n 1.7v 2049.505n 1.7v )
* (time, data): [(0, 0), (10, 0), (20, 0), (30, 1), (40, 1), (50, 1), (60, 1), (70, 1), (80, 1), (90, 1), (100, 1), (110, 0), (120, 0), (130, 0), (140, 0), (150, 0), (160, 0), (170, 0), (180, 0), (190, 1), (200, 1), (210, 0), (220, 0), (230, 0), (240, 0), (250, 0), (260, 0), (270, 0), (280, 0), (290, 0), (300, 0), (310, 1), (320, 1), (330, 1), (340, 1), (350, 1), (360, 1), (370, 1), (380, 1), (390, 1), (400, 1), (410, 1), (420, 1), (430, 1), (440, 1), (450, 1), (460, 0), (470, 1), (480, 1), (490, 1), (500, 1), (510, 1), (520, 1), (530, 1), (540, 1), (550, 0), (560, 0), (570, 0), (580, 0), (590, 0), (600, 0), (610, 0), (620, 0), (630, 0), (640, 0), (650, 1), (660, 1), (670, 1), (680, 0), (690, 0), (700, 0), (710, 1), (720, 1), (730, 1), (740, 1), (750, 1), (760, 1), (770, 1), (780, 0), (790, 0), (800, 0), (810, 0), (820, 1), (830, 1), (840, 1), (850, 1), (860, 0), (870, 1), (880, 0), (890, 0), (900, 0), (910, 0), (920, 0), (930, 0), (940, 0), (950, 0), (960, 0), (970, 1), (980, 1), (990, 0), (1000, 0), (1010, 1), (1020, 0), (1030, 0), (1040, 0), (1050, 0), (1060, 0), (1070, 1), (1080, 1), (1090, 0), (1100, 1), (1110, 0), (1120, 0), (1130, 1), (1140, 1), (1150, 1), (1160, 1), (1170, 0), (1180, 0), (1190, 0), (1200, 0), (1210, 0), (1220, 1), (1230, 0), (1240, 0), (1250, 1), (1260, 1), (1270, 1), (1280, 1), (1290, 1), (1300, 0), (1310, 0), (1320, 0), (1330, 0), (1340, 0), (1350, 0), (1360, 1), (1370, 0), (1380, 0), (1390, 0), (1400, 0), (1410, 0), (1420, 0), (1430, 0), (1440, 0), (1450, 0), (1460, 0), (1470, 0), (1480, 0), (1490, 0), (1500, 0), (1510, 0), (1520, 0), (1530, 0), (1540, 1), (1550, 1), (1560, 1), (1570, 1), (1580, 0), (1590, 0), (1600, 0), (1610, 0), (1620, 1), (1630, 0), (1640, 0), (1650, 0), (1660, 1), (1670, 1), (1680, 1), (1690, 1), (1700, 1), (1710, 0), (1720, 0), (1730, 0), (1740, 0), (1750, 0), (1760, 0), (1770, 0), (1780, 0), (1790, 0), (1800, 1), (1810, 1), (1820, 1), (1830, 1), (1840, 0), (1850, 0), (1860, 1), (1870, 1), (1880, 1), (1890, 1), (1900, 1), (1910, 0), (1920, 0), (1930, 0), (1940, 0), (1950, 0), (1960, 0), (1970, 1), (1980, 1), (1990, 1), (2000, 0), (2010, 1), (2020, 0), (2030, 0), (2040, 0), (2050, 0)]
Vdin0_9  din0_9  0 PWL (0n 0.0v 9.495n 0.0v 9.505n 0.0v 19.495n 0.0v 19.505n 0.0v 29.495n 0.0v 29.505n 1.7v 39.495n 1.7v 39.505n 1.7v 49.495n 1.7v 49.505n 1.7v 59.495n 1.7v 59.505n 1.7v 69.495n 1.7v 69.505n 1.7v 79.495n 1.7v 79.505n 1.7v 89.495n 1.7v 89.505n 1.7v 99.495n 1.7v 99.505n 1.7v 109.495n 1.7v 109.505n 0.0v 119.495n 0.0v 119.505n 0.0v 129.495n 0.0v 129.505n 0.0v 139.495n 0.0v 139.505n 0.0v 149.495n 0.0v 149.505n 0.0v 159.495n 0.0v 159.505n 0.0v 169.495n 0.0v 169.505n 0.0v 179.495n 0.0v 179.505n 0.0v 189.495n 0.0v 189.505n 1.7v 199.495n 1.7v 199.505n 1.7v 209.495n 1.7v 209.505n 0.0v 219.495n 0.0v 219.505n 0.0v 229.495n 0.0v 229.505n 0.0v 239.495n 0.0v 239.505n 0.0v 249.495n 0.0v 249.505n 0.0v 259.495n 0.0v 259.505n 0.0v 269.495n 0.0v 269.505n 0.0v 279.495n 0.0v 279.505n 0.0v 289.495n 0.0v 289.505n 0.0v 299.495n 0.0v 299.505n 0.0v 309.495n 0.0v 309.505n 1.7v 319.495n 1.7v 319.505n 1.7v 329.495n 1.7v 329.505n 1.7v 339.495n 1.7v 339.505n 1.7v 349.495n 1.7v 349.505n 1.7v 359.495n 1.7v 359.505n 1.7v 369.495n 1.7v 369.505n 1.7v 379.495n 1.7v 379.505n 1.7v 389.495n 1.7v 389.505n 1.7v 399.495n 1.7v 399.505n 1.7v 409.495n 1.7v 409.505n 1.7v 419.495n 1.7v 419.505n 1.7v 429.495n 1.7v 429.505n 1.7v 439.495n 1.7v 439.505n 1.7v 449.495n 1.7v 449.505n 1.7v 459.495n 1.7v 459.505n 0.0v 469.495n 0.0v 469.505n 1.7v 479.495n 1.7v 479.505n 1.7v 489.495n 1.7v 489.505n 1.7v 499.495n 1.7v 499.505n 1.7v 509.495n 1.7v 509.505n 1.7v 519.495n 1.7v 519.505n 1.7v 529.495n 1.7v 529.505n 1.7v 539.495n 1.7v 539.505n 1.7v 549.495n 1.7v 549.505n 0.0v 559.495n 0.0v 559.505n 0.0v 569.495n 0.0v 569.505n 0.0v 579.495n 0.0v 579.505n 0.0v 589.495n 0.0v 589.505n 0.0v 599.495n 0.0v 599.505n 0.0v 609.495n 0.0v 609.505n 0.0v 619.495n 0.0v 619.505n 0.0v 629.495n 0.0v 629.505n 0.0v 639.495n 0.0v 639.505n 0.0v 649.495n 0.0v 649.505n 1.7v 659.495n 1.7v 659.505n 1.7v 669.495n 1.7v 669.505n 1.7v 679.495n 1.7v 679.505n 0.0v 689.495n 0.0v 689.505n 0.0v 699.495n 0.0v 699.505n 0.0v 709.495n 0.0v 709.505n 1.7v 719.495n 1.7v 719.505n 1.7v 729.495n 1.7v 729.505n 1.7v 739.495n 1.7v 739.505n 1.7v 749.495n 1.7v 749.505n 1.7v 759.495n 1.7v 759.505n 1.7v 769.495n 1.7v 769.505n 1.7v 779.495n 1.7v 779.505n 0.0v 789.495n 0.0v 789.505n 0.0v 799.495n 0.0v 799.505n 0.0v 809.495n 0.0v 809.505n 0.0v 819.495n 0.0v 819.505n 1.7v 829.495n 1.7v 829.505n 1.7v 839.495n 1.7v 839.505n 1.7v 849.495n 1.7v 849.505n 1.7v 859.495n 1.7v 859.505n 0.0v 869.495n 0.0v 869.505n 1.7v 879.495n 1.7v 879.505n 0.0v 889.495n 0.0v 889.505n 0.0v 899.495n 0.0v 899.505n 0.0v 909.495n 0.0v 909.505n 0.0v 919.495n 0.0v 919.505n 0.0v 929.495n 0.0v 929.505n 0.0v 939.495n 0.0v 939.505n 0.0v 949.495n 0.0v 949.505n 0.0v 959.495n 0.0v 959.505n 0.0v 969.495n 0.0v 969.505n 1.7v 979.495n 1.7v 979.505n 1.7v 989.495n 1.7v 989.505n 0.0v 999.495n 0.0v 999.505n 0.0v 1009.495n 0.0v 1009.505n 1.7v 1019.495n 1.7v 1019.505n 0.0v 1029.495n 0.0v 1029.505n 0.0v 1039.495n 0.0v 1039.505n 0.0v 1049.495n 0.0v 1049.505n 0.0v 1059.495n 0.0v 1059.505n 0.0v 1069.495n 0.0v 1069.505n 1.7v 1079.495n 1.7v 1079.505n 1.7v 1089.495n 1.7v 1089.505n 0.0v 1099.495n 0.0v 1099.505n 1.7v 1109.495n 1.7v 1109.505n 0.0v 1119.495n 0.0v 1119.505n 0.0v 1129.495n 0.0v 1129.505n 1.7v 1139.495n 1.7v 1139.505n 1.7v 1149.495n 1.7v 1149.505n 1.7v 1159.495n 1.7v 1159.505n 1.7v 1169.495n 1.7v 1169.505n 0.0v 1179.495n 0.0v 1179.505n 0.0v 1189.495n 0.0v 1189.505n 0.0v 1199.495n 0.0v 1199.505n 0.0v 1209.495n 0.0v 1209.505n 0.0v 1219.495n 0.0v 1219.505n 1.7v 1229.495n 1.7v 1229.505n 0.0v 1239.495n 0.0v 1239.505n 0.0v 1249.495n 0.0v 1249.505n 1.7v 1259.495n 1.7v 1259.505n 1.7v 1269.495n 1.7v 1269.505n 1.7v 1279.495n 1.7v 1279.505n 1.7v 1289.495n 1.7v 1289.505n 1.7v 1299.495n 1.7v 1299.505n 0.0v 1309.495n 0.0v 1309.505n 0.0v 1319.495n 0.0v 1319.505n 0.0v 1329.495n 0.0v 1329.505n 0.0v 1339.495n 0.0v 1339.505n 0.0v 1349.495n 0.0v 1349.505n 0.0v 1359.495n 0.0v 1359.505n 1.7v 1369.495n 1.7v 1369.505n 0.0v 1379.495n 0.0v 1379.505n 0.0v 1389.495n 0.0v 1389.505n 0.0v 1399.495n 0.0v 1399.505n 0.0v 1409.495n 0.0v 1409.505n 0.0v 1419.495n 0.0v 1419.505n 0.0v 1429.495n 0.0v 1429.505n 0.0v 1439.495n 0.0v 1439.505n 0.0v 1449.495n 0.0v 1449.505n 0.0v 1459.495n 0.0v 1459.505n 0.0v 1469.495n 0.0v 1469.505n 0.0v 1479.495n 0.0v 1479.505n 0.0v 1489.495n 0.0v 1489.505n 0.0v 1499.495n 0.0v 1499.505n 0.0v 1509.495n 0.0v 1509.505n 0.0v 1519.495n 0.0v 1519.505n 0.0v 1529.495n 0.0v 1529.505n 0.0v 1539.495n 0.0v 1539.505n 1.7v 1549.495n 1.7v 1549.505n 1.7v 1559.495n 1.7v 1559.505n 1.7v 1569.495n 1.7v 1569.505n 1.7v 1579.495n 1.7v 1579.505n 0.0v 1589.495n 0.0v 1589.505n 0.0v 1599.495n 0.0v 1599.505n 0.0v 1609.495n 0.0v 1609.505n 0.0v 1619.495n 0.0v 1619.505n 1.7v 1629.495n 1.7v 1629.505n 0.0v 1639.495n 0.0v 1639.505n 0.0v 1649.495n 0.0v 1649.505n 0.0v 1659.495n 0.0v 1659.505n 1.7v 1669.495n 1.7v 1669.505n 1.7v 1679.495n 1.7v 1679.505n 1.7v 1689.495n 1.7v 1689.505n 1.7v 1699.495n 1.7v 1699.505n 1.7v 1709.495n 1.7v 1709.505n 0.0v 1719.495n 0.0v 1719.505n 0.0v 1729.495n 0.0v 1729.505n 0.0v 1739.495n 0.0v 1739.505n 0.0v 1749.495n 0.0v 1749.505n 0.0v 1759.495n 0.0v 1759.505n 0.0v 1769.495n 0.0v 1769.505n 0.0v 1779.495n 0.0v 1779.505n 0.0v 1789.495n 0.0v 1789.505n 0.0v 1799.495n 0.0v 1799.505n 1.7v 1809.495n 1.7v 1809.505n 1.7v 1819.495n 1.7v 1819.505n 1.7v 1829.495n 1.7v 1829.505n 1.7v 1839.495n 1.7v 1839.505n 0.0v 1849.495n 0.0v 1849.505n 0.0v 1859.495n 0.0v 1859.505n 1.7v 1869.495n 1.7v 1869.505n 1.7v 1879.495n 1.7v 1879.505n 1.7v 1889.495n 1.7v 1889.505n 1.7v 1899.495n 1.7v 1899.505n 1.7v 1909.495n 1.7v 1909.505n 0.0v 1919.495n 0.0v 1919.505n 0.0v 1929.495n 0.0v 1929.505n 0.0v 1939.495n 0.0v 1939.505n 0.0v 1949.495n 0.0v 1949.505n 0.0v 1959.495n 0.0v 1959.505n 0.0v 1969.495n 0.0v 1969.505n 1.7v 1979.495n 1.7v 1979.505n 1.7v 1989.495n 1.7v 1989.505n 1.7v 1999.495n 1.7v 1999.505n 0.0v 2009.495n 0.0v 2009.505n 1.7v 2019.495n 1.7v 2019.505n 0.0v 2029.495n 0.0v 2029.505n 0.0v 2039.495n 0.0v 2039.505n 0.0v 2049.495n 0.0v 2049.505n 0.0v )
* (time, data): [(0, 0), (10, 1), (20, 1), (30, 1), (40, 1), (50, 1), (60, 1), (70, 1), (80, 1), (90, 1), (100, 1), (110, 1), (120, 1), (130, 1), (140, 1), (150, 1), (160, 1), (170, 1), (180, 1), (190, 0), (200, 0), (210, 0), (220, 0), (230, 0), (240, 0), (250, 0), (260, 0), (270, 0), (280, 0), (290, 0), (300, 0), (310, 1), (320, 1), (330, 0), (340, 0), (350, 0), (360, 0), (370, 0), (380, 0), (390, 0), (400, 0), (410, 0), (420, 0), (430, 0), (440, 1), (450, 1), (460, 1), (470, 0), (480, 0), (490, 0), (500, 0), (510, 1), (520, 1), (530, 1), (540, 1), (550, 0), (560, 1), (570, 1), (580, 1), (590, 1), (600, 1), (610, 0), (620, 1), (630, 1), (640, 1), (650, 0), (660, 0), (670, 1), (680, 1), (690, 1), (700, 1), (710, 1), (720, 1), (730, 1), (740, 1), (750, 1), (760, 1), (770, 0), (780, 1), (790, 0), (800, 1), (810, 1), (820, 0), (830, 0), (840, 1), (850, 1), (860, 1), (870, 1), (880, 0), (890, 0), (900, 1), (910, 1), (920, 0), (930, 0), (940, 0), (950, 0), (960, 0), (970, 0), (980, 1), (990, 0), (1000, 0), (1010, 0), (1020, 1), (1030, 0), (1040, 0), (1050, 0), (1060, 0), (1070, 0), (1080, 0), (1090, 1), (1100, 0), (1110, 0), (1120, 0), (1130, 0), (1140, 0), (1150, 0), (1160, 0), (1170, 1), (1180, 1), (1190, 1), (1200, 1), (1210, 1), (1220, 1), (1230, 0), (1240, 1), (1250, 1), (1260, 1), (1270, 1), (1280, 1), (1290, 0), (1300, 0), (1310, 0), (1320, 0), (1330, 0), (1340, 1), (1350, 1), (1360, 1), (1370, 1), (1380, 1), (1390, 1), (1400, 0), (1410, 0), (1420, 0), (1430, 0), (1440, 0), (1450, 0), (1460, 0), (1470, 0), (1480, 0), (1490, 0), (1500, 0), (1510, 1), (1520, 1), (1530, 1), (1540, 1), (1550, 0), (1560, 1), (1570, 1), (1580, 0), (1590, 0), (1600, 0), (1610, 0), (1620, 0), (1630, 0), (1640, 0), (1650, 1), (1660, 0), (1670, 0), (1680, 0), (1690, 0), (1700, 0), (1710, 1), (1720, 1), (1730, 1), (1740, 1), (1750, 0), (1760, 0), (1770, 0), (1780, 0), (1790, 0), (1800, 0), (1810, 0), (1820, 0), (1830, 0), (1840, 0), (1850, 0), (1860, 1), (1870, 1), (1880, 1), (1890, 1), (1900, 1), (1910, 1), (1920, 0), (1930, 0), (1940, 0), (1950, 0), (1960, 0), (1970, 0), (1980, 0), (1990, 0), (2000, 1), (2010, 1), (2020, 0), (2030, 0), (2040, 0), (2050, 0)]
Vdin0_10  din0_10  0 PWL (0n 0.0v 9.495n 0.0v 9.505n 1.7v 19.495n 1.7v 19.505n 1.7v 29.495n 1.7v 29.505n 1.7v 39.495n 1.7v 39.505n 1.7v 49.495n 1.7v 49.505n 1.7v 59.495n 1.7v 59.505n 1.7v 69.495n 1.7v 69.505n 1.7v 79.495n 1.7v 79.505n 1.7v 89.495n 1.7v 89.505n 1.7v 99.495n 1.7v 99.505n 1.7v 109.495n 1.7v 109.505n 1.7v 119.495n 1.7v 119.505n 1.7v 129.495n 1.7v 129.505n 1.7v 139.495n 1.7v 139.505n 1.7v 149.495n 1.7v 149.505n 1.7v 159.495n 1.7v 159.505n 1.7v 169.495n 1.7v 169.505n 1.7v 179.495n 1.7v 179.505n 1.7v 189.495n 1.7v 189.505n 0.0v 199.495n 0.0v 199.505n 0.0v 209.495n 0.0v 209.505n 0.0v 219.495n 0.0v 219.505n 0.0v 229.495n 0.0v 229.505n 0.0v 239.495n 0.0v 239.505n 0.0v 249.495n 0.0v 249.505n 0.0v 259.495n 0.0v 259.505n 0.0v 269.495n 0.0v 269.505n 0.0v 279.495n 0.0v 279.505n 0.0v 289.495n 0.0v 289.505n 0.0v 299.495n 0.0v 299.505n 0.0v 309.495n 0.0v 309.505n 1.7v 319.495n 1.7v 319.505n 1.7v 329.495n 1.7v 329.505n 0.0v 339.495n 0.0v 339.505n 0.0v 349.495n 0.0v 349.505n 0.0v 359.495n 0.0v 359.505n 0.0v 369.495n 0.0v 369.505n 0.0v 379.495n 0.0v 379.505n 0.0v 389.495n 0.0v 389.505n 0.0v 399.495n 0.0v 399.505n 0.0v 409.495n 0.0v 409.505n 0.0v 419.495n 0.0v 419.505n 0.0v 429.495n 0.0v 429.505n 0.0v 439.495n 0.0v 439.505n 1.7v 449.495n 1.7v 449.505n 1.7v 459.495n 1.7v 459.505n 1.7v 469.495n 1.7v 469.505n 0.0v 479.495n 0.0v 479.505n 0.0v 489.495n 0.0v 489.505n 0.0v 499.495n 0.0v 499.505n 0.0v 509.495n 0.0v 509.505n 1.7v 519.495n 1.7v 519.505n 1.7v 529.495n 1.7v 529.505n 1.7v 539.495n 1.7v 539.505n 1.7v 549.495n 1.7v 549.505n 0.0v 559.495n 0.0v 559.505n 1.7v 569.495n 1.7v 569.505n 1.7v 579.495n 1.7v 579.505n 1.7v 589.495n 1.7v 589.505n 1.7v 599.495n 1.7v 599.505n 1.7v 609.495n 1.7v 609.505n 0.0v 619.495n 0.0v 619.505n 1.7v 629.495n 1.7v 629.505n 1.7v 639.495n 1.7v 639.505n 1.7v 649.495n 1.7v 649.505n 0.0v 659.495n 0.0v 659.505n 0.0v 669.495n 0.0v 669.505n 1.7v 679.495n 1.7v 679.505n 1.7v 689.495n 1.7v 689.505n 1.7v 699.495n 1.7v 699.505n 1.7v 709.495n 1.7v 709.505n 1.7v 719.495n 1.7v 719.505n 1.7v 729.495n 1.7v 729.505n 1.7v 739.495n 1.7v 739.505n 1.7v 749.495n 1.7v 749.505n 1.7v 759.495n 1.7v 759.505n 1.7v 769.495n 1.7v 769.505n 0.0v 779.495n 0.0v 779.505n 1.7v 789.495n 1.7v 789.505n 0.0v 799.495n 0.0v 799.505n 1.7v 809.495n 1.7v 809.505n 1.7v 819.495n 1.7v 819.505n 0.0v 829.495n 0.0v 829.505n 0.0v 839.495n 0.0v 839.505n 1.7v 849.495n 1.7v 849.505n 1.7v 859.495n 1.7v 859.505n 1.7v 869.495n 1.7v 869.505n 1.7v 879.495n 1.7v 879.505n 0.0v 889.495n 0.0v 889.505n 0.0v 899.495n 0.0v 899.505n 1.7v 909.495n 1.7v 909.505n 1.7v 919.495n 1.7v 919.505n 0.0v 929.495n 0.0v 929.505n 0.0v 939.495n 0.0v 939.505n 0.0v 949.495n 0.0v 949.505n 0.0v 959.495n 0.0v 959.505n 0.0v 969.495n 0.0v 969.505n 0.0v 979.495n 0.0v 979.505n 1.7v 989.495n 1.7v 989.505n 0.0v 999.495n 0.0v 999.505n 0.0v 1009.495n 0.0v 1009.505n 0.0v 1019.495n 0.0v 1019.505n 1.7v 1029.495n 1.7v 1029.505n 0.0v 1039.495n 0.0v 1039.505n 0.0v 1049.495n 0.0v 1049.505n 0.0v 1059.495n 0.0v 1059.505n 0.0v 1069.495n 0.0v 1069.505n 0.0v 1079.495n 0.0v 1079.505n 0.0v 1089.495n 0.0v 1089.505n 1.7v 1099.495n 1.7v 1099.505n 0.0v 1109.495n 0.0v 1109.505n 0.0v 1119.495n 0.0v 1119.505n 0.0v 1129.495n 0.0v 1129.505n 0.0v 1139.495n 0.0v 1139.505n 0.0v 1149.495n 0.0v 1149.505n 0.0v 1159.495n 0.0v 1159.505n 0.0v 1169.495n 0.0v 1169.505n 1.7v 1179.495n 1.7v 1179.505n 1.7v 1189.495n 1.7v 1189.505n 1.7v 1199.495n 1.7v 1199.505n 1.7v 1209.495n 1.7v 1209.505n 1.7v 1219.495n 1.7v 1219.505n 1.7v 1229.495n 1.7v 1229.505n 0.0v 1239.495n 0.0v 1239.505n 1.7v 1249.495n 1.7v 1249.505n 1.7v 1259.495n 1.7v 1259.505n 1.7v 1269.495n 1.7v 1269.505n 1.7v 1279.495n 1.7v 1279.505n 1.7v 1289.495n 1.7v 1289.505n 0.0v 1299.495n 0.0v 1299.505n 0.0v 1309.495n 0.0v 1309.505n 0.0v 1319.495n 0.0v 1319.505n 0.0v 1329.495n 0.0v 1329.505n 0.0v 1339.495n 0.0v 1339.505n 1.7v 1349.495n 1.7v 1349.505n 1.7v 1359.495n 1.7v 1359.505n 1.7v 1369.495n 1.7v 1369.505n 1.7v 1379.495n 1.7v 1379.505n 1.7v 1389.495n 1.7v 1389.505n 1.7v 1399.495n 1.7v 1399.505n 0.0v 1409.495n 0.0v 1409.505n 0.0v 1419.495n 0.0v 1419.505n 0.0v 1429.495n 0.0v 1429.505n 0.0v 1439.495n 0.0v 1439.505n 0.0v 1449.495n 0.0v 1449.505n 0.0v 1459.495n 0.0v 1459.505n 0.0v 1469.495n 0.0v 1469.505n 0.0v 1479.495n 0.0v 1479.505n 0.0v 1489.495n 0.0v 1489.505n 0.0v 1499.495n 0.0v 1499.505n 0.0v 1509.495n 0.0v 1509.505n 1.7v 1519.495n 1.7v 1519.505n 1.7v 1529.495n 1.7v 1529.505n 1.7v 1539.495n 1.7v 1539.505n 1.7v 1549.495n 1.7v 1549.505n 0.0v 1559.495n 0.0v 1559.505n 1.7v 1569.495n 1.7v 1569.505n 1.7v 1579.495n 1.7v 1579.505n 0.0v 1589.495n 0.0v 1589.505n 0.0v 1599.495n 0.0v 1599.505n 0.0v 1609.495n 0.0v 1609.505n 0.0v 1619.495n 0.0v 1619.505n 0.0v 1629.495n 0.0v 1629.505n 0.0v 1639.495n 0.0v 1639.505n 0.0v 1649.495n 0.0v 1649.505n 1.7v 1659.495n 1.7v 1659.505n 0.0v 1669.495n 0.0v 1669.505n 0.0v 1679.495n 0.0v 1679.505n 0.0v 1689.495n 0.0v 1689.505n 0.0v 1699.495n 0.0v 1699.505n 0.0v 1709.495n 0.0v 1709.505n 1.7v 1719.495n 1.7v 1719.505n 1.7v 1729.495n 1.7v 1729.505n 1.7v 1739.495n 1.7v 1739.505n 1.7v 1749.495n 1.7v 1749.505n 0.0v 1759.495n 0.0v 1759.505n 0.0v 1769.495n 0.0v 1769.505n 0.0v 1779.495n 0.0v 1779.505n 0.0v 1789.495n 0.0v 1789.505n 0.0v 1799.495n 0.0v 1799.505n 0.0v 1809.495n 0.0v 1809.505n 0.0v 1819.495n 0.0v 1819.505n 0.0v 1829.495n 0.0v 1829.505n 0.0v 1839.495n 0.0v 1839.505n 0.0v 1849.495n 0.0v 1849.505n 0.0v 1859.495n 0.0v 1859.505n 1.7v 1869.495n 1.7v 1869.505n 1.7v 1879.495n 1.7v 1879.505n 1.7v 1889.495n 1.7v 1889.505n 1.7v 1899.495n 1.7v 1899.505n 1.7v 1909.495n 1.7v 1909.505n 1.7v 1919.495n 1.7v 1919.505n 0.0v 1929.495n 0.0v 1929.505n 0.0v 1939.495n 0.0v 1939.505n 0.0v 1949.495n 0.0v 1949.505n 0.0v 1959.495n 0.0v 1959.505n 0.0v 1969.495n 0.0v 1969.505n 0.0v 1979.495n 0.0v 1979.505n 0.0v 1989.495n 0.0v 1989.505n 0.0v 1999.495n 0.0v 1999.505n 1.7v 2009.495n 1.7v 2009.505n 1.7v 2019.495n 1.7v 2019.505n 0.0v 2029.495n 0.0v 2029.505n 0.0v 2039.495n 0.0v 2039.505n 0.0v 2049.495n 0.0v 2049.505n 0.0v )
* (time, data): [(0, 0), (10, 0), (20, 0), (30, 0), (40, 0), (50, 0), (60, 1), (70, 1), (80, 1), (90, 1), (100, 0), (110, 1), (120, 1), (130, 1), (140, 1), (150, 0), (160, 0), (170, 0), (180, 0), (190, 0), (200, 0), (210, 0), (220, 0), (230, 0), (240, 0), (250, 0), (260, 0), (270, 0), (280, 1), (290, 1), (300, 1), (310, 1), (320, 1), (330, 0), (340, 0), (350, 0), (360, 0), (370, 0), (380, 0), (390, 0), (400, 0), (410, 0), (420, 0), (430, 0), (440, 1), (450, 1), (460, 0), (470, 0), (480, 0), (490, 0), (500, 0), (510, 0), (520, 0), (530, 0), (540, 0), (550, 0), (560, 1), (570, 1), (580, 1), (590, 1), (600, 0), (610, 1), (620, 0), (630, 1), (640, 1), (650, 0), (660, 0), (670, 0), (680, 0), (690, 0), (700, 0), (710, 1), (720, 1), (730, 1), (740, 0), (750, 0), (760, 0), (770, 0), (780, 0), (790, 0), (800, 1), (810, 1), (820, 0), (830, 0), (840, 1), (850, 1), (860, 1), (870, 0), (880, 1), (890, 1), (900, 0), (910, 0), (920, 1), (930, 1), (940, 1), (950, 1), (960, 1), (970, 1), (980, 0), (990, 1), (1000, 1), (1010, 0), (1020, 0), (1030, 0), (1040, 0), (1050, 0), (1060, 0), (1070, 1), (1080, 0), (1090, 0), (1100, 0), (1110, 1), (1120, 1), (1130, 0), (1140, 0), (1150, 1), (1160, 1), (1170, 1), (1180, 1), (1190, 1), (1200, 1), (1210, 1), (1220, 1), (1230, 1), (1240, 1), (1250, 1), (1260, 1), (1270, 1), (1280, 1), (1290, 1), (1300, 1), (1310, 1), (1320, 1), (1330, 1), (1340, 0), (1350, 0), (1360, 1), (1370, 1), (1380, 1), (1390, 1), (1400, 1), (1410, 1), (1420, 1), (1430, 1), (1440, 1), (1450, 1), (1460, 1), (1470, 1), (1480, 1), (1490, 1), (1500, 1), (1510, 1), (1520, 1), (1530, 1), (1540, 1), (1550, 1), (1560, 1), (1570, 1), (1580, 0), (1590, 0), (1600, 0), (1610, 0), (1620, 1), (1630, 0), (1640, 0), (1650, 0), (1660, 0), (1670, 0), (1680, 0), (1690, 0), (1700, 0), (1710, 0), (1720, 0), (1730, 1), (1740, 1), (1750, 0), (1760, 0), (1770, 0), (1780, 0), (1790, 0), (1800, 1), (1810, 1), (1820, 1), (1830, 1), (1840, 1), (1850, 1), (1860, 0), (1870, 0), (1880, 0), (1890, 0), (1900, 0), (1910, 1), (1920, 1), (1930, 1), (1940, 0), (1950, 0), (1960, 0), (1970, 1), (1980, 1), (1990, 1), (2000, 1), (2010, 1), (2020, 0), (2030, 0), (2040, 0), (2050, 0)]
Vdin0_11  din0_11  0 PWL (0n 0.0v 9.495n 0.0v 9.505n 0.0v 19.495n 0.0v 19.505n 0.0v 29.495n 0.0v 29.505n 0.0v 39.495n 0.0v 39.505n 0.0v 49.495n 0.0v 49.505n 0.0v 59.495n 0.0v 59.505n 1.7v 69.495n 1.7v 69.505n 1.7v 79.495n 1.7v 79.505n 1.7v 89.495n 1.7v 89.505n 1.7v 99.495n 1.7v 99.505n 0.0v 109.495n 0.0v 109.505n 1.7v 119.495n 1.7v 119.505n 1.7v 129.495n 1.7v 129.505n 1.7v 139.495n 1.7v 139.505n 1.7v 149.495n 1.7v 149.505n 0.0v 159.495n 0.0v 159.505n 0.0v 169.495n 0.0v 169.505n 0.0v 179.495n 0.0v 179.505n 0.0v 189.495n 0.0v 189.505n 0.0v 199.495n 0.0v 199.505n 0.0v 209.495n 0.0v 209.505n 0.0v 219.495n 0.0v 219.505n 0.0v 229.495n 0.0v 229.505n 0.0v 239.495n 0.0v 239.505n 0.0v 249.495n 0.0v 249.505n 0.0v 259.495n 0.0v 259.505n 0.0v 269.495n 0.0v 269.505n 0.0v 279.495n 0.0v 279.505n 1.7v 289.495n 1.7v 289.505n 1.7v 299.495n 1.7v 299.505n 1.7v 309.495n 1.7v 309.505n 1.7v 319.495n 1.7v 319.505n 1.7v 329.495n 1.7v 329.505n 0.0v 339.495n 0.0v 339.505n 0.0v 349.495n 0.0v 349.505n 0.0v 359.495n 0.0v 359.505n 0.0v 369.495n 0.0v 369.505n 0.0v 379.495n 0.0v 379.505n 0.0v 389.495n 0.0v 389.505n 0.0v 399.495n 0.0v 399.505n 0.0v 409.495n 0.0v 409.505n 0.0v 419.495n 0.0v 419.505n 0.0v 429.495n 0.0v 429.505n 0.0v 439.495n 0.0v 439.505n 1.7v 449.495n 1.7v 449.505n 1.7v 459.495n 1.7v 459.505n 0.0v 469.495n 0.0v 469.505n 0.0v 479.495n 0.0v 479.505n 0.0v 489.495n 0.0v 489.505n 0.0v 499.495n 0.0v 499.505n 0.0v 509.495n 0.0v 509.505n 0.0v 519.495n 0.0v 519.505n 0.0v 529.495n 0.0v 529.505n 0.0v 539.495n 0.0v 539.505n 0.0v 549.495n 0.0v 549.505n 0.0v 559.495n 0.0v 559.505n 1.7v 569.495n 1.7v 569.505n 1.7v 579.495n 1.7v 579.505n 1.7v 589.495n 1.7v 589.505n 1.7v 599.495n 1.7v 599.505n 0.0v 609.495n 0.0v 609.505n 1.7v 619.495n 1.7v 619.505n 0.0v 629.495n 0.0v 629.505n 1.7v 639.495n 1.7v 639.505n 1.7v 649.495n 1.7v 649.505n 0.0v 659.495n 0.0v 659.505n 0.0v 669.495n 0.0v 669.505n 0.0v 679.495n 0.0v 679.505n 0.0v 689.495n 0.0v 689.505n 0.0v 699.495n 0.0v 699.505n 0.0v 709.495n 0.0v 709.505n 1.7v 719.495n 1.7v 719.505n 1.7v 729.495n 1.7v 729.505n 1.7v 739.495n 1.7v 739.505n 0.0v 749.495n 0.0v 749.505n 0.0v 759.495n 0.0v 759.505n 0.0v 769.495n 0.0v 769.505n 0.0v 779.495n 0.0v 779.505n 0.0v 789.495n 0.0v 789.505n 0.0v 799.495n 0.0v 799.505n 1.7v 809.495n 1.7v 809.505n 1.7v 819.495n 1.7v 819.505n 0.0v 829.495n 0.0v 829.505n 0.0v 839.495n 0.0v 839.505n 1.7v 849.495n 1.7v 849.505n 1.7v 859.495n 1.7v 859.505n 1.7v 869.495n 1.7v 869.505n 0.0v 879.495n 0.0v 879.505n 1.7v 889.495n 1.7v 889.505n 1.7v 899.495n 1.7v 899.505n 0.0v 909.495n 0.0v 909.505n 0.0v 919.495n 0.0v 919.505n 1.7v 929.495n 1.7v 929.505n 1.7v 939.495n 1.7v 939.505n 1.7v 949.495n 1.7v 949.505n 1.7v 959.495n 1.7v 959.505n 1.7v 969.495n 1.7v 969.505n 1.7v 979.495n 1.7v 979.505n 0.0v 989.495n 0.0v 989.505n 1.7v 999.495n 1.7v 999.505n 1.7v 1009.495n 1.7v 1009.505n 0.0v 1019.495n 0.0v 1019.505n 0.0v 1029.495n 0.0v 1029.505n 0.0v 1039.495n 0.0v 1039.505n 0.0v 1049.495n 0.0v 1049.505n 0.0v 1059.495n 0.0v 1059.505n 0.0v 1069.495n 0.0v 1069.505n 1.7v 1079.495n 1.7v 1079.505n 0.0v 1089.495n 0.0v 1089.505n 0.0v 1099.495n 0.0v 1099.505n 0.0v 1109.495n 0.0v 1109.505n 1.7v 1119.495n 1.7v 1119.505n 1.7v 1129.495n 1.7v 1129.505n 0.0v 1139.495n 0.0v 1139.505n 0.0v 1149.495n 0.0v 1149.505n 1.7v 1159.495n 1.7v 1159.505n 1.7v 1169.495n 1.7v 1169.505n 1.7v 1179.495n 1.7v 1179.505n 1.7v 1189.495n 1.7v 1189.505n 1.7v 1199.495n 1.7v 1199.505n 1.7v 1209.495n 1.7v 1209.505n 1.7v 1219.495n 1.7v 1219.505n 1.7v 1229.495n 1.7v 1229.505n 1.7v 1239.495n 1.7v 1239.505n 1.7v 1249.495n 1.7v 1249.505n 1.7v 1259.495n 1.7v 1259.505n 1.7v 1269.495n 1.7v 1269.505n 1.7v 1279.495n 1.7v 1279.505n 1.7v 1289.495n 1.7v 1289.505n 1.7v 1299.495n 1.7v 1299.505n 1.7v 1309.495n 1.7v 1309.505n 1.7v 1319.495n 1.7v 1319.505n 1.7v 1329.495n 1.7v 1329.505n 1.7v 1339.495n 1.7v 1339.505n 0.0v 1349.495n 0.0v 1349.505n 0.0v 1359.495n 0.0v 1359.505n 1.7v 1369.495n 1.7v 1369.505n 1.7v 1379.495n 1.7v 1379.505n 1.7v 1389.495n 1.7v 1389.505n 1.7v 1399.495n 1.7v 1399.505n 1.7v 1409.495n 1.7v 1409.505n 1.7v 1419.495n 1.7v 1419.505n 1.7v 1429.495n 1.7v 1429.505n 1.7v 1439.495n 1.7v 1439.505n 1.7v 1449.495n 1.7v 1449.505n 1.7v 1459.495n 1.7v 1459.505n 1.7v 1469.495n 1.7v 1469.505n 1.7v 1479.495n 1.7v 1479.505n 1.7v 1489.495n 1.7v 1489.505n 1.7v 1499.495n 1.7v 1499.505n 1.7v 1509.495n 1.7v 1509.505n 1.7v 1519.495n 1.7v 1519.505n 1.7v 1529.495n 1.7v 1529.505n 1.7v 1539.495n 1.7v 1539.505n 1.7v 1549.495n 1.7v 1549.505n 1.7v 1559.495n 1.7v 1559.505n 1.7v 1569.495n 1.7v 1569.505n 1.7v 1579.495n 1.7v 1579.505n 0.0v 1589.495n 0.0v 1589.505n 0.0v 1599.495n 0.0v 1599.505n 0.0v 1609.495n 0.0v 1609.505n 0.0v 1619.495n 0.0v 1619.505n 1.7v 1629.495n 1.7v 1629.505n 0.0v 1639.495n 0.0v 1639.505n 0.0v 1649.495n 0.0v 1649.505n 0.0v 1659.495n 0.0v 1659.505n 0.0v 1669.495n 0.0v 1669.505n 0.0v 1679.495n 0.0v 1679.505n 0.0v 1689.495n 0.0v 1689.505n 0.0v 1699.495n 0.0v 1699.505n 0.0v 1709.495n 0.0v 1709.505n 0.0v 1719.495n 0.0v 1719.505n 0.0v 1729.495n 0.0v 1729.505n 1.7v 1739.495n 1.7v 1739.505n 1.7v 1749.495n 1.7v 1749.505n 0.0v 1759.495n 0.0v 1759.505n 0.0v 1769.495n 0.0v 1769.505n 0.0v 1779.495n 0.0v 1779.505n 0.0v 1789.495n 0.0v 1789.505n 0.0v 1799.495n 0.0v 1799.505n 1.7v 1809.495n 1.7v 1809.505n 1.7v 1819.495n 1.7v 1819.505n 1.7v 1829.495n 1.7v 1829.505n 1.7v 1839.495n 1.7v 1839.505n 1.7v 1849.495n 1.7v 1849.505n 1.7v 1859.495n 1.7v 1859.505n 0.0v 1869.495n 0.0v 1869.505n 0.0v 1879.495n 0.0v 1879.505n 0.0v 1889.495n 0.0v 1889.505n 0.0v 1899.495n 0.0v 1899.505n 0.0v 1909.495n 0.0v 1909.505n 1.7v 1919.495n 1.7v 1919.505n 1.7v 1929.495n 1.7v 1929.505n 1.7v 1939.495n 1.7v 1939.505n 0.0v 1949.495n 0.0v 1949.505n 0.0v 1959.495n 0.0v 1959.505n 0.0v 1969.495n 0.0v 1969.505n 1.7v 1979.495n 1.7v 1979.505n 1.7v 1989.495n 1.7v 1989.505n 1.7v 1999.495n 1.7v 1999.505n 1.7v 2009.495n 1.7v 2009.505n 1.7v 2019.495n 1.7v 2019.505n 0.0v 2029.495n 0.0v 2029.505n 0.0v 2039.495n 0.0v 2039.505n 0.0v 2049.495n 0.0v 2049.505n 0.0v )
* (time, data): [(0, 0), (10, 1), (20, 0), (30, 0), (40, 0), (50, 0), (60, 0), (70, 0), (80, 0), (90, 1), (100, 0), (110, 0), (120, 0), (130, 0), (140, 0), (150, 1), (160, 1), (170, 1), (180, 1), (190, 0), (200, 1), (210, 1), (220, 1), (230, 1), (240, 1), (250, 1), (260, 1), (270, 1), (280, 1), (290, 1), (300, 1), (310, 0), (320, 0), (330, 1), (340, 1), (350, 1), (360, 1), (370, 1), (380, 1), (390, 1), (400, 1), (410, 1), (420, 1), (430, 1), (440, 1), (450, 1), (460, 1), (470, 0), (480, 0), (490, 0), (500, 1), (510, 1), (520, 1), (530, 1), (540, 1), (550, 0), (560, 1), (570, 1), (580, 1), (590, 1), (600, 0), (610, 1), (620, 1), (630, 0), (640, 0), (650, 1), (660, 1), (670, 0), (680, 1), (690, 1), (700, 1), (710, 1), (720, 1), (730, 1), (740, 1), (750, 1), (760, 1), (770, 0), (780, 1), (790, 1), (800, 0), (810, 0), (820, 1), (830, 1), (840, 1), (850, 1), (860, 0), (870, 0), (880, 0), (890, 0), (900, 1), (910, 1), (920, 0), (930, 0), (940, 0), (950, 0), (960, 1), (970, 1), (980, 0), (990, 0), (1000, 1), (1010, 1), (1020, 1), (1030, 1), (1040, 1), (1050, 1), (1060, 1), (1070, 1), (1080, 1), (1090, 0), (1100, 0), (1110, 1), (1120, 1), (1130, 0), (1140, 1), (1150, 1), (1160, 1), (1170, 0), (1180, 0), (1190, 0), (1200, 0), (1210, 0), (1220, 0), (1230, 1), (1240, 0), (1250, 0), (1260, 0), (1270, 0), (1280, 0), (1290, 1), (1300, 0), (1310, 0), (1320, 0), (1330, 0), (1340, 1), (1350, 1), (1360, 0), (1370, 0), (1380, 0), (1390, 0), (1400, 1), (1410, 1), (1420, 1), (1430, 1), (1440, 1), (1450, 1), (1460, 1), (1470, 1), (1480, 1), (1490, 1), (1500, 0), (1510, 0), (1520, 0), (1530, 0), (1540, 1), (1550, 1), (1560, 1), (1570, 1), (1580, 1), (1590, 1), (1600, 1), (1610, 1), (1620, 0), (1630, 1), (1640, 1), (1650, 0), (1660, 0), (1670, 0), (1680, 0), (1690, 0), (1700, 0), (1710, 1), (1720, 1), (1730, 1), (1740, 1), (1750, 0), (1760, 0), (1770, 1), (1780, 0), (1790, 0), (1800, 0), (1810, 0), (1820, 0), (1830, 0), (1840, 1), (1850, 1), (1860, 1), (1870, 1), (1880, 1), (1890, 1), (1900, 1), (1910, 0), (1920, 1), (1930, 1), (1940, 0), (1950, 0), (1960, 0), (1970, 1), (1980, 1), (1990, 1), (2000, 1), (2010, 1), (2020, 0), (2030, 0), (2040, 0), (2050, 0)]
Vdin0_12  din0_12  0 PWL (0n 0.0v 9.495n 0.0v 9.505n 1.7v 19.495n 1.7v 19.505n 0.0v 29.495n 0.0v 29.505n 0.0v 39.495n 0.0v 39.505n 0.0v 49.495n 0.0v 49.505n 0.0v 59.495n 0.0v 59.505n 0.0v 69.495n 0.0v 69.505n 0.0v 79.495n 0.0v 79.505n 0.0v 89.495n 0.0v 89.505n 1.7v 99.495n 1.7v 99.505n 0.0v 109.495n 0.0v 109.505n 0.0v 119.495n 0.0v 119.505n 0.0v 129.495n 0.0v 129.505n 0.0v 139.495n 0.0v 139.505n 0.0v 149.495n 0.0v 149.505n 1.7v 159.495n 1.7v 159.505n 1.7v 169.495n 1.7v 169.505n 1.7v 179.495n 1.7v 179.505n 1.7v 189.495n 1.7v 189.505n 0.0v 199.495n 0.0v 199.505n 1.7v 209.495n 1.7v 209.505n 1.7v 219.495n 1.7v 219.505n 1.7v 229.495n 1.7v 229.505n 1.7v 239.495n 1.7v 239.505n 1.7v 249.495n 1.7v 249.505n 1.7v 259.495n 1.7v 259.505n 1.7v 269.495n 1.7v 269.505n 1.7v 279.495n 1.7v 279.505n 1.7v 289.495n 1.7v 289.505n 1.7v 299.495n 1.7v 299.505n 1.7v 309.495n 1.7v 309.505n 0.0v 319.495n 0.0v 319.505n 0.0v 329.495n 0.0v 329.505n 1.7v 339.495n 1.7v 339.505n 1.7v 349.495n 1.7v 349.505n 1.7v 359.495n 1.7v 359.505n 1.7v 369.495n 1.7v 369.505n 1.7v 379.495n 1.7v 379.505n 1.7v 389.495n 1.7v 389.505n 1.7v 399.495n 1.7v 399.505n 1.7v 409.495n 1.7v 409.505n 1.7v 419.495n 1.7v 419.505n 1.7v 429.495n 1.7v 429.505n 1.7v 439.495n 1.7v 439.505n 1.7v 449.495n 1.7v 449.505n 1.7v 459.495n 1.7v 459.505n 1.7v 469.495n 1.7v 469.505n 0.0v 479.495n 0.0v 479.505n 0.0v 489.495n 0.0v 489.505n 0.0v 499.495n 0.0v 499.505n 1.7v 509.495n 1.7v 509.505n 1.7v 519.495n 1.7v 519.505n 1.7v 529.495n 1.7v 529.505n 1.7v 539.495n 1.7v 539.505n 1.7v 549.495n 1.7v 549.505n 0.0v 559.495n 0.0v 559.505n 1.7v 569.495n 1.7v 569.505n 1.7v 579.495n 1.7v 579.505n 1.7v 589.495n 1.7v 589.505n 1.7v 599.495n 1.7v 599.505n 0.0v 609.495n 0.0v 609.505n 1.7v 619.495n 1.7v 619.505n 1.7v 629.495n 1.7v 629.505n 0.0v 639.495n 0.0v 639.505n 0.0v 649.495n 0.0v 649.505n 1.7v 659.495n 1.7v 659.505n 1.7v 669.495n 1.7v 669.505n 0.0v 679.495n 0.0v 679.505n 1.7v 689.495n 1.7v 689.505n 1.7v 699.495n 1.7v 699.505n 1.7v 709.495n 1.7v 709.505n 1.7v 719.495n 1.7v 719.505n 1.7v 729.495n 1.7v 729.505n 1.7v 739.495n 1.7v 739.505n 1.7v 749.495n 1.7v 749.505n 1.7v 759.495n 1.7v 759.505n 1.7v 769.495n 1.7v 769.505n 0.0v 779.495n 0.0v 779.505n 1.7v 789.495n 1.7v 789.505n 1.7v 799.495n 1.7v 799.505n 0.0v 809.495n 0.0v 809.505n 0.0v 819.495n 0.0v 819.505n 1.7v 829.495n 1.7v 829.505n 1.7v 839.495n 1.7v 839.505n 1.7v 849.495n 1.7v 849.505n 1.7v 859.495n 1.7v 859.505n 0.0v 869.495n 0.0v 869.505n 0.0v 879.495n 0.0v 879.505n 0.0v 889.495n 0.0v 889.505n 0.0v 899.495n 0.0v 899.505n 1.7v 909.495n 1.7v 909.505n 1.7v 919.495n 1.7v 919.505n 0.0v 929.495n 0.0v 929.505n 0.0v 939.495n 0.0v 939.505n 0.0v 949.495n 0.0v 949.505n 0.0v 959.495n 0.0v 959.505n 1.7v 969.495n 1.7v 969.505n 1.7v 979.495n 1.7v 979.505n 0.0v 989.495n 0.0v 989.505n 0.0v 999.495n 0.0v 999.505n 1.7v 1009.495n 1.7v 1009.505n 1.7v 1019.495n 1.7v 1019.505n 1.7v 1029.495n 1.7v 1029.505n 1.7v 1039.495n 1.7v 1039.505n 1.7v 1049.495n 1.7v 1049.505n 1.7v 1059.495n 1.7v 1059.505n 1.7v 1069.495n 1.7v 1069.505n 1.7v 1079.495n 1.7v 1079.505n 1.7v 1089.495n 1.7v 1089.505n 0.0v 1099.495n 0.0v 1099.505n 0.0v 1109.495n 0.0v 1109.505n 1.7v 1119.495n 1.7v 1119.505n 1.7v 1129.495n 1.7v 1129.505n 0.0v 1139.495n 0.0v 1139.505n 1.7v 1149.495n 1.7v 1149.505n 1.7v 1159.495n 1.7v 1159.505n 1.7v 1169.495n 1.7v 1169.505n 0.0v 1179.495n 0.0v 1179.505n 0.0v 1189.495n 0.0v 1189.505n 0.0v 1199.495n 0.0v 1199.505n 0.0v 1209.495n 0.0v 1209.505n 0.0v 1219.495n 0.0v 1219.505n 0.0v 1229.495n 0.0v 1229.505n 1.7v 1239.495n 1.7v 1239.505n 0.0v 1249.495n 0.0v 1249.505n 0.0v 1259.495n 0.0v 1259.505n 0.0v 1269.495n 0.0v 1269.505n 0.0v 1279.495n 0.0v 1279.505n 0.0v 1289.495n 0.0v 1289.505n 1.7v 1299.495n 1.7v 1299.505n 0.0v 1309.495n 0.0v 1309.505n 0.0v 1319.495n 0.0v 1319.505n 0.0v 1329.495n 0.0v 1329.505n 0.0v 1339.495n 0.0v 1339.505n 1.7v 1349.495n 1.7v 1349.505n 1.7v 1359.495n 1.7v 1359.505n 0.0v 1369.495n 0.0v 1369.505n 0.0v 1379.495n 0.0v 1379.505n 0.0v 1389.495n 0.0v 1389.505n 0.0v 1399.495n 0.0v 1399.505n 1.7v 1409.495n 1.7v 1409.505n 1.7v 1419.495n 1.7v 1419.505n 1.7v 1429.495n 1.7v 1429.505n 1.7v 1439.495n 1.7v 1439.505n 1.7v 1449.495n 1.7v 1449.505n 1.7v 1459.495n 1.7v 1459.505n 1.7v 1469.495n 1.7v 1469.505n 1.7v 1479.495n 1.7v 1479.505n 1.7v 1489.495n 1.7v 1489.505n 1.7v 1499.495n 1.7v 1499.505n 0.0v 1509.495n 0.0v 1509.505n 0.0v 1519.495n 0.0v 1519.505n 0.0v 1529.495n 0.0v 1529.505n 0.0v 1539.495n 0.0v 1539.505n 1.7v 1549.495n 1.7v 1549.505n 1.7v 1559.495n 1.7v 1559.505n 1.7v 1569.495n 1.7v 1569.505n 1.7v 1579.495n 1.7v 1579.505n 1.7v 1589.495n 1.7v 1589.505n 1.7v 1599.495n 1.7v 1599.505n 1.7v 1609.495n 1.7v 1609.505n 1.7v 1619.495n 1.7v 1619.505n 0.0v 1629.495n 0.0v 1629.505n 1.7v 1639.495n 1.7v 1639.505n 1.7v 1649.495n 1.7v 1649.505n 0.0v 1659.495n 0.0v 1659.505n 0.0v 1669.495n 0.0v 1669.505n 0.0v 1679.495n 0.0v 1679.505n 0.0v 1689.495n 0.0v 1689.505n 0.0v 1699.495n 0.0v 1699.505n 0.0v 1709.495n 0.0v 1709.505n 1.7v 1719.495n 1.7v 1719.505n 1.7v 1729.495n 1.7v 1729.505n 1.7v 1739.495n 1.7v 1739.505n 1.7v 1749.495n 1.7v 1749.505n 0.0v 1759.495n 0.0v 1759.505n 0.0v 1769.495n 0.0v 1769.505n 1.7v 1779.495n 1.7v 1779.505n 0.0v 1789.495n 0.0v 1789.505n 0.0v 1799.495n 0.0v 1799.505n 0.0v 1809.495n 0.0v 1809.505n 0.0v 1819.495n 0.0v 1819.505n 0.0v 1829.495n 0.0v 1829.505n 0.0v 1839.495n 0.0v 1839.505n 1.7v 1849.495n 1.7v 1849.505n 1.7v 1859.495n 1.7v 1859.505n 1.7v 1869.495n 1.7v 1869.505n 1.7v 1879.495n 1.7v 1879.505n 1.7v 1889.495n 1.7v 1889.505n 1.7v 1899.495n 1.7v 1899.505n 1.7v 1909.495n 1.7v 1909.505n 0.0v 1919.495n 0.0v 1919.505n 1.7v 1929.495n 1.7v 1929.505n 1.7v 1939.495n 1.7v 1939.505n 0.0v 1949.495n 0.0v 1949.505n 0.0v 1959.495n 0.0v 1959.505n 0.0v 1969.495n 0.0v 1969.505n 1.7v 1979.495n 1.7v 1979.505n 1.7v 1989.495n 1.7v 1989.505n 1.7v 1999.495n 1.7v 1999.505n 1.7v 2009.495n 1.7v 2009.505n 1.7v 2019.495n 1.7v 2019.505n 0.0v 2029.495n 0.0v 2029.505n 0.0v 2039.495n 0.0v 2039.505n 0.0v 2049.495n 0.0v 2049.505n 0.0v )
* (time, data): [(0, 0), (10, 1), (20, 1), (30, 0), (40, 0), (50, 0), (60, 0), (70, 0), (80, 0), (90, 0), (100, 0), (110, 0), (120, 0), (130, 0), (140, 0), (150, 1), (160, 1), (170, 1), (180, 1), (190, 0), (200, 1), (210, 1), (220, 1), (230, 1), (240, 1), (250, 1), (260, 1), (270, 1), (280, 0), (290, 0), (300, 0), (310, 1), (320, 1), (330, 1), (340, 1), (350, 1), (360, 1), (370, 1), (380, 1), (390, 1), (400, 1), (410, 1), (420, 1), (430, 1), (440, 1), (450, 1), (460, 1), (470, 0), (480, 0), (490, 0), (500, 0), (510, 1), (520, 1), (530, 1), (540, 1), (550, 1), (560, 0), (570, 0), (580, 0), (590, 0), (600, 0), (610, 1), (620, 0), (630, 1), (640, 1), (650, 0), (660, 0), (670, 0), (680, 0), (690, 0), (700, 1), (710, 0), (720, 0), (730, 0), (740, 1), (750, 1), (760, 1), (770, 0), (780, 0), (790, 0), (800, 0), (810, 0), (820, 0), (830, 0), (840, 0), (850, 0), (860, 0), (870, 0), (880, 0), (890, 0), (900, 1), (910, 1), (920, 1), (930, 1), (940, 1), (950, 1), (960, 0), (970, 1), (980, 0), (990, 1), (1000, 0), (1010, 1), (1020, 0), (1030, 1), (1040, 1), (1050, 1), (1060, 1), (1070, 0), (1080, 1), (1090, 1), (1100, 1), (1110, 1), (1120, 1), (1130, 1), (1140, 0), (1150, 0), (1160, 0), (1170, 1), (1180, 0), (1190, 0), (1200, 0), (1210, 0), (1220, 1), (1230, 0), (1240, 0), (1250, 0), (1260, 0), (1270, 0), (1280, 0), (1290, 1), (1300, 0), (1310, 0), (1320, 0), (1330, 0), (1340, 0), (1350, 0), (1360, 1), (1370, 1), (1380, 1), (1390, 1), (1400, 1), (1410, 1), (1420, 1), (1430, 1), (1440, 1), (1450, 1), (1460, 1), (1470, 1), (1480, 0), (1490, 0), (1500, 0), (1510, 1), (1520, 1), (1530, 1), (1540, 0), (1550, 0), (1560, 1), (1570, 1), (1580, 1), (1590, 1), (1600, 1), (1610, 1), (1620, 1), (1630, 1), (1640, 1), (1650, 0), (1660, 1), (1670, 1), (1680, 1), (1690, 1), (1700, 1), (1710, 0), (1720, 0), (1730, 1), (1740, 1), (1750, 0), (1760, 0), (1770, 0), (1780, 1), (1790, 1), (1800, 0), (1810, 0), (1820, 0), (1830, 0), (1840, 0), (1850, 0), (1860, 1), (1870, 1), (1880, 1), (1890, 1), (1900, 1), (1910, 1), (1920, 1), (1930, 0), (1940, 0), (1950, 0), (1960, 0), (1970, 0), (1980, 1), (1990, 1), (2000, 0), (2010, 0), (2020, 1), (2030, 1), (2040, 1), (2050, 1)]
Vdin0_13  din0_13  0 PWL (0n 0.0v 9.495n 0.0v 9.505n 1.7v 19.495n 1.7v 19.505n 1.7v 29.495n 1.7v 29.505n 0.0v 39.495n 0.0v 39.505n 0.0v 49.495n 0.0v 49.505n 0.0v 59.495n 0.0v 59.505n 0.0v 69.495n 0.0v 69.505n 0.0v 79.495n 0.0v 79.505n 0.0v 89.495n 0.0v 89.505n 0.0v 99.495n 0.0v 99.505n 0.0v 109.495n 0.0v 109.505n 0.0v 119.495n 0.0v 119.505n 0.0v 129.495n 0.0v 129.505n 0.0v 139.495n 0.0v 139.505n 0.0v 149.495n 0.0v 149.505n 1.7v 159.495n 1.7v 159.505n 1.7v 169.495n 1.7v 169.505n 1.7v 179.495n 1.7v 179.505n 1.7v 189.495n 1.7v 189.505n 0.0v 199.495n 0.0v 199.505n 1.7v 209.495n 1.7v 209.505n 1.7v 219.495n 1.7v 219.505n 1.7v 229.495n 1.7v 229.505n 1.7v 239.495n 1.7v 239.505n 1.7v 249.495n 1.7v 249.505n 1.7v 259.495n 1.7v 259.505n 1.7v 269.495n 1.7v 269.505n 1.7v 279.495n 1.7v 279.505n 0.0v 289.495n 0.0v 289.505n 0.0v 299.495n 0.0v 299.505n 0.0v 309.495n 0.0v 309.505n 1.7v 319.495n 1.7v 319.505n 1.7v 329.495n 1.7v 329.505n 1.7v 339.495n 1.7v 339.505n 1.7v 349.495n 1.7v 349.505n 1.7v 359.495n 1.7v 359.505n 1.7v 369.495n 1.7v 369.505n 1.7v 379.495n 1.7v 379.505n 1.7v 389.495n 1.7v 389.505n 1.7v 399.495n 1.7v 399.505n 1.7v 409.495n 1.7v 409.505n 1.7v 419.495n 1.7v 419.505n 1.7v 429.495n 1.7v 429.505n 1.7v 439.495n 1.7v 439.505n 1.7v 449.495n 1.7v 449.505n 1.7v 459.495n 1.7v 459.505n 1.7v 469.495n 1.7v 469.505n 0.0v 479.495n 0.0v 479.505n 0.0v 489.495n 0.0v 489.505n 0.0v 499.495n 0.0v 499.505n 0.0v 509.495n 0.0v 509.505n 1.7v 519.495n 1.7v 519.505n 1.7v 529.495n 1.7v 529.505n 1.7v 539.495n 1.7v 539.505n 1.7v 549.495n 1.7v 549.505n 1.7v 559.495n 1.7v 559.505n 0.0v 569.495n 0.0v 569.505n 0.0v 579.495n 0.0v 579.505n 0.0v 589.495n 0.0v 589.505n 0.0v 599.495n 0.0v 599.505n 0.0v 609.495n 0.0v 609.505n 1.7v 619.495n 1.7v 619.505n 0.0v 629.495n 0.0v 629.505n 1.7v 639.495n 1.7v 639.505n 1.7v 649.495n 1.7v 649.505n 0.0v 659.495n 0.0v 659.505n 0.0v 669.495n 0.0v 669.505n 0.0v 679.495n 0.0v 679.505n 0.0v 689.495n 0.0v 689.505n 0.0v 699.495n 0.0v 699.505n 1.7v 709.495n 1.7v 709.505n 0.0v 719.495n 0.0v 719.505n 0.0v 729.495n 0.0v 729.505n 0.0v 739.495n 0.0v 739.505n 1.7v 749.495n 1.7v 749.505n 1.7v 759.495n 1.7v 759.505n 1.7v 769.495n 1.7v 769.505n 0.0v 779.495n 0.0v 779.505n 0.0v 789.495n 0.0v 789.505n 0.0v 799.495n 0.0v 799.505n 0.0v 809.495n 0.0v 809.505n 0.0v 819.495n 0.0v 819.505n 0.0v 829.495n 0.0v 829.505n 0.0v 839.495n 0.0v 839.505n 0.0v 849.495n 0.0v 849.505n 0.0v 859.495n 0.0v 859.505n 0.0v 869.495n 0.0v 869.505n 0.0v 879.495n 0.0v 879.505n 0.0v 889.495n 0.0v 889.505n 0.0v 899.495n 0.0v 899.505n 1.7v 909.495n 1.7v 909.505n 1.7v 919.495n 1.7v 919.505n 1.7v 929.495n 1.7v 929.505n 1.7v 939.495n 1.7v 939.505n 1.7v 949.495n 1.7v 949.505n 1.7v 959.495n 1.7v 959.505n 0.0v 969.495n 0.0v 969.505n 1.7v 979.495n 1.7v 979.505n 0.0v 989.495n 0.0v 989.505n 1.7v 999.495n 1.7v 999.505n 0.0v 1009.495n 0.0v 1009.505n 1.7v 1019.495n 1.7v 1019.505n 0.0v 1029.495n 0.0v 1029.505n 1.7v 1039.495n 1.7v 1039.505n 1.7v 1049.495n 1.7v 1049.505n 1.7v 1059.495n 1.7v 1059.505n 1.7v 1069.495n 1.7v 1069.505n 0.0v 1079.495n 0.0v 1079.505n 1.7v 1089.495n 1.7v 1089.505n 1.7v 1099.495n 1.7v 1099.505n 1.7v 1109.495n 1.7v 1109.505n 1.7v 1119.495n 1.7v 1119.505n 1.7v 1129.495n 1.7v 1129.505n 1.7v 1139.495n 1.7v 1139.505n 0.0v 1149.495n 0.0v 1149.505n 0.0v 1159.495n 0.0v 1159.505n 0.0v 1169.495n 0.0v 1169.505n 1.7v 1179.495n 1.7v 1179.505n 0.0v 1189.495n 0.0v 1189.505n 0.0v 1199.495n 0.0v 1199.505n 0.0v 1209.495n 0.0v 1209.505n 0.0v 1219.495n 0.0v 1219.505n 1.7v 1229.495n 1.7v 1229.505n 0.0v 1239.495n 0.0v 1239.505n 0.0v 1249.495n 0.0v 1249.505n 0.0v 1259.495n 0.0v 1259.505n 0.0v 1269.495n 0.0v 1269.505n 0.0v 1279.495n 0.0v 1279.505n 0.0v 1289.495n 0.0v 1289.505n 1.7v 1299.495n 1.7v 1299.505n 0.0v 1309.495n 0.0v 1309.505n 0.0v 1319.495n 0.0v 1319.505n 0.0v 1329.495n 0.0v 1329.505n 0.0v 1339.495n 0.0v 1339.505n 0.0v 1349.495n 0.0v 1349.505n 0.0v 1359.495n 0.0v 1359.505n 1.7v 1369.495n 1.7v 1369.505n 1.7v 1379.495n 1.7v 1379.505n 1.7v 1389.495n 1.7v 1389.505n 1.7v 1399.495n 1.7v 1399.505n 1.7v 1409.495n 1.7v 1409.505n 1.7v 1419.495n 1.7v 1419.505n 1.7v 1429.495n 1.7v 1429.505n 1.7v 1439.495n 1.7v 1439.505n 1.7v 1449.495n 1.7v 1449.505n 1.7v 1459.495n 1.7v 1459.505n 1.7v 1469.495n 1.7v 1469.505n 1.7v 1479.495n 1.7v 1479.505n 0.0v 1489.495n 0.0v 1489.505n 0.0v 1499.495n 0.0v 1499.505n 0.0v 1509.495n 0.0v 1509.505n 1.7v 1519.495n 1.7v 1519.505n 1.7v 1529.495n 1.7v 1529.505n 1.7v 1539.495n 1.7v 1539.505n 0.0v 1549.495n 0.0v 1549.505n 0.0v 1559.495n 0.0v 1559.505n 1.7v 1569.495n 1.7v 1569.505n 1.7v 1579.495n 1.7v 1579.505n 1.7v 1589.495n 1.7v 1589.505n 1.7v 1599.495n 1.7v 1599.505n 1.7v 1609.495n 1.7v 1609.505n 1.7v 1619.495n 1.7v 1619.505n 1.7v 1629.495n 1.7v 1629.505n 1.7v 1639.495n 1.7v 1639.505n 1.7v 1649.495n 1.7v 1649.505n 0.0v 1659.495n 0.0v 1659.505n 1.7v 1669.495n 1.7v 1669.505n 1.7v 1679.495n 1.7v 1679.505n 1.7v 1689.495n 1.7v 1689.505n 1.7v 1699.495n 1.7v 1699.505n 1.7v 1709.495n 1.7v 1709.505n 0.0v 1719.495n 0.0v 1719.505n 0.0v 1729.495n 0.0v 1729.505n 1.7v 1739.495n 1.7v 1739.505n 1.7v 1749.495n 1.7v 1749.505n 0.0v 1759.495n 0.0v 1759.505n 0.0v 1769.495n 0.0v 1769.505n 0.0v 1779.495n 0.0v 1779.505n 1.7v 1789.495n 1.7v 1789.505n 1.7v 1799.495n 1.7v 1799.505n 0.0v 1809.495n 0.0v 1809.505n 0.0v 1819.495n 0.0v 1819.505n 0.0v 1829.495n 0.0v 1829.505n 0.0v 1839.495n 0.0v 1839.505n 0.0v 1849.495n 0.0v 1849.505n 0.0v 1859.495n 0.0v 1859.505n 1.7v 1869.495n 1.7v 1869.505n 1.7v 1879.495n 1.7v 1879.505n 1.7v 1889.495n 1.7v 1889.505n 1.7v 1899.495n 1.7v 1899.505n 1.7v 1909.495n 1.7v 1909.505n 1.7v 1919.495n 1.7v 1919.505n 1.7v 1929.495n 1.7v 1929.505n 0.0v 1939.495n 0.0v 1939.505n 0.0v 1949.495n 0.0v 1949.505n 0.0v 1959.495n 0.0v 1959.505n 0.0v 1969.495n 0.0v 1969.505n 0.0v 1979.495n 0.0v 1979.505n 1.7v 1989.495n 1.7v 1989.505n 1.7v 1999.495n 1.7v 1999.505n 0.0v 2009.495n 0.0v 2009.505n 0.0v 2019.495n 0.0v 2019.505n 1.7v 2029.495n 1.7v 2029.505n 1.7v 2039.495n 1.7v 2039.505n 1.7v 2049.495n 1.7v 2049.505n 1.7v )
* (time, data): [(0, 0), (10, 1), (20, 1), (30, 0), (40, 0), (50, 0), (60, 1), (70, 1), (80, 1), (90, 1), (100, 0), (110, 0), (120, 0), (130, 0), (140, 0), (150, 1), (160, 1), (170, 1), (180, 1), (190, 1), (200, 0), (210, 0), (220, 0), (230, 0), (240, 0), (250, 0), (260, 0), (270, 0), (280, 0), (290, 0), (300, 0), (310, 0), (320, 0), (330, 0), (340, 0), (350, 0), (360, 0), (370, 0), (380, 0), (390, 0), (400, 0), (410, 0), (420, 1), (430, 1), (440, 1), (450, 1), (460, 1), (470, 0), (480, 0), (490, 0), (500, 0), (510, 0), (520, 0), (530, 0), (540, 0), (550, 1), (560, 1), (570, 1), (580, 1), (590, 1), (600, 1), (610, 0), (620, 0), (630, 1), (640, 1), (650, 0), (660, 0), (670, 1), (680, 0), (690, 0), (700, 1), (710, 1), (720, 1), (730, 1), (740, 1), (750, 1), (760, 1), (770, 0), (780, 1), (790, 1), (800, 1), (810, 1), (820, 1), (830, 0), (840, 1), (850, 1), (860, 1), (870, 1), (880, 1), (890, 1), (900, 1), (910, 1), (920, 0), (930, 0), (940, 0), (950, 0), (960, 0), (970, 0), (980, 1), (990, 1), (1000, 0), (1010, 0), (1020, 1), (1030, 1), (1040, 1), (1050, 1), (1060, 1), (1070, 0), (1080, 0), (1090, 1), (1100, 1), (1110, 0), (1120, 0), (1130, 1), (1140, 1), (1150, 1), (1160, 1), (1170, 1), (1180, 1), (1190, 1), (1200, 1), (1210, 1), (1220, 0), (1230, 0), (1240, 0), (1250, 1), (1260, 1), (1270, 1), (1280, 1), (1290, 1), (1300, 1), (1310, 1), (1320, 1), (1330, 1), (1340, 0), (1350, 0), (1360, 1), (1370, 0), (1380, 0), (1390, 0), (1400, 1), (1410, 1), (1420, 1), (1430, 1), (1440, 1), (1450, 1), (1460, 1), (1470, 1), (1480, 1), (1490, 1), (1500, 1), (1510, 1), (1520, 1), (1530, 1), (1540, 1), (1550, 1), (1560, 1), (1570, 1), (1580, 0), (1590, 0), (1600, 0), (1610, 0), (1620, 0), (1630, 1), (1640, 1), (1650, 1), (1660, 0), (1670, 0), (1680, 0), (1690, 0), (1700, 0), (1710, 1), (1720, 1), (1730, 1), (1740, 1), (1750, 1), (1760, 1), (1770, 1), (1780, 1), (1790, 1), (1800, 1), (1810, 1), (1820, 1), (1830, 1), (1840, 0), (1850, 0), (1860, 1), (1870, 1), (1880, 1), (1890, 1), (1900, 1), (1910, 0), (1920, 0), (1930, 1), (1940, 0), (1950, 1), (1960, 1), (1970, 1), (1980, 0), (1990, 0), (2000, 0), (2010, 1), (2020, 0), (2030, 0), (2040, 0), (2050, 0)]
Vdin0_14  din0_14  0 PWL (0n 0.0v 9.495n 0.0v 9.505n 1.7v 19.495n 1.7v 19.505n 1.7v 29.495n 1.7v 29.505n 0.0v 39.495n 0.0v 39.505n 0.0v 49.495n 0.0v 49.505n 0.0v 59.495n 0.0v 59.505n 1.7v 69.495n 1.7v 69.505n 1.7v 79.495n 1.7v 79.505n 1.7v 89.495n 1.7v 89.505n 1.7v 99.495n 1.7v 99.505n 0.0v 109.495n 0.0v 109.505n 0.0v 119.495n 0.0v 119.505n 0.0v 129.495n 0.0v 129.505n 0.0v 139.495n 0.0v 139.505n 0.0v 149.495n 0.0v 149.505n 1.7v 159.495n 1.7v 159.505n 1.7v 169.495n 1.7v 169.505n 1.7v 179.495n 1.7v 179.505n 1.7v 189.495n 1.7v 189.505n 1.7v 199.495n 1.7v 199.505n 0.0v 209.495n 0.0v 209.505n 0.0v 219.495n 0.0v 219.505n 0.0v 229.495n 0.0v 229.505n 0.0v 239.495n 0.0v 239.505n 0.0v 249.495n 0.0v 249.505n 0.0v 259.495n 0.0v 259.505n 0.0v 269.495n 0.0v 269.505n 0.0v 279.495n 0.0v 279.505n 0.0v 289.495n 0.0v 289.505n 0.0v 299.495n 0.0v 299.505n 0.0v 309.495n 0.0v 309.505n 0.0v 319.495n 0.0v 319.505n 0.0v 329.495n 0.0v 329.505n 0.0v 339.495n 0.0v 339.505n 0.0v 349.495n 0.0v 349.505n 0.0v 359.495n 0.0v 359.505n 0.0v 369.495n 0.0v 369.505n 0.0v 379.495n 0.0v 379.505n 0.0v 389.495n 0.0v 389.505n 0.0v 399.495n 0.0v 399.505n 0.0v 409.495n 0.0v 409.505n 0.0v 419.495n 0.0v 419.505n 1.7v 429.495n 1.7v 429.505n 1.7v 439.495n 1.7v 439.505n 1.7v 449.495n 1.7v 449.505n 1.7v 459.495n 1.7v 459.505n 1.7v 469.495n 1.7v 469.505n 0.0v 479.495n 0.0v 479.505n 0.0v 489.495n 0.0v 489.505n 0.0v 499.495n 0.0v 499.505n 0.0v 509.495n 0.0v 509.505n 0.0v 519.495n 0.0v 519.505n 0.0v 529.495n 0.0v 529.505n 0.0v 539.495n 0.0v 539.505n 0.0v 549.495n 0.0v 549.505n 1.7v 559.495n 1.7v 559.505n 1.7v 569.495n 1.7v 569.505n 1.7v 579.495n 1.7v 579.505n 1.7v 589.495n 1.7v 589.505n 1.7v 599.495n 1.7v 599.505n 1.7v 609.495n 1.7v 609.505n 0.0v 619.495n 0.0v 619.505n 0.0v 629.495n 0.0v 629.505n 1.7v 639.495n 1.7v 639.505n 1.7v 649.495n 1.7v 649.505n 0.0v 659.495n 0.0v 659.505n 0.0v 669.495n 0.0v 669.505n 1.7v 679.495n 1.7v 679.505n 0.0v 689.495n 0.0v 689.505n 0.0v 699.495n 0.0v 699.505n 1.7v 709.495n 1.7v 709.505n 1.7v 719.495n 1.7v 719.505n 1.7v 729.495n 1.7v 729.505n 1.7v 739.495n 1.7v 739.505n 1.7v 749.495n 1.7v 749.505n 1.7v 759.495n 1.7v 759.505n 1.7v 769.495n 1.7v 769.505n 0.0v 779.495n 0.0v 779.505n 1.7v 789.495n 1.7v 789.505n 1.7v 799.495n 1.7v 799.505n 1.7v 809.495n 1.7v 809.505n 1.7v 819.495n 1.7v 819.505n 1.7v 829.495n 1.7v 829.505n 0.0v 839.495n 0.0v 839.505n 1.7v 849.495n 1.7v 849.505n 1.7v 859.495n 1.7v 859.505n 1.7v 869.495n 1.7v 869.505n 1.7v 879.495n 1.7v 879.505n 1.7v 889.495n 1.7v 889.505n 1.7v 899.495n 1.7v 899.505n 1.7v 909.495n 1.7v 909.505n 1.7v 919.495n 1.7v 919.505n 0.0v 929.495n 0.0v 929.505n 0.0v 939.495n 0.0v 939.505n 0.0v 949.495n 0.0v 949.505n 0.0v 959.495n 0.0v 959.505n 0.0v 969.495n 0.0v 969.505n 0.0v 979.495n 0.0v 979.505n 1.7v 989.495n 1.7v 989.505n 1.7v 999.495n 1.7v 999.505n 0.0v 1009.495n 0.0v 1009.505n 0.0v 1019.495n 0.0v 1019.505n 1.7v 1029.495n 1.7v 1029.505n 1.7v 1039.495n 1.7v 1039.505n 1.7v 1049.495n 1.7v 1049.505n 1.7v 1059.495n 1.7v 1059.505n 1.7v 1069.495n 1.7v 1069.505n 0.0v 1079.495n 0.0v 1079.505n 0.0v 1089.495n 0.0v 1089.505n 1.7v 1099.495n 1.7v 1099.505n 1.7v 1109.495n 1.7v 1109.505n 0.0v 1119.495n 0.0v 1119.505n 0.0v 1129.495n 0.0v 1129.505n 1.7v 1139.495n 1.7v 1139.505n 1.7v 1149.495n 1.7v 1149.505n 1.7v 1159.495n 1.7v 1159.505n 1.7v 1169.495n 1.7v 1169.505n 1.7v 1179.495n 1.7v 1179.505n 1.7v 1189.495n 1.7v 1189.505n 1.7v 1199.495n 1.7v 1199.505n 1.7v 1209.495n 1.7v 1209.505n 1.7v 1219.495n 1.7v 1219.505n 0.0v 1229.495n 0.0v 1229.505n 0.0v 1239.495n 0.0v 1239.505n 0.0v 1249.495n 0.0v 1249.505n 1.7v 1259.495n 1.7v 1259.505n 1.7v 1269.495n 1.7v 1269.505n 1.7v 1279.495n 1.7v 1279.505n 1.7v 1289.495n 1.7v 1289.505n 1.7v 1299.495n 1.7v 1299.505n 1.7v 1309.495n 1.7v 1309.505n 1.7v 1319.495n 1.7v 1319.505n 1.7v 1329.495n 1.7v 1329.505n 1.7v 1339.495n 1.7v 1339.505n 0.0v 1349.495n 0.0v 1349.505n 0.0v 1359.495n 0.0v 1359.505n 1.7v 1369.495n 1.7v 1369.505n 0.0v 1379.495n 0.0v 1379.505n 0.0v 1389.495n 0.0v 1389.505n 0.0v 1399.495n 0.0v 1399.505n 1.7v 1409.495n 1.7v 1409.505n 1.7v 1419.495n 1.7v 1419.505n 1.7v 1429.495n 1.7v 1429.505n 1.7v 1439.495n 1.7v 1439.505n 1.7v 1449.495n 1.7v 1449.505n 1.7v 1459.495n 1.7v 1459.505n 1.7v 1469.495n 1.7v 1469.505n 1.7v 1479.495n 1.7v 1479.505n 1.7v 1489.495n 1.7v 1489.505n 1.7v 1499.495n 1.7v 1499.505n 1.7v 1509.495n 1.7v 1509.505n 1.7v 1519.495n 1.7v 1519.505n 1.7v 1529.495n 1.7v 1529.505n 1.7v 1539.495n 1.7v 1539.505n 1.7v 1549.495n 1.7v 1549.505n 1.7v 1559.495n 1.7v 1559.505n 1.7v 1569.495n 1.7v 1569.505n 1.7v 1579.495n 1.7v 1579.505n 0.0v 1589.495n 0.0v 1589.505n 0.0v 1599.495n 0.0v 1599.505n 0.0v 1609.495n 0.0v 1609.505n 0.0v 1619.495n 0.0v 1619.505n 0.0v 1629.495n 0.0v 1629.505n 1.7v 1639.495n 1.7v 1639.505n 1.7v 1649.495n 1.7v 1649.505n 1.7v 1659.495n 1.7v 1659.505n 0.0v 1669.495n 0.0v 1669.505n 0.0v 1679.495n 0.0v 1679.505n 0.0v 1689.495n 0.0v 1689.505n 0.0v 1699.495n 0.0v 1699.505n 0.0v 1709.495n 0.0v 1709.505n 1.7v 1719.495n 1.7v 1719.505n 1.7v 1729.495n 1.7v 1729.505n 1.7v 1739.495n 1.7v 1739.505n 1.7v 1749.495n 1.7v 1749.505n 1.7v 1759.495n 1.7v 1759.505n 1.7v 1769.495n 1.7v 1769.505n 1.7v 1779.495n 1.7v 1779.505n 1.7v 1789.495n 1.7v 1789.505n 1.7v 1799.495n 1.7v 1799.505n 1.7v 1809.495n 1.7v 1809.505n 1.7v 1819.495n 1.7v 1819.505n 1.7v 1829.495n 1.7v 1829.505n 1.7v 1839.495n 1.7v 1839.505n 0.0v 1849.495n 0.0v 1849.505n 0.0v 1859.495n 0.0v 1859.505n 1.7v 1869.495n 1.7v 1869.505n 1.7v 1879.495n 1.7v 1879.505n 1.7v 1889.495n 1.7v 1889.505n 1.7v 1899.495n 1.7v 1899.505n 1.7v 1909.495n 1.7v 1909.505n 0.0v 1919.495n 0.0v 1919.505n 0.0v 1929.495n 0.0v 1929.505n 1.7v 1939.495n 1.7v 1939.505n 0.0v 1949.495n 0.0v 1949.505n 1.7v 1959.495n 1.7v 1959.505n 1.7v 1969.495n 1.7v 1969.505n 1.7v 1979.495n 1.7v 1979.505n 0.0v 1989.495n 0.0v 1989.505n 0.0v 1999.495n 0.0v 1999.505n 0.0v 2009.495n 0.0v 2009.505n 1.7v 2019.495n 1.7v 2019.505n 0.0v 2029.495n 0.0v 2029.505n 0.0v 2039.495n 0.0v 2039.505n 0.0v 2049.495n 0.0v 2049.505n 0.0v )
* (time, data): [(0, 0), (10, 1), (20, 0), (30, 1), (40, 1), (50, 1), (60, 0), (70, 0), (80, 0), (90, 1), (100, 0), (110, 0), (120, 0), (130, 0), (140, 0), (150, 1), (160, 1), (170, 1), (180, 1), (190, 1), (200, 1), (210, 1), (220, 1), (230, 1), (240, 1), (250, 1), (260, 1), (270, 1), (280, 0), (290, 0), (300, 0), (310, 0), (320, 1), (330, 1), (340, 1), (350, 1), (360, 1), (370, 1), (380, 1), (390, 1), (400, 1), (410, 1), (420, 0), (430, 0), (440, 0), (450, 0), (460, 1), (470, 1), (480, 1), (490, 1), (500, 1), (510, 0), (520, 0), (530, 0), (540, 0), (550, 0), (560, 0), (570, 0), (580, 0), (590, 0), (600, 1), (610, 0), (620, 1), (630, 1), (640, 1), (650, 1), (660, 1), (670, 0), (680, 1), (690, 1), (700, 0), (710, 1), (720, 1), (730, 1), (740, 0), (750, 0), (760, 0), (770, 1), (780, 0), (790, 0), (800, 0), (810, 0), (820, 1), (830, 1), (840, 0), (850, 0), (860, 0), (870, 1), (880, 1), (890, 1), (900, 1), (910, 1), (920, 0), (930, 0), (940, 0), (950, 0), (960, 1), (970, 0), (980, 0), (990, 1), (1000, 1), (1010, 1), (1020, 1), (1030, 0), (1040, 0), (1050, 0), (1060, 0), (1070, 1), (1080, 0), (1090, 1), (1100, 1), (1110, 1), (1120, 1), (1130, 0), (1140, 0), (1150, 0), (1160, 0), (1170, 1), (1180, 0), (1190, 0), (1200, 0), (1210, 0), (1220, 1), (1230, 0), (1240, 1), (1250, 0), (1260, 0), (1270, 0), (1280, 0), (1290, 1), (1300, 0), (1310, 0), (1320, 0), (1330, 0), (1340, 1), (1350, 1), (1360, 1), (1370, 0), (1380, 0), (1390, 0), (1400, 0), (1410, 0), (1420, 0), (1430, 0), (1440, 0), (1450, 0), (1460, 0), (1470, 0), (1480, 1), (1490, 1), (1500, 1), (1510, 0), (1520, 0), (1530, 0), (1540, 1), (1550, 1), (1560, 1), (1570, 1), (1580, 1), (1590, 1), (1600, 1), (1610, 1), (1620, 1), (1630, 0), (1640, 0), (1650, 0), (1660, 1), (1670, 1), (1680, 1), (1690, 1), (1700, 1), (1710, 0), (1720, 0), (1730, 1), (1740, 1), (1750, 0), (1760, 0), (1770, 0), (1780, 0), (1790, 0), (1800, 0), (1810, 0), (1820, 0), (1830, 0), (1840, 1), (1850, 1), (1860, 1), (1870, 1), (1880, 1), (1890, 1), (1900, 1), (1910, 0), (1920, 1), (1930, 0), (1940, 1), (1950, 0), (1960, 0), (1970, 1), (1980, 1), (1990, 1), (2000, 0), (2010, 1), (2020, 1), (2030, 1), (2040, 1), (2050, 1)]
Vdin0_15  din0_15  0 PWL (0n 0.0v 9.495n 0.0v 9.505n 1.7v 19.495n 1.7v 19.505n 0.0v 29.495n 0.0v 29.505n 1.7v 39.495n 1.7v 39.505n 1.7v 49.495n 1.7v 49.505n 1.7v 59.495n 1.7v 59.505n 0.0v 69.495n 0.0v 69.505n 0.0v 79.495n 0.0v 79.505n 0.0v 89.495n 0.0v 89.505n 1.7v 99.495n 1.7v 99.505n 0.0v 109.495n 0.0v 109.505n 0.0v 119.495n 0.0v 119.505n 0.0v 129.495n 0.0v 129.505n 0.0v 139.495n 0.0v 139.505n 0.0v 149.495n 0.0v 149.505n 1.7v 159.495n 1.7v 159.505n 1.7v 169.495n 1.7v 169.505n 1.7v 179.495n 1.7v 179.505n 1.7v 189.495n 1.7v 189.505n 1.7v 199.495n 1.7v 199.505n 1.7v 209.495n 1.7v 209.505n 1.7v 219.495n 1.7v 219.505n 1.7v 229.495n 1.7v 229.505n 1.7v 239.495n 1.7v 239.505n 1.7v 249.495n 1.7v 249.505n 1.7v 259.495n 1.7v 259.505n 1.7v 269.495n 1.7v 269.505n 1.7v 279.495n 1.7v 279.505n 0.0v 289.495n 0.0v 289.505n 0.0v 299.495n 0.0v 299.505n 0.0v 309.495n 0.0v 309.505n 0.0v 319.495n 0.0v 319.505n 1.7v 329.495n 1.7v 329.505n 1.7v 339.495n 1.7v 339.505n 1.7v 349.495n 1.7v 349.505n 1.7v 359.495n 1.7v 359.505n 1.7v 369.495n 1.7v 369.505n 1.7v 379.495n 1.7v 379.505n 1.7v 389.495n 1.7v 389.505n 1.7v 399.495n 1.7v 399.505n 1.7v 409.495n 1.7v 409.505n 1.7v 419.495n 1.7v 419.505n 0.0v 429.495n 0.0v 429.505n 0.0v 439.495n 0.0v 439.505n 0.0v 449.495n 0.0v 449.505n 0.0v 459.495n 0.0v 459.505n 1.7v 469.495n 1.7v 469.505n 1.7v 479.495n 1.7v 479.505n 1.7v 489.495n 1.7v 489.505n 1.7v 499.495n 1.7v 499.505n 1.7v 509.495n 1.7v 509.505n 0.0v 519.495n 0.0v 519.505n 0.0v 529.495n 0.0v 529.505n 0.0v 539.495n 0.0v 539.505n 0.0v 549.495n 0.0v 549.505n 0.0v 559.495n 0.0v 559.505n 0.0v 569.495n 0.0v 569.505n 0.0v 579.495n 0.0v 579.505n 0.0v 589.495n 0.0v 589.505n 0.0v 599.495n 0.0v 599.505n 1.7v 609.495n 1.7v 609.505n 0.0v 619.495n 0.0v 619.505n 1.7v 629.495n 1.7v 629.505n 1.7v 639.495n 1.7v 639.505n 1.7v 649.495n 1.7v 649.505n 1.7v 659.495n 1.7v 659.505n 1.7v 669.495n 1.7v 669.505n 0.0v 679.495n 0.0v 679.505n 1.7v 689.495n 1.7v 689.505n 1.7v 699.495n 1.7v 699.505n 0.0v 709.495n 0.0v 709.505n 1.7v 719.495n 1.7v 719.505n 1.7v 729.495n 1.7v 729.505n 1.7v 739.495n 1.7v 739.505n 0.0v 749.495n 0.0v 749.505n 0.0v 759.495n 0.0v 759.505n 0.0v 769.495n 0.0v 769.505n 1.7v 779.495n 1.7v 779.505n 0.0v 789.495n 0.0v 789.505n 0.0v 799.495n 0.0v 799.505n 0.0v 809.495n 0.0v 809.505n 0.0v 819.495n 0.0v 819.505n 1.7v 829.495n 1.7v 829.505n 1.7v 839.495n 1.7v 839.505n 0.0v 849.495n 0.0v 849.505n 0.0v 859.495n 0.0v 859.505n 0.0v 869.495n 0.0v 869.505n 1.7v 879.495n 1.7v 879.505n 1.7v 889.495n 1.7v 889.505n 1.7v 899.495n 1.7v 899.505n 1.7v 909.495n 1.7v 909.505n 1.7v 919.495n 1.7v 919.505n 0.0v 929.495n 0.0v 929.505n 0.0v 939.495n 0.0v 939.505n 0.0v 949.495n 0.0v 949.505n 0.0v 959.495n 0.0v 959.505n 1.7v 969.495n 1.7v 969.505n 0.0v 979.495n 0.0v 979.505n 0.0v 989.495n 0.0v 989.505n 1.7v 999.495n 1.7v 999.505n 1.7v 1009.495n 1.7v 1009.505n 1.7v 1019.495n 1.7v 1019.505n 1.7v 1029.495n 1.7v 1029.505n 0.0v 1039.495n 0.0v 1039.505n 0.0v 1049.495n 0.0v 1049.505n 0.0v 1059.495n 0.0v 1059.505n 0.0v 1069.495n 0.0v 1069.505n 1.7v 1079.495n 1.7v 1079.505n 0.0v 1089.495n 0.0v 1089.505n 1.7v 1099.495n 1.7v 1099.505n 1.7v 1109.495n 1.7v 1109.505n 1.7v 1119.495n 1.7v 1119.505n 1.7v 1129.495n 1.7v 1129.505n 0.0v 1139.495n 0.0v 1139.505n 0.0v 1149.495n 0.0v 1149.505n 0.0v 1159.495n 0.0v 1159.505n 0.0v 1169.495n 0.0v 1169.505n 1.7v 1179.495n 1.7v 1179.505n 0.0v 1189.495n 0.0v 1189.505n 0.0v 1199.495n 0.0v 1199.505n 0.0v 1209.495n 0.0v 1209.505n 0.0v 1219.495n 0.0v 1219.505n 1.7v 1229.495n 1.7v 1229.505n 0.0v 1239.495n 0.0v 1239.505n 1.7v 1249.495n 1.7v 1249.505n 0.0v 1259.495n 0.0v 1259.505n 0.0v 1269.495n 0.0v 1269.505n 0.0v 1279.495n 0.0v 1279.505n 0.0v 1289.495n 0.0v 1289.505n 1.7v 1299.495n 1.7v 1299.505n 0.0v 1309.495n 0.0v 1309.505n 0.0v 1319.495n 0.0v 1319.505n 0.0v 1329.495n 0.0v 1329.505n 0.0v 1339.495n 0.0v 1339.505n 1.7v 1349.495n 1.7v 1349.505n 1.7v 1359.495n 1.7v 1359.505n 1.7v 1369.495n 1.7v 1369.505n 0.0v 1379.495n 0.0v 1379.505n 0.0v 1389.495n 0.0v 1389.505n 0.0v 1399.495n 0.0v 1399.505n 0.0v 1409.495n 0.0v 1409.505n 0.0v 1419.495n 0.0v 1419.505n 0.0v 1429.495n 0.0v 1429.505n 0.0v 1439.495n 0.0v 1439.505n 0.0v 1449.495n 0.0v 1449.505n 0.0v 1459.495n 0.0v 1459.505n 0.0v 1469.495n 0.0v 1469.505n 0.0v 1479.495n 0.0v 1479.505n 1.7v 1489.495n 1.7v 1489.505n 1.7v 1499.495n 1.7v 1499.505n 1.7v 1509.495n 1.7v 1509.505n 0.0v 1519.495n 0.0v 1519.505n 0.0v 1529.495n 0.0v 1529.505n 0.0v 1539.495n 0.0v 1539.505n 1.7v 1549.495n 1.7v 1549.505n 1.7v 1559.495n 1.7v 1559.505n 1.7v 1569.495n 1.7v 1569.505n 1.7v 1579.495n 1.7v 1579.505n 1.7v 1589.495n 1.7v 1589.505n 1.7v 1599.495n 1.7v 1599.505n 1.7v 1609.495n 1.7v 1609.505n 1.7v 1619.495n 1.7v 1619.505n 1.7v 1629.495n 1.7v 1629.505n 0.0v 1639.495n 0.0v 1639.505n 0.0v 1649.495n 0.0v 1649.505n 0.0v 1659.495n 0.0v 1659.505n 1.7v 1669.495n 1.7v 1669.505n 1.7v 1679.495n 1.7v 1679.505n 1.7v 1689.495n 1.7v 1689.505n 1.7v 1699.495n 1.7v 1699.505n 1.7v 1709.495n 1.7v 1709.505n 0.0v 1719.495n 0.0v 1719.505n 0.0v 1729.495n 0.0v 1729.505n 1.7v 1739.495n 1.7v 1739.505n 1.7v 1749.495n 1.7v 1749.505n 0.0v 1759.495n 0.0v 1759.505n 0.0v 1769.495n 0.0v 1769.505n 0.0v 1779.495n 0.0v 1779.505n 0.0v 1789.495n 0.0v 1789.505n 0.0v 1799.495n 0.0v 1799.505n 0.0v 1809.495n 0.0v 1809.505n 0.0v 1819.495n 0.0v 1819.505n 0.0v 1829.495n 0.0v 1829.505n 0.0v 1839.495n 0.0v 1839.505n 1.7v 1849.495n 1.7v 1849.505n 1.7v 1859.495n 1.7v 1859.505n 1.7v 1869.495n 1.7v 1869.505n 1.7v 1879.495n 1.7v 1879.505n 1.7v 1889.495n 1.7v 1889.505n 1.7v 1899.495n 1.7v 1899.505n 1.7v 1909.495n 1.7v 1909.505n 0.0v 1919.495n 0.0v 1919.505n 1.7v 1929.495n 1.7v 1929.505n 0.0v 1939.495n 0.0v 1939.505n 1.7v 1949.495n 1.7v 1949.505n 0.0v 1959.495n 0.0v 1959.505n 0.0v 1969.495n 0.0v 1969.505n 1.7v 1979.495n 1.7v 1979.505n 1.7v 1989.495n 1.7v 1989.505n 1.7v 1999.495n 1.7v 1999.505n 0.0v 2009.495n 0.0v 2009.505n 1.7v 2019.495n 1.7v 2019.505n 1.7v 2029.495n 1.7v 2029.505n 1.7v 2039.495n 1.7v 2039.505n 1.7v 2049.495n 1.7v 2049.505n 1.7v )
* (time, data): [(0, 0), (10, 0), (20, 1), (30, 1), (40, 1), (50, 1), (60, 0), (70, 0), (80, 0), (90, 1), (100, 0), (110, 1), (120, 1), (130, 1), (140, 1), (150, 0), (160, 0), (170, 0), (180, 0), (190, 1), (200, 0), (210, 0), (220, 0), (230, 0), (240, 0), (250, 0), (260, 0), (270, 0), (280, 1), (290, 1), (300, 1), (310, 1), (320, 1), (330, 1), (340, 1), (350, 1), (360, 1), (370, 1), (380, 1), (390, 1), (400, 1), (410, 1), (420, 1), (430, 1), (440, 0), (450, 0), (460, 0), (470, 0), (480, 0), (490, 0), (500, 1), (510, 0), (520, 0), (530, 0), (540, 0), (550, 1), (560, 0), (570, 0), (580, 0), (590, 0), (600, 0), (610, 0), (620, 0), (630, 1), (640, 1), (650, 1), (660, 1), (670, 1), (680, 0), (690, 0), (700, 1), (710, 0), (720, 0), (730, 0), (740, 1), (750, 1), (760, 1), (770, 0), (780, 0), (790, 0), (800, 0), (810, 0), (820, 0), (830, 0), (840, 1), (850, 1), (860, 1), (870, 0), (880, 0), (890, 0), (900, 1), (910, 1), (920, 1), (930, 1), (940, 1), (950, 1), (960, 1), (970, 0), (980, 1), (990, 0), (1000, 1), (1010, 0), (1020, 0), (1030, 0), (1040, 0), (1050, 0), (1060, 0), (1070, 0), (1080, 0), (1090, 1), (1100, 1), (1110, 1), (1120, 1), (1130, 0), (1140, 1), (1150, 1), (1160, 1), (1170, 1), (1180, 1), (1190, 1), (1200, 1), (1210, 1), (1220, 1), (1230, 1), (1240, 0), (1250, 1), (1260, 1), (1270, 1), (1280, 1), (1290, 0), (1300, 0), (1310, 0), (1320, 0), (1330, 0), (1340, 1), (1350, 1), (1360, 1), (1370, 1), (1380, 1), (1390, 1), (1400, 0), (1410, 0), (1420, 0), (1430, 0), (1440, 0), (1450, 0), (1460, 0), (1470, 0), (1480, 0), (1490, 0), (1500, 0), (1510, 0), (1520, 0), (1530, 0), (1540, 0), (1550, 1), (1560, 1), (1570, 1), (1580, 1), (1590, 1), (1600, 1), (1610, 1), (1620, 1), (1630, 1), (1640, 1), (1650, 1), (1660, 0), (1670, 0), (1680, 0), (1690, 0), (1700, 0), (1710, 1), (1720, 1), (1730, 0), (1740, 0), (1750, 0), (1760, 0), (1770, 1), (1780, 0), (1790, 0), (1800, 0), (1810, 0), (1820, 0), (1830, 0), (1840, 1), (1850, 1), (1860, 1), (1870, 1), (1880, 1), (1890, 1), (1900, 1), (1910, 0), (1920, 0), (1930, 1), (1940, 1), (1950, 0), (1960, 0), (1970, 1), (1980, 0), (1990, 0), (2000, 1), (2010, 1), (2020, 0), (2030, 0), (2040, 0), (2050, 0)]
Vdin0_16  din0_16  0 PWL (0n 0.0v 9.495n 0.0v 9.505n 0.0v 19.495n 0.0v 19.505n 1.7v 29.495n 1.7v 29.505n 1.7v 39.495n 1.7v 39.505n 1.7v 49.495n 1.7v 49.505n 1.7v 59.495n 1.7v 59.505n 0.0v 69.495n 0.0v 69.505n 0.0v 79.495n 0.0v 79.505n 0.0v 89.495n 0.0v 89.505n 1.7v 99.495n 1.7v 99.505n 0.0v 109.495n 0.0v 109.505n 1.7v 119.495n 1.7v 119.505n 1.7v 129.495n 1.7v 129.505n 1.7v 139.495n 1.7v 139.505n 1.7v 149.495n 1.7v 149.505n 0.0v 159.495n 0.0v 159.505n 0.0v 169.495n 0.0v 169.505n 0.0v 179.495n 0.0v 179.505n 0.0v 189.495n 0.0v 189.505n 1.7v 199.495n 1.7v 199.505n 0.0v 209.495n 0.0v 209.505n 0.0v 219.495n 0.0v 219.505n 0.0v 229.495n 0.0v 229.505n 0.0v 239.495n 0.0v 239.505n 0.0v 249.495n 0.0v 249.505n 0.0v 259.495n 0.0v 259.505n 0.0v 269.495n 0.0v 269.505n 0.0v 279.495n 0.0v 279.505n 1.7v 289.495n 1.7v 289.505n 1.7v 299.495n 1.7v 299.505n 1.7v 309.495n 1.7v 309.505n 1.7v 319.495n 1.7v 319.505n 1.7v 329.495n 1.7v 329.505n 1.7v 339.495n 1.7v 339.505n 1.7v 349.495n 1.7v 349.505n 1.7v 359.495n 1.7v 359.505n 1.7v 369.495n 1.7v 369.505n 1.7v 379.495n 1.7v 379.505n 1.7v 389.495n 1.7v 389.505n 1.7v 399.495n 1.7v 399.505n 1.7v 409.495n 1.7v 409.505n 1.7v 419.495n 1.7v 419.505n 1.7v 429.495n 1.7v 429.505n 1.7v 439.495n 1.7v 439.505n 0.0v 449.495n 0.0v 449.505n 0.0v 459.495n 0.0v 459.505n 0.0v 469.495n 0.0v 469.505n 0.0v 479.495n 0.0v 479.505n 0.0v 489.495n 0.0v 489.505n 0.0v 499.495n 0.0v 499.505n 1.7v 509.495n 1.7v 509.505n 0.0v 519.495n 0.0v 519.505n 0.0v 529.495n 0.0v 529.505n 0.0v 539.495n 0.0v 539.505n 0.0v 549.495n 0.0v 549.505n 1.7v 559.495n 1.7v 559.505n 0.0v 569.495n 0.0v 569.505n 0.0v 579.495n 0.0v 579.505n 0.0v 589.495n 0.0v 589.505n 0.0v 599.495n 0.0v 599.505n 0.0v 609.495n 0.0v 609.505n 0.0v 619.495n 0.0v 619.505n 0.0v 629.495n 0.0v 629.505n 1.7v 639.495n 1.7v 639.505n 1.7v 649.495n 1.7v 649.505n 1.7v 659.495n 1.7v 659.505n 1.7v 669.495n 1.7v 669.505n 1.7v 679.495n 1.7v 679.505n 0.0v 689.495n 0.0v 689.505n 0.0v 699.495n 0.0v 699.505n 1.7v 709.495n 1.7v 709.505n 0.0v 719.495n 0.0v 719.505n 0.0v 729.495n 0.0v 729.505n 0.0v 739.495n 0.0v 739.505n 1.7v 749.495n 1.7v 749.505n 1.7v 759.495n 1.7v 759.505n 1.7v 769.495n 1.7v 769.505n 0.0v 779.495n 0.0v 779.505n 0.0v 789.495n 0.0v 789.505n 0.0v 799.495n 0.0v 799.505n 0.0v 809.495n 0.0v 809.505n 0.0v 819.495n 0.0v 819.505n 0.0v 829.495n 0.0v 829.505n 0.0v 839.495n 0.0v 839.505n 1.7v 849.495n 1.7v 849.505n 1.7v 859.495n 1.7v 859.505n 1.7v 869.495n 1.7v 869.505n 0.0v 879.495n 0.0v 879.505n 0.0v 889.495n 0.0v 889.505n 0.0v 899.495n 0.0v 899.505n 1.7v 909.495n 1.7v 909.505n 1.7v 919.495n 1.7v 919.505n 1.7v 929.495n 1.7v 929.505n 1.7v 939.495n 1.7v 939.505n 1.7v 949.495n 1.7v 949.505n 1.7v 959.495n 1.7v 959.505n 1.7v 969.495n 1.7v 969.505n 0.0v 979.495n 0.0v 979.505n 1.7v 989.495n 1.7v 989.505n 0.0v 999.495n 0.0v 999.505n 1.7v 1009.495n 1.7v 1009.505n 0.0v 1019.495n 0.0v 1019.505n 0.0v 1029.495n 0.0v 1029.505n 0.0v 1039.495n 0.0v 1039.505n 0.0v 1049.495n 0.0v 1049.505n 0.0v 1059.495n 0.0v 1059.505n 0.0v 1069.495n 0.0v 1069.505n 0.0v 1079.495n 0.0v 1079.505n 0.0v 1089.495n 0.0v 1089.505n 1.7v 1099.495n 1.7v 1099.505n 1.7v 1109.495n 1.7v 1109.505n 1.7v 1119.495n 1.7v 1119.505n 1.7v 1129.495n 1.7v 1129.505n 0.0v 1139.495n 0.0v 1139.505n 1.7v 1149.495n 1.7v 1149.505n 1.7v 1159.495n 1.7v 1159.505n 1.7v 1169.495n 1.7v 1169.505n 1.7v 1179.495n 1.7v 1179.505n 1.7v 1189.495n 1.7v 1189.505n 1.7v 1199.495n 1.7v 1199.505n 1.7v 1209.495n 1.7v 1209.505n 1.7v 1219.495n 1.7v 1219.505n 1.7v 1229.495n 1.7v 1229.505n 1.7v 1239.495n 1.7v 1239.505n 0.0v 1249.495n 0.0v 1249.505n 1.7v 1259.495n 1.7v 1259.505n 1.7v 1269.495n 1.7v 1269.505n 1.7v 1279.495n 1.7v 1279.505n 1.7v 1289.495n 1.7v 1289.505n 0.0v 1299.495n 0.0v 1299.505n 0.0v 1309.495n 0.0v 1309.505n 0.0v 1319.495n 0.0v 1319.505n 0.0v 1329.495n 0.0v 1329.505n 0.0v 1339.495n 0.0v 1339.505n 1.7v 1349.495n 1.7v 1349.505n 1.7v 1359.495n 1.7v 1359.505n 1.7v 1369.495n 1.7v 1369.505n 1.7v 1379.495n 1.7v 1379.505n 1.7v 1389.495n 1.7v 1389.505n 1.7v 1399.495n 1.7v 1399.505n 0.0v 1409.495n 0.0v 1409.505n 0.0v 1419.495n 0.0v 1419.505n 0.0v 1429.495n 0.0v 1429.505n 0.0v 1439.495n 0.0v 1439.505n 0.0v 1449.495n 0.0v 1449.505n 0.0v 1459.495n 0.0v 1459.505n 0.0v 1469.495n 0.0v 1469.505n 0.0v 1479.495n 0.0v 1479.505n 0.0v 1489.495n 0.0v 1489.505n 0.0v 1499.495n 0.0v 1499.505n 0.0v 1509.495n 0.0v 1509.505n 0.0v 1519.495n 0.0v 1519.505n 0.0v 1529.495n 0.0v 1529.505n 0.0v 1539.495n 0.0v 1539.505n 0.0v 1549.495n 0.0v 1549.505n 1.7v 1559.495n 1.7v 1559.505n 1.7v 1569.495n 1.7v 1569.505n 1.7v 1579.495n 1.7v 1579.505n 1.7v 1589.495n 1.7v 1589.505n 1.7v 1599.495n 1.7v 1599.505n 1.7v 1609.495n 1.7v 1609.505n 1.7v 1619.495n 1.7v 1619.505n 1.7v 1629.495n 1.7v 1629.505n 1.7v 1639.495n 1.7v 1639.505n 1.7v 1649.495n 1.7v 1649.505n 1.7v 1659.495n 1.7v 1659.505n 0.0v 1669.495n 0.0v 1669.505n 0.0v 1679.495n 0.0v 1679.505n 0.0v 1689.495n 0.0v 1689.505n 0.0v 1699.495n 0.0v 1699.505n 0.0v 1709.495n 0.0v 1709.505n 1.7v 1719.495n 1.7v 1719.505n 1.7v 1729.495n 1.7v 1729.505n 0.0v 1739.495n 0.0v 1739.505n 0.0v 1749.495n 0.0v 1749.505n 0.0v 1759.495n 0.0v 1759.505n 0.0v 1769.495n 0.0v 1769.505n 1.7v 1779.495n 1.7v 1779.505n 0.0v 1789.495n 0.0v 1789.505n 0.0v 1799.495n 0.0v 1799.505n 0.0v 1809.495n 0.0v 1809.505n 0.0v 1819.495n 0.0v 1819.505n 0.0v 1829.495n 0.0v 1829.505n 0.0v 1839.495n 0.0v 1839.505n 1.7v 1849.495n 1.7v 1849.505n 1.7v 1859.495n 1.7v 1859.505n 1.7v 1869.495n 1.7v 1869.505n 1.7v 1879.495n 1.7v 1879.505n 1.7v 1889.495n 1.7v 1889.505n 1.7v 1899.495n 1.7v 1899.505n 1.7v 1909.495n 1.7v 1909.505n 0.0v 1919.495n 0.0v 1919.505n 0.0v 1929.495n 0.0v 1929.505n 1.7v 1939.495n 1.7v 1939.505n 1.7v 1949.495n 1.7v 1949.505n 0.0v 1959.495n 0.0v 1959.505n 0.0v 1969.495n 0.0v 1969.505n 1.7v 1979.495n 1.7v 1979.505n 0.0v 1989.495n 0.0v 1989.505n 0.0v 1999.495n 0.0v 1999.505n 1.7v 2009.495n 1.7v 2009.505n 1.7v 2019.495n 1.7v 2019.505n 0.0v 2029.495n 0.0v 2029.505n 0.0v 2039.495n 0.0v 2039.505n 0.0v 2049.495n 0.0v 2049.505n 0.0v )
* (time, data): [(0, 0), (10, 0), (20, 0), (30, 1), (40, 1), (50, 1), (60, 0), (70, 0), (80, 0), (90, 0), (100, 1), (110, 0), (120, 0), (130, 0), (140, 0), (150, 0), (160, 0), (170, 0), (180, 0), (190, 0), (200, 0), (210, 0), (220, 0), (230, 0), (240, 0), (250, 0), (260, 0), (270, 0), (280, 1), (290, 1), (300, 1), (310, 1), (320, 0), (330, 1), (340, 1), (350, 1), (360, 1), (370, 1), (380, 1), (390, 1), (400, 1), (410, 1), (420, 0), (430, 0), (440, 1), (450, 1), (460, 1), (470, 0), (480, 0), (490, 0), (500, 0), (510, 0), (520, 0), (530, 0), (540, 0), (550, 0), (560, 0), (570, 0), (580, 0), (590, 0), (600, 1), (610, 0), (620, 1), (630, 0), (640, 0), (650, 1), (660, 1), (670, 1), (680, 1), (690, 1), (700, 1), (710, 1), (720, 1), (730, 1), (740, 0), (750, 0), (760, 0), (770, 0), (780, 0), (790, 1), (800, 1), (810, 1), (820, 0), (830, 0), (840, 1), (850, 1), (860, 0), (870, 1), (880, 1), (890, 1), (900, 0), (910, 0), (920, 0), (930, 0), (940, 0), (950, 0), (960, 0), (970, 1), (980, 1), (990, 0), (1000, 1), (1010, 1), (1020, 0), (1030, 1), (1040, 1), (1050, 1), (1060, 1), (1070, 1), (1080, 0), (1090, 0), (1100, 0), (1110, 0), (1120, 0), (1130, 0), (1140, 1), (1150, 1), (1160, 1), (1170, 0), (1180, 0), (1190, 0), (1200, 0), (1210, 0), (1220, 1), (1230, 0), (1240, 1), (1250, 1), (1260, 1), (1270, 1), (1280, 1), (1290, 1), (1300, 1), (1310, 1), (1320, 1), (1330, 1), (1340, 0), (1350, 0), (1360, 1), (1370, 0), (1380, 0), (1390, 0), (1400, 0), (1410, 0), (1420, 0), (1430, 0), (1440, 0), (1450, 0), (1460, 0), (1470, 0), (1480, 0), (1490, 0), (1500, 1), (1510, 1), (1520, 1), (1530, 1), (1540, 0), (1550, 1), (1560, 1), (1570, 1), (1580, 1), (1590, 1), (1600, 1), (1610, 1), (1620, 1), (1630, 1), (1640, 1), (1650, 1), (1660, 0), (1670, 0), (1680, 0), (1690, 0), (1700, 0), (1710, 1), (1720, 1), (1730, 1), (1740, 1), (1750, 1), (1760, 1), (1770, 1), (1780, 1), (1790, 1), (1800, 0), (1810, 0), (1820, 0), (1830, 0), (1840, 1), (1850, 1), (1860, 1), (1870, 1), (1880, 1), (1890, 1), (1900, 1), (1910, 0), (1920, 1), (1930, 1), (1940, 1), (1950, 0), (1960, 0), (1970, 0), (1980, 0), (1990, 0), (2000, 0), (2010, 0), (2020, 1), (2030, 1), (2040, 1), (2050, 1)]
Vdin0_17  din0_17  0 PWL (0n 0.0v 9.495n 0.0v 9.505n 0.0v 19.495n 0.0v 19.505n 0.0v 29.495n 0.0v 29.505n 1.7v 39.495n 1.7v 39.505n 1.7v 49.495n 1.7v 49.505n 1.7v 59.495n 1.7v 59.505n 0.0v 69.495n 0.0v 69.505n 0.0v 79.495n 0.0v 79.505n 0.0v 89.495n 0.0v 89.505n 0.0v 99.495n 0.0v 99.505n 1.7v 109.495n 1.7v 109.505n 0.0v 119.495n 0.0v 119.505n 0.0v 129.495n 0.0v 129.505n 0.0v 139.495n 0.0v 139.505n 0.0v 149.495n 0.0v 149.505n 0.0v 159.495n 0.0v 159.505n 0.0v 169.495n 0.0v 169.505n 0.0v 179.495n 0.0v 179.505n 0.0v 189.495n 0.0v 189.505n 0.0v 199.495n 0.0v 199.505n 0.0v 209.495n 0.0v 209.505n 0.0v 219.495n 0.0v 219.505n 0.0v 229.495n 0.0v 229.505n 0.0v 239.495n 0.0v 239.505n 0.0v 249.495n 0.0v 249.505n 0.0v 259.495n 0.0v 259.505n 0.0v 269.495n 0.0v 269.505n 0.0v 279.495n 0.0v 279.505n 1.7v 289.495n 1.7v 289.505n 1.7v 299.495n 1.7v 299.505n 1.7v 309.495n 1.7v 309.505n 1.7v 319.495n 1.7v 319.505n 0.0v 329.495n 0.0v 329.505n 1.7v 339.495n 1.7v 339.505n 1.7v 349.495n 1.7v 349.505n 1.7v 359.495n 1.7v 359.505n 1.7v 369.495n 1.7v 369.505n 1.7v 379.495n 1.7v 379.505n 1.7v 389.495n 1.7v 389.505n 1.7v 399.495n 1.7v 399.505n 1.7v 409.495n 1.7v 409.505n 1.7v 419.495n 1.7v 419.505n 0.0v 429.495n 0.0v 429.505n 0.0v 439.495n 0.0v 439.505n 1.7v 449.495n 1.7v 449.505n 1.7v 459.495n 1.7v 459.505n 1.7v 469.495n 1.7v 469.505n 0.0v 479.495n 0.0v 479.505n 0.0v 489.495n 0.0v 489.505n 0.0v 499.495n 0.0v 499.505n 0.0v 509.495n 0.0v 509.505n 0.0v 519.495n 0.0v 519.505n 0.0v 529.495n 0.0v 529.505n 0.0v 539.495n 0.0v 539.505n 0.0v 549.495n 0.0v 549.505n 0.0v 559.495n 0.0v 559.505n 0.0v 569.495n 0.0v 569.505n 0.0v 579.495n 0.0v 579.505n 0.0v 589.495n 0.0v 589.505n 0.0v 599.495n 0.0v 599.505n 1.7v 609.495n 1.7v 609.505n 0.0v 619.495n 0.0v 619.505n 1.7v 629.495n 1.7v 629.505n 0.0v 639.495n 0.0v 639.505n 0.0v 649.495n 0.0v 649.505n 1.7v 659.495n 1.7v 659.505n 1.7v 669.495n 1.7v 669.505n 1.7v 679.495n 1.7v 679.505n 1.7v 689.495n 1.7v 689.505n 1.7v 699.495n 1.7v 699.505n 1.7v 709.495n 1.7v 709.505n 1.7v 719.495n 1.7v 719.505n 1.7v 729.495n 1.7v 729.505n 1.7v 739.495n 1.7v 739.505n 0.0v 749.495n 0.0v 749.505n 0.0v 759.495n 0.0v 759.505n 0.0v 769.495n 0.0v 769.505n 0.0v 779.495n 0.0v 779.505n 0.0v 789.495n 0.0v 789.505n 1.7v 799.495n 1.7v 799.505n 1.7v 809.495n 1.7v 809.505n 1.7v 819.495n 1.7v 819.505n 0.0v 829.495n 0.0v 829.505n 0.0v 839.495n 0.0v 839.505n 1.7v 849.495n 1.7v 849.505n 1.7v 859.495n 1.7v 859.505n 0.0v 869.495n 0.0v 869.505n 1.7v 879.495n 1.7v 879.505n 1.7v 889.495n 1.7v 889.505n 1.7v 899.495n 1.7v 899.505n 0.0v 909.495n 0.0v 909.505n 0.0v 919.495n 0.0v 919.505n 0.0v 929.495n 0.0v 929.505n 0.0v 939.495n 0.0v 939.505n 0.0v 949.495n 0.0v 949.505n 0.0v 959.495n 0.0v 959.505n 0.0v 969.495n 0.0v 969.505n 1.7v 979.495n 1.7v 979.505n 1.7v 989.495n 1.7v 989.505n 0.0v 999.495n 0.0v 999.505n 1.7v 1009.495n 1.7v 1009.505n 1.7v 1019.495n 1.7v 1019.505n 0.0v 1029.495n 0.0v 1029.505n 1.7v 1039.495n 1.7v 1039.505n 1.7v 1049.495n 1.7v 1049.505n 1.7v 1059.495n 1.7v 1059.505n 1.7v 1069.495n 1.7v 1069.505n 1.7v 1079.495n 1.7v 1079.505n 0.0v 1089.495n 0.0v 1089.505n 0.0v 1099.495n 0.0v 1099.505n 0.0v 1109.495n 0.0v 1109.505n 0.0v 1119.495n 0.0v 1119.505n 0.0v 1129.495n 0.0v 1129.505n 0.0v 1139.495n 0.0v 1139.505n 1.7v 1149.495n 1.7v 1149.505n 1.7v 1159.495n 1.7v 1159.505n 1.7v 1169.495n 1.7v 1169.505n 0.0v 1179.495n 0.0v 1179.505n 0.0v 1189.495n 0.0v 1189.505n 0.0v 1199.495n 0.0v 1199.505n 0.0v 1209.495n 0.0v 1209.505n 0.0v 1219.495n 0.0v 1219.505n 1.7v 1229.495n 1.7v 1229.505n 0.0v 1239.495n 0.0v 1239.505n 1.7v 1249.495n 1.7v 1249.505n 1.7v 1259.495n 1.7v 1259.505n 1.7v 1269.495n 1.7v 1269.505n 1.7v 1279.495n 1.7v 1279.505n 1.7v 1289.495n 1.7v 1289.505n 1.7v 1299.495n 1.7v 1299.505n 1.7v 1309.495n 1.7v 1309.505n 1.7v 1319.495n 1.7v 1319.505n 1.7v 1329.495n 1.7v 1329.505n 1.7v 1339.495n 1.7v 1339.505n 0.0v 1349.495n 0.0v 1349.505n 0.0v 1359.495n 0.0v 1359.505n 1.7v 1369.495n 1.7v 1369.505n 0.0v 1379.495n 0.0v 1379.505n 0.0v 1389.495n 0.0v 1389.505n 0.0v 1399.495n 0.0v 1399.505n 0.0v 1409.495n 0.0v 1409.505n 0.0v 1419.495n 0.0v 1419.505n 0.0v 1429.495n 0.0v 1429.505n 0.0v 1439.495n 0.0v 1439.505n 0.0v 1449.495n 0.0v 1449.505n 0.0v 1459.495n 0.0v 1459.505n 0.0v 1469.495n 0.0v 1469.505n 0.0v 1479.495n 0.0v 1479.505n 0.0v 1489.495n 0.0v 1489.505n 0.0v 1499.495n 0.0v 1499.505n 1.7v 1509.495n 1.7v 1509.505n 1.7v 1519.495n 1.7v 1519.505n 1.7v 1529.495n 1.7v 1529.505n 1.7v 1539.495n 1.7v 1539.505n 0.0v 1549.495n 0.0v 1549.505n 1.7v 1559.495n 1.7v 1559.505n 1.7v 1569.495n 1.7v 1569.505n 1.7v 1579.495n 1.7v 1579.505n 1.7v 1589.495n 1.7v 1589.505n 1.7v 1599.495n 1.7v 1599.505n 1.7v 1609.495n 1.7v 1609.505n 1.7v 1619.495n 1.7v 1619.505n 1.7v 1629.495n 1.7v 1629.505n 1.7v 1639.495n 1.7v 1639.505n 1.7v 1649.495n 1.7v 1649.505n 1.7v 1659.495n 1.7v 1659.505n 0.0v 1669.495n 0.0v 1669.505n 0.0v 1679.495n 0.0v 1679.505n 0.0v 1689.495n 0.0v 1689.505n 0.0v 1699.495n 0.0v 1699.505n 0.0v 1709.495n 0.0v 1709.505n 1.7v 1719.495n 1.7v 1719.505n 1.7v 1729.495n 1.7v 1729.505n 1.7v 1739.495n 1.7v 1739.505n 1.7v 1749.495n 1.7v 1749.505n 1.7v 1759.495n 1.7v 1759.505n 1.7v 1769.495n 1.7v 1769.505n 1.7v 1779.495n 1.7v 1779.505n 1.7v 1789.495n 1.7v 1789.505n 1.7v 1799.495n 1.7v 1799.505n 0.0v 1809.495n 0.0v 1809.505n 0.0v 1819.495n 0.0v 1819.505n 0.0v 1829.495n 0.0v 1829.505n 0.0v 1839.495n 0.0v 1839.505n 1.7v 1849.495n 1.7v 1849.505n 1.7v 1859.495n 1.7v 1859.505n 1.7v 1869.495n 1.7v 1869.505n 1.7v 1879.495n 1.7v 1879.505n 1.7v 1889.495n 1.7v 1889.505n 1.7v 1899.495n 1.7v 1899.505n 1.7v 1909.495n 1.7v 1909.505n 0.0v 1919.495n 0.0v 1919.505n 1.7v 1929.495n 1.7v 1929.505n 1.7v 1939.495n 1.7v 1939.505n 1.7v 1949.495n 1.7v 1949.505n 0.0v 1959.495n 0.0v 1959.505n 0.0v 1969.495n 0.0v 1969.505n 0.0v 1979.495n 0.0v 1979.505n 0.0v 1989.495n 0.0v 1989.505n 0.0v 1999.495n 0.0v 1999.505n 0.0v 2009.495n 0.0v 2009.505n 0.0v 2019.495n 0.0v 2019.505n 1.7v 2029.495n 1.7v 2029.505n 1.7v 2039.495n 1.7v 2039.505n 1.7v 2049.495n 1.7v 2049.505n 1.7v )
* (time, data): [(0, 0), (10, 1), (20, 1), (30, 0), (40, 0), (50, 0), (60, 1), (70, 1), (80, 1), (90, 0), (100, 1), (110, 1), (120, 1), (130, 1), (140, 1), (150, 1), (160, 1), (170, 1), (180, 1), (190, 1), (200, 0), (210, 0), (220, 0), (230, 0), (240, 0), (250, 0), (260, 0), (270, 0), (280, 1), (290, 1), (300, 1), (310, 0), (320, 0), (330, 1), (340, 1), (350, 1), (360, 1), (370, 1), (380, 1), (390, 1), (400, 1), (410, 1), (420, 0), (430, 0), (440, 0), (450, 0), (460, 1), (470, 0), (480, 0), (490, 0), (500, 1), (510, 0), (520, 0), (530, 0), (540, 0), (550, 1), (560, 1), (570, 1), (580, 1), (590, 1), (600, 0), (610, 0), (620, 0), (630, 0), (640, 0), (650, 0), (660, 0), (670, 1), (680, 0), (690, 0), (700, 1), (710, 1), (720, 1), (730, 1), (740, 0), (750, 0), (760, 0), (770, 1), (780, 1), (790, 0), (800, 0), (810, 0), (820, 1), (830, 1), (840, 0), (850, 0), (860, 1), (870, 0), (880, 0), (890, 0), (900, 0), (910, 0), (920, 0), (930, 0), (940, 0), (950, 0), (960, 0), (970, 1), (980, 1), (990, 0), (1000, 1), (1010, 1), (1020, 0), (1030, 1), (1040, 1), (1050, 1), (1060, 1), (1070, 1), (1080, 1), (1090, 0), (1100, 0), (1110, 1), (1120, 1), (1130, 0), (1140, 1), (1150, 1), (1160, 1), (1170, 0), (1180, 0), (1190, 0), (1200, 0), (1210, 0), (1220, 1), (1230, 0), (1240, 1), (1250, 1), (1260, 1), (1270, 1), (1280, 1), (1290, 1), (1300, 0), (1310, 0), (1320, 0), (1330, 0), (1340, 0), (1350, 0), (1360, 1), (1370, 0), (1380, 0), (1390, 0), (1400, 1), (1410, 1), (1420, 1), (1430, 1), (1440, 1), (1450, 1), (1460, 1), (1470, 1), (1480, 0), (1490, 0), (1500, 0), (1510, 0), (1520, 0), (1530, 0), (1540, 1), (1550, 0), (1560, 0), (1570, 0), (1580, 0), (1590, 0), (1600, 0), (1610, 0), (1620, 1), (1630, 0), (1640, 0), (1650, 0), (1660, 1), (1670, 1), (1680, 1), (1690, 1), (1700, 1), (1710, 1), (1720, 1), (1730, 0), (1740, 0), (1750, 0), (1760, 0), (1770, 0), (1780, 0), (1790, 0), (1800, 1), (1810, 1), (1820, 1), (1830, 1), (1840, 1), (1850, 1), (1860, 0), (1870, 0), (1880, 0), (1890, 0), (1900, 0), (1910, 1), (1920, 0), (1930, 1), (1940, 0), (1950, 0), (1960, 0), (1970, 1), (1980, 0), (1990, 0), (2000, 1), (2010, 0), (2020, 1), (2030, 1), (2040, 1), (2050, 1)]
Vdin0_18  din0_18  0 PWL (0n 0.0v 9.495n 0.0v 9.505n 1.7v 19.495n 1.7v 19.505n 1.7v 29.495n 1.7v 29.505n 0.0v 39.495n 0.0v 39.505n 0.0v 49.495n 0.0v 49.505n 0.0v 59.495n 0.0v 59.505n 1.7v 69.495n 1.7v 69.505n 1.7v 79.495n 1.7v 79.505n 1.7v 89.495n 1.7v 89.505n 0.0v 99.495n 0.0v 99.505n 1.7v 109.495n 1.7v 109.505n 1.7v 119.495n 1.7v 119.505n 1.7v 129.495n 1.7v 129.505n 1.7v 139.495n 1.7v 139.505n 1.7v 149.495n 1.7v 149.505n 1.7v 159.495n 1.7v 159.505n 1.7v 169.495n 1.7v 169.505n 1.7v 179.495n 1.7v 179.505n 1.7v 189.495n 1.7v 189.505n 1.7v 199.495n 1.7v 199.505n 0.0v 209.495n 0.0v 209.505n 0.0v 219.495n 0.0v 219.505n 0.0v 229.495n 0.0v 229.505n 0.0v 239.495n 0.0v 239.505n 0.0v 249.495n 0.0v 249.505n 0.0v 259.495n 0.0v 259.505n 0.0v 269.495n 0.0v 269.505n 0.0v 279.495n 0.0v 279.505n 1.7v 289.495n 1.7v 289.505n 1.7v 299.495n 1.7v 299.505n 1.7v 309.495n 1.7v 309.505n 0.0v 319.495n 0.0v 319.505n 0.0v 329.495n 0.0v 329.505n 1.7v 339.495n 1.7v 339.505n 1.7v 349.495n 1.7v 349.505n 1.7v 359.495n 1.7v 359.505n 1.7v 369.495n 1.7v 369.505n 1.7v 379.495n 1.7v 379.505n 1.7v 389.495n 1.7v 389.505n 1.7v 399.495n 1.7v 399.505n 1.7v 409.495n 1.7v 409.505n 1.7v 419.495n 1.7v 419.505n 0.0v 429.495n 0.0v 429.505n 0.0v 439.495n 0.0v 439.505n 0.0v 449.495n 0.0v 449.505n 0.0v 459.495n 0.0v 459.505n 1.7v 469.495n 1.7v 469.505n 0.0v 479.495n 0.0v 479.505n 0.0v 489.495n 0.0v 489.505n 0.0v 499.495n 0.0v 499.505n 1.7v 509.495n 1.7v 509.505n 0.0v 519.495n 0.0v 519.505n 0.0v 529.495n 0.0v 529.505n 0.0v 539.495n 0.0v 539.505n 0.0v 549.495n 0.0v 549.505n 1.7v 559.495n 1.7v 559.505n 1.7v 569.495n 1.7v 569.505n 1.7v 579.495n 1.7v 579.505n 1.7v 589.495n 1.7v 589.505n 1.7v 599.495n 1.7v 599.505n 0.0v 609.495n 0.0v 609.505n 0.0v 619.495n 0.0v 619.505n 0.0v 629.495n 0.0v 629.505n 0.0v 639.495n 0.0v 639.505n 0.0v 649.495n 0.0v 649.505n 0.0v 659.495n 0.0v 659.505n 0.0v 669.495n 0.0v 669.505n 1.7v 679.495n 1.7v 679.505n 0.0v 689.495n 0.0v 689.505n 0.0v 699.495n 0.0v 699.505n 1.7v 709.495n 1.7v 709.505n 1.7v 719.495n 1.7v 719.505n 1.7v 729.495n 1.7v 729.505n 1.7v 739.495n 1.7v 739.505n 0.0v 749.495n 0.0v 749.505n 0.0v 759.495n 0.0v 759.505n 0.0v 769.495n 0.0v 769.505n 1.7v 779.495n 1.7v 779.505n 1.7v 789.495n 1.7v 789.505n 0.0v 799.495n 0.0v 799.505n 0.0v 809.495n 0.0v 809.505n 0.0v 819.495n 0.0v 819.505n 1.7v 829.495n 1.7v 829.505n 1.7v 839.495n 1.7v 839.505n 0.0v 849.495n 0.0v 849.505n 0.0v 859.495n 0.0v 859.505n 1.7v 869.495n 1.7v 869.505n 0.0v 879.495n 0.0v 879.505n 0.0v 889.495n 0.0v 889.505n 0.0v 899.495n 0.0v 899.505n 0.0v 909.495n 0.0v 909.505n 0.0v 919.495n 0.0v 919.505n 0.0v 929.495n 0.0v 929.505n 0.0v 939.495n 0.0v 939.505n 0.0v 949.495n 0.0v 949.505n 0.0v 959.495n 0.0v 959.505n 0.0v 969.495n 0.0v 969.505n 1.7v 979.495n 1.7v 979.505n 1.7v 989.495n 1.7v 989.505n 0.0v 999.495n 0.0v 999.505n 1.7v 1009.495n 1.7v 1009.505n 1.7v 1019.495n 1.7v 1019.505n 0.0v 1029.495n 0.0v 1029.505n 1.7v 1039.495n 1.7v 1039.505n 1.7v 1049.495n 1.7v 1049.505n 1.7v 1059.495n 1.7v 1059.505n 1.7v 1069.495n 1.7v 1069.505n 1.7v 1079.495n 1.7v 1079.505n 1.7v 1089.495n 1.7v 1089.505n 0.0v 1099.495n 0.0v 1099.505n 0.0v 1109.495n 0.0v 1109.505n 1.7v 1119.495n 1.7v 1119.505n 1.7v 1129.495n 1.7v 1129.505n 0.0v 1139.495n 0.0v 1139.505n 1.7v 1149.495n 1.7v 1149.505n 1.7v 1159.495n 1.7v 1159.505n 1.7v 1169.495n 1.7v 1169.505n 0.0v 1179.495n 0.0v 1179.505n 0.0v 1189.495n 0.0v 1189.505n 0.0v 1199.495n 0.0v 1199.505n 0.0v 1209.495n 0.0v 1209.505n 0.0v 1219.495n 0.0v 1219.505n 1.7v 1229.495n 1.7v 1229.505n 0.0v 1239.495n 0.0v 1239.505n 1.7v 1249.495n 1.7v 1249.505n 1.7v 1259.495n 1.7v 1259.505n 1.7v 1269.495n 1.7v 1269.505n 1.7v 1279.495n 1.7v 1279.505n 1.7v 1289.495n 1.7v 1289.505n 1.7v 1299.495n 1.7v 1299.505n 0.0v 1309.495n 0.0v 1309.505n 0.0v 1319.495n 0.0v 1319.505n 0.0v 1329.495n 0.0v 1329.505n 0.0v 1339.495n 0.0v 1339.505n 0.0v 1349.495n 0.0v 1349.505n 0.0v 1359.495n 0.0v 1359.505n 1.7v 1369.495n 1.7v 1369.505n 0.0v 1379.495n 0.0v 1379.505n 0.0v 1389.495n 0.0v 1389.505n 0.0v 1399.495n 0.0v 1399.505n 1.7v 1409.495n 1.7v 1409.505n 1.7v 1419.495n 1.7v 1419.505n 1.7v 1429.495n 1.7v 1429.505n 1.7v 1439.495n 1.7v 1439.505n 1.7v 1449.495n 1.7v 1449.505n 1.7v 1459.495n 1.7v 1459.505n 1.7v 1469.495n 1.7v 1469.505n 1.7v 1479.495n 1.7v 1479.505n 0.0v 1489.495n 0.0v 1489.505n 0.0v 1499.495n 0.0v 1499.505n 0.0v 1509.495n 0.0v 1509.505n 0.0v 1519.495n 0.0v 1519.505n 0.0v 1529.495n 0.0v 1529.505n 0.0v 1539.495n 0.0v 1539.505n 1.7v 1549.495n 1.7v 1549.505n 0.0v 1559.495n 0.0v 1559.505n 0.0v 1569.495n 0.0v 1569.505n 0.0v 1579.495n 0.0v 1579.505n 0.0v 1589.495n 0.0v 1589.505n 0.0v 1599.495n 0.0v 1599.505n 0.0v 1609.495n 0.0v 1609.505n 0.0v 1619.495n 0.0v 1619.505n 1.7v 1629.495n 1.7v 1629.505n 0.0v 1639.495n 0.0v 1639.505n 0.0v 1649.495n 0.0v 1649.505n 0.0v 1659.495n 0.0v 1659.505n 1.7v 1669.495n 1.7v 1669.505n 1.7v 1679.495n 1.7v 1679.505n 1.7v 1689.495n 1.7v 1689.505n 1.7v 1699.495n 1.7v 1699.505n 1.7v 1709.495n 1.7v 1709.505n 1.7v 1719.495n 1.7v 1719.505n 1.7v 1729.495n 1.7v 1729.505n 0.0v 1739.495n 0.0v 1739.505n 0.0v 1749.495n 0.0v 1749.505n 0.0v 1759.495n 0.0v 1759.505n 0.0v 1769.495n 0.0v 1769.505n 0.0v 1779.495n 0.0v 1779.505n 0.0v 1789.495n 0.0v 1789.505n 0.0v 1799.495n 0.0v 1799.505n 1.7v 1809.495n 1.7v 1809.505n 1.7v 1819.495n 1.7v 1819.505n 1.7v 1829.495n 1.7v 1829.505n 1.7v 1839.495n 1.7v 1839.505n 1.7v 1849.495n 1.7v 1849.505n 1.7v 1859.495n 1.7v 1859.505n 0.0v 1869.495n 0.0v 1869.505n 0.0v 1879.495n 0.0v 1879.505n 0.0v 1889.495n 0.0v 1889.505n 0.0v 1899.495n 0.0v 1899.505n 0.0v 1909.495n 0.0v 1909.505n 1.7v 1919.495n 1.7v 1919.505n 0.0v 1929.495n 0.0v 1929.505n 1.7v 1939.495n 1.7v 1939.505n 0.0v 1949.495n 0.0v 1949.505n 0.0v 1959.495n 0.0v 1959.505n 0.0v 1969.495n 0.0v 1969.505n 1.7v 1979.495n 1.7v 1979.505n 0.0v 1989.495n 0.0v 1989.505n 0.0v 1999.495n 0.0v 1999.505n 1.7v 2009.495n 1.7v 2009.505n 0.0v 2019.495n 0.0v 2019.505n 1.7v 2029.495n 1.7v 2029.505n 1.7v 2039.495n 1.7v 2039.505n 1.7v 2049.495n 1.7v 2049.505n 1.7v )
* (time, data): [(0, 0), (10, 0), (20, 0), (30, 1), (40, 1), (50, 1), (60, 0), (70, 0), (80, 0), (90, 0), (100, 0), (110, 0), (120, 0), (130, 0), (140, 0), (150, 1), (160, 1), (170, 1), (180, 1), (190, 0), (200, 0), (210, 1), (220, 1), (230, 1), (240, 1), (250, 1), (260, 1), (270, 1), (280, 1), (290, 1), (300, 1), (310, 0), (320, 0), (330, 1), (340, 1), (350, 1), (360, 1), (370, 1), (380, 1), (390, 1), (400, 1), (410, 1), (420, 1), (430, 1), (440, 1), (450, 1), (460, 0), (470, 0), (480, 0), (490, 0), (500, 1), (510, 0), (520, 1), (530, 1), (540, 1), (550, 0), (560, 0), (570, 0), (580, 0), (590, 0), (600, 0), (610, 0), (620, 1), (630, 1), (640, 1), (650, 1), (660, 1), (670, 1), (680, 0), (690, 0), (700, 0), (710, 0), (720, 0), (730, 0), (740, 0), (750, 0), (760, 0), (770, 1), (780, 0), (790, 1), (800, 1), (810, 1), (820, 0), (830, 0), (840, 1), (850, 1), (860, 1), (870, 1), (880, 0), (890, 0), (900, 0), (910, 0), (920, 0), (930, 0), (940, 0), (950, 0), (960, 0), (970, 0), (980, 1), (990, 1), (1000, 1), (1010, 1), (1020, 1), (1030, 1), (1040, 1), (1050, 1), (1060, 1), (1070, 0), (1080, 1), (1090, 0), (1100, 1), (1110, 0), (1120, 0), (1130, 1), (1140, 0), (1150, 0), (1160, 0), (1170, 0), (1180, 0), (1190, 0), (1200, 0), (1210, 0), (1220, 1), (1230, 0), (1240, 1), (1250, 0), (1260, 0), (1270, 0), (1280, 0), (1290, 0), (1300, 0), (1310, 0), (1320, 0), (1330, 0), (1340, 1), (1350, 1), (1360, 1), (1370, 1), (1380, 1), (1390, 1), (1400, 0), (1410, 0), (1420, 0), (1430, 0), (1440, 0), (1450, 0), (1460, 0), (1470, 0), (1480, 0), (1490, 0), (1500, 1), (1510, 1), (1520, 1), (1530, 1), (1540, 1), (1550, 1), (1560, 0), (1570, 0), (1580, 1), (1590, 1), (1600, 1), (1610, 1), (1620, 1), (1630, 1), (1640, 1), (1650, 0), (1660, 0), (1670, 0), (1680, 0), (1690, 0), (1700, 0), (1710, 0), (1720, 0), (1730, 0), (1740, 0), (1750, 1), (1760, 1), (1770, 0), (1780, 0), (1790, 0), (1800, 1), (1810, 1), (1820, 1), (1830, 1), (1840, 0), (1850, 0), (1860, 0), (1870, 0), (1880, 0), (1890, 0), (1900, 0), (1910, 1), (1920, 1), (1930, 0), (1940, 0), (1950, 0), (1960, 0), (1970, 0), (1980, 0), (1990, 0), (2000, 0), (2010, 1), (2020, 1), (2030, 1), (2040, 1), (2050, 1)]
Vdin0_19  din0_19  0 PWL (0n 0.0v 9.495n 0.0v 9.505n 0.0v 19.495n 0.0v 19.505n 0.0v 29.495n 0.0v 29.505n 1.7v 39.495n 1.7v 39.505n 1.7v 49.495n 1.7v 49.505n 1.7v 59.495n 1.7v 59.505n 0.0v 69.495n 0.0v 69.505n 0.0v 79.495n 0.0v 79.505n 0.0v 89.495n 0.0v 89.505n 0.0v 99.495n 0.0v 99.505n 0.0v 109.495n 0.0v 109.505n 0.0v 119.495n 0.0v 119.505n 0.0v 129.495n 0.0v 129.505n 0.0v 139.495n 0.0v 139.505n 0.0v 149.495n 0.0v 149.505n 1.7v 159.495n 1.7v 159.505n 1.7v 169.495n 1.7v 169.505n 1.7v 179.495n 1.7v 179.505n 1.7v 189.495n 1.7v 189.505n 0.0v 199.495n 0.0v 199.505n 0.0v 209.495n 0.0v 209.505n 1.7v 219.495n 1.7v 219.505n 1.7v 229.495n 1.7v 229.505n 1.7v 239.495n 1.7v 239.505n 1.7v 249.495n 1.7v 249.505n 1.7v 259.495n 1.7v 259.505n 1.7v 269.495n 1.7v 269.505n 1.7v 279.495n 1.7v 279.505n 1.7v 289.495n 1.7v 289.505n 1.7v 299.495n 1.7v 299.505n 1.7v 309.495n 1.7v 309.505n 0.0v 319.495n 0.0v 319.505n 0.0v 329.495n 0.0v 329.505n 1.7v 339.495n 1.7v 339.505n 1.7v 349.495n 1.7v 349.505n 1.7v 359.495n 1.7v 359.505n 1.7v 369.495n 1.7v 369.505n 1.7v 379.495n 1.7v 379.505n 1.7v 389.495n 1.7v 389.505n 1.7v 399.495n 1.7v 399.505n 1.7v 409.495n 1.7v 409.505n 1.7v 419.495n 1.7v 419.505n 1.7v 429.495n 1.7v 429.505n 1.7v 439.495n 1.7v 439.505n 1.7v 449.495n 1.7v 449.505n 1.7v 459.495n 1.7v 459.505n 0.0v 469.495n 0.0v 469.505n 0.0v 479.495n 0.0v 479.505n 0.0v 489.495n 0.0v 489.505n 0.0v 499.495n 0.0v 499.505n 1.7v 509.495n 1.7v 509.505n 0.0v 519.495n 0.0v 519.505n 1.7v 529.495n 1.7v 529.505n 1.7v 539.495n 1.7v 539.505n 1.7v 549.495n 1.7v 549.505n 0.0v 559.495n 0.0v 559.505n 0.0v 569.495n 0.0v 569.505n 0.0v 579.495n 0.0v 579.505n 0.0v 589.495n 0.0v 589.505n 0.0v 599.495n 0.0v 599.505n 0.0v 609.495n 0.0v 609.505n 0.0v 619.495n 0.0v 619.505n 1.7v 629.495n 1.7v 629.505n 1.7v 639.495n 1.7v 639.505n 1.7v 649.495n 1.7v 649.505n 1.7v 659.495n 1.7v 659.505n 1.7v 669.495n 1.7v 669.505n 1.7v 679.495n 1.7v 679.505n 0.0v 689.495n 0.0v 689.505n 0.0v 699.495n 0.0v 699.505n 0.0v 709.495n 0.0v 709.505n 0.0v 719.495n 0.0v 719.505n 0.0v 729.495n 0.0v 729.505n 0.0v 739.495n 0.0v 739.505n 0.0v 749.495n 0.0v 749.505n 0.0v 759.495n 0.0v 759.505n 0.0v 769.495n 0.0v 769.505n 1.7v 779.495n 1.7v 779.505n 0.0v 789.495n 0.0v 789.505n 1.7v 799.495n 1.7v 799.505n 1.7v 809.495n 1.7v 809.505n 1.7v 819.495n 1.7v 819.505n 0.0v 829.495n 0.0v 829.505n 0.0v 839.495n 0.0v 839.505n 1.7v 849.495n 1.7v 849.505n 1.7v 859.495n 1.7v 859.505n 1.7v 869.495n 1.7v 869.505n 1.7v 879.495n 1.7v 879.505n 0.0v 889.495n 0.0v 889.505n 0.0v 899.495n 0.0v 899.505n 0.0v 909.495n 0.0v 909.505n 0.0v 919.495n 0.0v 919.505n 0.0v 929.495n 0.0v 929.505n 0.0v 939.495n 0.0v 939.505n 0.0v 949.495n 0.0v 949.505n 0.0v 959.495n 0.0v 959.505n 0.0v 969.495n 0.0v 969.505n 0.0v 979.495n 0.0v 979.505n 1.7v 989.495n 1.7v 989.505n 1.7v 999.495n 1.7v 999.505n 1.7v 1009.495n 1.7v 1009.505n 1.7v 1019.495n 1.7v 1019.505n 1.7v 1029.495n 1.7v 1029.505n 1.7v 1039.495n 1.7v 1039.505n 1.7v 1049.495n 1.7v 1049.505n 1.7v 1059.495n 1.7v 1059.505n 1.7v 1069.495n 1.7v 1069.505n 0.0v 1079.495n 0.0v 1079.505n 1.7v 1089.495n 1.7v 1089.505n 0.0v 1099.495n 0.0v 1099.505n 1.7v 1109.495n 1.7v 1109.505n 0.0v 1119.495n 0.0v 1119.505n 0.0v 1129.495n 0.0v 1129.505n 1.7v 1139.495n 1.7v 1139.505n 0.0v 1149.495n 0.0v 1149.505n 0.0v 1159.495n 0.0v 1159.505n 0.0v 1169.495n 0.0v 1169.505n 0.0v 1179.495n 0.0v 1179.505n 0.0v 1189.495n 0.0v 1189.505n 0.0v 1199.495n 0.0v 1199.505n 0.0v 1209.495n 0.0v 1209.505n 0.0v 1219.495n 0.0v 1219.505n 1.7v 1229.495n 1.7v 1229.505n 0.0v 1239.495n 0.0v 1239.505n 1.7v 1249.495n 1.7v 1249.505n 0.0v 1259.495n 0.0v 1259.505n 0.0v 1269.495n 0.0v 1269.505n 0.0v 1279.495n 0.0v 1279.505n 0.0v 1289.495n 0.0v 1289.505n 0.0v 1299.495n 0.0v 1299.505n 0.0v 1309.495n 0.0v 1309.505n 0.0v 1319.495n 0.0v 1319.505n 0.0v 1329.495n 0.0v 1329.505n 0.0v 1339.495n 0.0v 1339.505n 1.7v 1349.495n 1.7v 1349.505n 1.7v 1359.495n 1.7v 1359.505n 1.7v 1369.495n 1.7v 1369.505n 1.7v 1379.495n 1.7v 1379.505n 1.7v 1389.495n 1.7v 1389.505n 1.7v 1399.495n 1.7v 1399.505n 0.0v 1409.495n 0.0v 1409.505n 0.0v 1419.495n 0.0v 1419.505n 0.0v 1429.495n 0.0v 1429.505n 0.0v 1439.495n 0.0v 1439.505n 0.0v 1449.495n 0.0v 1449.505n 0.0v 1459.495n 0.0v 1459.505n 0.0v 1469.495n 0.0v 1469.505n 0.0v 1479.495n 0.0v 1479.505n 0.0v 1489.495n 0.0v 1489.505n 0.0v 1499.495n 0.0v 1499.505n 1.7v 1509.495n 1.7v 1509.505n 1.7v 1519.495n 1.7v 1519.505n 1.7v 1529.495n 1.7v 1529.505n 1.7v 1539.495n 1.7v 1539.505n 1.7v 1549.495n 1.7v 1549.505n 1.7v 1559.495n 1.7v 1559.505n 0.0v 1569.495n 0.0v 1569.505n 0.0v 1579.495n 0.0v 1579.505n 1.7v 1589.495n 1.7v 1589.505n 1.7v 1599.495n 1.7v 1599.505n 1.7v 1609.495n 1.7v 1609.505n 1.7v 1619.495n 1.7v 1619.505n 1.7v 1629.495n 1.7v 1629.505n 1.7v 1639.495n 1.7v 1639.505n 1.7v 1649.495n 1.7v 1649.505n 0.0v 1659.495n 0.0v 1659.505n 0.0v 1669.495n 0.0v 1669.505n 0.0v 1679.495n 0.0v 1679.505n 0.0v 1689.495n 0.0v 1689.505n 0.0v 1699.495n 0.0v 1699.505n 0.0v 1709.495n 0.0v 1709.505n 0.0v 1719.495n 0.0v 1719.505n 0.0v 1729.495n 0.0v 1729.505n 0.0v 1739.495n 0.0v 1739.505n 0.0v 1749.495n 0.0v 1749.505n 1.7v 1759.495n 1.7v 1759.505n 1.7v 1769.495n 1.7v 1769.505n 0.0v 1779.495n 0.0v 1779.505n 0.0v 1789.495n 0.0v 1789.505n 0.0v 1799.495n 0.0v 1799.505n 1.7v 1809.495n 1.7v 1809.505n 1.7v 1819.495n 1.7v 1819.505n 1.7v 1829.495n 1.7v 1829.505n 1.7v 1839.495n 1.7v 1839.505n 0.0v 1849.495n 0.0v 1849.505n 0.0v 1859.495n 0.0v 1859.505n 0.0v 1869.495n 0.0v 1869.505n 0.0v 1879.495n 0.0v 1879.505n 0.0v 1889.495n 0.0v 1889.505n 0.0v 1899.495n 0.0v 1899.505n 0.0v 1909.495n 0.0v 1909.505n 1.7v 1919.495n 1.7v 1919.505n 1.7v 1929.495n 1.7v 1929.505n 0.0v 1939.495n 0.0v 1939.505n 0.0v 1949.495n 0.0v 1949.505n 0.0v 1959.495n 0.0v 1959.505n 0.0v 1969.495n 0.0v 1969.505n 0.0v 1979.495n 0.0v 1979.505n 0.0v 1989.495n 0.0v 1989.505n 0.0v 1999.495n 0.0v 1999.505n 0.0v 2009.495n 0.0v 2009.505n 1.7v 2019.495n 1.7v 2019.505n 1.7v 2029.495n 1.7v 2029.505n 1.7v 2039.495n 1.7v 2039.505n 1.7v 2049.495n 1.7v 2049.505n 1.7v )
* (time, data): [(0, 0), (10, 1), (20, 0), (30, 1), (40, 1), (50, 1), (60, 1), (70, 1), (80, 1), (90, 0), (100, 0), (110, 0), (120, 0), (130, 0), (140, 0), (150, 1), (160, 1), (170, 1), (180, 1), (190, 0), (200, 0), (210, 0), (220, 0), (230, 0), (240, 0), (250, 0), (260, 0), (270, 0), (280, 0), (290, 0), (300, 0), (310, 1), (320, 0), (330, 1), (340, 1), (350, 1), (360, 1), (370, 1), (380, 1), (390, 1), (400, 1), (410, 1), (420, 0), (430, 0), (440, 1), (450, 1), (460, 1), (470, 1), (480, 1), (490, 1), (500, 0), (510, 0), (520, 1), (530, 1), (540, 1), (550, 0), (560, 0), (570, 0), (580, 0), (590, 0), (600, 1), (610, 1), (620, 1), (630, 0), (640, 0), (650, 0), (660, 0), (670, 0), (680, 0), (690, 0), (700, 0), (710, 1), (720, 1), (730, 1), (740, 1), (750, 1), (760, 1), (770, 0), (780, 1), (790, 1), (800, 1), (810, 1), (820, 1), (830, 1), (840, 1), (850, 1), (860, 1), (870, 1), (880, 0), (890, 0), (900, 0), (910, 0), (920, 1), (930, 1), (940, 1), (950, 1), (960, 0), (970, 1), (980, 1), (990, 1), (1000, 1), (1010, 0), (1020, 1), (1030, 1), (1040, 1), (1050, 1), (1060, 1), (1070, 1), (1080, 1), (1090, 1), (1100, 0), (1110, 0), (1120, 0), (1130, 0), (1140, 0), (1150, 0), (1160, 0), (1170, 1), (1180, 1), (1190, 1), (1200, 1), (1210, 1), (1220, 1), (1230, 0), (1240, 1), (1250, 0), (1260, 0), (1270, 0), (1280, 0), (1290, 1), (1300, 0), (1310, 0), (1320, 0), (1330, 0), (1340, 1), (1350, 1), (1360, 1), (1370, 0), (1380, 0), (1390, 0), (1400, 0), (1410, 0), (1420, 0), (1430, 0), (1440, 0), (1450, 0), (1460, 0), (1470, 0), (1480, 0), (1490, 0), (1500, 1), (1510, 1), (1520, 1), (1530, 1), (1540, 1), (1550, 0), (1560, 1), (1570, 1), (1580, 1), (1590, 1), (1600, 1), (1610, 1), (1620, 1), (1630, 0), (1640, 0), (1650, 1), (1660, 1), (1670, 1), (1680, 1), (1690, 1), (1700, 1), (1710, 1), (1720, 1), (1730, 1), (1740, 1), (1750, 0), (1760, 0), (1770, 0), (1780, 1), (1790, 1), (1800, 0), (1810, 0), (1820, 0), (1830, 0), (1840, 1), (1850, 1), (1860, 0), (1870, 0), (1880, 0), (1890, 0), (1900, 0), (1910, 0), (1920, 0), (1930, 1), (1940, 1), (1950, 0), (1960, 0), (1970, 1), (1980, 0), (1990, 0), (2000, 0), (2010, 0), (2020, 0), (2030, 0), (2040, 0), (2050, 0)]
Vdin0_20  din0_20  0 PWL (0n 0.0v 9.495n 0.0v 9.505n 1.7v 19.495n 1.7v 19.505n 0.0v 29.495n 0.0v 29.505n 1.7v 39.495n 1.7v 39.505n 1.7v 49.495n 1.7v 49.505n 1.7v 59.495n 1.7v 59.505n 1.7v 69.495n 1.7v 69.505n 1.7v 79.495n 1.7v 79.505n 1.7v 89.495n 1.7v 89.505n 0.0v 99.495n 0.0v 99.505n 0.0v 109.495n 0.0v 109.505n 0.0v 119.495n 0.0v 119.505n 0.0v 129.495n 0.0v 129.505n 0.0v 139.495n 0.0v 139.505n 0.0v 149.495n 0.0v 149.505n 1.7v 159.495n 1.7v 159.505n 1.7v 169.495n 1.7v 169.505n 1.7v 179.495n 1.7v 179.505n 1.7v 189.495n 1.7v 189.505n 0.0v 199.495n 0.0v 199.505n 0.0v 209.495n 0.0v 209.505n 0.0v 219.495n 0.0v 219.505n 0.0v 229.495n 0.0v 229.505n 0.0v 239.495n 0.0v 239.505n 0.0v 249.495n 0.0v 249.505n 0.0v 259.495n 0.0v 259.505n 0.0v 269.495n 0.0v 269.505n 0.0v 279.495n 0.0v 279.505n 0.0v 289.495n 0.0v 289.505n 0.0v 299.495n 0.0v 299.505n 0.0v 309.495n 0.0v 309.505n 1.7v 319.495n 1.7v 319.505n 0.0v 329.495n 0.0v 329.505n 1.7v 339.495n 1.7v 339.505n 1.7v 349.495n 1.7v 349.505n 1.7v 359.495n 1.7v 359.505n 1.7v 369.495n 1.7v 369.505n 1.7v 379.495n 1.7v 379.505n 1.7v 389.495n 1.7v 389.505n 1.7v 399.495n 1.7v 399.505n 1.7v 409.495n 1.7v 409.505n 1.7v 419.495n 1.7v 419.505n 0.0v 429.495n 0.0v 429.505n 0.0v 439.495n 0.0v 439.505n 1.7v 449.495n 1.7v 449.505n 1.7v 459.495n 1.7v 459.505n 1.7v 469.495n 1.7v 469.505n 1.7v 479.495n 1.7v 479.505n 1.7v 489.495n 1.7v 489.505n 1.7v 499.495n 1.7v 499.505n 0.0v 509.495n 0.0v 509.505n 0.0v 519.495n 0.0v 519.505n 1.7v 529.495n 1.7v 529.505n 1.7v 539.495n 1.7v 539.505n 1.7v 549.495n 1.7v 549.505n 0.0v 559.495n 0.0v 559.505n 0.0v 569.495n 0.0v 569.505n 0.0v 579.495n 0.0v 579.505n 0.0v 589.495n 0.0v 589.505n 0.0v 599.495n 0.0v 599.505n 1.7v 609.495n 1.7v 609.505n 1.7v 619.495n 1.7v 619.505n 1.7v 629.495n 1.7v 629.505n 0.0v 639.495n 0.0v 639.505n 0.0v 649.495n 0.0v 649.505n 0.0v 659.495n 0.0v 659.505n 0.0v 669.495n 0.0v 669.505n 0.0v 679.495n 0.0v 679.505n 0.0v 689.495n 0.0v 689.505n 0.0v 699.495n 0.0v 699.505n 0.0v 709.495n 0.0v 709.505n 1.7v 719.495n 1.7v 719.505n 1.7v 729.495n 1.7v 729.505n 1.7v 739.495n 1.7v 739.505n 1.7v 749.495n 1.7v 749.505n 1.7v 759.495n 1.7v 759.505n 1.7v 769.495n 1.7v 769.505n 0.0v 779.495n 0.0v 779.505n 1.7v 789.495n 1.7v 789.505n 1.7v 799.495n 1.7v 799.505n 1.7v 809.495n 1.7v 809.505n 1.7v 819.495n 1.7v 819.505n 1.7v 829.495n 1.7v 829.505n 1.7v 839.495n 1.7v 839.505n 1.7v 849.495n 1.7v 849.505n 1.7v 859.495n 1.7v 859.505n 1.7v 869.495n 1.7v 869.505n 1.7v 879.495n 1.7v 879.505n 0.0v 889.495n 0.0v 889.505n 0.0v 899.495n 0.0v 899.505n 0.0v 909.495n 0.0v 909.505n 0.0v 919.495n 0.0v 919.505n 1.7v 929.495n 1.7v 929.505n 1.7v 939.495n 1.7v 939.505n 1.7v 949.495n 1.7v 949.505n 1.7v 959.495n 1.7v 959.505n 0.0v 969.495n 0.0v 969.505n 1.7v 979.495n 1.7v 979.505n 1.7v 989.495n 1.7v 989.505n 1.7v 999.495n 1.7v 999.505n 1.7v 1009.495n 1.7v 1009.505n 0.0v 1019.495n 0.0v 1019.505n 1.7v 1029.495n 1.7v 1029.505n 1.7v 1039.495n 1.7v 1039.505n 1.7v 1049.495n 1.7v 1049.505n 1.7v 1059.495n 1.7v 1059.505n 1.7v 1069.495n 1.7v 1069.505n 1.7v 1079.495n 1.7v 1079.505n 1.7v 1089.495n 1.7v 1089.505n 1.7v 1099.495n 1.7v 1099.505n 0.0v 1109.495n 0.0v 1109.505n 0.0v 1119.495n 0.0v 1119.505n 0.0v 1129.495n 0.0v 1129.505n 0.0v 1139.495n 0.0v 1139.505n 0.0v 1149.495n 0.0v 1149.505n 0.0v 1159.495n 0.0v 1159.505n 0.0v 1169.495n 0.0v 1169.505n 1.7v 1179.495n 1.7v 1179.505n 1.7v 1189.495n 1.7v 1189.505n 1.7v 1199.495n 1.7v 1199.505n 1.7v 1209.495n 1.7v 1209.505n 1.7v 1219.495n 1.7v 1219.505n 1.7v 1229.495n 1.7v 1229.505n 0.0v 1239.495n 0.0v 1239.505n 1.7v 1249.495n 1.7v 1249.505n 0.0v 1259.495n 0.0v 1259.505n 0.0v 1269.495n 0.0v 1269.505n 0.0v 1279.495n 0.0v 1279.505n 0.0v 1289.495n 0.0v 1289.505n 1.7v 1299.495n 1.7v 1299.505n 0.0v 1309.495n 0.0v 1309.505n 0.0v 1319.495n 0.0v 1319.505n 0.0v 1329.495n 0.0v 1329.505n 0.0v 1339.495n 0.0v 1339.505n 1.7v 1349.495n 1.7v 1349.505n 1.7v 1359.495n 1.7v 1359.505n 1.7v 1369.495n 1.7v 1369.505n 0.0v 1379.495n 0.0v 1379.505n 0.0v 1389.495n 0.0v 1389.505n 0.0v 1399.495n 0.0v 1399.505n 0.0v 1409.495n 0.0v 1409.505n 0.0v 1419.495n 0.0v 1419.505n 0.0v 1429.495n 0.0v 1429.505n 0.0v 1439.495n 0.0v 1439.505n 0.0v 1449.495n 0.0v 1449.505n 0.0v 1459.495n 0.0v 1459.505n 0.0v 1469.495n 0.0v 1469.505n 0.0v 1479.495n 0.0v 1479.505n 0.0v 1489.495n 0.0v 1489.505n 0.0v 1499.495n 0.0v 1499.505n 1.7v 1509.495n 1.7v 1509.505n 1.7v 1519.495n 1.7v 1519.505n 1.7v 1529.495n 1.7v 1529.505n 1.7v 1539.495n 1.7v 1539.505n 1.7v 1549.495n 1.7v 1549.505n 0.0v 1559.495n 0.0v 1559.505n 1.7v 1569.495n 1.7v 1569.505n 1.7v 1579.495n 1.7v 1579.505n 1.7v 1589.495n 1.7v 1589.505n 1.7v 1599.495n 1.7v 1599.505n 1.7v 1609.495n 1.7v 1609.505n 1.7v 1619.495n 1.7v 1619.505n 1.7v 1629.495n 1.7v 1629.505n 0.0v 1639.495n 0.0v 1639.505n 0.0v 1649.495n 0.0v 1649.505n 1.7v 1659.495n 1.7v 1659.505n 1.7v 1669.495n 1.7v 1669.505n 1.7v 1679.495n 1.7v 1679.505n 1.7v 1689.495n 1.7v 1689.505n 1.7v 1699.495n 1.7v 1699.505n 1.7v 1709.495n 1.7v 1709.505n 1.7v 1719.495n 1.7v 1719.505n 1.7v 1729.495n 1.7v 1729.505n 1.7v 1739.495n 1.7v 1739.505n 1.7v 1749.495n 1.7v 1749.505n 0.0v 1759.495n 0.0v 1759.505n 0.0v 1769.495n 0.0v 1769.505n 0.0v 1779.495n 0.0v 1779.505n 1.7v 1789.495n 1.7v 1789.505n 1.7v 1799.495n 1.7v 1799.505n 0.0v 1809.495n 0.0v 1809.505n 0.0v 1819.495n 0.0v 1819.505n 0.0v 1829.495n 0.0v 1829.505n 0.0v 1839.495n 0.0v 1839.505n 1.7v 1849.495n 1.7v 1849.505n 1.7v 1859.495n 1.7v 1859.505n 0.0v 1869.495n 0.0v 1869.505n 0.0v 1879.495n 0.0v 1879.505n 0.0v 1889.495n 0.0v 1889.505n 0.0v 1899.495n 0.0v 1899.505n 0.0v 1909.495n 0.0v 1909.505n 0.0v 1919.495n 0.0v 1919.505n 0.0v 1929.495n 0.0v 1929.505n 1.7v 1939.495n 1.7v 1939.505n 1.7v 1949.495n 1.7v 1949.505n 0.0v 1959.495n 0.0v 1959.505n 0.0v 1969.495n 0.0v 1969.505n 1.7v 1979.495n 1.7v 1979.505n 0.0v 1989.495n 0.0v 1989.505n 0.0v 1999.495n 0.0v 1999.505n 0.0v 2009.495n 0.0v 2009.505n 0.0v 2019.495n 0.0v 2019.505n 0.0v 2029.495n 0.0v 2029.505n 0.0v 2039.495n 0.0v 2039.505n 0.0v 2049.495n 0.0v 2049.505n 0.0v )
* (time, data): [(0, 0), (10, 0), (20, 1), (30, 0), (40, 0), (50, 0), (60, 1), (70, 1), (80, 1), (90, 0), (100, 0), (110, 0), (120, 0), (130, 0), (140, 0), (150, 1), (160, 1), (170, 1), (180, 1), (190, 1), (200, 0), (210, 1), (220, 1), (230, 1), (240, 1), (250, 1), (260, 1), (270, 1), (280, 1), (290, 1), (300, 1), (310, 0), (320, 1), (330, 1), (340, 1), (350, 1), (360, 1), (370, 1), (380, 1), (390, 1), (400, 1), (410, 1), (420, 0), (430, 0), (440, 0), (450, 0), (460, 1), (470, 1), (480, 1), (490, 1), (500, 1), (510, 1), (520, 0), (530, 0), (540, 0), (550, 0), (560, 1), (570, 1), (580, 1), (590, 1), (600, 0), (610, 1), (620, 0), (630, 0), (640, 0), (650, 1), (660, 1), (670, 0), (680, 1), (690, 1), (700, 1), (710, 0), (720, 0), (730, 0), (740, 0), (750, 0), (760, 0), (770, 1), (780, 1), (790, 1), (800, 0), (810, 0), (820, 0), (830, 0), (840, 1), (850, 1), (860, 0), (870, 0), (880, 1), (890, 1), (900, 1), (910, 1), (920, 0), (930, 0), (940, 0), (950, 0), (960, 0), (970, 0), (980, 1), (990, 0), (1000, 1), (1010, 1), (1020, 1), (1030, 1), (1040, 1), (1050, 1), (1060, 1), (1070, 0), (1080, 1), (1090, 1), (1100, 1), (1110, 1), (1120, 1), (1130, 1), (1140, 0), (1150, 0), (1160, 0), (1170, 1), (1180, 0), (1190, 0), (1200, 0), (1210, 0), (1220, 0), (1230, 0), (1240, 0), (1250, 0), (1260, 0), (1270, 0), (1280, 0), (1290, 0), (1300, 1), (1310, 1), (1320, 1), (1330, 1), (1340, 0), (1350, 0), (1360, 0), (1370, 1), (1380, 1), (1390, 1), (1400, 1), (1410, 1), (1420, 1), (1430, 1), (1440, 1), (1450, 1), (1460, 1), (1470, 1), (1480, 0), (1490, 0), (1500, 0), (1510, 0), (1520, 0), (1530, 0), (1540, 0), (1550, 0), (1560, 0), (1570, 0), (1580, 0), (1590, 0), (1600, 0), (1610, 0), (1620, 0), (1630, 0), (1640, 0), (1650, 0), (1660, 0), (1670, 0), (1680, 0), (1690, 0), (1700, 0), (1710, 1), (1720, 1), (1730, 0), (1740, 0), (1750, 0), (1760, 0), (1770, 0), (1780, 1), (1790, 1), (1800, 1), (1810, 1), (1820, 1), (1830, 1), (1840, 1), (1850, 1), (1860, 0), (1870, 0), (1880, 0), (1890, 0), (1900, 0), (1910, 0), (1920, 1), (1930, 1), (1940, 0), (1950, 0), (1960, 0), (1970, 0), (1980, 0), (1990, 0), (2000, 1), (2010, 0), (2020, 1), (2030, 1), (2040, 1), (2050, 1)]
Vdin0_21  din0_21  0 PWL (0n 0.0v 9.495n 0.0v 9.505n 0.0v 19.495n 0.0v 19.505n 1.7v 29.495n 1.7v 29.505n 0.0v 39.495n 0.0v 39.505n 0.0v 49.495n 0.0v 49.505n 0.0v 59.495n 0.0v 59.505n 1.7v 69.495n 1.7v 69.505n 1.7v 79.495n 1.7v 79.505n 1.7v 89.495n 1.7v 89.505n 0.0v 99.495n 0.0v 99.505n 0.0v 109.495n 0.0v 109.505n 0.0v 119.495n 0.0v 119.505n 0.0v 129.495n 0.0v 129.505n 0.0v 139.495n 0.0v 139.505n 0.0v 149.495n 0.0v 149.505n 1.7v 159.495n 1.7v 159.505n 1.7v 169.495n 1.7v 169.505n 1.7v 179.495n 1.7v 179.505n 1.7v 189.495n 1.7v 189.505n 1.7v 199.495n 1.7v 199.505n 0.0v 209.495n 0.0v 209.505n 1.7v 219.495n 1.7v 219.505n 1.7v 229.495n 1.7v 229.505n 1.7v 239.495n 1.7v 239.505n 1.7v 249.495n 1.7v 249.505n 1.7v 259.495n 1.7v 259.505n 1.7v 269.495n 1.7v 269.505n 1.7v 279.495n 1.7v 279.505n 1.7v 289.495n 1.7v 289.505n 1.7v 299.495n 1.7v 299.505n 1.7v 309.495n 1.7v 309.505n 0.0v 319.495n 0.0v 319.505n 1.7v 329.495n 1.7v 329.505n 1.7v 339.495n 1.7v 339.505n 1.7v 349.495n 1.7v 349.505n 1.7v 359.495n 1.7v 359.505n 1.7v 369.495n 1.7v 369.505n 1.7v 379.495n 1.7v 379.505n 1.7v 389.495n 1.7v 389.505n 1.7v 399.495n 1.7v 399.505n 1.7v 409.495n 1.7v 409.505n 1.7v 419.495n 1.7v 419.505n 0.0v 429.495n 0.0v 429.505n 0.0v 439.495n 0.0v 439.505n 0.0v 449.495n 0.0v 449.505n 0.0v 459.495n 0.0v 459.505n 1.7v 469.495n 1.7v 469.505n 1.7v 479.495n 1.7v 479.505n 1.7v 489.495n 1.7v 489.505n 1.7v 499.495n 1.7v 499.505n 1.7v 509.495n 1.7v 509.505n 1.7v 519.495n 1.7v 519.505n 0.0v 529.495n 0.0v 529.505n 0.0v 539.495n 0.0v 539.505n 0.0v 549.495n 0.0v 549.505n 0.0v 559.495n 0.0v 559.505n 1.7v 569.495n 1.7v 569.505n 1.7v 579.495n 1.7v 579.505n 1.7v 589.495n 1.7v 589.505n 1.7v 599.495n 1.7v 599.505n 0.0v 609.495n 0.0v 609.505n 1.7v 619.495n 1.7v 619.505n 0.0v 629.495n 0.0v 629.505n 0.0v 639.495n 0.0v 639.505n 0.0v 649.495n 0.0v 649.505n 1.7v 659.495n 1.7v 659.505n 1.7v 669.495n 1.7v 669.505n 0.0v 679.495n 0.0v 679.505n 1.7v 689.495n 1.7v 689.505n 1.7v 699.495n 1.7v 699.505n 1.7v 709.495n 1.7v 709.505n 0.0v 719.495n 0.0v 719.505n 0.0v 729.495n 0.0v 729.505n 0.0v 739.495n 0.0v 739.505n 0.0v 749.495n 0.0v 749.505n 0.0v 759.495n 0.0v 759.505n 0.0v 769.495n 0.0v 769.505n 1.7v 779.495n 1.7v 779.505n 1.7v 789.495n 1.7v 789.505n 1.7v 799.495n 1.7v 799.505n 0.0v 809.495n 0.0v 809.505n 0.0v 819.495n 0.0v 819.505n 0.0v 829.495n 0.0v 829.505n 0.0v 839.495n 0.0v 839.505n 1.7v 849.495n 1.7v 849.505n 1.7v 859.495n 1.7v 859.505n 0.0v 869.495n 0.0v 869.505n 0.0v 879.495n 0.0v 879.505n 1.7v 889.495n 1.7v 889.505n 1.7v 899.495n 1.7v 899.505n 1.7v 909.495n 1.7v 909.505n 1.7v 919.495n 1.7v 919.505n 0.0v 929.495n 0.0v 929.505n 0.0v 939.495n 0.0v 939.505n 0.0v 949.495n 0.0v 949.505n 0.0v 959.495n 0.0v 959.505n 0.0v 969.495n 0.0v 969.505n 0.0v 979.495n 0.0v 979.505n 1.7v 989.495n 1.7v 989.505n 0.0v 999.495n 0.0v 999.505n 1.7v 1009.495n 1.7v 1009.505n 1.7v 1019.495n 1.7v 1019.505n 1.7v 1029.495n 1.7v 1029.505n 1.7v 1039.495n 1.7v 1039.505n 1.7v 1049.495n 1.7v 1049.505n 1.7v 1059.495n 1.7v 1059.505n 1.7v 1069.495n 1.7v 1069.505n 0.0v 1079.495n 0.0v 1079.505n 1.7v 1089.495n 1.7v 1089.505n 1.7v 1099.495n 1.7v 1099.505n 1.7v 1109.495n 1.7v 1109.505n 1.7v 1119.495n 1.7v 1119.505n 1.7v 1129.495n 1.7v 1129.505n 1.7v 1139.495n 1.7v 1139.505n 0.0v 1149.495n 0.0v 1149.505n 0.0v 1159.495n 0.0v 1159.505n 0.0v 1169.495n 0.0v 1169.505n 1.7v 1179.495n 1.7v 1179.505n 0.0v 1189.495n 0.0v 1189.505n 0.0v 1199.495n 0.0v 1199.505n 0.0v 1209.495n 0.0v 1209.505n 0.0v 1219.495n 0.0v 1219.505n 0.0v 1229.495n 0.0v 1229.505n 0.0v 1239.495n 0.0v 1239.505n 0.0v 1249.495n 0.0v 1249.505n 0.0v 1259.495n 0.0v 1259.505n 0.0v 1269.495n 0.0v 1269.505n 0.0v 1279.495n 0.0v 1279.505n 0.0v 1289.495n 0.0v 1289.505n 0.0v 1299.495n 0.0v 1299.505n 1.7v 1309.495n 1.7v 1309.505n 1.7v 1319.495n 1.7v 1319.505n 1.7v 1329.495n 1.7v 1329.505n 1.7v 1339.495n 1.7v 1339.505n 0.0v 1349.495n 0.0v 1349.505n 0.0v 1359.495n 0.0v 1359.505n 0.0v 1369.495n 0.0v 1369.505n 1.7v 1379.495n 1.7v 1379.505n 1.7v 1389.495n 1.7v 1389.505n 1.7v 1399.495n 1.7v 1399.505n 1.7v 1409.495n 1.7v 1409.505n 1.7v 1419.495n 1.7v 1419.505n 1.7v 1429.495n 1.7v 1429.505n 1.7v 1439.495n 1.7v 1439.505n 1.7v 1449.495n 1.7v 1449.505n 1.7v 1459.495n 1.7v 1459.505n 1.7v 1469.495n 1.7v 1469.505n 1.7v 1479.495n 1.7v 1479.505n 0.0v 1489.495n 0.0v 1489.505n 0.0v 1499.495n 0.0v 1499.505n 0.0v 1509.495n 0.0v 1509.505n 0.0v 1519.495n 0.0v 1519.505n 0.0v 1529.495n 0.0v 1529.505n 0.0v 1539.495n 0.0v 1539.505n 0.0v 1549.495n 0.0v 1549.505n 0.0v 1559.495n 0.0v 1559.505n 0.0v 1569.495n 0.0v 1569.505n 0.0v 1579.495n 0.0v 1579.505n 0.0v 1589.495n 0.0v 1589.505n 0.0v 1599.495n 0.0v 1599.505n 0.0v 1609.495n 0.0v 1609.505n 0.0v 1619.495n 0.0v 1619.505n 0.0v 1629.495n 0.0v 1629.505n 0.0v 1639.495n 0.0v 1639.505n 0.0v 1649.495n 0.0v 1649.505n 0.0v 1659.495n 0.0v 1659.505n 0.0v 1669.495n 0.0v 1669.505n 0.0v 1679.495n 0.0v 1679.505n 0.0v 1689.495n 0.0v 1689.505n 0.0v 1699.495n 0.0v 1699.505n 0.0v 1709.495n 0.0v 1709.505n 1.7v 1719.495n 1.7v 1719.505n 1.7v 1729.495n 1.7v 1729.505n 0.0v 1739.495n 0.0v 1739.505n 0.0v 1749.495n 0.0v 1749.505n 0.0v 1759.495n 0.0v 1759.505n 0.0v 1769.495n 0.0v 1769.505n 0.0v 1779.495n 0.0v 1779.505n 1.7v 1789.495n 1.7v 1789.505n 1.7v 1799.495n 1.7v 1799.505n 1.7v 1809.495n 1.7v 1809.505n 1.7v 1819.495n 1.7v 1819.505n 1.7v 1829.495n 1.7v 1829.505n 1.7v 1839.495n 1.7v 1839.505n 1.7v 1849.495n 1.7v 1849.505n 1.7v 1859.495n 1.7v 1859.505n 0.0v 1869.495n 0.0v 1869.505n 0.0v 1879.495n 0.0v 1879.505n 0.0v 1889.495n 0.0v 1889.505n 0.0v 1899.495n 0.0v 1899.505n 0.0v 1909.495n 0.0v 1909.505n 0.0v 1919.495n 0.0v 1919.505n 1.7v 1929.495n 1.7v 1929.505n 1.7v 1939.495n 1.7v 1939.505n 0.0v 1949.495n 0.0v 1949.505n 0.0v 1959.495n 0.0v 1959.505n 0.0v 1969.495n 0.0v 1969.505n 0.0v 1979.495n 0.0v 1979.505n 0.0v 1989.495n 0.0v 1989.505n 0.0v 1999.495n 0.0v 1999.505n 1.7v 2009.495n 1.7v 2009.505n 0.0v 2019.495n 0.0v 2019.505n 1.7v 2029.495n 1.7v 2029.505n 1.7v 2039.495n 1.7v 2039.505n 1.7v 2049.495n 1.7v 2049.505n 1.7v )
* (time, data): [(0, 0), (10, 1), (20, 0), (30, 0), (40, 0), (50, 0), (60, 0), (70, 0), (80, 0), (90, 0), (100, 0), (110, 1), (120, 1), (130, 1), (140, 1), (150, 1), (160, 1), (170, 1), (180, 1), (190, 1), (200, 0), (210, 1), (220, 1), (230, 1), (240, 1), (250, 1), (260, 1), (270, 1), (280, 0), (290, 0), (300, 0), (310, 0), (320, 0), (330, 0), (340, 0), (350, 0), (360, 0), (370, 0), (380, 0), (390, 0), (400, 0), (410, 0), (420, 1), (430, 1), (440, 1), (450, 1), (460, 0), (470, 1), (480, 1), (490, 1), (500, 0), (510, 0), (520, 1), (530, 1), (540, 1), (550, 1), (560, 0), (570, 0), (580, 0), (590, 0), (600, 0), (610, 0), (620, 1), (630, 1), (640, 1), (650, 0), (660, 0), (670, 0), (680, 0), (690, 0), (700, 1), (710, 0), (720, 0), (730, 0), (740, 1), (750, 1), (760, 1), (770, 0), (780, 1), (790, 0), (800, 1), (810, 1), (820, 1), (830, 0), (840, 0), (850, 0), (860, 1), (870, 0), (880, 0), (890, 0), (900, 1), (910, 1), (920, 1), (930, 1), (940, 1), (950, 1), (960, 0), (970, 0), (980, 0), (990, 0), (1000, 0), (1010, 1), (1020, 0), (1030, 0), (1040, 0), (1050, 0), (1060, 0), (1070, 0), (1080, 0), (1090, 1), (1100, 0), (1110, 0), (1120, 0), (1130, 0), (1140, 0), (1150, 0), (1160, 0), (1170, 1), (1180, 1), (1190, 1), (1200, 1), (1210, 1), (1220, 1), (1230, 0), (1240, 0), (1250, 1), (1260, 1), (1270, 1), (1280, 1), (1290, 0), (1300, 0), (1310, 0), (1320, 0), (1330, 0), (1340, 1), (1350, 1), (1360, 1), (1370, 0), (1380, 0), (1390, 0), (1400, 1), (1410, 1), (1420, 1), (1430, 1), (1440, 1), (1450, 1), (1460, 1), (1470, 1), (1480, 0), (1490, 0), (1500, 1), (1510, 0), (1520, 0), (1530, 0), (1540, 1), (1550, 1), (1560, 0), (1570, 0), (1580, 1), (1590, 1), (1600, 1), (1610, 1), (1620, 0), (1630, 1), (1640, 1), (1650, 1), (1660, 1), (1670, 1), (1680, 1), (1690, 1), (1700, 1), (1710, 1), (1720, 1), (1730, 1), (1740, 1), (1750, 1), (1760, 1), (1770, 1), (1780, 1), (1790, 1), (1800, 1), (1810, 1), (1820, 1), (1830, 1), (1840, 1), (1850, 1), (1860, 0), (1870, 0), (1880, 0), (1890, 0), (1900, 0), (1910, 0), (1920, 1), (1930, 0), (1940, 0), (1950, 1), (1960, 1), (1970, 1), (1980, 0), (1990, 0), (2000, 1), (2010, 1), (2020, 1), (2030, 1), (2040, 1), (2050, 1)]
Vdin0_22  din0_22  0 PWL (0n 0.0v 9.495n 0.0v 9.505n 1.7v 19.495n 1.7v 19.505n 0.0v 29.495n 0.0v 29.505n 0.0v 39.495n 0.0v 39.505n 0.0v 49.495n 0.0v 49.505n 0.0v 59.495n 0.0v 59.505n 0.0v 69.495n 0.0v 69.505n 0.0v 79.495n 0.0v 79.505n 0.0v 89.495n 0.0v 89.505n 0.0v 99.495n 0.0v 99.505n 0.0v 109.495n 0.0v 109.505n 1.7v 119.495n 1.7v 119.505n 1.7v 129.495n 1.7v 129.505n 1.7v 139.495n 1.7v 139.505n 1.7v 149.495n 1.7v 149.505n 1.7v 159.495n 1.7v 159.505n 1.7v 169.495n 1.7v 169.505n 1.7v 179.495n 1.7v 179.505n 1.7v 189.495n 1.7v 189.505n 1.7v 199.495n 1.7v 199.505n 0.0v 209.495n 0.0v 209.505n 1.7v 219.495n 1.7v 219.505n 1.7v 229.495n 1.7v 229.505n 1.7v 239.495n 1.7v 239.505n 1.7v 249.495n 1.7v 249.505n 1.7v 259.495n 1.7v 259.505n 1.7v 269.495n 1.7v 269.505n 1.7v 279.495n 1.7v 279.505n 0.0v 289.495n 0.0v 289.505n 0.0v 299.495n 0.0v 299.505n 0.0v 309.495n 0.0v 309.505n 0.0v 319.495n 0.0v 319.505n 0.0v 329.495n 0.0v 329.505n 0.0v 339.495n 0.0v 339.505n 0.0v 349.495n 0.0v 349.505n 0.0v 359.495n 0.0v 359.505n 0.0v 369.495n 0.0v 369.505n 0.0v 379.495n 0.0v 379.505n 0.0v 389.495n 0.0v 389.505n 0.0v 399.495n 0.0v 399.505n 0.0v 409.495n 0.0v 409.505n 0.0v 419.495n 0.0v 419.505n 1.7v 429.495n 1.7v 429.505n 1.7v 439.495n 1.7v 439.505n 1.7v 449.495n 1.7v 449.505n 1.7v 459.495n 1.7v 459.505n 0.0v 469.495n 0.0v 469.505n 1.7v 479.495n 1.7v 479.505n 1.7v 489.495n 1.7v 489.505n 1.7v 499.495n 1.7v 499.505n 0.0v 509.495n 0.0v 509.505n 0.0v 519.495n 0.0v 519.505n 1.7v 529.495n 1.7v 529.505n 1.7v 539.495n 1.7v 539.505n 1.7v 549.495n 1.7v 549.505n 1.7v 559.495n 1.7v 559.505n 0.0v 569.495n 0.0v 569.505n 0.0v 579.495n 0.0v 579.505n 0.0v 589.495n 0.0v 589.505n 0.0v 599.495n 0.0v 599.505n 0.0v 609.495n 0.0v 609.505n 0.0v 619.495n 0.0v 619.505n 1.7v 629.495n 1.7v 629.505n 1.7v 639.495n 1.7v 639.505n 1.7v 649.495n 1.7v 649.505n 0.0v 659.495n 0.0v 659.505n 0.0v 669.495n 0.0v 669.505n 0.0v 679.495n 0.0v 679.505n 0.0v 689.495n 0.0v 689.505n 0.0v 699.495n 0.0v 699.505n 1.7v 709.495n 1.7v 709.505n 0.0v 719.495n 0.0v 719.505n 0.0v 729.495n 0.0v 729.505n 0.0v 739.495n 0.0v 739.505n 1.7v 749.495n 1.7v 749.505n 1.7v 759.495n 1.7v 759.505n 1.7v 769.495n 1.7v 769.505n 0.0v 779.495n 0.0v 779.505n 1.7v 789.495n 1.7v 789.505n 0.0v 799.495n 0.0v 799.505n 1.7v 809.495n 1.7v 809.505n 1.7v 819.495n 1.7v 819.505n 1.7v 829.495n 1.7v 829.505n 0.0v 839.495n 0.0v 839.505n 0.0v 849.495n 0.0v 849.505n 0.0v 859.495n 0.0v 859.505n 1.7v 869.495n 1.7v 869.505n 0.0v 879.495n 0.0v 879.505n 0.0v 889.495n 0.0v 889.505n 0.0v 899.495n 0.0v 899.505n 1.7v 909.495n 1.7v 909.505n 1.7v 919.495n 1.7v 919.505n 1.7v 929.495n 1.7v 929.505n 1.7v 939.495n 1.7v 939.505n 1.7v 949.495n 1.7v 949.505n 1.7v 959.495n 1.7v 959.505n 0.0v 969.495n 0.0v 969.505n 0.0v 979.495n 0.0v 979.505n 0.0v 989.495n 0.0v 989.505n 0.0v 999.495n 0.0v 999.505n 0.0v 1009.495n 0.0v 1009.505n 1.7v 1019.495n 1.7v 1019.505n 0.0v 1029.495n 0.0v 1029.505n 0.0v 1039.495n 0.0v 1039.505n 0.0v 1049.495n 0.0v 1049.505n 0.0v 1059.495n 0.0v 1059.505n 0.0v 1069.495n 0.0v 1069.505n 0.0v 1079.495n 0.0v 1079.505n 0.0v 1089.495n 0.0v 1089.505n 1.7v 1099.495n 1.7v 1099.505n 0.0v 1109.495n 0.0v 1109.505n 0.0v 1119.495n 0.0v 1119.505n 0.0v 1129.495n 0.0v 1129.505n 0.0v 1139.495n 0.0v 1139.505n 0.0v 1149.495n 0.0v 1149.505n 0.0v 1159.495n 0.0v 1159.505n 0.0v 1169.495n 0.0v 1169.505n 1.7v 1179.495n 1.7v 1179.505n 1.7v 1189.495n 1.7v 1189.505n 1.7v 1199.495n 1.7v 1199.505n 1.7v 1209.495n 1.7v 1209.505n 1.7v 1219.495n 1.7v 1219.505n 1.7v 1229.495n 1.7v 1229.505n 0.0v 1239.495n 0.0v 1239.505n 0.0v 1249.495n 0.0v 1249.505n 1.7v 1259.495n 1.7v 1259.505n 1.7v 1269.495n 1.7v 1269.505n 1.7v 1279.495n 1.7v 1279.505n 1.7v 1289.495n 1.7v 1289.505n 0.0v 1299.495n 0.0v 1299.505n 0.0v 1309.495n 0.0v 1309.505n 0.0v 1319.495n 0.0v 1319.505n 0.0v 1329.495n 0.0v 1329.505n 0.0v 1339.495n 0.0v 1339.505n 1.7v 1349.495n 1.7v 1349.505n 1.7v 1359.495n 1.7v 1359.505n 1.7v 1369.495n 1.7v 1369.505n 0.0v 1379.495n 0.0v 1379.505n 0.0v 1389.495n 0.0v 1389.505n 0.0v 1399.495n 0.0v 1399.505n 1.7v 1409.495n 1.7v 1409.505n 1.7v 1419.495n 1.7v 1419.505n 1.7v 1429.495n 1.7v 1429.505n 1.7v 1439.495n 1.7v 1439.505n 1.7v 1449.495n 1.7v 1449.505n 1.7v 1459.495n 1.7v 1459.505n 1.7v 1469.495n 1.7v 1469.505n 1.7v 1479.495n 1.7v 1479.505n 0.0v 1489.495n 0.0v 1489.505n 0.0v 1499.495n 0.0v 1499.505n 1.7v 1509.495n 1.7v 1509.505n 0.0v 1519.495n 0.0v 1519.505n 0.0v 1529.495n 0.0v 1529.505n 0.0v 1539.495n 0.0v 1539.505n 1.7v 1549.495n 1.7v 1549.505n 1.7v 1559.495n 1.7v 1559.505n 0.0v 1569.495n 0.0v 1569.505n 0.0v 1579.495n 0.0v 1579.505n 1.7v 1589.495n 1.7v 1589.505n 1.7v 1599.495n 1.7v 1599.505n 1.7v 1609.495n 1.7v 1609.505n 1.7v 1619.495n 1.7v 1619.505n 0.0v 1629.495n 0.0v 1629.505n 1.7v 1639.495n 1.7v 1639.505n 1.7v 1649.495n 1.7v 1649.505n 1.7v 1659.495n 1.7v 1659.505n 1.7v 1669.495n 1.7v 1669.505n 1.7v 1679.495n 1.7v 1679.505n 1.7v 1689.495n 1.7v 1689.505n 1.7v 1699.495n 1.7v 1699.505n 1.7v 1709.495n 1.7v 1709.505n 1.7v 1719.495n 1.7v 1719.505n 1.7v 1729.495n 1.7v 1729.505n 1.7v 1739.495n 1.7v 1739.505n 1.7v 1749.495n 1.7v 1749.505n 1.7v 1759.495n 1.7v 1759.505n 1.7v 1769.495n 1.7v 1769.505n 1.7v 1779.495n 1.7v 1779.505n 1.7v 1789.495n 1.7v 1789.505n 1.7v 1799.495n 1.7v 1799.505n 1.7v 1809.495n 1.7v 1809.505n 1.7v 1819.495n 1.7v 1819.505n 1.7v 1829.495n 1.7v 1829.505n 1.7v 1839.495n 1.7v 1839.505n 1.7v 1849.495n 1.7v 1849.505n 1.7v 1859.495n 1.7v 1859.505n 0.0v 1869.495n 0.0v 1869.505n 0.0v 1879.495n 0.0v 1879.505n 0.0v 1889.495n 0.0v 1889.505n 0.0v 1899.495n 0.0v 1899.505n 0.0v 1909.495n 0.0v 1909.505n 0.0v 1919.495n 0.0v 1919.505n 1.7v 1929.495n 1.7v 1929.505n 0.0v 1939.495n 0.0v 1939.505n 0.0v 1949.495n 0.0v 1949.505n 1.7v 1959.495n 1.7v 1959.505n 1.7v 1969.495n 1.7v 1969.505n 1.7v 1979.495n 1.7v 1979.505n 0.0v 1989.495n 0.0v 1989.505n 0.0v 1999.495n 0.0v 1999.505n 1.7v 2009.495n 1.7v 2009.505n 1.7v 2019.495n 1.7v 2019.505n 1.7v 2029.495n 1.7v 2029.505n 1.7v 2039.495n 1.7v 2039.505n 1.7v 2049.495n 1.7v 2049.505n 1.7v )
* (time, data): [(0, 0), (10, 0), (20, 1), (30, 0), (40, 0), (50, 0), (60, 0), (70, 0), (80, 0), (90, 1), (100, 1), (110, 0), (120, 0), (130, 0), (140, 0), (150, 0), (160, 0), (170, 0), (180, 0), (190, 0), (200, 0), (210, 0), (220, 0), (230, 0), (240, 0), (250, 0), (260, 0), (270, 0), (280, 0), (290, 0), (300, 0), (310, 0), (320, 0), (330, 0), (340, 0), (350, 0), (360, 0), (370, 0), (380, 0), (390, 0), (400, 0), (410, 0), (420, 0), (430, 0), (440, 0), (450, 0), (460, 1), (470, 1), (480, 1), (490, 1), (500, 1), (510, 1), (520, 1), (530, 1), (540, 1), (550, 1), (560, 1), (570, 1), (580, 1), (590, 1), (600, 1), (610, 0), (620, 1), (630, 0), (640, 0), (650, 0), (660, 0), (670, 0), (680, 1), (690, 1), (700, 1), (710, 1), (720, 1), (730, 1), (740, 1), (750, 1), (760, 1), (770, 1), (780, 0), (790, 0), (800, 1), (810, 1), (820, 0), (830, 0), (840, 0), (850, 0), (860, 1), (870, 0), (880, 0), (890, 0), (900, 1), (910, 1), (920, 0), (930, 0), (940, 0), (950, 0), (960, 0), (970, 0), (980, 1), (990, 1), (1000, 0), (1010, 1), (1020, 0), (1030, 1), (1040, 1), (1050, 1), (1060, 1), (1070, 1), (1080, 1), (1090, 1), (1100, 1), (1110, 1), (1120, 1), (1130, 1), (1140, 1), (1150, 1), (1160, 1), (1170, 0), (1180, 1), (1190, 1), (1200, 1), (1210, 1), (1220, 0), (1230, 0), (1240, 1), (1250, 1), (1260, 1), (1270, 1), (1280, 1), (1290, 0), (1300, 1), (1310, 1), (1320, 1), (1330, 1), (1340, 0), (1350, 0), (1360, 0), (1370, 0), (1380, 0), (1390, 0), (1400, 1), (1410, 1), (1420, 1), (1430, 1), (1440, 1), (1450, 1), (1460, 1), (1470, 1), (1480, 1), (1490, 1), (1500, 0), (1510, 1), (1520, 1), (1530, 1), (1540, 0), (1550, 1), (1560, 0), (1570, 0), (1580, 0), (1590, 0), (1600, 0), (1610, 0), (1620, 0), (1630, 0), (1640, 0), (1650, 1), (1660, 0), (1670, 0), (1680, 0), (1690, 0), (1700, 0), (1710, 0), (1720, 0), (1730, 1), (1740, 1), (1750, 1), (1760, 1), (1770, 0), (1780, 1), (1790, 1), (1800, 0), (1810, 0), (1820, 0), (1830, 0), (1840, 1), (1850, 1), (1860, 0), (1870, 0), (1880, 0), (1890, 0), (1900, 0), (1910, 0), (1920, 0), (1930, 1), (1940, 1), (1950, 1), (1960, 1), (1970, 0), (1980, 1), (1990, 1), (2000, 0), (2010, 1), (2020, 0), (2030, 0), (2040, 0), (2050, 0)]
Vdin0_23  din0_23  0 PWL (0n 0.0v 9.495n 0.0v 9.505n 0.0v 19.495n 0.0v 19.505n 1.7v 29.495n 1.7v 29.505n 0.0v 39.495n 0.0v 39.505n 0.0v 49.495n 0.0v 49.505n 0.0v 59.495n 0.0v 59.505n 0.0v 69.495n 0.0v 69.505n 0.0v 79.495n 0.0v 79.505n 0.0v 89.495n 0.0v 89.505n 1.7v 99.495n 1.7v 99.505n 1.7v 109.495n 1.7v 109.505n 0.0v 119.495n 0.0v 119.505n 0.0v 129.495n 0.0v 129.505n 0.0v 139.495n 0.0v 139.505n 0.0v 149.495n 0.0v 149.505n 0.0v 159.495n 0.0v 159.505n 0.0v 169.495n 0.0v 169.505n 0.0v 179.495n 0.0v 179.505n 0.0v 189.495n 0.0v 189.505n 0.0v 199.495n 0.0v 199.505n 0.0v 209.495n 0.0v 209.505n 0.0v 219.495n 0.0v 219.505n 0.0v 229.495n 0.0v 229.505n 0.0v 239.495n 0.0v 239.505n 0.0v 249.495n 0.0v 249.505n 0.0v 259.495n 0.0v 259.505n 0.0v 269.495n 0.0v 269.505n 0.0v 279.495n 0.0v 279.505n 0.0v 289.495n 0.0v 289.505n 0.0v 299.495n 0.0v 299.505n 0.0v 309.495n 0.0v 309.505n 0.0v 319.495n 0.0v 319.505n 0.0v 329.495n 0.0v 329.505n 0.0v 339.495n 0.0v 339.505n 0.0v 349.495n 0.0v 349.505n 0.0v 359.495n 0.0v 359.505n 0.0v 369.495n 0.0v 369.505n 0.0v 379.495n 0.0v 379.505n 0.0v 389.495n 0.0v 389.505n 0.0v 399.495n 0.0v 399.505n 0.0v 409.495n 0.0v 409.505n 0.0v 419.495n 0.0v 419.505n 0.0v 429.495n 0.0v 429.505n 0.0v 439.495n 0.0v 439.505n 0.0v 449.495n 0.0v 449.505n 0.0v 459.495n 0.0v 459.505n 1.7v 469.495n 1.7v 469.505n 1.7v 479.495n 1.7v 479.505n 1.7v 489.495n 1.7v 489.505n 1.7v 499.495n 1.7v 499.505n 1.7v 509.495n 1.7v 509.505n 1.7v 519.495n 1.7v 519.505n 1.7v 529.495n 1.7v 529.505n 1.7v 539.495n 1.7v 539.505n 1.7v 549.495n 1.7v 549.505n 1.7v 559.495n 1.7v 559.505n 1.7v 569.495n 1.7v 569.505n 1.7v 579.495n 1.7v 579.505n 1.7v 589.495n 1.7v 589.505n 1.7v 599.495n 1.7v 599.505n 1.7v 609.495n 1.7v 609.505n 0.0v 619.495n 0.0v 619.505n 1.7v 629.495n 1.7v 629.505n 0.0v 639.495n 0.0v 639.505n 0.0v 649.495n 0.0v 649.505n 0.0v 659.495n 0.0v 659.505n 0.0v 669.495n 0.0v 669.505n 0.0v 679.495n 0.0v 679.505n 1.7v 689.495n 1.7v 689.505n 1.7v 699.495n 1.7v 699.505n 1.7v 709.495n 1.7v 709.505n 1.7v 719.495n 1.7v 719.505n 1.7v 729.495n 1.7v 729.505n 1.7v 739.495n 1.7v 739.505n 1.7v 749.495n 1.7v 749.505n 1.7v 759.495n 1.7v 759.505n 1.7v 769.495n 1.7v 769.505n 1.7v 779.495n 1.7v 779.505n 0.0v 789.495n 0.0v 789.505n 0.0v 799.495n 0.0v 799.505n 1.7v 809.495n 1.7v 809.505n 1.7v 819.495n 1.7v 819.505n 0.0v 829.495n 0.0v 829.505n 0.0v 839.495n 0.0v 839.505n 0.0v 849.495n 0.0v 849.505n 0.0v 859.495n 0.0v 859.505n 1.7v 869.495n 1.7v 869.505n 0.0v 879.495n 0.0v 879.505n 0.0v 889.495n 0.0v 889.505n 0.0v 899.495n 0.0v 899.505n 1.7v 909.495n 1.7v 909.505n 1.7v 919.495n 1.7v 919.505n 0.0v 929.495n 0.0v 929.505n 0.0v 939.495n 0.0v 939.505n 0.0v 949.495n 0.0v 949.505n 0.0v 959.495n 0.0v 959.505n 0.0v 969.495n 0.0v 969.505n 0.0v 979.495n 0.0v 979.505n 1.7v 989.495n 1.7v 989.505n 1.7v 999.495n 1.7v 999.505n 0.0v 1009.495n 0.0v 1009.505n 1.7v 1019.495n 1.7v 1019.505n 0.0v 1029.495n 0.0v 1029.505n 1.7v 1039.495n 1.7v 1039.505n 1.7v 1049.495n 1.7v 1049.505n 1.7v 1059.495n 1.7v 1059.505n 1.7v 1069.495n 1.7v 1069.505n 1.7v 1079.495n 1.7v 1079.505n 1.7v 1089.495n 1.7v 1089.505n 1.7v 1099.495n 1.7v 1099.505n 1.7v 1109.495n 1.7v 1109.505n 1.7v 1119.495n 1.7v 1119.505n 1.7v 1129.495n 1.7v 1129.505n 1.7v 1139.495n 1.7v 1139.505n 1.7v 1149.495n 1.7v 1149.505n 1.7v 1159.495n 1.7v 1159.505n 1.7v 1169.495n 1.7v 1169.505n 0.0v 1179.495n 0.0v 1179.505n 1.7v 1189.495n 1.7v 1189.505n 1.7v 1199.495n 1.7v 1199.505n 1.7v 1209.495n 1.7v 1209.505n 1.7v 1219.495n 1.7v 1219.505n 0.0v 1229.495n 0.0v 1229.505n 0.0v 1239.495n 0.0v 1239.505n 1.7v 1249.495n 1.7v 1249.505n 1.7v 1259.495n 1.7v 1259.505n 1.7v 1269.495n 1.7v 1269.505n 1.7v 1279.495n 1.7v 1279.505n 1.7v 1289.495n 1.7v 1289.505n 0.0v 1299.495n 0.0v 1299.505n 1.7v 1309.495n 1.7v 1309.505n 1.7v 1319.495n 1.7v 1319.505n 1.7v 1329.495n 1.7v 1329.505n 1.7v 1339.495n 1.7v 1339.505n 0.0v 1349.495n 0.0v 1349.505n 0.0v 1359.495n 0.0v 1359.505n 0.0v 1369.495n 0.0v 1369.505n 0.0v 1379.495n 0.0v 1379.505n 0.0v 1389.495n 0.0v 1389.505n 0.0v 1399.495n 0.0v 1399.505n 1.7v 1409.495n 1.7v 1409.505n 1.7v 1419.495n 1.7v 1419.505n 1.7v 1429.495n 1.7v 1429.505n 1.7v 1439.495n 1.7v 1439.505n 1.7v 1449.495n 1.7v 1449.505n 1.7v 1459.495n 1.7v 1459.505n 1.7v 1469.495n 1.7v 1469.505n 1.7v 1479.495n 1.7v 1479.505n 1.7v 1489.495n 1.7v 1489.505n 1.7v 1499.495n 1.7v 1499.505n 0.0v 1509.495n 0.0v 1509.505n 1.7v 1519.495n 1.7v 1519.505n 1.7v 1529.495n 1.7v 1529.505n 1.7v 1539.495n 1.7v 1539.505n 0.0v 1549.495n 0.0v 1549.505n 1.7v 1559.495n 1.7v 1559.505n 0.0v 1569.495n 0.0v 1569.505n 0.0v 1579.495n 0.0v 1579.505n 0.0v 1589.495n 0.0v 1589.505n 0.0v 1599.495n 0.0v 1599.505n 0.0v 1609.495n 0.0v 1609.505n 0.0v 1619.495n 0.0v 1619.505n 0.0v 1629.495n 0.0v 1629.505n 0.0v 1639.495n 0.0v 1639.505n 0.0v 1649.495n 0.0v 1649.505n 1.7v 1659.495n 1.7v 1659.505n 0.0v 1669.495n 0.0v 1669.505n 0.0v 1679.495n 0.0v 1679.505n 0.0v 1689.495n 0.0v 1689.505n 0.0v 1699.495n 0.0v 1699.505n 0.0v 1709.495n 0.0v 1709.505n 0.0v 1719.495n 0.0v 1719.505n 0.0v 1729.495n 0.0v 1729.505n 1.7v 1739.495n 1.7v 1739.505n 1.7v 1749.495n 1.7v 1749.505n 1.7v 1759.495n 1.7v 1759.505n 1.7v 1769.495n 1.7v 1769.505n 0.0v 1779.495n 0.0v 1779.505n 1.7v 1789.495n 1.7v 1789.505n 1.7v 1799.495n 1.7v 1799.505n 0.0v 1809.495n 0.0v 1809.505n 0.0v 1819.495n 0.0v 1819.505n 0.0v 1829.495n 0.0v 1829.505n 0.0v 1839.495n 0.0v 1839.505n 1.7v 1849.495n 1.7v 1849.505n 1.7v 1859.495n 1.7v 1859.505n 0.0v 1869.495n 0.0v 1869.505n 0.0v 1879.495n 0.0v 1879.505n 0.0v 1889.495n 0.0v 1889.505n 0.0v 1899.495n 0.0v 1899.505n 0.0v 1909.495n 0.0v 1909.505n 0.0v 1919.495n 0.0v 1919.505n 0.0v 1929.495n 0.0v 1929.505n 1.7v 1939.495n 1.7v 1939.505n 1.7v 1949.495n 1.7v 1949.505n 1.7v 1959.495n 1.7v 1959.505n 1.7v 1969.495n 1.7v 1969.505n 0.0v 1979.495n 0.0v 1979.505n 1.7v 1989.495n 1.7v 1989.505n 1.7v 1999.495n 1.7v 1999.505n 0.0v 2009.495n 0.0v 2009.505n 1.7v 2019.495n 1.7v 2019.505n 0.0v 2029.495n 0.0v 2029.505n 0.0v 2039.495n 0.0v 2039.505n 0.0v 2049.495n 0.0v 2049.505n 0.0v )
* (time, data): [(0, 0), (10, 1), (20, 1), (30, 0), (40, 0), (50, 0), (60, 1), (70, 1), (80, 1), (90, 1), (100, 0), (110, 0), (120, 0), (130, 0), (140, 0), (150, 0), (160, 0), (170, 0), (180, 0), (190, 1), (200, 1), (210, 0), (220, 0), (230, 0), (240, 0), (250, 0), (260, 0), (270, 0), (280, 1), (290, 1), (300, 1), (310, 1), (320, 0), (330, 1), (340, 1), (350, 1), (360, 1), (370, 1), (380, 1), (390, 1), (400, 1), (410, 1), (420, 0), (430, 0), (440, 1), (450, 1), (460, 0), (470, 0), (480, 0), (490, 0), (500, 1), (510, 0), (520, 1), (530, 1), (540, 1), (550, 0), (560, 0), (570, 0), (580, 0), (590, 0), (600, 1), (610, 0), (620, 1), (630, 0), (640, 0), (650, 0), (660, 0), (670, 0), (680, 1), (690, 1), (700, 0), (710, 0), (720, 0), (730, 0), (740, 0), (750, 0), (760, 0), (770, 1), (780, 0), (790, 0), (800, 1), (810, 1), (820, 1), (830, 0), (840, 1), (850, 1), (860, 0), (870, 1), (880, 0), (890, 0), (900, 0), (910, 0), (920, 0), (930, 0), (940, 0), (950, 0), (960, 0), (970, 1), (980, 1), (990, 1), (1000, 1), (1010, 1), (1020, 1), (1030, 1), (1040, 1), (1050, 1), (1060, 1), (1070, 0), (1080, 1), (1090, 1), (1100, 1), (1110, 0), (1120, 0), (1130, 0), (1140, 0), (1150, 1), (1160, 1), (1170, 0), (1180, 1), (1190, 1), (1200, 1), (1210, 1), (1220, 0), (1230, 1), (1240, 0), (1250, 1), (1260, 1), (1270, 1), (1280, 1), (1290, 0), (1300, 0), (1310, 0), (1320, 0), (1330, 0), (1340, 1), (1350, 1), (1360, 1), (1370, 0), (1380, 0), (1390, 0), (1400, 0), (1410, 0), (1420, 0), (1430, 0), (1440, 0), (1450, 0), (1460, 0), (1470, 0), (1480, 1), (1490, 1), (1500, 1), (1510, 1), (1520, 1), (1530, 1), (1540, 0), (1550, 0), (1560, 0), (1570, 0), (1580, 0), (1590, 0), (1600, 0), (1610, 0), (1620, 0), (1630, 1), (1640, 1), (1650, 0), (1660, 0), (1670, 0), (1680, 0), (1690, 0), (1700, 0), (1710, 0), (1720, 0), (1730, 1), (1740, 1), (1750, 0), (1760, 0), (1770, 1), (1780, 1), (1790, 1), (1800, 1), (1810, 1), (1820, 1), (1830, 1), (1840, 1), (1850, 1), (1860, 0), (1870, 0), (1880, 0), (1890, 0), (1900, 0), (1910, 1), (1920, 1), (1930, 1), (1940, 0), (1950, 1), (1960, 1), (1970, 0), (1980, 0), (1990, 0), (2000, 1), (2010, 1), (2020, 1), (2030, 1), (2040, 1), (2050, 1)]
Vdin0_24  din0_24  0 PWL (0n 0.0v 9.495n 0.0v 9.505n 1.7v 19.495n 1.7v 19.505n 1.7v 29.495n 1.7v 29.505n 0.0v 39.495n 0.0v 39.505n 0.0v 49.495n 0.0v 49.505n 0.0v 59.495n 0.0v 59.505n 1.7v 69.495n 1.7v 69.505n 1.7v 79.495n 1.7v 79.505n 1.7v 89.495n 1.7v 89.505n 1.7v 99.495n 1.7v 99.505n 0.0v 109.495n 0.0v 109.505n 0.0v 119.495n 0.0v 119.505n 0.0v 129.495n 0.0v 129.505n 0.0v 139.495n 0.0v 139.505n 0.0v 149.495n 0.0v 149.505n 0.0v 159.495n 0.0v 159.505n 0.0v 169.495n 0.0v 169.505n 0.0v 179.495n 0.0v 179.505n 0.0v 189.495n 0.0v 189.505n 1.7v 199.495n 1.7v 199.505n 1.7v 209.495n 1.7v 209.505n 0.0v 219.495n 0.0v 219.505n 0.0v 229.495n 0.0v 229.505n 0.0v 239.495n 0.0v 239.505n 0.0v 249.495n 0.0v 249.505n 0.0v 259.495n 0.0v 259.505n 0.0v 269.495n 0.0v 269.505n 0.0v 279.495n 0.0v 279.505n 1.7v 289.495n 1.7v 289.505n 1.7v 299.495n 1.7v 299.505n 1.7v 309.495n 1.7v 309.505n 1.7v 319.495n 1.7v 319.505n 0.0v 329.495n 0.0v 329.505n 1.7v 339.495n 1.7v 339.505n 1.7v 349.495n 1.7v 349.505n 1.7v 359.495n 1.7v 359.505n 1.7v 369.495n 1.7v 369.505n 1.7v 379.495n 1.7v 379.505n 1.7v 389.495n 1.7v 389.505n 1.7v 399.495n 1.7v 399.505n 1.7v 409.495n 1.7v 409.505n 1.7v 419.495n 1.7v 419.505n 0.0v 429.495n 0.0v 429.505n 0.0v 439.495n 0.0v 439.505n 1.7v 449.495n 1.7v 449.505n 1.7v 459.495n 1.7v 459.505n 0.0v 469.495n 0.0v 469.505n 0.0v 479.495n 0.0v 479.505n 0.0v 489.495n 0.0v 489.505n 0.0v 499.495n 0.0v 499.505n 1.7v 509.495n 1.7v 509.505n 0.0v 519.495n 0.0v 519.505n 1.7v 529.495n 1.7v 529.505n 1.7v 539.495n 1.7v 539.505n 1.7v 549.495n 1.7v 549.505n 0.0v 559.495n 0.0v 559.505n 0.0v 569.495n 0.0v 569.505n 0.0v 579.495n 0.0v 579.505n 0.0v 589.495n 0.0v 589.505n 0.0v 599.495n 0.0v 599.505n 1.7v 609.495n 1.7v 609.505n 0.0v 619.495n 0.0v 619.505n 1.7v 629.495n 1.7v 629.505n 0.0v 639.495n 0.0v 639.505n 0.0v 649.495n 0.0v 649.505n 0.0v 659.495n 0.0v 659.505n 0.0v 669.495n 0.0v 669.505n 0.0v 679.495n 0.0v 679.505n 1.7v 689.495n 1.7v 689.505n 1.7v 699.495n 1.7v 699.505n 0.0v 709.495n 0.0v 709.505n 0.0v 719.495n 0.0v 719.505n 0.0v 729.495n 0.0v 729.505n 0.0v 739.495n 0.0v 739.505n 0.0v 749.495n 0.0v 749.505n 0.0v 759.495n 0.0v 759.505n 0.0v 769.495n 0.0v 769.505n 1.7v 779.495n 1.7v 779.505n 0.0v 789.495n 0.0v 789.505n 0.0v 799.495n 0.0v 799.505n 1.7v 809.495n 1.7v 809.505n 1.7v 819.495n 1.7v 819.505n 1.7v 829.495n 1.7v 829.505n 0.0v 839.495n 0.0v 839.505n 1.7v 849.495n 1.7v 849.505n 1.7v 859.495n 1.7v 859.505n 0.0v 869.495n 0.0v 869.505n 1.7v 879.495n 1.7v 879.505n 0.0v 889.495n 0.0v 889.505n 0.0v 899.495n 0.0v 899.505n 0.0v 909.495n 0.0v 909.505n 0.0v 919.495n 0.0v 919.505n 0.0v 929.495n 0.0v 929.505n 0.0v 939.495n 0.0v 939.505n 0.0v 949.495n 0.0v 949.505n 0.0v 959.495n 0.0v 959.505n 0.0v 969.495n 0.0v 969.505n 1.7v 979.495n 1.7v 979.505n 1.7v 989.495n 1.7v 989.505n 1.7v 999.495n 1.7v 999.505n 1.7v 1009.495n 1.7v 1009.505n 1.7v 1019.495n 1.7v 1019.505n 1.7v 1029.495n 1.7v 1029.505n 1.7v 1039.495n 1.7v 1039.505n 1.7v 1049.495n 1.7v 1049.505n 1.7v 1059.495n 1.7v 1059.505n 1.7v 1069.495n 1.7v 1069.505n 0.0v 1079.495n 0.0v 1079.505n 1.7v 1089.495n 1.7v 1089.505n 1.7v 1099.495n 1.7v 1099.505n 1.7v 1109.495n 1.7v 1109.505n 0.0v 1119.495n 0.0v 1119.505n 0.0v 1129.495n 0.0v 1129.505n 0.0v 1139.495n 0.0v 1139.505n 0.0v 1149.495n 0.0v 1149.505n 1.7v 1159.495n 1.7v 1159.505n 1.7v 1169.495n 1.7v 1169.505n 0.0v 1179.495n 0.0v 1179.505n 1.7v 1189.495n 1.7v 1189.505n 1.7v 1199.495n 1.7v 1199.505n 1.7v 1209.495n 1.7v 1209.505n 1.7v 1219.495n 1.7v 1219.505n 0.0v 1229.495n 0.0v 1229.505n 1.7v 1239.495n 1.7v 1239.505n 0.0v 1249.495n 0.0v 1249.505n 1.7v 1259.495n 1.7v 1259.505n 1.7v 1269.495n 1.7v 1269.505n 1.7v 1279.495n 1.7v 1279.505n 1.7v 1289.495n 1.7v 1289.505n 0.0v 1299.495n 0.0v 1299.505n 0.0v 1309.495n 0.0v 1309.505n 0.0v 1319.495n 0.0v 1319.505n 0.0v 1329.495n 0.0v 1329.505n 0.0v 1339.495n 0.0v 1339.505n 1.7v 1349.495n 1.7v 1349.505n 1.7v 1359.495n 1.7v 1359.505n 1.7v 1369.495n 1.7v 1369.505n 0.0v 1379.495n 0.0v 1379.505n 0.0v 1389.495n 0.0v 1389.505n 0.0v 1399.495n 0.0v 1399.505n 0.0v 1409.495n 0.0v 1409.505n 0.0v 1419.495n 0.0v 1419.505n 0.0v 1429.495n 0.0v 1429.505n 0.0v 1439.495n 0.0v 1439.505n 0.0v 1449.495n 0.0v 1449.505n 0.0v 1459.495n 0.0v 1459.505n 0.0v 1469.495n 0.0v 1469.505n 0.0v 1479.495n 0.0v 1479.505n 1.7v 1489.495n 1.7v 1489.505n 1.7v 1499.495n 1.7v 1499.505n 1.7v 1509.495n 1.7v 1509.505n 1.7v 1519.495n 1.7v 1519.505n 1.7v 1529.495n 1.7v 1529.505n 1.7v 1539.495n 1.7v 1539.505n 0.0v 1549.495n 0.0v 1549.505n 0.0v 1559.495n 0.0v 1559.505n 0.0v 1569.495n 0.0v 1569.505n 0.0v 1579.495n 0.0v 1579.505n 0.0v 1589.495n 0.0v 1589.505n 0.0v 1599.495n 0.0v 1599.505n 0.0v 1609.495n 0.0v 1609.505n 0.0v 1619.495n 0.0v 1619.505n 0.0v 1629.495n 0.0v 1629.505n 1.7v 1639.495n 1.7v 1639.505n 1.7v 1649.495n 1.7v 1649.505n 0.0v 1659.495n 0.0v 1659.505n 0.0v 1669.495n 0.0v 1669.505n 0.0v 1679.495n 0.0v 1679.505n 0.0v 1689.495n 0.0v 1689.505n 0.0v 1699.495n 0.0v 1699.505n 0.0v 1709.495n 0.0v 1709.505n 0.0v 1719.495n 0.0v 1719.505n 0.0v 1729.495n 0.0v 1729.505n 1.7v 1739.495n 1.7v 1739.505n 1.7v 1749.495n 1.7v 1749.505n 0.0v 1759.495n 0.0v 1759.505n 0.0v 1769.495n 0.0v 1769.505n 1.7v 1779.495n 1.7v 1779.505n 1.7v 1789.495n 1.7v 1789.505n 1.7v 1799.495n 1.7v 1799.505n 1.7v 1809.495n 1.7v 1809.505n 1.7v 1819.495n 1.7v 1819.505n 1.7v 1829.495n 1.7v 1829.505n 1.7v 1839.495n 1.7v 1839.505n 1.7v 1849.495n 1.7v 1849.505n 1.7v 1859.495n 1.7v 1859.505n 0.0v 1869.495n 0.0v 1869.505n 0.0v 1879.495n 0.0v 1879.505n 0.0v 1889.495n 0.0v 1889.505n 0.0v 1899.495n 0.0v 1899.505n 0.0v 1909.495n 0.0v 1909.505n 1.7v 1919.495n 1.7v 1919.505n 1.7v 1929.495n 1.7v 1929.505n 1.7v 1939.495n 1.7v 1939.505n 0.0v 1949.495n 0.0v 1949.505n 1.7v 1959.495n 1.7v 1959.505n 1.7v 1969.495n 1.7v 1969.505n 0.0v 1979.495n 0.0v 1979.505n 0.0v 1989.495n 0.0v 1989.505n 0.0v 1999.495n 0.0v 1999.505n 1.7v 2009.495n 1.7v 2009.505n 1.7v 2019.495n 1.7v 2019.505n 1.7v 2029.495n 1.7v 2029.505n 1.7v 2039.495n 1.7v 2039.505n 1.7v 2049.495n 1.7v 2049.505n 1.7v )
* (time, data): [(0, 0), (10, 1), (20, 0), (30, 0), (40, 0), (50, 0), (60, 1), (70, 1), (80, 1), (90, 1), (100, 1), (110, 0), (120, 0), (130, 0), (140, 0), (150, 0), (160, 0), (170, 0), (180, 0), (190, 1), (200, 1), (210, 0), (220, 0), (230, 0), (240, 0), (250, 0), (260, 0), (270, 0), (280, 1), (290, 1), (300, 1), (310, 0), (320, 1), (330, 1), (340, 1), (350, 1), (360, 1), (370, 1), (380, 1), (390, 1), (400, 1), (410, 1), (420, 0), (430, 0), (440, 0), (450, 0), (460, 1), (470, 0), (480, 0), (490, 0), (500, 0), (510, 0), (520, 0), (530, 0), (540, 0), (550, 1), (560, 1), (570, 1), (580, 1), (590, 1), (600, 0), (610, 0), (620, 1), (630, 1), (640, 1), (650, 1), (660, 1), (670, 1), (680, 1), (690, 1), (700, 1), (710, 0), (720, 0), (730, 0), (740, 0), (750, 0), (760, 0), (770, 0), (780, 0), (790, 1), (800, 1), (810, 1), (820, 0), (830, 1), (840, 0), (850, 0), (860, 1), (870, 1), (880, 1), (890, 1), (900, 0), (910, 0), (920, 0), (930, 0), (940, 0), (950, 0), (960, 0), (970, 0), (980, 0), (990, 0), (1000, 0), (1010, 0), (1020, 1), (1030, 0), (1040, 0), (1050, 0), (1060, 0), (1070, 1), (1080, 1), (1090, 1), (1100, 1), (1110, 1), (1120, 1), (1130, 0), (1140, 1), (1150, 1), (1160, 1), (1170, 1), (1180, 0), (1190, 0), (1200, 0), (1210, 0), (1220, 0), (1230, 0), (1240, 1), (1250, 0), (1260, 0), (1270, 0), (1280, 0), (1290, 0), (1300, 1), (1310, 1), (1320, 1), (1330, 1), (1340, 1), (1350, 1), (1360, 1), (1370, 0), (1380, 0), (1390, 0), (1400, 0), (1410, 0), (1420, 0), (1430, 0), (1440, 0), (1450, 0), (1460, 0), (1470, 0), (1480, 1), (1490, 1), (1500, 0), (1510, 1), (1520, 1), (1530, 1), (1540, 1), (1550, 0), (1560, 1), (1570, 1), (1580, 0), (1590, 0), (1600, 0), (1610, 0), (1620, 1), (1630, 1), (1640, 1), (1650, 0), (1660, 0), (1670, 0), (1680, 0), (1690, 0), (1700, 0), (1710, 0), (1720, 0), (1730, 0), (1740, 0), (1750, 1), (1760, 1), (1770, 0), (1780, 0), (1790, 0), (1800, 0), (1810, 0), (1820, 0), (1830, 0), (1840, 1), (1850, 1), (1860, 0), (1870, 0), (1880, 0), (1890, 0), (1900, 0), (1910, 1), (1920, 1), (1930, 1), (1940, 1), (1950, 1), (1960, 1), (1970, 1), (1980, 1), (1990, 1), (2000, 1), (2010, 0), (2020, 0), (2030, 0), (2040, 0), (2050, 0)]
Vdin0_25  din0_25  0 PWL (0n 0.0v 9.495n 0.0v 9.505n 1.7v 19.495n 1.7v 19.505n 0.0v 29.495n 0.0v 29.505n 0.0v 39.495n 0.0v 39.505n 0.0v 49.495n 0.0v 49.505n 0.0v 59.495n 0.0v 59.505n 1.7v 69.495n 1.7v 69.505n 1.7v 79.495n 1.7v 79.505n 1.7v 89.495n 1.7v 89.505n 1.7v 99.495n 1.7v 99.505n 1.7v 109.495n 1.7v 109.505n 0.0v 119.495n 0.0v 119.505n 0.0v 129.495n 0.0v 129.505n 0.0v 139.495n 0.0v 139.505n 0.0v 149.495n 0.0v 149.505n 0.0v 159.495n 0.0v 159.505n 0.0v 169.495n 0.0v 169.505n 0.0v 179.495n 0.0v 179.505n 0.0v 189.495n 0.0v 189.505n 1.7v 199.495n 1.7v 199.505n 1.7v 209.495n 1.7v 209.505n 0.0v 219.495n 0.0v 219.505n 0.0v 229.495n 0.0v 229.505n 0.0v 239.495n 0.0v 239.505n 0.0v 249.495n 0.0v 249.505n 0.0v 259.495n 0.0v 259.505n 0.0v 269.495n 0.0v 269.505n 0.0v 279.495n 0.0v 279.505n 1.7v 289.495n 1.7v 289.505n 1.7v 299.495n 1.7v 299.505n 1.7v 309.495n 1.7v 309.505n 0.0v 319.495n 0.0v 319.505n 1.7v 329.495n 1.7v 329.505n 1.7v 339.495n 1.7v 339.505n 1.7v 349.495n 1.7v 349.505n 1.7v 359.495n 1.7v 359.505n 1.7v 369.495n 1.7v 369.505n 1.7v 379.495n 1.7v 379.505n 1.7v 389.495n 1.7v 389.505n 1.7v 399.495n 1.7v 399.505n 1.7v 409.495n 1.7v 409.505n 1.7v 419.495n 1.7v 419.505n 0.0v 429.495n 0.0v 429.505n 0.0v 439.495n 0.0v 439.505n 0.0v 449.495n 0.0v 449.505n 0.0v 459.495n 0.0v 459.505n 1.7v 469.495n 1.7v 469.505n 0.0v 479.495n 0.0v 479.505n 0.0v 489.495n 0.0v 489.505n 0.0v 499.495n 0.0v 499.505n 0.0v 509.495n 0.0v 509.505n 0.0v 519.495n 0.0v 519.505n 0.0v 529.495n 0.0v 529.505n 0.0v 539.495n 0.0v 539.505n 0.0v 549.495n 0.0v 549.505n 1.7v 559.495n 1.7v 559.505n 1.7v 569.495n 1.7v 569.505n 1.7v 579.495n 1.7v 579.505n 1.7v 589.495n 1.7v 589.505n 1.7v 599.495n 1.7v 599.505n 0.0v 609.495n 0.0v 609.505n 0.0v 619.495n 0.0v 619.505n 1.7v 629.495n 1.7v 629.505n 1.7v 639.495n 1.7v 639.505n 1.7v 649.495n 1.7v 649.505n 1.7v 659.495n 1.7v 659.505n 1.7v 669.495n 1.7v 669.505n 1.7v 679.495n 1.7v 679.505n 1.7v 689.495n 1.7v 689.505n 1.7v 699.495n 1.7v 699.505n 1.7v 709.495n 1.7v 709.505n 0.0v 719.495n 0.0v 719.505n 0.0v 729.495n 0.0v 729.505n 0.0v 739.495n 0.0v 739.505n 0.0v 749.495n 0.0v 749.505n 0.0v 759.495n 0.0v 759.505n 0.0v 769.495n 0.0v 769.505n 0.0v 779.495n 0.0v 779.505n 0.0v 789.495n 0.0v 789.505n 1.7v 799.495n 1.7v 799.505n 1.7v 809.495n 1.7v 809.505n 1.7v 819.495n 1.7v 819.505n 0.0v 829.495n 0.0v 829.505n 1.7v 839.495n 1.7v 839.505n 0.0v 849.495n 0.0v 849.505n 0.0v 859.495n 0.0v 859.505n 1.7v 869.495n 1.7v 869.505n 1.7v 879.495n 1.7v 879.505n 1.7v 889.495n 1.7v 889.505n 1.7v 899.495n 1.7v 899.505n 0.0v 909.495n 0.0v 909.505n 0.0v 919.495n 0.0v 919.505n 0.0v 929.495n 0.0v 929.505n 0.0v 939.495n 0.0v 939.505n 0.0v 949.495n 0.0v 949.505n 0.0v 959.495n 0.0v 959.505n 0.0v 969.495n 0.0v 969.505n 0.0v 979.495n 0.0v 979.505n 0.0v 989.495n 0.0v 989.505n 0.0v 999.495n 0.0v 999.505n 0.0v 1009.495n 0.0v 1009.505n 0.0v 1019.495n 0.0v 1019.505n 1.7v 1029.495n 1.7v 1029.505n 0.0v 1039.495n 0.0v 1039.505n 0.0v 1049.495n 0.0v 1049.505n 0.0v 1059.495n 0.0v 1059.505n 0.0v 1069.495n 0.0v 1069.505n 1.7v 1079.495n 1.7v 1079.505n 1.7v 1089.495n 1.7v 1089.505n 1.7v 1099.495n 1.7v 1099.505n 1.7v 1109.495n 1.7v 1109.505n 1.7v 1119.495n 1.7v 1119.505n 1.7v 1129.495n 1.7v 1129.505n 0.0v 1139.495n 0.0v 1139.505n 1.7v 1149.495n 1.7v 1149.505n 1.7v 1159.495n 1.7v 1159.505n 1.7v 1169.495n 1.7v 1169.505n 1.7v 1179.495n 1.7v 1179.505n 0.0v 1189.495n 0.0v 1189.505n 0.0v 1199.495n 0.0v 1199.505n 0.0v 1209.495n 0.0v 1209.505n 0.0v 1219.495n 0.0v 1219.505n 0.0v 1229.495n 0.0v 1229.505n 0.0v 1239.495n 0.0v 1239.505n 1.7v 1249.495n 1.7v 1249.505n 0.0v 1259.495n 0.0v 1259.505n 0.0v 1269.495n 0.0v 1269.505n 0.0v 1279.495n 0.0v 1279.505n 0.0v 1289.495n 0.0v 1289.505n 0.0v 1299.495n 0.0v 1299.505n 1.7v 1309.495n 1.7v 1309.505n 1.7v 1319.495n 1.7v 1319.505n 1.7v 1329.495n 1.7v 1329.505n 1.7v 1339.495n 1.7v 1339.505n 1.7v 1349.495n 1.7v 1349.505n 1.7v 1359.495n 1.7v 1359.505n 1.7v 1369.495n 1.7v 1369.505n 0.0v 1379.495n 0.0v 1379.505n 0.0v 1389.495n 0.0v 1389.505n 0.0v 1399.495n 0.0v 1399.505n 0.0v 1409.495n 0.0v 1409.505n 0.0v 1419.495n 0.0v 1419.505n 0.0v 1429.495n 0.0v 1429.505n 0.0v 1439.495n 0.0v 1439.505n 0.0v 1449.495n 0.0v 1449.505n 0.0v 1459.495n 0.0v 1459.505n 0.0v 1469.495n 0.0v 1469.505n 0.0v 1479.495n 0.0v 1479.505n 1.7v 1489.495n 1.7v 1489.505n 1.7v 1499.495n 1.7v 1499.505n 0.0v 1509.495n 0.0v 1509.505n 1.7v 1519.495n 1.7v 1519.505n 1.7v 1529.495n 1.7v 1529.505n 1.7v 1539.495n 1.7v 1539.505n 1.7v 1549.495n 1.7v 1549.505n 0.0v 1559.495n 0.0v 1559.505n 1.7v 1569.495n 1.7v 1569.505n 1.7v 1579.495n 1.7v 1579.505n 0.0v 1589.495n 0.0v 1589.505n 0.0v 1599.495n 0.0v 1599.505n 0.0v 1609.495n 0.0v 1609.505n 0.0v 1619.495n 0.0v 1619.505n 1.7v 1629.495n 1.7v 1629.505n 1.7v 1639.495n 1.7v 1639.505n 1.7v 1649.495n 1.7v 1649.505n 0.0v 1659.495n 0.0v 1659.505n 0.0v 1669.495n 0.0v 1669.505n 0.0v 1679.495n 0.0v 1679.505n 0.0v 1689.495n 0.0v 1689.505n 0.0v 1699.495n 0.0v 1699.505n 0.0v 1709.495n 0.0v 1709.505n 0.0v 1719.495n 0.0v 1719.505n 0.0v 1729.495n 0.0v 1729.505n 0.0v 1739.495n 0.0v 1739.505n 0.0v 1749.495n 0.0v 1749.505n 1.7v 1759.495n 1.7v 1759.505n 1.7v 1769.495n 1.7v 1769.505n 0.0v 1779.495n 0.0v 1779.505n 0.0v 1789.495n 0.0v 1789.505n 0.0v 1799.495n 0.0v 1799.505n 0.0v 1809.495n 0.0v 1809.505n 0.0v 1819.495n 0.0v 1819.505n 0.0v 1829.495n 0.0v 1829.505n 0.0v 1839.495n 0.0v 1839.505n 1.7v 1849.495n 1.7v 1849.505n 1.7v 1859.495n 1.7v 1859.505n 0.0v 1869.495n 0.0v 1869.505n 0.0v 1879.495n 0.0v 1879.505n 0.0v 1889.495n 0.0v 1889.505n 0.0v 1899.495n 0.0v 1899.505n 0.0v 1909.495n 0.0v 1909.505n 1.7v 1919.495n 1.7v 1919.505n 1.7v 1929.495n 1.7v 1929.505n 1.7v 1939.495n 1.7v 1939.505n 1.7v 1949.495n 1.7v 1949.505n 1.7v 1959.495n 1.7v 1959.505n 1.7v 1969.495n 1.7v 1969.505n 1.7v 1979.495n 1.7v 1979.505n 1.7v 1989.495n 1.7v 1989.505n 1.7v 1999.495n 1.7v 1999.505n 1.7v 2009.495n 1.7v 2009.505n 0.0v 2019.495n 0.0v 2019.505n 0.0v 2029.495n 0.0v 2029.505n 0.0v 2039.495n 0.0v 2039.505n 0.0v 2049.495n 0.0v 2049.505n 0.0v )
* (time, data): [(0, 0), (10, 0), (20, 0), (30, 0), (40, 0), (50, 0), (60, 1), (70, 1), (80, 1), (90, 0), (100, 1), (110, 0), (120, 0), (130, 0), (140, 0), (150, 1), (160, 1), (170, 1), (180, 1), (190, 1), (200, 1), (210, 1), (220, 1), (230, 1), (240, 1), (250, 1), (260, 1), (270, 1), (280, 1), (290, 1), (300, 1), (310, 0), (320, 1), (330, 0), (340, 0), (350, 0), (360, 0), (370, 0), (380, 0), (390, 0), (400, 0), (410, 0), (420, 0), (430, 0), (440, 0), (450, 0), (460, 0), (470, 1), (480, 1), (490, 1), (500, 0), (510, 1), (520, 1), (530, 1), (540, 1), (550, 0), (560, 0), (570, 0), (580, 0), (590, 0), (600, 0), (610, 0), (620, 1), (630, 1), (640, 1), (650, 0), (660, 0), (670, 0), (680, 1), (690, 1), (700, 1), (710, 1), (720, 1), (730, 1), (740, 1), (750, 1), (760, 1), (770, 0), (780, 0), (790, 0), (800, 1), (810, 1), (820, 0), (830, 1), (840, 1), (850, 1), (860, 0), (870, 0), (880, 1), (890, 1), (900, 0), (910, 0), (920, 1), (930, 1), (940, 1), (950, 1), (960, 0), (970, 1), (980, 0), (990, 0), (1000, 1), (1010, 1), (1020, 0), (1030, 1), (1040, 1), (1050, 1), (1060, 1), (1070, 1), (1080, 0), (1090, 0), (1100, 1), (1110, 0), (1120, 0), (1130, 1), (1140, 1), (1150, 1), (1160, 1), (1170, 1), (1180, 1), (1190, 1), (1200, 1), (1210, 1), (1220, 0), (1230, 1), (1240, 1), (1250, 0), (1260, 0), (1270, 0), (1280, 0), (1290, 1), (1300, 0), (1310, 0), (1320, 0), (1330, 0), (1340, 0), (1350, 0), (1360, 1), (1370, 0), (1380, 0), (1390, 0), (1400, 1), (1410, 1), (1420, 1), (1430, 1), (1440, 1), (1450, 1), (1460, 1), (1470, 1), (1480, 0), (1490, 0), (1500, 0), (1510, 1), (1520, 1), (1530, 1), (1540, 1), (1550, 1), (1560, 0), (1570, 0), (1580, 0), (1590, 0), (1600, 0), (1610, 0), (1620, 1), (1630, 1), (1640, 1), (1650, 0), (1660, 0), (1670, 0), (1680, 0), (1690, 0), (1700, 0), (1710, 0), (1720, 0), (1730, 1), (1740, 1), (1750, 1), (1760, 1), (1770, 0), (1780, 1), (1790, 1), (1800, 0), (1810, 0), (1820, 0), (1830, 0), (1840, 1), (1850, 1), (1860, 1), (1870, 1), (1880, 1), (1890, 1), (1900, 1), (1910, 0), (1920, 1), (1930, 0), (1940, 1), (1950, 1), (1960, 1), (1970, 1), (1980, 0), (1990, 0), (2000, 0), (2010, 1), (2020, 0), (2030, 0), (2040, 0), (2050, 0)]
Vdin0_26  din0_26  0 PWL (0n 0.0v 9.495n 0.0v 9.505n 0.0v 19.495n 0.0v 19.505n 0.0v 29.495n 0.0v 29.505n 0.0v 39.495n 0.0v 39.505n 0.0v 49.495n 0.0v 49.505n 0.0v 59.495n 0.0v 59.505n 1.7v 69.495n 1.7v 69.505n 1.7v 79.495n 1.7v 79.505n 1.7v 89.495n 1.7v 89.505n 0.0v 99.495n 0.0v 99.505n 1.7v 109.495n 1.7v 109.505n 0.0v 119.495n 0.0v 119.505n 0.0v 129.495n 0.0v 129.505n 0.0v 139.495n 0.0v 139.505n 0.0v 149.495n 0.0v 149.505n 1.7v 159.495n 1.7v 159.505n 1.7v 169.495n 1.7v 169.505n 1.7v 179.495n 1.7v 179.505n 1.7v 189.495n 1.7v 189.505n 1.7v 199.495n 1.7v 199.505n 1.7v 209.495n 1.7v 209.505n 1.7v 219.495n 1.7v 219.505n 1.7v 229.495n 1.7v 229.505n 1.7v 239.495n 1.7v 239.505n 1.7v 249.495n 1.7v 249.505n 1.7v 259.495n 1.7v 259.505n 1.7v 269.495n 1.7v 269.505n 1.7v 279.495n 1.7v 279.505n 1.7v 289.495n 1.7v 289.505n 1.7v 299.495n 1.7v 299.505n 1.7v 309.495n 1.7v 309.505n 0.0v 319.495n 0.0v 319.505n 1.7v 329.495n 1.7v 329.505n 0.0v 339.495n 0.0v 339.505n 0.0v 349.495n 0.0v 349.505n 0.0v 359.495n 0.0v 359.505n 0.0v 369.495n 0.0v 369.505n 0.0v 379.495n 0.0v 379.505n 0.0v 389.495n 0.0v 389.505n 0.0v 399.495n 0.0v 399.505n 0.0v 409.495n 0.0v 409.505n 0.0v 419.495n 0.0v 419.505n 0.0v 429.495n 0.0v 429.505n 0.0v 439.495n 0.0v 439.505n 0.0v 449.495n 0.0v 449.505n 0.0v 459.495n 0.0v 459.505n 0.0v 469.495n 0.0v 469.505n 1.7v 479.495n 1.7v 479.505n 1.7v 489.495n 1.7v 489.505n 1.7v 499.495n 1.7v 499.505n 0.0v 509.495n 0.0v 509.505n 1.7v 519.495n 1.7v 519.505n 1.7v 529.495n 1.7v 529.505n 1.7v 539.495n 1.7v 539.505n 1.7v 549.495n 1.7v 549.505n 0.0v 559.495n 0.0v 559.505n 0.0v 569.495n 0.0v 569.505n 0.0v 579.495n 0.0v 579.505n 0.0v 589.495n 0.0v 589.505n 0.0v 599.495n 0.0v 599.505n 0.0v 609.495n 0.0v 609.505n 0.0v 619.495n 0.0v 619.505n 1.7v 629.495n 1.7v 629.505n 1.7v 639.495n 1.7v 639.505n 1.7v 649.495n 1.7v 649.505n 0.0v 659.495n 0.0v 659.505n 0.0v 669.495n 0.0v 669.505n 0.0v 679.495n 0.0v 679.505n 1.7v 689.495n 1.7v 689.505n 1.7v 699.495n 1.7v 699.505n 1.7v 709.495n 1.7v 709.505n 1.7v 719.495n 1.7v 719.505n 1.7v 729.495n 1.7v 729.505n 1.7v 739.495n 1.7v 739.505n 1.7v 749.495n 1.7v 749.505n 1.7v 759.495n 1.7v 759.505n 1.7v 769.495n 1.7v 769.505n 0.0v 779.495n 0.0v 779.505n 0.0v 789.495n 0.0v 789.505n 0.0v 799.495n 0.0v 799.505n 1.7v 809.495n 1.7v 809.505n 1.7v 819.495n 1.7v 819.505n 0.0v 829.495n 0.0v 829.505n 1.7v 839.495n 1.7v 839.505n 1.7v 849.495n 1.7v 849.505n 1.7v 859.495n 1.7v 859.505n 0.0v 869.495n 0.0v 869.505n 0.0v 879.495n 0.0v 879.505n 1.7v 889.495n 1.7v 889.505n 1.7v 899.495n 1.7v 899.505n 0.0v 909.495n 0.0v 909.505n 0.0v 919.495n 0.0v 919.505n 1.7v 929.495n 1.7v 929.505n 1.7v 939.495n 1.7v 939.505n 1.7v 949.495n 1.7v 949.505n 1.7v 959.495n 1.7v 959.505n 0.0v 969.495n 0.0v 969.505n 1.7v 979.495n 1.7v 979.505n 0.0v 989.495n 0.0v 989.505n 0.0v 999.495n 0.0v 999.505n 1.7v 1009.495n 1.7v 1009.505n 1.7v 1019.495n 1.7v 1019.505n 0.0v 1029.495n 0.0v 1029.505n 1.7v 1039.495n 1.7v 1039.505n 1.7v 1049.495n 1.7v 1049.505n 1.7v 1059.495n 1.7v 1059.505n 1.7v 1069.495n 1.7v 1069.505n 1.7v 1079.495n 1.7v 1079.505n 0.0v 1089.495n 0.0v 1089.505n 0.0v 1099.495n 0.0v 1099.505n 1.7v 1109.495n 1.7v 1109.505n 0.0v 1119.495n 0.0v 1119.505n 0.0v 1129.495n 0.0v 1129.505n 1.7v 1139.495n 1.7v 1139.505n 1.7v 1149.495n 1.7v 1149.505n 1.7v 1159.495n 1.7v 1159.505n 1.7v 1169.495n 1.7v 1169.505n 1.7v 1179.495n 1.7v 1179.505n 1.7v 1189.495n 1.7v 1189.505n 1.7v 1199.495n 1.7v 1199.505n 1.7v 1209.495n 1.7v 1209.505n 1.7v 1219.495n 1.7v 1219.505n 0.0v 1229.495n 0.0v 1229.505n 1.7v 1239.495n 1.7v 1239.505n 1.7v 1249.495n 1.7v 1249.505n 0.0v 1259.495n 0.0v 1259.505n 0.0v 1269.495n 0.0v 1269.505n 0.0v 1279.495n 0.0v 1279.505n 0.0v 1289.495n 0.0v 1289.505n 1.7v 1299.495n 1.7v 1299.505n 0.0v 1309.495n 0.0v 1309.505n 0.0v 1319.495n 0.0v 1319.505n 0.0v 1329.495n 0.0v 1329.505n 0.0v 1339.495n 0.0v 1339.505n 0.0v 1349.495n 0.0v 1349.505n 0.0v 1359.495n 0.0v 1359.505n 1.7v 1369.495n 1.7v 1369.505n 0.0v 1379.495n 0.0v 1379.505n 0.0v 1389.495n 0.0v 1389.505n 0.0v 1399.495n 0.0v 1399.505n 1.7v 1409.495n 1.7v 1409.505n 1.7v 1419.495n 1.7v 1419.505n 1.7v 1429.495n 1.7v 1429.505n 1.7v 1439.495n 1.7v 1439.505n 1.7v 1449.495n 1.7v 1449.505n 1.7v 1459.495n 1.7v 1459.505n 1.7v 1469.495n 1.7v 1469.505n 1.7v 1479.495n 1.7v 1479.505n 0.0v 1489.495n 0.0v 1489.505n 0.0v 1499.495n 0.0v 1499.505n 0.0v 1509.495n 0.0v 1509.505n 1.7v 1519.495n 1.7v 1519.505n 1.7v 1529.495n 1.7v 1529.505n 1.7v 1539.495n 1.7v 1539.505n 1.7v 1549.495n 1.7v 1549.505n 1.7v 1559.495n 1.7v 1559.505n 0.0v 1569.495n 0.0v 1569.505n 0.0v 1579.495n 0.0v 1579.505n 0.0v 1589.495n 0.0v 1589.505n 0.0v 1599.495n 0.0v 1599.505n 0.0v 1609.495n 0.0v 1609.505n 0.0v 1619.495n 0.0v 1619.505n 1.7v 1629.495n 1.7v 1629.505n 1.7v 1639.495n 1.7v 1639.505n 1.7v 1649.495n 1.7v 1649.505n 0.0v 1659.495n 0.0v 1659.505n 0.0v 1669.495n 0.0v 1669.505n 0.0v 1679.495n 0.0v 1679.505n 0.0v 1689.495n 0.0v 1689.505n 0.0v 1699.495n 0.0v 1699.505n 0.0v 1709.495n 0.0v 1709.505n 0.0v 1719.495n 0.0v 1719.505n 0.0v 1729.495n 0.0v 1729.505n 1.7v 1739.495n 1.7v 1739.505n 1.7v 1749.495n 1.7v 1749.505n 1.7v 1759.495n 1.7v 1759.505n 1.7v 1769.495n 1.7v 1769.505n 0.0v 1779.495n 0.0v 1779.505n 1.7v 1789.495n 1.7v 1789.505n 1.7v 1799.495n 1.7v 1799.505n 0.0v 1809.495n 0.0v 1809.505n 0.0v 1819.495n 0.0v 1819.505n 0.0v 1829.495n 0.0v 1829.505n 0.0v 1839.495n 0.0v 1839.505n 1.7v 1849.495n 1.7v 1849.505n 1.7v 1859.495n 1.7v 1859.505n 1.7v 1869.495n 1.7v 1869.505n 1.7v 1879.495n 1.7v 1879.505n 1.7v 1889.495n 1.7v 1889.505n 1.7v 1899.495n 1.7v 1899.505n 1.7v 1909.495n 1.7v 1909.505n 0.0v 1919.495n 0.0v 1919.505n 1.7v 1929.495n 1.7v 1929.505n 0.0v 1939.495n 0.0v 1939.505n 1.7v 1949.495n 1.7v 1949.505n 1.7v 1959.495n 1.7v 1959.505n 1.7v 1969.495n 1.7v 1969.505n 1.7v 1979.495n 1.7v 1979.505n 0.0v 1989.495n 0.0v 1989.505n 0.0v 1999.495n 0.0v 1999.505n 0.0v 2009.495n 0.0v 2009.505n 1.7v 2019.495n 1.7v 2019.505n 0.0v 2029.495n 0.0v 2029.505n 0.0v 2039.495n 0.0v 2039.505n 0.0v 2049.495n 0.0v 2049.505n 0.0v )
* (time, data): [(0, 0), (10, 0), (20, 0), (30, 0), (40, 0), (50, 0), (60, 0), (70, 0), (80, 0), (90, 0), (100, 0), (110, 0), (120, 0), (130, 0), (140, 0), (150, 1), (160, 1), (170, 1), (180, 1), (190, 1), (200, 1), (210, 0), (220, 0), (230, 0), (240, 0), (250, 0), (260, 0), (270, 0), (280, 0), (290, 0), (300, 0), (310, 1), (320, 0), (330, 1), (340, 1), (350, 1), (360, 1), (370, 1), (380, 1), (390, 1), (400, 1), (410, 1), (420, 0), (430, 0), (440, 0), (450, 0), (460, 1), (470, 0), (480, 0), (490, 0), (500, 0), (510, 1), (520, 0), (530, 0), (540, 0), (550, 0), (560, 0), (570, 0), (580, 0), (590, 0), (600, 1), (610, 0), (620, 1), (630, 1), (640, 1), (650, 0), (660, 0), (670, 0), (680, 0), (690, 0), (700, 0), (710, 1), (720, 1), (730, 1), (740, 1), (750, 1), (760, 1), (770, 0), (780, 0), (790, 0), (800, 0), (810, 0), (820, 1), (830, 0), (840, 0), (850, 0), (860, 1), (870, 0), (880, 1), (890, 1), (900, 0), (910, 0), (920, 0), (930, 0), (940, 0), (950, 0), (960, 0), (970, 1), (980, 1), (990, 1), (1000, 0), (1010, 1), (1020, 0), (1030, 1), (1040, 1), (1050, 1), (1060, 1), (1070, 1), (1080, 1), (1090, 0), (1100, 1), (1110, 1), (1120, 1), (1130, 0), (1140, 1), (1150, 0), (1160, 0), (1170, 0), (1180, 0), (1190, 0), (1200, 0), (1210, 0), (1220, 0), (1230, 1), (1240, 1), (1250, 1), (1260, 1), (1270, 1), (1280, 1), (1290, 0), (1300, 1), (1310, 1), (1320, 1), (1330, 1), (1340, 1), (1350, 1), (1360, 0), (1370, 0), (1380, 0), (1390, 0), (1400, 1), (1410, 1), (1420, 1), (1430, 1), (1440, 1), (1450, 1), (1460, 1), (1470, 1), (1480, 1), (1490, 1), (1500, 0), (1510, 0), (1520, 0), (1530, 0), (1540, 1), (1550, 1), (1560, 0), (1570, 0), (1580, 1), (1590, 1), (1600, 1), (1610, 1), (1620, 0), (1630, 0), (1640, 0), (1650, 0), (1660, 1), (1670, 1), (1680, 1), (1690, 1), (1700, 1), (1710, 1), (1720, 1), (1730, 1), (1740, 1), (1750, 1), (1760, 1), (1770, 0), (1780, 1), (1790, 1), (1800, 0), (1810, 0), (1820, 0), (1830, 0), (1840, 0), (1850, 0), (1860, 1), (1870, 1), (1880, 1), (1890, 1), (1900, 1), (1910, 0), (1920, 0), (1930, 1), (1940, 0), (1950, 0), (1960, 0), (1970, 1), (1980, 1), (1990, 1), (2000, 0), (2010, 1), (2020, 1), (2030, 1), (2040, 1), (2050, 1)]
Vdin0_27  din0_27  0 PWL (0n 0.0v 9.495n 0.0v 9.505n 0.0v 19.495n 0.0v 19.505n 0.0v 29.495n 0.0v 29.505n 0.0v 39.495n 0.0v 39.505n 0.0v 49.495n 0.0v 49.505n 0.0v 59.495n 0.0v 59.505n 0.0v 69.495n 0.0v 69.505n 0.0v 79.495n 0.0v 79.505n 0.0v 89.495n 0.0v 89.505n 0.0v 99.495n 0.0v 99.505n 0.0v 109.495n 0.0v 109.505n 0.0v 119.495n 0.0v 119.505n 0.0v 129.495n 0.0v 129.505n 0.0v 139.495n 0.0v 139.505n 0.0v 149.495n 0.0v 149.505n 1.7v 159.495n 1.7v 159.505n 1.7v 169.495n 1.7v 169.505n 1.7v 179.495n 1.7v 179.505n 1.7v 189.495n 1.7v 189.505n 1.7v 199.495n 1.7v 199.505n 1.7v 209.495n 1.7v 209.505n 0.0v 219.495n 0.0v 219.505n 0.0v 229.495n 0.0v 229.505n 0.0v 239.495n 0.0v 239.505n 0.0v 249.495n 0.0v 249.505n 0.0v 259.495n 0.0v 259.505n 0.0v 269.495n 0.0v 269.505n 0.0v 279.495n 0.0v 279.505n 0.0v 289.495n 0.0v 289.505n 0.0v 299.495n 0.0v 299.505n 0.0v 309.495n 0.0v 309.505n 1.7v 319.495n 1.7v 319.505n 0.0v 329.495n 0.0v 329.505n 1.7v 339.495n 1.7v 339.505n 1.7v 349.495n 1.7v 349.505n 1.7v 359.495n 1.7v 359.505n 1.7v 369.495n 1.7v 369.505n 1.7v 379.495n 1.7v 379.505n 1.7v 389.495n 1.7v 389.505n 1.7v 399.495n 1.7v 399.505n 1.7v 409.495n 1.7v 409.505n 1.7v 419.495n 1.7v 419.505n 0.0v 429.495n 0.0v 429.505n 0.0v 439.495n 0.0v 439.505n 0.0v 449.495n 0.0v 449.505n 0.0v 459.495n 0.0v 459.505n 1.7v 469.495n 1.7v 469.505n 0.0v 479.495n 0.0v 479.505n 0.0v 489.495n 0.0v 489.505n 0.0v 499.495n 0.0v 499.505n 0.0v 509.495n 0.0v 509.505n 1.7v 519.495n 1.7v 519.505n 0.0v 529.495n 0.0v 529.505n 0.0v 539.495n 0.0v 539.505n 0.0v 549.495n 0.0v 549.505n 0.0v 559.495n 0.0v 559.505n 0.0v 569.495n 0.0v 569.505n 0.0v 579.495n 0.0v 579.505n 0.0v 589.495n 0.0v 589.505n 0.0v 599.495n 0.0v 599.505n 1.7v 609.495n 1.7v 609.505n 0.0v 619.495n 0.0v 619.505n 1.7v 629.495n 1.7v 629.505n 1.7v 639.495n 1.7v 639.505n 1.7v 649.495n 1.7v 649.505n 0.0v 659.495n 0.0v 659.505n 0.0v 669.495n 0.0v 669.505n 0.0v 679.495n 0.0v 679.505n 0.0v 689.495n 0.0v 689.505n 0.0v 699.495n 0.0v 699.505n 0.0v 709.495n 0.0v 709.505n 1.7v 719.495n 1.7v 719.505n 1.7v 729.495n 1.7v 729.505n 1.7v 739.495n 1.7v 739.505n 1.7v 749.495n 1.7v 749.505n 1.7v 759.495n 1.7v 759.505n 1.7v 769.495n 1.7v 769.505n 0.0v 779.495n 0.0v 779.505n 0.0v 789.495n 0.0v 789.505n 0.0v 799.495n 0.0v 799.505n 0.0v 809.495n 0.0v 809.505n 0.0v 819.495n 0.0v 819.505n 1.7v 829.495n 1.7v 829.505n 0.0v 839.495n 0.0v 839.505n 0.0v 849.495n 0.0v 849.505n 0.0v 859.495n 0.0v 859.505n 1.7v 869.495n 1.7v 869.505n 0.0v 879.495n 0.0v 879.505n 1.7v 889.495n 1.7v 889.505n 1.7v 899.495n 1.7v 899.505n 0.0v 909.495n 0.0v 909.505n 0.0v 919.495n 0.0v 919.505n 0.0v 929.495n 0.0v 929.505n 0.0v 939.495n 0.0v 939.505n 0.0v 949.495n 0.0v 949.505n 0.0v 959.495n 0.0v 959.505n 0.0v 969.495n 0.0v 969.505n 1.7v 979.495n 1.7v 979.505n 1.7v 989.495n 1.7v 989.505n 1.7v 999.495n 1.7v 999.505n 0.0v 1009.495n 0.0v 1009.505n 1.7v 1019.495n 1.7v 1019.505n 0.0v 1029.495n 0.0v 1029.505n 1.7v 1039.495n 1.7v 1039.505n 1.7v 1049.495n 1.7v 1049.505n 1.7v 1059.495n 1.7v 1059.505n 1.7v 1069.495n 1.7v 1069.505n 1.7v 1079.495n 1.7v 1079.505n 1.7v 1089.495n 1.7v 1089.505n 0.0v 1099.495n 0.0v 1099.505n 1.7v 1109.495n 1.7v 1109.505n 1.7v 1119.495n 1.7v 1119.505n 1.7v 1129.495n 1.7v 1129.505n 0.0v 1139.495n 0.0v 1139.505n 1.7v 1149.495n 1.7v 1149.505n 0.0v 1159.495n 0.0v 1159.505n 0.0v 1169.495n 0.0v 1169.505n 0.0v 1179.495n 0.0v 1179.505n 0.0v 1189.495n 0.0v 1189.505n 0.0v 1199.495n 0.0v 1199.505n 0.0v 1209.495n 0.0v 1209.505n 0.0v 1219.495n 0.0v 1219.505n 0.0v 1229.495n 0.0v 1229.505n 1.7v 1239.495n 1.7v 1239.505n 1.7v 1249.495n 1.7v 1249.505n 1.7v 1259.495n 1.7v 1259.505n 1.7v 1269.495n 1.7v 1269.505n 1.7v 1279.495n 1.7v 1279.505n 1.7v 1289.495n 1.7v 1289.505n 0.0v 1299.495n 0.0v 1299.505n 1.7v 1309.495n 1.7v 1309.505n 1.7v 1319.495n 1.7v 1319.505n 1.7v 1329.495n 1.7v 1329.505n 1.7v 1339.495n 1.7v 1339.505n 1.7v 1349.495n 1.7v 1349.505n 1.7v 1359.495n 1.7v 1359.505n 0.0v 1369.495n 0.0v 1369.505n 0.0v 1379.495n 0.0v 1379.505n 0.0v 1389.495n 0.0v 1389.505n 0.0v 1399.495n 0.0v 1399.505n 1.7v 1409.495n 1.7v 1409.505n 1.7v 1419.495n 1.7v 1419.505n 1.7v 1429.495n 1.7v 1429.505n 1.7v 1439.495n 1.7v 1439.505n 1.7v 1449.495n 1.7v 1449.505n 1.7v 1459.495n 1.7v 1459.505n 1.7v 1469.495n 1.7v 1469.505n 1.7v 1479.495n 1.7v 1479.505n 1.7v 1489.495n 1.7v 1489.505n 1.7v 1499.495n 1.7v 1499.505n 0.0v 1509.495n 0.0v 1509.505n 0.0v 1519.495n 0.0v 1519.505n 0.0v 1529.495n 0.0v 1529.505n 0.0v 1539.495n 0.0v 1539.505n 1.7v 1549.495n 1.7v 1549.505n 1.7v 1559.495n 1.7v 1559.505n 0.0v 1569.495n 0.0v 1569.505n 0.0v 1579.495n 0.0v 1579.505n 1.7v 1589.495n 1.7v 1589.505n 1.7v 1599.495n 1.7v 1599.505n 1.7v 1609.495n 1.7v 1609.505n 1.7v 1619.495n 1.7v 1619.505n 0.0v 1629.495n 0.0v 1629.505n 0.0v 1639.495n 0.0v 1639.505n 0.0v 1649.495n 0.0v 1649.505n 0.0v 1659.495n 0.0v 1659.505n 1.7v 1669.495n 1.7v 1669.505n 1.7v 1679.495n 1.7v 1679.505n 1.7v 1689.495n 1.7v 1689.505n 1.7v 1699.495n 1.7v 1699.505n 1.7v 1709.495n 1.7v 1709.505n 1.7v 1719.495n 1.7v 1719.505n 1.7v 1729.495n 1.7v 1729.505n 1.7v 1739.495n 1.7v 1739.505n 1.7v 1749.495n 1.7v 1749.505n 1.7v 1759.495n 1.7v 1759.505n 1.7v 1769.495n 1.7v 1769.505n 0.0v 1779.495n 0.0v 1779.505n 1.7v 1789.495n 1.7v 1789.505n 1.7v 1799.495n 1.7v 1799.505n 0.0v 1809.495n 0.0v 1809.505n 0.0v 1819.495n 0.0v 1819.505n 0.0v 1829.495n 0.0v 1829.505n 0.0v 1839.495n 0.0v 1839.505n 0.0v 1849.495n 0.0v 1849.505n 0.0v 1859.495n 0.0v 1859.505n 1.7v 1869.495n 1.7v 1869.505n 1.7v 1879.495n 1.7v 1879.505n 1.7v 1889.495n 1.7v 1889.505n 1.7v 1899.495n 1.7v 1899.505n 1.7v 1909.495n 1.7v 1909.505n 0.0v 1919.495n 0.0v 1919.505n 0.0v 1929.495n 0.0v 1929.505n 1.7v 1939.495n 1.7v 1939.505n 0.0v 1949.495n 0.0v 1949.505n 0.0v 1959.495n 0.0v 1959.505n 0.0v 1969.495n 0.0v 1969.505n 1.7v 1979.495n 1.7v 1979.505n 1.7v 1989.495n 1.7v 1989.505n 1.7v 1999.495n 1.7v 1999.505n 0.0v 2009.495n 0.0v 2009.505n 1.7v 2019.495n 1.7v 2019.505n 1.7v 2029.495n 1.7v 2029.505n 1.7v 2039.495n 1.7v 2039.505n 1.7v 2049.495n 1.7v 2049.505n 1.7v )
* (time, data): [(0, 0), (10, 1), (20, 0), (30, 0), (40, 0), (50, 0), (60, 0), (70, 0), (80, 0), (90, 1), (100, 1), (110, 0), (120, 0), (130, 0), (140, 0), (150, 0), (160, 0), (170, 0), (180, 0), (190, 0), (200, 1), (210, 0), (220, 0), (230, 0), (240, 0), (250, 0), (260, 0), (270, 0), (280, 1), (290, 1), (300, 1), (310, 0), (320, 1), (330, 0), (340, 0), (350, 0), (360, 0), (370, 0), (380, 0), (390, 0), (400, 0), (410, 0), (420, 0), (430, 0), (440, 0), (450, 0), (460, 0), (470, 0), (480, 0), (490, 0), (500, 1), (510, 1), (520, 0), (530, 0), (540, 0), (550, 1), (560, 0), (570, 0), (580, 0), (590, 0), (600, 0), (610, 0), (620, 0), (630, 1), (640, 1), (650, 1), (660, 1), (670, 0), (680, 0), (690, 0), (700, 0), (710, 1), (720, 1), (730, 1), (740, 1), (750, 1), (760, 1), (770, 1), (780, 0), (790, 0), (800, 1), (810, 1), (820, 0), (830, 0), (840, 0), (850, 0), (860, 0), (870, 0), (880, 1), (890, 1), (900, 0), (910, 0), (920, 1), (930, 1), (940, 1), (950, 1), (960, 1), (970, 1), (980, 1), (990, 1), (1000, 1), (1010, 1), (1020, 1), (1030, 0), (1040, 0), (1050, 0), (1060, 0), (1070, 0), (1080, 1), (1090, 0), (1100, 0), (1110, 0), (1120, 0), (1130, 1), (1140, 1), (1150, 1), (1160, 1), (1170, 1), (1180, 1), (1190, 1), (1200, 1), (1210, 1), (1220, 1), (1230, 0), (1240, 0), (1250, 1), (1260, 1), (1270, 1), (1280, 1), (1290, 1), (1300, 0), (1310, 0), (1320, 0), (1330, 0), (1340, 0), (1350, 0), (1360, 0), (1370, 1), (1380, 1), (1390, 1), (1400, 0), (1410, 0), (1420, 0), (1430, 0), (1440, 0), (1450, 0), (1460, 0), (1470, 0), (1480, 1), (1490, 1), (1500, 0), (1510, 0), (1520, 0), (1530, 0), (1540, 1), (1550, 0), (1560, 1), (1570, 1), (1580, 1), (1590, 1), (1600, 1), (1610, 1), (1620, 1), (1630, 1), (1640, 1), (1650, 1), (1660, 0), (1670, 0), (1680, 0), (1690, 0), (1700, 0), (1710, 0), (1720, 0), (1730, 0), (1740, 0), (1750, 1), (1760, 1), (1770, 0), (1780, 0), (1790, 0), (1800, 1), (1810, 1), (1820, 1), (1830, 1), (1840, 0), (1850, 0), (1860, 1), (1870, 1), (1880, 1), (1890, 1), (1900, 1), (1910, 1), (1920, 0), (1930, 0), (1940, 0), (1950, 0), (1960, 0), (1970, 0), (1980, 1), (1990, 1), (2000, 0), (2010, 0), (2020, 1), (2030, 1), (2040, 1), (2050, 1)]
Vdin0_28  din0_28  0 PWL (0n 0.0v 9.495n 0.0v 9.505n 1.7v 19.495n 1.7v 19.505n 0.0v 29.495n 0.0v 29.505n 0.0v 39.495n 0.0v 39.505n 0.0v 49.495n 0.0v 49.505n 0.0v 59.495n 0.0v 59.505n 0.0v 69.495n 0.0v 69.505n 0.0v 79.495n 0.0v 79.505n 0.0v 89.495n 0.0v 89.505n 1.7v 99.495n 1.7v 99.505n 1.7v 109.495n 1.7v 109.505n 0.0v 119.495n 0.0v 119.505n 0.0v 129.495n 0.0v 129.505n 0.0v 139.495n 0.0v 139.505n 0.0v 149.495n 0.0v 149.505n 0.0v 159.495n 0.0v 159.505n 0.0v 169.495n 0.0v 169.505n 0.0v 179.495n 0.0v 179.505n 0.0v 189.495n 0.0v 189.505n 0.0v 199.495n 0.0v 199.505n 1.7v 209.495n 1.7v 209.505n 0.0v 219.495n 0.0v 219.505n 0.0v 229.495n 0.0v 229.505n 0.0v 239.495n 0.0v 239.505n 0.0v 249.495n 0.0v 249.505n 0.0v 259.495n 0.0v 259.505n 0.0v 269.495n 0.0v 269.505n 0.0v 279.495n 0.0v 279.505n 1.7v 289.495n 1.7v 289.505n 1.7v 299.495n 1.7v 299.505n 1.7v 309.495n 1.7v 309.505n 0.0v 319.495n 0.0v 319.505n 1.7v 329.495n 1.7v 329.505n 0.0v 339.495n 0.0v 339.505n 0.0v 349.495n 0.0v 349.505n 0.0v 359.495n 0.0v 359.505n 0.0v 369.495n 0.0v 369.505n 0.0v 379.495n 0.0v 379.505n 0.0v 389.495n 0.0v 389.505n 0.0v 399.495n 0.0v 399.505n 0.0v 409.495n 0.0v 409.505n 0.0v 419.495n 0.0v 419.505n 0.0v 429.495n 0.0v 429.505n 0.0v 439.495n 0.0v 439.505n 0.0v 449.495n 0.0v 449.505n 0.0v 459.495n 0.0v 459.505n 0.0v 469.495n 0.0v 469.505n 0.0v 479.495n 0.0v 479.505n 0.0v 489.495n 0.0v 489.505n 0.0v 499.495n 0.0v 499.505n 1.7v 509.495n 1.7v 509.505n 1.7v 519.495n 1.7v 519.505n 0.0v 529.495n 0.0v 529.505n 0.0v 539.495n 0.0v 539.505n 0.0v 549.495n 0.0v 549.505n 1.7v 559.495n 1.7v 559.505n 0.0v 569.495n 0.0v 569.505n 0.0v 579.495n 0.0v 579.505n 0.0v 589.495n 0.0v 589.505n 0.0v 599.495n 0.0v 599.505n 0.0v 609.495n 0.0v 609.505n 0.0v 619.495n 0.0v 619.505n 0.0v 629.495n 0.0v 629.505n 1.7v 639.495n 1.7v 639.505n 1.7v 649.495n 1.7v 649.505n 1.7v 659.495n 1.7v 659.505n 1.7v 669.495n 1.7v 669.505n 0.0v 679.495n 0.0v 679.505n 0.0v 689.495n 0.0v 689.505n 0.0v 699.495n 0.0v 699.505n 0.0v 709.495n 0.0v 709.505n 1.7v 719.495n 1.7v 719.505n 1.7v 729.495n 1.7v 729.505n 1.7v 739.495n 1.7v 739.505n 1.7v 749.495n 1.7v 749.505n 1.7v 759.495n 1.7v 759.505n 1.7v 769.495n 1.7v 769.505n 1.7v 779.495n 1.7v 779.505n 0.0v 789.495n 0.0v 789.505n 0.0v 799.495n 0.0v 799.505n 1.7v 809.495n 1.7v 809.505n 1.7v 819.495n 1.7v 819.505n 0.0v 829.495n 0.0v 829.505n 0.0v 839.495n 0.0v 839.505n 0.0v 849.495n 0.0v 849.505n 0.0v 859.495n 0.0v 859.505n 0.0v 869.495n 0.0v 869.505n 0.0v 879.495n 0.0v 879.505n 1.7v 889.495n 1.7v 889.505n 1.7v 899.495n 1.7v 899.505n 0.0v 909.495n 0.0v 909.505n 0.0v 919.495n 0.0v 919.505n 1.7v 929.495n 1.7v 929.505n 1.7v 939.495n 1.7v 939.505n 1.7v 949.495n 1.7v 949.505n 1.7v 959.495n 1.7v 959.505n 1.7v 969.495n 1.7v 969.505n 1.7v 979.495n 1.7v 979.505n 1.7v 989.495n 1.7v 989.505n 1.7v 999.495n 1.7v 999.505n 1.7v 1009.495n 1.7v 1009.505n 1.7v 1019.495n 1.7v 1019.505n 1.7v 1029.495n 1.7v 1029.505n 0.0v 1039.495n 0.0v 1039.505n 0.0v 1049.495n 0.0v 1049.505n 0.0v 1059.495n 0.0v 1059.505n 0.0v 1069.495n 0.0v 1069.505n 0.0v 1079.495n 0.0v 1079.505n 1.7v 1089.495n 1.7v 1089.505n 0.0v 1099.495n 0.0v 1099.505n 0.0v 1109.495n 0.0v 1109.505n 0.0v 1119.495n 0.0v 1119.505n 0.0v 1129.495n 0.0v 1129.505n 1.7v 1139.495n 1.7v 1139.505n 1.7v 1149.495n 1.7v 1149.505n 1.7v 1159.495n 1.7v 1159.505n 1.7v 1169.495n 1.7v 1169.505n 1.7v 1179.495n 1.7v 1179.505n 1.7v 1189.495n 1.7v 1189.505n 1.7v 1199.495n 1.7v 1199.505n 1.7v 1209.495n 1.7v 1209.505n 1.7v 1219.495n 1.7v 1219.505n 1.7v 1229.495n 1.7v 1229.505n 0.0v 1239.495n 0.0v 1239.505n 0.0v 1249.495n 0.0v 1249.505n 1.7v 1259.495n 1.7v 1259.505n 1.7v 1269.495n 1.7v 1269.505n 1.7v 1279.495n 1.7v 1279.505n 1.7v 1289.495n 1.7v 1289.505n 1.7v 1299.495n 1.7v 1299.505n 0.0v 1309.495n 0.0v 1309.505n 0.0v 1319.495n 0.0v 1319.505n 0.0v 1329.495n 0.0v 1329.505n 0.0v 1339.495n 0.0v 1339.505n 0.0v 1349.495n 0.0v 1349.505n 0.0v 1359.495n 0.0v 1359.505n 0.0v 1369.495n 0.0v 1369.505n 1.7v 1379.495n 1.7v 1379.505n 1.7v 1389.495n 1.7v 1389.505n 1.7v 1399.495n 1.7v 1399.505n 0.0v 1409.495n 0.0v 1409.505n 0.0v 1419.495n 0.0v 1419.505n 0.0v 1429.495n 0.0v 1429.505n 0.0v 1439.495n 0.0v 1439.505n 0.0v 1449.495n 0.0v 1449.505n 0.0v 1459.495n 0.0v 1459.505n 0.0v 1469.495n 0.0v 1469.505n 0.0v 1479.495n 0.0v 1479.505n 1.7v 1489.495n 1.7v 1489.505n 1.7v 1499.495n 1.7v 1499.505n 0.0v 1509.495n 0.0v 1509.505n 0.0v 1519.495n 0.0v 1519.505n 0.0v 1529.495n 0.0v 1529.505n 0.0v 1539.495n 0.0v 1539.505n 1.7v 1549.495n 1.7v 1549.505n 0.0v 1559.495n 0.0v 1559.505n 1.7v 1569.495n 1.7v 1569.505n 1.7v 1579.495n 1.7v 1579.505n 1.7v 1589.495n 1.7v 1589.505n 1.7v 1599.495n 1.7v 1599.505n 1.7v 1609.495n 1.7v 1609.505n 1.7v 1619.495n 1.7v 1619.505n 1.7v 1629.495n 1.7v 1629.505n 1.7v 1639.495n 1.7v 1639.505n 1.7v 1649.495n 1.7v 1649.505n 1.7v 1659.495n 1.7v 1659.505n 0.0v 1669.495n 0.0v 1669.505n 0.0v 1679.495n 0.0v 1679.505n 0.0v 1689.495n 0.0v 1689.505n 0.0v 1699.495n 0.0v 1699.505n 0.0v 1709.495n 0.0v 1709.505n 0.0v 1719.495n 0.0v 1719.505n 0.0v 1729.495n 0.0v 1729.505n 0.0v 1739.495n 0.0v 1739.505n 0.0v 1749.495n 0.0v 1749.505n 1.7v 1759.495n 1.7v 1759.505n 1.7v 1769.495n 1.7v 1769.505n 0.0v 1779.495n 0.0v 1779.505n 0.0v 1789.495n 0.0v 1789.505n 0.0v 1799.495n 0.0v 1799.505n 1.7v 1809.495n 1.7v 1809.505n 1.7v 1819.495n 1.7v 1819.505n 1.7v 1829.495n 1.7v 1829.505n 1.7v 1839.495n 1.7v 1839.505n 0.0v 1849.495n 0.0v 1849.505n 0.0v 1859.495n 0.0v 1859.505n 1.7v 1869.495n 1.7v 1869.505n 1.7v 1879.495n 1.7v 1879.505n 1.7v 1889.495n 1.7v 1889.505n 1.7v 1899.495n 1.7v 1899.505n 1.7v 1909.495n 1.7v 1909.505n 1.7v 1919.495n 1.7v 1919.505n 0.0v 1929.495n 0.0v 1929.505n 0.0v 1939.495n 0.0v 1939.505n 0.0v 1949.495n 0.0v 1949.505n 0.0v 1959.495n 0.0v 1959.505n 0.0v 1969.495n 0.0v 1969.505n 0.0v 1979.495n 0.0v 1979.505n 1.7v 1989.495n 1.7v 1989.505n 1.7v 1999.495n 1.7v 1999.505n 0.0v 2009.495n 0.0v 2009.505n 0.0v 2019.495n 0.0v 2019.505n 1.7v 2029.495n 1.7v 2029.505n 1.7v 2039.495n 1.7v 2039.505n 1.7v 2049.495n 1.7v 2049.505n 1.7v )
* (time, data): [(0, 0), (10, 1), (20, 1), (30, 0), (40, 0), (50, 0), (60, 0), (70, 0), (80, 0), (90, 1), (100, 0), (110, 1), (120, 1), (130, 1), (140, 1), (150, 0), (160, 0), (170, 0), (180, 0), (190, 0), (200, 1), (210, 1), (220, 1), (230, 1), (240, 1), (250, 1), (260, 1), (270, 1), (280, 1), (290, 1), (300, 1), (310, 1), (320, 1), (330, 0), (340, 0), (350, 0), (360, 0), (370, 0), (380, 0), (390, 0), (400, 0), (410, 0), (420, 0), (430, 0), (440, 0), (450, 0), (460, 1), (470, 0), (480, 0), (490, 0), (500, 1), (510, 0), (520, 1), (530, 1), (540, 1), (550, 1), (560, 0), (570, 0), (580, 0), (590, 0), (600, 1), (610, 0), (620, 1), (630, 0), (640, 0), (650, 1), (660, 1), (670, 0), (680, 0), (690, 0), (700, 1), (710, 0), (720, 0), (730, 0), (740, 0), (750, 0), (760, 0), (770, 1), (780, 0), (790, 1), (800, 1), (810, 1), (820, 0), (830, 1), (840, 1), (850, 1), (860, 0), (870, 1), (880, 1), (890, 1), (900, 1), (910, 1), (920, 1), (930, 1), (940, 1), (950, 1), (960, 0), (970, 0), (980, 0), (990, 0), (1000, 0), (1010, 1), (1020, 0), (1030, 0), (1040, 0), (1050, 0), (1060, 0), (1070, 1), (1080, 1), (1090, 1), (1100, 0), (1110, 0), (1120, 0), (1130, 0), (1140, 1), (1150, 0), (1160, 0), (1170, 0), (1180, 0), (1190, 0), (1200, 0), (1210, 0), (1220, 0), (1230, 0), (1240, 0), (1250, 0), (1260, 0), (1270, 0), (1280, 0), (1290, 1), (1300, 0), (1310, 0), (1320, 0), (1330, 0), (1340, 0), (1350, 0), (1360, 0), (1370, 1), (1380, 1), (1390, 1), (1400, 1), (1410, 1), (1420, 1), (1430, 1), (1440, 1), (1450, 1), (1460, 1), (1470, 1), (1480, 1), (1490, 1), (1500, 1), (1510, 0), (1520, 0), (1530, 0), (1540, 0), (1550, 0), (1560, 1), (1570, 1), (1580, 0), (1590, 0), (1600, 0), (1610, 0), (1620, 1), (1630, 1), (1640, 1), (1650, 0), (1660, 1), (1670, 1), (1680, 1), (1690, 1), (1700, 1), (1710, 0), (1720, 0), (1730, 1), (1740, 1), (1750, 1), (1760, 1), (1770, 0), (1780, 1), (1790, 1), (1800, 0), (1810, 0), (1820, 0), (1830, 0), (1840, 1), (1850, 1), (1860, 0), (1870, 0), (1880, 0), (1890, 0), (1900, 0), (1910, 1), (1920, 1), (1930, 1), (1940, 0), (1950, 0), (1960, 0), (1970, 0), (1980, 0), (1990, 0), (2000, 0), (2010, 0), (2020, 1), (2030, 1), (2040, 1), (2050, 1)]
Vdin0_29  din0_29  0 PWL (0n 0.0v 9.495n 0.0v 9.505n 1.7v 19.495n 1.7v 19.505n 1.7v 29.495n 1.7v 29.505n 0.0v 39.495n 0.0v 39.505n 0.0v 49.495n 0.0v 49.505n 0.0v 59.495n 0.0v 59.505n 0.0v 69.495n 0.0v 69.505n 0.0v 79.495n 0.0v 79.505n 0.0v 89.495n 0.0v 89.505n 1.7v 99.495n 1.7v 99.505n 0.0v 109.495n 0.0v 109.505n 1.7v 119.495n 1.7v 119.505n 1.7v 129.495n 1.7v 129.505n 1.7v 139.495n 1.7v 139.505n 1.7v 149.495n 1.7v 149.505n 0.0v 159.495n 0.0v 159.505n 0.0v 169.495n 0.0v 169.505n 0.0v 179.495n 0.0v 179.505n 0.0v 189.495n 0.0v 189.505n 0.0v 199.495n 0.0v 199.505n 1.7v 209.495n 1.7v 209.505n 1.7v 219.495n 1.7v 219.505n 1.7v 229.495n 1.7v 229.505n 1.7v 239.495n 1.7v 239.505n 1.7v 249.495n 1.7v 249.505n 1.7v 259.495n 1.7v 259.505n 1.7v 269.495n 1.7v 269.505n 1.7v 279.495n 1.7v 279.505n 1.7v 289.495n 1.7v 289.505n 1.7v 299.495n 1.7v 299.505n 1.7v 309.495n 1.7v 309.505n 1.7v 319.495n 1.7v 319.505n 1.7v 329.495n 1.7v 329.505n 0.0v 339.495n 0.0v 339.505n 0.0v 349.495n 0.0v 349.505n 0.0v 359.495n 0.0v 359.505n 0.0v 369.495n 0.0v 369.505n 0.0v 379.495n 0.0v 379.505n 0.0v 389.495n 0.0v 389.505n 0.0v 399.495n 0.0v 399.505n 0.0v 409.495n 0.0v 409.505n 0.0v 419.495n 0.0v 419.505n 0.0v 429.495n 0.0v 429.505n 0.0v 439.495n 0.0v 439.505n 0.0v 449.495n 0.0v 449.505n 0.0v 459.495n 0.0v 459.505n 1.7v 469.495n 1.7v 469.505n 0.0v 479.495n 0.0v 479.505n 0.0v 489.495n 0.0v 489.505n 0.0v 499.495n 0.0v 499.505n 1.7v 509.495n 1.7v 509.505n 0.0v 519.495n 0.0v 519.505n 1.7v 529.495n 1.7v 529.505n 1.7v 539.495n 1.7v 539.505n 1.7v 549.495n 1.7v 549.505n 1.7v 559.495n 1.7v 559.505n 0.0v 569.495n 0.0v 569.505n 0.0v 579.495n 0.0v 579.505n 0.0v 589.495n 0.0v 589.505n 0.0v 599.495n 0.0v 599.505n 1.7v 609.495n 1.7v 609.505n 0.0v 619.495n 0.0v 619.505n 1.7v 629.495n 1.7v 629.505n 0.0v 639.495n 0.0v 639.505n 0.0v 649.495n 0.0v 649.505n 1.7v 659.495n 1.7v 659.505n 1.7v 669.495n 1.7v 669.505n 0.0v 679.495n 0.0v 679.505n 0.0v 689.495n 0.0v 689.505n 0.0v 699.495n 0.0v 699.505n 1.7v 709.495n 1.7v 709.505n 0.0v 719.495n 0.0v 719.505n 0.0v 729.495n 0.0v 729.505n 0.0v 739.495n 0.0v 739.505n 0.0v 749.495n 0.0v 749.505n 0.0v 759.495n 0.0v 759.505n 0.0v 769.495n 0.0v 769.505n 1.7v 779.495n 1.7v 779.505n 0.0v 789.495n 0.0v 789.505n 1.7v 799.495n 1.7v 799.505n 1.7v 809.495n 1.7v 809.505n 1.7v 819.495n 1.7v 819.505n 0.0v 829.495n 0.0v 829.505n 1.7v 839.495n 1.7v 839.505n 1.7v 849.495n 1.7v 849.505n 1.7v 859.495n 1.7v 859.505n 0.0v 869.495n 0.0v 869.505n 1.7v 879.495n 1.7v 879.505n 1.7v 889.495n 1.7v 889.505n 1.7v 899.495n 1.7v 899.505n 1.7v 909.495n 1.7v 909.505n 1.7v 919.495n 1.7v 919.505n 1.7v 929.495n 1.7v 929.505n 1.7v 939.495n 1.7v 939.505n 1.7v 949.495n 1.7v 949.505n 1.7v 959.495n 1.7v 959.505n 0.0v 969.495n 0.0v 969.505n 0.0v 979.495n 0.0v 979.505n 0.0v 989.495n 0.0v 989.505n 0.0v 999.495n 0.0v 999.505n 0.0v 1009.495n 0.0v 1009.505n 1.7v 1019.495n 1.7v 1019.505n 0.0v 1029.495n 0.0v 1029.505n 0.0v 1039.495n 0.0v 1039.505n 0.0v 1049.495n 0.0v 1049.505n 0.0v 1059.495n 0.0v 1059.505n 0.0v 1069.495n 0.0v 1069.505n 1.7v 1079.495n 1.7v 1079.505n 1.7v 1089.495n 1.7v 1089.505n 1.7v 1099.495n 1.7v 1099.505n 0.0v 1109.495n 0.0v 1109.505n 0.0v 1119.495n 0.0v 1119.505n 0.0v 1129.495n 0.0v 1129.505n 0.0v 1139.495n 0.0v 1139.505n 1.7v 1149.495n 1.7v 1149.505n 0.0v 1159.495n 0.0v 1159.505n 0.0v 1169.495n 0.0v 1169.505n 0.0v 1179.495n 0.0v 1179.505n 0.0v 1189.495n 0.0v 1189.505n 0.0v 1199.495n 0.0v 1199.505n 0.0v 1209.495n 0.0v 1209.505n 0.0v 1219.495n 0.0v 1219.505n 0.0v 1229.495n 0.0v 1229.505n 0.0v 1239.495n 0.0v 1239.505n 0.0v 1249.495n 0.0v 1249.505n 0.0v 1259.495n 0.0v 1259.505n 0.0v 1269.495n 0.0v 1269.505n 0.0v 1279.495n 0.0v 1279.505n 0.0v 1289.495n 0.0v 1289.505n 1.7v 1299.495n 1.7v 1299.505n 0.0v 1309.495n 0.0v 1309.505n 0.0v 1319.495n 0.0v 1319.505n 0.0v 1329.495n 0.0v 1329.505n 0.0v 1339.495n 0.0v 1339.505n 0.0v 1349.495n 0.0v 1349.505n 0.0v 1359.495n 0.0v 1359.505n 0.0v 1369.495n 0.0v 1369.505n 1.7v 1379.495n 1.7v 1379.505n 1.7v 1389.495n 1.7v 1389.505n 1.7v 1399.495n 1.7v 1399.505n 1.7v 1409.495n 1.7v 1409.505n 1.7v 1419.495n 1.7v 1419.505n 1.7v 1429.495n 1.7v 1429.505n 1.7v 1439.495n 1.7v 1439.505n 1.7v 1449.495n 1.7v 1449.505n 1.7v 1459.495n 1.7v 1459.505n 1.7v 1469.495n 1.7v 1469.505n 1.7v 1479.495n 1.7v 1479.505n 1.7v 1489.495n 1.7v 1489.505n 1.7v 1499.495n 1.7v 1499.505n 1.7v 1509.495n 1.7v 1509.505n 0.0v 1519.495n 0.0v 1519.505n 0.0v 1529.495n 0.0v 1529.505n 0.0v 1539.495n 0.0v 1539.505n 0.0v 1549.495n 0.0v 1549.505n 0.0v 1559.495n 0.0v 1559.505n 1.7v 1569.495n 1.7v 1569.505n 1.7v 1579.495n 1.7v 1579.505n 0.0v 1589.495n 0.0v 1589.505n 0.0v 1599.495n 0.0v 1599.505n 0.0v 1609.495n 0.0v 1609.505n 0.0v 1619.495n 0.0v 1619.505n 1.7v 1629.495n 1.7v 1629.505n 1.7v 1639.495n 1.7v 1639.505n 1.7v 1649.495n 1.7v 1649.505n 0.0v 1659.495n 0.0v 1659.505n 1.7v 1669.495n 1.7v 1669.505n 1.7v 1679.495n 1.7v 1679.505n 1.7v 1689.495n 1.7v 1689.505n 1.7v 1699.495n 1.7v 1699.505n 1.7v 1709.495n 1.7v 1709.505n 0.0v 1719.495n 0.0v 1719.505n 0.0v 1729.495n 0.0v 1729.505n 1.7v 1739.495n 1.7v 1739.505n 1.7v 1749.495n 1.7v 1749.505n 1.7v 1759.495n 1.7v 1759.505n 1.7v 1769.495n 1.7v 1769.505n 0.0v 1779.495n 0.0v 1779.505n 1.7v 1789.495n 1.7v 1789.505n 1.7v 1799.495n 1.7v 1799.505n 0.0v 1809.495n 0.0v 1809.505n 0.0v 1819.495n 0.0v 1819.505n 0.0v 1829.495n 0.0v 1829.505n 0.0v 1839.495n 0.0v 1839.505n 1.7v 1849.495n 1.7v 1849.505n 1.7v 1859.495n 1.7v 1859.505n 0.0v 1869.495n 0.0v 1869.505n 0.0v 1879.495n 0.0v 1879.505n 0.0v 1889.495n 0.0v 1889.505n 0.0v 1899.495n 0.0v 1899.505n 0.0v 1909.495n 0.0v 1909.505n 1.7v 1919.495n 1.7v 1919.505n 1.7v 1929.495n 1.7v 1929.505n 1.7v 1939.495n 1.7v 1939.505n 0.0v 1949.495n 0.0v 1949.505n 0.0v 1959.495n 0.0v 1959.505n 0.0v 1969.495n 0.0v 1969.505n 0.0v 1979.495n 0.0v 1979.505n 0.0v 1989.495n 0.0v 1989.505n 0.0v 1999.495n 0.0v 1999.505n 0.0v 2009.495n 0.0v 2009.505n 0.0v 2019.495n 0.0v 2019.505n 1.7v 2029.495n 1.7v 2029.505n 1.7v 2039.495n 1.7v 2039.505n 1.7v 2049.495n 1.7v 2049.505n 1.7v )
* (time, data): [(0, 0), (10, 0), (20, 1), (30, 0), (40, 0), (50, 0), (60, 0), (70, 0), (80, 0), (90, 1), (100, 1), (110, 1), (120, 1), (130, 1), (140, 1), (150, 1), (160, 1), (170, 1), (180, 1), (190, 1), (200, 0), (210, 0), (220, 0), (230, 0), (240, 0), (250, 0), (260, 0), (270, 0), (280, 1), (290, 1), (300, 1), (310, 0), (320, 1), (330, 1), (340, 1), (350, 1), (360, 1), (370, 1), (380, 1), (390, 1), (400, 1), (410, 1), (420, 0), (430, 0), (440, 0), (450, 0), (460, 0), (470, 1), (480, 1), (490, 1), (500, 1), (510, 1), (520, 1), (530, 1), (540, 1), (550, 0), (560, 0), (570, 0), (580, 0), (590, 0), (600, 1), (610, 1), (620, 1), (630, 0), (640, 0), (650, 0), (660, 0), (670, 1), (680, 0), (690, 0), (700, 1), (710, 0), (720, 0), (730, 0), (740, 0), (750, 0), (760, 0), (770, 1), (780, 1), (790, 0), (800, 0), (810, 0), (820, 1), (830, 1), (840, 0), (850, 0), (860, 1), (870, 1), (880, 1), (890, 1), (900, 0), (910, 0), (920, 0), (930, 0), (940, 0), (950, 0), (960, 1), (970, 1), (980, 1), (990, 1), (1000, 0), (1010, 0), (1020, 1), (1030, 0), (1040, 0), (1050, 0), (1060, 0), (1070, 0), (1080, 1), (1090, 0), (1100, 0), (1110, 1), (1120, 1), (1130, 1), (1140, 0), (1150, 0), (1160, 0), (1170, 1), (1180, 1), (1190, 1), (1200, 1), (1210, 1), (1220, 1), (1230, 0), (1240, 0), (1250, 0), (1260, 0), (1270, 0), (1280, 0), (1290, 1), (1300, 1), (1310, 1), (1320, 1), (1330, 1), (1340, 0), (1350, 0), (1360, 1), (1370, 1), (1380, 1), (1390, 1), (1400, 0), (1410, 0), (1420, 0), (1430, 0), (1440, 0), (1450, 0), (1460, 0), (1470, 0), (1480, 1), (1490, 1), (1500, 1), (1510, 0), (1520, 0), (1530, 0), (1540, 0), (1550, 0), (1560, 0), (1570, 0), (1580, 1), (1590, 1), (1600, 1), (1610, 1), (1620, 0), (1630, 0), (1640, 0), (1650, 1), (1660, 1), (1670, 1), (1680, 1), (1690, 1), (1700, 1), (1710, 1), (1720, 1), (1730, 0), (1740, 0), (1750, 0), (1760, 0), (1770, 0), (1780, 1), (1790, 1), (1800, 0), (1810, 0), (1820, 0), (1830, 0), (1840, 1), (1850, 1), (1860, 0), (1870, 0), (1880, 0), (1890, 0), (1900, 0), (1910, 0), (1920, 0), (1930, 1), (1940, 1), (1950, 1), (1960, 1), (1970, 0), (1980, 1), (1990, 1), (2000, 0), (2010, 1), (2020, 0), (2030, 0), (2040, 0), (2050, 0)]
Vdin0_30  din0_30  0 PWL (0n 0.0v 9.495n 0.0v 9.505n 0.0v 19.495n 0.0v 19.505n 1.7v 29.495n 1.7v 29.505n 0.0v 39.495n 0.0v 39.505n 0.0v 49.495n 0.0v 49.505n 0.0v 59.495n 0.0v 59.505n 0.0v 69.495n 0.0v 69.505n 0.0v 79.495n 0.0v 79.505n 0.0v 89.495n 0.0v 89.505n 1.7v 99.495n 1.7v 99.505n 1.7v 109.495n 1.7v 109.505n 1.7v 119.495n 1.7v 119.505n 1.7v 129.495n 1.7v 129.505n 1.7v 139.495n 1.7v 139.505n 1.7v 149.495n 1.7v 149.505n 1.7v 159.495n 1.7v 159.505n 1.7v 169.495n 1.7v 169.505n 1.7v 179.495n 1.7v 179.505n 1.7v 189.495n 1.7v 189.505n 1.7v 199.495n 1.7v 199.505n 0.0v 209.495n 0.0v 209.505n 0.0v 219.495n 0.0v 219.505n 0.0v 229.495n 0.0v 229.505n 0.0v 239.495n 0.0v 239.505n 0.0v 249.495n 0.0v 249.505n 0.0v 259.495n 0.0v 259.505n 0.0v 269.495n 0.0v 269.505n 0.0v 279.495n 0.0v 279.505n 1.7v 289.495n 1.7v 289.505n 1.7v 299.495n 1.7v 299.505n 1.7v 309.495n 1.7v 309.505n 0.0v 319.495n 0.0v 319.505n 1.7v 329.495n 1.7v 329.505n 1.7v 339.495n 1.7v 339.505n 1.7v 349.495n 1.7v 349.505n 1.7v 359.495n 1.7v 359.505n 1.7v 369.495n 1.7v 369.505n 1.7v 379.495n 1.7v 379.505n 1.7v 389.495n 1.7v 389.505n 1.7v 399.495n 1.7v 399.505n 1.7v 409.495n 1.7v 409.505n 1.7v 419.495n 1.7v 419.505n 0.0v 429.495n 0.0v 429.505n 0.0v 439.495n 0.0v 439.505n 0.0v 449.495n 0.0v 449.505n 0.0v 459.495n 0.0v 459.505n 0.0v 469.495n 0.0v 469.505n 1.7v 479.495n 1.7v 479.505n 1.7v 489.495n 1.7v 489.505n 1.7v 499.495n 1.7v 499.505n 1.7v 509.495n 1.7v 509.505n 1.7v 519.495n 1.7v 519.505n 1.7v 529.495n 1.7v 529.505n 1.7v 539.495n 1.7v 539.505n 1.7v 549.495n 1.7v 549.505n 0.0v 559.495n 0.0v 559.505n 0.0v 569.495n 0.0v 569.505n 0.0v 579.495n 0.0v 579.505n 0.0v 589.495n 0.0v 589.505n 0.0v 599.495n 0.0v 599.505n 1.7v 609.495n 1.7v 609.505n 1.7v 619.495n 1.7v 619.505n 1.7v 629.495n 1.7v 629.505n 0.0v 639.495n 0.0v 639.505n 0.0v 649.495n 0.0v 649.505n 0.0v 659.495n 0.0v 659.505n 0.0v 669.495n 0.0v 669.505n 1.7v 679.495n 1.7v 679.505n 0.0v 689.495n 0.0v 689.505n 0.0v 699.495n 0.0v 699.505n 1.7v 709.495n 1.7v 709.505n 0.0v 719.495n 0.0v 719.505n 0.0v 729.495n 0.0v 729.505n 0.0v 739.495n 0.0v 739.505n 0.0v 749.495n 0.0v 749.505n 0.0v 759.495n 0.0v 759.505n 0.0v 769.495n 0.0v 769.505n 1.7v 779.495n 1.7v 779.505n 1.7v 789.495n 1.7v 789.505n 0.0v 799.495n 0.0v 799.505n 0.0v 809.495n 0.0v 809.505n 0.0v 819.495n 0.0v 819.505n 1.7v 829.495n 1.7v 829.505n 1.7v 839.495n 1.7v 839.505n 0.0v 849.495n 0.0v 849.505n 0.0v 859.495n 0.0v 859.505n 1.7v 869.495n 1.7v 869.505n 1.7v 879.495n 1.7v 879.505n 1.7v 889.495n 1.7v 889.505n 1.7v 899.495n 1.7v 899.505n 0.0v 909.495n 0.0v 909.505n 0.0v 919.495n 0.0v 919.505n 0.0v 929.495n 0.0v 929.505n 0.0v 939.495n 0.0v 939.505n 0.0v 949.495n 0.0v 949.505n 0.0v 959.495n 0.0v 959.505n 1.7v 969.495n 1.7v 969.505n 1.7v 979.495n 1.7v 979.505n 1.7v 989.495n 1.7v 989.505n 1.7v 999.495n 1.7v 999.505n 0.0v 1009.495n 0.0v 1009.505n 0.0v 1019.495n 0.0v 1019.505n 1.7v 1029.495n 1.7v 1029.505n 0.0v 1039.495n 0.0v 1039.505n 0.0v 1049.495n 0.0v 1049.505n 0.0v 1059.495n 0.0v 1059.505n 0.0v 1069.495n 0.0v 1069.505n 0.0v 1079.495n 0.0v 1079.505n 1.7v 1089.495n 1.7v 1089.505n 0.0v 1099.495n 0.0v 1099.505n 0.0v 1109.495n 0.0v 1109.505n 1.7v 1119.495n 1.7v 1119.505n 1.7v 1129.495n 1.7v 1129.505n 1.7v 1139.495n 1.7v 1139.505n 0.0v 1149.495n 0.0v 1149.505n 0.0v 1159.495n 0.0v 1159.505n 0.0v 1169.495n 0.0v 1169.505n 1.7v 1179.495n 1.7v 1179.505n 1.7v 1189.495n 1.7v 1189.505n 1.7v 1199.495n 1.7v 1199.505n 1.7v 1209.495n 1.7v 1209.505n 1.7v 1219.495n 1.7v 1219.505n 1.7v 1229.495n 1.7v 1229.505n 0.0v 1239.495n 0.0v 1239.505n 0.0v 1249.495n 0.0v 1249.505n 0.0v 1259.495n 0.0v 1259.505n 0.0v 1269.495n 0.0v 1269.505n 0.0v 1279.495n 0.0v 1279.505n 0.0v 1289.495n 0.0v 1289.505n 1.7v 1299.495n 1.7v 1299.505n 1.7v 1309.495n 1.7v 1309.505n 1.7v 1319.495n 1.7v 1319.505n 1.7v 1329.495n 1.7v 1329.505n 1.7v 1339.495n 1.7v 1339.505n 0.0v 1349.495n 0.0v 1349.505n 0.0v 1359.495n 0.0v 1359.505n 1.7v 1369.495n 1.7v 1369.505n 1.7v 1379.495n 1.7v 1379.505n 1.7v 1389.495n 1.7v 1389.505n 1.7v 1399.495n 1.7v 1399.505n 0.0v 1409.495n 0.0v 1409.505n 0.0v 1419.495n 0.0v 1419.505n 0.0v 1429.495n 0.0v 1429.505n 0.0v 1439.495n 0.0v 1439.505n 0.0v 1449.495n 0.0v 1449.505n 0.0v 1459.495n 0.0v 1459.505n 0.0v 1469.495n 0.0v 1469.505n 0.0v 1479.495n 0.0v 1479.505n 1.7v 1489.495n 1.7v 1489.505n 1.7v 1499.495n 1.7v 1499.505n 1.7v 1509.495n 1.7v 1509.505n 0.0v 1519.495n 0.0v 1519.505n 0.0v 1529.495n 0.0v 1529.505n 0.0v 1539.495n 0.0v 1539.505n 0.0v 1549.495n 0.0v 1549.505n 0.0v 1559.495n 0.0v 1559.505n 0.0v 1569.495n 0.0v 1569.505n 0.0v 1579.495n 0.0v 1579.505n 1.7v 1589.495n 1.7v 1589.505n 1.7v 1599.495n 1.7v 1599.505n 1.7v 1609.495n 1.7v 1609.505n 1.7v 1619.495n 1.7v 1619.505n 0.0v 1629.495n 0.0v 1629.505n 0.0v 1639.495n 0.0v 1639.505n 0.0v 1649.495n 0.0v 1649.505n 1.7v 1659.495n 1.7v 1659.505n 1.7v 1669.495n 1.7v 1669.505n 1.7v 1679.495n 1.7v 1679.505n 1.7v 1689.495n 1.7v 1689.505n 1.7v 1699.495n 1.7v 1699.505n 1.7v 1709.495n 1.7v 1709.505n 1.7v 1719.495n 1.7v 1719.505n 1.7v 1729.495n 1.7v 1729.505n 0.0v 1739.495n 0.0v 1739.505n 0.0v 1749.495n 0.0v 1749.505n 0.0v 1759.495n 0.0v 1759.505n 0.0v 1769.495n 0.0v 1769.505n 0.0v 1779.495n 0.0v 1779.505n 1.7v 1789.495n 1.7v 1789.505n 1.7v 1799.495n 1.7v 1799.505n 0.0v 1809.495n 0.0v 1809.505n 0.0v 1819.495n 0.0v 1819.505n 0.0v 1829.495n 0.0v 1829.505n 0.0v 1839.495n 0.0v 1839.505n 1.7v 1849.495n 1.7v 1849.505n 1.7v 1859.495n 1.7v 1859.505n 0.0v 1869.495n 0.0v 1869.505n 0.0v 1879.495n 0.0v 1879.505n 0.0v 1889.495n 0.0v 1889.505n 0.0v 1899.495n 0.0v 1899.505n 0.0v 1909.495n 0.0v 1909.505n 0.0v 1919.495n 0.0v 1919.505n 0.0v 1929.495n 0.0v 1929.505n 1.7v 1939.495n 1.7v 1939.505n 1.7v 1949.495n 1.7v 1949.505n 1.7v 1959.495n 1.7v 1959.505n 1.7v 1969.495n 1.7v 1969.505n 0.0v 1979.495n 0.0v 1979.505n 1.7v 1989.495n 1.7v 1989.505n 1.7v 1999.495n 1.7v 1999.505n 0.0v 2009.495n 0.0v 2009.505n 1.7v 2019.495n 1.7v 2019.505n 0.0v 2029.495n 0.0v 2029.505n 0.0v 2039.495n 0.0v 2039.505n 0.0v 2049.495n 0.0v 2049.505n 0.0v )
* (time, data): [(0, 0), (10, 0), (20, 1), (30, 0), (40, 0), (50, 0), (60, 1), (70, 1), (80, 1), (90, 0), (100, 1), (110, 0), (120, 0), (130, 0), (140, 0), (150, 1), (160, 1), (170, 1), (180, 1), (190, 0), (200, 1), (210, 0), (220, 0), (230, 0), (240, 0), (250, 0), (260, 0), (270, 0), (280, 0), (290, 0), (300, 0), (310, 0), (320, 1), (330, 1), (340, 1), (350, 1), (360, 1), (370, 1), (380, 1), (390, 1), (400, 1), (410, 1), (420, 0), (430, 0), (440, 1), (450, 1), (460, 1), (470, 1), (480, 1), (490, 1), (500, 0), (510, 0), (520, 1), (530, 1), (540, 1), (550, 1), (560, 1), (570, 1), (580, 1), (590, 1), (600, 0), (610, 0), (620, 0), (630, 1), (640, 1), (650, 1), (660, 1), (670, 0), (680, 0), (690, 0), (700, 1), (710, 0), (720, 0), (730, 0), (740, 1), (750, 1), (760, 1), (770, 1), (780, 0), (790, 1), (800, 1), (810, 1), (820, 0), (830, 0), (840, 1), (850, 1), (860, 1), (870, 0), (880, 1), (890, 1), (900, 1), (910, 1), (920, 0), (930, 0), (940, 0), (950, 0), (960, 1), (970, 1), (980, 0), (990, 1), (1000, 1), (1010, 1), (1020, 1), (1030, 0), (1040, 0), (1050, 0), (1060, 0), (1070, 1), (1080, 1), (1090, 0), (1100, 0), (1110, 1), (1120, 1), (1130, 1), (1140, 0), (1150, 1), (1160, 1), (1170, 0), (1180, 1), (1190, 1), (1200, 1), (1210, 1), (1220, 0), (1230, 0), (1240, 0), (1250, 1), (1260, 1), (1270, 1), (1280, 1), (1290, 1), (1300, 1), (1310, 1), (1320, 1), (1330, 1), (1340, 1), (1350, 1), (1360, 1), (1370, 0), (1380, 0), (1390, 0), (1400, 1), (1410, 1), (1420, 1), (1430, 1), (1440, 1), (1450, 1), (1460, 1), (1470, 1), (1480, 1), (1490, 1), (1500, 1), (1510, 0), (1520, 0), (1530, 0), (1540, 1), (1550, 0), (1560, 1), (1570, 1), (1580, 0), (1590, 0), (1600, 0), (1610, 0), (1620, 0), (1630, 0), (1640, 0), (1650, 0), (1660, 0), (1670, 0), (1680, 0), (1690, 0), (1700, 0), (1710, 0), (1720, 0), (1730, 1), (1740, 1), (1750, 1), (1760, 1), (1770, 1), (1780, 1), (1790, 1), (1800, 0), (1810, 0), (1820, 0), (1830, 0), (1840, 1), (1850, 1), (1860, 0), (1870, 0), (1880, 0), (1890, 0), (1900, 0), (1910, 1), (1920, 1), (1930, 0), (1940, 1), (1950, 1), (1960, 1), (1970, 0), (1980, 0), (1990, 0), (2000, 0), (2010, 1), (2020, 0), (2030, 0), (2040, 0), (2050, 0)]
Vdin0_31  din0_31  0 PWL (0n 0.0v 9.495n 0.0v 9.505n 0.0v 19.495n 0.0v 19.505n 1.7v 29.495n 1.7v 29.505n 0.0v 39.495n 0.0v 39.505n 0.0v 49.495n 0.0v 49.505n 0.0v 59.495n 0.0v 59.505n 1.7v 69.495n 1.7v 69.505n 1.7v 79.495n 1.7v 79.505n 1.7v 89.495n 1.7v 89.505n 0.0v 99.495n 0.0v 99.505n 1.7v 109.495n 1.7v 109.505n 0.0v 119.495n 0.0v 119.505n 0.0v 129.495n 0.0v 129.505n 0.0v 139.495n 0.0v 139.505n 0.0v 149.495n 0.0v 149.505n 1.7v 159.495n 1.7v 159.505n 1.7v 169.495n 1.7v 169.505n 1.7v 179.495n 1.7v 179.505n 1.7v 189.495n 1.7v 189.505n 0.0v 199.495n 0.0v 199.505n 1.7v 209.495n 1.7v 209.505n 0.0v 219.495n 0.0v 219.505n 0.0v 229.495n 0.0v 229.505n 0.0v 239.495n 0.0v 239.505n 0.0v 249.495n 0.0v 249.505n 0.0v 259.495n 0.0v 259.505n 0.0v 269.495n 0.0v 269.505n 0.0v 279.495n 0.0v 279.505n 0.0v 289.495n 0.0v 289.505n 0.0v 299.495n 0.0v 299.505n 0.0v 309.495n 0.0v 309.505n 0.0v 319.495n 0.0v 319.505n 1.7v 329.495n 1.7v 329.505n 1.7v 339.495n 1.7v 339.505n 1.7v 349.495n 1.7v 349.505n 1.7v 359.495n 1.7v 359.505n 1.7v 369.495n 1.7v 369.505n 1.7v 379.495n 1.7v 379.505n 1.7v 389.495n 1.7v 389.505n 1.7v 399.495n 1.7v 399.505n 1.7v 409.495n 1.7v 409.505n 1.7v 419.495n 1.7v 419.505n 0.0v 429.495n 0.0v 429.505n 0.0v 439.495n 0.0v 439.505n 1.7v 449.495n 1.7v 449.505n 1.7v 459.495n 1.7v 459.505n 1.7v 469.495n 1.7v 469.505n 1.7v 479.495n 1.7v 479.505n 1.7v 489.495n 1.7v 489.505n 1.7v 499.495n 1.7v 499.505n 0.0v 509.495n 0.0v 509.505n 0.0v 519.495n 0.0v 519.505n 1.7v 529.495n 1.7v 529.505n 1.7v 539.495n 1.7v 539.505n 1.7v 549.495n 1.7v 549.505n 1.7v 559.495n 1.7v 559.505n 1.7v 569.495n 1.7v 569.505n 1.7v 579.495n 1.7v 579.505n 1.7v 589.495n 1.7v 589.505n 1.7v 599.495n 1.7v 599.505n 0.0v 609.495n 0.0v 609.505n 0.0v 619.495n 0.0v 619.505n 0.0v 629.495n 0.0v 629.505n 1.7v 639.495n 1.7v 639.505n 1.7v 649.495n 1.7v 649.505n 1.7v 659.495n 1.7v 659.505n 1.7v 669.495n 1.7v 669.505n 0.0v 679.495n 0.0v 679.505n 0.0v 689.495n 0.0v 689.505n 0.0v 699.495n 0.0v 699.505n 1.7v 709.495n 1.7v 709.505n 0.0v 719.495n 0.0v 719.505n 0.0v 729.495n 0.0v 729.505n 0.0v 739.495n 0.0v 739.505n 1.7v 749.495n 1.7v 749.505n 1.7v 759.495n 1.7v 759.505n 1.7v 769.495n 1.7v 769.505n 1.7v 779.495n 1.7v 779.505n 0.0v 789.495n 0.0v 789.505n 1.7v 799.495n 1.7v 799.505n 1.7v 809.495n 1.7v 809.505n 1.7v 819.495n 1.7v 819.505n 0.0v 829.495n 0.0v 829.505n 0.0v 839.495n 0.0v 839.505n 1.7v 849.495n 1.7v 849.505n 1.7v 859.495n 1.7v 859.505n 1.7v 869.495n 1.7v 869.505n 0.0v 879.495n 0.0v 879.505n 1.7v 889.495n 1.7v 889.505n 1.7v 899.495n 1.7v 899.505n 1.7v 909.495n 1.7v 909.505n 1.7v 919.495n 1.7v 919.505n 0.0v 929.495n 0.0v 929.505n 0.0v 939.495n 0.0v 939.505n 0.0v 949.495n 0.0v 949.505n 0.0v 959.495n 0.0v 959.505n 1.7v 969.495n 1.7v 969.505n 1.7v 979.495n 1.7v 979.505n 0.0v 989.495n 0.0v 989.505n 1.7v 999.495n 1.7v 999.505n 1.7v 1009.495n 1.7v 1009.505n 1.7v 1019.495n 1.7v 1019.505n 1.7v 1029.495n 1.7v 1029.505n 0.0v 1039.495n 0.0v 1039.505n 0.0v 1049.495n 0.0v 1049.505n 0.0v 1059.495n 0.0v 1059.505n 0.0v 1069.495n 0.0v 1069.505n 1.7v 1079.495n 1.7v 1079.505n 1.7v 1089.495n 1.7v 1089.505n 0.0v 1099.495n 0.0v 1099.505n 0.0v 1109.495n 0.0v 1109.505n 1.7v 1119.495n 1.7v 1119.505n 1.7v 1129.495n 1.7v 1129.505n 1.7v 1139.495n 1.7v 1139.505n 0.0v 1149.495n 0.0v 1149.505n 1.7v 1159.495n 1.7v 1159.505n 1.7v 1169.495n 1.7v 1169.505n 0.0v 1179.495n 0.0v 1179.505n 1.7v 1189.495n 1.7v 1189.505n 1.7v 1199.495n 1.7v 1199.505n 1.7v 1209.495n 1.7v 1209.505n 1.7v 1219.495n 1.7v 1219.505n 0.0v 1229.495n 0.0v 1229.505n 0.0v 1239.495n 0.0v 1239.505n 0.0v 1249.495n 0.0v 1249.505n 1.7v 1259.495n 1.7v 1259.505n 1.7v 1269.495n 1.7v 1269.505n 1.7v 1279.495n 1.7v 1279.505n 1.7v 1289.495n 1.7v 1289.505n 1.7v 1299.495n 1.7v 1299.505n 1.7v 1309.495n 1.7v 1309.505n 1.7v 1319.495n 1.7v 1319.505n 1.7v 1329.495n 1.7v 1329.505n 1.7v 1339.495n 1.7v 1339.505n 1.7v 1349.495n 1.7v 1349.505n 1.7v 1359.495n 1.7v 1359.505n 1.7v 1369.495n 1.7v 1369.505n 0.0v 1379.495n 0.0v 1379.505n 0.0v 1389.495n 0.0v 1389.505n 0.0v 1399.495n 0.0v 1399.505n 1.7v 1409.495n 1.7v 1409.505n 1.7v 1419.495n 1.7v 1419.505n 1.7v 1429.495n 1.7v 1429.505n 1.7v 1439.495n 1.7v 1439.505n 1.7v 1449.495n 1.7v 1449.505n 1.7v 1459.495n 1.7v 1459.505n 1.7v 1469.495n 1.7v 1469.505n 1.7v 1479.495n 1.7v 1479.505n 1.7v 1489.495n 1.7v 1489.505n 1.7v 1499.495n 1.7v 1499.505n 1.7v 1509.495n 1.7v 1509.505n 0.0v 1519.495n 0.0v 1519.505n 0.0v 1529.495n 0.0v 1529.505n 0.0v 1539.495n 0.0v 1539.505n 1.7v 1549.495n 1.7v 1549.505n 0.0v 1559.495n 0.0v 1559.505n 1.7v 1569.495n 1.7v 1569.505n 1.7v 1579.495n 1.7v 1579.505n 0.0v 1589.495n 0.0v 1589.505n 0.0v 1599.495n 0.0v 1599.505n 0.0v 1609.495n 0.0v 1609.505n 0.0v 1619.495n 0.0v 1619.505n 0.0v 1629.495n 0.0v 1629.505n 0.0v 1639.495n 0.0v 1639.505n 0.0v 1649.495n 0.0v 1649.505n 0.0v 1659.495n 0.0v 1659.505n 0.0v 1669.495n 0.0v 1669.505n 0.0v 1679.495n 0.0v 1679.505n 0.0v 1689.495n 0.0v 1689.505n 0.0v 1699.495n 0.0v 1699.505n 0.0v 1709.495n 0.0v 1709.505n 0.0v 1719.495n 0.0v 1719.505n 0.0v 1729.495n 0.0v 1729.505n 1.7v 1739.495n 1.7v 1739.505n 1.7v 1749.495n 1.7v 1749.505n 1.7v 1759.495n 1.7v 1759.505n 1.7v 1769.495n 1.7v 1769.505n 1.7v 1779.495n 1.7v 1779.505n 1.7v 1789.495n 1.7v 1789.505n 1.7v 1799.495n 1.7v 1799.505n 0.0v 1809.495n 0.0v 1809.505n 0.0v 1819.495n 0.0v 1819.505n 0.0v 1829.495n 0.0v 1829.505n 0.0v 1839.495n 0.0v 1839.505n 1.7v 1849.495n 1.7v 1849.505n 1.7v 1859.495n 1.7v 1859.505n 0.0v 1869.495n 0.0v 1869.505n 0.0v 1879.495n 0.0v 1879.505n 0.0v 1889.495n 0.0v 1889.505n 0.0v 1899.495n 0.0v 1899.505n 0.0v 1909.495n 0.0v 1909.505n 1.7v 1919.495n 1.7v 1919.505n 1.7v 1929.495n 1.7v 1929.505n 0.0v 1939.495n 0.0v 1939.505n 1.7v 1949.495n 1.7v 1949.505n 1.7v 1959.495n 1.7v 1959.505n 1.7v 1969.495n 1.7v 1969.505n 0.0v 1979.495n 0.0v 1979.505n 0.0v 1989.495n 0.0v 1989.505n 0.0v 1999.495n 0.0v 1999.505n 0.0v 2009.495n 0.0v 2009.505n 1.7v 2019.495n 1.7v 2019.505n 0.0v 2029.495n 0.0v 2029.505n 0.0v 2039.495n 0.0v 2039.505n 0.0v 2049.495n 0.0v 2049.505n 0.0v )
* (time, data): [(0, 0), (10, 0), (20, 0), (30, 0), (40, 0), (50, 0), (60, 0), (70, 0), (80, 0), (90, 0), (100, 0), (110, 0), (120, 0), (130, 0), (140, 0), (150, 0), (160, 0), (170, 0), (180, 0), (190, 0), (200, 0), (210, 0), (220, 0), (230, 0), (240, 0), (250, 0), (260, 0), (270, 0), (280, 0), (290, 0), (300, 0), (310, 0), (320, 0), (330, 0), (340, 0), (350, 0), (360, 0), (370, 0), (380, 0), (390, 0), (400, 0), (410, 0), (420, 0), (430, 0), (440, 0), (450, 0), (460, 0), (470, 0), (480, 0), (490, 0), (500, 0), (510, 0), (520, 0), (530, 0), (540, 0), (550, 0), (560, 0), (570, 0), (580, 0), (590, 0), (600, 0), (610, 0), (620, 0), (630, 0), (640, 0), (650, 0), (660, 0), (670, 0), (680, 0), (690, 0), (700, 0), (710, 0), (720, 0), (730, 0), (740, 0), (750, 0), (760, 0), (770, 0), (780, 0), (790, 0), (800, 0), (810, 0), (820, 0), (830, 0), (840, 0), (850, 0), (860, 0), (870, 0), (880, 0), (890, 0), (900, 0), (910, 0), (920, 0), (930, 0), (940, 0), (950, 0), (960, 0), (970, 0), (980, 0), (990, 0), (1000, 0), (1010, 0), (1020, 0), (1030, 0), (1040, 0), (1050, 0), (1060, 0), (1070, 0), (1080, 0), (1090, 0), (1100, 0), (1110, 0), (1120, 0), (1130, 0), (1140, 0), (1150, 0), (1160, 0), (1170, 0), (1180, 0), (1190, 0), (1200, 0), (1210, 0), (1220, 0), (1230, 0), (1240, 0), (1250, 0), (1260, 0), (1270, 0), (1280, 0), (1290, 0), (1300, 0), (1310, 0), (1320, 0), (1330, 0), (1340, 0), (1350, 0), (1360, 0), (1370, 0), (1380, 0), (1390, 0), (1400, 0), (1410, 0), (1420, 0), (1430, 0), (1440, 0), (1450, 0), (1460, 0), (1470, 0), (1480, 0), (1490, 0), (1500, 0), (1510, 0), (1520, 0), (1530, 0), (1540, 0), (1550, 0), (1560, 0), (1570, 0), (1580, 0), (1590, 0), (1600, 0), (1610, 0), (1620, 0), (1630, 0), (1640, 0), (1650, 0), (1660, 0), (1670, 0), (1680, 0), (1690, 0), (1700, 0), (1710, 0), (1720, 0), (1730, 0), (1740, 0), (1750, 0), (1760, 0), (1770, 0), (1780, 0), (1790, 0), (1800, 0), (1810, 0), (1820, 0), (1830, 0), (1840, 0), (1850, 0), (1860, 0), (1870, 0), (1880, 0), (1890, 0), (1900, 0), (1910, 0), (1920, 0), (1930, 0), (1940, 0), (1950, 0), (1960, 0), (1970, 0), (1980, 0), (1990, 0), (2000, 0), (2010, 0), (2020, 0), (2030, 0), (2040, 0), (2050, 0)]
Vdin0_32  din0_32  0 PWL (0n 0.0v 9.495n 0.0v 9.505n 0.0v 19.495n 0.0v 19.505n 0.0v 29.495n 0.0v 29.505n 0.0v 39.495n 0.0v 39.505n 0.0v 49.495n 0.0v 49.505n 0.0v 59.495n 0.0v 59.505n 0.0v 69.495n 0.0v 69.505n 0.0v 79.495n 0.0v 79.505n 0.0v 89.495n 0.0v 89.505n 0.0v 99.495n 0.0v 99.505n 0.0v 109.495n 0.0v 109.505n 0.0v 119.495n 0.0v 119.505n 0.0v 129.495n 0.0v 129.505n 0.0v 139.495n 0.0v 139.505n 0.0v 149.495n 0.0v 149.505n 0.0v 159.495n 0.0v 159.505n 0.0v 169.495n 0.0v 169.505n 0.0v 179.495n 0.0v 179.505n 0.0v 189.495n 0.0v 189.505n 0.0v 199.495n 0.0v 199.505n 0.0v 209.495n 0.0v 209.505n 0.0v 219.495n 0.0v 219.505n 0.0v 229.495n 0.0v 229.505n 0.0v 239.495n 0.0v 239.505n 0.0v 249.495n 0.0v 249.505n 0.0v 259.495n 0.0v 259.505n 0.0v 269.495n 0.0v 269.505n 0.0v 279.495n 0.0v 279.505n 0.0v 289.495n 0.0v 289.505n 0.0v 299.495n 0.0v 299.505n 0.0v 309.495n 0.0v 309.505n 0.0v 319.495n 0.0v 319.505n 0.0v 329.495n 0.0v 329.505n 0.0v 339.495n 0.0v 339.505n 0.0v 349.495n 0.0v 349.505n 0.0v 359.495n 0.0v 359.505n 0.0v 369.495n 0.0v 369.505n 0.0v 379.495n 0.0v 379.505n 0.0v 389.495n 0.0v 389.505n 0.0v 399.495n 0.0v 399.505n 0.0v 409.495n 0.0v 409.505n 0.0v 419.495n 0.0v 419.505n 0.0v 429.495n 0.0v 429.505n 0.0v 439.495n 0.0v 439.505n 0.0v 449.495n 0.0v 449.505n 0.0v 459.495n 0.0v 459.505n 0.0v 469.495n 0.0v 469.505n 0.0v 479.495n 0.0v 479.505n 0.0v 489.495n 0.0v 489.505n 0.0v 499.495n 0.0v 499.505n 0.0v 509.495n 0.0v 509.505n 0.0v 519.495n 0.0v 519.505n 0.0v 529.495n 0.0v 529.505n 0.0v 539.495n 0.0v 539.505n 0.0v 549.495n 0.0v 549.505n 0.0v 559.495n 0.0v 559.505n 0.0v 569.495n 0.0v 569.505n 0.0v 579.495n 0.0v 579.505n 0.0v 589.495n 0.0v 589.505n 0.0v 599.495n 0.0v 599.505n 0.0v 609.495n 0.0v 609.505n 0.0v 619.495n 0.0v 619.505n 0.0v 629.495n 0.0v 629.505n 0.0v 639.495n 0.0v 639.505n 0.0v 649.495n 0.0v 649.505n 0.0v 659.495n 0.0v 659.505n 0.0v 669.495n 0.0v 669.505n 0.0v 679.495n 0.0v 679.505n 0.0v 689.495n 0.0v 689.505n 0.0v 699.495n 0.0v 699.505n 0.0v 709.495n 0.0v 709.505n 0.0v 719.495n 0.0v 719.505n 0.0v 729.495n 0.0v 729.505n 0.0v 739.495n 0.0v 739.505n 0.0v 749.495n 0.0v 749.505n 0.0v 759.495n 0.0v 759.505n 0.0v 769.495n 0.0v 769.505n 0.0v 779.495n 0.0v 779.505n 0.0v 789.495n 0.0v 789.505n 0.0v 799.495n 0.0v 799.505n 0.0v 809.495n 0.0v 809.505n 0.0v 819.495n 0.0v 819.505n 0.0v 829.495n 0.0v 829.505n 0.0v 839.495n 0.0v 839.505n 0.0v 849.495n 0.0v 849.505n 0.0v 859.495n 0.0v 859.505n 0.0v 869.495n 0.0v 869.505n 0.0v 879.495n 0.0v 879.505n 0.0v 889.495n 0.0v 889.505n 0.0v 899.495n 0.0v 899.505n 0.0v 909.495n 0.0v 909.505n 0.0v 919.495n 0.0v 919.505n 0.0v 929.495n 0.0v 929.505n 0.0v 939.495n 0.0v 939.505n 0.0v 949.495n 0.0v 949.505n 0.0v 959.495n 0.0v 959.505n 0.0v 969.495n 0.0v 969.505n 0.0v 979.495n 0.0v 979.505n 0.0v 989.495n 0.0v 989.505n 0.0v 999.495n 0.0v 999.505n 0.0v 1009.495n 0.0v 1009.505n 0.0v 1019.495n 0.0v 1019.505n 0.0v 1029.495n 0.0v 1029.505n 0.0v 1039.495n 0.0v 1039.505n 0.0v 1049.495n 0.0v 1049.505n 0.0v 1059.495n 0.0v 1059.505n 0.0v 1069.495n 0.0v 1069.505n 0.0v 1079.495n 0.0v 1079.505n 0.0v 1089.495n 0.0v 1089.505n 0.0v 1099.495n 0.0v 1099.505n 0.0v 1109.495n 0.0v 1109.505n 0.0v 1119.495n 0.0v 1119.505n 0.0v 1129.495n 0.0v 1129.505n 0.0v 1139.495n 0.0v 1139.505n 0.0v 1149.495n 0.0v 1149.505n 0.0v 1159.495n 0.0v 1159.505n 0.0v 1169.495n 0.0v 1169.505n 0.0v 1179.495n 0.0v 1179.505n 0.0v 1189.495n 0.0v 1189.505n 0.0v 1199.495n 0.0v 1199.505n 0.0v 1209.495n 0.0v 1209.505n 0.0v 1219.495n 0.0v 1219.505n 0.0v 1229.495n 0.0v 1229.505n 0.0v 1239.495n 0.0v 1239.505n 0.0v 1249.495n 0.0v 1249.505n 0.0v 1259.495n 0.0v 1259.505n 0.0v 1269.495n 0.0v 1269.505n 0.0v 1279.495n 0.0v 1279.505n 0.0v 1289.495n 0.0v 1289.505n 0.0v 1299.495n 0.0v 1299.505n 0.0v 1309.495n 0.0v 1309.505n 0.0v 1319.495n 0.0v 1319.505n 0.0v 1329.495n 0.0v 1329.505n 0.0v 1339.495n 0.0v 1339.505n 0.0v 1349.495n 0.0v 1349.505n 0.0v 1359.495n 0.0v 1359.505n 0.0v 1369.495n 0.0v 1369.505n 0.0v 1379.495n 0.0v 1379.505n 0.0v 1389.495n 0.0v 1389.505n 0.0v 1399.495n 0.0v 1399.505n 0.0v 1409.495n 0.0v 1409.505n 0.0v 1419.495n 0.0v 1419.505n 0.0v 1429.495n 0.0v 1429.505n 0.0v 1439.495n 0.0v 1439.505n 0.0v 1449.495n 0.0v 1449.505n 0.0v 1459.495n 0.0v 1459.505n 0.0v 1469.495n 0.0v 1469.505n 0.0v 1479.495n 0.0v 1479.505n 0.0v 1489.495n 0.0v 1489.505n 0.0v 1499.495n 0.0v 1499.505n 0.0v 1509.495n 0.0v 1509.505n 0.0v 1519.495n 0.0v 1519.505n 0.0v 1529.495n 0.0v 1529.505n 0.0v 1539.495n 0.0v 1539.505n 0.0v 1549.495n 0.0v 1549.505n 0.0v 1559.495n 0.0v 1559.505n 0.0v 1569.495n 0.0v 1569.505n 0.0v 1579.495n 0.0v 1579.505n 0.0v 1589.495n 0.0v 1589.505n 0.0v 1599.495n 0.0v 1599.505n 0.0v 1609.495n 0.0v 1609.505n 0.0v 1619.495n 0.0v 1619.505n 0.0v 1629.495n 0.0v 1629.505n 0.0v 1639.495n 0.0v 1639.505n 0.0v 1649.495n 0.0v 1649.505n 0.0v 1659.495n 0.0v 1659.505n 0.0v 1669.495n 0.0v 1669.505n 0.0v 1679.495n 0.0v 1679.505n 0.0v 1689.495n 0.0v 1689.505n 0.0v 1699.495n 0.0v 1699.505n 0.0v 1709.495n 0.0v 1709.505n 0.0v 1719.495n 0.0v 1719.505n 0.0v 1729.495n 0.0v 1729.505n 0.0v 1739.495n 0.0v 1739.505n 0.0v 1749.495n 0.0v 1749.505n 0.0v 1759.495n 0.0v 1759.505n 0.0v 1769.495n 0.0v 1769.505n 0.0v 1779.495n 0.0v 1779.505n 0.0v 1789.495n 0.0v 1789.505n 0.0v 1799.495n 0.0v 1799.505n 0.0v 1809.495n 0.0v 1809.505n 0.0v 1819.495n 0.0v 1819.505n 0.0v 1829.495n 0.0v 1829.505n 0.0v 1839.495n 0.0v 1839.505n 0.0v 1849.495n 0.0v 1849.505n 0.0v 1859.495n 0.0v 1859.505n 0.0v 1869.495n 0.0v 1869.505n 0.0v 1879.495n 0.0v 1879.505n 0.0v 1889.495n 0.0v 1889.505n 0.0v 1899.495n 0.0v 1899.505n 0.0v 1909.495n 0.0v 1909.505n 0.0v 1919.495n 0.0v 1919.505n 0.0v 1929.495n 0.0v 1929.505n 0.0v 1939.495n 0.0v 1939.505n 0.0v 1949.495n 0.0v 1949.505n 0.0v 1959.495n 0.0v 1959.505n 0.0v 1969.495n 0.0v 1969.505n 0.0v 1979.495n 0.0v 1979.505n 0.0v 1989.495n 0.0v 1989.505n 0.0v 1999.495n 0.0v 1999.505n 0.0v 2009.495n 0.0v 2009.505n 0.0v 2019.495n 0.0v 2019.505n 0.0v 2029.495n 0.0v 2029.505n 0.0v 2039.495n 0.0v 2039.505n 0.0v 2049.495n 0.0v 2049.505n 0.0v )
* (time, data): [(0, 0), (10, 1), (20, 0), (30, 1), (40, 1), (50, 1), (60, 0), (70, 0), (80, 0), (90, 0), (100, 1), (110, 0), (120, 0), (130, 0), (140, 0), (150, 0), (160, 0), (170, 0), (180, 0), (190, 0), (200, 1), (210, 0), (220, 0), (230, 0), (240, 0), (250, 0), (260, 0), (270, 0), (280, 0), (290, 0), (300, 0), (310, 0), (320, 1), (330, 1), (340, 1), (350, 1), (360, 1), (370, 1), (380, 1), (390, 1), (400, 1), (410, 1), (420, 1), (430, 1), (440, 0), (450, 0), (460, 1), (470, 0), (480, 0), (490, 0), (500, 0), (510, 1), (520, 0), (530, 0), (540, 0), (550, 1), (560, 1), (570, 1), (580, 1), (590, 1), (600, 0), (610, 1), (620, 0), (630, 0), (640, 0), (650, 0), (660, 0), (670, 1), (680, 1), (690, 1), (700, 1), (710, 1), (720, 1), (730, 1), (740, 0), (750, 0), (760, 0), (770, 1), (780, 0), (790, 0), (800, 1), (810, 1), (820, 0), (830, 0), (840, 1), (850, 1), (860, 0), (870, 1), (880, 1), (890, 1), (900, 1), (910, 1), (920, 1), (930, 1), (940, 1), (950, 1), (960, 0), (970, 1), (980, 1), (990, 0), (1000, 1), (1010, 0), (1020, 0), (1030, 1), (1040, 1), (1050, 1), (1060, 1), (1070, 1), (1080, 1), (1090, 1), (1100, 0), (1110, 1), (1120, 1), (1130, 0), (1140, 1), (1150, 0), (1160, 0), (1170, 1), (1180, 0), (1190, 0), (1200, 0), (1210, 0), (1220, 1), (1230, 1), (1240, 0), (1250, 0), (1260, 0), (1270, 0), (1280, 0), (1290, 0), (1300, 0), (1310, 0), (1320, 0), (1330, 0), (1340, 1), (1350, 1), (1360, 1), (1370, 1), (1380, 1), (1390, 1), (1400, 0), (1410, 0), (1420, 0), (1430, 0), (1440, 0), (1450, 0), (1460, 0), (1470, 0), (1480, 0), (1490, 0), (1500, 0), (1510, 0), (1520, 0), (1530, 0), (1540, 1), (1550, 1), (1560, 1), (1570, 1), (1580, 0), (1590, 0), (1600, 0), (1610, 0), (1620, 0), (1630, 1), (1640, 1), (1650, 0), (1660, 0), (1670, 0), (1680, 0), (1690, 0), (1700, 0), (1710, 1), (1720, 1), (1730, 1), (1740, 1), (1750, 0), (1760, 0), (1770, 0), (1780, 0), (1790, 0), (1800, 0), (1810, 0), (1820, 0), (1830, 0), (1840, 1), (1850, 1), (1860, 1), (1870, 1), (1880, 1), (1890, 1), (1900, 1), (1910, 0), (1920, 0), (1930, 0), (1940, 0), (1950, 0), (1960, 0), (1970, 0), (1980, 0), (1990, 0), (2000, 0), (2010, 1), (2020, 1), (2030, 1), (2040, 1), (2050, 1)]
Va0_0  a0_0  0 PWL (0n 0.0v 9.495n 0.0v 9.505n 1.7v 19.495n 1.7v 19.505n 0.0v 29.495n 0.0v 29.505n 1.7v 39.495n 1.7v 39.505n 1.7v 49.495n 1.7v 49.505n 1.7v 59.495n 1.7v 59.505n 0.0v 69.495n 0.0v 69.505n 0.0v 79.495n 0.0v 79.505n 0.0v 89.495n 0.0v 89.505n 0.0v 99.495n 0.0v 99.505n 1.7v 109.495n 1.7v 109.505n 0.0v 119.495n 0.0v 119.505n 0.0v 129.495n 0.0v 129.505n 0.0v 139.495n 0.0v 139.505n 0.0v 149.495n 0.0v 149.505n 0.0v 159.495n 0.0v 159.505n 0.0v 169.495n 0.0v 169.505n 0.0v 179.495n 0.0v 179.505n 0.0v 189.495n 0.0v 189.505n 0.0v 199.495n 0.0v 199.505n 1.7v 209.495n 1.7v 209.505n 0.0v 219.495n 0.0v 219.505n 0.0v 229.495n 0.0v 229.505n 0.0v 239.495n 0.0v 239.505n 0.0v 249.495n 0.0v 249.505n 0.0v 259.495n 0.0v 259.505n 0.0v 269.495n 0.0v 269.505n 0.0v 279.495n 0.0v 279.505n 0.0v 289.495n 0.0v 289.505n 0.0v 299.495n 0.0v 299.505n 0.0v 309.495n 0.0v 309.505n 0.0v 319.495n 0.0v 319.505n 1.7v 329.495n 1.7v 329.505n 1.7v 339.495n 1.7v 339.505n 1.7v 349.495n 1.7v 349.505n 1.7v 359.495n 1.7v 359.505n 1.7v 369.495n 1.7v 369.505n 1.7v 379.495n 1.7v 379.505n 1.7v 389.495n 1.7v 389.505n 1.7v 399.495n 1.7v 399.505n 1.7v 409.495n 1.7v 409.505n 1.7v 419.495n 1.7v 419.505n 1.7v 429.495n 1.7v 429.505n 1.7v 439.495n 1.7v 439.505n 0.0v 449.495n 0.0v 449.505n 0.0v 459.495n 0.0v 459.505n 1.7v 469.495n 1.7v 469.505n 0.0v 479.495n 0.0v 479.505n 0.0v 489.495n 0.0v 489.505n 0.0v 499.495n 0.0v 499.505n 0.0v 509.495n 0.0v 509.505n 1.7v 519.495n 1.7v 519.505n 0.0v 529.495n 0.0v 529.505n 0.0v 539.495n 0.0v 539.505n 0.0v 549.495n 0.0v 549.505n 1.7v 559.495n 1.7v 559.505n 1.7v 569.495n 1.7v 569.505n 1.7v 579.495n 1.7v 579.505n 1.7v 589.495n 1.7v 589.505n 1.7v 599.495n 1.7v 599.505n 0.0v 609.495n 0.0v 609.505n 1.7v 619.495n 1.7v 619.505n 0.0v 629.495n 0.0v 629.505n 0.0v 639.495n 0.0v 639.505n 0.0v 649.495n 0.0v 649.505n 0.0v 659.495n 0.0v 659.505n 0.0v 669.495n 0.0v 669.505n 1.7v 679.495n 1.7v 679.505n 1.7v 689.495n 1.7v 689.505n 1.7v 699.495n 1.7v 699.505n 1.7v 709.495n 1.7v 709.505n 1.7v 719.495n 1.7v 719.505n 1.7v 729.495n 1.7v 729.505n 1.7v 739.495n 1.7v 739.505n 0.0v 749.495n 0.0v 749.505n 0.0v 759.495n 0.0v 759.505n 0.0v 769.495n 0.0v 769.505n 1.7v 779.495n 1.7v 779.505n 0.0v 789.495n 0.0v 789.505n 0.0v 799.495n 0.0v 799.505n 1.7v 809.495n 1.7v 809.505n 1.7v 819.495n 1.7v 819.505n 0.0v 829.495n 0.0v 829.505n 0.0v 839.495n 0.0v 839.505n 1.7v 849.495n 1.7v 849.505n 1.7v 859.495n 1.7v 859.505n 0.0v 869.495n 0.0v 869.505n 1.7v 879.495n 1.7v 879.505n 1.7v 889.495n 1.7v 889.505n 1.7v 899.495n 1.7v 899.505n 1.7v 909.495n 1.7v 909.505n 1.7v 919.495n 1.7v 919.505n 1.7v 929.495n 1.7v 929.505n 1.7v 939.495n 1.7v 939.505n 1.7v 949.495n 1.7v 949.505n 1.7v 959.495n 1.7v 959.505n 0.0v 969.495n 0.0v 969.505n 1.7v 979.495n 1.7v 979.505n 1.7v 989.495n 1.7v 989.505n 0.0v 999.495n 0.0v 999.505n 1.7v 1009.495n 1.7v 1009.505n 0.0v 1019.495n 0.0v 1019.505n 0.0v 1029.495n 0.0v 1029.505n 1.7v 1039.495n 1.7v 1039.505n 1.7v 1049.495n 1.7v 1049.505n 1.7v 1059.495n 1.7v 1059.505n 1.7v 1069.495n 1.7v 1069.505n 1.7v 1079.495n 1.7v 1079.505n 1.7v 1089.495n 1.7v 1089.505n 1.7v 1099.495n 1.7v 1099.505n 0.0v 1109.495n 0.0v 1109.505n 1.7v 1119.495n 1.7v 1119.505n 1.7v 1129.495n 1.7v 1129.505n 0.0v 1139.495n 0.0v 1139.505n 1.7v 1149.495n 1.7v 1149.505n 0.0v 1159.495n 0.0v 1159.505n 0.0v 1169.495n 0.0v 1169.505n 1.7v 1179.495n 1.7v 1179.505n 0.0v 1189.495n 0.0v 1189.505n 0.0v 1199.495n 0.0v 1199.505n 0.0v 1209.495n 0.0v 1209.505n 0.0v 1219.495n 0.0v 1219.505n 1.7v 1229.495n 1.7v 1229.505n 1.7v 1239.495n 1.7v 1239.505n 0.0v 1249.495n 0.0v 1249.505n 0.0v 1259.495n 0.0v 1259.505n 0.0v 1269.495n 0.0v 1269.505n 0.0v 1279.495n 0.0v 1279.505n 0.0v 1289.495n 0.0v 1289.505n 0.0v 1299.495n 0.0v 1299.505n 0.0v 1309.495n 0.0v 1309.505n 0.0v 1319.495n 0.0v 1319.505n 0.0v 1329.495n 0.0v 1329.505n 0.0v 1339.495n 0.0v 1339.505n 1.7v 1349.495n 1.7v 1349.505n 1.7v 1359.495n 1.7v 1359.505n 1.7v 1369.495n 1.7v 1369.505n 1.7v 1379.495n 1.7v 1379.505n 1.7v 1389.495n 1.7v 1389.505n 1.7v 1399.495n 1.7v 1399.505n 0.0v 1409.495n 0.0v 1409.505n 0.0v 1419.495n 0.0v 1419.505n 0.0v 1429.495n 0.0v 1429.505n 0.0v 1439.495n 0.0v 1439.505n 0.0v 1449.495n 0.0v 1449.505n 0.0v 1459.495n 0.0v 1459.505n 0.0v 1469.495n 0.0v 1469.505n 0.0v 1479.495n 0.0v 1479.505n 0.0v 1489.495n 0.0v 1489.505n 0.0v 1499.495n 0.0v 1499.505n 0.0v 1509.495n 0.0v 1509.505n 0.0v 1519.495n 0.0v 1519.505n 0.0v 1529.495n 0.0v 1529.505n 0.0v 1539.495n 0.0v 1539.505n 1.7v 1549.495n 1.7v 1549.505n 1.7v 1559.495n 1.7v 1559.505n 1.7v 1569.495n 1.7v 1569.505n 1.7v 1579.495n 1.7v 1579.505n 0.0v 1589.495n 0.0v 1589.505n 0.0v 1599.495n 0.0v 1599.505n 0.0v 1609.495n 0.0v 1609.505n 0.0v 1619.495n 0.0v 1619.505n 0.0v 1629.495n 0.0v 1629.505n 1.7v 1639.495n 1.7v 1639.505n 1.7v 1649.495n 1.7v 1649.505n 0.0v 1659.495n 0.0v 1659.505n 0.0v 1669.495n 0.0v 1669.505n 0.0v 1679.495n 0.0v 1679.505n 0.0v 1689.495n 0.0v 1689.505n 0.0v 1699.495n 0.0v 1699.505n 0.0v 1709.495n 0.0v 1709.505n 1.7v 1719.495n 1.7v 1719.505n 1.7v 1729.495n 1.7v 1729.505n 1.7v 1739.495n 1.7v 1739.505n 1.7v 1749.495n 1.7v 1749.505n 0.0v 1759.495n 0.0v 1759.505n 0.0v 1769.495n 0.0v 1769.505n 0.0v 1779.495n 0.0v 1779.505n 0.0v 1789.495n 0.0v 1789.505n 0.0v 1799.495n 0.0v 1799.505n 0.0v 1809.495n 0.0v 1809.505n 0.0v 1819.495n 0.0v 1819.505n 0.0v 1829.495n 0.0v 1829.505n 0.0v 1839.495n 0.0v 1839.505n 1.7v 1849.495n 1.7v 1849.505n 1.7v 1859.495n 1.7v 1859.505n 1.7v 1869.495n 1.7v 1869.505n 1.7v 1879.495n 1.7v 1879.505n 1.7v 1889.495n 1.7v 1889.505n 1.7v 1899.495n 1.7v 1899.505n 1.7v 1909.495n 1.7v 1909.505n 0.0v 1919.495n 0.0v 1919.505n 0.0v 1929.495n 0.0v 1929.505n 0.0v 1939.495n 0.0v 1939.505n 0.0v 1949.495n 0.0v 1949.505n 0.0v 1959.495n 0.0v 1959.505n 0.0v 1969.495n 0.0v 1969.505n 0.0v 1979.495n 0.0v 1979.505n 0.0v 1989.495n 0.0v 1989.505n 0.0v 1999.495n 0.0v 1999.505n 0.0v 2009.495n 0.0v 2009.505n 1.7v 2019.495n 1.7v 2019.505n 1.7v 2029.495n 1.7v 2029.505n 1.7v 2039.495n 1.7v 2039.505n 1.7v 2049.495n 1.7v 2049.505n 1.7v )
* (time, data): [(0, 0), (10, 1), (20, 0), (30, 0), (40, 0), (50, 0), (60, 0), (70, 0), (80, 0), (90, 0), (100, 1), (110, 0), (120, 0), (130, 0), (140, 0), (150, 0), (160, 0), (170, 0), (180, 0), (190, 0), (200, 0), (210, 0), (220, 0), (230, 0), (240, 0), (250, 0), (260, 0), (270, 0), (280, 0), (290, 0), (300, 0), (310, 0), (320, 0), (330, 0), (340, 0), (350, 0), (360, 0), (370, 0), (380, 0), (390, 0), (400, 0), (410, 0), (420, 0), (430, 0), (440, 0), (450, 0), (460, 0), (470, 0), (480, 0), (490, 0), (500, 0), (510, 0), (520, 0), (530, 0), (540, 0), (550, 1), (560, 1), (570, 1), (580, 1), (590, 1), (600, 0), (610, 0), (620, 0), (630, 0), (640, 0), (650, 0), (660, 0), (670, 0), (680, 0), (690, 0), (700, 0), (710, 0), (720, 0), (730, 0), (740, 0), (750, 0), (760, 0), (770, 0), (780, 0), (790, 0), (800, 1), (810, 1), (820, 0), (830, 0), (840, 0), (850, 0), (860, 0), (870, 0), (880, 0), (890, 0), (900, 0), (910, 0), (920, 0), (930, 0), (940, 0), (950, 0), (960, 0), (970, 1), (980, 1), (990, 0), (1000, 1), (1010, 0), (1020, 0), (1030, 0), (1040, 0), (1050, 0), (1060, 0), (1070, 1), (1080, 1), (1090, 1), (1100, 0), (1110, 1), (1120, 1), (1130, 0), (1140, 0), (1150, 0), (1160, 0), (1170, 0), (1180, 0), (1190, 0), (1200, 0), (1210, 0), (1220, 0), (1230, 0), (1240, 0), (1250, 0), (1260, 0), (1270, 0), (1280, 0), (1290, 0), (1300, 0), (1310, 0), (1320, 0), (1330, 0), (1340, 0), (1350, 0), (1360, 1), (1370, 0), (1380, 0), (1390, 0), (1400, 0), (1410, 0), (1420, 0), (1430, 0), (1440, 0), (1450, 0), (1460, 0), (1470, 0), (1480, 0), (1490, 0), (1500, 0), (1510, 0), (1520, 0), (1530, 0), (1540, 0), (1550, 0), (1560, 1), (1570, 1), (1580, 0), (1590, 0), (1600, 0), (1610, 0), (1620, 0), (1630, 1), (1640, 1), (1650, 0), (1660, 0), (1670, 0), (1680, 0), (1690, 0), (1700, 0), (1710, 0), (1720, 0), (1730, 0), (1740, 0), (1750, 0), (1760, 0), (1770, 0), (1780, 0), (1790, 0), (1800, 0), (1810, 0), (1820, 0), (1830, 0), (1840, 0), (1850, 0), (1860, 0), (1870, 0), (1880, 0), (1890, 0), (1900, 0), (1910, 0), (1920, 0), (1930, 0), (1940, 0), (1950, 0), (1960, 0), (1970, 0), (1980, 0), (1990, 0), (2000, 0), (2010, 1), (2020, 0), (2030, 0), (2040, 0), (2050, 0)]
Va0_1  a0_1  0 PWL (0n 0.0v 9.495n 0.0v 9.505n 1.7v 19.495n 1.7v 19.505n 0.0v 29.495n 0.0v 29.505n 0.0v 39.495n 0.0v 39.505n 0.0v 49.495n 0.0v 49.505n 0.0v 59.495n 0.0v 59.505n 0.0v 69.495n 0.0v 69.505n 0.0v 79.495n 0.0v 79.505n 0.0v 89.495n 0.0v 89.505n 0.0v 99.495n 0.0v 99.505n 1.7v 109.495n 1.7v 109.505n 0.0v 119.495n 0.0v 119.505n 0.0v 129.495n 0.0v 129.505n 0.0v 139.495n 0.0v 139.505n 0.0v 149.495n 0.0v 149.505n 0.0v 159.495n 0.0v 159.505n 0.0v 169.495n 0.0v 169.505n 0.0v 179.495n 0.0v 179.505n 0.0v 189.495n 0.0v 189.505n 0.0v 199.495n 0.0v 199.505n 0.0v 209.495n 0.0v 209.505n 0.0v 219.495n 0.0v 219.505n 0.0v 229.495n 0.0v 229.505n 0.0v 239.495n 0.0v 239.505n 0.0v 249.495n 0.0v 249.505n 0.0v 259.495n 0.0v 259.505n 0.0v 269.495n 0.0v 269.505n 0.0v 279.495n 0.0v 279.505n 0.0v 289.495n 0.0v 289.505n 0.0v 299.495n 0.0v 299.505n 0.0v 309.495n 0.0v 309.505n 0.0v 319.495n 0.0v 319.505n 0.0v 329.495n 0.0v 329.505n 0.0v 339.495n 0.0v 339.505n 0.0v 349.495n 0.0v 349.505n 0.0v 359.495n 0.0v 359.505n 0.0v 369.495n 0.0v 369.505n 0.0v 379.495n 0.0v 379.505n 0.0v 389.495n 0.0v 389.505n 0.0v 399.495n 0.0v 399.505n 0.0v 409.495n 0.0v 409.505n 0.0v 419.495n 0.0v 419.505n 0.0v 429.495n 0.0v 429.505n 0.0v 439.495n 0.0v 439.505n 0.0v 449.495n 0.0v 449.505n 0.0v 459.495n 0.0v 459.505n 0.0v 469.495n 0.0v 469.505n 0.0v 479.495n 0.0v 479.505n 0.0v 489.495n 0.0v 489.505n 0.0v 499.495n 0.0v 499.505n 0.0v 509.495n 0.0v 509.505n 0.0v 519.495n 0.0v 519.505n 0.0v 529.495n 0.0v 529.505n 0.0v 539.495n 0.0v 539.505n 0.0v 549.495n 0.0v 549.505n 1.7v 559.495n 1.7v 559.505n 1.7v 569.495n 1.7v 569.505n 1.7v 579.495n 1.7v 579.505n 1.7v 589.495n 1.7v 589.505n 1.7v 599.495n 1.7v 599.505n 0.0v 609.495n 0.0v 609.505n 0.0v 619.495n 0.0v 619.505n 0.0v 629.495n 0.0v 629.505n 0.0v 639.495n 0.0v 639.505n 0.0v 649.495n 0.0v 649.505n 0.0v 659.495n 0.0v 659.505n 0.0v 669.495n 0.0v 669.505n 0.0v 679.495n 0.0v 679.505n 0.0v 689.495n 0.0v 689.505n 0.0v 699.495n 0.0v 699.505n 0.0v 709.495n 0.0v 709.505n 0.0v 719.495n 0.0v 719.505n 0.0v 729.495n 0.0v 729.505n 0.0v 739.495n 0.0v 739.505n 0.0v 749.495n 0.0v 749.505n 0.0v 759.495n 0.0v 759.505n 0.0v 769.495n 0.0v 769.505n 0.0v 779.495n 0.0v 779.505n 0.0v 789.495n 0.0v 789.505n 0.0v 799.495n 0.0v 799.505n 1.7v 809.495n 1.7v 809.505n 1.7v 819.495n 1.7v 819.505n 0.0v 829.495n 0.0v 829.505n 0.0v 839.495n 0.0v 839.505n 0.0v 849.495n 0.0v 849.505n 0.0v 859.495n 0.0v 859.505n 0.0v 869.495n 0.0v 869.505n 0.0v 879.495n 0.0v 879.505n 0.0v 889.495n 0.0v 889.505n 0.0v 899.495n 0.0v 899.505n 0.0v 909.495n 0.0v 909.505n 0.0v 919.495n 0.0v 919.505n 0.0v 929.495n 0.0v 929.505n 0.0v 939.495n 0.0v 939.505n 0.0v 949.495n 0.0v 949.505n 0.0v 959.495n 0.0v 959.505n 0.0v 969.495n 0.0v 969.505n 1.7v 979.495n 1.7v 979.505n 1.7v 989.495n 1.7v 989.505n 0.0v 999.495n 0.0v 999.505n 1.7v 1009.495n 1.7v 1009.505n 0.0v 1019.495n 0.0v 1019.505n 0.0v 1029.495n 0.0v 1029.505n 0.0v 1039.495n 0.0v 1039.505n 0.0v 1049.495n 0.0v 1049.505n 0.0v 1059.495n 0.0v 1059.505n 0.0v 1069.495n 0.0v 1069.505n 1.7v 1079.495n 1.7v 1079.505n 1.7v 1089.495n 1.7v 1089.505n 1.7v 1099.495n 1.7v 1099.505n 0.0v 1109.495n 0.0v 1109.505n 1.7v 1119.495n 1.7v 1119.505n 1.7v 1129.495n 1.7v 1129.505n 0.0v 1139.495n 0.0v 1139.505n 0.0v 1149.495n 0.0v 1149.505n 0.0v 1159.495n 0.0v 1159.505n 0.0v 1169.495n 0.0v 1169.505n 0.0v 1179.495n 0.0v 1179.505n 0.0v 1189.495n 0.0v 1189.505n 0.0v 1199.495n 0.0v 1199.505n 0.0v 1209.495n 0.0v 1209.505n 0.0v 1219.495n 0.0v 1219.505n 0.0v 1229.495n 0.0v 1229.505n 0.0v 1239.495n 0.0v 1239.505n 0.0v 1249.495n 0.0v 1249.505n 0.0v 1259.495n 0.0v 1259.505n 0.0v 1269.495n 0.0v 1269.505n 0.0v 1279.495n 0.0v 1279.505n 0.0v 1289.495n 0.0v 1289.505n 0.0v 1299.495n 0.0v 1299.505n 0.0v 1309.495n 0.0v 1309.505n 0.0v 1319.495n 0.0v 1319.505n 0.0v 1329.495n 0.0v 1329.505n 0.0v 1339.495n 0.0v 1339.505n 0.0v 1349.495n 0.0v 1349.505n 0.0v 1359.495n 0.0v 1359.505n 1.7v 1369.495n 1.7v 1369.505n 0.0v 1379.495n 0.0v 1379.505n 0.0v 1389.495n 0.0v 1389.505n 0.0v 1399.495n 0.0v 1399.505n 0.0v 1409.495n 0.0v 1409.505n 0.0v 1419.495n 0.0v 1419.505n 0.0v 1429.495n 0.0v 1429.505n 0.0v 1439.495n 0.0v 1439.505n 0.0v 1449.495n 0.0v 1449.505n 0.0v 1459.495n 0.0v 1459.505n 0.0v 1469.495n 0.0v 1469.505n 0.0v 1479.495n 0.0v 1479.505n 0.0v 1489.495n 0.0v 1489.505n 0.0v 1499.495n 0.0v 1499.505n 0.0v 1509.495n 0.0v 1509.505n 0.0v 1519.495n 0.0v 1519.505n 0.0v 1529.495n 0.0v 1529.505n 0.0v 1539.495n 0.0v 1539.505n 0.0v 1549.495n 0.0v 1549.505n 0.0v 1559.495n 0.0v 1559.505n 1.7v 1569.495n 1.7v 1569.505n 1.7v 1579.495n 1.7v 1579.505n 0.0v 1589.495n 0.0v 1589.505n 0.0v 1599.495n 0.0v 1599.505n 0.0v 1609.495n 0.0v 1609.505n 0.0v 1619.495n 0.0v 1619.505n 0.0v 1629.495n 0.0v 1629.505n 1.7v 1639.495n 1.7v 1639.505n 1.7v 1649.495n 1.7v 1649.505n 0.0v 1659.495n 0.0v 1659.505n 0.0v 1669.495n 0.0v 1669.505n 0.0v 1679.495n 0.0v 1679.505n 0.0v 1689.495n 0.0v 1689.505n 0.0v 1699.495n 0.0v 1699.505n 0.0v 1709.495n 0.0v 1709.505n 0.0v 1719.495n 0.0v 1719.505n 0.0v 1729.495n 0.0v 1729.505n 0.0v 1739.495n 0.0v 1739.505n 0.0v 1749.495n 0.0v 1749.505n 0.0v 1759.495n 0.0v 1759.505n 0.0v 1769.495n 0.0v 1769.505n 0.0v 1779.495n 0.0v 1779.505n 0.0v 1789.495n 0.0v 1789.505n 0.0v 1799.495n 0.0v 1799.505n 0.0v 1809.495n 0.0v 1809.505n 0.0v 1819.495n 0.0v 1819.505n 0.0v 1829.495n 0.0v 1829.505n 0.0v 1839.495n 0.0v 1839.505n 0.0v 1849.495n 0.0v 1849.505n 0.0v 1859.495n 0.0v 1859.505n 0.0v 1869.495n 0.0v 1869.505n 0.0v 1879.495n 0.0v 1879.505n 0.0v 1889.495n 0.0v 1889.505n 0.0v 1899.495n 0.0v 1899.505n 0.0v 1909.495n 0.0v 1909.505n 0.0v 1919.495n 0.0v 1919.505n 0.0v 1929.495n 0.0v 1929.505n 0.0v 1939.495n 0.0v 1939.505n 0.0v 1949.495n 0.0v 1949.505n 0.0v 1959.495n 0.0v 1959.505n 0.0v 1969.495n 0.0v 1969.505n 0.0v 1979.495n 0.0v 1979.505n 0.0v 1989.495n 0.0v 1989.505n 0.0v 1999.495n 0.0v 1999.505n 0.0v 2009.495n 0.0v 2009.505n 1.7v 2019.495n 1.7v 2019.505n 0.0v 2029.495n 0.0v 2029.505n 0.0v 2039.495n 0.0v 2039.505n 0.0v 2049.495n 0.0v 2049.505n 0.0v )
* (time, data): [(0, 0), (10, 1), (20, 0), (30, 0), (40, 0), (50, 0), (60, 0), (70, 0), (80, 0), (90, 0), (100, 1), (110, 0), (120, 0), (130, 0), (140, 0), (150, 0), (160, 0), (170, 0), (180, 0), (190, 0), (200, 0), (210, 0), (220, 0), (230, 0), (240, 0), (250, 0), (260, 0), (270, 0), (280, 0), (290, 0), (300, 0), (310, 0), (320, 0), (330, 0), (340, 0), (350, 0), (360, 0), (370, 0), (380, 0), (390, 0), (400, 0), (410, 0), (420, 0), (430, 0), (440, 0), (450, 0), (460, 0), (470, 0), (480, 0), (490, 0), (500, 0), (510, 0), (520, 0), (530, 0), (540, 0), (550, 1), (560, 1), (570, 1), (580, 1), (590, 1), (600, 0), (610, 0), (620, 0), (630, 0), (640, 0), (650, 0), (660, 0), (670, 0), (680, 0), (690, 0), (700, 0), (710, 0), (720, 0), (730, 0), (740, 0), (750, 0), (760, 0), (770, 0), (780, 0), (790, 0), (800, 1), (810, 1), (820, 0), (830, 0), (840, 0), (850, 0), (860, 0), (870, 0), (880, 0), (890, 0), (900, 0), (910, 0), (920, 0), (930, 0), (940, 0), (950, 0), (960, 0), (970, 1), (980, 1), (990, 0), (1000, 1), (1010, 0), (1020, 0), (1030, 0), (1040, 0), (1050, 0), (1060, 0), (1070, 1), (1080, 1), (1090, 1), (1100, 0), (1110, 1), (1120, 1), (1130, 0), (1140, 0), (1150, 0), (1160, 0), (1170, 0), (1180, 0), (1190, 0), (1200, 0), (1210, 0), (1220, 0), (1230, 0), (1240, 0), (1250, 0), (1260, 0), (1270, 0), (1280, 0), (1290, 0), (1300, 0), (1310, 0), (1320, 0), (1330, 0), (1340, 0), (1350, 0), (1360, 1), (1370, 0), (1380, 0), (1390, 0), (1400, 0), (1410, 0), (1420, 0), (1430, 0), (1440, 0), (1450, 0), (1460, 0), (1470, 0), (1480, 0), (1490, 0), (1500, 0), (1510, 0), (1520, 0), (1530, 0), (1540, 0), (1550, 0), (1560, 1), (1570, 1), (1580, 0), (1590, 0), (1600, 0), (1610, 0), (1620, 0), (1630, 1), (1640, 1), (1650, 0), (1660, 0), (1670, 0), (1680, 0), (1690, 0), (1700, 0), (1710, 0), (1720, 0), (1730, 0), (1740, 0), (1750, 0), (1760, 0), (1770, 0), (1780, 0), (1790, 0), (1800, 0), (1810, 0), (1820, 0), (1830, 0), (1840, 0), (1850, 0), (1860, 0), (1870, 0), (1880, 0), (1890, 0), (1900, 0), (1910, 0), (1920, 0), (1930, 0), (1940, 0), (1950, 0), (1960, 0), (1970, 0), (1980, 0), (1990, 0), (2000, 0), (2010, 1), (2020, 0), (2030, 0), (2040, 0), (2050, 0)]
Va0_2  a0_2  0 PWL (0n 0.0v 9.495n 0.0v 9.505n 1.7v 19.495n 1.7v 19.505n 0.0v 29.495n 0.0v 29.505n 0.0v 39.495n 0.0v 39.505n 0.0v 49.495n 0.0v 49.505n 0.0v 59.495n 0.0v 59.505n 0.0v 69.495n 0.0v 69.505n 0.0v 79.495n 0.0v 79.505n 0.0v 89.495n 0.0v 89.505n 0.0v 99.495n 0.0v 99.505n 1.7v 109.495n 1.7v 109.505n 0.0v 119.495n 0.0v 119.505n 0.0v 129.495n 0.0v 129.505n 0.0v 139.495n 0.0v 139.505n 0.0v 149.495n 0.0v 149.505n 0.0v 159.495n 0.0v 159.505n 0.0v 169.495n 0.0v 169.505n 0.0v 179.495n 0.0v 179.505n 0.0v 189.495n 0.0v 189.505n 0.0v 199.495n 0.0v 199.505n 0.0v 209.495n 0.0v 209.505n 0.0v 219.495n 0.0v 219.505n 0.0v 229.495n 0.0v 229.505n 0.0v 239.495n 0.0v 239.505n 0.0v 249.495n 0.0v 249.505n 0.0v 259.495n 0.0v 259.505n 0.0v 269.495n 0.0v 269.505n 0.0v 279.495n 0.0v 279.505n 0.0v 289.495n 0.0v 289.505n 0.0v 299.495n 0.0v 299.505n 0.0v 309.495n 0.0v 309.505n 0.0v 319.495n 0.0v 319.505n 0.0v 329.495n 0.0v 329.505n 0.0v 339.495n 0.0v 339.505n 0.0v 349.495n 0.0v 349.505n 0.0v 359.495n 0.0v 359.505n 0.0v 369.495n 0.0v 369.505n 0.0v 379.495n 0.0v 379.505n 0.0v 389.495n 0.0v 389.505n 0.0v 399.495n 0.0v 399.505n 0.0v 409.495n 0.0v 409.505n 0.0v 419.495n 0.0v 419.505n 0.0v 429.495n 0.0v 429.505n 0.0v 439.495n 0.0v 439.505n 0.0v 449.495n 0.0v 449.505n 0.0v 459.495n 0.0v 459.505n 0.0v 469.495n 0.0v 469.505n 0.0v 479.495n 0.0v 479.505n 0.0v 489.495n 0.0v 489.505n 0.0v 499.495n 0.0v 499.505n 0.0v 509.495n 0.0v 509.505n 0.0v 519.495n 0.0v 519.505n 0.0v 529.495n 0.0v 529.505n 0.0v 539.495n 0.0v 539.505n 0.0v 549.495n 0.0v 549.505n 1.7v 559.495n 1.7v 559.505n 1.7v 569.495n 1.7v 569.505n 1.7v 579.495n 1.7v 579.505n 1.7v 589.495n 1.7v 589.505n 1.7v 599.495n 1.7v 599.505n 0.0v 609.495n 0.0v 609.505n 0.0v 619.495n 0.0v 619.505n 0.0v 629.495n 0.0v 629.505n 0.0v 639.495n 0.0v 639.505n 0.0v 649.495n 0.0v 649.505n 0.0v 659.495n 0.0v 659.505n 0.0v 669.495n 0.0v 669.505n 0.0v 679.495n 0.0v 679.505n 0.0v 689.495n 0.0v 689.505n 0.0v 699.495n 0.0v 699.505n 0.0v 709.495n 0.0v 709.505n 0.0v 719.495n 0.0v 719.505n 0.0v 729.495n 0.0v 729.505n 0.0v 739.495n 0.0v 739.505n 0.0v 749.495n 0.0v 749.505n 0.0v 759.495n 0.0v 759.505n 0.0v 769.495n 0.0v 769.505n 0.0v 779.495n 0.0v 779.505n 0.0v 789.495n 0.0v 789.505n 0.0v 799.495n 0.0v 799.505n 1.7v 809.495n 1.7v 809.505n 1.7v 819.495n 1.7v 819.505n 0.0v 829.495n 0.0v 829.505n 0.0v 839.495n 0.0v 839.505n 0.0v 849.495n 0.0v 849.505n 0.0v 859.495n 0.0v 859.505n 0.0v 869.495n 0.0v 869.505n 0.0v 879.495n 0.0v 879.505n 0.0v 889.495n 0.0v 889.505n 0.0v 899.495n 0.0v 899.505n 0.0v 909.495n 0.0v 909.505n 0.0v 919.495n 0.0v 919.505n 0.0v 929.495n 0.0v 929.505n 0.0v 939.495n 0.0v 939.505n 0.0v 949.495n 0.0v 949.505n 0.0v 959.495n 0.0v 959.505n 0.0v 969.495n 0.0v 969.505n 1.7v 979.495n 1.7v 979.505n 1.7v 989.495n 1.7v 989.505n 0.0v 999.495n 0.0v 999.505n 1.7v 1009.495n 1.7v 1009.505n 0.0v 1019.495n 0.0v 1019.505n 0.0v 1029.495n 0.0v 1029.505n 0.0v 1039.495n 0.0v 1039.505n 0.0v 1049.495n 0.0v 1049.505n 0.0v 1059.495n 0.0v 1059.505n 0.0v 1069.495n 0.0v 1069.505n 1.7v 1079.495n 1.7v 1079.505n 1.7v 1089.495n 1.7v 1089.505n 1.7v 1099.495n 1.7v 1099.505n 0.0v 1109.495n 0.0v 1109.505n 1.7v 1119.495n 1.7v 1119.505n 1.7v 1129.495n 1.7v 1129.505n 0.0v 1139.495n 0.0v 1139.505n 0.0v 1149.495n 0.0v 1149.505n 0.0v 1159.495n 0.0v 1159.505n 0.0v 1169.495n 0.0v 1169.505n 0.0v 1179.495n 0.0v 1179.505n 0.0v 1189.495n 0.0v 1189.505n 0.0v 1199.495n 0.0v 1199.505n 0.0v 1209.495n 0.0v 1209.505n 0.0v 1219.495n 0.0v 1219.505n 0.0v 1229.495n 0.0v 1229.505n 0.0v 1239.495n 0.0v 1239.505n 0.0v 1249.495n 0.0v 1249.505n 0.0v 1259.495n 0.0v 1259.505n 0.0v 1269.495n 0.0v 1269.505n 0.0v 1279.495n 0.0v 1279.505n 0.0v 1289.495n 0.0v 1289.505n 0.0v 1299.495n 0.0v 1299.505n 0.0v 1309.495n 0.0v 1309.505n 0.0v 1319.495n 0.0v 1319.505n 0.0v 1329.495n 0.0v 1329.505n 0.0v 1339.495n 0.0v 1339.505n 0.0v 1349.495n 0.0v 1349.505n 0.0v 1359.495n 0.0v 1359.505n 1.7v 1369.495n 1.7v 1369.505n 0.0v 1379.495n 0.0v 1379.505n 0.0v 1389.495n 0.0v 1389.505n 0.0v 1399.495n 0.0v 1399.505n 0.0v 1409.495n 0.0v 1409.505n 0.0v 1419.495n 0.0v 1419.505n 0.0v 1429.495n 0.0v 1429.505n 0.0v 1439.495n 0.0v 1439.505n 0.0v 1449.495n 0.0v 1449.505n 0.0v 1459.495n 0.0v 1459.505n 0.0v 1469.495n 0.0v 1469.505n 0.0v 1479.495n 0.0v 1479.505n 0.0v 1489.495n 0.0v 1489.505n 0.0v 1499.495n 0.0v 1499.505n 0.0v 1509.495n 0.0v 1509.505n 0.0v 1519.495n 0.0v 1519.505n 0.0v 1529.495n 0.0v 1529.505n 0.0v 1539.495n 0.0v 1539.505n 0.0v 1549.495n 0.0v 1549.505n 0.0v 1559.495n 0.0v 1559.505n 1.7v 1569.495n 1.7v 1569.505n 1.7v 1579.495n 1.7v 1579.505n 0.0v 1589.495n 0.0v 1589.505n 0.0v 1599.495n 0.0v 1599.505n 0.0v 1609.495n 0.0v 1609.505n 0.0v 1619.495n 0.0v 1619.505n 0.0v 1629.495n 0.0v 1629.505n 1.7v 1639.495n 1.7v 1639.505n 1.7v 1649.495n 1.7v 1649.505n 0.0v 1659.495n 0.0v 1659.505n 0.0v 1669.495n 0.0v 1669.505n 0.0v 1679.495n 0.0v 1679.505n 0.0v 1689.495n 0.0v 1689.505n 0.0v 1699.495n 0.0v 1699.505n 0.0v 1709.495n 0.0v 1709.505n 0.0v 1719.495n 0.0v 1719.505n 0.0v 1729.495n 0.0v 1729.505n 0.0v 1739.495n 0.0v 1739.505n 0.0v 1749.495n 0.0v 1749.505n 0.0v 1759.495n 0.0v 1759.505n 0.0v 1769.495n 0.0v 1769.505n 0.0v 1779.495n 0.0v 1779.505n 0.0v 1789.495n 0.0v 1789.505n 0.0v 1799.495n 0.0v 1799.505n 0.0v 1809.495n 0.0v 1809.505n 0.0v 1819.495n 0.0v 1819.505n 0.0v 1829.495n 0.0v 1829.505n 0.0v 1839.495n 0.0v 1839.505n 0.0v 1849.495n 0.0v 1849.505n 0.0v 1859.495n 0.0v 1859.505n 0.0v 1869.495n 0.0v 1869.505n 0.0v 1879.495n 0.0v 1879.505n 0.0v 1889.495n 0.0v 1889.505n 0.0v 1899.495n 0.0v 1899.505n 0.0v 1909.495n 0.0v 1909.505n 0.0v 1919.495n 0.0v 1919.505n 0.0v 1929.495n 0.0v 1929.505n 0.0v 1939.495n 0.0v 1939.505n 0.0v 1949.495n 0.0v 1949.505n 0.0v 1959.495n 0.0v 1959.505n 0.0v 1969.495n 0.0v 1969.505n 0.0v 1979.495n 0.0v 1979.505n 0.0v 1989.495n 0.0v 1989.505n 0.0v 1999.495n 0.0v 1999.505n 0.0v 2009.495n 0.0v 2009.505n 1.7v 2019.495n 1.7v 2019.505n 0.0v 2029.495n 0.0v 2029.505n 0.0v 2039.495n 0.0v 2039.505n 0.0v 2049.495n 0.0v 2049.505n 0.0v )
* (time, data): [(0, 0), (10, 1), (20, 0), (30, 0), (40, 0), (50, 0), (60, 0), (70, 0), (80, 0), (90, 0), (100, 1), (110, 0), (120, 0), (130, 0), (140, 0), (150, 0), (160, 0), (170, 0), (180, 0), (190, 0), (200, 0), (210, 0), (220, 0), (230, 0), (240, 0), (250, 0), (260, 0), (270, 0), (280, 0), (290, 0), (300, 0), (310, 0), (320, 0), (330, 0), (340, 0), (350, 0), (360, 0), (370, 0), (380, 0), (390, 0), (400, 0), (410, 0), (420, 0), (430, 0), (440, 0), (450, 0), (460, 0), (470, 0), (480, 0), (490, 0), (500, 0), (510, 0), (520, 0), (530, 0), (540, 0), (550, 1), (560, 1), (570, 1), (580, 1), (590, 1), (600, 0), (610, 0), (620, 0), (630, 0), (640, 0), (650, 0), (660, 0), (670, 0), (680, 0), (690, 0), (700, 0), (710, 0), (720, 0), (730, 0), (740, 0), (750, 0), (760, 0), (770, 0), (780, 0), (790, 0), (800, 1), (810, 1), (820, 0), (830, 0), (840, 0), (850, 0), (860, 0), (870, 0), (880, 0), (890, 0), (900, 0), (910, 0), (920, 0), (930, 0), (940, 0), (950, 0), (960, 0), (970, 1), (980, 1), (990, 0), (1000, 1), (1010, 0), (1020, 0), (1030, 0), (1040, 0), (1050, 0), (1060, 0), (1070, 1), (1080, 1), (1090, 1), (1100, 0), (1110, 1), (1120, 1), (1130, 0), (1140, 0), (1150, 0), (1160, 0), (1170, 0), (1180, 0), (1190, 0), (1200, 0), (1210, 0), (1220, 0), (1230, 0), (1240, 0), (1250, 0), (1260, 0), (1270, 0), (1280, 0), (1290, 0), (1300, 0), (1310, 0), (1320, 0), (1330, 0), (1340, 0), (1350, 0), (1360, 1), (1370, 0), (1380, 0), (1390, 0), (1400, 0), (1410, 0), (1420, 0), (1430, 0), (1440, 0), (1450, 0), (1460, 0), (1470, 0), (1480, 0), (1490, 0), (1500, 0), (1510, 0), (1520, 0), (1530, 0), (1540, 0), (1550, 0), (1560, 1), (1570, 1), (1580, 0), (1590, 0), (1600, 0), (1610, 0), (1620, 0), (1630, 1), (1640, 1), (1650, 0), (1660, 0), (1670, 0), (1680, 0), (1690, 0), (1700, 0), (1710, 0), (1720, 0), (1730, 0), (1740, 0), (1750, 0), (1760, 0), (1770, 0), (1780, 0), (1790, 0), (1800, 0), (1810, 0), (1820, 0), (1830, 0), (1840, 0), (1850, 0), (1860, 0), (1870, 0), (1880, 0), (1890, 0), (1900, 0), (1910, 0), (1920, 0), (1930, 0), (1940, 0), (1950, 0), (1960, 0), (1970, 0), (1980, 0), (1990, 0), (2000, 0), (2010, 1), (2020, 0), (2030, 0), (2040, 0), (2050, 0)]
Va0_3  a0_3  0 PWL (0n 0.0v 9.495n 0.0v 9.505n 1.7v 19.495n 1.7v 19.505n 0.0v 29.495n 0.0v 29.505n 0.0v 39.495n 0.0v 39.505n 0.0v 49.495n 0.0v 49.505n 0.0v 59.495n 0.0v 59.505n 0.0v 69.495n 0.0v 69.505n 0.0v 79.495n 0.0v 79.505n 0.0v 89.495n 0.0v 89.505n 0.0v 99.495n 0.0v 99.505n 1.7v 109.495n 1.7v 109.505n 0.0v 119.495n 0.0v 119.505n 0.0v 129.495n 0.0v 129.505n 0.0v 139.495n 0.0v 139.505n 0.0v 149.495n 0.0v 149.505n 0.0v 159.495n 0.0v 159.505n 0.0v 169.495n 0.0v 169.505n 0.0v 179.495n 0.0v 179.505n 0.0v 189.495n 0.0v 189.505n 0.0v 199.495n 0.0v 199.505n 0.0v 209.495n 0.0v 209.505n 0.0v 219.495n 0.0v 219.505n 0.0v 229.495n 0.0v 229.505n 0.0v 239.495n 0.0v 239.505n 0.0v 249.495n 0.0v 249.505n 0.0v 259.495n 0.0v 259.505n 0.0v 269.495n 0.0v 269.505n 0.0v 279.495n 0.0v 279.505n 0.0v 289.495n 0.0v 289.505n 0.0v 299.495n 0.0v 299.505n 0.0v 309.495n 0.0v 309.505n 0.0v 319.495n 0.0v 319.505n 0.0v 329.495n 0.0v 329.505n 0.0v 339.495n 0.0v 339.505n 0.0v 349.495n 0.0v 349.505n 0.0v 359.495n 0.0v 359.505n 0.0v 369.495n 0.0v 369.505n 0.0v 379.495n 0.0v 379.505n 0.0v 389.495n 0.0v 389.505n 0.0v 399.495n 0.0v 399.505n 0.0v 409.495n 0.0v 409.505n 0.0v 419.495n 0.0v 419.505n 0.0v 429.495n 0.0v 429.505n 0.0v 439.495n 0.0v 439.505n 0.0v 449.495n 0.0v 449.505n 0.0v 459.495n 0.0v 459.505n 0.0v 469.495n 0.0v 469.505n 0.0v 479.495n 0.0v 479.505n 0.0v 489.495n 0.0v 489.505n 0.0v 499.495n 0.0v 499.505n 0.0v 509.495n 0.0v 509.505n 0.0v 519.495n 0.0v 519.505n 0.0v 529.495n 0.0v 529.505n 0.0v 539.495n 0.0v 539.505n 0.0v 549.495n 0.0v 549.505n 1.7v 559.495n 1.7v 559.505n 1.7v 569.495n 1.7v 569.505n 1.7v 579.495n 1.7v 579.505n 1.7v 589.495n 1.7v 589.505n 1.7v 599.495n 1.7v 599.505n 0.0v 609.495n 0.0v 609.505n 0.0v 619.495n 0.0v 619.505n 0.0v 629.495n 0.0v 629.505n 0.0v 639.495n 0.0v 639.505n 0.0v 649.495n 0.0v 649.505n 0.0v 659.495n 0.0v 659.505n 0.0v 669.495n 0.0v 669.505n 0.0v 679.495n 0.0v 679.505n 0.0v 689.495n 0.0v 689.505n 0.0v 699.495n 0.0v 699.505n 0.0v 709.495n 0.0v 709.505n 0.0v 719.495n 0.0v 719.505n 0.0v 729.495n 0.0v 729.505n 0.0v 739.495n 0.0v 739.505n 0.0v 749.495n 0.0v 749.505n 0.0v 759.495n 0.0v 759.505n 0.0v 769.495n 0.0v 769.505n 0.0v 779.495n 0.0v 779.505n 0.0v 789.495n 0.0v 789.505n 0.0v 799.495n 0.0v 799.505n 1.7v 809.495n 1.7v 809.505n 1.7v 819.495n 1.7v 819.505n 0.0v 829.495n 0.0v 829.505n 0.0v 839.495n 0.0v 839.505n 0.0v 849.495n 0.0v 849.505n 0.0v 859.495n 0.0v 859.505n 0.0v 869.495n 0.0v 869.505n 0.0v 879.495n 0.0v 879.505n 0.0v 889.495n 0.0v 889.505n 0.0v 899.495n 0.0v 899.505n 0.0v 909.495n 0.0v 909.505n 0.0v 919.495n 0.0v 919.505n 0.0v 929.495n 0.0v 929.505n 0.0v 939.495n 0.0v 939.505n 0.0v 949.495n 0.0v 949.505n 0.0v 959.495n 0.0v 959.505n 0.0v 969.495n 0.0v 969.505n 1.7v 979.495n 1.7v 979.505n 1.7v 989.495n 1.7v 989.505n 0.0v 999.495n 0.0v 999.505n 1.7v 1009.495n 1.7v 1009.505n 0.0v 1019.495n 0.0v 1019.505n 0.0v 1029.495n 0.0v 1029.505n 0.0v 1039.495n 0.0v 1039.505n 0.0v 1049.495n 0.0v 1049.505n 0.0v 1059.495n 0.0v 1059.505n 0.0v 1069.495n 0.0v 1069.505n 1.7v 1079.495n 1.7v 1079.505n 1.7v 1089.495n 1.7v 1089.505n 1.7v 1099.495n 1.7v 1099.505n 0.0v 1109.495n 0.0v 1109.505n 1.7v 1119.495n 1.7v 1119.505n 1.7v 1129.495n 1.7v 1129.505n 0.0v 1139.495n 0.0v 1139.505n 0.0v 1149.495n 0.0v 1149.505n 0.0v 1159.495n 0.0v 1159.505n 0.0v 1169.495n 0.0v 1169.505n 0.0v 1179.495n 0.0v 1179.505n 0.0v 1189.495n 0.0v 1189.505n 0.0v 1199.495n 0.0v 1199.505n 0.0v 1209.495n 0.0v 1209.505n 0.0v 1219.495n 0.0v 1219.505n 0.0v 1229.495n 0.0v 1229.505n 0.0v 1239.495n 0.0v 1239.505n 0.0v 1249.495n 0.0v 1249.505n 0.0v 1259.495n 0.0v 1259.505n 0.0v 1269.495n 0.0v 1269.505n 0.0v 1279.495n 0.0v 1279.505n 0.0v 1289.495n 0.0v 1289.505n 0.0v 1299.495n 0.0v 1299.505n 0.0v 1309.495n 0.0v 1309.505n 0.0v 1319.495n 0.0v 1319.505n 0.0v 1329.495n 0.0v 1329.505n 0.0v 1339.495n 0.0v 1339.505n 0.0v 1349.495n 0.0v 1349.505n 0.0v 1359.495n 0.0v 1359.505n 1.7v 1369.495n 1.7v 1369.505n 0.0v 1379.495n 0.0v 1379.505n 0.0v 1389.495n 0.0v 1389.505n 0.0v 1399.495n 0.0v 1399.505n 0.0v 1409.495n 0.0v 1409.505n 0.0v 1419.495n 0.0v 1419.505n 0.0v 1429.495n 0.0v 1429.505n 0.0v 1439.495n 0.0v 1439.505n 0.0v 1449.495n 0.0v 1449.505n 0.0v 1459.495n 0.0v 1459.505n 0.0v 1469.495n 0.0v 1469.505n 0.0v 1479.495n 0.0v 1479.505n 0.0v 1489.495n 0.0v 1489.505n 0.0v 1499.495n 0.0v 1499.505n 0.0v 1509.495n 0.0v 1509.505n 0.0v 1519.495n 0.0v 1519.505n 0.0v 1529.495n 0.0v 1529.505n 0.0v 1539.495n 0.0v 1539.505n 0.0v 1549.495n 0.0v 1549.505n 0.0v 1559.495n 0.0v 1559.505n 1.7v 1569.495n 1.7v 1569.505n 1.7v 1579.495n 1.7v 1579.505n 0.0v 1589.495n 0.0v 1589.505n 0.0v 1599.495n 0.0v 1599.505n 0.0v 1609.495n 0.0v 1609.505n 0.0v 1619.495n 0.0v 1619.505n 0.0v 1629.495n 0.0v 1629.505n 1.7v 1639.495n 1.7v 1639.505n 1.7v 1649.495n 1.7v 1649.505n 0.0v 1659.495n 0.0v 1659.505n 0.0v 1669.495n 0.0v 1669.505n 0.0v 1679.495n 0.0v 1679.505n 0.0v 1689.495n 0.0v 1689.505n 0.0v 1699.495n 0.0v 1699.505n 0.0v 1709.495n 0.0v 1709.505n 0.0v 1719.495n 0.0v 1719.505n 0.0v 1729.495n 0.0v 1729.505n 0.0v 1739.495n 0.0v 1739.505n 0.0v 1749.495n 0.0v 1749.505n 0.0v 1759.495n 0.0v 1759.505n 0.0v 1769.495n 0.0v 1769.505n 0.0v 1779.495n 0.0v 1779.505n 0.0v 1789.495n 0.0v 1789.505n 0.0v 1799.495n 0.0v 1799.505n 0.0v 1809.495n 0.0v 1809.505n 0.0v 1819.495n 0.0v 1819.505n 0.0v 1829.495n 0.0v 1829.505n 0.0v 1839.495n 0.0v 1839.505n 0.0v 1849.495n 0.0v 1849.505n 0.0v 1859.495n 0.0v 1859.505n 0.0v 1869.495n 0.0v 1869.505n 0.0v 1879.495n 0.0v 1879.505n 0.0v 1889.495n 0.0v 1889.505n 0.0v 1899.495n 0.0v 1899.505n 0.0v 1909.495n 0.0v 1909.505n 0.0v 1919.495n 0.0v 1919.505n 0.0v 1929.495n 0.0v 1929.505n 0.0v 1939.495n 0.0v 1939.505n 0.0v 1949.495n 0.0v 1949.505n 0.0v 1959.495n 0.0v 1959.505n 0.0v 1969.495n 0.0v 1969.505n 0.0v 1979.495n 0.0v 1979.505n 0.0v 1989.495n 0.0v 1989.505n 0.0v 1999.495n 0.0v 1999.505n 0.0v 2009.495n 0.0v 2009.505n 1.7v 2019.495n 1.7v 2019.505n 0.0v 2029.495n 0.0v 2029.505n 0.0v 2039.495n 0.0v 2039.505n 0.0v 2049.495n 0.0v 2049.505n 0.0v )
* (time, data): [(0, 0), (10, 1), (20, 0), (30, 0), (40, 0), (50, 0), (60, 0), (70, 0), (80, 0), (90, 0), (100, 1), (110, 0), (120, 0), (130, 0), (140, 0), (150, 0), (160, 0), (170, 0), (180, 0), (190, 0), (200, 0), (210, 0), (220, 0), (230, 0), (240, 0), (250, 0), (260, 0), (270, 0), (280, 0), (290, 0), (300, 0), (310, 0), (320, 0), (330, 0), (340, 0), (350, 0), (360, 0), (370, 0), (380, 0), (390, 0), (400, 0), (410, 0), (420, 0), (430, 0), (440, 0), (450, 0), (460, 0), (470, 0), (480, 0), (490, 0), (500, 0), (510, 0), (520, 0), (530, 0), (540, 0), (550, 1), (560, 1), (570, 1), (580, 1), (590, 1), (600, 0), (610, 0), (620, 0), (630, 0), (640, 0), (650, 0), (660, 0), (670, 0), (680, 0), (690, 0), (700, 0), (710, 0), (720, 0), (730, 0), (740, 0), (750, 0), (760, 0), (770, 0), (780, 0), (790, 0), (800, 1), (810, 1), (820, 0), (830, 0), (840, 0), (850, 0), (860, 0), (870, 0), (880, 0), (890, 0), (900, 0), (910, 0), (920, 0), (930, 0), (940, 0), (950, 0), (960, 0), (970, 1), (980, 1), (990, 0), (1000, 1), (1010, 0), (1020, 0), (1030, 0), (1040, 0), (1050, 0), (1060, 0), (1070, 1), (1080, 1), (1090, 1), (1100, 0), (1110, 1), (1120, 1), (1130, 0), (1140, 0), (1150, 0), (1160, 0), (1170, 0), (1180, 0), (1190, 0), (1200, 0), (1210, 0), (1220, 0), (1230, 0), (1240, 0), (1250, 0), (1260, 0), (1270, 0), (1280, 0), (1290, 0), (1300, 0), (1310, 0), (1320, 0), (1330, 0), (1340, 0), (1350, 0), (1360, 1), (1370, 0), (1380, 0), (1390, 0), (1400, 0), (1410, 0), (1420, 0), (1430, 0), (1440, 0), (1450, 0), (1460, 0), (1470, 0), (1480, 0), (1490, 0), (1500, 0), (1510, 0), (1520, 0), (1530, 0), (1540, 0), (1550, 0), (1560, 1), (1570, 1), (1580, 0), (1590, 0), (1600, 0), (1610, 0), (1620, 0), (1630, 1), (1640, 1), (1650, 0), (1660, 0), (1670, 0), (1680, 0), (1690, 0), (1700, 0), (1710, 0), (1720, 0), (1730, 0), (1740, 0), (1750, 0), (1760, 0), (1770, 0), (1780, 0), (1790, 0), (1800, 0), (1810, 0), (1820, 0), (1830, 0), (1840, 0), (1850, 0), (1860, 0), (1870, 0), (1880, 0), (1890, 0), (1900, 0), (1910, 0), (1920, 0), (1930, 0), (1940, 0), (1950, 0), (1960, 0), (1970, 0), (1980, 0), (1990, 0), (2000, 0), (2010, 1), (2020, 0), (2030, 0), (2040, 0), (2050, 0)]
Va0_4  a0_4  0 PWL (0n 0.0v 9.495n 0.0v 9.505n 1.7v 19.495n 1.7v 19.505n 0.0v 29.495n 0.0v 29.505n 0.0v 39.495n 0.0v 39.505n 0.0v 49.495n 0.0v 49.505n 0.0v 59.495n 0.0v 59.505n 0.0v 69.495n 0.0v 69.505n 0.0v 79.495n 0.0v 79.505n 0.0v 89.495n 0.0v 89.505n 0.0v 99.495n 0.0v 99.505n 1.7v 109.495n 1.7v 109.505n 0.0v 119.495n 0.0v 119.505n 0.0v 129.495n 0.0v 129.505n 0.0v 139.495n 0.0v 139.505n 0.0v 149.495n 0.0v 149.505n 0.0v 159.495n 0.0v 159.505n 0.0v 169.495n 0.0v 169.505n 0.0v 179.495n 0.0v 179.505n 0.0v 189.495n 0.0v 189.505n 0.0v 199.495n 0.0v 199.505n 0.0v 209.495n 0.0v 209.505n 0.0v 219.495n 0.0v 219.505n 0.0v 229.495n 0.0v 229.505n 0.0v 239.495n 0.0v 239.505n 0.0v 249.495n 0.0v 249.505n 0.0v 259.495n 0.0v 259.505n 0.0v 269.495n 0.0v 269.505n 0.0v 279.495n 0.0v 279.505n 0.0v 289.495n 0.0v 289.505n 0.0v 299.495n 0.0v 299.505n 0.0v 309.495n 0.0v 309.505n 0.0v 319.495n 0.0v 319.505n 0.0v 329.495n 0.0v 329.505n 0.0v 339.495n 0.0v 339.505n 0.0v 349.495n 0.0v 349.505n 0.0v 359.495n 0.0v 359.505n 0.0v 369.495n 0.0v 369.505n 0.0v 379.495n 0.0v 379.505n 0.0v 389.495n 0.0v 389.505n 0.0v 399.495n 0.0v 399.505n 0.0v 409.495n 0.0v 409.505n 0.0v 419.495n 0.0v 419.505n 0.0v 429.495n 0.0v 429.505n 0.0v 439.495n 0.0v 439.505n 0.0v 449.495n 0.0v 449.505n 0.0v 459.495n 0.0v 459.505n 0.0v 469.495n 0.0v 469.505n 0.0v 479.495n 0.0v 479.505n 0.0v 489.495n 0.0v 489.505n 0.0v 499.495n 0.0v 499.505n 0.0v 509.495n 0.0v 509.505n 0.0v 519.495n 0.0v 519.505n 0.0v 529.495n 0.0v 529.505n 0.0v 539.495n 0.0v 539.505n 0.0v 549.495n 0.0v 549.505n 1.7v 559.495n 1.7v 559.505n 1.7v 569.495n 1.7v 569.505n 1.7v 579.495n 1.7v 579.505n 1.7v 589.495n 1.7v 589.505n 1.7v 599.495n 1.7v 599.505n 0.0v 609.495n 0.0v 609.505n 0.0v 619.495n 0.0v 619.505n 0.0v 629.495n 0.0v 629.505n 0.0v 639.495n 0.0v 639.505n 0.0v 649.495n 0.0v 649.505n 0.0v 659.495n 0.0v 659.505n 0.0v 669.495n 0.0v 669.505n 0.0v 679.495n 0.0v 679.505n 0.0v 689.495n 0.0v 689.505n 0.0v 699.495n 0.0v 699.505n 0.0v 709.495n 0.0v 709.505n 0.0v 719.495n 0.0v 719.505n 0.0v 729.495n 0.0v 729.505n 0.0v 739.495n 0.0v 739.505n 0.0v 749.495n 0.0v 749.505n 0.0v 759.495n 0.0v 759.505n 0.0v 769.495n 0.0v 769.505n 0.0v 779.495n 0.0v 779.505n 0.0v 789.495n 0.0v 789.505n 0.0v 799.495n 0.0v 799.505n 1.7v 809.495n 1.7v 809.505n 1.7v 819.495n 1.7v 819.505n 0.0v 829.495n 0.0v 829.505n 0.0v 839.495n 0.0v 839.505n 0.0v 849.495n 0.0v 849.505n 0.0v 859.495n 0.0v 859.505n 0.0v 869.495n 0.0v 869.505n 0.0v 879.495n 0.0v 879.505n 0.0v 889.495n 0.0v 889.505n 0.0v 899.495n 0.0v 899.505n 0.0v 909.495n 0.0v 909.505n 0.0v 919.495n 0.0v 919.505n 0.0v 929.495n 0.0v 929.505n 0.0v 939.495n 0.0v 939.505n 0.0v 949.495n 0.0v 949.505n 0.0v 959.495n 0.0v 959.505n 0.0v 969.495n 0.0v 969.505n 1.7v 979.495n 1.7v 979.505n 1.7v 989.495n 1.7v 989.505n 0.0v 999.495n 0.0v 999.505n 1.7v 1009.495n 1.7v 1009.505n 0.0v 1019.495n 0.0v 1019.505n 0.0v 1029.495n 0.0v 1029.505n 0.0v 1039.495n 0.0v 1039.505n 0.0v 1049.495n 0.0v 1049.505n 0.0v 1059.495n 0.0v 1059.505n 0.0v 1069.495n 0.0v 1069.505n 1.7v 1079.495n 1.7v 1079.505n 1.7v 1089.495n 1.7v 1089.505n 1.7v 1099.495n 1.7v 1099.505n 0.0v 1109.495n 0.0v 1109.505n 1.7v 1119.495n 1.7v 1119.505n 1.7v 1129.495n 1.7v 1129.505n 0.0v 1139.495n 0.0v 1139.505n 0.0v 1149.495n 0.0v 1149.505n 0.0v 1159.495n 0.0v 1159.505n 0.0v 1169.495n 0.0v 1169.505n 0.0v 1179.495n 0.0v 1179.505n 0.0v 1189.495n 0.0v 1189.505n 0.0v 1199.495n 0.0v 1199.505n 0.0v 1209.495n 0.0v 1209.505n 0.0v 1219.495n 0.0v 1219.505n 0.0v 1229.495n 0.0v 1229.505n 0.0v 1239.495n 0.0v 1239.505n 0.0v 1249.495n 0.0v 1249.505n 0.0v 1259.495n 0.0v 1259.505n 0.0v 1269.495n 0.0v 1269.505n 0.0v 1279.495n 0.0v 1279.505n 0.0v 1289.495n 0.0v 1289.505n 0.0v 1299.495n 0.0v 1299.505n 0.0v 1309.495n 0.0v 1309.505n 0.0v 1319.495n 0.0v 1319.505n 0.0v 1329.495n 0.0v 1329.505n 0.0v 1339.495n 0.0v 1339.505n 0.0v 1349.495n 0.0v 1349.505n 0.0v 1359.495n 0.0v 1359.505n 1.7v 1369.495n 1.7v 1369.505n 0.0v 1379.495n 0.0v 1379.505n 0.0v 1389.495n 0.0v 1389.505n 0.0v 1399.495n 0.0v 1399.505n 0.0v 1409.495n 0.0v 1409.505n 0.0v 1419.495n 0.0v 1419.505n 0.0v 1429.495n 0.0v 1429.505n 0.0v 1439.495n 0.0v 1439.505n 0.0v 1449.495n 0.0v 1449.505n 0.0v 1459.495n 0.0v 1459.505n 0.0v 1469.495n 0.0v 1469.505n 0.0v 1479.495n 0.0v 1479.505n 0.0v 1489.495n 0.0v 1489.505n 0.0v 1499.495n 0.0v 1499.505n 0.0v 1509.495n 0.0v 1509.505n 0.0v 1519.495n 0.0v 1519.505n 0.0v 1529.495n 0.0v 1529.505n 0.0v 1539.495n 0.0v 1539.505n 0.0v 1549.495n 0.0v 1549.505n 0.0v 1559.495n 0.0v 1559.505n 1.7v 1569.495n 1.7v 1569.505n 1.7v 1579.495n 1.7v 1579.505n 0.0v 1589.495n 0.0v 1589.505n 0.0v 1599.495n 0.0v 1599.505n 0.0v 1609.495n 0.0v 1609.505n 0.0v 1619.495n 0.0v 1619.505n 0.0v 1629.495n 0.0v 1629.505n 1.7v 1639.495n 1.7v 1639.505n 1.7v 1649.495n 1.7v 1649.505n 0.0v 1659.495n 0.0v 1659.505n 0.0v 1669.495n 0.0v 1669.505n 0.0v 1679.495n 0.0v 1679.505n 0.0v 1689.495n 0.0v 1689.505n 0.0v 1699.495n 0.0v 1699.505n 0.0v 1709.495n 0.0v 1709.505n 0.0v 1719.495n 0.0v 1719.505n 0.0v 1729.495n 0.0v 1729.505n 0.0v 1739.495n 0.0v 1739.505n 0.0v 1749.495n 0.0v 1749.505n 0.0v 1759.495n 0.0v 1759.505n 0.0v 1769.495n 0.0v 1769.505n 0.0v 1779.495n 0.0v 1779.505n 0.0v 1789.495n 0.0v 1789.505n 0.0v 1799.495n 0.0v 1799.505n 0.0v 1809.495n 0.0v 1809.505n 0.0v 1819.495n 0.0v 1819.505n 0.0v 1829.495n 0.0v 1829.505n 0.0v 1839.495n 0.0v 1839.505n 0.0v 1849.495n 0.0v 1849.505n 0.0v 1859.495n 0.0v 1859.505n 0.0v 1869.495n 0.0v 1869.505n 0.0v 1879.495n 0.0v 1879.505n 0.0v 1889.495n 0.0v 1889.505n 0.0v 1899.495n 0.0v 1899.505n 0.0v 1909.495n 0.0v 1909.505n 0.0v 1919.495n 0.0v 1919.505n 0.0v 1929.495n 0.0v 1929.505n 0.0v 1939.495n 0.0v 1939.505n 0.0v 1949.495n 0.0v 1949.505n 0.0v 1959.495n 0.0v 1959.505n 0.0v 1969.495n 0.0v 1969.505n 0.0v 1979.495n 0.0v 1979.505n 0.0v 1989.495n 0.0v 1989.505n 0.0v 1999.495n 0.0v 1999.505n 0.0v 2009.495n 0.0v 2009.505n 1.7v 2019.495n 1.7v 2019.505n 0.0v 2029.495n 0.0v 2029.505n 0.0v 2039.495n 0.0v 2039.505n 0.0v 2049.495n 0.0v 2049.505n 0.0v )
* (time, data): [(0, 0), (10, 1), (20, 0), (30, 0), (40, 0), (50, 0), (60, 0), (70, 0), (80, 0), (90, 0), (100, 1), (110, 0), (120, 0), (130, 0), (140, 0), (150, 0), (160, 0), (170, 0), (180, 0), (190, 0), (200, 0), (210, 0), (220, 0), (230, 0), (240, 0), (250, 0), (260, 0), (270, 0), (280, 0), (290, 0), (300, 0), (310, 0), (320, 0), (330, 0), (340, 0), (350, 0), (360, 0), (370, 0), (380, 0), (390, 0), (400, 0), (410, 0), (420, 0), (430, 0), (440, 0), (450, 0), (460, 0), (470, 0), (480, 0), (490, 0), (500, 0), (510, 0), (520, 0), (530, 0), (540, 0), (550, 1), (560, 1), (570, 1), (580, 1), (590, 1), (600, 0), (610, 0), (620, 0), (630, 0), (640, 0), (650, 0), (660, 0), (670, 0), (680, 0), (690, 0), (700, 0), (710, 0), (720, 0), (730, 0), (740, 0), (750, 0), (760, 0), (770, 0), (780, 0), (790, 0), (800, 1), (810, 1), (820, 0), (830, 0), (840, 0), (850, 0), (860, 0), (870, 0), (880, 0), (890, 0), (900, 0), (910, 0), (920, 0), (930, 0), (940, 0), (950, 0), (960, 0), (970, 1), (980, 1), (990, 0), (1000, 1), (1010, 0), (1020, 0), (1030, 0), (1040, 0), (1050, 0), (1060, 0), (1070, 1), (1080, 1), (1090, 1), (1100, 0), (1110, 1), (1120, 1), (1130, 0), (1140, 0), (1150, 0), (1160, 0), (1170, 0), (1180, 0), (1190, 0), (1200, 0), (1210, 0), (1220, 0), (1230, 0), (1240, 0), (1250, 0), (1260, 0), (1270, 0), (1280, 0), (1290, 0), (1300, 0), (1310, 0), (1320, 0), (1330, 0), (1340, 0), (1350, 0), (1360, 1), (1370, 0), (1380, 0), (1390, 0), (1400, 0), (1410, 0), (1420, 0), (1430, 0), (1440, 0), (1450, 0), (1460, 0), (1470, 0), (1480, 0), (1490, 0), (1500, 0), (1510, 0), (1520, 0), (1530, 0), (1540, 0), (1550, 0), (1560, 1), (1570, 1), (1580, 0), (1590, 0), (1600, 0), (1610, 0), (1620, 0), (1630, 1), (1640, 1), (1650, 0), (1660, 0), (1670, 0), (1680, 0), (1690, 0), (1700, 0), (1710, 0), (1720, 0), (1730, 0), (1740, 0), (1750, 0), (1760, 0), (1770, 0), (1780, 0), (1790, 0), (1800, 0), (1810, 0), (1820, 0), (1830, 0), (1840, 0), (1850, 0), (1860, 0), (1870, 0), (1880, 0), (1890, 0), (1900, 0), (1910, 0), (1920, 0), (1930, 0), (1940, 0), (1950, 0), (1960, 0), (1970, 0), (1980, 0), (1990, 0), (2000, 0), (2010, 1), (2020, 0), (2030, 0), (2040, 0), (2050, 0)]
Va0_5  a0_5  0 PWL (0n 0.0v 9.495n 0.0v 9.505n 1.7v 19.495n 1.7v 19.505n 0.0v 29.495n 0.0v 29.505n 0.0v 39.495n 0.0v 39.505n 0.0v 49.495n 0.0v 49.505n 0.0v 59.495n 0.0v 59.505n 0.0v 69.495n 0.0v 69.505n 0.0v 79.495n 0.0v 79.505n 0.0v 89.495n 0.0v 89.505n 0.0v 99.495n 0.0v 99.505n 1.7v 109.495n 1.7v 109.505n 0.0v 119.495n 0.0v 119.505n 0.0v 129.495n 0.0v 129.505n 0.0v 139.495n 0.0v 139.505n 0.0v 149.495n 0.0v 149.505n 0.0v 159.495n 0.0v 159.505n 0.0v 169.495n 0.0v 169.505n 0.0v 179.495n 0.0v 179.505n 0.0v 189.495n 0.0v 189.505n 0.0v 199.495n 0.0v 199.505n 0.0v 209.495n 0.0v 209.505n 0.0v 219.495n 0.0v 219.505n 0.0v 229.495n 0.0v 229.505n 0.0v 239.495n 0.0v 239.505n 0.0v 249.495n 0.0v 249.505n 0.0v 259.495n 0.0v 259.505n 0.0v 269.495n 0.0v 269.505n 0.0v 279.495n 0.0v 279.505n 0.0v 289.495n 0.0v 289.505n 0.0v 299.495n 0.0v 299.505n 0.0v 309.495n 0.0v 309.505n 0.0v 319.495n 0.0v 319.505n 0.0v 329.495n 0.0v 329.505n 0.0v 339.495n 0.0v 339.505n 0.0v 349.495n 0.0v 349.505n 0.0v 359.495n 0.0v 359.505n 0.0v 369.495n 0.0v 369.505n 0.0v 379.495n 0.0v 379.505n 0.0v 389.495n 0.0v 389.505n 0.0v 399.495n 0.0v 399.505n 0.0v 409.495n 0.0v 409.505n 0.0v 419.495n 0.0v 419.505n 0.0v 429.495n 0.0v 429.505n 0.0v 439.495n 0.0v 439.505n 0.0v 449.495n 0.0v 449.505n 0.0v 459.495n 0.0v 459.505n 0.0v 469.495n 0.0v 469.505n 0.0v 479.495n 0.0v 479.505n 0.0v 489.495n 0.0v 489.505n 0.0v 499.495n 0.0v 499.505n 0.0v 509.495n 0.0v 509.505n 0.0v 519.495n 0.0v 519.505n 0.0v 529.495n 0.0v 529.505n 0.0v 539.495n 0.0v 539.505n 0.0v 549.495n 0.0v 549.505n 1.7v 559.495n 1.7v 559.505n 1.7v 569.495n 1.7v 569.505n 1.7v 579.495n 1.7v 579.505n 1.7v 589.495n 1.7v 589.505n 1.7v 599.495n 1.7v 599.505n 0.0v 609.495n 0.0v 609.505n 0.0v 619.495n 0.0v 619.505n 0.0v 629.495n 0.0v 629.505n 0.0v 639.495n 0.0v 639.505n 0.0v 649.495n 0.0v 649.505n 0.0v 659.495n 0.0v 659.505n 0.0v 669.495n 0.0v 669.505n 0.0v 679.495n 0.0v 679.505n 0.0v 689.495n 0.0v 689.505n 0.0v 699.495n 0.0v 699.505n 0.0v 709.495n 0.0v 709.505n 0.0v 719.495n 0.0v 719.505n 0.0v 729.495n 0.0v 729.505n 0.0v 739.495n 0.0v 739.505n 0.0v 749.495n 0.0v 749.505n 0.0v 759.495n 0.0v 759.505n 0.0v 769.495n 0.0v 769.505n 0.0v 779.495n 0.0v 779.505n 0.0v 789.495n 0.0v 789.505n 0.0v 799.495n 0.0v 799.505n 1.7v 809.495n 1.7v 809.505n 1.7v 819.495n 1.7v 819.505n 0.0v 829.495n 0.0v 829.505n 0.0v 839.495n 0.0v 839.505n 0.0v 849.495n 0.0v 849.505n 0.0v 859.495n 0.0v 859.505n 0.0v 869.495n 0.0v 869.505n 0.0v 879.495n 0.0v 879.505n 0.0v 889.495n 0.0v 889.505n 0.0v 899.495n 0.0v 899.505n 0.0v 909.495n 0.0v 909.505n 0.0v 919.495n 0.0v 919.505n 0.0v 929.495n 0.0v 929.505n 0.0v 939.495n 0.0v 939.505n 0.0v 949.495n 0.0v 949.505n 0.0v 959.495n 0.0v 959.505n 0.0v 969.495n 0.0v 969.505n 1.7v 979.495n 1.7v 979.505n 1.7v 989.495n 1.7v 989.505n 0.0v 999.495n 0.0v 999.505n 1.7v 1009.495n 1.7v 1009.505n 0.0v 1019.495n 0.0v 1019.505n 0.0v 1029.495n 0.0v 1029.505n 0.0v 1039.495n 0.0v 1039.505n 0.0v 1049.495n 0.0v 1049.505n 0.0v 1059.495n 0.0v 1059.505n 0.0v 1069.495n 0.0v 1069.505n 1.7v 1079.495n 1.7v 1079.505n 1.7v 1089.495n 1.7v 1089.505n 1.7v 1099.495n 1.7v 1099.505n 0.0v 1109.495n 0.0v 1109.505n 1.7v 1119.495n 1.7v 1119.505n 1.7v 1129.495n 1.7v 1129.505n 0.0v 1139.495n 0.0v 1139.505n 0.0v 1149.495n 0.0v 1149.505n 0.0v 1159.495n 0.0v 1159.505n 0.0v 1169.495n 0.0v 1169.505n 0.0v 1179.495n 0.0v 1179.505n 0.0v 1189.495n 0.0v 1189.505n 0.0v 1199.495n 0.0v 1199.505n 0.0v 1209.495n 0.0v 1209.505n 0.0v 1219.495n 0.0v 1219.505n 0.0v 1229.495n 0.0v 1229.505n 0.0v 1239.495n 0.0v 1239.505n 0.0v 1249.495n 0.0v 1249.505n 0.0v 1259.495n 0.0v 1259.505n 0.0v 1269.495n 0.0v 1269.505n 0.0v 1279.495n 0.0v 1279.505n 0.0v 1289.495n 0.0v 1289.505n 0.0v 1299.495n 0.0v 1299.505n 0.0v 1309.495n 0.0v 1309.505n 0.0v 1319.495n 0.0v 1319.505n 0.0v 1329.495n 0.0v 1329.505n 0.0v 1339.495n 0.0v 1339.505n 0.0v 1349.495n 0.0v 1349.505n 0.0v 1359.495n 0.0v 1359.505n 1.7v 1369.495n 1.7v 1369.505n 0.0v 1379.495n 0.0v 1379.505n 0.0v 1389.495n 0.0v 1389.505n 0.0v 1399.495n 0.0v 1399.505n 0.0v 1409.495n 0.0v 1409.505n 0.0v 1419.495n 0.0v 1419.505n 0.0v 1429.495n 0.0v 1429.505n 0.0v 1439.495n 0.0v 1439.505n 0.0v 1449.495n 0.0v 1449.505n 0.0v 1459.495n 0.0v 1459.505n 0.0v 1469.495n 0.0v 1469.505n 0.0v 1479.495n 0.0v 1479.505n 0.0v 1489.495n 0.0v 1489.505n 0.0v 1499.495n 0.0v 1499.505n 0.0v 1509.495n 0.0v 1509.505n 0.0v 1519.495n 0.0v 1519.505n 0.0v 1529.495n 0.0v 1529.505n 0.0v 1539.495n 0.0v 1539.505n 0.0v 1549.495n 0.0v 1549.505n 0.0v 1559.495n 0.0v 1559.505n 1.7v 1569.495n 1.7v 1569.505n 1.7v 1579.495n 1.7v 1579.505n 0.0v 1589.495n 0.0v 1589.505n 0.0v 1599.495n 0.0v 1599.505n 0.0v 1609.495n 0.0v 1609.505n 0.0v 1619.495n 0.0v 1619.505n 0.0v 1629.495n 0.0v 1629.505n 1.7v 1639.495n 1.7v 1639.505n 1.7v 1649.495n 1.7v 1649.505n 0.0v 1659.495n 0.0v 1659.505n 0.0v 1669.495n 0.0v 1669.505n 0.0v 1679.495n 0.0v 1679.505n 0.0v 1689.495n 0.0v 1689.505n 0.0v 1699.495n 0.0v 1699.505n 0.0v 1709.495n 0.0v 1709.505n 0.0v 1719.495n 0.0v 1719.505n 0.0v 1729.495n 0.0v 1729.505n 0.0v 1739.495n 0.0v 1739.505n 0.0v 1749.495n 0.0v 1749.505n 0.0v 1759.495n 0.0v 1759.505n 0.0v 1769.495n 0.0v 1769.505n 0.0v 1779.495n 0.0v 1779.505n 0.0v 1789.495n 0.0v 1789.505n 0.0v 1799.495n 0.0v 1799.505n 0.0v 1809.495n 0.0v 1809.505n 0.0v 1819.495n 0.0v 1819.505n 0.0v 1829.495n 0.0v 1829.505n 0.0v 1839.495n 0.0v 1839.505n 0.0v 1849.495n 0.0v 1849.505n 0.0v 1859.495n 0.0v 1859.505n 0.0v 1869.495n 0.0v 1869.505n 0.0v 1879.495n 0.0v 1879.505n 0.0v 1889.495n 0.0v 1889.505n 0.0v 1899.495n 0.0v 1899.505n 0.0v 1909.495n 0.0v 1909.505n 0.0v 1919.495n 0.0v 1919.505n 0.0v 1929.495n 0.0v 1929.505n 0.0v 1939.495n 0.0v 1939.505n 0.0v 1949.495n 0.0v 1949.505n 0.0v 1959.495n 0.0v 1959.505n 0.0v 1969.495n 0.0v 1969.505n 0.0v 1979.495n 0.0v 1979.505n 0.0v 1989.495n 0.0v 1989.505n 0.0v 1999.495n 0.0v 1999.505n 0.0v 2009.495n 0.0v 2009.505n 1.7v 2019.495n 1.7v 2019.505n 0.0v 2029.495n 0.0v 2029.505n 0.0v 2039.495n 0.0v 2039.505n 0.0v 2049.495n 0.0v 2049.505n 0.0v )
* (time, data): [(0, 0), (10, 1), (20, 0), (30, 0), (40, 0), (50, 0), (60, 0), (70, 0), (80, 0), (90, 0), (100, 1), (110, 0), (120, 0), (130, 0), (140, 0), (150, 0), (160, 0), (170, 0), (180, 0), (190, 0), (200, 0), (210, 0), (220, 0), (230, 0), (240, 0), (250, 0), (260, 0), (270, 0), (280, 0), (290, 0), (300, 0), (310, 0), (320, 0), (330, 0), (340, 0), (350, 0), (360, 0), (370, 0), (380, 0), (390, 0), (400, 0), (410, 0), (420, 0), (430, 0), (440, 0), (450, 0), (460, 0), (470, 0), (480, 0), (490, 0), (500, 0), (510, 0), (520, 0), (530, 0), (540, 0), (550, 1), (560, 1), (570, 1), (580, 1), (590, 1), (600, 0), (610, 0), (620, 0), (630, 0), (640, 0), (650, 0), (660, 0), (670, 0), (680, 0), (690, 0), (700, 0), (710, 0), (720, 0), (730, 0), (740, 0), (750, 0), (760, 0), (770, 0), (780, 0), (790, 0), (800, 1), (810, 1), (820, 0), (830, 0), (840, 0), (850, 0), (860, 0), (870, 0), (880, 0), (890, 0), (900, 0), (910, 0), (920, 0), (930, 0), (940, 0), (950, 0), (960, 0), (970, 1), (980, 1), (990, 0), (1000, 1), (1010, 0), (1020, 0), (1030, 0), (1040, 0), (1050, 0), (1060, 0), (1070, 1), (1080, 1), (1090, 1), (1100, 0), (1110, 1), (1120, 1), (1130, 0), (1140, 0), (1150, 0), (1160, 0), (1170, 0), (1180, 0), (1190, 0), (1200, 0), (1210, 0), (1220, 0), (1230, 0), (1240, 0), (1250, 0), (1260, 0), (1270, 0), (1280, 0), (1290, 0), (1300, 0), (1310, 0), (1320, 0), (1330, 0), (1340, 0), (1350, 0), (1360, 1), (1370, 0), (1380, 0), (1390, 0), (1400, 0), (1410, 0), (1420, 0), (1430, 0), (1440, 0), (1450, 0), (1460, 0), (1470, 0), (1480, 0), (1490, 0), (1500, 0), (1510, 0), (1520, 0), (1530, 0), (1540, 0), (1550, 0), (1560, 1), (1570, 1), (1580, 0), (1590, 0), (1600, 0), (1610, 0), (1620, 0), (1630, 1), (1640, 1), (1650, 0), (1660, 0), (1670, 0), (1680, 0), (1690, 0), (1700, 0), (1710, 0), (1720, 0), (1730, 0), (1740, 0), (1750, 0), (1760, 0), (1770, 0), (1780, 0), (1790, 0), (1800, 0), (1810, 0), (1820, 0), (1830, 0), (1840, 0), (1850, 0), (1860, 0), (1870, 0), (1880, 0), (1890, 0), (1900, 0), (1910, 0), (1920, 0), (1930, 0), (1940, 0), (1950, 0), (1960, 0), (1970, 0), (1980, 0), (1990, 0), (2000, 0), (2010, 1), (2020, 0), (2030, 0), (2040, 0), (2050, 0)]
Va0_6  a0_6  0 PWL (0n 0.0v 9.495n 0.0v 9.505n 1.7v 19.495n 1.7v 19.505n 0.0v 29.495n 0.0v 29.505n 0.0v 39.495n 0.0v 39.505n 0.0v 49.495n 0.0v 49.505n 0.0v 59.495n 0.0v 59.505n 0.0v 69.495n 0.0v 69.505n 0.0v 79.495n 0.0v 79.505n 0.0v 89.495n 0.0v 89.505n 0.0v 99.495n 0.0v 99.505n 1.7v 109.495n 1.7v 109.505n 0.0v 119.495n 0.0v 119.505n 0.0v 129.495n 0.0v 129.505n 0.0v 139.495n 0.0v 139.505n 0.0v 149.495n 0.0v 149.505n 0.0v 159.495n 0.0v 159.505n 0.0v 169.495n 0.0v 169.505n 0.0v 179.495n 0.0v 179.505n 0.0v 189.495n 0.0v 189.505n 0.0v 199.495n 0.0v 199.505n 0.0v 209.495n 0.0v 209.505n 0.0v 219.495n 0.0v 219.505n 0.0v 229.495n 0.0v 229.505n 0.0v 239.495n 0.0v 239.505n 0.0v 249.495n 0.0v 249.505n 0.0v 259.495n 0.0v 259.505n 0.0v 269.495n 0.0v 269.505n 0.0v 279.495n 0.0v 279.505n 0.0v 289.495n 0.0v 289.505n 0.0v 299.495n 0.0v 299.505n 0.0v 309.495n 0.0v 309.505n 0.0v 319.495n 0.0v 319.505n 0.0v 329.495n 0.0v 329.505n 0.0v 339.495n 0.0v 339.505n 0.0v 349.495n 0.0v 349.505n 0.0v 359.495n 0.0v 359.505n 0.0v 369.495n 0.0v 369.505n 0.0v 379.495n 0.0v 379.505n 0.0v 389.495n 0.0v 389.505n 0.0v 399.495n 0.0v 399.505n 0.0v 409.495n 0.0v 409.505n 0.0v 419.495n 0.0v 419.505n 0.0v 429.495n 0.0v 429.505n 0.0v 439.495n 0.0v 439.505n 0.0v 449.495n 0.0v 449.505n 0.0v 459.495n 0.0v 459.505n 0.0v 469.495n 0.0v 469.505n 0.0v 479.495n 0.0v 479.505n 0.0v 489.495n 0.0v 489.505n 0.0v 499.495n 0.0v 499.505n 0.0v 509.495n 0.0v 509.505n 0.0v 519.495n 0.0v 519.505n 0.0v 529.495n 0.0v 529.505n 0.0v 539.495n 0.0v 539.505n 0.0v 549.495n 0.0v 549.505n 1.7v 559.495n 1.7v 559.505n 1.7v 569.495n 1.7v 569.505n 1.7v 579.495n 1.7v 579.505n 1.7v 589.495n 1.7v 589.505n 1.7v 599.495n 1.7v 599.505n 0.0v 609.495n 0.0v 609.505n 0.0v 619.495n 0.0v 619.505n 0.0v 629.495n 0.0v 629.505n 0.0v 639.495n 0.0v 639.505n 0.0v 649.495n 0.0v 649.505n 0.0v 659.495n 0.0v 659.505n 0.0v 669.495n 0.0v 669.505n 0.0v 679.495n 0.0v 679.505n 0.0v 689.495n 0.0v 689.505n 0.0v 699.495n 0.0v 699.505n 0.0v 709.495n 0.0v 709.505n 0.0v 719.495n 0.0v 719.505n 0.0v 729.495n 0.0v 729.505n 0.0v 739.495n 0.0v 739.505n 0.0v 749.495n 0.0v 749.505n 0.0v 759.495n 0.0v 759.505n 0.0v 769.495n 0.0v 769.505n 0.0v 779.495n 0.0v 779.505n 0.0v 789.495n 0.0v 789.505n 0.0v 799.495n 0.0v 799.505n 1.7v 809.495n 1.7v 809.505n 1.7v 819.495n 1.7v 819.505n 0.0v 829.495n 0.0v 829.505n 0.0v 839.495n 0.0v 839.505n 0.0v 849.495n 0.0v 849.505n 0.0v 859.495n 0.0v 859.505n 0.0v 869.495n 0.0v 869.505n 0.0v 879.495n 0.0v 879.505n 0.0v 889.495n 0.0v 889.505n 0.0v 899.495n 0.0v 899.505n 0.0v 909.495n 0.0v 909.505n 0.0v 919.495n 0.0v 919.505n 0.0v 929.495n 0.0v 929.505n 0.0v 939.495n 0.0v 939.505n 0.0v 949.495n 0.0v 949.505n 0.0v 959.495n 0.0v 959.505n 0.0v 969.495n 0.0v 969.505n 1.7v 979.495n 1.7v 979.505n 1.7v 989.495n 1.7v 989.505n 0.0v 999.495n 0.0v 999.505n 1.7v 1009.495n 1.7v 1009.505n 0.0v 1019.495n 0.0v 1019.505n 0.0v 1029.495n 0.0v 1029.505n 0.0v 1039.495n 0.0v 1039.505n 0.0v 1049.495n 0.0v 1049.505n 0.0v 1059.495n 0.0v 1059.505n 0.0v 1069.495n 0.0v 1069.505n 1.7v 1079.495n 1.7v 1079.505n 1.7v 1089.495n 1.7v 1089.505n 1.7v 1099.495n 1.7v 1099.505n 0.0v 1109.495n 0.0v 1109.505n 1.7v 1119.495n 1.7v 1119.505n 1.7v 1129.495n 1.7v 1129.505n 0.0v 1139.495n 0.0v 1139.505n 0.0v 1149.495n 0.0v 1149.505n 0.0v 1159.495n 0.0v 1159.505n 0.0v 1169.495n 0.0v 1169.505n 0.0v 1179.495n 0.0v 1179.505n 0.0v 1189.495n 0.0v 1189.505n 0.0v 1199.495n 0.0v 1199.505n 0.0v 1209.495n 0.0v 1209.505n 0.0v 1219.495n 0.0v 1219.505n 0.0v 1229.495n 0.0v 1229.505n 0.0v 1239.495n 0.0v 1239.505n 0.0v 1249.495n 0.0v 1249.505n 0.0v 1259.495n 0.0v 1259.505n 0.0v 1269.495n 0.0v 1269.505n 0.0v 1279.495n 0.0v 1279.505n 0.0v 1289.495n 0.0v 1289.505n 0.0v 1299.495n 0.0v 1299.505n 0.0v 1309.495n 0.0v 1309.505n 0.0v 1319.495n 0.0v 1319.505n 0.0v 1329.495n 0.0v 1329.505n 0.0v 1339.495n 0.0v 1339.505n 0.0v 1349.495n 0.0v 1349.505n 0.0v 1359.495n 0.0v 1359.505n 1.7v 1369.495n 1.7v 1369.505n 0.0v 1379.495n 0.0v 1379.505n 0.0v 1389.495n 0.0v 1389.505n 0.0v 1399.495n 0.0v 1399.505n 0.0v 1409.495n 0.0v 1409.505n 0.0v 1419.495n 0.0v 1419.505n 0.0v 1429.495n 0.0v 1429.505n 0.0v 1439.495n 0.0v 1439.505n 0.0v 1449.495n 0.0v 1449.505n 0.0v 1459.495n 0.0v 1459.505n 0.0v 1469.495n 0.0v 1469.505n 0.0v 1479.495n 0.0v 1479.505n 0.0v 1489.495n 0.0v 1489.505n 0.0v 1499.495n 0.0v 1499.505n 0.0v 1509.495n 0.0v 1509.505n 0.0v 1519.495n 0.0v 1519.505n 0.0v 1529.495n 0.0v 1529.505n 0.0v 1539.495n 0.0v 1539.505n 0.0v 1549.495n 0.0v 1549.505n 0.0v 1559.495n 0.0v 1559.505n 1.7v 1569.495n 1.7v 1569.505n 1.7v 1579.495n 1.7v 1579.505n 0.0v 1589.495n 0.0v 1589.505n 0.0v 1599.495n 0.0v 1599.505n 0.0v 1609.495n 0.0v 1609.505n 0.0v 1619.495n 0.0v 1619.505n 0.0v 1629.495n 0.0v 1629.505n 1.7v 1639.495n 1.7v 1639.505n 1.7v 1649.495n 1.7v 1649.505n 0.0v 1659.495n 0.0v 1659.505n 0.0v 1669.495n 0.0v 1669.505n 0.0v 1679.495n 0.0v 1679.505n 0.0v 1689.495n 0.0v 1689.505n 0.0v 1699.495n 0.0v 1699.505n 0.0v 1709.495n 0.0v 1709.505n 0.0v 1719.495n 0.0v 1719.505n 0.0v 1729.495n 0.0v 1729.505n 0.0v 1739.495n 0.0v 1739.505n 0.0v 1749.495n 0.0v 1749.505n 0.0v 1759.495n 0.0v 1759.505n 0.0v 1769.495n 0.0v 1769.505n 0.0v 1779.495n 0.0v 1779.505n 0.0v 1789.495n 0.0v 1789.505n 0.0v 1799.495n 0.0v 1799.505n 0.0v 1809.495n 0.0v 1809.505n 0.0v 1819.495n 0.0v 1819.505n 0.0v 1829.495n 0.0v 1829.505n 0.0v 1839.495n 0.0v 1839.505n 0.0v 1849.495n 0.0v 1849.505n 0.0v 1859.495n 0.0v 1859.505n 0.0v 1869.495n 0.0v 1869.505n 0.0v 1879.495n 0.0v 1879.505n 0.0v 1889.495n 0.0v 1889.505n 0.0v 1899.495n 0.0v 1899.505n 0.0v 1909.495n 0.0v 1909.505n 0.0v 1919.495n 0.0v 1919.505n 0.0v 1929.495n 0.0v 1929.505n 0.0v 1939.495n 0.0v 1939.505n 0.0v 1949.495n 0.0v 1949.505n 0.0v 1959.495n 0.0v 1959.505n 0.0v 1969.495n 0.0v 1969.505n 0.0v 1979.495n 0.0v 1979.505n 0.0v 1989.495n 0.0v 1989.505n 0.0v 1999.495n 0.0v 1999.505n 0.0v 2009.495n 0.0v 2009.505n 1.7v 2019.495n 1.7v 2019.505n 0.0v 2029.495n 0.0v 2029.505n 0.0v 2039.495n 0.0v 2039.505n 0.0v 2049.495n 0.0v 2049.505n 0.0v )
* (time, data): [(0, 0), (10, 0), (20, 1), (30, 0), (40, 0), (50, 0), (60, 1), (70, 1), (80, 1), (90, 1), (100, 0), (110, 0), (120, 0), (130, 0), (140, 0), (150, 1), (160, 1), (170, 1), (180, 1), (190, 0), (200, 0), (210, 1), (220, 1), (230, 1), (240, 1), (250, 1), (260, 1), (270, 1), (280, 0), (290, 0), (300, 0), (310, 0), (320, 0), (330, 0), (340, 0), (350, 0), (360, 0), (370, 0), (380, 0), (390, 0), (400, 0), (410, 0), (420, 0), (430, 0), (440, 1), (450, 1), (460, 0), (470, 0), (480, 0), (490, 0), (500, 0), (510, 0), (520, 0), (530, 0), (540, 0), (550, 0), (560, 0), (570, 0), (580, 0), (590, 0), (600, 1), (610, 0), (620, 1), (630, 0), (640, 0), (650, 0), (660, 0), (670, 0), (680, 0), (690, 0), (700, 0), (710, 0), (720, 0), (730, 0), (740, 0), (750, 0), (760, 0), (770, 0), (780, 1), (790, 0), (800, 0), (810, 0), (820, 1), (830, 0), (840, 0), (850, 0), (860, 1), (870, 0), (880, 0), (890, 0), (900, 0), (910, 0), (920, 0), (930, 0), (940, 0), (950, 0), (960, 0), (970, 0), (980, 0), (990, 1), (1000, 0), (1010, 0), (1020, 0), (1030, 0), (1040, 0), (1050, 0), (1060, 0), (1070, 0), (1080, 0), (1090, 0), (1100, 1), (1110, 0), (1120, 0), (1130, 1), (1140, 0), (1150, 1), (1160, 1), (1170, 0), (1180, 0), (1190, 0), (1200, 0), (1210, 0), (1220, 0), (1230, 0), (1240, 0), (1250, 1), (1260, 1), (1270, 1), (1280, 1), (1290, 0), (1300, 0), (1310, 0), (1320, 0), (1330, 0), (1340, 0), (1350, 0), (1360, 0), (1370, 0), (1380, 0), (1390, 0), (1400, 1), (1410, 1), (1420, 1), (1430, 1), (1440, 1), (1450, 1), (1460, 1), (1470, 1), (1480, 1), (1490, 1), (1500, 0), (1510, 0), (1520, 0), (1530, 0), (1540, 0), (1550, 0), (1560, 0), (1570, 0), (1580, 0), (1590, 0), (1600, 0), (1610, 0), (1620, 1), (1630, 0), (1640, 0), (1650, 1), (1660, 1), (1670, 1), (1680, 1), (1690, 1), (1700, 1), (1710, 0), (1720, 0), (1730, 0), (1740, 0), (1750, 1), (1760, 1), (1770, 1), (1780, 0), (1790, 0), (1800, 1), (1810, 1), (1820, 1), (1830, 1), (1840, 0), (1850, 0), (1860, 0), (1870, 0), (1880, 0), (1890, 0), (1900, 0), (1910, 0), (1920, 1), (1930, 1), (1940, 0), (1950, 0), (1960, 0), (1970, 1), (1980, 0), (1990, 0), (2000, 0), (2010, 0), (2020, 0), (2030, 0), (2040, 0), (2050, 0)]
Va0_7  a0_7  0 PWL (0n 0.0v 9.495n 0.0v 9.505n 0.0v 19.495n 0.0v 19.505n 1.7v 29.495n 1.7v 29.505n 0.0v 39.495n 0.0v 39.505n 0.0v 49.495n 0.0v 49.505n 0.0v 59.495n 0.0v 59.505n 1.7v 69.495n 1.7v 69.505n 1.7v 79.495n 1.7v 79.505n 1.7v 89.495n 1.7v 89.505n 1.7v 99.495n 1.7v 99.505n 0.0v 109.495n 0.0v 109.505n 0.0v 119.495n 0.0v 119.505n 0.0v 129.495n 0.0v 129.505n 0.0v 139.495n 0.0v 139.505n 0.0v 149.495n 0.0v 149.505n 1.7v 159.495n 1.7v 159.505n 1.7v 169.495n 1.7v 169.505n 1.7v 179.495n 1.7v 179.505n 1.7v 189.495n 1.7v 189.505n 0.0v 199.495n 0.0v 199.505n 0.0v 209.495n 0.0v 209.505n 1.7v 219.495n 1.7v 219.505n 1.7v 229.495n 1.7v 229.505n 1.7v 239.495n 1.7v 239.505n 1.7v 249.495n 1.7v 249.505n 1.7v 259.495n 1.7v 259.505n 1.7v 269.495n 1.7v 269.505n 1.7v 279.495n 1.7v 279.505n 0.0v 289.495n 0.0v 289.505n 0.0v 299.495n 0.0v 299.505n 0.0v 309.495n 0.0v 309.505n 0.0v 319.495n 0.0v 319.505n 0.0v 329.495n 0.0v 329.505n 0.0v 339.495n 0.0v 339.505n 0.0v 349.495n 0.0v 349.505n 0.0v 359.495n 0.0v 359.505n 0.0v 369.495n 0.0v 369.505n 0.0v 379.495n 0.0v 379.505n 0.0v 389.495n 0.0v 389.505n 0.0v 399.495n 0.0v 399.505n 0.0v 409.495n 0.0v 409.505n 0.0v 419.495n 0.0v 419.505n 0.0v 429.495n 0.0v 429.505n 0.0v 439.495n 0.0v 439.505n 1.7v 449.495n 1.7v 449.505n 1.7v 459.495n 1.7v 459.505n 0.0v 469.495n 0.0v 469.505n 0.0v 479.495n 0.0v 479.505n 0.0v 489.495n 0.0v 489.505n 0.0v 499.495n 0.0v 499.505n 0.0v 509.495n 0.0v 509.505n 0.0v 519.495n 0.0v 519.505n 0.0v 529.495n 0.0v 529.505n 0.0v 539.495n 0.0v 539.505n 0.0v 549.495n 0.0v 549.505n 0.0v 559.495n 0.0v 559.505n 0.0v 569.495n 0.0v 569.505n 0.0v 579.495n 0.0v 579.505n 0.0v 589.495n 0.0v 589.505n 0.0v 599.495n 0.0v 599.505n 1.7v 609.495n 1.7v 609.505n 0.0v 619.495n 0.0v 619.505n 1.7v 629.495n 1.7v 629.505n 0.0v 639.495n 0.0v 639.505n 0.0v 649.495n 0.0v 649.505n 0.0v 659.495n 0.0v 659.505n 0.0v 669.495n 0.0v 669.505n 0.0v 679.495n 0.0v 679.505n 0.0v 689.495n 0.0v 689.505n 0.0v 699.495n 0.0v 699.505n 0.0v 709.495n 0.0v 709.505n 0.0v 719.495n 0.0v 719.505n 0.0v 729.495n 0.0v 729.505n 0.0v 739.495n 0.0v 739.505n 0.0v 749.495n 0.0v 749.505n 0.0v 759.495n 0.0v 759.505n 0.0v 769.495n 0.0v 769.505n 0.0v 779.495n 0.0v 779.505n 1.7v 789.495n 1.7v 789.505n 0.0v 799.495n 0.0v 799.505n 0.0v 809.495n 0.0v 809.505n 0.0v 819.495n 0.0v 819.505n 1.7v 829.495n 1.7v 829.505n 0.0v 839.495n 0.0v 839.505n 0.0v 849.495n 0.0v 849.505n 0.0v 859.495n 0.0v 859.505n 1.7v 869.495n 1.7v 869.505n 0.0v 879.495n 0.0v 879.505n 0.0v 889.495n 0.0v 889.505n 0.0v 899.495n 0.0v 899.505n 0.0v 909.495n 0.0v 909.505n 0.0v 919.495n 0.0v 919.505n 0.0v 929.495n 0.0v 929.505n 0.0v 939.495n 0.0v 939.505n 0.0v 949.495n 0.0v 949.505n 0.0v 959.495n 0.0v 959.505n 0.0v 969.495n 0.0v 969.505n 0.0v 979.495n 0.0v 979.505n 0.0v 989.495n 0.0v 989.505n 1.7v 999.495n 1.7v 999.505n 0.0v 1009.495n 0.0v 1009.505n 0.0v 1019.495n 0.0v 1019.505n 0.0v 1029.495n 0.0v 1029.505n 0.0v 1039.495n 0.0v 1039.505n 0.0v 1049.495n 0.0v 1049.505n 0.0v 1059.495n 0.0v 1059.505n 0.0v 1069.495n 0.0v 1069.505n 0.0v 1079.495n 0.0v 1079.505n 0.0v 1089.495n 0.0v 1089.505n 0.0v 1099.495n 0.0v 1099.505n 1.7v 1109.495n 1.7v 1109.505n 0.0v 1119.495n 0.0v 1119.505n 0.0v 1129.495n 0.0v 1129.505n 1.7v 1139.495n 1.7v 1139.505n 0.0v 1149.495n 0.0v 1149.505n 1.7v 1159.495n 1.7v 1159.505n 1.7v 1169.495n 1.7v 1169.505n 0.0v 1179.495n 0.0v 1179.505n 0.0v 1189.495n 0.0v 1189.505n 0.0v 1199.495n 0.0v 1199.505n 0.0v 1209.495n 0.0v 1209.505n 0.0v 1219.495n 0.0v 1219.505n 0.0v 1229.495n 0.0v 1229.505n 0.0v 1239.495n 0.0v 1239.505n 0.0v 1249.495n 0.0v 1249.505n 1.7v 1259.495n 1.7v 1259.505n 1.7v 1269.495n 1.7v 1269.505n 1.7v 1279.495n 1.7v 1279.505n 1.7v 1289.495n 1.7v 1289.505n 0.0v 1299.495n 0.0v 1299.505n 0.0v 1309.495n 0.0v 1309.505n 0.0v 1319.495n 0.0v 1319.505n 0.0v 1329.495n 0.0v 1329.505n 0.0v 1339.495n 0.0v 1339.505n 0.0v 1349.495n 0.0v 1349.505n 0.0v 1359.495n 0.0v 1359.505n 0.0v 1369.495n 0.0v 1369.505n 0.0v 1379.495n 0.0v 1379.505n 0.0v 1389.495n 0.0v 1389.505n 0.0v 1399.495n 0.0v 1399.505n 1.7v 1409.495n 1.7v 1409.505n 1.7v 1419.495n 1.7v 1419.505n 1.7v 1429.495n 1.7v 1429.505n 1.7v 1439.495n 1.7v 1439.505n 1.7v 1449.495n 1.7v 1449.505n 1.7v 1459.495n 1.7v 1459.505n 1.7v 1469.495n 1.7v 1469.505n 1.7v 1479.495n 1.7v 1479.505n 1.7v 1489.495n 1.7v 1489.505n 1.7v 1499.495n 1.7v 1499.505n 0.0v 1509.495n 0.0v 1509.505n 0.0v 1519.495n 0.0v 1519.505n 0.0v 1529.495n 0.0v 1529.505n 0.0v 1539.495n 0.0v 1539.505n 0.0v 1549.495n 0.0v 1549.505n 0.0v 1559.495n 0.0v 1559.505n 0.0v 1569.495n 0.0v 1569.505n 0.0v 1579.495n 0.0v 1579.505n 0.0v 1589.495n 0.0v 1589.505n 0.0v 1599.495n 0.0v 1599.505n 0.0v 1609.495n 0.0v 1609.505n 0.0v 1619.495n 0.0v 1619.505n 1.7v 1629.495n 1.7v 1629.505n 0.0v 1639.495n 0.0v 1639.505n 0.0v 1649.495n 0.0v 1649.505n 1.7v 1659.495n 1.7v 1659.505n 1.7v 1669.495n 1.7v 1669.505n 1.7v 1679.495n 1.7v 1679.505n 1.7v 1689.495n 1.7v 1689.505n 1.7v 1699.495n 1.7v 1699.505n 1.7v 1709.495n 1.7v 1709.505n 0.0v 1719.495n 0.0v 1719.505n 0.0v 1729.495n 0.0v 1729.505n 0.0v 1739.495n 0.0v 1739.505n 0.0v 1749.495n 0.0v 1749.505n 1.7v 1759.495n 1.7v 1759.505n 1.7v 1769.495n 1.7v 1769.505n 1.7v 1779.495n 1.7v 1779.505n 0.0v 1789.495n 0.0v 1789.505n 0.0v 1799.495n 0.0v 1799.505n 1.7v 1809.495n 1.7v 1809.505n 1.7v 1819.495n 1.7v 1819.505n 1.7v 1829.495n 1.7v 1829.505n 1.7v 1839.495n 1.7v 1839.505n 0.0v 1849.495n 0.0v 1849.505n 0.0v 1859.495n 0.0v 1859.505n 0.0v 1869.495n 0.0v 1869.505n 0.0v 1879.495n 0.0v 1879.505n 0.0v 1889.495n 0.0v 1889.505n 0.0v 1899.495n 0.0v 1899.505n 0.0v 1909.495n 0.0v 1909.505n 0.0v 1919.495n 0.0v 1919.505n 1.7v 1929.495n 1.7v 1929.505n 1.7v 1939.495n 1.7v 1939.505n 0.0v 1949.495n 0.0v 1949.505n 0.0v 1959.495n 0.0v 1959.505n 0.0v 1969.495n 0.0v 1969.505n 1.7v 1979.495n 1.7v 1979.505n 0.0v 1989.495n 0.0v 1989.505n 0.0v 1999.495n 0.0v 1999.505n 0.0v 2009.495n 0.0v 2009.505n 0.0v 2019.495n 0.0v 2019.505n 0.0v 2029.495n 0.0v 2029.505n 0.0v 2039.495n 0.0v 2039.505n 0.0v 2049.495n 0.0v 2049.505n 0.0v )
* (time, data): [(0, 0), (10, 0), (20, 0), (30, 0), (40, 0), (50, 1), (60, 1), (70, 1), (80, 1), (90, 1), (100, 0), (110, 0), (120, 0), (130, 1), (140, 0), (150, 1), (160, 1), (170, 1), (180, 1), (190, 0), (200, 1), (210, 1), (220, 1), (230, 1), (240, 1), (250, 1), (260, 1), (270, 0), (280, 0), (290, 0), (300, 1), (310, 1), (320, 1), (330, 0), (340, 1), (350, 1), (360, 1), (370, 0), (380, 0), (390, 0), (400, 0), (410, 1), (420, 1), (430, 1), (440, 1), (450, 1), (460, 1), (470, 0), (480, 0), (490, 1), (500, 1), (510, 0), (520, 0), (530, 0), (540, 0), (550, 0), (560, 0), (570, 1), (580, 1), (590, 1), (600, 1), (610, 1), (620, 1), (630, 0), (640, 0), (650, 0), (660, 1), (670, 0), (680, 0), (690, 1), (700, 1), (710, 1), (720, 1), (730, 1), (740, 0), (750, 1), (760, 0), (770, 0), (780, 0), (790, 0), (800, 0), (810, 0), (820, 1), (830, 1), (840, 1), (850, 1), (860, 1), (870, 0), (880, 0), (890, 0), (900, 0), (910, 1), (920, 1), (930, 1), (940, 1), (950, 0), (960, 0), (970, 0), (980, 0), (990, 1), (1000, 1), (1010, 1), (1020, 1), (1030, 1), (1040, 1), (1050, 1), (1060, 1), (1070, 0), (1080, 0), (1090, 0), (1100, 0), (1110, 0), (1120, 1), (1130, 1), (1140, 0), (1150, 1), (1160, 0), (1170, 0), (1180, 0), (1190, 0), (1200, 0), (1210, 0), (1220, 0), (1230, 0), (1240, 0), (1250, 0), (1260, 1), (1270, 0), (1280, 1), (1290, 1), (1300, 1), (1310, 1), (1320, 1), (1330, 1), (1340, 1), (1350, 0), (1360, 0), (1370, 0), (1380, 0), (1390, 1), (1400, 1), (1410, 1), (1420, 1), (1430, 1), (1440, 1), (1450, 0), (1460, 0), (1470, 0), (1480, 0), (1490, 1), (1500, 1), (1510, 1), (1520, 0), (1530, 0), (1540, 0), (1550, 1), (1560, 1), (1570, 1), (1580, 1), (1590, 0), (1600, 1), (1610, 0), (1620, 0), (1630, 0), (1640, 0), (1650, 1), (1660, 1), (1670, 1), (1680, 1), (1690, 1), (1700, 0), (1710, 0), (1720, 0), (1730, 0), (1740, 0), (1750, 0), (1760, 1), (1770, 1), (1780, 1), (1790, 1), (1800, 1), (1810, 1), (1820, 1), (1830, 0), (1840, 0), (1850, 0), (1860, 0), (1870, 0), (1880, 1), (1890, 1), (1900, 1), (1910, 1), (1920, 1), (1930, 1), (1940, 1), (1950, 1), (1960, 1), (1970, 1), (1980, 1), (1990, 0), (2000, 0), (2010, 0), (2020, 0), (2030, 0), (2040, 0), (2050, 0)]
Va1_0  a1_0  0 PWL (0n 0.0v 9.495n 0.0v 9.505n 0.0v 19.495n 0.0v 19.505n 0.0v 29.495n 0.0v 29.505n 0.0v 39.495n 0.0v 39.505n 0.0v 49.495n 0.0v 49.505n 1.7v 59.495n 1.7v 59.505n 1.7v 69.495n 1.7v 69.505n 1.7v 79.495n 1.7v 79.505n 1.7v 89.495n 1.7v 89.505n 1.7v 99.495n 1.7v 99.505n 0.0v 109.495n 0.0v 109.505n 0.0v 119.495n 0.0v 119.505n 0.0v 129.495n 0.0v 129.505n 1.7v 139.495n 1.7v 139.505n 0.0v 149.495n 0.0v 149.505n 1.7v 159.495n 1.7v 159.505n 1.7v 169.495n 1.7v 169.505n 1.7v 179.495n 1.7v 179.505n 1.7v 189.495n 1.7v 189.505n 0.0v 199.495n 0.0v 199.505n 1.7v 209.495n 1.7v 209.505n 1.7v 219.495n 1.7v 219.505n 1.7v 229.495n 1.7v 229.505n 1.7v 239.495n 1.7v 239.505n 1.7v 249.495n 1.7v 249.505n 1.7v 259.495n 1.7v 259.505n 1.7v 269.495n 1.7v 269.505n 0.0v 279.495n 0.0v 279.505n 0.0v 289.495n 0.0v 289.505n 0.0v 299.495n 0.0v 299.505n 1.7v 309.495n 1.7v 309.505n 1.7v 319.495n 1.7v 319.505n 1.7v 329.495n 1.7v 329.505n 0.0v 339.495n 0.0v 339.505n 1.7v 349.495n 1.7v 349.505n 1.7v 359.495n 1.7v 359.505n 1.7v 369.495n 1.7v 369.505n 0.0v 379.495n 0.0v 379.505n 0.0v 389.495n 0.0v 389.505n 0.0v 399.495n 0.0v 399.505n 0.0v 409.495n 0.0v 409.505n 1.7v 419.495n 1.7v 419.505n 1.7v 429.495n 1.7v 429.505n 1.7v 439.495n 1.7v 439.505n 1.7v 449.495n 1.7v 449.505n 1.7v 459.495n 1.7v 459.505n 1.7v 469.495n 1.7v 469.505n 0.0v 479.495n 0.0v 479.505n 0.0v 489.495n 0.0v 489.505n 1.7v 499.495n 1.7v 499.505n 1.7v 509.495n 1.7v 509.505n 0.0v 519.495n 0.0v 519.505n 0.0v 529.495n 0.0v 529.505n 0.0v 539.495n 0.0v 539.505n 0.0v 549.495n 0.0v 549.505n 0.0v 559.495n 0.0v 559.505n 0.0v 569.495n 0.0v 569.505n 1.7v 579.495n 1.7v 579.505n 1.7v 589.495n 1.7v 589.505n 1.7v 599.495n 1.7v 599.505n 1.7v 609.495n 1.7v 609.505n 1.7v 619.495n 1.7v 619.505n 1.7v 629.495n 1.7v 629.505n 0.0v 639.495n 0.0v 639.505n 0.0v 649.495n 0.0v 649.505n 0.0v 659.495n 0.0v 659.505n 1.7v 669.495n 1.7v 669.505n 0.0v 679.495n 0.0v 679.505n 0.0v 689.495n 0.0v 689.505n 1.7v 699.495n 1.7v 699.505n 1.7v 709.495n 1.7v 709.505n 1.7v 719.495n 1.7v 719.505n 1.7v 729.495n 1.7v 729.505n 1.7v 739.495n 1.7v 739.505n 0.0v 749.495n 0.0v 749.505n 1.7v 759.495n 1.7v 759.505n 0.0v 769.495n 0.0v 769.505n 0.0v 779.495n 0.0v 779.505n 0.0v 789.495n 0.0v 789.505n 0.0v 799.495n 0.0v 799.505n 0.0v 809.495n 0.0v 809.505n 0.0v 819.495n 0.0v 819.505n 1.7v 829.495n 1.7v 829.505n 1.7v 839.495n 1.7v 839.505n 1.7v 849.495n 1.7v 849.505n 1.7v 859.495n 1.7v 859.505n 1.7v 869.495n 1.7v 869.505n 0.0v 879.495n 0.0v 879.505n 0.0v 889.495n 0.0v 889.505n 0.0v 899.495n 0.0v 899.505n 0.0v 909.495n 0.0v 909.505n 1.7v 919.495n 1.7v 919.505n 1.7v 929.495n 1.7v 929.505n 1.7v 939.495n 1.7v 939.505n 1.7v 949.495n 1.7v 949.505n 0.0v 959.495n 0.0v 959.505n 0.0v 969.495n 0.0v 969.505n 0.0v 979.495n 0.0v 979.505n 0.0v 989.495n 0.0v 989.505n 1.7v 999.495n 1.7v 999.505n 1.7v 1009.495n 1.7v 1009.505n 1.7v 1019.495n 1.7v 1019.505n 1.7v 1029.495n 1.7v 1029.505n 1.7v 1039.495n 1.7v 1039.505n 1.7v 1049.495n 1.7v 1049.505n 1.7v 1059.495n 1.7v 1059.505n 1.7v 1069.495n 1.7v 1069.505n 0.0v 1079.495n 0.0v 1079.505n 0.0v 1089.495n 0.0v 1089.505n 0.0v 1099.495n 0.0v 1099.505n 0.0v 1109.495n 0.0v 1109.505n 0.0v 1119.495n 0.0v 1119.505n 1.7v 1129.495n 1.7v 1129.505n 1.7v 1139.495n 1.7v 1139.505n 0.0v 1149.495n 0.0v 1149.505n 1.7v 1159.495n 1.7v 1159.505n 0.0v 1169.495n 0.0v 1169.505n 0.0v 1179.495n 0.0v 1179.505n 0.0v 1189.495n 0.0v 1189.505n 0.0v 1199.495n 0.0v 1199.505n 0.0v 1209.495n 0.0v 1209.505n 0.0v 1219.495n 0.0v 1219.505n 0.0v 1229.495n 0.0v 1229.505n 0.0v 1239.495n 0.0v 1239.505n 0.0v 1249.495n 0.0v 1249.505n 0.0v 1259.495n 0.0v 1259.505n 1.7v 1269.495n 1.7v 1269.505n 0.0v 1279.495n 0.0v 1279.505n 1.7v 1289.495n 1.7v 1289.505n 1.7v 1299.495n 1.7v 1299.505n 1.7v 1309.495n 1.7v 1309.505n 1.7v 1319.495n 1.7v 1319.505n 1.7v 1329.495n 1.7v 1329.505n 1.7v 1339.495n 1.7v 1339.505n 1.7v 1349.495n 1.7v 1349.505n 0.0v 1359.495n 0.0v 1359.505n 0.0v 1369.495n 0.0v 1369.505n 0.0v 1379.495n 0.0v 1379.505n 0.0v 1389.495n 0.0v 1389.505n 1.7v 1399.495n 1.7v 1399.505n 1.7v 1409.495n 1.7v 1409.505n 1.7v 1419.495n 1.7v 1419.505n 1.7v 1429.495n 1.7v 1429.505n 1.7v 1439.495n 1.7v 1439.505n 1.7v 1449.495n 1.7v 1449.505n 0.0v 1459.495n 0.0v 1459.505n 0.0v 1469.495n 0.0v 1469.505n 0.0v 1479.495n 0.0v 1479.505n 0.0v 1489.495n 0.0v 1489.505n 1.7v 1499.495n 1.7v 1499.505n 1.7v 1509.495n 1.7v 1509.505n 1.7v 1519.495n 1.7v 1519.505n 0.0v 1529.495n 0.0v 1529.505n 0.0v 1539.495n 0.0v 1539.505n 0.0v 1549.495n 0.0v 1549.505n 1.7v 1559.495n 1.7v 1559.505n 1.7v 1569.495n 1.7v 1569.505n 1.7v 1579.495n 1.7v 1579.505n 1.7v 1589.495n 1.7v 1589.505n 0.0v 1599.495n 0.0v 1599.505n 1.7v 1609.495n 1.7v 1609.505n 0.0v 1619.495n 0.0v 1619.505n 0.0v 1629.495n 0.0v 1629.505n 0.0v 1639.495n 0.0v 1639.505n 0.0v 1649.495n 0.0v 1649.505n 1.7v 1659.495n 1.7v 1659.505n 1.7v 1669.495n 1.7v 1669.505n 1.7v 1679.495n 1.7v 1679.505n 1.7v 1689.495n 1.7v 1689.505n 1.7v 1699.495n 1.7v 1699.505n 0.0v 1709.495n 0.0v 1709.505n 0.0v 1719.495n 0.0v 1719.505n 0.0v 1729.495n 0.0v 1729.505n 0.0v 1739.495n 0.0v 1739.505n 0.0v 1749.495n 0.0v 1749.505n 0.0v 1759.495n 0.0v 1759.505n 1.7v 1769.495n 1.7v 1769.505n 1.7v 1779.495n 1.7v 1779.505n 1.7v 1789.495n 1.7v 1789.505n 1.7v 1799.495n 1.7v 1799.505n 1.7v 1809.495n 1.7v 1809.505n 1.7v 1819.495n 1.7v 1819.505n 1.7v 1829.495n 1.7v 1829.505n 0.0v 1839.495n 0.0v 1839.505n 0.0v 1849.495n 0.0v 1849.505n 0.0v 1859.495n 0.0v 1859.505n 0.0v 1869.495n 0.0v 1869.505n 0.0v 1879.495n 0.0v 1879.505n 1.7v 1889.495n 1.7v 1889.505n 1.7v 1899.495n 1.7v 1899.505n 1.7v 1909.495n 1.7v 1909.505n 1.7v 1919.495n 1.7v 1919.505n 1.7v 1929.495n 1.7v 1929.505n 1.7v 1939.495n 1.7v 1939.505n 1.7v 1949.495n 1.7v 1949.505n 1.7v 1959.495n 1.7v 1959.505n 1.7v 1969.495n 1.7v 1969.505n 1.7v 1979.495n 1.7v 1979.505n 1.7v 1989.495n 1.7v 1989.505n 0.0v 1999.495n 0.0v 1999.505n 0.0v 2009.495n 0.0v 2009.505n 0.0v 2019.495n 0.0v 2019.505n 0.0v 2029.495n 0.0v 2029.505n 0.0v 2039.495n 0.0v 2039.505n 0.0v 2049.495n 0.0v 2049.505n 0.0v )
* (time, data): [(0, 0), (10, 0), (20, 0), (30, 0), (40, 0), (50, 0), (60, 0), (70, 0), (80, 0), (90, 0), (100, 0), (110, 0), (120, 0), (130, 0), (140, 0), (150, 1), (160, 1), (170, 1), (180, 1), (190, 0), (200, 1), (210, 1), (220, 1), (230, 1), (240, 0), (250, 1), (260, 1), (270, 0), (280, 0), (290, 0), (300, 0), (310, 0), (320, 0), (330, 0), (340, 0), (350, 0), (360, 0), (370, 0), (380, 0), (390, 0), (400, 0), (410, 0), (420, 0), (430, 1), (440, 1), (450, 1), (460, 1), (470, 0), (480, 0), (490, 0), (500, 0), (510, 0), (520, 0), (530, 0), (540, 0), (550, 0), (560, 0), (570, 0), (580, 0), (590, 0), (600, 1), (610, 1), (620, 1), (630, 0), (640, 0), (650, 0), (660, 0), (670, 0), (680, 0), (690, 0), (700, 0), (710, 0), (720, 0), (730, 0), (740, 0), (750, 1), (760, 0), (770, 0), (780, 0), (790, 0), (800, 0), (810, 0), (820, 1), (830, 1), (840, 1), (850, 1), (860, 0), (870, 0), (880, 0), (890, 0), (900, 0), (910, 0), (920, 0), (930, 0), (940, 0), (950, 0), (960, 0), (970, 0), (980, 0), (990, 1), (1000, 1), (1010, 1), (1020, 1), (1030, 1), (1040, 1), (1050, 1), (1060, 1), (1070, 0), (1080, 0), (1090, 0), (1100, 0), (1110, 0), (1120, 1), (1130, 1), (1140, 0), (1150, 0), (1160, 0), (1170, 0), (1180, 0), (1190, 0), (1200, 0), (1210, 0), (1220, 0), (1230, 0), (1240, 0), (1250, 0), (1260, 0), (1270, 0), (1280, 0), (1290, 0), (1300, 1), (1310, 1), (1320, 1), (1330, 1), (1340, 1), (1350, 0), (1360, 0), (1370, 0), (1380, 0), (1390, 1), (1400, 1), (1410, 1), (1420, 0), (1430, 0), (1440, 0), (1450, 0), (1460, 0), (1470, 0), (1480, 0), (1490, 1), (1500, 1), (1510, 1), (1520, 0), (1530, 0), (1540, 0), (1550, 1), (1560, 1), (1570, 1), (1580, 1), (1590, 0), (1600, 0), (1610, 0), (1620, 0), (1630, 0), (1640, 0), (1650, 0), (1660, 0), (1670, 1), (1680, 0), (1690, 0), (1700, 0), (1710, 0), (1720, 0), (1730, 0), (1740, 0), (1750, 0), (1760, 1), (1770, 1), (1780, 0), (1790, 0), (1800, 0), (1810, 0), (1820, 0), (1830, 0), (1840, 0), (1850, 0), (1860, 0), (1870, 0), (1880, 0), (1890, 0), (1900, 0), (1910, 0), (1920, 0), (1930, 0), (1940, 1), (1950, 1), (1960, 1), (1970, 1), (1980, 1), (1990, 0), (2000, 0), (2010, 0), (2020, 0), (2030, 0), (2040, 0), (2050, 0)]
Va1_1  a1_1  0 PWL (0n 0.0v 9.495n 0.0v 9.505n 0.0v 19.495n 0.0v 19.505n 0.0v 29.495n 0.0v 29.505n 0.0v 39.495n 0.0v 39.505n 0.0v 49.495n 0.0v 49.505n 0.0v 59.495n 0.0v 59.505n 0.0v 69.495n 0.0v 69.505n 0.0v 79.495n 0.0v 79.505n 0.0v 89.495n 0.0v 89.505n 0.0v 99.495n 0.0v 99.505n 0.0v 109.495n 0.0v 109.505n 0.0v 119.495n 0.0v 119.505n 0.0v 129.495n 0.0v 129.505n 0.0v 139.495n 0.0v 139.505n 0.0v 149.495n 0.0v 149.505n 1.7v 159.495n 1.7v 159.505n 1.7v 169.495n 1.7v 169.505n 1.7v 179.495n 1.7v 179.505n 1.7v 189.495n 1.7v 189.505n 0.0v 199.495n 0.0v 199.505n 1.7v 209.495n 1.7v 209.505n 1.7v 219.495n 1.7v 219.505n 1.7v 229.495n 1.7v 229.505n 1.7v 239.495n 1.7v 239.505n 0.0v 249.495n 0.0v 249.505n 1.7v 259.495n 1.7v 259.505n 1.7v 269.495n 1.7v 269.505n 0.0v 279.495n 0.0v 279.505n 0.0v 289.495n 0.0v 289.505n 0.0v 299.495n 0.0v 299.505n 0.0v 309.495n 0.0v 309.505n 0.0v 319.495n 0.0v 319.505n 0.0v 329.495n 0.0v 329.505n 0.0v 339.495n 0.0v 339.505n 0.0v 349.495n 0.0v 349.505n 0.0v 359.495n 0.0v 359.505n 0.0v 369.495n 0.0v 369.505n 0.0v 379.495n 0.0v 379.505n 0.0v 389.495n 0.0v 389.505n 0.0v 399.495n 0.0v 399.505n 0.0v 409.495n 0.0v 409.505n 0.0v 419.495n 0.0v 419.505n 0.0v 429.495n 0.0v 429.505n 1.7v 439.495n 1.7v 439.505n 1.7v 449.495n 1.7v 449.505n 1.7v 459.495n 1.7v 459.505n 1.7v 469.495n 1.7v 469.505n 0.0v 479.495n 0.0v 479.505n 0.0v 489.495n 0.0v 489.505n 0.0v 499.495n 0.0v 499.505n 0.0v 509.495n 0.0v 509.505n 0.0v 519.495n 0.0v 519.505n 0.0v 529.495n 0.0v 529.505n 0.0v 539.495n 0.0v 539.505n 0.0v 549.495n 0.0v 549.505n 0.0v 559.495n 0.0v 559.505n 0.0v 569.495n 0.0v 569.505n 0.0v 579.495n 0.0v 579.505n 0.0v 589.495n 0.0v 589.505n 0.0v 599.495n 0.0v 599.505n 1.7v 609.495n 1.7v 609.505n 1.7v 619.495n 1.7v 619.505n 1.7v 629.495n 1.7v 629.505n 0.0v 639.495n 0.0v 639.505n 0.0v 649.495n 0.0v 649.505n 0.0v 659.495n 0.0v 659.505n 0.0v 669.495n 0.0v 669.505n 0.0v 679.495n 0.0v 679.505n 0.0v 689.495n 0.0v 689.505n 0.0v 699.495n 0.0v 699.505n 0.0v 709.495n 0.0v 709.505n 0.0v 719.495n 0.0v 719.505n 0.0v 729.495n 0.0v 729.505n 0.0v 739.495n 0.0v 739.505n 0.0v 749.495n 0.0v 749.505n 1.7v 759.495n 1.7v 759.505n 0.0v 769.495n 0.0v 769.505n 0.0v 779.495n 0.0v 779.505n 0.0v 789.495n 0.0v 789.505n 0.0v 799.495n 0.0v 799.505n 0.0v 809.495n 0.0v 809.505n 0.0v 819.495n 0.0v 819.505n 1.7v 829.495n 1.7v 829.505n 1.7v 839.495n 1.7v 839.505n 1.7v 849.495n 1.7v 849.505n 1.7v 859.495n 1.7v 859.505n 0.0v 869.495n 0.0v 869.505n 0.0v 879.495n 0.0v 879.505n 0.0v 889.495n 0.0v 889.505n 0.0v 899.495n 0.0v 899.505n 0.0v 909.495n 0.0v 909.505n 0.0v 919.495n 0.0v 919.505n 0.0v 929.495n 0.0v 929.505n 0.0v 939.495n 0.0v 939.505n 0.0v 949.495n 0.0v 949.505n 0.0v 959.495n 0.0v 959.505n 0.0v 969.495n 0.0v 969.505n 0.0v 979.495n 0.0v 979.505n 0.0v 989.495n 0.0v 989.505n 1.7v 999.495n 1.7v 999.505n 1.7v 1009.495n 1.7v 1009.505n 1.7v 1019.495n 1.7v 1019.505n 1.7v 1029.495n 1.7v 1029.505n 1.7v 1039.495n 1.7v 1039.505n 1.7v 1049.495n 1.7v 1049.505n 1.7v 1059.495n 1.7v 1059.505n 1.7v 1069.495n 1.7v 1069.505n 0.0v 1079.495n 0.0v 1079.505n 0.0v 1089.495n 0.0v 1089.505n 0.0v 1099.495n 0.0v 1099.505n 0.0v 1109.495n 0.0v 1109.505n 0.0v 1119.495n 0.0v 1119.505n 1.7v 1129.495n 1.7v 1129.505n 1.7v 1139.495n 1.7v 1139.505n 0.0v 1149.495n 0.0v 1149.505n 0.0v 1159.495n 0.0v 1159.505n 0.0v 1169.495n 0.0v 1169.505n 0.0v 1179.495n 0.0v 1179.505n 0.0v 1189.495n 0.0v 1189.505n 0.0v 1199.495n 0.0v 1199.505n 0.0v 1209.495n 0.0v 1209.505n 0.0v 1219.495n 0.0v 1219.505n 0.0v 1229.495n 0.0v 1229.505n 0.0v 1239.495n 0.0v 1239.505n 0.0v 1249.495n 0.0v 1249.505n 0.0v 1259.495n 0.0v 1259.505n 0.0v 1269.495n 0.0v 1269.505n 0.0v 1279.495n 0.0v 1279.505n 0.0v 1289.495n 0.0v 1289.505n 0.0v 1299.495n 0.0v 1299.505n 1.7v 1309.495n 1.7v 1309.505n 1.7v 1319.495n 1.7v 1319.505n 1.7v 1329.495n 1.7v 1329.505n 1.7v 1339.495n 1.7v 1339.505n 1.7v 1349.495n 1.7v 1349.505n 0.0v 1359.495n 0.0v 1359.505n 0.0v 1369.495n 0.0v 1369.505n 0.0v 1379.495n 0.0v 1379.505n 0.0v 1389.495n 0.0v 1389.505n 1.7v 1399.495n 1.7v 1399.505n 1.7v 1409.495n 1.7v 1409.505n 1.7v 1419.495n 1.7v 1419.505n 0.0v 1429.495n 0.0v 1429.505n 0.0v 1439.495n 0.0v 1439.505n 0.0v 1449.495n 0.0v 1449.505n 0.0v 1459.495n 0.0v 1459.505n 0.0v 1469.495n 0.0v 1469.505n 0.0v 1479.495n 0.0v 1479.505n 0.0v 1489.495n 0.0v 1489.505n 1.7v 1499.495n 1.7v 1499.505n 1.7v 1509.495n 1.7v 1509.505n 1.7v 1519.495n 1.7v 1519.505n 0.0v 1529.495n 0.0v 1529.505n 0.0v 1539.495n 0.0v 1539.505n 0.0v 1549.495n 0.0v 1549.505n 1.7v 1559.495n 1.7v 1559.505n 1.7v 1569.495n 1.7v 1569.505n 1.7v 1579.495n 1.7v 1579.505n 1.7v 1589.495n 1.7v 1589.505n 0.0v 1599.495n 0.0v 1599.505n 0.0v 1609.495n 0.0v 1609.505n 0.0v 1619.495n 0.0v 1619.505n 0.0v 1629.495n 0.0v 1629.505n 0.0v 1639.495n 0.0v 1639.505n 0.0v 1649.495n 0.0v 1649.505n 0.0v 1659.495n 0.0v 1659.505n 0.0v 1669.495n 0.0v 1669.505n 1.7v 1679.495n 1.7v 1679.505n 0.0v 1689.495n 0.0v 1689.505n 0.0v 1699.495n 0.0v 1699.505n 0.0v 1709.495n 0.0v 1709.505n 0.0v 1719.495n 0.0v 1719.505n 0.0v 1729.495n 0.0v 1729.505n 0.0v 1739.495n 0.0v 1739.505n 0.0v 1749.495n 0.0v 1749.505n 0.0v 1759.495n 0.0v 1759.505n 1.7v 1769.495n 1.7v 1769.505n 1.7v 1779.495n 1.7v 1779.505n 0.0v 1789.495n 0.0v 1789.505n 0.0v 1799.495n 0.0v 1799.505n 0.0v 1809.495n 0.0v 1809.505n 0.0v 1819.495n 0.0v 1819.505n 0.0v 1829.495n 0.0v 1829.505n 0.0v 1839.495n 0.0v 1839.505n 0.0v 1849.495n 0.0v 1849.505n 0.0v 1859.495n 0.0v 1859.505n 0.0v 1869.495n 0.0v 1869.505n 0.0v 1879.495n 0.0v 1879.505n 0.0v 1889.495n 0.0v 1889.505n 0.0v 1899.495n 0.0v 1899.505n 0.0v 1909.495n 0.0v 1909.505n 0.0v 1919.495n 0.0v 1919.505n 0.0v 1929.495n 0.0v 1929.505n 0.0v 1939.495n 0.0v 1939.505n 1.7v 1949.495n 1.7v 1949.505n 1.7v 1959.495n 1.7v 1959.505n 1.7v 1969.495n 1.7v 1969.505n 1.7v 1979.495n 1.7v 1979.505n 1.7v 1989.495n 1.7v 1989.505n 0.0v 1999.495n 0.0v 1999.505n 0.0v 2009.495n 0.0v 2009.505n 0.0v 2019.495n 0.0v 2019.505n 0.0v 2029.495n 0.0v 2029.505n 0.0v 2039.495n 0.0v 2039.505n 0.0v 2049.495n 0.0v 2049.505n 0.0v )
* (time, data): [(0, 0), (10, 0), (20, 0), (30, 0), (40, 0), (50, 0), (60, 0), (70, 0), (80, 0), (90, 0), (100, 0), (110, 0), (120, 0), (130, 0), (140, 0), (150, 1), (160, 1), (170, 1), (180, 1), (190, 0), (200, 1), (210, 1), (220, 1), (230, 1), (240, 0), (250, 1), (260, 1), (270, 0), (280, 0), (290, 0), (300, 0), (310, 0), (320, 0), (330, 0), (340, 0), (350, 0), (360, 0), (370, 0), (380, 0), (390, 0), (400, 0), (410, 0), (420, 0), (430, 1), (440, 1), (450, 1), (460, 1), (470, 0), (480, 0), (490, 0), (500, 0), (510, 0), (520, 0), (530, 0), (540, 0), (550, 0), (560, 0), (570, 0), (580, 0), (590, 0), (600, 1), (610, 1), (620, 1), (630, 0), (640, 0), (650, 0), (660, 0), (670, 0), (680, 0), (690, 0), (700, 0), (710, 0), (720, 0), (730, 0), (740, 0), (750, 1), (760, 0), (770, 0), (780, 0), (790, 0), (800, 0), (810, 0), (820, 1), (830, 1), (840, 1), (850, 1), (860, 0), (870, 0), (880, 0), (890, 0), (900, 0), (910, 0), (920, 0), (930, 0), (940, 0), (950, 0), (960, 0), (970, 0), (980, 0), (990, 1), (1000, 1), (1010, 1), (1020, 1), (1030, 1), (1040, 1), (1050, 1), (1060, 1), (1070, 0), (1080, 0), (1090, 0), (1100, 0), (1110, 0), (1120, 1), (1130, 1), (1140, 0), (1150, 0), (1160, 0), (1170, 0), (1180, 0), (1190, 0), (1200, 0), (1210, 0), (1220, 0), (1230, 0), (1240, 0), (1250, 0), (1260, 0), (1270, 0), (1280, 0), (1290, 0), (1300, 1), (1310, 1), (1320, 1), (1330, 1), (1340, 1), (1350, 0), (1360, 0), (1370, 0), (1380, 0), (1390, 1), (1400, 1), (1410, 1), (1420, 0), (1430, 0), (1440, 0), (1450, 0), (1460, 0), (1470, 0), (1480, 0), (1490, 1), (1500, 1), (1510, 1), (1520, 0), (1530, 0), (1540, 0), (1550, 1), (1560, 1), (1570, 1), (1580, 1), (1590, 0), (1600, 0), (1610, 0), (1620, 0), (1630, 0), (1640, 0), (1650, 0), (1660, 0), (1670, 1), (1680, 0), (1690, 0), (1700, 0), (1710, 0), (1720, 0), (1730, 0), (1740, 0), (1750, 0), (1760, 1), (1770, 1), (1780, 0), (1790, 0), (1800, 0), (1810, 0), (1820, 0), (1830, 0), (1840, 0), (1850, 0), (1860, 0), (1870, 0), (1880, 0), (1890, 0), (1900, 0), (1910, 0), (1920, 0), (1930, 0), (1940, 1), (1950, 1), (1960, 1), (1970, 1), (1980, 1), (1990, 0), (2000, 0), (2010, 0), (2020, 0), (2030, 0), (2040, 0), (2050, 0)]
Va1_2  a1_2  0 PWL (0n 0.0v 9.495n 0.0v 9.505n 0.0v 19.495n 0.0v 19.505n 0.0v 29.495n 0.0v 29.505n 0.0v 39.495n 0.0v 39.505n 0.0v 49.495n 0.0v 49.505n 0.0v 59.495n 0.0v 59.505n 0.0v 69.495n 0.0v 69.505n 0.0v 79.495n 0.0v 79.505n 0.0v 89.495n 0.0v 89.505n 0.0v 99.495n 0.0v 99.505n 0.0v 109.495n 0.0v 109.505n 0.0v 119.495n 0.0v 119.505n 0.0v 129.495n 0.0v 129.505n 0.0v 139.495n 0.0v 139.505n 0.0v 149.495n 0.0v 149.505n 1.7v 159.495n 1.7v 159.505n 1.7v 169.495n 1.7v 169.505n 1.7v 179.495n 1.7v 179.505n 1.7v 189.495n 1.7v 189.505n 0.0v 199.495n 0.0v 199.505n 1.7v 209.495n 1.7v 209.505n 1.7v 219.495n 1.7v 219.505n 1.7v 229.495n 1.7v 229.505n 1.7v 239.495n 1.7v 239.505n 0.0v 249.495n 0.0v 249.505n 1.7v 259.495n 1.7v 259.505n 1.7v 269.495n 1.7v 269.505n 0.0v 279.495n 0.0v 279.505n 0.0v 289.495n 0.0v 289.505n 0.0v 299.495n 0.0v 299.505n 0.0v 309.495n 0.0v 309.505n 0.0v 319.495n 0.0v 319.505n 0.0v 329.495n 0.0v 329.505n 0.0v 339.495n 0.0v 339.505n 0.0v 349.495n 0.0v 349.505n 0.0v 359.495n 0.0v 359.505n 0.0v 369.495n 0.0v 369.505n 0.0v 379.495n 0.0v 379.505n 0.0v 389.495n 0.0v 389.505n 0.0v 399.495n 0.0v 399.505n 0.0v 409.495n 0.0v 409.505n 0.0v 419.495n 0.0v 419.505n 0.0v 429.495n 0.0v 429.505n 1.7v 439.495n 1.7v 439.505n 1.7v 449.495n 1.7v 449.505n 1.7v 459.495n 1.7v 459.505n 1.7v 469.495n 1.7v 469.505n 0.0v 479.495n 0.0v 479.505n 0.0v 489.495n 0.0v 489.505n 0.0v 499.495n 0.0v 499.505n 0.0v 509.495n 0.0v 509.505n 0.0v 519.495n 0.0v 519.505n 0.0v 529.495n 0.0v 529.505n 0.0v 539.495n 0.0v 539.505n 0.0v 549.495n 0.0v 549.505n 0.0v 559.495n 0.0v 559.505n 0.0v 569.495n 0.0v 569.505n 0.0v 579.495n 0.0v 579.505n 0.0v 589.495n 0.0v 589.505n 0.0v 599.495n 0.0v 599.505n 1.7v 609.495n 1.7v 609.505n 1.7v 619.495n 1.7v 619.505n 1.7v 629.495n 1.7v 629.505n 0.0v 639.495n 0.0v 639.505n 0.0v 649.495n 0.0v 649.505n 0.0v 659.495n 0.0v 659.505n 0.0v 669.495n 0.0v 669.505n 0.0v 679.495n 0.0v 679.505n 0.0v 689.495n 0.0v 689.505n 0.0v 699.495n 0.0v 699.505n 0.0v 709.495n 0.0v 709.505n 0.0v 719.495n 0.0v 719.505n 0.0v 729.495n 0.0v 729.505n 0.0v 739.495n 0.0v 739.505n 0.0v 749.495n 0.0v 749.505n 1.7v 759.495n 1.7v 759.505n 0.0v 769.495n 0.0v 769.505n 0.0v 779.495n 0.0v 779.505n 0.0v 789.495n 0.0v 789.505n 0.0v 799.495n 0.0v 799.505n 0.0v 809.495n 0.0v 809.505n 0.0v 819.495n 0.0v 819.505n 1.7v 829.495n 1.7v 829.505n 1.7v 839.495n 1.7v 839.505n 1.7v 849.495n 1.7v 849.505n 1.7v 859.495n 1.7v 859.505n 0.0v 869.495n 0.0v 869.505n 0.0v 879.495n 0.0v 879.505n 0.0v 889.495n 0.0v 889.505n 0.0v 899.495n 0.0v 899.505n 0.0v 909.495n 0.0v 909.505n 0.0v 919.495n 0.0v 919.505n 0.0v 929.495n 0.0v 929.505n 0.0v 939.495n 0.0v 939.505n 0.0v 949.495n 0.0v 949.505n 0.0v 959.495n 0.0v 959.505n 0.0v 969.495n 0.0v 969.505n 0.0v 979.495n 0.0v 979.505n 0.0v 989.495n 0.0v 989.505n 1.7v 999.495n 1.7v 999.505n 1.7v 1009.495n 1.7v 1009.505n 1.7v 1019.495n 1.7v 1019.505n 1.7v 1029.495n 1.7v 1029.505n 1.7v 1039.495n 1.7v 1039.505n 1.7v 1049.495n 1.7v 1049.505n 1.7v 1059.495n 1.7v 1059.505n 1.7v 1069.495n 1.7v 1069.505n 0.0v 1079.495n 0.0v 1079.505n 0.0v 1089.495n 0.0v 1089.505n 0.0v 1099.495n 0.0v 1099.505n 0.0v 1109.495n 0.0v 1109.505n 0.0v 1119.495n 0.0v 1119.505n 1.7v 1129.495n 1.7v 1129.505n 1.7v 1139.495n 1.7v 1139.505n 0.0v 1149.495n 0.0v 1149.505n 0.0v 1159.495n 0.0v 1159.505n 0.0v 1169.495n 0.0v 1169.505n 0.0v 1179.495n 0.0v 1179.505n 0.0v 1189.495n 0.0v 1189.505n 0.0v 1199.495n 0.0v 1199.505n 0.0v 1209.495n 0.0v 1209.505n 0.0v 1219.495n 0.0v 1219.505n 0.0v 1229.495n 0.0v 1229.505n 0.0v 1239.495n 0.0v 1239.505n 0.0v 1249.495n 0.0v 1249.505n 0.0v 1259.495n 0.0v 1259.505n 0.0v 1269.495n 0.0v 1269.505n 0.0v 1279.495n 0.0v 1279.505n 0.0v 1289.495n 0.0v 1289.505n 0.0v 1299.495n 0.0v 1299.505n 1.7v 1309.495n 1.7v 1309.505n 1.7v 1319.495n 1.7v 1319.505n 1.7v 1329.495n 1.7v 1329.505n 1.7v 1339.495n 1.7v 1339.505n 1.7v 1349.495n 1.7v 1349.505n 0.0v 1359.495n 0.0v 1359.505n 0.0v 1369.495n 0.0v 1369.505n 0.0v 1379.495n 0.0v 1379.505n 0.0v 1389.495n 0.0v 1389.505n 1.7v 1399.495n 1.7v 1399.505n 1.7v 1409.495n 1.7v 1409.505n 1.7v 1419.495n 1.7v 1419.505n 0.0v 1429.495n 0.0v 1429.505n 0.0v 1439.495n 0.0v 1439.505n 0.0v 1449.495n 0.0v 1449.505n 0.0v 1459.495n 0.0v 1459.505n 0.0v 1469.495n 0.0v 1469.505n 0.0v 1479.495n 0.0v 1479.505n 0.0v 1489.495n 0.0v 1489.505n 1.7v 1499.495n 1.7v 1499.505n 1.7v 1509.495n 1.7v 1509.505n 1.7v 1519.495n 1.7v 1519.505n 0.0v 1529.495n 0.0v 1529.505n 0.0v 1539.495n 0.0v 1539.505n 0.0v 1549.495n 0.0v 1549.505n 1.7v 1559.495n 1.7v 1559.505n 1.7v 1569.495n 1.7v 1569.505n 1.7v 1579.495n 1.7v 1579.505n 1.7v 1589.495n 1.7v 1589.505n 0.0v 1599.495n 0.0v 1599.505n 0.0v 1609.495n 0.0v 1609.505n 0.0v 1619.495n 0.0v 1619.505n 0.0v 1629.495n 0.0v 1629.505n 0.0v 1639.495n 0.0v 1639.505n 0.0v 1649.495n 0.0v 1649.505n 0.0v 1659.495n 0.0v 1659.505n 0.0v 1669.495n 0.0v 1669.505n 1.7v 1679.495n 1.7v 1679.505n 0.0v 1689.495n 0.0v 1689.505n 0.0v 1699.495n 0.0v 1699.505n 0.0v 1709.495n 0.0v 1709.505n 0.0v 1719.495n 0.0v 1719.505n 0.0v 1729.495n 0.0v 1729.505n 0.0v 1739.495n 0.0v 1739.505n 0.0v 1749.495n 0.0v 1749.505n 0.0v 1759.495n 0.0v 1759.505n 1.7v 1769.495n 1.7v 1769.505n 1.7v 1779.495n 1.7v 1779.505n 0.0v 1789.495n 0.0v 1789.505n 0.0v 1799.495n 0.0v 1799.505n 0.0v 1809.495n 0.0v 1809.505n 0.0v 1819.495n 0.0v 1819.505n 0.0v 1829.495n 0.0v 1829.505n 0.0v 1839.495n 0.0v 1839.505n 0.0v 1849.495n 0.0v 1849.505n 0.0v 1859.495n 0.0v 1859.505n 0.0v 1869.495n 0.0v 1869.505n 0.0v 1879.495n 0.0v 1879.505n 0.0v 1889.495n 0.0v 1889.505n 0.0v 1899.495n 0.0v 1899.505n 0.0v 1909.495n 0.0v 1909.505n 0.0v 1919.495n 0.0v 1919.505n 0.0v 1929.495n 0.0v 1929.505n 0.0v 1939.495n 0.0v 1939.505n 1.7v 1949.495n 1.7v 1949.505n 1.7v 1959.495n 1.7v 1959.505n 1.7v 1969.495n 1.7v 1969.505n 1.7v 1979.495n 1.7v 1979.505n 1.7v 1989.495n 1.7v 1989.505n 0.0v 1999.495n 0.0v 1999.505n 0.0v 2009.495n 0.0v 2009.505n 0.0v 2019.495n 0.0v 2019.505n 0.0v 2029.495n 0.0v 2029.505n 0.0v 2039.495n 0.0v 2039.505n 0.0v 2049.495n 0.0v 2049.505n 0.0v )
* (time, data): [(0, 0), (10, 0), (20, 0), (30, 0), (40, 0), (50, 0), (60, 0), (70, 0), (80, 0), (90, 0), (100, 0), (110, 0), (120, 0), (130, 0), (140, 0), (150, 1), (160, 1), (170, 1), (180, 1), (190, 0), (200, 1), (210, 1), (220, 1), (230, 1), (240, 0), (250, 1), (260, 1), (270, 0), (280, 0), (290, 0), (300, 0), (310, 0), (320, 0), (330, 0), (340, 0), (350, 0), (360, 0), (370, 0), (380, 0), (390, 0), (400, 0), (410, 0), (420, 0), (430, 1), (440, 1), (450, 1), (460, 1), (470, 0), (480, 0), (490, 0), (500, 0), (510, 0), (520, 0), (530, 0), (540, 0), (550, 0), (560, 0), (570, 0), (580, 0), (590, 0), (600, 1), (610, 1), (620, 1), (630, 0), (640, 0), (650, 0), (660, 0), (670, 0), (680, 0), (690, 0), (700, 0), (710, 0), (720, 0), (730, 0), (740, 0), (750, 1), (760, 0), (770, 0), (780, 0), (790, 0), (800, 0), (810, 0), (820, 1), (830, 1), (840, 1), (850, 1), (860, 0), (870, 0), (880, 0), (890, 0), (900, 0), (910, 0), (920, 0), (930, 0), (940, 0), (950, 0), (960, 0), (970, 0), (980, 0), (990, 1), (1000, 1), (1010, 1), (1020, 1), (1030, 1), (1040, 1), (1050, 1), (1060, 1), (1070, 0), (1080, 0), (1090, 0), (1100, 0), (1110, 0), (1120, 1), (1130, 1), (1140, 0), (1150, 0), (1160, 0), (1170, 0), (1180, 0), (1190, 0), (1200, 0), (1210, 0), (1220, 0), (1230, 0), (1240, 0), (1250, 0), (1260, 0), (1270, 0), (1280, 0), (1290, 0), (1300, 1), (1310, 1), (1320, 1), (1330, 1), (1340, 1), (1350, 0), (1360, 0), (1370, 0), (1380, 0), (1390, 1), (1400, 1), (1410, 1), (1420, 0), (1430, 0), (1440, 0), (1450, 0), (1460, 0), (1470, 0), (1480, 0), (1490, 1), (1500, 1), (1510, 1), (1520, 0), (1530, 0), (1540, 0), (1550, 1), (1560, 1), (1570, 1), (1580, 1), (1590, 0), (1600, 0), (1610, 0), (1620, 0), (1630, 0), (1640, 0), (1650, 0), (1660, 0), (1670, 1), (1680, 0), (1690, 0), (1700, 0), (1710, 0), (1720, 0), (1730, 0), (1740, 0), (1750, 0), (1760, 1), (1770, 1), (1780, 0), (1790, 0), (1800, 0), (1810, 0), (1820, 0), (1830, 0), (1840, 0), (1850, 0), (1860, 0), (1870, 0), (1880, 0), (1890, 0), (1900, 0), (1910, 0), (1920, 0), (1930, 0), (1940, 1), (1950, 1), (1960, 1), (1970, 1), (1980, 1), (1990, 0), (2000, 0), (2010, 0), (2020, 0), (2030, 0), (2040, 0), (2050, 0)]
Va1_3  a1_3  0 PWL (0n 0.0v 9.495n 0.0v 9.505n 0.0v 19.495n 0.0v 19.505n 0.0v 29.495n 0.0v 29.505n 0.0v 39.495n 0.0v 39.505n 0.0v 49.495n 0.0v 49.505n 0.0v 59.495n 0.0v 59.505n 0.0v 69.495n 0.0v 69.505n 0.0v 79.495n 0.0v 79.505n 0.0v 89.495n 0.0v 89.505n 0.0v 99.495n 0.0v 99.505n 0.0v 109.495n 0.0v 109.505n 0.0v 119.495n 0.0v 119.505n 0.0v 129.495n 0.0v 129.505n 0.0v 139.495n 0.0v 139.505n 0.0v 149.495n 0.0v 149.505n 1.7v 159.495n 1.7v 159.505n 1.7v 169.495n 1.7v 169.505n 1.7v 179.495n 1.7v 179.505n 1.7v 189.495n 1.7v 189.505n 0.0v 199.495n 0.0v 199.505n 1.7v 209.495n 1.7v 209.505n 1.7v 219.495n 1.7v 219.505n 1.7v 229.495n 1.7v 229.505n 1.7v 239.495n 1.7v 239.505n 0.0v 249.495n 0.0v 249.505n 1.7v 259.495n 1.7v 259.505n 1.7v 269.495n 1.7v 269.505n 0.0v 279.495n 0.0v 279.505n 0.0v 289.495n 0.0v 289.505n 0.0v 299.495n 0.0v 299.505n 0.0v 309.495n 0.0v 309.505n 0.0v 319.495n 0.0v 319.505n 0.0v 329.495n 0.0v 329.505n 0.0v 339.495n 0.0v 339.505n 0.0v 349.495n 0.0v 349.505n 0.0v 359.495n 0.0v 359.505n 0.0v 369.495n 0.0v 369.505n 0.0v 379.495n 0.0v 379.505n 0.0v 389.495n 0.0v 389.505n 0.0v 399.495n 0.0v 399.505n 0.0v 409.495n 0.0v 409.505n 0.0v 419.495n 0.0v 419.505n 0.0v 429.495n 0.0v 429.505n 1.7v 439.495n 1.7v 439.505n 1.7v 449.495n 1.7v 449.505n 1.7v 459.495n 1.7v 459.505n 1.7v 469.495n 1.7v 469.505n 0.0v 479.495n 0.0v 479.505n 0.0v 489.495n 0.0v 489.505n 0.0v 499.495n 0.0v 499.505n 0.0v 509.495n 0.0v 509.505n 0.0v 519.495n 0.0v 519.505n 0.0v 529.495n 0.0v 529.505n 0.0v 539.495n 0.0v 539.505n 0.0v 549.495n 0.0v 549.505n 0.0v 559.495n 0.0v 559.505n 0.0v 569.495n 0.0v 569.505n 0.0v 579.495n 0.0v 579.505n 0.0v 589.495n 0.0v 589.505n 0.0v 599.495n 0.0v 599.505n 1.7v 609.495n 1.7v 609.505n 1.7v 619.495n 1.7v 619.505n 1.7v 629.495n 1.7v 629.505n 0.0v 639.495n 0.0v 639.505n 0.0v 649.495n 0.0v 649.505n 0.0v 659.495n 0.0v 659.505n 0.0v 669.495n 0.0v 669.505n 0.0v 679.495n 0.0v 679.505n 0.0v 689.495n 0.0v 689.505n 0.0v 699.495n 0.0v 699.505n 0.0v 709.495n 0.0v 709.505n 0.0v 719.495n 0.0v 719.505n 0.0v 729.495n 0.0v 729.505n 0.0v 739.495n 0.0v 739.505n 0.0v 749.495n 0.0v 749.505n 1.7v 759.495n 1.7v 759.505n 0.0v 769.495n 0.0v 769.505n 0.0v 779.495n 0.0v 779.505n 0.0v 789.495n 0.0v 789.505n 0.0v 799.495n 0.0v 799.505n 0.0v 809.495n 0.0v 809.505n 0.0v 819.495n 0.0v 819.505n 1.7v 829.495n 1.7v 829.505n 1.7v 839.495n 1.7v 839.505n 1.7v 849.495n 1.7v 849.505n 1.7v 859.495n 1.7v 859.505n 0.0v 869.495n 0.0v 869.505n 0.0v 879.495n 0.0v 879.505n 0.0v 889.495n 0.0v 889.505n 0.0v 899.495n 0.0v 899.505n 0.0v 909.495n 0.0v 909.505n 0.0v 919.495n 0.0v 919.505n 0.0v 929.495n 0.0v 929.505n 0.0v 939.495n 0.0v 939.505n 0.0v 949.495n 0.0v 949.505n 0.0v 959.495n 0.0v 959.505n 0.0v 969.495n 0.0v 969.505n 0.0v 979.495n 0.0v 979.505n 0.0v 989.495n 0.0v 989.505n 1.7v 999.495n 1.7v 999.505n 1.7v 1009.495n 1.7v 1009.505n 1.7v 1019.495n 1.7v 1019.505n 1.7v 1029.495n 1.7v 1029.505n 1.7v 1039.495n 1.7v 1039.505n 1.7v 1049.495n 1.7v 1049.505n 1.7v 1059.495n 1.7v 1059.505n 1.7v 1069.495n 1.7v 1069.505n 0.0v 1079.495n 0.0v 1079.505n 0.0v 1089.495n 0.0v 1089.505n 0.0v 1099.495n 0.0v 1099.505n 0.0v 1109.495n 0.0v 1109.505n 0.0v 1119.495n 0.0v 1119.505n 1.7v 1129.495n 1.7v 1129.505n 1.7v 1139.495n 1.7v 1139.505n 0.0v 1149.495n 0.0v 1149.505n 0.0v 1159.495n 0.0v 1159.505n 0.0v 1169.495n 0.0v 1169.505n 0.0v 1179.495n 0.0v 1179.505n 0.0v 1189.495n 0.0v 1189.505n 0.0v 1199.495n 0.0v 1199.505n 0.0v 1209.495n 0.0v 1209.505n 0.0v 1219.495n 0.0v 1219.505n 0.0v 1229.495n 0.0v 1229.505n 0.0v 1239.495n 0.0v 1239.505n 0.0v 1249.495n 0.0v 1249.505n 0.0v 1259.495n 0.0v 1259.505n 0.0v 1269.495n 0.0v 1269.505n 0.0v 1279.495n 0.0v 1279.505n 0.0v 1289.495n 0.0v 1289.505n 0.0v 1299.495n 0.0v 1299.505n 1.7v 1309.495n 1.7v 1309.505n 1.7v 1319.495n 1.7v 1319.505n 1.7v 1329.495n 1.7v 1329.505n 1.7v 1339.495n 1.7v 1339.505n 1.7v 1349.495n 1.7v 1349.505n 0.0v 1359.495n 0.0v 1359.505n 0.0v 1369.495n 0.0v 1369.505n 0.0v 1379.495n 0.0v 1379.505n 0.0v 1389.495n 0.0v 1389.505n 1.7v 1399.495n 1.7v 1399.505n 1.7v 1409.495n 1.7v 1409.505n 1.7v 1419.495n 1.7v 1419.505n 0.0v 1429.495n 0.0v 1429.505n 0.0v 1439.495n 0.0v 1439.505n 0.0v 1449.495n 0.0v 1449.505n 0.0v 1459.495n 0.0v 1459.505n 0.0v 1469.495n 0.0v 1469.505n 0.0v 1479.495n 0.0v 1479.505n 0.0v 1489.495n 0.0v 1489.505n 1.7v 1499.495n 1.7v 1499.505n 1.7v 1509.495n 1.7v 1509.505n 1.7v 1519.495n 1.7v 1519.505n 0.0v 1529.495n 0.0v 1529.505n 0.0v 1539.495n 0.0v 1539.505n 0.0v 1549.495n 0.0v 1549.505n 1.7v 1559.495n 1.7v 1559.505n 1.7v 1569.495n 1.7v 1569.505n 1.7v 1579.495n 1.7v 1579.505n 1.7v 1589.495n 1.7v 1589.505n 0.0v 1599.495n 0.0v 1599.505n 0.0v 1609.495n 0.0v 1609.505n 0.0v 1619.495n 0.0v 1619.505n 0.0v 1629.495n 0.0v 1629.505n 0.0v 1639.495n 0.0v 1639.505n 0.0v 1649.495n 0.0v 1649.505n 0.0v 1659.495n 0.0v 1659.505n 0.0v 1669.495n 0.0v 1669.505n 1.7v 1679.495n 1.7v 1679.505n 0.0v 1689.495n 0.0v 1689.505n 0.0v 1699.495n 0.0v 1699.505n 0.0v 1709.495n 0.0v 1709.505n 0.0v 1719.495n 0.0v 1719.505n 0.0v 1729.495n 0.0v 1729.505n 0.0v 1739.495n 0.0v 1739.505n 0.0v 1749.495n 0.0v 1749.505n 0.0v 1759.495n 0.0v 1759.505n 1.7v 1769.495n 1.7v 1769.505n 1.7v 1779.495n 1.7v 1779.505n 0.0v 1789.495n 0.0v 1789.505n 0.0v 1799.495n 0.0v 1799.505n 0.0v 1809.495n 0.0v 1809.505n 0.0v 1819.495n 0.0v 1819.505n 0.0v 1829.495n 0.0v 1829.505n 0.0v 1839.495n 0.0v 1839.505n 0.0v 1849.495n 0.0v 1849.505n 0.0v 1859.495n 0.0v 1859.505n 0.0v 1869.495n 0.0v 1869.505n 0.0v 1879.495n 0.0v 1879.505n 0.0v 1889.495n 0.0v 1889.505n 0.0v 1899.495n 0.0v 1899.505n 0.0v 1909.495n 0.0v 1909.505n 0.0v 1919.495n 0.0v 1919.505n 0.0v 1929.495n 0.0v 1929.505n 0.0v 1939.495n 0.0v 1939.505n 1.7v 1949.495n 1.7v 1949.505n 1.7v 1959.495n 1.7v 1959.505n 1.7v 1969.495n 1.7v 1969.505n 1.7v 1979.495n 1.7v 1979.505n 1.7v 1989.495n 1.7v 1989.505n 0.0v 1999.495n 0.0v 1999.505n 0.0v 2009.495n 0.0v 2009.505n 0.0v 2019.495n 0.0v 2019.505n 0.0v 2029.495n 0.0v 2029.505n 0.0v 2039.495n 0.0v 2039.505n 0.0v 2049.495n 0.0v 2049.505n 0.0v )
* (time, data): [(0, 0), (10, 0), (20, 0), (30, 0), (40, 0), (50, 0), (60, 0), (70, 0), (80, 0), (90, 0), (100, 0), (110, 0), (120, 0), (130, 0), (140, 0), (150, 1), (160, 1), (170, 1), (180, 1), (190, 0), (200, 1), (210, 1), (220, 1), (230, 1), (240, 0), (250, 1), (260, 1), (270, 0), (280, 0), (290, 0), (300, 0), (310, 0), (320, 0), (330, 0), (340, 0), (350, 0), (360, 0), (370, 0), (380, 0), (390, 0), (400, 0), (410, 0), (420, 0), (430, 1), (440, 1), (450, 1), (460, 1), (470, 0), (480, 0), (490, 0), (500, 0), (510, 0), (520, 0), (530, 0), (540, 0), (550, 0), (560, 0), (570, 0), (580, 0), (590, 0), (600, 1), (610, 1), (620, 1), (630, 0), (640, 0), (650, 0), (660, 0), (670, 0), (680, 0), (690, 0), (700, 0), (710, 0), (720, 0), (730, 0), (740, 0), (750, 1), (760, 0), (770, 0), (780, 0), (790, 0), (800, 0), (810, 0), (820, 1), (830, 1), (840, 1), (850, 1), (860, 0), (870, 0), (880, 0), (890, 0), (900, 0), (910, 0), (920, 0), (930, 0), (940, 0), (950, 0), (960, 0), (970, 0), (980, 0), (990, 1), (1000, 1), (1010, 1), (1020, 1), (1030, 1), (1040, 1), (1050, 1), (1060, 1), (1070, 0), (1080, 0), (1090, 0), (1100, 0), (1110, 0), (1120, 1), (1130, 1), (1140, 0), (1150, 0), (1160, 0), (1170, 0), (1180, 0), (1190, 0), (1200, 0), (1210, 0), (1220, 0), (1230, 0), (1240, 0), (1250, 0), (1260, 0), (1270, 0), (1280, 0), (1290, 0), (1300, 1), (1310, 1), (1320, 1), (1330, 1), (1340, 1), (1350, 0), (1360, 0), (1370, 0), (1380, 0), (1390, 1), (1400, 1), (1410, 1), (1420, 0), (1430, 0), (1440, 0), (1450, 0), (1460, 0), (1470, 0), (1480, 0), (1490, 1), (1500, 1), (1510, 1), (1520, 0), (1530, 0), (1540, 0), (1550, 1), (1560, 1), (1570, 1), (1580, 1), (1590, 0), (1600, 0), (1610, 0), (1620, 0), (1630, 0), (1640, 0), (1650, 0), (1660, 0), (1670, 1), (1680, 0), (1690, 0), (1700, 0), (1710, 0), (1720, 0), (1730, 0), (1740, 0), (1750, 0), (1760, 1), (1770, 1), (1780, 0), (1790, 0), (1800, 0), (1810, 0), (1820, 0), (1830, 0), (1840, 0), (1850, 0), (1860, 0), (1870, 0), (1880, 0), (1890, 0), (1900, 0), (1910, 0), (1920, 0), (1930, 0), (1940, 1), (1950, 1), (1960, 1), (1970, 1), (1980, 1), (1990, 0), (2000, 0), (2010, 0), (2020, 0), (2030, 0), (2040, 0), (2050, 0)]
Va1_4  a1_4  0 PWL (0n 0.0v 9.495n 0.0v 9.505n 0.0v 19.495n 0.0v 19.505n 0.0v 29.495n 0.0v 29.505n 0.0v 39.495n 0.0v 39.505n 0.0v 49.495n 0.0v 49.505n 0.0v 59.495n 0.0v 59.505n 0.0v 69.495n 0.0v 69.505n 0.0v 79.495n 0.0v 79.505n 0.0v 89.495n 0.0v 89.505n 0.0v 99.495n 0.0v 99.505n 0.0v 109.495n 0.0v 109.505n 0.0v 119.495n 0.0v 119.505n 0.0v 129.495n 0.0v 129.505n 0.0v 139.495n 0.0v 139.505n 0.0v 149.495n 0.0v 149.505n 1.7v 159.495n 1.7v 159.505n 1.7v 169.495n 1.7v 169.505n 1.7v 179.495n 1.7v 179.505n 1.7v 189.495n 1.7v 189.505n 0.0v 199.495n 0.0v 199.505n 1.7v 209.495n 1.7v 209.505n 1.7v 219.495n 1.7v 219.505n 1.7v 229.495n 1.7v 229.505n 1.7v 239.495n 1.7v 239.505n 0.0v 249.495n 0.0v 249.505n 1.7v 259.495n 1.7v 259.505n 1.7v 269.495n 1.7v 269.505n 0.0v 279.495n 0.0v 279.505n 0.0v 289.495n 0.0v 289.505n 0.0v 299.495n 0.0v 299.505n 0.0v 309.495n 0.0v 309.505n 0.0v 319.495n 0.0v 319.505n 0.0v 329.495n 0.0v 329.505n 0.0v 339.495n 0.0v 339.505n 0.0v 349.495n 0.0v 349.505n 0.0v 359.495n 0.0v 359.505n 0.0v 369.495n 0.0v 369.505n 0.0v 379.495n 0.0v 379.505n 0.0v 389.495n 0.0v 389.505n 0.0v 399.495n 0.0v 399.505n 0.0v 409.495n 0.0v 409.505n 0.0v 419.495n 0.0v 419.505n 0.0v 429.495n 0.0v 429.505n 1.7v 439.495n 1.7v 439.505n 1.7v 449.495n 1.7v 449.505n 1.7v 459.495n 1.7v 459.505n 1.7v 469.495n 1.7v 469.505n 0.0v 479.495n 0.0v 479.505n 0.0v 489.495n 0.0v 489.505n 0.0v 499.495n 0.0v 499.505n 0.0v 509.495n 0.0v 509.505n 0.0v 519.495n 0.0v 519.505n 0.0v 529.495n 0.0v 529.505n 0.0v 539.495n 0.0v 539.505n 0.0v 549.495n 0.0v 549.505n 0.0v 559.495n 0.0v 559.505n 0.0v 569.495n 0.0v 569.505n 0.0v 579.495n 0.0v 579.505n 0.0v 589.495n 0.0v 589.505n 0.0v 599.495n 0.0v 599.505n 1.7v 609.495n 1.7v 609.505n 1.7v 619.495n 1.7v 619.505n 1.7v 629.495n 1.7v 629.505n 0.0v 639.495n 0.0v 639.505n 0.0v 649.495n 0.0v 649.505n 0.0v 659.495n 0.0v 659.505n 0.0v 669.495n 0.0v 669.505n 0.0v 679.495n 0.0v 679.505n 0.0v 689.495n 0.0v 689.505n 0.0v 699.495n 0.0v 699.505n 0.0v 709.495n 0.0v 709.505n 0.0v 719.495n 0.0v 719.505n 0.0v 729.495n 0.0v 729.505n 0.0v 739.495n 0.0v 739.505n 0.0v 749.495n 0.0v 749.505n 1.7v 759.495n 1.7v 759.505n 0.0v 769.495n 0.0v 769.505n 0.0v 779.495n 0.0v 779.505n 0.0v 789.495n 0.0v 789.505n 0.0v 799.495n 0.0v 799.505n 0.0v 809.495n 0.0v 809.505n 0.0v 819.495n 0.0v 819.505n 1.7v 829.495n 1.7v 829.505n 1.7v 839.495n 1.7v 839.505n 1.7v 849.495n 1.7v 849.505n 1.7v 859.495n 1.7v 859.505n 0.0v 869.495n 0.0v 869.505n 0.0v 879.495n 0.0v 879.505n 0.0v 889.495n 0.0v 889.505n 0.0v 899.495n 0.0v 899.505n 0.0v 909.495n 0.0v 909.505n 0.0v 919.495n 0.0v 919.505n 0.0v 929.495n 0.0v 929.505n 0.0v 939.495n 0.0v 939.505n 0.0v 949.495n 0.0v 949.505n 0.0v 959.495n 0.0v 959.505n 0.0v 969.495n 0.0v 969.505n 0.0v 979.495n 0.0v 979.505n 0.0v 989.495n 0.0v 989.505n 1.7v 999.495n 1.7v 999.505n 1.7v 1009.495n 1.7v 1009.505n 1.7v 1019.495n 1.7v 1019.505n 1.7v 1029.495n 1.7v 1029.505n 1.7v 1039.495n 1.7v 1039.505n 1.7v 1049.495n 1.7v 1049.505n 1.7v 1059.495n 1.7v 1059.505n 1.7v 1069.495n 1.7v 1069.505n 0.0v 1079.495n 0.0v 1079.505n 0.0v 1089.495n 0.0v 1089.505n 0.0v 1099.495n 0.0v 1099.505n 0.0v 1109.495n 0.0v 1109.505n 0.0v 1119.495n 0.0v 1119.505n 1.7v 1129.495n 1.7v 1129.505n 1.7v 1139.495n 1.7v 1139.505n 0.0v 1149.495n 0.0v 1149.505n 0.0v 1159.495n 0.0v 1159.505n 0.0v 1169.495n 0.0v 1169.505n 0.0v 1179.495n 0.0v 1179.505n 0.0v 1189.495n 0.0v 1189.505n 0.0v 1199.495n 0.0v 1199.505n 0.0v 1209.495n 0.0v 1209.505n 0.0v 1219.495n 0.0v 1219.505n 0.0v 1229.495n 0.0v 1229.505n 0.0v 1239.495n 0.0v 1239.505n 0.0v 1249.495n 0.0v 1249.505n 0.0v 1259.495n 0.0v 1259.505n 0.0v 1269.495n 0.0v 1269.505n 0.0v 1279.495n 0.0v 1279.505n 0.0v 1289.495n 0.0v 1289.505n 0.0v 1299.495n 0.0v 1299.505n 1.7v 1309.495n 1.7v 1309.505n 1.7v 1319.495n 1.7v 1319.505n 1.7v 1329.495n 1.7v 1329.505n 1.7v 1339.495n 1.7v 1339.505n 1.7v 1349.495n 1.7v 1349.505n 0.0v 1359.495n 0.0v 1359.505n 0.0v 1369.495n 0.0v 1369.505n 0.0v 1379.495n 0.0v 1379.505n 0.0v 1389.495n 0.0v 1389.505n 1.7v 1399.495n 1.7v 1399.505n 1.7v 1409.495n 1.7v 1409.505n 1.7v 1419.495n 1.7v 1419.505n 0.0v 1429.495n 0.0v 1429.505n 0.0v 1439.495n 0.0v 1439.505n 0.0v 1449.495n 0.0v 1449.505n 0.0v 1459.495n 0.0v 1459.505n 0.0v 1469.495n 0.0v 1469.505n 0.0v 1479.495n 0.0v 1479.505n 0.0v 1489.495n 0.0v 1489.505n 1.7v 1499.495n 1.7v 1499.505n 1.7v 1509.495n 1.7v 1509.505n 1.7v 1519.495n 1.7v 1519.505n 0.0v 1529.495n 0.0v 1529.505n 0.0v 1539.495n 0.0v 1539.505n 0.0v 1549.495n 0.0v 1549.505n 1.7v 1559.495n 1.7v 1559.505n 1.7v 1569.495n 1.7v 1569.505n 1.7v 1579.495n 1.7v 1579.505n 1.7v 1589.495n 1.7v 1589.505n 0.0v 1599.495n 0.0v 1599.505n 0.0v 1609.495n 0.0v 1609.505n 0.0v 1619.495n 0.0v 1619.505n 0.0v 1629.495n 0.0v 1629.505n 0.0v 1639.495n 0.0v 1639.505n 0.0v 1649.495n 0.0v 1649.505n 0.0v 1659.495n 0.0v 1659.505n 0.0v 1669.495n 0.0v 1669.505n 1.7v 1679.495n 1.7v 1679.505n 0.0v 1689.495n 0.0v 1689.505n 0.0v 1699.495n 0.0v 1699.505n 0.0v 1709.495n 0.0v 1709.505n 0.0v 1719.495n 0.0v 1719.505n 0.0v 1729.495n 0.0v 1729.505n 0.0v 1739.495n 0.0v 1739.505n 0.0v 1749.495n 0.0v 1749.505n 0.0v 1759.495n 0.0v 1759.505n 1.7v 1769.495n 1.7v 1769.505n 1.7v 1779.495n 1.7v 1779.505n 0.0v 1789.495n 0.0v 1789.505n 0.0v 1799.495n 0.0v 1799.505n 0.0v 1809.495n 0.0v 1809.505n 0.0v 1819.495n 0.0v 1819.505n 0.0v 1829.495n 0.0v 1829.505n 0.0v 1839.495n 0.0v 1839.505n 0.0v 1849.495n 0.0v 1849.505n 0.0v 1859.495n 0.0v 1859.505n 0.0v 1869.495n 0.0v 1869.505n 0.0v 1879.495n 0.0v 1879.505n 0.0v 1889.495n 0.0v 1889.505n 0.0v 1899.495n 0.0v 1899.505n 0.0v 1909.495n 0.0v 1909.505n 0.0v 1919.495n 0.0v 1919.505n 0.0v 1929.495n 0.0v 1929.505n 0.0v 1939.495n 0.0v 1939.505n 1.7v 1949.495n 1.7v 1949.505n 1.7v 1959.495n 1.7v 1959.505n 1.7v 1969.495n 1.7v 1969.505n 1.7v 1979.495n 1.7v 1979.505n 1.7v 1989.495n 1.7v 1989.505n 0.0v 1999.495n 0.0v 1999.505n 0.0v 2009.495n 0.0v 2009.505n 0.0v 2019.495n 0.0v 2019.505n 0.0v 2029.495n 0.0v 2029.505n 0.0v 2039.495n 0.0v 2039.505n 0.0v 2049.495n 0.0v 2049.505n 0.0v )
* (time, data): [(0, 0), (10, 0), (20, 0), (30, 0), (40, 0), (50, 0), (60, 0), (70, 0), (80, 0), (90, 0), (100, 0), (110, 0), (120, 0), (130, 0), (140, 0), (150, 1), (160, 1), (170, 1), (180, 1), (190, 0), (200, 1), (210, 1), (220, 1), (230, 1), (240, 0), (250, 1), (260, 1), (270, 0), (280, 0), (290, 0), (300, 0), (310, 0), (320, 0), (330, 0), (340, 0), (350, 0), (360, 0), (370, 0), (380, 0), (390, 0), (400, 0), (410, 0), (420, 0), (430, 1), (440, 1), (450, 1), (460, 1), (470, 0), (480, 0), (490, 0), (500, 0), (510, 0), (520, 0), (530, 0), (540, 0), (550, 0), (560, 0), (570, 0), (580, 0), (590, 0), (600, 1), (610, 1), (620, 1), (630, 0), (640, 0), (650, 0), (660, 0), (670, 0), (680, 0), (690, 0), (700, 0), (710, 0), (720, 0), (730, 0), (740, 0), (750, 1), (760, 0), (770, 0), (780, 0), (790, 0), (800, 0), (810, 0), (820, 1), (830, 1), (840, 1), (850, 1), (860, 0), (870, 0), (880, 0), (890, 0), (900, 0), (910, 0), (920, 0), (930, 0), (940, 0), (950, 0), (960, 0), (970, 0), (980, 0), (990, 1), (1000, 1), (1010, 1), (1020, 1), (1030, 1), (1040, 1), (1050, 1), (1060, 1), (1070, 0), (1080, 0), (1090, 0), (1100, 0), (1110, 0), (1120, 1), (1130, 1), (1140, 0), (1150, 0), (1160, 0), (1170, 0), (1180, 0), (1190, 0), (1200, 0), (1210, 0), (1220, 0), (1230, 0), (1240, 0), (1250, 0), (1260, 0), (1270, 0), (1280, 0), (1290, 0), (1300, 1), (1310, 1), (1320, 1), (1330, 1), (1340, 1), (1350, 0), (1360, 0), (1370, 0), (1380, 0), (1390, 1), (1400, 1), (1410, 1), (1420, 0), (1430, 0), (1440, 0), (1450, 0), (1460, 0), (1470, 0), (1480, 0), (1490, 1), (1500, 1), (1510, 1), (1520, 0), (1530, 0), (1540, 0), (1550, 1), (1560, 1), (1570, 1), (1580, 1), (1590, 0), (1600, 0), (1610, 0), (1620, 0), (1630, 0), (1640, 0), (1650, 0), (1660, 0), (1670, 1), (1680, 0), (1690, 0), (1700, 0), (1710, 0), (1720, 0), (1730, 0), (1740, 0), (1750, 0), (1760, 1), (1770, 1), (1780, 0), (1790, 0), (1800, 0), (1810, 0), (1820, 0), (1830, 0), (1840, 0), (1850, 0), (1860, 0), (1870, 0), (1880, 0), (1890, 0), (1900, 0), (1910, 0), (1920, 0), (1930, 0), (1940, 1), (1950, 1), (1960, 1), (1970, 1), (1980, 1), (1990, 0), (2000, 0), (2010, 0), (2020, 0), (2030, 0), (2040, 0), (2050, 0)]
Va1_5  a1_5  0 PWL (0n 0.0v 9.495n 0.0v 9.505n 0.0v 19.495n 0.0v 19.505n 0.0v 29.495n 0.0v 29.505n 0.0v 39.495n 0.0v 39.505n 0.0v 49.495n 0.0v 49.505n 0.0v 59.495n 0.0v 59.505n 0.0v 69.495n 0.0v 69.505n 0.0v 79.495n 0.0v 79.505n 0.0v 89.495n 0.0v 89.505n 0.0v 99.495n 0.0v 99.505n 0.0v 109.495n 0.0v 109.505n 0.0v 119.495n 0.0v 119.505n 0.0v 129.495n 0.0v 129.505n 0.0v 139.495n 0.0v 139.505n 0.0v 149.495n 0.0v 149.505n 1.7v 159.495n 1.7v 159.505n 1.7v 169.495n 1.7v 169.505n 1.7v 179.495n 1.7v 179.505n 1.7v 189.495n 1.7v 189.505n 0.0v 199.495n 0.0v 199.505n 1.7v 209.495n 1.7v 209.505n 1.7v 219.495n 1.7v 219.505n 1.7v 229.495n 1.7v 229.505n 1.7v 239.495n 1.7v 239.505n 0.0v 249.495n 0.0v 249.505n 1.7v 259.495n 1.7v 259.505n 1.7v 269.495n 1.7v 269.505n 0.0v 279.495n 0.0v 279.505n 0.0v 289.495n 0.0v 289.505n 0.0v 299.495n 0.0v 299.505n 0.0v 309.495n 0.0v 309.505n 0.0v 319.495n 0.0v 319.505n 0.0v 329.495n 0.0v 329.505n 0.0v 339.495n 0.0v 339.505n 0.0v 349.495n 0.0v 349.505n 0.0v 359.495n 0.0v 359.505n 0.0v 369.495n 0.0v 369.505n 0.0v 379.495n 0.0v 379.505n 0.0v 389.495n 0.0v 389.505n 0.0v 399.495n 0.0v 399.505n 0.0v 409.495n 0.0v 409.505n 0.0v 419.495n 0.0v 419.505n 0.0v 429.495n 0.0v 429.505n 1.7v 439.495n 1.7v 439.505n 1.7v 449.495n 1.7v 449.505n 1.7v 459.495n 1.7v 459.505n 1.7v 469.495n 1.7v 469.505n 0.0v 479.495n 0.0v 479.505n 0.0v 489.495n 0.0v 489.505n 0.0v 499.495n 0.0v 499.505n 0.0v 509.495n 0.0v 509.505n 0.0v 519.495n 0.0v 519.505n 0.0v 529.495n 0.0v 529.505n 0.0v 539.495n 0.0v 539.505n 0.0v 549.495n 0.0v 549.505n 0.0v 559.495n 0.0v 559.505n 0.0v 569.495n 0.0v 569.505n 0.0v 579.495n 0.0v 579.505n 0.0v 589.495n 0.0v 589.505n 0.0v 599.495n 0.0v 599.505n 1.7v 609.495n 1.7v 609.505n 1.7v 619.495n 1.7v 619.505n 1.7v 629.495n 1.7v 629.505n 0.0v 639.495n 0.0v 639.505n 0.0v 649.495n 0.0v 649.505n 0.0v 659.495n 0.0v 659.505n 0.0v 669.495n 0.0v 669.505n 0.0v 679.495n 0.0v 679.505n 0.0v 689.495n 0.0v 689.505n 0.0v 699.495n 0.0v 699.505n 0.0v 709.495n 0.0v 709.505n 0.0v 719.495n 0.0v 719.505n 0.0v 729.495n 0.0v 729.505n 0.0v 739.495n 0.0v 739.505n 0.0v 749.495n 0.0v 749.505n 1.7v 759.495n 1.7v 759.505n 0.0v 769.495n 0.0v 769.505n 0.0v 779.495n 0.0v 779.505n 0.0v 789.495n 0.0v 789.505n 0.0v 799.495n 0.0v 799.505n 0.0v 809.495n 0.0v 809.505n 0.0v 819.495n 0.0v 819.505n 1.7v 829.495n 1.7v 829.505n 1.7v 839.495n 1.7v 839.505n 1.7v 849.495n 1.7v 849.505n 1.7v 859.495n 1.7v 859.505n 0.0v 869.495n 0.0v 869.505n 0.0v 879.495n 0.0v 879.505n 0.0v 889.495n 0.0v 889.505n 0.0v 899.495n 0.0v 899.505n 0.0v 909.495n 0.0v 909.505n 0.0v 919.495n 0.0v 919.505n 0.0v 929.495n 0.0v 929.505n 0.0v 939.495n 0.0v 939.505n 0.0v 949.495n 0.0v 949.505n 0.0v 959.495n 0.0v 959.505n 0.0v 969.495n 0.0v 969.505n 0.0v 979.495n 0.0v 979.505n 0.0v 989.495n 0.0v 989.505n 1.7v 999.495n 1.7v 999.505n 1.7v 1009.495n 1.7v 1009.505n 1.7v 1019.495n 1.7v 1019.505n 1.7v 1029.495n 1.7v 1029.505n 1.7v 1039.495n 1.7v 1039.505n 1.7v 1049.495n 1.7v 1049.505n 1.7v 1059.495n 1.7v 1059.505n 1.7v 1069.495n 1.7v 1069.505n 0.0v 1079.495n 0.0v 1079.505n 0.0v 1089.495n 0.0v 1089.505n 0.0v 1099.495n 0.0v 1099.505n 0.0v 1109.495n 0.0v 1109.505n 0.0v 1119.495n 0.0v 1119.505n 1.7v 1129.495n 1.7v 1129.505n 1.7v 1139.495n 1.7v 1139.505n 0.0v 1149.495n 0.0v 1149.505n 0.0v 1159.495n 0.0v 1159.505n 0.0v 1169.495n 0.0v 1169.505n 0.0v 1179.495n 0.0v 1179.505n 0.0v 1189.495n 0.0v 1189.505n 0.0v 1199.495n 0.0v 1199.505n 0.0v 1209.495n 0.0v 1209.505n 0.0v 1219.495n 0.0v 1219.505n 0.0v 1229.495n 0.0v 1229.505n 0.0v 1239.495n 0.0v 1239.505n 0.0v 1249.495n 0.0v 1249.505n 0.0v 1259.495n 0.0v 1259.505n 0.0v 1269.495n 0.0v 1269.505n 0.0v 1279.495n 0.0v 1279.505n 0.0v 1289.495n 0.0v 1289.505n 0.0v 1299.495n 0.0v 1299.505n 1.7v 1309.495n 1.7v 1309.505n 1.7v 1319.495n 1.7v 1319.505n 1.7v 1329.495n 1.7v 1329.505n 1.7v 1339.495n 1.7v 1339.505n 1.7v 1349.495n 1.7v 1349.505n 0.0v 1359.495n 0.0v 1359.505n 0.0v 1369.495n 0.0v 1369.505n 0.0v 1379.495n 0.0v 1379.505n 0.0v 1389.495n 0.0v 1389.505n 1.7v 1399.495n 1.7v 1399.505n 1.7v 1409.495n 1.7v 1409.505n 1.7v 1419.495n 1.7v 1419.505n 0.0v 1429.495n 0.0v 1429.505n 0.0v 1439.495n 0.0v 1439.505n 0.0v 1449.495n 0.0v 1449.505n 0.0v 1459.495n 0.0v 1459.505n 0.0v 1469.495n 0.0v 1469.505n 0.0v 1479.495n 0.0v 1479.505n 0.0v 1489.495n 0.0v 1489.505n 1.7v 1499.495n 1.7v 1499.505n 1.7v 1509.495n 1.7v 1509.505n 1.7v 1519.495n 1.7v 1519.505n 0.0v 1529.495n 0.0v 1529.505n 0.0v 1539.495n 0.0v 1539.505n 0.0v 1549.495n 0.0v 1549.505n 1.7v 1559.495n 1.7v 1559.505n 1.7v 1569.495n 1.7v 1569.505n 1.7v 1579.495n 1.7v 1579.505n 1.7v 1589.495n 1.7v 1589.505n 0.0v 1599.495n 0.0v 1599.505n 0.0v 1609.495n 0.0v 1609.505n 0.0v 1619.495n 0.0v 1619.505n 0.0v 1629.495n 0.0v 1629.505n 0.0v 1639.495n 0.0v 1639.505n 0.0v 1649.495n 0.0v 1649.505n 0.0v 1659.495n 0.0v 1659.505n 0.0v 1669.495n 0.0v 1669.505n 1.7v 1679.495n 1.7v 1679.505n 0.0v 1689.495n 0.0v 1689.505n 0.0v 1699.495n 0.0v 1699.505n 0.0v 1709.495n 0.0v 1709.505n 0.0v 1719.495n 0.0v 1719.505n 0.0v 1729.495n 0.0v 1729.505n 0.0v 1739.495n 0.0v 1739.505n 0.0v 1749.495n 0.0v 1749.505n 0.0v 1759.495n 0.0v 1759.505n 1.7v 1769.495n 1.7v 1769.505n 1.7v 1779.495n 1.7v 1779.505n 0.0v 1789.495n 0.0v 1789.505n 0.0v 1799.495n 0.0v 1799.505n 0.0v 1809.495n 0.0v 1809.505n 0.0v 1819.495n 0.0v 1819.505n 0.0v 1829.495n 0.0v 1829.505n 0.0v 1839.495n 0.0v 1839.505n 0.0v 1849.495n 0.0v 1849.505n 0.0v 1859.495n 0.0v 1859.505n 0.0v 1869.495n 0.0v 1869.505n 0.0v 1879.495n 0.0v 1879.505n 0.0v 1889.495n 0.0v 1889.505n 0.0v 1899.495n 0.0v 1899.505n 0.0v 1909.495n 0.0v 1909.505n 0.0v 1919.495n 0.0v 1919.505n 0.0v 1929.495n 0.0v 1929.505n 0.0v 1939.495n 0.0v 1939.505n 1.7v 1949.495n 1.7v 1949.505n 1.7v 1959.495n 1.7v 1959.505n 1.7v 1969.495n 1.7v 1969.505n 1.7v 1979.495n 1.7v 1979.505n 1.7v 1989.495n 1.7v 1989.505n 0.0v 1999.495n 0.0v 1999.505n 0.0v 2009.495n 0.0v 2009.505n 0.0v 2019.495n 0.0v 2019.505n 0.0v 2029.495n 0.0v 2029.505n 0.0v 2039.495n 0.0v 2039.505n 0.0v 2049.495n 0.0v 2049.505n 0.0v )
* (time, data): [(0, 0), (10, 0), (20, 0), (30, 0), (40, 0), (50, 0), (60, 0), (70, 0), (80, 0), (90, 0), (100, 0), (110, 0), (120, 0), (130, 0), (140, 0), (150, 1), (160, 1), (170, 1), (180, 1), (190, 0), (200, 1), (210, 1), (220, 1), (230, 1), (240, 0), (250, 1), (260, 1), (270, 0), (280, 0), (290, 0), (300, 0), (310, 0), (320, 0), (330, 0), (340, 0), (350, 0), (360, 0), (370, 0), (380, 0), (390, 0), (400, 0), (410, 0), (420, 0), (430, 1), (440, 1), (450, 1), (460, 1), (470, 0), (480, 0), (490, 0), (500, 0), (510, 0), (520, 0), (530, 0), (540, 0), (550, 0), (560, 0), (570, 0), (580, 0), (590, 0), (600, 1), (610, 1), (620, 1), (630, 0), (640, 0), (650, 0), (660, 0), (670, 0), (680, 0), (690, 0), (700, 0), (710, 0), (720, 0), (730, 0), (740, 0), (750, 1), (760, 0), (770, 0), (780, 0), (790, 0), (800, 0), (810, 0), (820, 1), (830, 1), (840, 1), (850, 1), (860, 0), (870, 0), (880, 0), (890, 0), (900, 0), (910, 0), (920, 0), (930, 0), (940, 0), (950, 0), (960, 0), (970, 0), (980, 0), (990, 1), (1000, 1), (1010, 1), (1020, 1), (1030, 1), (1040, 1), (1050, 1), (1060, 1), (1070, 0), (1080, 0), (1090, 0), (1100, 0), (1110, 0), (1120, 1), (1130, 1), (1140, 0), (1150, 0), (1160, 0), (1170, 0), (1180, 0), (1190, 0), (1200, 0), (1210, 0), (1220, 0), (1230, 0), (1240, 0), (1250, 0), (1260, 0), (1270, 0), (1280, 0), (1290, 0), (1300, 1), (1310, 1), (1320, 1), (1330, 1), (1340, 1), (1350, 0), (1360, 0), (1370, 0), (1380, 0), (1390, 1), (1400, 1), (1410, 1), (1420, 0), (1430, 0), (1440, 0), (1450, 0), (1460, 0), (1470, 0), (1480, 0), (1490, 1), (1500, 1), (1510, 1), (1520, 0), (1530, 0), (1540, 0), (1550, 1), (1560, 1), (1570, 1), (1580, 1), (1590, 0), (1600, 0), (1610, 0), (1620, 0), (1630, 0), (1640, 0), (1650, 0), (1660, 0), (1670, 1), (1680, 0), (1690, 0), (1700, 0), (1710, 0), (1720, 0), (1730, 0), (1740, 0), (1750, 0), (1760, 1), (1770, 1), (1780, 0), (1790, 0), (1800, 0), (1810, 0), (1820, 0), (1830, 0), (1840, 0), (1850, 0), (1860, 0), (1870, 0), (1880, 0), (1890, 0), (1900, 0), (1910, 0), (1920, 0), (1930, 0), (1940, 1), (1950, 1), (1960, 1), (1970, 1), (1980, 1), (1990, 0), (2000, 0), (2010, 0), (2020, 0), (2030, 0), (2040, 0), (2050, 0)]
Va1_6  a1_6  0 PWL (0n 0.0v 9.495n 0.0v 9.505n 0.0v 19.495n 0.0v 19.505n 0.0v 29.495n 0.0v 29.505n 0.0v 39.495n 0.0v 39.505n 0.0v 49.495n 0.0v 49.505n 0.0v 59.495n 0.0v 59.505n 0.0v 69.495n 0.0v 69.505n 0.0v 79.495n 0.0v 79.505n 0.0v 89.495n 0.0v 89.505n 0.0v 99.495n 0.0v 99.505n 0.0v 109.495n 0.0v 109.505n 0.0v 119.495n 0.0v 119.505n 0.0v 129.495n 0.0v 129.505n 0.0v 139.495n 0.0v 139.505n 0.0v 149.495n 0.0v 149.505n 1.7v 159.495n 1.7v 159.505n 1.7v 169.495n 1.7v 169.505n 1.7v 179.495n 1.7v 179.505n 1.7v 189.495n 1.7v 189.505n 0.0v 199.495n 0.0v 199.505n 1.7v 209.495n 1.7v 209.505n 1.7v 219.495n 1.7v 219.505n 1.7v 229.495n 1.7v 229.505n 1.7v 239.495n 1.7v 239.505n 0.0v 249.495n 0.0v 249.505n 1.7v 259.495n 1.7v 259.505n 1.7v 269.495n 1.7v 269.505n 0.0v 279.495n 0.0v 279.505n 0.0v 289.495n 0.0v 289.505n 0.0v 299.495n 0.0v 299.505n 0.0v 309.495n 0.0v 309.505n 0.0v 319.495n 0.0v 319.505n 0.0v 329.495n 0.0v 329.505n 0.0v 339.495n 0.0v 339.505n 0.0v 349.495n 0.0v 349.505n 0.0v 359.495n 0.0v 359.505n 0.0v 369.495n 0.0v 369.505n 0.0v 379.495n 0.0v 379.505n 0.0v 389.495n 0.0v 389.505n 0.0v 399.495n 0.0v 399.505n 0.0v 409.495n 0.0v 409.505n 0.0v 419.495n 0.0v 419.505n 0.0v 429.495n 0.0v 429.505n 1.7v 439.495n 1.7v 439.505n 1.7v 449.495n 1.7v 449.505n 1.7v 459.495n 1.7v 459.505n 1.7v 469.495n 1.7v 469.505n 0.0v 479.495n 0.0v 479.505n 0.0v 489.495n 0.0v 489.505n 0.0v 499.495n 0.0v 499.505n 0.0v 509.495n 0.0v 509.505n 0.0v 519.495n 0.0v 519.505n 0.0v 529.495n 0.0v 529.505n 0.0v 539.495n 0.0v 539.505n 0.0v 549.495n 0.0v 549.505n 0.0v 559.495n 0.0v 559.505n 0.0v 569.495n 0.0v 569.505n 0.0v 579.495n 0.0v 579.505n 0.0v 589.495n 0.0v 589.505n 0.0v 599.495n 0.0v 599.505n 1.7v 609.495n 1.7v 609.505n 1.7v 619.495n 1.7v 619.505n 1.7v 629.495n 1.7v 629.505n 0.0v 639.495n 0.0v 639.505n 0.0v 649.495n 0.0v 649.505n 0.0v 659.495n 0.0v 659.505n 0.0v 669.495n 0.0v 669.505n 0.0v 679.495n 0.0v 679.505n 0.0v 689.495n 0.0v 689.505n 0.0v 699.495n 0.0v 699.505n 0.0v 709.495n 0.0v 709.505n 0.0v 719.495n 0.0v 719.505n 0.0v 729.495n 0.0v 729.505n 0.0v 739.495n 0.0v 739.505n 0.0v 749.495n 0.0v 749.505n 1.7v 759.495n 1.7v 759.505n 0.0v 769.495n 0.0v 769.505n 0.0v 779.495n 0.0v 779.505n 0.0v 789.495n 0.0v 789.505n 0.0v 799.495n 0.0v 799.505n 0.0v 809.495n 0.0v 809.505n 0.0v 819.495n 0.0v 819.505n 1.7v 829.495n 1.7v 829.505n 1.7v 839.495n 1.7v 839.505n 1.7v 849.495n 1.7v 849.505n 1.7v 859.495n 1.7v 859.505n 0.0v 869.495n 0.0v 869.505n 0.0v 879.495n 0.0v 879.505n 0.0v 889.495n 0.0v 889.505n 0.0v 899.495n 0.0v 899.505n 0.0v 909.495n 0.0v 909.505n 0.0v 919.495n 0.0v 919.505n 0.0v 929.495n 0.0v 929.505n 0.0v 939.495n 0.0v 939.505n 0.0v 949.495n 0.0v 949.505n 0.0v 959.495n 0.0v 959.505n 0.0v 969.495n 0.0v 969.505n 0.0v 979.495n 0.0v 979.505n 0.0v 989.495n 0.0v 989.505n 1.7v 999.495n 1.7v 999.505n 1.7v 1009.495n 1.7v 1009.505n 1.7v 1019.495n 1.7v 1019.505n 1.7v 1029.495n 1.7v 1029.505n 1.7v 1039.495n 1.7v 1039.505n 1.7v 1049.495n 1.7v 1049.505n 1.7v 1059.495n 1.7v 1059.505n 1.7v 1069.495n 1.7v 1069.505n 0.0v 1079.495n 0.0v 1079.505n 0.0v 1089.495n 0.0v 1089.505n 0.0v 1099.495n 0.0v 1099.505n 0.0v 1109.495n 0.0v 1109.505n 0.0v 1119.495n 0.0v 1119.505n 1.7v 1129.495n 1.7v 1129.505n 1.7v 1139.495n 1.7v 1139.505n 0.0v 1149.495n 0.0v 1149.505n 0.0v 1159.495n 0.0v 1159.505n 0.0v 1169.495n 0.0v 1169.505n 0.0v 1179.495n 0.0v 1179.505n 0.0v 1189.495n 0.0v 1189.505n 0.0v 1199.495n 0.0v 1199.505n 0.0v 1209.495n 0.0v 1209.505n 0.0v 1219.495n 0.0v 1219.505n 0.0v 1229.495n 0.0v 1229.505n 0.0v 1239.495n 0.0v 1239.505n 0.0v 1249.495n 0.0v 1249.505n 0.0v 1259.495n 0.0v 1259.505n 0.0v 1269.495n 0.0v 1269.505n 0.0v 1279.495n 0.0v 1279.505n 0.0v 1289.495n 0.0v 1289.505n 0.0v 1299.495n 0.0v 1299.505n 1.7v 1309.495n 1.7v 1309.505n 1.7v 1319.495n 1.7v 1319.505n 1.7v 1329.495n 1.7v 1329.505n 1.7v 1339.495n 1.7v 1339.505n 1.7v 1349.495n 1.7v 1349.505n 0.0v 1359.495n 0.0v 1359.505n 0.0v 1369.495n 0.0v 1369.505n 0.0v 1379.495n 0.0v 1379.505n 0.0v 1389.495n 0.0v 1389.505n 1.7v 1399.495n 1.7v 1399.505n 1.7v 1409.495n 1.7v 1409.505n 1.7v 1419.495n 1.7v 1419.505n 0.0v 1429.495n 0.0v 1429.505n 0.0v 1439.495n 0.0v 1439.505n 0.0v 1449.495n 0.0v 1449.505n 0.0v 1459.495n 0.0v 1459.505n 0.0v 1469.495n 0.0v 1469.505n 0.0v 1479.495n 0.0v 1479.505n 0.0v 1489.495n 0.0v 1489.505n 1.7v 1499.495n 1.7v 1499.505n 1.7v 1509.495n 1.7v 1509.505n 1.7v 1519.495n 1.7v 1519.505n 0.0v 1529.495n 0.0v 1529.505n 0.0v 1539.495n 0.0v 1539.505n 0.0v 1549.495n 0.0v 1549.505n 1.7v 1559.495n 1.7v 1559.505n 1.7v 1569.495n 1.7v 1569.505n 1.7v 1579.495n 1.7v 1579.505n 1.7v 1589.495n 1.7v 1589.505n 0.0v 1599.495n 0.0v 1599.505n 0.0v 1609.495n 0.0v 1609.505n 0.0v 1619.495n 0.0v 1619.505n 0.0v 1629.495n 0.0v 1629.505n 0.0v 1639.495n 0.0v 1639.505n 0.0v 1649.495n 0.0v 1649.505n 0.0v 1659.495n 0.0v 1659.505n 0.0v 1669.495n 0.0v 1669.505n 1.7v 1679.495n 1.7v 1679.505n 0.0v 1689.495n 0.0v 1689.505n 0.0v 1699.495n 0.0v 1699.505n 0.0v 1709.495n 0.0v 1709.505n 0.0v 1719.495n 0.0v 1719.505n 0.0v 1729.495n 0.0v 1729.505n 0.0v 1739.495n 0.0v 1739.505n 0.0v 1749.495n 0.0v 1749.505n 0.0v 1759.495n 0.0v 1759.505n 1.7v 1769.495n 1.7v 1769.505n 1.7v 1779.495n 1.7v 1779.505n 0.0v 1789.495n 0.0v 1789.505n 0.0v 1799.495n 0.0v 1799.505n 0.0v 1809.495n 0.0v 1809.505n 0.0v 1819.495n 0.0v 1819.505n 0.0v 1829.495n 0.0v 1829.505n 0.0v 1839.495n 0.0v 1839.505n 0.0v 1849.495n 0.0v 1849.505n 0.0v 1859.495n 0.0v 1859.505n 0.0v 1869.495n 0.0v 1869.505n 0.0v 1879.495n 0.0v 1879.505n 0.0v 1889.495n 0.0v 1889.505n 0.0v 1899.495n 0.0v 1899.505n 0.0v 1909.495n 0.0v 1909.505n 0.0v 1919.495n 0.0v 1919.505n 0.0v 1929.495n 0.0v 1929.505n 0.0v 1939.495n 0.0v 1939.505n 1.7v 1949.495n 1.7v 1949.505n 1.7v 1959.495n 1.7v 1959.505n 1.7v 1969.495n 1.7v 1969.505n 1.7v 1979.495n 1.7v 1979.505n 1.7v 1989.495n 1.7v 1989.505n 0.0v 1999.495n 0.0v 1999.505n 0.0v 2009.495n 0.0v 2009.505n 0.0v 2019.495n 0.0v 2019.505n 0.0v 2029.495n 0.0v 2029.505n 0.0v 2039.495n 0.0v 2039.505n 0.0v 2049.495n 0.0v 2049.505n 0.0v )
* (time, data): [(0, 0), (10, 0), (20, 0), (30, 0), (40, 1), (50, 0), (60, 0), (70, 0), (80, 0), (90, 0), (100, 1), (110, 1), (120, 1), (130, 0), (140, 0), (150, 0), (160, 0), (170, 0), (180, 0), (190, 1), (200, 0), (210, 0), (220, 0), (230, 0), (240, 0), (250, 0), (260, 0), (270, 1), (280, 1), (290, 1), (300, 0), (310, 0), (320, 0), (330, 0), (340, 0), (350, 0), (360, 0), (370, 0), (380, 0), (390, 1), (400, 1), (410, 0), (420, 0), (430, 0), (440, 0), (450, 0), (460, 0), (470, 1), (480, 0), (490, 0), (500, 0), (510, 0), (520, 0), (530, 0), (540, 0), (550, 0), (560, 0), (570, 0), (580, 0), (590, 0), (600, 0), (610, 0), (620, 0), (630, 1), (640, 1), (650, 1), (660, 0), (670, 0), (680, 1), (690, 0), (700, 0), (710, 0), (720, 0), (730, 0), (740, 1), (750, 0), (760, 0), (770, 1), (780, 1), (790, 1), (800, 0), (810, 1), (820, 0), (830, 0), (840, 0), (850, 0), (860, 0), (870, 1), (880, 1), (890, 1), (900, 1), (910, 0), (920, 0), (930, 0), (940, 0), (950, 0), (960, 0), (970, 0), (980, 0), (990, 0), (1000, 0), (1010, 0), (1020, 0), (1030, 0), (1040, 0), (1050, 0), (1060, 0), (1070, 1), (1080, 1), (1090, 1), (1100, 1), (1110, 1), (1120, 0), (1130, 0), (1140, 1), (1150, 0), (1160, 0), (1170, 0), (1180, 0), (1190, 1), (1200, 1), (1210, 1), (1220, 0), (1230, 1), (1240, 1), (1250, 1), (1260, 0), (1270, 1), (1280, 0), (1290, 0), (1300, 0), (1310, 0), (1320, 0), (1330, 0), (1340, 0), (1350, 1), (1360, 1), (1370, 0), (1380, 0), (1390, 0), (1400, 0), (1410, 0), (1420, 0), (1430, 0), (1440, 0), (1450, 1), (1460, 1), (1470, 1), (1480, 1), (1490, 0), (1500, 0), (1510, 0), (1520, 1), (1530, 1), (1540, 1), (1550, 0), (1560, 0), (1570, 0), (1580, 0), (1590, 1), (1600, 0), (1610, 1), (1620, 1), (1630, 0), (1640, 0), (1650, 0), (1660, 0), (1670, 0), (1680, 0), (1690, 0), (1700, 0), (1710, 0), (1720, 0), (1730, 0), (1740, 0), (1750, 0), (1760, 0), (1770, 0), (1780, 0), (1790, 0), (1800, 0), (1810, 0), (1820, 0), (1830, 1), (1840, 1), (1850, 1), (1860, 1), (1870, 1), (1880, 0), (1890, 0), (1900, 0), (1910, 0), (1920, 0), (1930, 0), (1940, 0), (1950, 0), (1960, 0), (1970, 0), (1980, 0), (1990, 1), (2000, 1), (2010, 1), (2020, 1), (2030, 1), (2040, 1), (2050, 1)]
Va1_7  a1_7  0 PWL (0n 0.0v 9.495n 0.0v 9.505n 0.0v 19.495n 0.0v 19.505n 0.0v 29.495n 0.0v 29.505n 0.0v 39.495n 0.0v 39.505n 1.7v 49.495n 1.7v 49.505n 0.0v 59.495n 0.0v 59.505n 0.0v 69.495n 0.0v 69.505n 0.0v 79.495n 0.0v 79.505n 0.0v 89.495n 0.0v 89.505n 0.0v 99.495n 0.0v 99.505n 1.7v 109.495n 1.7v 109.505n 1.7v 119.495n 1.7v 119.505n 1.7v 129.495n 1.7v 129.505n 0.0v 139.495n 0.0v 139.505n 0.0v 149.495n 0.0v 149.505n 0.0v 159.495n 0.0v 159.505n 0.0v 169.495n 0.0v 169.505n 0.0v 179.495n 0.0v 179.505n 0.0v 189.495n 0.0v 189.505n 1.7v 199.495n 1.7v 199.505n 0.0v 209.495n 0.0v 209.505n 0.0v 219.495n 0.0v 219.505n 0.0v 229.495n 0.0v 229.505n 0.0v 239.495n 0.0v 239.505n 0.0v 249.495n 0.0v 249.505n 0.0v 259.495n 0.0v 259.505n 0.0v 269.495n 0.0v 269.505n 1.7v 279.495n 1.7v 279.505n 1.7v 289.495n 1.7v 289.505n 1.7v 299.495n 1.7v 299.505n 0.0v 309.495n 0.0v 309.505n 0.0v 319.495n 0.0v 319.505n 0.0v 329.495n 0.0v 329.505n 0.0v 339.495n 0.0v 339.505n 0.0v 349.495n 0.0v 349.505n 0.0v 359.495n 0.0v 359.505n 0.0v 369.495n 0.0v 369.505n 0.0v 379.495n 0.0v 379.505n 0.0v 389.495n 0.0v 389.505n 1.7v 399.495n 1.7v 399.505n 1.7v 409.495n 1.7v 409.505n 0.0v 419.495n 0.0v 419.505n 0.0v 429.495n 0.0v 429.505n 0.0v 439.495n 0.0v 439.505n 0.0v 449.495n 0.0v 449.505n 0.0v 459.495n 0.0v 459.505n 0.0v 469.495n 0.0v 469.505n 1.7v 479.495n 1.7v 479.505n 0.0v 489.495n 0.0v 489.505n 0.0v 499.495n 0.0v 499.505n 0.0v 509.495n 0.0v 509.505n 0.0v 519.495n 0.0v 519.505n 0.0v 529.495n 0.0v 529.505n 0.0v 539.495n 0.0v 539.505n 0.0v 549.495n 0.0v 549.505n 0.0v 559.495n 0.0v 559.505n 0.0v 569.495n 0.0v 569.505n 0.0v 579.495n 0.0v 579.505n 0.0v 589.495n 0.0v 589.505n 0.0v 599.495n 0.0v 599.505n 0.0v 609.495n 0.0v 609.505n 0.0v 619.495n 0.0v 619.505n 0.0v 629.495n 0.0v 629.505n 1.7v 639.495n 1.7v 639.505n 1.7v 649.495n 1.7v 649.505n 1.7v 659.495n 1.7v 659.505n 0.0v 669.495n 0.0v 669.505n 0.0v 679.495n 0.0v 679.505n 1.7v 689.495n 1.7v 689.505n 0.0v 699.495n 0.0v 699.505n 0.0v 709.495n 0.0v 709.505n 0.0v 719.495n 0.0v 719.505n 0.0v 729.495n 0.0v 729.505n 0.0v 739.495n 0.0v 739.505n 1.7v 749.495n 1.7v 749.505n 0.0v 759.495n 0.0v 759.505n 0.0v 769.495n 0.0v 769.505n 1.7v 779.495n 1.7v 779.505n 1.7v 789.495n 1.7v 789.505n 1.7v 799.495n 1.7v 799.505n 0.0v 809.495n 0.0v 809.505n 1.7v 819.495n 1.7v 819.505n 0.0v 829.495n 0.0v 829.505n 0.0v 839.495n 0.0v 839.505n 0.0v 849.495n 0.0v 849.505n 0.0v 859.495n 0.0v 859.505n 0.0v 869.495n 0.0v 869.505n 1.7v 879.495n 1.7v 879.505n 1.7v 889.495n 1.7v 889.505n 1.7v 899.495n 1.7v 899.505n 1.7v 909.495n 1.7v 909.505n 0.0v 919.495n 0.0v 919.505n 0.0v 929.495n 0.0v 929.505n 0.0v 939.495n 0.0v 939.505n 0.0v 949.495n 0.0v 949.505n 0.0v 959.495n 0.0v 959.505n 0.0v 969.495n 0.0v 969.505n 0.0v 979.495n 0.0v 979.505n 0.0v 989.495n 0.0v 989.505n 0.0v 999.495n 0.0v 999.505n 0.0v 1009.495n 0.0v 1009.505n 0.0v 1019.495n 0.0v 1019.505n 0.0v 1029.495n 0.0v 1029.505n 0.0v 1039.495n 0.0v 1039.505n 0.0v 1049.495n 0.0v 1049.505n 0.0v 1059.495n 0.0v 1059.505n 0.0v 1069.495n 0.0v 1069.505n 1.7v 1079.495n 1.7v 1079.505n 1.7v 1089.495n 1.7v 1089.505n 1.7v 1099.495n 1.7v 1099.505n 1.7v 1109.495n 1.7v 1109.505n 1.7v 1119.495n 1.7v 1119.505n 0.0v 1129.495n 0.0v 1129.505n 0.0v 1139.495n 0.0v 1139.505n 1.7v 1149.495n 1.7v 1149.505n 0.0v 1159.495n 0.0v 1159.505n 0.0v 1169.495n 0.0v 1169.505n 0.0v 1179.495n 0.0v 1179.505n 0.0v 1189.495n 0.0v 1189.505n 1.7v 1199.495n 1.7v 1199.505n 1.7v 1209.495n 1.7v 1209.505n 1.7v 1219.495n 1.7v 1219.505n 0.0v 1229.495n 0.0v 1229.505n 1.7v 1239.495n 1.7v 1239.505n 1.7v 1249.495n 1.7v 1249.505n 1.7v 1259.495n 1.7v 1259.505n 0.0v 1269.495n 0.0v 1269.505n 1.7v 1279.495n 1.7v 1279.505n 0.0v 1289.495n 0.0v 1289.505n 0.0v 1299.495n 0.0v 1299.505n 0.0v 1309.495n 0.0v 1309.505n 0.0v 1319.495n 0.0v 1319.505n 0.0v 1329.495n 0.0v 1329.505n 0.0v 1339.495n 0.0v 1339.505n 0.0v 1349.495n 0.0v 1349.505n 1.7v 1359.495n 1.7v 1359.505n 1.7v 1369.495n 1.7v 1369.505n 0.0v 1379.495n 0.0v 1379.505n 0.0v 1389.495n 0.0v 1389.505n 0.0v 1399.495n 0.0v 1399.505n 0.0v 1409.495n 0.0v 1409.505n 0.0v 1419.495n 0.0v 1419.505n 0.0v 1429.495n 0.0v 1429.505n 0.0v 1439.495n 0.0v 1439.505n 0.0v 1449.495n 0.0v 1449.505n 1.7v 1459.495n 1.7v 1459.505n 1.7v 1469.495n 1.7v 1469.505n 1.7v 1479.495n 1.7v 1479.505n 1.7v 1489.495n 1.7v 1489.505n 0.0v 1499.495n 0.0v 1499.505n 0.0v 1509.495n 0.0v 1509.505n 0.0v 1519.495n 0.0v 1519.505n 1.7v 1529.495n 1.7v 1529.505n 1.7v 1539.495n 1.7v 1539.505n 1.7v 1549.495n 1.7v 1549.505n 0.0v 1559.495n 0.0v 1559.505n 0.0v 1569.495n 0.0v 1569.505n 0.0v 1579.495n 0.0v 1579.505n 0.0v 1589.495n 0.0v 1589.505n 1.7v 1599.495n 1.7v 1599.505n 0.0v 1609.495n 0.0v 1609.505n 1.7v 1619.495n 1.7v 1619.505n 1.7v 1629.495n 1.7v 1629.505n 0.0v 1639.495n 0.0v 1639.505n 0.0v 1649.495n 0.0v 1649.505n 0.0v 1659.495n 0.0v 1659.505n 0.0v 1669.495n 0.0v 1669.505n 0.0v 1679.495n 0.0v 1679.505n 0.0v 1689.495n 0.0v 1689.505n 0.0v 1699.495n 0.0v 1699.505n 0.0v 1709.495n 0.0v 1709.505n 0.0v 1719.495n 0.0v 1719.505n 0.0v 1729.495n 0.0v 1729.505n 0.0v 1739.495n 0.0v 1739.505n 0.0v 1749.495n 0.0v 1749.505n 0.0v 1759.495n 0.0v 1759.505n 0.0v 1769.495n 0.0v 1769.505n 0.0v 1779.495n 0.0v 1779.505n 0.0v 1789.495n 0.0v 1789.505n 0.0v 1799.495n 0.0v 1799.505n 0.0v 1809.495n 0.0v 1809.505n 0.0v 1819.495n 0.0v 1819.505n 0.0v 1829.495n 0.0v 1829.505n 1.7v 1839.495n 1.7v 1839.505n 1.7v 1849.495n 1.7v 1849.505n 1.7v 1859.495n 1.7v 1859.505n 1.7v 1869.495n 1.7v 1869.505n 1.7v 1879.495n 1.7v 1879.505n 0.0v 1889.495n 0.0v 1889.505n 0.0v 1899.495n 0.0v 1899.505n 0.0v 1909.495n 0.0v 1909.505n 0.0v 1919.495n 0.0v 1919.505n 0.0v 1929.495n 0.0v 1929.505n 0.0v 1939.495n 0.0v 1939.505n 0.0v 1949.495n 0.0v 1949.505n 0.0v 1959.495n 0.0v 1959.505n 0.0v 1969.495n 0.0v 1969.505n 0.0v 1979.495n 0.0v 1979.505n 0.0v 1989.495n 0.0v 1989.505n 1.7v 1999.495n 1.7v 1999.505n 1.7v 2009.495n 1.7v 2009.505n 1.7v 2019.495n 1.7v 2019.505n 1.7v 2029.495n 1.7v 2029.505n 1.7v 2039.495n 1.7v 2039.505n 1.7v 2049.495n 1.7v 2049.505n 1.7v )

 * Generation of control signals
* (time, data): [(0, 1), (10, 0), (20, 0), (30, 0), (40, 1), (50, 1), (60, 0), (70, 1), (80, 1), (90, 0), (100, 0), (110, 0), (120, 1), (130, 1), (140, 1), (150, 0), (160, 1), (170, 1), (180, 1), (190, 0), (200, 0), (210, 0), (220, 1), (230, 1), (240, 1), (250, 1), (260, 1), (270, 1), (280, 0), (290, 1), (300, 1), (310, 0), (320, 0), (330, 0), (340, 1), (350, 1), (360, 1), (370, 1), (380, 1), (390, 1), (400, 1), (410, 1), (420, 0), (430, 1), (440, 0), (450, 1), (460, 0), (470, 0), (480, 1), (490, 1), (500, 0), (510, 0), (520, 0), (530, 1), (540, 1), (550, 0), (560, 0), (570, 1), (580, 1), (590, 1), (600, 0), (610, 0), (620, 0), (630, 0), (640, 1), (650, 0), (660, 1), (670, 0), (680, 0), (690, 1), (700, 0), (710, 0), (720, 1), (730, 1), (740, 0), (750, 1), (760, 1), (770, 0), (780, 0), (790, 0), (800, 0), (810, 1), (820, 0), (830, 0), (840, 0), (850, 1), (860, 0), (870, 0), (880, 0), (890, 1), (900, 0), (910, 1), (920, 0), (930, 1), (940, 1), (950, 1), (960, 0), (970, 0), (980, 0), (990, 0), (1000, 0), (1010, 0), (1020, 0), (1030, 0), (1040, 1), (1050, 1), (1060, 1), (1070, 0), (1080, 0), (1090, 0), (1100, 0), (1110, 0), (1120, 1), (1130, 0), (1140, 0), (1150, 0), (1160, 1), (1170, 0), (1180, 0), (1190, 1), (1200, 1), (1210, 1), (1220, 0), (1230, 0), (1240, 0), (1250, 0), (1260, 1), (1270, 1), (1280, 1), (1290, 0), (1300, 0), (1310, 1), (1320, 1), (1330, 1), (1340, 0), (1350, 1), (1360, 0), (1370, 0), (1380, 1), (1390, 1), (1400, 0), (1410, 1), (1420, 1), (1430, 1), (1440, 1), (1450, 1), (1460, 1), (1470, 1), (1480, 0), (1490, 1), (1500, 0), (1510, 0), (1520, 1), (1530, 1), (1540, 0), (1550, 0), (1560, 0), (1570, 1), (1580, 0), (1590, 1), (1600, 1), (1610, 1), (1620, 0), (1630, 0), (1640, 1), (1650, 0), (1660, 0), (1670, 1), (1680, 1), (1690, 1), (1700, 1), (1710, 0), (1720, 1), (1730, 0), (1740, 1), (1750, 0), (1760, 1), (1770, 0), (1780, 0), (1790, 1), (1800, 0), (1810, 1), (1820, 1), (1830, 1), (1840, 0), (1850, 1), (1860, 0), (1870, 1), (1880, 1), (1890, 1), (1900, 1), (1910, 0), (1920, 0), (1930, 0), (1940, 0), (1950, 0), (1960, 1), (1970, 0), (1980, 0), (1990, 1), (2000, 0), (2010, 0), (2020, 0), (2030, 1), (2040, 1), (2050, 1)]
VCSB0 CSB0 0 PWL (0n 1.7v 9.495n 1.7v 9.505n 0.0v 19.495n 0.0v 19.505n 0.0v 29.495n 0.0v 29.505n 0.0v 39.495n 0.0v 39.505n 1.7v 49.495n 1.7v 49.505n 1.7v 59.495n 1.7v 59.505n 0.0v 69.495n 0.0v 69.505n 1.7v 79.495n 1.7v 79.505n 1.7v 89.495n 1.7v 89.505n 0.0v 99.495n 0.0v 99.505n 0.0v 109.495n 0.0v 109.505n 0.0v 119.495n 0.0v 119.505n 1.7v 129.495n 1.7v 129.505n 1.7v 139.495n 1.7v 139.505n 1.7v 149.495n 1.7v 149.505n 0.0v 159.495n 0.0v 159.505n 1.7v 169.495n 1.7v 169.505n 1.7v 179.495n 1.7v 179.505n 1.7v 189.495n 1.7v 189.505n 0.0v 199.495n 0.0v 199.505n 0.0v 209.495n 0.0v 209.505n 0.0v 219.495n 0.0v 219.505n 1.7v 229.495n 1.7v 229.505n 1.7v 239.495n 1.7v 239.505n 1.7v 249.495n 1.7v 249.505n 1.7v 259.495n 1.7v 259.505n 1.7v 269.495n 1.7v 269.505n 1.7v 279.495n 1.7v 279.505n 0.0v 289.495n 0.0v 289.505n 1.7v 299.495n 1.7v 299.505n 1.7v 309.495n 1.7v 309.505n 0.0v 319.495n 0.0v 319.505n 0.0v 329.495n 0.0v 329.505n 0.0v 339.495n 0.0v 339.505n 1.7v 349.495n 1.7v 349.505n 1.7v 359.495n 1.7v 359.505n 1.7v 369.495n 1.7v 369.505n 1.7v 379.495n 1.7v 379.505n 1.7v 389.495n 1.7v 389.505n 1.7v 399.495n 1.7v 399.505n 1.7v 409.495n 1.7v 409.505n 1.7v 419.495n 1.7v 419.505n 0.0v 429.495n 0.0v 429.505n 1.7v 439.495n 1.7v 439.505n 0.0v 449.495n 0.0v 449.505n 1.7v 459.495n 1.7v 459.505n 0.0v 469.495n 0.0v 469.505n 0.0v 479.495n 0.0v 479.505n 1.7v 489.495n 1.7v 489.505n 1.7v 499.495n 1.7v 499.505n 0.0v 509.495n 0.0v 509.505n 0.0v 519.495n 0.0v 519.505n 0.0v 529.495n 0.0v 529.505n 1.7v 539.495n 1.7v 539.505n 1.7v 549.495n 1.7v 549.505n 0.0v 559.495n 0.0v 559.505n 0.0v 569.495n 0.0v 569.505n 1.7v 579.495n 1.7v 579.505n 1.7v 589.495n 1.7v 589.505n 1.7v 599.495n 1.7v 599.505n 0.0v 609.495n 0.0v 609.505n 0.0v 619.495n 0.0v 619.505n 0.0v 629.495n 0.0v 629.505n 0.0v 639.495n 0.0v 639.505n 1.7v 649.495n 1.7v 649.505n 0.0v 659.495n 0.0v 659.505n 1.7v 669.495n 1.7v 669.505n 0.0v 679.495n 0.0v 679.505n 0.0v 689.495n 0.0v 689.505n 1.7v 699.495n 1.7v 699.505n 0.0v 709.495n 0.0v 709.505n 0.0v 719.495n 0.0v 719.505n 1.7v 729.495n 1.7v 729.505n 1.7v 739.495n 1.7v 739.505n 0.0v 749.495n 0.0v 749.505n 1.7v 759.495n 1.7v 759.505n 1.7v 769.495n 1.7v 769.505n 0.0v 779.495n 0.0v 779.505n 0.0v 789.495n 0.0v 789.505n 0.0v 799.495n 0.0v 799.505n 0.0v 809.495n 0.0v 809.505n 1.7v 819.495n 1.7v 819.505n 0.0v 829.495n 0.0v 829.505n 0.0v 839.495n 0.0v 839.505n 0.0v 849.495n 0.0v 849.505n 1.7v 859.495n 1.7v 859.505n 0.0v 869.495n 0.0v 869.505n 0.0v 879.495n 0.0v 879.505n 0.0v 889.495n 0.0v 889.505n 1.7v 899.495n 1.7v 899.505n 0.0v 909.495n 0.0v 909.505n 1.7v 919.495n 1.7v 919.505n 0.0v 929.495n 0.0v 929.505n 1.7v 939.495n 1.7v 939.505n 1.7v 949.495n 1.7v 949.505n 1.7v 959.495n 1.7v 959.505n 0.0v 969.495n 0.0v 969.505n 0.0v 979.495n 0.0v 979.505n 0.0v 989.495n 0.0v 989.505n 0.0v 999.495n 0.0v 999.505n 0.0v 1009.495n 0.0v 1009.505n 0.0v 1019.495n 0.0v 1019.505n 0.0v 1029.495n 0.0v 1029.505n 0.0v 1039.495n 0.0v 1039.505n 1.7v 1049.495n 1.7v 1049.505n 1.7v 1059.495n 1.7v 1059.505n 1.7v 1069.495n 1.7v 1069.505n 0.0v 1079.495n 0.0v 1079.505n 0.0v 1089.495n 0.0v 1089.505n 0.0v 1099.495n 0.0v 1099.505n 0.0v 1109.495n 0.0v 1109.505n 0.0v 1119.495n 0.0v 1119.505n 1.7v 1129.495n 1.7v 1129.505n 0.0v 1139.495n 0.0v 1139.505n 0.0v 1149.495n 0.0v 1149.505n 0.0v 1159.495n 0.0v 1159.505n 1.7v 1169.495n 1.7v 1169.505n 0.0v 1179.495n 0.0v 1179.505n 0.0v 1189.495n 0.0v 1189.505n 1.7v 1199.495n 1.7v 1199.505n 1.7v 1209.495n 1.7v 1209.505n 1.7v 1219.495n 1.7v 1219.505n 0.0v 1229.495n 0.0v 1229.505n 0.0v 1239.495n 0.0v 1239.505n 0.0v 1249.495n 0.0v 1249.505n 0.0v 1259.495n 0.0v 1259.505n 1.7v 1269.495n 1.7v 1269.505n 1.7v 1279.495n 1.7v 1279.505n 1.7v 1289.495n 1.7v 1289.505n 0.0v 1299.495n 0.0v 1299.505n 0.0v 1309.495n 0.0v 1309.505n 1.7v 1319.495n 1.7v 1319.505n 1.7v 1329.495n 1.7v 1329.505n 1.7v 1339.495n 1.7v 1339.505n 0.0v 1349.495n 0.0v 1349.505n 1.7v 1359.495n 1.7v 1359.505n 0.0v 1369.495n 0.0v 1369.505n 0.0v 1379.495n 0.0v 1379.505n 1.7v 1389.495n 1.7v 1389.505n 1.7v 1399.495n 1.7v 1399.505n 0.0v 1409.495n 0.0v 1409.505n 1.7v 1419.495n 1.7v 1419.505n 1.7v 1429.495n 1.7v 1429.505n 1.7v 1439.495n 1.7v 1439.505n 1.7v 1449.495n 1.7v 1449.505n 1.7v 1459.495n 1.7v 1459.505n 1.7v 1469.495n 1.7v 1469.505n 1.7v 1479.495n 1.7v 1479.505n 0.0v 1489.495n 0.0v 1489.505n 1.7v 1499.495n 1.7v 1499.505n 0.0v 1509.495n 0.0v 1509.505n 0.0v 1519.495n 0.0v 1519.505n 1.7v 1529.495n 1.7v 1529.505n 1.7v 1539.495n 1.7v 1539.505n 0.0v 1549.495n 0.0v 1549.505n 0.0v 1559.495n 0.0v 1559.505n 0.0v 1569.495n 0.0v 1569.505n 1.7v 1579.495n 1.7v 1579.505n 0.0v 1589.495n 0.0v 1589.505n 1.7v 1599.495n 1.7v 1599.505n 1.7v 1609.495n 1.7v 1609.505n 1.7v 1619.495n 1.7v 1619.505n 0.0v 1629.495n 0.0v 1629.505n 0.0v 1639.495n 0.0v 1639.505n 1.7v 1649.495n 1.7v 1649.505n 0.0v 1659.495n 0.0v 1659.505n 0.0v 1669.495n 0.0v 1669.505n 1.7v 1679.495n 1.7v 1679.505n 1.7v 1689.495n 1.7v 1689.505n 1.7v 1699.495n 1.7v 1699.505n 1.7v 1709.495n 1.7v 1709.505n 0.0v 1719.495n 0.0v 1719.505n 1.7v 1729.495n 1.7v 1729.505n 0.0v 1739.495n 0.0v 1739.505n 1.7v 1749.495n 1.7v 1749.505n 0.0v 1759.495n 0.0v 1759.505n 1.7v 1769.495n 1.7v 1769.505n 0.0v 1779.495n 0.0v 1779.505n 0.0v 1789.495n 0.0v 1789.505n 1.7v 1799.495n 1.7v 1799.505n 0.0v 1809.495n 0.0v 1809.505n 1.7v 1819.495n 1.7v 1819.505n 1.7v 1829.495n 1.7v 1829.505n 1.7v 1839.495n 1.7v 1839.505n 0.0v 1849.495n 0.0v 1849.505n 1.7v 1859.495n 1.7v 1859.505n 0.0v 1869.495n 0.0v 1869.505n 1.7v 1879.495n 1.7v 1879.505n 1.7v 1889.495n 1.7v 1889.505n 1.7v 1899.495n 1.7v 1899.505n 1.7v 1909.495n 1.7v 1909.505n 0.0v 1919.495n 0.0v 1919.505n 0.0v 1929.495n 0.0v 1929.505n 0.0v 1939.495n 0.0v 1939.505n 0.0v 1949.495n 0.0v 1949.505n 0.0v 1959.495n 0.0v 1959.505n 1.7v 1969.495n 1.7v 1969.505n 0.0v 1979.495n 0.0v 1979.505n 0.0v 1989.495n 0.0v 1989.505n 1.7v 1999.495n 1.7v 1999.505n 0.0v 2009.495n 0.0v 2009.505n 0.0v 2019.495n 0.0v 2019.505n 0.0v 2029.495n 0.0v 2029.505n 1.7v 2039.495n 1.7v 2039.505n 1.7v 2049.495n 1.7v 2049.505n 1.7v )
* (time, data): [(0, 1), (10, 1), (20, 1), (30, 1), (40, 0), (50, 0), (60, 1), (70, 1), (80, 1), (90, 1), (100, 0), (110, 1), (120, 1), (130, 0), (140, 0), (150, 0), (160, 1), (170, 1), (180, 0), (190, 0), (200, 0), (210, 1), (220, 0), (230, 1), (240, 0), (250, 0), (260, 1), (270, 0), (280, 1), (290, 1), (300, 0), (310, 1), (320, 1), (330, 0), (340, 0), (350, 1), (360, 1), (370, 0), (380, 1), (390, 0), (400, 1), (410, 0), (420, 1), (430, 0), (440, 1), (450, 1), (460, 1), (470, 0), (480, 0), (490, 0), (500, 1), (510, 0), (520, 1), (530, 1), (540, 1), (550, 1), (560, 1), (570, 0), (580, 1), (590, 1), (600, 0), (610, 1), (620, 0), (630, 0), (640, 1), (650, 1), (660, 0), (670, 0), (680, 0), (690, 0), (700, 1), (710, 1), (720, 1), (730, 1), (740, 0), (750, 0), (760, 0), (770, 0), (780, 1), (790, 1), (800, 0), (810, 0), (820, 0), (830, 1), (840, 1), (850, 1), (860, 0), (870, 0), (880, 1), (890, 1), (900, 1), (910, 0), (920, 1), (930, 1), (940, 0), (950, 0), (960, 1), (970, 1), (980, 0), (990, 0), (1000, 1), (1010, 1), (1020, 1), (1030, 0), (1040, 1), (1050, 1), (1060, 0), (1070, 0), (1080, 1), (1090, 1), (1100, 1), (1110, 1), (1120, 0), (1130, 1), (1140, 0), (1150, 0), (1160, 0), (1170, 1), (1180, 1), (1190, 0), (1200, 1), (1210, 1), (1220, 0), (1230, 0), (1240, 1), (1250, 1), (1260, 0), (1270, 0), (1280, 0), (1290, 1), (1300, 0), (1310, 0), (1320, 0), (1330, 1), (1340, 1), (1350, 0), (1360, 0), (1370, 0), (1380, 1), (1390, 0), (1400, 1), (1410, 1), (1420, 0), (1430, 1), (1440, 1), (1450, 0), (1460, 0), (1470, 1), (1480, 1), (1490, 0), (1500, 1), (1510, 1), (1520, 0), (1530, 1), (1540, 1), (1550, 0), (1560, 1), (1570, 0), (1580, 1), (1590, 0), (1600, 0), (1610, 0), (1620, 1), (1630, 0), (1640, 0), (1650, 0), (1660, 0), (1670, 0), (1680, 0), (1690, 1), (1700, 0), (1710, 1), (1720, 1), (1730, 1), (1740, 1), (1750, 1), (1760, 0), (1770, 0), (1780, 0), (1790, 1), (1800, 1), (1810, 1), (1820, 1), (1830, 0), (1840, 1), (1850, 1), (1860, 1), (1870, 1), (1880, 0), (1890, 1), (1900, 1), (1910, 1), (1920, 1), (1930, 1), (1940, 0), (1950, 1), (1960, 0), (1970, 1), (1980, 1), (1990, 0), (2000, 1), (2010, 1), (2020, 1), (2030, 1), (2040, 1), (2050, 1)]
VCSB1 CSB1 0 PWL (0n 1.7v 9.495n 1.7v 9.505n 1.7v 19.495n 1.7v 19.505n 1.7v 29.495n 1.7v 29.505n 1.7v 39.495n 1.7v 39.505n 0.0v 49.495n 0.0v 49.505n 0.0v 59.495n 0.0v 59.505n 1.7v 69.495n 1.7v 69.505n 1.7v 79.495n 1.7v 79.505n 1.7v 89.495n 1.7v 89.505n 1.7v 99.495n 1.7v 99.505n 0.0v 109.495n 0.0v 109.505n 1.7v 119.495n 1.7v 119.505n 1.7v 129.495n 1.7v 129.505n 0.0v 139.495n 0.0v 139.505n 0.0v 149.495n 0.0v 149.505n 0.0v 159.495n 0.0v 159.505n 1.7v 169.495n 1.7v 169.505n 1.7v 179.495n 1.7v 179.505n 0.0v 189.495n 0.0v 189.505n 0.0v 199.495n 0.0v 199.505n 0.0v 209.495n 0.0v 209.505n 1.7v 219.495n 1.7v 219.505n 0.0v 229.495n 0.0v 229.505n 1.7v 239.495n 1.7v 239.505n 0.0v 249.495n 0.0v 249.505n 0.0v 259.495n 0.0v 259.505n 1.7v 269.495n 1.7v 269.505n 0.0v 279.495n 0.0v 279.505n 1.7v 289.495n 1.7v 289.505n 1.7v 299.495n 1.7v 299.505n 0.0v 309.495n 0.0v 309.505n 1.7v 319.495n 1.7v 319.505n 1.7v 329.495n 1.7v 329.505n 0.0v 339.495n 0.0v 339.505n 0.0v 349.495n 0.0v 349.505n 1.7v 359.495n 1.7v 359.505n 1.7v 369.495n 1.7v 369.505n 0.0v 379.495n 0.0v 379.505n 1.7v 389.495n 1.7v 389.505n 0.0v 399.495n 0.0v 399.505n 1.7v 409.495n 1.7v 409.505n 0.0v 419.495n 0.0v 419.505n 1.7v 429.495n 1.7v 429.505n 0.0v 439.495n 0.0v 439.505n 1.7v 449.495n 1.7v 449.505n 1.7v 459.495n 1.7v 459.505n 1.7v 469.495n 1.7v 469.505n 0.0v 479.495n 0.0v 479.505n 0.0v 489.495n 0.0v 489.505n 0.0v 499.495n 0.0v 499.505n 1.7v 509.495n 1.7v 509.505n 0.0v 519.495n 0.0v 519.505n 1.7v 529.495n 1.7v 529.505n 1.7v 539.495n 1.7v 539.505n 1.7v 549.495n 1.7v 549.505n 1.7v 559.495n 1.7v 559.505n 1.7v 569.495n 1.7v 569.505n 0.0v 579.495n 0.0v 579.505n 1.7v 589.495n 1.7v 589.505n 1.7v 599.495n 1.7v 599.505n 0.0v 609.495n 0.0v 609.505n 1.7v 619.495n 1.7v 619.505n 0.0v 629.495n 0.0v 629.505n 0.0v 639.495n 0.0v 639.505n 1.7v 649.495n 1.7v 649.505n 1.7v 659.495n 1.7v 659.505n 0.0v 669.495n 0.0v 669.505n 0.0v 679.495n 0.0v 679.505n 0.0v 689.495n 0.0v 689.505n 0.0v 699.495n 0.0v 699.505n 1.7v 709.495n 1.7v 709.505n 1.7v 719.495n 1.7v 719.505n 1.7v 729.495n 1.7v 729.505n 1.7v 739.495n 1.7v 739.505n 0.0v 749.495n 0.0v 749.505n 0.0v 759.495n 0.0v 759.505n 0.0v 769.495n 0.0v 769.505n 0.0v 779.495n 0.0v 779.505n 1.7v 789.495n 1.7v 789.505n 1.7v 799.495n 1.7v 799.505n 0.0v 809.495n 0.0v 809.505n 0.0v 819.495n 0.0v 819.505n 0.0v 829.495n 0.0v 829.505n 1.7v 839.495n 1.7v 839.505n 1.7v 849.495n 1.7v 849.505n 1.7v 859.495n 1.7v 859.505n 0.0v 869.495n 0.0v 869.505n 0.0v 879.495n 0.0v 879.505n 1.7v 889.495n 1.7v 889.505n 1.7v 899.495n 1.7v 899.505n 1.7v 909.495n 1.7v 909.505n 0.0v 919.495n 0.0v 919.505n 1.7v 929.495n 1.7v 929.505n 1.7v 939.495n 1.7v 939.505n 0.0v 949.495n 0.0v 949.505n 0.0v 959.495n 0.0v 959.505n 1.7v 969.495n 1.7v 969.505n 1.7v 979.495n 1.7v 979.505n 0.0v 989.495n 0.0v 989.505n 0.0v 999.495n 0.0v 999.505n 1.7v 1009.495n 1.7v 1009.505n 1.7v 1019.495n 1.7v 1019.505n 1.7v 1029.495n 1.7v 1029.505n 0.0v 1039.495n 0.0v 1039.505n 1.7v 1049.495n 1.7v 1049.505n 1.7v 1059.495n 1.7v 1059.505n 0.0v 1069.495n 0.0v 1069.505n 0.0v 1079.495n 0.0v 1079.505n 1.7v 1089.495n 1.7v 1089.505n 1.7v 1099.495n 1.7v 1099.505n 1.7v 1109.495n 1.7v 1109.505n 1.7v 1119.495n 1.7v 1119.505n 0.0v 1129.495n 0.0v 1129.505n 1.7v 1139.495n 1.7v 1139.505n 0.0v 1149.495n 0.0v 1149.505n 0.0v 1159.495n 0.0v 1159.505n 0.0v 1169.495n 0.0v 1169.505n 1.7v 1179.495n 1.7v 1179.505n 1.7v 1189.495n 1.7v 1189.505n 0.0v 1199.495n 0.0v 1199.505n 1.7v 1209.495n 1.7v 1209.505n 1.7v 1219.495n 1.7v 1219.505n 0.0v 1229.495n 0.0v 1229.505n 0.0v 1239.495n 0.0v 1239.505n 1.7v 1249.495n 1.7v 1249.505n 1.7v 1259.495n 1.7v 1259.505n 0.0v 1269.495n 0.0v 1269.505n 0.0v 1279.495n 0.0v 1279.505n 0.0v 1289.495n 0.0v 1289.505n 1.7v 1299.495n 1.7v 1299.505n 0.0v 1309.495n 0.0v 1309.505n 0.0v 1319.495n 0.0v 1319.505n 0.0v 1329.495n 0.0v 1329.505n 1.7v 1339.495n 1.7v 1339.505n 1.7v 1349.495n 1.7v 1349.505n 0.0v 1359.495n 0.0v 1359.505n 0.0v 1369.495n 0.0v 1369.505n 0.0v 1379.495n 0.0v 1379.505n 1.7v 1389.495n 1.7v 1389.505n 0.0v 1399.495n 0.0v 1399.505n 1.7v 1409.495n 1.7v 1409.505n 1.7v 1419.495n 1.7v 1419.505n 0.0v 1429.495n 0.0v 1429.505n 1.7v 1439.495n 1.7v 1439.505n 1.7v 1449.495n 1.7v 1449.505n 0.0v 1459.495n 0.0v 1459.505n 0.0v 1469.495n 0.0v 1469.505n 1.7v 1479.495n 1.7v 1479.505n 1.7v 1489.495n 1.7v 1489.505n 0.0v 1499.495n 0.0v 1499.505n 1.7v 1509.495n 1.7v 1509.505n 1.7v 1519.495n 1.7v 1519.505n 0.0v 1529.495n 0.0v 1529.505n 1.7v 1539.495n 1.7v 1539.505n 1.7v 1549.495n 1.7v 1549.505n 0.0v 1559.495n 0.0v 1559.505n 1.7v 1569.495n 1.7v 1569.505n 0.0v 1579.495n 0.0v 1579.505n 1.7v 1589.495n 1.7v 1589.505n 0.0v 1599.495n 0.0v 1599.505n 0.0v 1609.495n 0.0v 1609.505n 0.0v 1619.495n 0.0v 1619.505n 1.7v 1629.495n 1.7v 1629.505n 0.0v 1639.495n 0.0v 1639.505n 0.0v 1649.495n 0.0v 1649.505n 0.0v 1659.495n 0.0v 1659.505n 0.0v 1669.495n 0.0v 1669.505n 0.0v 1679.495n 0.0v 1679.505n 0.0v 1689.495n 0.0v 1689.505n 1.7v 1699.495n 1.7v 1699.505n 0.0v 1709.495n 0.0v 1709.505n 1.7v 1719.495n 1.7v 1719.505n 1.7v 1729.495n 1.7v 1729.505n 1.7v 1739.495n 1.7v 1739.505n 1.7v 1749.495n 1.7v 1749.505n 1.7v 1759.495n 1.7v 1759.505n 0.0v 1769.495n 0.0v 1769.505n 0.0v 1779.495n 0.0v 1779.505n 0.0v 1789.495n 0.0v 1789.505n 1.7v 1799.495n 1.7v 1799.505n 1.7v 1809.495n 1.7v 1809.505n 1.7v 1819.495n 1.7v 1819.505n 1.7v 1829.495n 1.7v 1829.505n 0.0v 1839.495n 0.0v 1839.505n 1.7v 1849.495n 1.7v 1849.505n 1.7v 1859.495n 1.7v 1859.505n 1.7v 1869.495n 1.7v 1869.505n 1.7v 1879.495n 1.7v 1879.505n 0.0v 1889.495n 0.0v 1889.505n 1.7v 1899.495n 1.7v 1899.505n 1.7v 1909.495n 1.7v 1909.505n 1.7v 1919.495n 1.7v 1919.505n 1.7v 1929.495n 1.7v 1929.505n 1.7v 1939.495n 1.7v 1939.505n 0.0v 1949.495n 0.0v 1949.505n 1.7v 1959.495n 1.7v 1959.505n 0.0v 1969.495n 0.0v 1969.505n 1.7v 1979.495n 1.7v 1979.505n 1.7v 1989.495n 1.7v 1989.505n 0.0v 1999.495n 0.0v 1999.505n 1.7v 2009.495n 1.7v 2009.505n 1.7v 2019.495n 1.7v 2019.505n 1.7v 2029.495n 1.7v 2029.505n 1.7v 2039.495n 1.7v 2039.505n 1.7v 2049.495n 1.7v 2049.505n 1.7v )

* Generation of spare enable signals
* (time, data): [(0, 0), (10, 0), (20, 0), (30, 0), (40, 0), (50, 0), (60, 0), (70, 0), (80, 0), (90, 0), (100, 0), (110, 0), (120, 0), (130, 0), (140, 0), (150, 0), (160, 0), (170, 0), (180, 0), (190, 0), (200, 0), (210, 0), (220, 0), (230, 0), (240, 0), (250, 0), (260, 0), (270, 0), (280, 0), (290, 0), (300, 0), (310, 0), (320, 0), (330, 0), (340, 0), (350, 0), (360, 0), (370, 0), (380, 0), (390, 0), (400, 0), (410, 0), (420, 0), (430, 0), (440, 0), (450, 0), (460, 0), (470, 0), (480, 0), (490, 0), (500, 0), (510, 0), (520, 0), (530, 0), (540, 0), (550, 0), (560, 0), (570, 0), (580, 0), (590, 0), (600, 0), (610, 0), (620, 0), (630, 0), (640, 0), (650, 0), (660, 0), (670, 0), (680, 0), (690, 0), (700, 0), (710, 0), (720, 0), (730, 0), (740, 0), (750, 0), (760, 0), (770, 0), (780, 0), (790, 0), (800, 0), (810, 0), (820, 0), (830, 0), (840, 0), (850, 0), (860, 0), (870, 0), (880, 0), (890, 0), (900, 0), (910, 0), (920, 0), (930, 0), (940, 0), (950, 0), (960, 0), (970, 0), (980, 0), (990, 0), (1000, 0), (1010, 0), (1020, 0), (1030, 0), (1040, 0), (1050, 0), (1060, 0), (1070, 0), (1080, 0), (1090, 0), (1100, 0), (1110, 0), (1120, 0), (1130, 0), (1140, 0), (1150, 0), (1160, 0), (1170, 0), (1180, 0), (1190, 0), (1200, 0), (1210, 0), (1220, 0), (1230, 0), (1240, 0), (1250, 0), (1260, 0), (1270, 0), (1280, 0), (1290, 0), (1300, 0), (1310, 0), (1320, 0), (1330, 0), (1340, 0), (1350, 0), (1360, 0), (1370, 0), (1380, 0), (1390, 0), (1400, 0), (1410, 0), (1420, 0), (1430, 0), (1440, 0), (1450, 0), (1460, 0), (1470, 0), (1480, 0), (1490, 0), (1500, 0), (1510, 0), (1520, 0), (1530, 0), (1540, 0), (1550, 0), (1560, 0), (1570, 0), (1580, 0), (1590, 0), (1600, 0), (1610, 0), (1620, 0), (1630, 0), (1640, 0), (1650, 0), (1660, 0), (1670, 0), (1680, 0), (1690, 0), (1700, 0), (1710, 0), (1720, 0), (1730, 0), (1740, 0), (1750, 0), (1760, 0), (1770, 0), (1780, 0), (1790, 0), (1800, 0), (1810, 0), (1820, 0), (1830, 0), (1840, 0), (1850, 0), (1860, 0), (1870, 0), (1880, 0), (1890, 0), (1900, 0), (1910, 0), (1920, 0), (1930, 0), (1940, 0), (1950, 0), (1960, 0), (1970, 0), (1980, 0), (1990, 0), (2000, 0), (2010, 0), (2020, 0), (2030, 0), (2040, 0), (2050, 0)]
VSPARE_WEN0_0  SPARE_WEN0_0  0 PWL (0n 0.0v 9.495n 0.0v 9.505n 0.0v 19.495n 0.0v 19.505n 0.0v 29.495n 0.0v 29.505n 0.0v 39.495n 0.0v 39.505n 0.0v 49.495n 0.0v 49.505n 0.0v 59.495n 0.0v 59.505n 0.0v 69.495n 0.0v 69.505n 0.0v 79.495n 0.0v 79.505n 0.0v 89.495n 0.0v 89.505n 0.0v 99.495n 0.0v 99.505n 0.0v 109.495n 0.0v 109.505n 0.0v 119.495n 0.0v 119.505n 0.0v 129.495n 0.0v 129.505n 0.0v 139.495n 0.0v 139.505n 0.0v 149.495n 0.0v 149.505n 0.0v 159.495n 0.0v 159.505n 0.0v 169.495n 0.0v 169.505n 0.0v 179.495n 0.0v 179.505n 0.0v 189.495n 0.0v 189.505n 0.0v 199.495n 0.0v 199.505n 0.0v 209.495n 0.0v 209.505n 0.0v 219.495n 0.0v 219.505n 0.0v 229.495n 0.0v 229.505n 0.0v 239.495n 0.0v 239.505n 0.0v 249.495n 0.0v 249.505n 0.0v 259.495n 0.0v 259.505n 0.0v 269.495n 0.0v 269.505n 0.0v 279.495n 0.0v 279.505n 0.0v 289.495n 0.0v 289.505n 0.0v 299.495n 0.0v 299.505n 0.0v 309.495n 0.0v 309.505n 0.0v 319.495n 0.0v 319.505n 0.0v 329.495n 0.0v 329.505n 0.0v 339.495n 0.0v 339.505n 0.0v 349.495n 0.0v 349.505n 0.0v 359.495n 0.0v 359.505n 0.0v 369.495n 0.0v 369.505n 0.0v 379.495n 0.0v 379.505n 0.0v 389.495n 0.0v 389.505n 0.0v 399.495n 0.0v 399.505n 0.0v 409.495n 0.0v 409.505n 0.0v 419.495n 0.0v 419.505n 0.0v 429.495n 0.0v 429.505n 0.0v 439.495n 0.0v 439.505n 0.0v 449.495n 0.0v 449.505n 0.0v 459.495n 0.0v 459.505n 0.0v 469.495n 0.0v 469.505n 0.0v 479.495n 0.0v 479.505n 0.0v 489.495n 0.0v 489.505n 0.0v 499.495n 0.0v 499.505n 0.0v 509.495n 0.0v 509.505n 0.0v 519.495n 0.0v 519.505n 0.0v 529.495n 0.0v 529.505n 0.0v 539.495n 0.0v 539.505n 0.0v 549.495n 0.0v 549.505n 0.0v 559.495n 0.0v 559.505n 0.0v 569.495n 0.0v 569.505n 0.0v 579.495n 0.0v 579.505n 0.0v 589.495n 0.0v 589.505n 0.0v 599.495n 0.0v 599.505n 0.0v 609.495n 0.0v 609.505n 0.0v 619.495n 0.0v 619.505n 0.0v 629.495n 0.0v 629.505n 0.0v 639.495n 0.0v 639.505n 0.0v 649.495n 0.0v 649.505n 0.0v 659.495n 0.0v 659.505n 0.0v 669.495n 0.0v 669.505n 0.0v 679.495n 0.0v 679.505n 0.0v 689.495n 0.0v 689.505n 0.0v 699.495n 0.0v 699.505n 0.0v 709.495n 0.0v 709.505n 0.0v 719.495n 0.0v 719.505n 0.0v 729.495n 0.0v 729.505n 0.0v 739.495n 0.0v 739.505n 0.0v 749.495n 0.0v 749.505n 0.0v 759.495n 0.0v 759.505n 0.0v 769.495n 0.0v 769.505n 0.0v 779.495n 0.0v 779.505n 0.0v 789.495n 0.0v 789.505n 0.0v 799.495n 0.0v 799.505n 0.0v 809.495n 0.0v 809.505n 0.0v 819.495n 0.0v 819.505n 0.0v 829.495n 0.0v 829.505n 0.0v 839.495n 0.0v 839.505n 0.0v 849.495n 0.0v 849.505n 0.0v 859.495n 0.0v 859.505n 0.0v 869.495n 0.0v 869.505n 0.0v 879.495n 0.0v 879.505n 0.0v 889.495n 0.0v 889.505n 0.0v 899.495n 0.0v 899.505n 0.0v 909.495n 0.0v 909.505n 0.0v 919.495n 0.0v 919.505n 0.0v 929.495n 0.0v 929.505n 0.0v 939.495n 0.0v 939.505n 0.0v 949.495n 0.0v 949.505n 0.0v 959.495n 0.0v 959.505n 0.0v 969.495n 0.0v 969.505n 0.0v 979.495n 0.0v 979.505n 0.0v 989.495n 0.0v 989.505n 0.0v 999.495n 0.0v 999.505n 0.0v 1009.495n 0.0v 1009.505n 0.0v 1019.495n 0.0v 1019.505n 0.0v 1029.495n 0.0v 1029.505n 0.0v 1039.495n 0.0v 1039.505n 0.0v 1049.495n 0.0v 1049.505n 0.0v 1059.495n 0.0v 1059.505n 0.0v 1069.495n 0.0v 1069.505n 0.0v 1079.495n 0.0v 1079.505n 0.0v 1089.495n 0.0v 1089.505n 0.0v 1099.495n 0.0v 1099.505n 0.0v 1109.495n 0.0v 1109.505n 0.0v 1119.495n 0.0v 1119.505n 0.0v 1129.495n 0.0v 1129.505n 0.0v 1139.495n 0.0v 1139.505n 0.0v 1149.495n 0.0v 1149.505n 0.0v 1159.495n 0.0v 1159.505n 0.0v 1169.495n 0.0v 1169.505n 0.0v 1179.495n 0.0v 1179.505n 0.0v 1189.495n 0.0v 1189.505n 0.0v 1199.495n 0.0v 1199.505n 0.0v 1209.495n 0.0v 1209.505n 0.0v 1219.495n 0.0v 1219.505n 0.0v 1229.495n 0.0v 1229.505n 0.0v 1239.495n 0.0v 1239.505n 0.0v 1249.495n 0.0v 1249.505n 0.0v 1259.495n 0.0v 1259.505n 0.0v 1269.495n 0.0v 1269.505n 0.0v 1279.495n 0.0v 1279.505n 0.0v 1289.495n 0.0v 1289.505n 0.0v 1299.495n 0.0v 1299.505n 0.0v 1309.495n 0.0v 1309.505n 0.0v 1319.495n 0.0v 1319.505n 0.0v 1329.495n 0.0v 1329.505n 0.0v 1339.495n 0.0v 1339.505n 0.0v 1349.495n 0.0v 1349.505n 0.0v 1359.495n 0.0v 1359.505n 0.0v 1369.495n 0.0v 1369.505n 0.0v 1379.495n 0.0v 1379.505n 0.0v 1389.495n 0.0v 1389.505n 0.0v 1399.495n 0.0v 1399.505n 0.0v 1409.495n 0.0v 1409.505n 0.0v 1419.495n 0.0v 1419.505n 0.0v 1429.495n 0.0v 1429.505n 0.0v 1439.495n 0.0v 1439.505n 0.0v 1449.495n 0.0v 1449.505n 0.0v 1459.495n 0.0v 1459.505n 0.0v 1469.495n 0.0v 1469.505n 0.0v 1479.495n 0.0v 1479.505n 0.0v 1489.495n 0.0v 1489.505n 0.0v 1499.495n 0.0v 1499.505n 0.0v 1509.495n 0.0v 1509.505n 0.0v 1519.495n 0.0v 1519.505n 0.0v 1529.495n 0.0v 1529.505n 0.0v 1539.495n 0.0v 1539.505n 0.0v 1549.495n 0.0v 1549.505n 0.0v 1559.495n 0.0v 1559.505n 0.0v 1569.495n 0.0v 1569.505n 0.0v 1579.495n 0.0v 1579.505n 0.0v 1589.495n 0.0v 1589.505n 0.0v 1599.495n 0.0v 1599.505n 0.0v 1609.495n 0.0v 1609.505n 0.0v 1619.495n 0.0v 1619.505n 0.0v 1629.495n 0.0v 1629.505n 0.0v 1639.495n 0.0v 1639.505n 0.0v 1649.495n 0.0v 1649.505n 0.0v 1659.495n 0.0v 1659.505n 0.0v 1669.495n 0.0v 1669.505n 0.0v 1679.495n 0.0v 1679.505n 0.0v 1689.495n 0.0v 1689.505n 0.0v 1699.495n 0.0v 1699.505n 0.0v 1709.495n 0.0v 1709.505n 0.0v 1719.495n 0.0v 1719.505n 0.0v 1729.495n 0.0v 1729.505n 0.0v 1739.495n 0.0v 1739.505n 0.0v 1749.495n 0.0v 1749.505n 0.0v 1759.495n 0.0v 1759.505n 0.0v 1769.495n 0.0v 1769.505n 0.0v 1779.495n 0.0v 1779.505n 0.0v 1789.495n 0.0v 1789.505n 0.0v 1799.495n 0.0v 1799.505n 0.0v 1809.495n 0.0v 1809.505n 0.0v 1819.495n 0.0v 1819.505n 0.0v 1829.495n 0.0v 1829.505n 0.0v 1839.495n 0.0v 1839.505n 0.0v 1849.495n 0.0v 1849.505n 0.0v 1859.495n 0.0v 1859.505n 0.0v 1869.495n 0.0v 1869.505n 0.0v 1879.495n 0.0v 1879.505n 0.0v 1889.495n 0.0v 1889.505n 0.0v 1899.495n 0.0v 1899.505n 0.0v 1909.495n 0.0v 1909.505n 0.0v 1919.495n 0.0v 1919.505n 0.0v 1929.495n 0.0v 1929.505n 0.0v 1939.495n 0.0v 1939.505n 0.0v 1949.495n 0.0v 1949.505n 0.0v 1959.495n 0.0v 1959.505n 0.0v 1969.495n 0.0v 1969.505n 0.0v 1979.495n 0.0v 1979.505n 0.0v 1989.495n 0.0v 1989.505n 0.0v 1999.495n 0.0v 1999.505n 0.0v 2009.495n 0.0v 2009.505n 0.0v 2019.495n 0.0v 2019.505n 0.0v 2029.495n 0.0v 2029.505n 0.0v 2039.495n 0.0v 2039.505n 0.0v 2049.495n 0.0v 2049.505n 0.0v )
* PULSE: period=10
Vclk0 clk0 0 PULSE (0 1.7 9.995n 0.01n 0.01n 4.99n 10n)
* PULSE: period=10
Vclk1 clk1 0 PULSE (0 1.7 9.995n 0.01n 0.01n 4.99n 10n)

 * Generation of dout measurements
* CHECK dout1_0 vdout1_0ck4 = 0 time = 50
* CHECK dout1_1 vdout1_1ck4 = 0 time = 50
* CHECK dout1_2 vdout1_2ck4 = 1.7 time = 50
* CHECK dout1_3 vdout1_3ck4 = 0 time = 50
* CHECK dout1_4 vdout1_4ck4 = 0 time = 50
* CHECK dout1_5 vdout1_5ck4 = 0 time = 50
* CHECK dout1_6 vdout1_6ck4 = 1.7 time = 50
* CHECK dout1_7 vdout1_7ck4 = 0 time = 50
* CHECK dout1_8 vdout1_8ck4 = 1.7 time = 50
* CHECK dout1_9 vdout1_9ck4 = 0 time = 50
* CHECK dout1_10 vdout1_10ck4 = 1.7 time = 50
* CHECK dout1_11 vdout1_11ck4 = 0 time = 50
* CHECK dout1_12 vdout1_12ck4 = 0 time = 50
* CHECK dout1_13 vdout1_13ck4 = 1.7 time = 50
* CHECK dout1_14 vdout1_14ck4 = 1.7 time = 50
* CHECK dout1_15 vdout1_15ck4 = 0 time = 50
* CHECK dout1_16 vdout1_16ck4 = 1.7 time = 50
* CHECK dout1_17 vdout1_17ck4 = 0 time = 50
* CHECK dout1_18 vdout1_18ck4 = 1.7 time = 50
* CHECK dout1_19 vdout1_19ck4 = 0 time = 50
* CHECK dout1_20 vdout1_20ck4 = 0 time = 50
* CHECK dout1_21 vdout1_21ck4 = 1.7 time = 50
* CHECK dout1_22 vdout1_22ck4 = 0 time = 50
* CHECK dout1_23 vdout1_23ck4 = 1.7 time = 50
* CHECK dout1_24 vdout1_24ck4 = 1.7 time = 50
* CHECK dout1_25 vdout1_25ck4 = 0 time = 50
* CHECK dout1_26 vdout1_26ck4 = 0 time = 50
* CHECK dout1_27 vdout1_27ck4 = 0 time = 50
* CHECK dout1_28 vdout1_28ck4 = 0 time = 50
* CHECK dout1_29 vdout1_29ck4 = 1.7 time = 50
* CHECK dout1_30 vdout1_30ck4 = 1.7 time = 50
* CHECK dout1_31 vdout1_31ck4 = 1.7 time = 50
* CHECK dout1_32 vdout1_32ck4 = 0 time = 50
* CHECK dout1_0 vdout1_0ck5 = 1.7 time = 60
* CHECK dout1_1 vdout1_1ck5 = 0 time = 60
* CHECK dout1_2 vdout1_2ck5 = 0 time = 60
* CHECK dout1_3 vdout1_3ck5 = 1.7 time = 60
* CHECK dout1_4 vdout1_4ck5 = 0 time = 60
* CHECK dout1_5 vdout1_5ck5 = 1.7 time = 60
* CHECK dout1_6 vdout1_6ck5 = 1.7 time = 60
* CHECK dout1_7 vdout1_7ck5 = 1.7 time = 60
* CHECK dout1_8 vdout1_8ck5 = 0 time = 60
* CHECK dout1_9 vdout1_9ck5 = 1.7 time = 60
* CHECK dout1_10 vdout1_10ck5 = 1.7 time = 60
* CHECK dout1_11 vdout1_11ck5 = 0 time = 60
* CHECK dout1_12 vdout1_12ck5 = 0 time = 60
* CHECK dout1_13 vdout1_13ck5 = 0 time = 60
* CHECK dout1_14 vdout1_14ck5 = 0 time = 60
* CHECK dout1_15 vdout1_15ck5 = 1.7 time = 60
* CHECK dout1_16 vdout1_16ck5 = 1.7 time = 60
* CHECK dout1_17 vdout1_17ck5 = 1.7 time = 60
* CHECK dout1_18 vdout1_18ck5 = 0 time = 60
* CHECK dout1_19 vdout1_19ck5 = 1.7 time = 60
* CHECK dout1_20 vdout1_20ck5 = 1.7 time = 60
* CHECK dout1_21 vdout1_21ck5 = 0 time = 60
* CHECK dout1_22 vdout1_22ck5 = 0 time = 60
* CHECK dout1_23 vdout1_23ck5 = 0 time = 60
* CHECK dout1_24 vdout1_24ck5 = 0 time = 60
* CHECK dout1_25 vdout1_25ck5 = 0 time = 60
* CHECK dout1_26 vdout1_26ck5 = 0 time = 60
* CHECK dout1_27 vdout1_27ck5 = 0 time = 60
* CHECK dout1_28 vdout1_28ck5 = 0 time = 60
* CHECK dout1_29 vdout1_29ck5 = 0 time = 60
* CHECK dout1_30 vdout1_30ck5 = 0 time = 60
* CHECK dout1_31 vdout1_31ck5 = 0 time = 60
* CHECK dout1_32 vdout1_32ck5 = 0 time = 60
* CHECK dout1_0 vdout1_0ck10 = 1.7 time = 110
* CHECK dout1_1 vdout1_1ck10 = 0 time = 110
* CHECK dout1_2 vdout1_2ck10 = 1.7 time = 110
* CHECK dout1_3 vdout1_3ck10 = 1.7 time = 110
* CHECK dout1_4 vdout1_4ck10 = 1.7 time = 110
* CHECK dout1_5 vdout1_5ck10 = 0 time = 110
* CHECK dout1_6 vdout1_6ck10 = 0 time = 110
* CHECK dout1_7 vdout1_7ck10 = 0 time = 110
* CHECK dout1_8 vdout1_8ck10 = 0 time = 110
* CHECK dout1_9 vdout1_9ck10 = 1.7 time = 110
* CHECK dout1_10 vdout1_10ck10 = 1.7 time = 110
* CHECK dout1_11 vdout1_11ck10 = 1.7 time = 110
* CHECK dout1_12 vdout1_12ck10 = 1.7 time = 110
* CHECK dout1_13 vdout1_13ck10 = 0 time = 110
* CHECK dout1_14 vdout1_14ck10 = 1.7 time = 110
* CHECK dout1_15 vdout1_15ck10 = 1.7 time = 110
* CHECK dout1_16 vdout1_16ck10 = 1.7 time = 110
* CHECK dout1_17 vdout1_17ck10 = 0 time = 110
* CHECK dout1_18 vdout1_18ck10 = 0 time = 110
* CHECK dout1_19 vdout1_19ck10 = 0 time = 110
* CHECK dout1_20 vdout1_20ck10 = 0 time = 110
* CHECK dout1_21 vdout1_21ck10 = 0 time = 110
* CHECK dout1_22 vdout1_22ck10 = 0 time = 110
* CHECK dout1_23 vdout1_23ck10 = 1.7 time = 110
* CHECK dout1_24 vdout1_24ck10 = 1.7 time = 110
* CHECK dout1_25 vdout1_25ck10 = 1.7 time = 110
* CHECK dout1_26 vdout1_26ck10 = 0 time = 110
* CHECK dout1_27 vdout1_27ck10 = 0 time = 110
* CHECK dout1_28 vdout1_28ck10 = 1.7 time = 110
* CHECK dout1_29 vdout1_29ck10 = 1.7 time = 110
* CHECK dout1_30 vdout1_30ck10 = 1.7 time = 110
* CHECK dout1_31 vdout1_31ck10 = 0 time = 110
* CHECK dout1_32 vdout1_32ck10 = 0 time = 110
* CHECK dout1_0 vdout1_0ck13 = 1.7 time = 140
* CHECK dout1_1 vdout1_1ck13 = 0 time = 140
* CHECK dout1_2 vdout1_2ck13 = 0 time = 140
* CHECK dout1_3 vdout1_3ck13 = 1.7 time = 140
* CHECK dout1_4 vdout1_4ck13 = 0 time = 140
* CHECK dout1_5 vdout1_5ck13 = 1.7 time = 140
* CHECK dout1_6 vdout1_6ck13 = 1.7 time = 140
* CHECK dout1_7 vdout1_7ck13 = 1.7 time = 140
* CHECK dout1_8 vdout1_8ck13 = 0 time = 140
* CHECK dout1_9 vdout1_9ck13 = 1.7 time = 140
* CHECK dout1_10 vdout1_10ck13 = 1.7 time = 140
* CHECK dout1_11 vdout1_11ck13 = 0 time = 140
* CHECK dout1_12 vdout1_12ck13 = 0 time = 140
* CHECK dout1_13 vdout1_13ck13 = 0 time = 140
* CHECK dout1_14 vdout1_14ck13 = 0 time = 140
* CHECK dout1_15 vdout1_15ck13 = 1.7 time = 140
* CHECK dout1_16 vdout1_16ck13 = 1.7 time = 140
* CHECK dout1_17 vdout1_17ck13 = 1.7 time = 140
* CHECK dout1_18 vdout1_18ck13 = 0 time = 140
* CHECK dout1_19 vdout1_19ck13 = 1.7 time = 140
* CHECK dout1_20 vdout1_20ck13 = 1.7 time = 140
* CHECK dout1_21 vdout1_21ck13 = 0 time = 140
* CHECK dout1_22 vdout1_22ck13 = 0 time = 140
* CHECK dout1_23 vdout1_23ck13 = 0 time = 140
* CHECK dout1_24 vdout1_24ck13 = 0 time = 140
* CHECK dout1_25 vdout1_25ck13 = 0 time = 140
* CHECK dout1_26 vdout1_26ck13 = 0 time = 140
* CHECK dout1_27 vdout1_27ck13 = 0 time = 140
* CHECK dout1_28 vdout1_28ck13 = 0 time = 140
* CHECK dout1_29 vdout1_29ck13 = 0 time = 140
* CHECK dout1_30 vdout1_30ck13 = 0 time = 140
* CHECK dout1_31 vdout1_31ck13 = 0 time = 140
* CHECK dout1_32 vdout1_32ck13 = 0 time = 140
* CHECK dout1_0 vdout1_0ck14 = 0 time = 150
* CHECK dout1_1 vdout1_1ck14 = 0 time = 150
* CHECK dout1_2 vdout1_2ck14 = 0 time = 150
* CHECK dout1_3 vdout1_3ck14 = 1.7 time = 150
* CHECK dout1_4 vdout1_4ck14 = 1.7 time = 150
* CHECK dout1_5 vdout1_5ck14 = 1.7 time = 150
* CHECK dout1_6 vdout1_6ck14 = 0 time = 150
* CHECK dout1_7 vdout1_7ck14 = 1.7 time = 150
* CHECK dout1_8 vdout1_8ck14 = 1.7 time = 150
* CHECK dout1_9 vdout1_9ck14 = 0 time = 150
* CHECK dout1_10 vdout1_10ck14 = 1.7 time = 150
* CHECK dout1_11 vdout1_11ck14 = 1.7 time = 150
* CHECK dout1_12 vdout1_12ck14 = 0 time = 150
* CHECK dout1_13 vdout1_13ck14 = 0 time = 150
* CHECK dout1_14 vdout1_14ck14 = 0 time = 150
* CHECK dout1_15 vdout1_15ck14 = 0 time = 150
* CHECK dout1_16 vdout1_16ck14 = 1.7 time = 150
* CHECK dout1_17 vdout1_17ck14 = 0 time = 150
* CHECK dout1_18 vdout1_18ck14 = 1.7 time = 150
* CHECK dout1_19 vdout1_19ck14 = 0 time = 150
* CHECK dout1_20 vdout1_20ck14 = 0 time = 150
* CHECK dout1_21 vdout1_21ck14 = 0 time = 150
* CHECK dout1_22 vdout1_22ck14 = 1.7 time = 150
* CHECK dout1_23 vdout1_23ck14 = 0 time = 150
* CHECK dout1_24 vdout1_24ck14 = 0 time = 150
* CHECK dout1_25 vdout1_25ck14 = 0 time = 150
* CHECK dout1_26 vdout1_26ck14 = 0 time = 150
* CHECK dout1_27 vdout1_27ck14 = 0 time = 150
* CHECK dout1_28 vdout1_28ck14 = 0 time = 150
* CHECK dout1_29 vdout1_29ck14 = 1.7 time = 150
* CHECK dout1_30 vdout1_30ck14 = 1.7 time = 150
* CHECK dout1_31 vdout1_31ck14 = 0 time = 150
* CHECK dout1_32 vdout1_32ck14 = 0 time = 150
* CHECK dout1_0 vdout1_0ck15 = 0 time = 160
* CHECK dout1_1 vdout1_1ck15 = 1.7 time = 160
* CHECK dout1_2 vdout1_2ck15 = 0 time = 160
* CHECK dout1_3 vdout1_3ck15 = 0 time = 160
* CHECK dout1_4 vdout1_4ck15 = 0 time = 160
* CHECK dout1_5 vdout1_5ck15 = 1.7 time = 160
* CHECK dout1_6 vdout1_6ck15 = 0 time = 160
* CHECK dout1_7 vdout1_7ck15 = 1.7 time = 160
* CHECK dout1_8 vdout1_8ck15 = 0 time = 160
* CHECK dout1_9 vdout1_9ck15 = 1.7 time = 160
* CHECK dout1_10 vdout1_10ck15 = 1.7 time = 160
* CHECK dout1_11 vdout1_11ck15 = 0 time = 160
* CHECK dout1_12 vdout1_12ck15 = 0 time = 160
* CHECK dout1_13 vdout1_13ck15 = 0 time = 160
* CHECK dout1_14 vdout1_14ck15 = 0 time = 160
* CHECK dout1_15 vdout1_15ck15 = 0 time = 160
* CHECK dout1_16 vdout1_16ck15 = 0 time = 160
* CHECK dout1_17 vdout1_17ck15 = 1.7 time = 160
* CHECK dout1_18 vdout1_18ck15 = 1.7 time = 160
* CHECK dout1_19 vdout1_19ck15 = 0 time = 160
* CHECK dout1_20 vdout1_20ck15 = 0 time = 160
* CHECK dout1_21 vdout1_21ck15 = 0 time = 160
* CHECK dout1_22 vdout1_22ck15 = 0 time = 160
* CHECK dout1_23 vdout1_23ck15 = 1.7 time = 160
* CHECK dout1_24 vdout1_24ck15 = 0 time = 160
* CHECK dout1_25 vdout1_25ck15 = 1.7 time = 160
* CHECK dout1_26 vdout1_26ck15 = 1.7 time = 160
* CHECK dout1_27 vdout1_27ck15 = 0 time = 160
* CHECK dout1_28 vdout1_28ck15 = 1.7 time = 160
* CHECK dout1_29 vdout1_29ck15 = 0 time = 160
* CHECK dout1_30 vdout1_30ck15 = 1.7 time = 160
* CHECK dout1_31 vdout1_31ck15 = 1.7 time = 160
* CHECK dout1_32 vdout1_32ck15 = 0 time = 160
* CHECK dout1_0 vdout1_0ck18 = 0 time = 190
* CHECK dout1_1 vdout1_1ck18 = 1.7 time = 190
* CHECK dout1_2 vdout1_2ck18 = 0 time = 190
* CHECK dout1_3 vdout1_3ck18 = 0 time = 190
* CHECK dout1_4 vdout1_4ck18 = 0 time = 190
* CHECK dout1_5 vdout1_5ck18 = 1.7 time = 190
* CHECK dout1_6 vdout1_6ck18 = 0 time = 190
* CHECK dout1_7 vdout1_7ck18 = 1.7 time = 190
* CHECK dout1_8 vdout1_8ck18 = 0 time = 190
* CHECK dout1_9 vdout1_9ck18 = 1.7 time = 190
* CHECK dout1_10 vdout1_10ck18 = 1.7 time = 190
* CHECK dout1_11 vdout1_11ck18 = 0 time = 190
* CHECK dout1_12 vdout1_12ck18 = 0 time = 190
* CHECK dout1_13 vdout1_13ck18 = 0 time = 190
* CHECK dout1_14 vdout1_14ck18 = 0 time = 190
* CHECK dout1_15 vdout1_15ck18 = 0 time = 190
* CHECK dout1_16 vdout1_16ck18 = 0 time = 190
* CHECK dout1_17 vdout1_17ck18 = 1.7 time = 190
* CHECK dout1_18 vdout1_18ck18 = 1.7 time = 190
* CHECK dout1_19 vdout1_19ck18 = 0 time = 190
* CHECK dout1_20 vdout1_20ck18 = 0 time = 190
* CHECK dout1_21 vdout1_21ck18 = 0 time = 190
* CHECK dout1_22 vdout1_22ck18 = 0 time = 190
* CHECK dout1_23 vdout1_23ck18 = 1.7 time = 190
* CHECK dout1_24 vdout1_24ck18 = 0 time = 190
* CHECK dout1_25 vdout1_25ck18 = 1.7 time = 190
* CHECK dout1_26 vdout1_26ck18 = 1.7 time = 190
* CHECK dout1_27 vdout1_27ck18 = 0 time = 190
* CHECK dout1_28 vdout1_28ck18 = 1.7 time = 190
* CHECK dout1_29 vdout1_29ck18 = 0 time = 190
* CHECK dout1_30 vdout1_30ck18 = 1.7 time = 190
* CHECK dout1_31 vdout1_31ck18 = 1.7 time = 190
* CHECK dout1_32 vdout1_32ck18 = 0 time = 190
* CHECK dout1_0 vdout1_0ck19 = 0 time = 200
* CHECK dout1_1 vdout1_1ck19 = 1.7 time = 200
* CHECK dout1_2 vdout1_2ck19 = 1.7 time = 200
* CHECK dout1_3 vdout1_3ck19 = 1.7 time = 200
* CHECK dout1_4 vdout1_4ck19 = 1.7 time = 200
* CHECK dout1_5 vdout1_5ck19 = 1.7 time = 200
* CHECK dout1_6 vdout1_6ck19 = 1.7 time = 200
* CHECK dout1_7 vdout1_7ck19 = 1.7 time = 200
* CHECK dout1_8 vdout1_8ck19 = 1.7 time = 200
* CHECK dout1_9 vdout1_9ck19 = 0 time = 200
* CHECK dout1_10 vdout1_10ck19 = 1.7 time = 200
* CHECK dout1_11 vdout1_11ck19 = 0 time = 200
* CHECK dout1_12 vdout1_12ck19 = 1.7 time = 200
* CHECK dout1_13 vdout1_13ck19 = 1.7 time = 200
* CHECK dout1_14 vdout1_14ck19 = 1.7 time = 200
* CHECK dout1_15 vdout1_15ck19 = 1.7 time = 200
* CHECK dout1_16 vdout1_16ck19 = 0 time = 200
* CHECK dout1_17 vdout1_17ck19 = 0 time = 200
* CHECK dout1_18 vdout1_18ck19 = 1.7 time = 200
* CHECK dout1_19 vdout1_19ck19 = 1.7 time = 200
* CHECK dout1_20 vdout1_20ck19 = 1.7 time = 200
* CHECK dout1_21 vdout1_21ck19 = 1.7 time = 200
* CHECK dout1_22 vdout1_22ck19 = 1.7 time = 200
* CHECK dout1_23 vdout1_23ck19 = 0 time = 200
* CHECK dout1_24 vdout1_24ck19 = 0 time = 200
* CHECK dout1_25 vdout1_25ck19 = 0 time = 200
* CHECK dout1_26 vdout1_26ck19 = 1.7 time = 200
* CHECK dout1_27 vdout1_27ck19 = 1.7 time = 200
* CHECK dout1_28 vdout1_28ck19 = 0 time = 200
* CHECK dout1_29 vdout1_29ck19 = 0 time = 200
* CHECK dout1_30 vdout1_30ck19 = 1.7 time = 200
* CHECK dout1_31 vdout1_31ck19 = 1.7 time = 200
* CHECK dout1_32 vdout1_32ck19 = 0 time = 200
* CHECK dout1_0 vdout1_0ck20 = 0 time = 210
* CHECK dout1_1 vdout1_1ck20 = 1.7 time = 210
* CHECK dout1_2 vdout1_2ck20 = 0 time = 210
* CHECK dout1_3 vdout1_3ck20 = 0 time = 210
* CHECK dout1_4 vdout1_4ck20 = 0 time = 210
* CHECK dout1_5 vdout1_5ck20 = 1.7 time = 210
* CHECK dout1_6 vdout1_6ck20 = 0 time = 210
* CHECK dout1_7 vdout1_7ck20 = 1.7 time = 210
* CHECK dout1_8 vdout1_8ck20 = 0 time = 210
* CHECK dout1_9 vdout1_9ck20 = 1.7 time = 210
* CHECK dout1_10 vdout1_10ck20 = 1.7 time = 210
* CHECK dout1_11 vdout1_11ck20 = 0 time = 210
* CHECK dout1_12 vdout1_12ck20 = 0 time = 210
* CHECK dout1_13 vdout1_13ck20 = 0 time = 210
* CHECK dout1_14 vdout1_14ck20 = 0 time = 210
* CHECK dout1_15 vdout1_15ck20 = 0 time = 210
* CHECK dout1_16 vdout1_16ck20 = 0 time = 210
* CHECK dout1_17 vdout1_17ck20 = 1.7 time = 210
* CHECK dout1_18 vdout1_18ck20 = 1.7 time = 210
* CHECK dout1_19 vdout1_19ck20 = 0 time = 210
* CHECK dout1_20 vdout1_20ck20 = 0 time = 210
* CHECK dout1_21 vdout1_21ck20 = 0 time = 210
* CHECK dout1_22 vdout1_22ck20 = 0 time = 210
* CHECK dout1_23 vdout1_23ck20 = 1.7 time = 210
* CHECK dout1_24 vdout1_24ck20 = 0 time = 210
* CHECK dout1_25 vdout1_25ck20 = 1.7 time = 210
* CHECK dout1_26 vdout1_26ck20 = 1.7 time = 210
* CHECK dout1_27 vdout1_27ck20 = 0 time = 210
* CHECK dout1_28 vdout1_28ck20 = 1.7 time = 210
* CHECK dout1_29 vdout1_29ck20 = 0 time = 210
* CHECK dout1_30 vdout1_30ck20 = 1.7 time = 210
* CHECK dout1_31 vdout1_31ck20 = 1.7 time = 210
* CHECK dout1_32 vdout1_32ck20 = 0 time = 210
* CHECK dout1_0 vdout1_0ck22 = 0 time = 230
* CHECK dout1_1 vdout1_1ck22 = 1.7 time = 230
* CHECK dout1_2 vdout1_2ck22 = 0 time = 230
* CHECK dout1_3 vdout1_3ck22 = 0 time = 230
* CHECK dout1_4 vdout1_4ck22 = 0 time = 230
* CHECK dout1_5 vdout1_5ck22 = 1.7 time = 230
* CHECK dout1_6 vdout1_6ck22 = 0 time = 230
* CHECK dout1_7 vdout1_7ck22 = 1.7 time = 230
* CHECK dout1_8 vdout1_8ck22 = 0 time = 230
* CHECK dout1_9 vdout1_9ck22 = 1.7 time = 230
* CHECK dout1_10 vdout1_10ck22 = 1.7 time = 230
* CHECK dout1_11 vdout1_11ck22 = 0 time = 230
* CHECK dout1_12 vdout1_12ck22 = 0 time = 230
* CHECK dout1_13 vdout1_13ck22 = 0 time = 230
* CHECK dout1_14 vdout1_14ck22 = 0 time = 230
* CHECK dout1_15 vdout1_15ck22 = 0 time = 230
* CHECK dout1_16 vdout1_16ck22 = 0 time = 230
* CHECK dout1_17 vdout1_17ck22 = 1.7 time = 230
* CHECK dout1_18 vdout1_18ck22 = 1.7 time = 230
* CHECK dout1_19 vdout1_19ck22 = 0 time = 230
* CHECK dout1_20 vdout1_20ck22 = 0 time = 230
* CHECK dout1_21 vdout1_21ck22 = 0 time = 230
* CHECK dout1_22 vdout1_22ck22 = 0 time = 230
* CHECK dout1_23 vdout1_23ck22 = 1.7 time = 230
* CHECK dout1_24 vdout1_24ck22 = 0 time = 230
* CHECK dout1_25 vdout1_25ck22 = 1.7 time = 230
* CHECK dout1_26 vdout1_26ck22 = 1.7 time = 230
* CHECK dout1_27 vdout1_27ck22 = 0 time = 230
* CHECK dout1_28 vdout1_28ck22 = 1.7 time = 230
* CHECK dout1_29 vdout1_29ck22 = 0 time = 230
* CHECK dout1_30 vdout1_30ck22 = 1.7 time = 230
* CHECK dout1_31 vdout1_31ck22 = 1.7 time = 230
* CHECK dout1_32 vdout1_32ck22 = 0 time = 230
* CHECK dout1_0 vdout1_0ck24 = 0 time = 250
* CHECK dout1_1 vdout1_1ck24 = 1.7 time = 250
* CHECK dout1_2 vdout1_2ck24 = 1.7 time = 250
* CHECK dout1_3 vdout1_3ck24 = 1.7 time = 250
* CHECK dout1_4 vdout1_4ck24 = 1.7 time = 250
* CHECK dout1_5 vdout1_5ck24 = 1.7 time = 250
* CHECK dout1_6 vdout1_6ck24 = 1.7 time = 250
* CHECK dout1_7 vdout1_7ck24 = 0 time = 250
* CHECK dout1_8 vdout1_8ck24 = 1.7 time = 250
* CHECK dout1_9 vdout1_9ck24 = 1.7 time = 250
* CHECK dout1_10 vdout1_10ck24 = 0 time = 250
* CHECK dout1_11 vdout1_11ck24 = 0 time = 250
* CHECK dout1_12 vdout1_12ck24 = 1.7 time = 250
* CHECK dout1_13 vdout1_13ck24 = 1.7 time = 250
* CHECK dout1_14 vdout1_14ck24 = 0 time = 250
* CHECK dout1_15 vdout1_15ck24 = 1.7 time = 250
* CHECK dout1_16 vdout1_16ck24 = 0 time = 250
* CHECK dout1_17 vdout1_17ck24 = 0 time = 250
* CHECK dout1_18 vdout1_18ck24 = 0 time = 250
* CHECK dout1_19 vdout1_19ck24 = 0 time = 250
* CHECK dout1_20 vdout1_20ck24 = 0 time = 250
* CHECK dout1_21 vdout1_21ck24 = 0 time = 250
* CHECK dout1_22 vdout1_22ck24 = 0 time = 250
* CHECK dout1_23 vdout1_23ck24 = 0 time = 250
* CHECK dout1_24 vdout1_24ck24 = 1.7 time = 250
* CHECK dout1_25 vdout1_25ck24 = 1.7 time = 250
* CHECK dout1_26 vdout1_26ck24 = 1.7 time = 250
* CHECK dout1_27 vdout1_27ck24 = 1.7 time = 250
* CHECK dout1_28 vdout1_28ck24 = 1.7 time = 250
* CHECK dout1_29 vdout1_29ck24 = 1.7 time = 250
* CHECK dout1_30 vdout1_30ck24 = 0 time = 250
* CHECK dout1_31 vdout1_31ck24 = 1.7 time = 250
* CHECK dout1_32 vdout1_32ck24 = 0 time = 250
* CHECK dout1_0 vdout1_0ck25 = 0 time = 260
* CHECK dout1_1 vdout1_1ck25 = 1.7 time = 260
* CHECK dout1_2 vdout1_2ck25 = 0 time = 260
* CHECK dout1_3 vdout1_3ck25 = 0 time = 260
* CHECK dout1_4 vdout1_4ck25 = 0 time = 260
* CHECK dout1_5 vdout1_5ck25 = 1.7 time = 260
* CHECK dout1_6 vdout1_6ck25 = 0 time = 260
* CHECK dout1_7 vdout1_7ck25 = 1.7 time = 260
* CHECK dout1_8 vdout1_8ck25 = 0 time = 260
* CHECK dout1_9 vdout1_9ck25 = 1.7 time = 260
* CHECK dout1_10 vdout1_10ck25 = 1.7 time = 260
* CHECK dout1_11 vdout1_11ck25 = 0 time = 260
* CHECK dout1_12 vdout1_12ck25 = 0 time = 260
* CHECK dout1_13 vdout1_13ck25 = 0 time = 260
* CHECK dout1_14 vdout1_14ck25 = 0 time = 260
* CHECK dout1_15 vdout1_15ck25 = 0 time = 260
* CHECK dout1_16 vdout1_16ck25 = 0 time = 260
* CHECK dout1_17 vdout1_17ck25 = 1.7 time = 260
* CHECK dout1_18 vdout1_18ck25 = 1.7 time = 260
* CHECK dout1_19 vdout1_19ck25 = 0 time = 260
* CHECK dout1_20 vdout1_20ck25 = 0 time = 260
* CHECK dout1_21 vdout1_21ck25 = 0 time = 260
* CHECK dout1_22 vdout1_22ck25 = 0 time = 260
* CHECK dout1_23 vdout1_23ck25 = 1.7 time = 260
* CHECK dout1_24 vdout1_24ck25 = 0 time = 260
* CHECK dout1_25 vdout1_25ck25 = 1.7 time = 260
* CHECK dout1_26 vdout1_26ck25 = 1.7 time = 260
* CHECK dout1_27 vdout1_27ck25 = 0 time = 260
* CHECK dout1_28 vdout1_28ck25 = 1.7 time = 260
* CHECK dout1_29 vdout1_29ck25 = 0 time = 260
* CHECK dout1_30 vdout1_30ck25 = 1.7 time = 260
* CHECK dout1_31 vdout1_31ck25 = 1.7 time = 260
* CHECK dout1_32 vdout1_32ck25 = 0 time = 260
* CHECK dout1_0 vdout1_0ck27 = 0 time = 280
* CHECK dout1_1 vdout1_1ck27 = 1.7 time = 280
* CHECK dout1_2 vdout1_2ck27 = 1.7 time = 280
* CHECK dout1_3 vdout1_3ck27 = 1.7 time = 280
* CHECK dout1_4 vdout1_4ck27 = 1.7 time = 280
* CHECK dout1_5 vdout1_5ck27 = 1.7 time = 280
* CHECK dout1_6 vdout1_6ck27 = 0 time = 280
* CHECK dout1_7 vdout1_7ck27 = 1.7 time = 280
* CHECK dout1_8 vdout1_8ck27 = 0 time = 280
* CHECK dout1_9 vdout1_9ck27 = 0 time = 280
* CHECK dout1_10 vdout1_10ck27 = 0 time = 280
* CHECK dout1_11 vdout1_11ck27 = 0 time = 280
* CHECK dout1_12 vdout1_12ck27 = 1.7 time = 280
* CHECK dout1_13 vdout1_13ck27 = 1.7 time = 280
* CHECK dout1_14 vdout1_14ck27 = 0 time = 280
* CHECK dout1_15 vdout1_15ck27 = 1.7 time = 280
* CHECK dout1_16 vdout1_16ck27 = 0 time = 280
* CHECK dout1_17 vdout1_17ck27 = 0 time = 280
* CHECK dout1_18 vdout1_18ck27 = 0 time = 280
* CHECK dout1_19 vdout1_19ck27 = 1.7 time = 280
* CHECK dout1_20 vdout1_20ck27 = 0 time = 280
* CHECK dout1_21 vdout1_21ck27 = 1.7 time = 280
* CHECK dout1_22 vdout1_22ck27 = 1.7 time = 280
* CHECK dout1_23 vdout1_23ck27 = 0 time = 280
* CHECK dout1_24 vdout1_24ck27 = 0 time = 280
* CHECK dout1_25 vdout1_25ck27 = 0 time = 280
* CHECK dout1_26 vdout1_26ck27 = 1.7 time = 280
* CHECK dout1_27 vdout1_27ck27 = 0 time = 280
* CHECK dout1_28 vdout1_28ck27 = 0 time = 280
* CHECK dout1_29 vdout1_29ck27 = 1.7 time = 280
* CHECK dout1_30 vdout1_30ck27 = 0 time = 280
* CHECK dout1_31 vdout1_31ck27 = 0 time = 280
* CHECK dout1_32 vdout1_32ck27 = 0 time = 280
* CHECK dout1_0 vdout1_0ck30 = 0 time = 310
* CHECK dout1_1 vdout1_1ck30 = 1.7 time = 310
* CHECK dout1_2 vdout1_2ck30 = 1.7 time = 310
* CHECK dout1_3 vdout1_3ck30 = 1.7 time = 310
* CHECK dout1_4 vdout1_4ck30 = 1.7 time = 310
* CHECK dout1_5 vdout1_5ck30 = 1.7 time = 310
* CHECK dout1_6 vdout1_6ck30 = 1.7 time = 310
* CHECK dout1_7 vdout1_7ck30 = 0 time = 310
* CHECK dout1_8 vdout1_8ck30 = 1.7 time = 310
* CHECK dout1_9 vdout1_9ck30 = 1.7 time = 310
* CHECK dout1_10 vdout1_10ck30 = 0 time = 310
* CHECK dout1_11 vdout1_11ck30 = 0 time = 310
* CHECK dout1_12 vdout1_12ck30 = 1.7 time = 310
* CHECK dout1_13 vdout1_13ck30 = 1.7 time = 310
* CHECK dout1_14 vdout1_14ck30 = 0 time = 310
* CHECK dout1_15 vdout1_15ck30 = 1.7 time = 310
* CHECK dout1_16 vdout1_16ck30 = 0 time = 310
* CHECK dout1_17 vdout1_17ck30 = 0 time = 310
* CHECK dout1_18 vdout1_18ck30 = 0 time = 310
* CHECK dout1_19 vdout1_19ck30 = 0 time = 310
* CHECK dout1_20 vdout1_20ck30 = 0 time = 310
* CHECK dout1_21 vdout1_21ck30 = 0 time = 310
* CHECK dout1_22 vdout1_22ck30 = 0 time = 310
* CHECK dout1_23 vdout1_23ck30 = 0 time = 310
* CHECK dout1_24 vdout1_24ck30 = 1.7 time = 310
* CHECK dout1_25 vdout1_25ck30 = 1.7 time = 310
* CHECK dout1_26 vdout1_26ck30 = 1.7 time = 310
* CHECK dout1_27 vdout1_27ck30 = 1.7 time = 310
* CHECK dout1_28 vdout1_28ck30 = 1.7 time = 310
* CHECK dout1_29 vdout1_29ck30 = 1.7 time = 310
* CHECK dout1_30 vdout1_30ck30 = 0 time = 310
* CHECK dout1_31 vdout1_31ck30 = 1.7 time = 310
* CHECK dout1_32 vdout1_32ck30 = 0 time = 310
* CHECK dout1_0 vdout1_0ck33 = 1.7 time = 340
* CHECK dout1_1 vdout1_1ck33 = 0 time = 340
* CHECK dout1_2 vdout1_2ck33 = 0 time = 340
* CHECK dout1_3 vdout1_3ck33 = 0 time = 340
* CHECK dout1_4 vdout1_4ck33 = 1.7 time = 340
* CHECK dout1_5 vdout1_5ck33 = 0 time = 340
* CHECK dout1_6 vdout1_6ck33 = 1.7 time = 340
* CHECK dout1_7 vdout1_7ck33 = 0 time = 340
* CHECK dout1_8 vdout1_8ck33 = 0 time = 340
* CHECK dout1_9 vdout1_9ck33 = 1.7 time = 340
* CHECK dout1_10 vdout1_10ck33 = 1.7 time = 340
* CHECK dout1_11 vdout1_11ck33 = 1.7 time = 340
* CHECK dout1_12 vdout1_12ck33 = 0 time = 340
* CHECK dout1_13 vdout1_13ck33 = 1.7 time = 340
* CHECK dout1_14 vdout1_14ck33 = 0 time = 340
* CHECK dout1_15 vdout1_15ck33 = 0 time = 340
* CHECK dout1_16 vdout1_16ck33 = 1.7 time = 340
* CHECK dout1_17 vdout1_17ck33 = 1.7 time = 340
* CHECK dout1_18 vdout1_18ck33 = 0 time = 340
* CHECK dout1_19 vdout1_19ck33 = 0 time = 340
* CHECK dout1_20 vdout1_20ck33 = 1.7 time = 340
* CHECK dout1_21 vdout1_21ck33 = 0 time = 340
* CHECK dout1_22 vdout1_22ck33 = 0 time = 340
* CHECK dout1_23 vdout1_23ck33 = 0 time = 340
* CHECK dout1_24 vdout1_24ck33 = 1.7 time = 340
* CHECK dout1_25 vdout1_25ck33 = 0 time = 340
* CHECK dout1_26 vdout1_26ck33 = 0 time = 340
* CHECK dout1_27 vdout1_27ck33 = 1.7 time = 340
* CHECK dout1_28 vdout1_28ck33 = 0 time = 340
* CHECK dout1_29 vdout1_29ck33 = 1.7 time = 340
* CHECK dout1_30 vdout1_30ck33 = 0 time = 340
* CHECK dout1_31 vdout1_31ck33 = 0 time = 340
* CHECK dout1_32 vdout1_32ck33 = 0 time = 340
* CHECK dout1_0 vdout1_0ck34 = 1.7 time = 350
* CHECK dout1_1 vdout1_1ck34 = 1.7 time = 350
* CHECK dout1_2 vdout1_2ck34 = 1.7 time = 350
* CHECK dout1_3 vdout1_3ck34 = 1.7 time = 350
* CHECK dout1_4 vdout1_4ck34 = 1.7 time = 350
* CHECK dout1_5 vdout1_5ck34 = 1.7 time = 350
* CHECK dout1_6 vdout1_6ck34 = 0 time = 350
* CHECK dout1_7 vdout1_7ck34 = 0 time = 350
* CHECK dout1_8 vdout1_8ck34 = 1.7 time = 350
* CHECK dout1_9 vdout1_9ck34 = 1.7 time = 350
* CHECK dout1_10 vdout1_10ck34 = 0 time = 350
* CHECK dout1_11 vdout1_11ck34 = 0 time = 350
* CHECK dout1_12 vdout1_12ck34 = 1.7 time = 350
* CHECK dout1_13 vdout1_13ck34 = 1.7 time = 350
* CHECK dout1_14 vdout1_14ck34 = 0 time = 350
* CHECK dout1_15 vdout1_15ck34 = 1.7 time = 350
* CHECK dout1_16 vdout1_16ck34 = 1.7 time = 350
* CHECK dout1_17 vdout1_17ck34 = 1.7 time = 350
* CHECK dout1_18 vdout1_18ck34 = 1.7 time = 350
* CHECK dout1_19 vdout1_19ck34 = 1.7 time = 350
* CHECK dout1_20 vdout1_20ck34 = 1.7 time = 350
* CHECK dout1_21 vdout1_21ck34 = 1.7 time = 350
* CHECK dout1_22 vdout1_22ck34 = 0 time = 350
* CHECK dout1_23 vdout1_23ck34 = 0 time = 350
* CHECK dout1_24 vdout1_24ck34 = 1.7 time = 350
* CHECK dout1_25 vdout1_25ck34 = 1.7 time = 350
* CHECK dout1_26 vdout1_26ck34 = 0 time = 350
* CHECK dout1_27 vdout1_27ck34 = 1.7 time = 350
* CHECK dout1_28 vdout1_28ck34 = 0 time = 350
* CHECK dout1_29 vdout1_29ck34 = 0 time = 350
* CHECK dout1_30 vdout1_30ck34 = 1.7 time = 350
* CHECK dout1_31 vdout1_31ck34 = 1.7 time = 350
* CHECK dout1_32 vdout1_32ck34 = 0 time = 350
* CHECK dout1_0 vdout1_0ck37 = 1.7 time = 380
* CHECK dout1_1 vdout1_1ck37 = 0 time = 380
* CHECK dout1_2 vdout1_2ck37 = 0 time = 380
* CHECK dout1_3 vdout1_3ck37 = 0 time = 380
* CHECK dout1_4 vdout1_4ck37 = 1.7 time = 380
* CHECK dout1_5 vdout1_5ck37 = 0 time = 380
* CHECK dout1_6 vdout1_6ck37 = 1.7 time = 380
* CHECK dout1_7 vdout1_7ck37 = 0 time = 380
* CHECK dout1_8 vdout1_8ck37 = 0 time = 380
* CHECK dout1_9 vdout1_9ck37 = 1.7 time = 380
* CHECK dout1_10 vdout1_10ck37 = 1.7 time = 380
* CHECK dout1_11 vdout1_11ck37 = 1.7 time = 380
* CHECK dout1_12 vdout1_12ck37 = 0 time = 380
* CHECK dout1_13 vdout1_13ck37 = 1.7 time = 380
* CHECK dout1_14 vdout1_14ck37 = 0 time = 380
* CHECK dout1_15 vdout1_15ck37 = 0 time = 380
* CHECK dout1_16 vdout1_16ck37 = 1.7 time = 380
* CHECK dout1_17 vdout1_17ck37 = 1.7 time = 380
* CHECK dout1_18 vdout1_18ck37 = 0 time = 380
* CHECK dout1_19 vdout1_19ck37 = 0 time = 380
* CHECK dout1_20 vdout1_20ck37 = 1.7 time = 380
* CHECK dout1_21 vdout1_21ck37 = 0 time = 380
* CHECK dout1_22 vdout1_22ck37 = 0 time = 380
* CHECK dout1_23 vdout1_23ck37 = 0 time = 380
* CHECK dout1_24 vdout1_24ck37 = 1.7 time = 380
* CHECK dout1_25 vdout1_25ck37 = 0 time = 380
* CHECK dout1_26 vdout1_26ck37 = 0 time = 380
* CHECK dout1_27 vdout1_27ck37 = 1.7 time = 380
* CHECK dout1_28 vdout1_28ck37 = 0 time = 380
* CHECK dout1_29 vdout1_29ck37 = 1.7 time = 380
* CHECK dout1_30 vdout1_30ck37 = 0 time = 380
* CHECK dout1_31 vdout1_31ck37 = 0 time = 380
* CHECK dout1_32 vdout1_32ck37 = 0 time = 380
* CHECK dout1_0 vdout1_0ck39 = 0 time = 400
* CHECK dout1_1 vdout1_1ck39 = 1.7 time = 400
* CHECK dout1_2 vdout1_2ck39 = 1.7 time = 400
* CHECK dout1_3 vdout1_3ck39 = 1.7 time = 400
* CHECK dout1_4 vdout1_4ck39 = 1.7 time = 400
* CHECK dout1_5 vdout1_5ck39 = 1.7 time = 400
* CHECK dout1_6 vdout1_6ck39 = 0 time = 400
* CHECK dout1_7 vdout1_7ck39 = 1.7 time = 400
* CHECK dout1_8 vdout1_8ck39 = 0 time = 400
* CHECK dout1_9 vdout1_9ck39 = 0 time = 400
* CHECK dout1_10 vdout1_10ck39 = 0 time = 400
* CHECK dout1_11 vdout1_11ck39 = 0 time = 400
* CHECK dout1_12 vdout1_12ck39 = 1.7 time = 400
* CHECK dout1_13 vdout1_13ck39 = 1.7 time = 400
* CHECK dout1_14 vdout1_14ck39 = 0 time = 400
* CHECK dout1_15 vdout1_15ck39 = 1.7 time = 400
* CHECK dout1_16 vdout1_16ck39 = 0 time = 400
* CHECK dout1_17 vdout1_17ck39 = 0 time = 400
* CHECK dout1_18 vdout1_18ck39 = 0 time = 400
* CHECK dout1_19 vdout1_19ck39 = 1.7 time = 400
* CHECK dout1_20 vdout1_20ck39 = 0 time = 400
* CHECK dout1_21 vdout1_21ck39 = 1.7 time = 400
* CHECK dout1_22 vdout1_22ck39 = 1.7 time = 400
* CHECK dout1_23 vdout1_23ck39 = 0 time = 400
* CHECK dout1_24 vdout1_24ck39 = 0 time = 400
* CHECK dout1_25 vdout1_25ck39 = 0 time = 400
* CHECK dout1_26 vdout1_26ck39 = 1.7 time = 400
* CHECK dout1_27 vdout1_27ck39 = 0 time = 400
* CHECK dout1_28 vdout1_28ck39 = 0 time = 400
* CHECK dout1_29 vdout1_29ck39 = 1.7 time = 400
* CHECK dout1_30 vdout1_30ck39 = 0 time = 400
* CHECK dout1_31 vdout1_31ck39 = 0 time = 400
* CHECK dout1_32 vdout1_32ck39 = 0 time = 400
* CHECK dout1_0 vdout1_0ck41 = 1.7 time = 420
* CHECK dout1_1 vdout1_1ck41 = 1.7 time = 420
* CHECK dout1_2 vdout1_2ck41 = 1.7 time = 420
* CHECK dout1_3 vdout1_3ck41 = 1.7 time = 420
* CHECK dout1_4 vdout1_4ck41 = 1.7 time = 420
* CHECK dout1_5 vdout1_5ck41 = 1.7 time = 420
* CHECK dout1_6 vdout1_6ck41 = 0 time = 420
* CHECK dout1_7 vdout1_7ck41 = 0 time = 420
* CHECK dout1_8 vdout1_8ck41 = 1.7 time = 420
* CHECK dout1_9 vdout1_9ck41 = 1.7 time = 420
* CHECK dout1_10 vdout1_10ck41 = 0 time = 420
* CHECK dout1_11 vdout1_11ck41 = 0 time = 420
* CHECK dout1_12 vdout1_12ck41 = 1.7 time = 420
* CHECK dout1_13 vdout1_13ck41 = 1.7 time = 420
* CHECK dout1_14 vdout1_14ck41 = 0 time = 420
* CHECK dout1_15 vdout1_15ck41 = 1.7 time = 420
* CHECK dout1_16 vdout1_16ck41 = 1.7 time = 420
* CHECK dout1_17 vdout1_17ck41 = 1.7 time = 420
* CHECK dout1_18 vdout1_18ck41 = 1.7 time = 420
* CHECK dout1_19 vdout1_19ck41 = 1.7 time = 420
* CHECK dout1_20 vdout1_20ck41 = 1.7 time = 420
* CHECK dout1_21 vdout1_21ck41 = 1.7 time = 420
* CHECK dout1_22 vdout1_22ck41 = 0 time = 420
* CHECK dout1_23 vdout1_23ck41 = 0 time = 420
* CHECK dout1_24 vdout1_24ck41 = 1.7 time = 420
* CHECK dout1_25 vdout1_25ck41 = 1.7 time = 420
* CHECK dout1_26 vdout1_26ck41 = 0 time = 420
* CHECK dout1_27 vdout1_27ck41 = 1.7 time = 420
* CHECK dout1_28 vdout1_28ck41 = 0 time = 420
* CHECK dout1_29 vdout1_29ck41 = 0 time = 420
* CHECK dout1_30 vdout1_30ck41 = 1.7 time = 420
* CHECK dout1_31 vdout1_31ck41 = 1.7 time = 420
* CHECK dout1_32 vdout1_32ck41 = 0 time = 420
* CHECK dout1_0 vdout1_0ck43 = 0 time = 440
* CHECK dout1_1 vdout1_1ck43 = 1.7 time = 440
* CHECK dout1_2 vdout1_2ck43 = 0 time = 440
* CHECK dout1_3 vdout1_3ck43 = 0 time = 440
* CHECK dout1_4 vdout1_4ck43 = 0 time = 440
* CHECK dout1_5 vdout1_5ck43 = 1.7 time = 440
* CHECK dout1_6 vdout1_6ck43 = 0 time = 440
* CHECK dout1_7 vdout1_7ck43 = 1.7 time = 440
* CHECK dout1_8 vdout1_8ck43 = 0 time = 440
* CHECK dout1_9 vdout1_9ck43 = 1.7 time = 440
* CHECK dout1_10 vdout1_10ck43 = 1.7 time = 440
* CHECK dout1_11 vdout1_11ck43 = 0 time = 440
* CHECK dout1_12 vdout1_12ck43 = 0 time = 440
* CHECK dout1_13 vdout1_13ck43 = 0 time = 440
* CHECK dout1_14 vdout1_14ck43 = 0 time = 440
* CHECK dout1_15 vdout1_15ck43 = 0 time = 440
* CHECK dout1_16 vdout1_16ck43 = 0 time = 440
* CHECK dout1_17 vdout1_17ck43 = 1.7 time = 440
* CHECK dout1_18 vdout1_18ck43 = 1.7 time = 440
* CHECK dout1_19 vdout1_19ck43 = 0 time = 440
* CHECK dout1_20 vdout1_20ck43 = 0 time = 440
* CHECK dout1_21 vdout1_21ck43 = 0 time = 440
* CHECK dout1_22 vdout1_22ck43 = 0 time = 440
* CHECK dout1_23 vdout1_23ck43 = 1.7 time = 440
* CHECK dout1_24 vdout1_24ck43 = 0 time = 440
* CHECK dout1_25 vdout1_25ck43 = 1.7 time = 440
* CHECK dout1_26 vdout1_26ck43 = 1.7 time = 440
* CHECK dout1_27 vdout1_27ck43 = 0 time = 440
* CHECK dout1_28 vdout1_28ck43 = 1.7 time = 440
* CHECK dout1_29 vdout1_29ck43 = 0 time = 440
* CHECK dout1_30 vdout1_30ck43 = 1.7 time = 440
* CHECK dout1_31 vdout1_31ck43 = 1.7 time = 440
* CHECK dout1_32 vdout1_32ck43 = 0 time = 440
* CHECK dout1_0 vdout1_0ck47 = 0 time = 480
* CHECK dout1_1 vdout1_1ck47 = 0 time = 480
* CHECK dout1_2 vdout1_2ck47 = 1.7 time = 480
* CHECK dout1_3 vdout1_3ck47 = 1.7 time = 480
* CHECK dout1_4 vdout1_4ck47 = 0 time = 480
* CHECK dout1_5 vdout1_5ck47 = 1.7 time = 480
* CHECK dout1_6 vdout1_6ck47 = 1.7 time = 480
* CHECK dout1_7 vdout1_7ck47 = 0 time = 480
* CHECK dout1_8 vdout1_8ck47 = 0 time = 480
* CHECK dout1_9 vdout1_9ck47 = 1.7 time = 480
* CHECK dout1_10 vdout1_10ck47 = 1.7 time = 480
* CHECK dout1_11 vdout1_11ck47 = 1.7 time = 480
* CHECK dout1_12 vdout1_12ck47 = 1.7 time = 480
* CHECK dout1_13 vdout1_13ck47 = 1.7 time = 480
* CHECK dout1_14 vdout1_14ck47 = 1.7 time = 480
* CHECK dout1_15 vdout1_15ck47 = 0 time = 480
* CHECK dout1_16 vdout1_16ck47 = 0 time = 480
* CHECK dout1_17 vdout1_17ck47 = 1.7 time = 480
* CHECK dout1_18 vdout1_18ck47 = 0 time = 480
* CHECK dout1_19 vdout1_19ck47 = 1.7 time = 480
* CHECK dout1_20 vdout1_20ck47 = 1.7 time = 480
* CHECK dout1_21 vdout1_21ck47 = 0 time = 480
* CHECK dout1_22 vdout1_22ck47 = 1.7 time = 480
* CHECK dout1_23 vdout1_23ck47 = 0 time = 480
* CHECK dout1_24 vdout1_24ck47 = 1.7 time = 480
* CHECK dout1_25 vdout1_25ck47 = 0 time = 480
* CHECK dout1_26 vdout1_26ck47 = 0 time = 480
* CHECK dout1_27 vdout1_27ck47 = 0 time = 480
* CHECK dout1_28 vdout1_28ck47 = 0 time = 480
* CHECK dout1_29 vdout1_29ck47 = 0 time = 480
* CHECK dout1_30 vdout1_30ck47 = 0 time = 480
* CHECK dout1_31 vdout1_31ck47 = 1.7 time = 480
* CHECK dout1_32 vdout1_32ck47 = 0 time = 480
* CHECK dout1_0 vdout1_0ck48 = 1.7 time = 490
* CHECK dout1_1 vdout1_1ck48 = 0 time = 490
* CHECK dout1_2 vdout1_2ck48 = 0 time = 490
* CHECK dout1_3 vdout1_3ck48 = 0 time = 490
* CHECK dout1_4 vdout1_4ck48 = 1.7 time = 490
* CHECK dout1_5 vdout1_5ck48 = 0 time = 490
* CHECK dout1_6 vdout1_6ck48 = 1.7 time = 490
* CHECK dout1_7 vdout1_7ck48 = 1.7 time = 490
* CHECK dout1_8 vdout1_8ck48 = 0 time = 490
* CHECK dout1_9 vdout1_9ck48 = 1.7 time = 490
* CHECK dout1_10 vdout1_10ck48 = 0 time = 490
* CHECK dout1_11 vdout1_11ck48 = 0 time = 490
* CHECK dout1_12 vdout1_12ck48 = 0 time = 490
* CHECK dout1_13 vdout1_13ck48 = 0 time = 490
* CHECK dout1_14 vdout1_14ck48 = 0 time = 490
* CHECK dout1_15 vdout1_15ck48 = 1.7 time = 490
* CHECK dout1_16 vdout1_16ck48 = 0 time = 490
* CHECK dout1_17 vdout1_17ck48 = 0 time = 490
* CHECK dout1_18 vdout1_18ck48 = 0 time = 490
* CHECK dout1_19 vdout1_19ck48 = 0 time = 490
* CHECK dout1_20 vdout1_20ck48 = 1.7 time = 490
* CHECK dout1_21 vdout1_21ck48 = 1.7 time = 490
* CHECK dout1_22 vdout1_22ck48 = 1.7 time = 490
* CHECK dout1_23 vdout1_23ck48 = 1.7 time = 490
* CHECK dout1_24 vdout1_24ck48 = 0 time = 490
* CHECK dout1_25 vdout1_25ck48 = 0 time = 490
* CHECK dout1_26 vdout1_26ck48 = 1.7 time = 490
* CHECK dout1_27 vdout1_27ck48 = 0 time = 490
* CHECK dout1_28 vdout1_28ck48 = 0 time = 490
* CHECK dout1_29 vdout1_29ck48 = 0 time = 490
* CHECK dout1_30 vdout1_30ck48 = 1.7 time = 490
* CHECK dout1_31 vdout1_31ck48 = 1.7 time = 490
* CHECK dout1_32 vdout1_32ck48 = 0 time = 490
* CHECK dout1_0 vdout1_0ck49 = 0 time = 500
* CHECK dout1_1 vdout1_1ck49 = 1.7 time = 500
* CHECK dout1_2 vdout1_2ck49 = 0 time = 500
* CHECK dout1_3 vdout1_3ck49 = 0 time = 500
* CHECK dout1_4 vdout1_4ck49 = 0 time = 500
* CHECK dout1_5 vdout1_5ck49 = 1.7 time = 500
* CHECK dout1_6 vdout1_6ck49 = 0 time = 500
* CHECK dout1_7 vdout1_7ck49 = 1.7 time = 500
* CHECK dout1_8 vdout1_8ck49 = 1.7 time = 500
* CHECK dout1_9 vdout1_9ck49 = 0 time = 500
* CHECK dout1_10 vdout1_10ck49 = 1.7 time = 500
* CHECK dout1_11 vdout1_11ck49 = 0 time = 500
* CHECK dout1_12 vdout1_12ck49 = 1.7 time = 500
* CHECK dout1_13 vdout1_13ck49 = 1.7 time = 500
* CHECK dout1_14 vdout1_14ck49 = 1.7 time = 500
* CHECK dout1_15 vdout1_15ck49 = 1.7 time = 500
* CHECK dout1_16 vdout1_16ck49 = 0 time = 500
* CHECK dout1_17 vdout1_17ck49 = 1.7 time = 500
* CHECK dout1_18 vdout1_18ck49 = 1.7 time = 500
* CHECK dout1_19 vdout1_19ck49 = 0 time = 500
* CHECK dout1_20 vdout1_20ck49 = 1.7 time = 500
* CHECK dout1_21 vdout1_21ck49 = 1.7 time = 500
* CHECK dout1_22 vdout1_22ck49 = 0 time = 500
* CHECK dout1_23 vdout1_23ck49 = 1.7 time = 500
* CHECK dout1_24 vdout1_24ck49 = 0 time = 500
* CHECK dout1_25 vdout1_25ck49 = 1.7 time = 500
* CHECK dout1_26 vdout1_26ck49 = 0 time = 500
* CHECK dout1_27 vdout1_27ck49 = 1.7 time = 500
* CHECK dout1_28 vdout1_28ck49 = 0 time = 500
* CHECK dout1_29 vdout1_29ck49 = 1.7 time = 500
* CHECK dout1_30 vdout1_30ck49 = 0 time = 500
* CHECK dout1_31 vdout1_31ck49 = 1.7 time = 500
* CHECK dout1_32 vdout1_32ck49 = 0 time = 500
* CHECK dout1_0 vdout1_0ck51 = 1.7 time = 520
* CHECK dout1_1 vdout1_1ck51 = 1.7 time = 520
* CHECK dout1_2 vdout1_2ck51 = 1.7 time = 520
* CHECK dout1_3 vdout1_3ck51 = 1.7 time = 520
* CHECK dout1_4 vdout1_4ck51 = 1.7 time = 520
* CHECK dout1_5 vdout1_5ck51 = 0 time = 520
* CHECK dout1_6 vdout1_6ck51 = 1.7 time = 520
* CHECK dout1_7 vdout1_7ck51 = 1.7 time = 520
* CHECK dout1_8 vdout1_8ck51 = 1.7 time = 520
* CHECK dout1_9 vdout1_9ck51 = 1.7 time = 520
* CHECK dout1_10 vdout1_10ck51 = 0 time = 520
* CHECK dout1_11 vdout1_11ck51 = 0 time = 520
* CHECK dout1_12 vdout1_12ck51 = 1.7 time = 520
* CHECK dout1_13 vdout1_13ck51 = 0 time = 520
* CHECK dout1_14 vdout1_14ck51 = 0 time = 520
* CHECK dout1_15 vdout1_15ck51 = 1.7 time = 520
* CHECK dout1_16 vdout1_16ck51 = 1.7 time = 520
* CHECK dout1_17 vdout1_17ck51 = 0 time = 520
* CHECK dout1_18 vdout1_18ck51 = 1.7 time = 520
* CHECK dout1_19 vdout1_19ck51 = 1.7 time = 520
* CHECK dout1_20 vdout1_20ck51 = 0 time = 520
* CHECK dout1_21 vdout1_21ck51 = 1.7 time = 520
* CHECK dout1_22 vdout1_22ck51 = 0 time = 520
* CHECK dout1_23 vdout1_23ck51 = 1.7 time = 520
* CHECK dout1_24 vdout1_24ck51 = 1.7 time = 520
* CHECK dout1_25 vdout1_25ck51 = 0 time = 520
* CHECK dout1_26 vdout1_26ck51 = 0 time = 520
* CHECK dout1_27 vdout1_27ck51 = 0 time = 520
* CHECK dout1_28 vdout1_28ck51 = 1.7 time = 520
* CHECK dout1_29 vdout1_29ck51 = 1.7 time = 520
* CHECK dout1_30 vdout1_30ck51 = 1.7 time = 520
* CHECK dout1_31 vdout1_31ck51 = 0 time = 520
* CHECK dout1_32 vdout1_32ck51 = 0 time = 520
* CHECK dout1_0 vdout1_0ck57 = 1.7 time = 580
* CHECK dout1_1 vdout1_1ck57 = 0 time = 580
* CHECK dout1_2 vdout1_2ck57 = 0 time = 580
* CHECK dout1_3 vdout1_3ck57 = 0 time = 580
* CHECK dout1_4 vdout1_4ck57 = 0 time = 580
* CHECK dout1_5 vdout1_5ck57 = 1.7 time = 580
* CHECK dout1_6 vdout1_6ck57 = 0 time = 580
* CHECK dout1_7 vdout1_7ck57 = 1.7 time = 580
* CHECK dout1_8 vdout1_8ck57 = 1.7 time = 580
* CHECK dout1_9 vdout1_9ck57 = 1.7 time = 580
* CHECK dout1_10 vdout1_10ck57 = 1.7 time = 580
* CHECK dout1_11 vdout1_11ck57 = 0 time = 580
* CHECK dout1_12 vdout1_12ck57 = 1.7 time = 580
* CHECK dout1_13 vdout1_13ck57 = 1.7 time = 580
* CHECK dout1_14 vdout1_14ck57 = 0 time = 580
* CHECK dout1_15 vdout1_15ck57 = 0 time = 580
* CHECK dout1_16 vdout1_16ck57 = 0 time = 580
* CHECK dout1_17 vdout1_17ck57 = 0 time = 580
* CHECK dout1_18 vdout1_18ck57 = 0 time = 580
* CHECK dout1_19 vdout1_19ck57 = 0 time = 580
* CHECK dout1_20 vdout1_20ck57 = 0 time = 580
* CHECK dout1_21 vdout1_21ck57 = 1.7 time = 580
* CHECK dout1_22 vdout1_22ck57 = 0 time = 580
* CHECK dout1_23 vdout1_23ck57 = 1.7 time = 580
* CHECK dout1_24 vdout1_24ck57 = 0 time = 580
* CHECK dout1_25 vdout1_25ck57 = 0 time = 580
* CHECK dout1_26 vdout1_26ck57 = 1.7 time = 580
* CHECK dout1_27 vdout1_27ck57 = 1.7 time = 580
* CHECK dout1_28 vdout1_28ck57 = 1.7 time = 580
* CHECK dout1_29 vdout1_29ck57 = 0 time = 580
* CHECK dout1_30 vdout1_30ck57 = 1.7 time = 580
* CHECK dout1_31 vdout1_31ck57 = 0 time = 580
* CHECK dout1_32 vdout1_32ck57 = 0 time = 580
* CHECK dout1_0 vdout1_0ck60 = 0 time = 610
* CHECK dout1_1 vdout1_1ck60 = 1.7 time = 610
* CHECK dout1_2 vdout1_2ck60 = 0 time = 610
* CHECK dout1_3 vdout1_3ck60 = 0 time = 610
* CHECK dout1_4 vdout1_4ck60 = 0 time = 610
* CHECK dout1_5 vdout1_5ck60 = 0 time = 610
* CHECK dout1_6 vdout1_6ck60 = 1.7 time = 610
* CHECK dout1_7 vdout1_7ck60 = 0 time = 610
* CHECK dout1_8 vdout1_8ck60 = 0 time = 610
* CHECK dout1_9 vdout1_9ck60 = 0 time = 610
* CHECK dout1_10 vdout1_10ck60 = 1.7 time = 610
* CHECK dout1_11 vdout1_11ck60 = 1.7 time = 610
* CHECK dout1_12 vdout1_12ck60 = 1.7 time = 610
* CHECK dout1_13 vdout1_13ck60 = 0 time = 610
* CHECK dout1_14 vdout1_14ck60 = 1.7 time = 610
* CHECK dout1_15 vdout1_15ck60 = 0 time = 610
* CHECK dout1_16 vdout1_16ck60 = 0 time = 610
* CHECK dout1_17 vdout1_17ck60 = 0 time = 610
* CHECK dout1_18 vdout1_18ck60 = 1.7 time = 610
* CHECK dout1_19 vdout1_19ck60 = 0 time = 610
* CHECK dout1_20 vdout1_20ck60 = 0 time = 610
* CHECK dout1_21 vdout1_21ck60 = 1.7 time = 610
* CHECK dout1_22 vdout1_22ck60 = 0 time = 610
* CHECK dout1_23 vdout1_23ck60 = 1.7 time = 610
* CHECK dout1_24 vdout1_24ck60 = 0 time = 610
* CHECK dout1_25 vdout1_25ck60 = 1.7 time = 610
* CHECK dout1_26 vdout1_26ck60 = 0 time = 610
* CHECK dout1_27 vdout1_27ck60 = 0 time = 610
* CHECK dout1_28 vdout1_28ck60 = 0 time = 610
* CHECK dout1_29 vdout1_29ck60 = 0 time = 610
* CHECK dout1_30 vdout1_30ck60 = 0 time = 610
* CHECK dout1_31 vdout1_31ck60 = 1.7 time = 610
* CHECK dout1_32 vdout1_32ck60 = 0 time = 610
* CHECK dout1_0 vdout1_0ck62 = 0 time = 630
* CHECK dout1_1 vdout1_1ck62 = 1.7 time = 630
* CHECK dout1_2 vdout1_2ck62 = 0 time = 630
* CHECK dout1_3 vdout1_3ck62 = 0 time = 630
* CHECK dout1_4 vdout1_4ck62 = 0 time = 630
* CHECK dout1_5 vdout1_5ck62 = 0 time = 630
* CHECK dout1_6 vdout1_6ck62 = 1.7 time = 630
* CHECK dout1_7 vdout1_7ck62 = 0 time = 630
* CHECK dout1_8 vdout1_8ck62 = 0 time = 630
* CHECK dout1_9 vdout1_9ck62 = 0 time = 630
* CHECK dout1_10 vdout1_10ck62 = 1.7 time = 630
* CHECK dout1_11 vdout1_11ck62 = 1.7 time = 630
* CHECK dout1_12 vdout1_12ck62 = 1.7 time = 630
* CHECK dout1_13 vdout1_13ck62 = 0 time = 630
* CHECK dout1_14 vdout1_14ck62 = 1.7 time = 630
* CHECK dout1_15 vdout1_15ck62 = 0 time = 630
* CHECK dout1_16 vdout1_16ck62 = 0 time = 630
* CHECK dout1_17 vdout1_17ck62 = 0 time = 630
* CHECK dout1_18 vdout1_18ck62 = 1.7 time = 630
* CHECK dout1_19 vdout1_19ck62 = 0 time = 630
* CHECK dout1_20 vdout1_20ck62 = 0 time = 630
* CHECK dout1_21 vdout1_21ck62 = 1.7 time = 630
* CHECK dout1_22 vdout1_22ck62 = 0 time = 630
* CHECK dout1_23 vdout1_23ck62 = 1.7 time = 630
* CHECK dout1_24 vdout1_24ck62 = 0 time = 630
* CHECK dout1_25 vdout1_25ck62 = 1.7 time = 630
* CHECK dout1_26 vdout1_26ck62 = 0 time = 630
* CHECK dout1_27 vdout1_27ck62 = 0 time = 630
* CHECK dout1_28 vdout1_28ck62 = 0 time = 630
* CHECK dout1_29 vdout1_29ck62 = 0 time = 630
* CHECK dout1_30 vdout1_30ck62 = 0 time = 630
* CHECK dout1_31 vdout1_31ck62 = 1.7 time = 630
* CHECK dout1_32 vdout1_32ck62 = 0 time = 630
* CHECK dout1_0 vdout1_0ck63 = 1.7 time = 640
* CHECK dout1_1 vdout1_1ck63 = 0 time = 640
* CHECK dout1_2 vdout1_2ck63 = 1.7 time = 640
* CHECK dout1_3 vdout1_3ck63 = 0 time = 640
* CHECK dout1_4 vdout1_4ck63 = 1.7 time = 640
* CHECK dout1_5 vdout1_5ck63 = 1.7 time = 640
* CHECK dout1_6 vdout1_6ck63 = 1.7 time = 640
* CHECK dout1_7 vdout1_7ck63 = 0 time = 640
* CHECK dout1_8 vdout1_8ck63 = 1.7 time = 640
* CHECK dout1_9 vdout1_9ck63 = 0 time = 640
* CHECK dout1_10 vdout1_10ck63 = 1.7 time = 640
* CHECK dout1_11 vdout1_11ck63 = 0 time = 640
* CHECK dout1_12 vdout1_12ck63 = 1.7 time = 640
* CHECK dout1_13 vdout1_13ck63 = 0 time = 640
* CHECK dout1_14 vdout1_14ck63 = 0 time = 640
* CHECK dout1_15 vdout1_15ck63 = 1.7 time = 640
* CHECK dout1_16 vdout1_16ck63 = 0 time = 640
* CHECK dout1_17 vdout1_17ck63 = 1.7 time = 640
* CHECK dout1_18 vdout1_18ck63 = 0 time = 640
* CHECK dout1_19 vdout1_19ck63 = 1.7 time = 640
* CHECK dout1_20 vdout1_20ck63 = 1.7 time = 640
* CHECK dout1_21 vdout1_21ck63 = 0 time = 640
* CHECK dout1_22 vdout1_22ck63 = 1.7 time = 640
* CHECK dout1_23 vdout1_23ck63 = 1.7 time = 640
* CHECK dout1_24 vdout1_24ck63 = 1.7 time = 640
* CHECK dout1_25 vdout1_25ck63 = 1.7 time = 640
* CHECK dout1_26 vdout1_26ck63 = 1.7 time = 640
* CHECK dout1_27 vdout1_27ck63 = 1.7 time = 640
* CHECK dout1_28 vdout1_28ck63 = 0 time = 640
* CHECK dout1_29 vdout1_29ck63 = 1.7 time = 640
* CHECK dout1_30 vdout1_30ck63 = 1.7 time = 640
* CHECK dout1_31 vdout1_31ck63 = 0 time = 640
* CHECK dout1_32 vdout1_32ck63 = 0 time = 640
* CHECK dout1_0 vdout1_0ck66 = 1.7 time = 670
* CHECK dout1_1 vdout1_1ck66 = 0 time = 670
* CHECK dout1_2 vdout1_2ck66 = 0 time = 670
* CHECK dout1_3 vdout1_3ck66 = 1.7 time = 670
* CHECK dout1_4 vdout1_4ck66 = 1.7 time = 670
* CHECK dout1_5 vdout1_5ck66 = 1.7 time = 670
* CHECK dout1_6 vdout1_6ck66 = 1.7 time = 670
* CHECK dout1_7 vdout1_7ck66 = 0 time = 670
* CHECK dout1_8 vdout1_8ck66 = 1.7 time = 670
* CHECK dout1_9 vdout1_9ck66 = 0 time = 670
* CHECK dout1_10 vdout1_10ck66 = 0 time = 670
* CHECK dout1_11 vdout1_11ck66 = 1.7 time = 670
* CHECK dout1_12 vdout1_12ck66 = 1.7 time = 670
* CHECK dout1_13 vdout1_13ck66 = 1.7 time = 670
* CHECK dout1_14 vdout1_14ck66 = 0 time = 670
* CHECK dout1_15 vdout1_15ck66 = 0 time = 670
* CHECK dout1_16 vdout1_16ck66 = 0 time = 670
* CHECK dout1_17 vdout1_17ck66 = 0 time = 670
* CHECK dout1_18 vdout1_18ck66 = 0 time = 670
* CHECK dout1_19 vdout1_19ck66 = 0 time = 670
* CHECK dout1_20 vdout1_20ck66 = 1.7 time = 670
* CHECK dout1_21 vdout1_21ck66 = 1.7 time = 670
* CHECK dout1_22 vdout1_22ck66 = 0 time = 670
* CHECK dout1_23 vdout1_23ck66 = 0 time = 670
* CHECK dout1_24 vdout1_24ck66 = 0 time = 670
* CHECK dout1_25 vdout1_25ck66 = 0 time = 670
* CHECK dout1_26 vdout1_26ck66 = 0 time = 670
* CHECK dout1_27 vdout1_27ck66 = 0 time = 670
* CHECK dout1_28 vdout1_28ck66 = 0 time = 670
* CHECK dout1_29 vdout1_29ck66 = 0 time = 670
* CHECK dout1_30 vdout1_30ck66 = 1.7 time = 670
* CHECK dout1_31 vdout1_31ck66 = 0 time = 670
* CHECK dout1_32 vdout1_32ck66 = 0 time = 670
* CHECK dout1_0 vdout1_0ck67 = 0 time = 680
* CHECK dout1_1 vdout1_1ck67 = 1.7 time = 680
* CHECK dout1_2 vdout1_2ck67 = 1.7 time = 680
* CHECK dout1_3 vdout1_3ck67 = 0 time = 680
* CHECK dout1_4 vdout1_4ck67 = 1.7 time = 680
* CHECK dout1_5 vdout1_5ck67 = 0 time = 680
* CHECK dout1_6 vdout1_6ck67 = 1.7 time = 680
* CHECK dout1_7 vdout1_7ck67 = 1.7 time = 680
* CHECK dout1_8 vdout1_8ck67 = 1.7 time = 680
* CHECK dout1_9 vdout1_9ck67 = 1.7 time = 680
* CHECK dout1_10 vdout1_10ck67 = 0 time = 680
* CHECK dout1_11 vdout1_11ck67 = 0 time = 680
* CHECK dout1_12 vdout1_12ck67 = 1.7 time = 680
* CHECK dout1_13 vdout1_13ck67 = 0 time = 680
* CHECK dout1_14 vdout1_14ck67 = 0 time = 680
* CHECK dout1_15 vdout1_15ck67 = 1.7 time = 680
* CHECK dout1_16 vdout1_16ck67 = 1.7 time = 680
* CHECK dout1_17 vdout1_17ck67 = 1.7 time = 680
* CHECK dout1_18 vdout1_18ck67 = 0 time = 680
* CHECK dout1_19 vdout1_19ck67 = 1.7 time = 680
* CHECK dout1_20 vdout1_20ck67 = 0 time = 680
* CHECK dout1_21 vdout1_21ck67 = 1.7 time = 680
* CHECK dout1_22 vdout1_22ck67 = 0 time = 680
* CHECK dout1_23 vdout1_23ck67 = 0 time = 680
* CHECK dout1_24 vdout1_24ck67 = 0 time = 680
* CHECK dout1_25 vdout1_25ck67 = 1.7 time = 680
* CHECK dout1_26 vdout1_26ck67 = 0 time = 680
* CHECK dout1_27 vdout1_27ck67 = 0 time = 680
* CHECK dout1_28 vdout1_28ck67 = 1.7 time = 680
* CHECK dout1_29 vdout1_29ck67 = 1.7 time = 680
* CHECK dout1_30 vdout1_30ck67 = 0 time = 680
* CHECK dout1_31 vdout1_31ck67 = 1.7 time = 680
* CHECK dout1_32 vdout1_32ck67 = 0 time = 680
* CHECK dout1_0 vdout1_0ck68 = 1.7 time = 690
* CHECK dout1_1 vdout1_1ck68 = 0 time = 690
* CHECK dout1_2 vdout1_2ck68 = 1.7 time = 690
* CHECK dout1_3 vdout1_3ck68 = 0 time = 690
* CHECK dout1_4 vdout1_4ck68 = 1.7 time = 690
* CHECK dout1_5 vdout1_5ck68 = 1.7 time = 690
* CHECK dout1_6 vdout1_6ck68 = 1.7 time = 690
* CHECK dout1_7 vdout1_7ck68 = 0 time = 690
* CHECK dout1_8 vdout1_8ck68 = 1.7 time = 690
* CHECK dout1_9 vdout1_9ck68 = 0 time = 690
* CHECK dout1_10 vdout1_10ck68 = 1.7 time = 690
* CHECK dout1_11 vdout1_11ck68 = 0 time = 690
* CHECK dout1_12 vdout1_12ck68 = 1.7 time = 690
* CHECK dout1_13 vdout1_13ck68 = 0 time = 690
* CHECK dout1_14 vdout1_14ck68 = 0 time = 690
* CHECK dout1_15 vdout1_15ck68 = 1.7 time = 690
* CHECK dout1_16 vdout1_16ck68 = 0 time = 690
* CHECK dout1_17 vdout1_17ck68 = 1.7 time = 690
* CHECK dout1_18 vdout1_18ck68 = 0 time = 690
* CHECK dout1_19 vdout1_19ck68 = 1.7 time = 690
* CHECK dout1_20 vdout1_20ck68 = 1.7 time = 690
* CHECK dout1_21 vdout1_21ck68 = 0 time = 690
* CHECK dout1_22 vdout1_22ck68 = 1.7 time = 690
* CHECK dout1_23 vdout1_23ck68 = 1.7 time = 690
* CHECK dout1_24 vdout1_24ck68 = 1.7 time = 690
* CHECK dout1_25 vdout1_25ck68 = 1.7 time = 690
* CHECK dout1_26 vdout1_26ck68 = 1.7 time = 690
* CHECK dout1_27 vdout1_27ck68 = 1.7 time = 690
* CHECK dout1_28 vdout1_28ck68 = 0 time = 690
* CHECK dout1_29 vdout1_29ck68 = 1.7 time = 690
* CHECK dout1_30 vdout1_30ck68 = 1.7 time = 690
* CHECK dout1_31 vdout1_31ck68 = 0 time = 690
* CHECK dout1_32 vdout1_32ck68 = 0 time = 690
* CHECK dout1_0 vdout1_0ck69 = 0 time = 700
* CHECK dout1_1 vdout1_1ck69 = 1.7 time = 700
* CHECK dout1_2 vdout1_2ck69 = 1.7 time = 700
* CHECK dout1_3 vdout1_3ck69 = 0 time = 700
* CHECK dout1_4 vdout1_4ck69 = 0 time = 700
* CHECK dout1_5 vdout1_5ck69 = 1.7 time = 700
* CHECK dout1_6 vdout1_6ck69 = 0 time = 700
* CHECK dout1_7 vdout1_7ck69 = 1.7 time = 700
* CHECK dout1_8 vdout1_8ck69 = 0 time = 700
* CHECK dout1_9 vdout1_9ck69 = 0 time = 700
* CHECK dout1_10 vdout1_10ck69 = 1.7 time = 700
* CHECK dout1_11 vdout1_11ck69 = 0 time = 700
* CHECK dout1_12 vdout1_12ck69 = 1.7 time = 700
* CHECK dout1_13 vdout1_13ck69 = 0 time = 700
* CHECK dout1_14 vdout1_14ck69 = 0 time = 700
* CHECK dout1_15 vdout1_15ck69 = 1.7 time = 700
* CHECK dout1_16 vdout1_16ck69 = 0 time = 700
* CHECK dout1_17 vdout1_17ck69 = 1.7 time = 700
* CHECK dout1_18 vdout1_18ck69 = 0 time = 700
* CHECK dout1_19 vdout1_19ck69 = 0 time = 700
* CHECK dout1_20 vdout1_20ck69 = 0 time = 700
* CHECK dout1_21 vdout1_21ck69 = 1.7 time = 700
* CHECK dout1_22 vdout1_22ck69 = 0 time = 700
* CHECK dout1_23 vdout1_23ck69 = 1.7 time = 700
* CHECK dout1_24 vdout1_24ck69 = 1.7 time = 700
* CHECK dout1_25 vdout1_25ck69 = 1.7 time = 700
* CHECK dout1_26 vdout1_26ck69 = 1.7 time = 700
* CHECK dout1_27 vdout1_27ck69 = 0 time = 700
* CHECK dout1_28 vdout1_28ck69 = 0 time = 700
* CHECK dout1_29 vdout1_29ck69 = 0 time = 700
* CHECK dout1_30 vdout1_30ck69 = 0 time = 700
* CHECK dout1_31 vdout1_31ck69 = 0 time = 700
* CHECK dout1_32 vdout1_32ck69 = 0 time = 700
* CHECK dout1_0 vdout1_0ck74 = 1.7 time = 750
* CHECK dout1_1 vdout1_1ck74 = 0 time = 750
* CHECK dout1_2 vdout1_2ck74 = 1.7 time = 750
* CHECK dout1_3 vdout1_3ck74 = 0 time = 750
* CHECK dout1_4 vdout1_4ck74 = 1.7 time = 750
* CHECK dout1_5 vdout1_5ck74 = 1.7 time = 750
* CHECK dout1_6 vdout1_6ck74 = 1.7 time = 750
* CHECK dout1_7 vdout1_7ck74 = 0 time = 750
* CHECK dout1_8 vdout1_8ck74 = 1.7 time = 750
* CHECK dout1_9 vdout1_9ck74 = 0 time = 750
* CHECK dout1_10 vdout1_10ck74 = 1.7 time = 750
* CHECK dout1_11 vdout1_11ck74 = 0 time = 750
* CHECK dout1_12 vdout1_12ck74 = 1.7 time = 750
* CHECK dout1_13 vdout1_13ck74 = 0 time = 750
* CHECK dout1_14 vdout1_14ck74 = 0 time = 750
* CHECK dout1_15 vdout1_15ck74 = 1.7 time = 750
* CHECK dout1_16 vdout1_16ck74 = 0 time = 750
* CHECK dout1_17 vdout1_17ck74 = 1.7 time = 750
* CHECK dout1_18 vdout1_18ck74 = 0 time = 750
* CHECK dout1_19 vdout1_19ck74 = 1.7 time = 750
* CHECK dout1_20 vdout1_20ck74 = 1.7 time = 750
* CHECK dout1_21 vdout1_21ck74 = 0 time = 750
* CHECK dout1_22 vdout1_22ck74 = 1.7 time = 750
* CHECK dout1_23 vdout1_23ck74 = 1.7 time = 750
* CHECK dout1_24 vdout1_24ck74 = 1.7 time = 750
* CHECK dout1_25 vdout1_25ck74 = 1.7 time = 750
* CHECK dout1_26 vdout1_26ck74 = 1.7 time = 750
* CHECK dout1_27 vdout1_27ck74 = 1.7 time = 750
* CHECK dout1_28 vdout1_28ck74 = 0 time = 750
* CHECK dout1_29 vdout1_29ck74 = 1.7 time = 750
* CHECK dout1_30 vdout1_30ck74 = 1.7 time = 750
* CHECK dout1_31 vdout1_31ck74 = 0 time = 750
* CHECK dout1_32 vdout1_32ck74 = 0 time = 750
* CHECK dout1_0 vdout1_0ck75 = 0 time = 760
* CHECK dout1_1 vdout1_1ck75 = 1.7 time = 760
* CHECK dout1_2 vdout1_2ck75 = 0 time = 760
* CHECK dout1_3 vdout1_3ck75 = 0 time = 760
* CHECK dout1_4 vdout1_4ck75 = 0 time = 760
* CHECK dout1_5 vdout1_5ck75 = 0 time = 760
* CHECK dout1_6 vdout1_6ck75 = 1.7 time = 760
* CHECK dout1_7 vdout1_7ck75 = 0 time = 760
* CHECK dout1_8 vdout1_8ck75 = 0 time = 760
* CHECK dout1_9 vdout1_9ck75 = 0 time = 760
* CHECK dout1_10 vdout1_10ck75 = 1.7 time = 760
* CHECK dout1_11 vdout1_11ck75 = 1.7 time = 760
* CHECK dout1_12 vdout1_12ck75 = 1.7 time = 760
* CHECK dout1_13 vdout1_13ck75 = 0 time = 760
* CHECK dout1_14 vdout1_14ck75 = 1.7 time = 760
* CHECK dout1_15 vdout1_15ck75 = 0 time = 760
* CHECK dout1_16 vdout1_16ck75 = 0 time = 760
* CHECK dout1_17 vdout1_17ck75 = 0 time = 760
* CHECK dout1_18 vdout1_18ck75 = 1.7 time = 760
* CHECK dout1_19 vdout1_19ck75 = 0 time = 760
* CHECK dout1_20 vdout1_20ck75 = 0 time = 760
* CHECK dout1_21 vdout1_21ck75 = 1.7 time = 760
* CHECK dout1_22 vdout1_22ck75 = 0 time = 760
* CHECK dout1_23 vdout1_23ck75 = 1.7 time = 760
* CHECK dout1_24 vdout1_24ck75 = 0 time = 760
* CHECK dout1_25 vdout1_25ck75 = 1.7 time = 760
* CHECK dout1_26 vdout1_26ck75 = 0 time = 760
* CHECK dout1_27 vdout1_27ck75 = 0 time = 760
* CHECK dout1_28 vdout1_28ck75 = 0 time = 760
* CHECK dout1_29 vdout1_29ck75 = 0 time = 760
* CHECK dout1_30 vdout1_30ck75 = 0 time = 760
* CHECK dout1_31 vdout1_31ck75 = 1.7 time = 760
* CHECK dout1_32 vdout1_32ck75 = 0 time = 760
* CHECK dout1_0 vdout1_0ck76 = 1.7 time = 770
* CHECK dout1_1 vdout1_1ck76 = 0 time = 770
* CHECK dout1_2 vdout1_2ck76 = 1.7 time = 770
* CHECK dout1_3 vdout1_3ck76 = 0 time = 770
* CHECK dout1_4 vdout1_4ck76 = 0 time = 770
* CHECK dout1_5 vdout1_5ck76 = 0 time = 770
* CHECK dout1_6 vdout1_6ck76 = 0 time = 770
* CHECK dout1_7 vdout1_7ck76 = 1.7 time = 770
* CHECK dout1_8 vdout1_8ck76 = 0 time = 770
* CHECK dout1_9 vdout1_9ck76 = 1.7 time = 770
* CHECK dout1_10 vdout1_10ck76 = 1.7 time = 770
* CHECK dout1_11 vdout1_11ck76 = 0 time = 770
* CHECK dout1_12 vdout1_12ck76 = 1.7 time = 770
* CHECK dout1_13 vdout1_13ck76 = 1.7 time = 770
* CHECK dout1_14 vdout1_14ck76 = 1.7 time = 770
* CHECK dout1_15 vdout1_15ck76 = 0 time = 770
* CHECK dout1_16 vdout1_16ck76 = 1.7 time = 770
* CHECK dout1_17 vdout1_17ck76 = 0 time = 770
* CHECK dout1_18 vdout1_18ck76 = 0 time = 770
* CHECK dout1_19 vdout1_19ck76 = 0 time = 770
* CHECK dout1_20 vdout1_20ck76 = 1.7 time = 770
* CHECK dout1_21 vdout1_21ck76 = 0 time = 770
* CHECK dout1_22 vdout1_22ck76 = 1.7 time = 770
* CHECK dout1_23 vdout1_23ck76 = 1.7 time = 770
* CHECK dout1_24 vdout1_24ck76 = 0 time = 770
* CHECK dout1_25 vdout1_25ck76 = 0 time = 770
* CHECK dout1_26 vdout1_26ck76 = 1.7 time = 770
* CHECK dout1_27 vdout1_27ck76 = 1.7 time = 770
* CHECK dout1_28 vdout1_28ck76 = 1.7 time = 770
* CHECK dout1_29 vdout1_29ck76 = 0 time = 770
* CHECK dout1_30 vdout1_30ck76 = 0 time = 770
* CHECK dout1_31 vdout1_31ck76 = 1.7 time = 770
* CHECK dout1_32 vdout1_32ck76 = 0 time = 770
* CHECK dout1_0 vdout1_0ck77 = 1.7 time = 780
* CHECK dout1_1 vdout1_1ck77 = 0 time = 780
* CHECK dout1_2 vdout1_2ck77 = 1.7 time = 780
* CHECK dout1_3 vdout1_3ck77 = 0 time = 780
* CHECK dout1_4 vdout1_4ck77 = 1.7 time = 780
* CHECK dout1_5 vdout1_5ck77 = 1.7 time = 780
* CHECK dout1_6 vdout1_6ck77 = 1.7 time = 780
* CHECK dout1_7 vdout1_7ck77 = 0 time = 780
* CHECK dout1_8 vdout1_8ck77 = 1.7 time = 780
* CHECK dout1_9 vdout1_9ck77 = 0 time = 780
* CHECK dout1_10 vdout1_10ck77 = 1.7 time = 780
* CHECK dout1_11 vdout1_11ck77 = 0 time = 780
* CHECK dout1_12 vdout1_12ck77 = 1.7 time = 780
* CHECK dout1_13 vdout1_13ck77 = 0 time = 780
* CHECK dout1_14 vdout1_14ck77 = 0 time = 780
* CHECK dout1_15 vdout1_15ck77 = 1.7 time = 780
* CHECK dout1_16 vdout1_16ck77 = 0 time = 780
* CHECK dout1_17 vdout1_17ck77 = 1.7 time = 780
* CHECK dout1_18 vdout1_18ck77 = 0 time = 780
* CHECK dout1_19 vdout1_19ck77 = 1.7 time = 780
* CHECK dout1_20 vdout1_20ck77 = 1.7 time = 780
* CHECK dout1_21 vdout1_21ck77 = 0 time = 780
* CHECK dout1_22 vdout1_22ck77 = 1.7 time = 780
* CHECK dout1_23 vdout1_23ck77 = 1.7 time = 780
* CHECK dout1_24 vdout1_24ck77 = 1.7 time = 780
* CHECK dout1_25 vdout1_25ck77 = 1.7 time = 780
* CHECK dout1_26 vdout1_26ck77 = 1.7 time = 780
* CHECK dout1_27 vdout1_27ck77 = 1.7 time = 780
* CHECK dout1_28 vdout1_28ck77 = 0 time = 780
* CHECK dout1_29 vdout1_29ck77 = 1.7 time = 780
* CHECK dout1_30 vdout1_30ck77 = 1.7 time = 780
* CHECK dout1_31 vdout1_31ck77 = 0 time = 780
* CHECK dout1_32 vdout1_32ck77 = 0 time = 780
* CHECK dout1_0 vdout1_0ck80 = 1.7 time = 810
* CHECK dout1_1 vdout1_1ck80 = 1.7 time = 810
* CHECK dout1_2 vdout1_2ck80 = 1.7 time = 810
* CHECK dout1_3 vdout1_3ck80 = 0 time = 810
* CHECK dout1_4 vdout1_4ck80 = 0 time = 810
* CHECK dout1_5 vdout1_5ck80 = 1.7 time = 810
* CHECK dout1_6 vdout1_6ck80 = 0 time = 810
* CHECK dout1_7 vdout1_7ck80 = 0 time = 810
* CHECK dout1_8 vdout1_8ck80 = 0 time = 810
* CHECK dout1_9 vdout1_9ck80 = 0 time = 810
* CHECK dout1_10 vdout1_10ck80 = 0 time = 810
* CHECK dout1_11 vdout1_11ck80 = 0 time = 810
* CHECK dout1_12 vdout1_12ck80 = 1.7 time = 810
* CHECK dout1_13 vdout1_13ck80 = 0 time = 810
* CHECK dout1_14 vdout1_14ck80 = 1.7 time = 810
* CHECK dout1_15 vdout1_15ck80 = 0 time = 810
* CHECK dout1_16 vdout1_16ck80 = 0 time = 810
* CHECK dout1_17 vdout1_17ck80 = 1.7 time = 810
* CHECK dout1_18 vdout1_18ck80 = 0 time = 810
* CHECK dout1_19 vdout1_19ck80 = 1.7 time = 810
* CHECK dout1_20 vdout1_20ck80 = 1.7 time = 810
* CHECK dout1_21 vdout1_21ck80 = 1.7 time = 810
* CHECK dout1_22 vdout1_22ck80 = 0 time = 810
* CHECK dout1_23 vdout1_23ck80 = 0 time = 810
* CHECK dout1_24 vdout1_24ck80 = 0 time = 810
* CHECK dout1_25 vdout1_25ck80 = 1.7 time = 810
* CHECK dout1_26 vdout1_26ck80 = 0 time = 810
* CHECK dout1_27 vdout1_27ck80 = 0 time = 810
* CHECK dout1_28 vdout1_28ck80 = 0 time = 810
* CHECK dout1_29 vdout1_29ck80 = 1.7 time = 810
* CHECK dout1_30 vdout1_30ck80 = 0 time = 810
* CHECK dout1_31 vdout1_31ck80 = 1.7 time = 810
* CHECK dout1_32 vdout1_32ck80 = 0 time = 810
* CHECK dout1_0 vdout1_0ck81 = 1.7 time = 820
* CHECK dout1_1 vdout1_1ck81 = 0 time = 820
* CHECK dout1_2 vdout1_2ck81 = 0 time = 820
* CHECK dout1_3 vdout1_3ck81 = 0 time = 820
* CHECK dout1_4 vdout1_4ck81 = 1.7 time = 820
* CHECK dout1_5 vdout1_5ck81 = 1.7 time = 820
* CHECK dout1_6 vdout1_6ck81 = 0 time = 820
* CHECK dout1_7 vdout1_7ck81 = 0 time = 820
* CHECK dout1_8 vdout1_8ck81 = 1.7 time = 820
* CHECK dout1_9 vdout1_9ck81 = 0 time = 820
* CHECK dout1_10 vdout1_10ck81 = 1.7 time = 820
* CHECK dout1_11 vdout1_11ck81 = 0 time = 820
* CHECK dout1_12 vdout1_12ck81 = 1.7 time = 820
* CHECK dout1_13 vdout1_13ck81 = 0 time = 820
* CHECK dout1_14 vdout1_14ck81 = 1.7 time = 820
* CHECK dout1_15 vdout1_15ck81 = 0 time = 820
* CHECK dout1_16 vdout1_16ck81 = 0 time = 820
* CHECK dout1_17 vdout1_17ck81 = 0 time = 820
* CHECK dout1_18 vdout1_18ck81 = 1.7 time = 820
* CHECK dout1_19 vdout1_19ck81 = 0 time = 820
* CHECK dout1_20 vdout1_20ck81 = 1.7 time = 820
* CHECK dout1_21 vdout1_21ck81 = 1.7 time = 820
* CHECK dout1_22 vdout1_22ck81 = 1.7 time = 820
* CHECK dout1_23 vdout1_23ck81 = 0 time = 820
* CHECK dout1_24 vdout1_24ck81 = 0 time = 820
* CHECK dout1_25 vdout1_25ck81 = 0 time = 820
* CHECK dout1_26 vdout1_26ck81 = 0 time = 820
* CHECK dout1_27 vdout1_27ck81 = 0 time = 820
* CHECK dout1_28 vdout1_28ck81 = 0 time = 820
* CHECK dout1_29 vdout1_29ck81 = 0 time = 820
* CHECK dout1_30 vdout1_30ck81 = 1.7 time = 820
* CHECK dout1_31 vdout1_31ck81 = 0 time = 820
* CHECK dout1_32 vdout1_32ck81 = 0 time = 820
* CHECK dout1_0 vdout1_0ck82 = 0 time = 830
* CHECK dout1_1 vdout1_1ck82 = 0 time = 830
* CHECK dout1_2 vdout1_2ck82 = 1.7 time = 830
* CHECK dout1_3 vdout1_3ck82 = 0 time = 830
* CHECK dout1_4 vdout1_4ck82 = 1.7 time = 830
* CHECK dout1_5 vdout1_5ck82 = 0 time = 830
* CHECK dout1_6 vdout1_6ck82 = 1.7 time = 830
* CHECK dout1_7 vdout1_7ck82 = 1.7 time = 830
* CHECK dout1_8 vdout1_8ck82 = 0 time = 830
* CHECK dout1_9 vdout1_9ck82 = 0 time = 830
* CHECK dout1_10 vdout1_10ck82 = 1.7 time = 830
* CHECK dout1_11 vdout1_11ck82 = 1.7 time = 830
* CHECK dout1_12 vdout1_12ck82 = 0 time = 830
* CHECK dout1_13 vdout1_13ck82 = 0 time = 830
* CHECK dout1_14 vdout1_14ck82 = 1.7 time = 830
* CHECK dout1_15 vdout1_15ck82 = 0 time = 830
* CHECK dout1_16 vdout1_16ck82 = 0 time = 830
* CHECK dout1_17 vdout1_17ck82 = 1.7 time = 830
* CHECK dout1_18 vdout1_18ck82 = 0 time = 830
* CHECK dout1_19 vdout1_19ck82 = 1.7 time = 830
* CHECK dout1_20 vdout1_20ck82 = 1.7 time = 830
* CHECK dout1_21 vdout1_21ck82 = 0 time = 830
* CHECK dout1_22 vdout1_22ck82 = 1.7 time = 830
* CHECK dout1_23 vdout1_23ck82 = 1.7 time = 830
* CHECK dout1_24 vdout1_24ck82 = 1.7 time = 830
* CHECK dout1_25 vdout1_25ck82 = 1.7 time = 830
* CHECK dout1_26 vdout1_26ck82 = 1.7 time = 830
* CHECK dout1_27 vdout1_27ck82 = 0 time = 830
* CHECK dout1_28 vdout1_28ck82 = 1.7 time = 830
* CHECK dout1_29 vdout1_29ck82 = 1.7 time = 830
* CHECK dout1_30 vdout1_30ck82 = 0 time = 830
* CHECK dout1_31 vdout1_31ck82 = 1.7 time = 830
* CHECK dout1_32 vdout1_32ck82 = 0 time = 830
* CHECK dout1_0 vdout1_0ck86 = 0 time = 870
* CHECK dout1_1 vdout1_1ck86 = 0 time = 870
* CHECK dout1_2 vdout1_2ck86 = 1.7 time = 870
* CHECK dout1_3 vdout1_3ck86 = 0 time = 870
* CHECK dout1_4 vdout1_4ck86 = 0 time = 870
* CHECK dout1_5 vdout1_5ck86 = 0 time = 870
* CHECK dout1_6 vdout1_6ck86 = 0 time = 870
* CHECK dout1_7 vdout1_7ck86 = 0 time = 870
* CHECK dout1_8 vdout1_8ck86 = 1.7 time = 870
* CHECK dout1_9 vdout1_9ck86 = 1.7 time = 870
* CHECK dout1_10 vdout1_10ck86 = 1.7 time = 870
* CHECK dout1_11 vdout1_11ck86 = 1.7 time = 870
* CHECK dout1_12 vdout1_12ck86 = 1.7 time = 870
* CHECK dout1_13 vdout1_13ck86 = 0 time = 870
* CHECK dout1_14 vdout1_14ck86 = 1.7 time = 870
* CHECK dout1_15 vdout1_15ck86 = 0 time = 870
* CHECK dout1_16 vdout1_16ck86 = 1.7 time = 870
* CHECK dout1_17 vdout1_17ck86 = 1.7 time = 870
* CHECK dout1_18 vdout1_18ck86 = 0 time = 870
* CHECK dout1_19 vdout1_19ck86 = 1.7 time = 870
* CHECK dout1_20 vdout1_20ck86 = 1.7 time = 870
* CHECK dout1_21 vdout1_21ck86 = 1.7 time = 870
* CHECK dout1_22 vdout1_22ck86 = 0 time = 870
* CHECK dout1_23 vdout1_23ck86 = 0 time = 870
* CHECK dout1_24 vdout1_24ck86 = 1.7 time = 870
* CHECK dout1_25 vdout1_25ck86 = 0 time = 870
* CHECK dout1_26 vdout1_26ck86 = 1.7 time = 870
* CHECK dout1_27 vdout1_27ck86 = 0 time = 870
* CHECK dout1_28 vdout1_28ck86 = 0 time = 870
* CHECK dout1_29 vdout1_29ck86 = 1.7 time = 870
* CHECK dout1_30 vdout1_30ck86 = 0 time = 870
* CHECK dout1_31 vdout1_31ck86 = 1.7 time = 870
* CHECK dout1_32 vdout1_32ck86 = 0 time = 870
* CHECK dout1_0 vdout1_0ck87 = 0 time = 880
* CHECK dout1_1 vdout1_1ck87 = 1.7 time = 880
* CHECK dout1_2 vdout1_2ck87 = 1.7 time = 880
* CHECK dout1_3 vdout1_3ck87 = 0 time = 880
* CHECK dout1_4 vdout1_4ck87 = 1.7 time = 880
* CHECK dout1_5 vdout1_5ck87 = 0 time = 880
* CHECK dout1_6 vdout1_6ck87 = 0 time = 880
* CHECK dout1_7 vdout1_7ck87 = 0 time = 880
* CHECK dout1_8 vdout1_8ck87 = 1.7 time = 880
* CHECK dout1_9 vdout1_9ck87 = 0 time = 880
* CHECK dout1_10 vdout1_10ck87 = 1.7 time = 880
* CHECK dout1_11 vdout1_11ck87 = 1.7 time = 880
* CHECK dout1_12 vdout1_12ck87 = 0 time = 880
* CHECK dout1_13 vdout1_13ck87 = 0 time = 880
* CHECK dout1_14 vdout1_14ck87 = 1.7 time = 880
* CHECK dout1_15 vdout1_15ck87 = 0 time = 880
* CHECK dout1_16 vdout1_16ck87 = 1.7 time = 880
* CHECK dout1_17 vdout1_17ck87 = 0 time = 880
* CHECK dout1_18 vdout1_18ck87 = 1.7 time = 880
* CHECK dout1_19 vdout1_19ck87 = 1.7 time = 880
* CHECK dout1_20 vdout1_20ck87 = 1.7 time = 880
* CHECK dout1_21 vdout1_21ck87 = 0 time = 880
* CHECK dout1_22 vdout1_22ck87 = 1.7 time = 880
* CHECK dout1_23 vdout1_23ck87 = 1.7 time = 880
* CHECK dout1_24 vdout1_24ck87 = 0 time = 880
* CHECK dout1_25 vdout1_25ck87 = 1.7 time = 880
* CHECK dout1_26 vdout1_26ck87 = 0 time = 880
* CHECK dout1_27 vdout1_27ck87 = 1.7 time = 880
* CHECK dout1_28 vdout1_28ck87 = 0 time = 880
* CHECK dout1_29 vdout1_29ck87 = 0 time = 880
* CHECK dout1_30 vdout1_30ck87 = 1.7 time = 880
* CHECK dout1_31 vdout1_31ck87 = 1.7 time = 880
* CHECK dout1_32 vdout1_32ck87 = 0 time = 880
* CHECK dout1_0 vdout1_0ck91 = 1.7 time = 920
* CHECK dout1_1 vdout1_1ck91 = 1.7 time = 920
* CHECK dout1_2 vdout1_2ck91 = 1.7 time = 920
* CHECK dout1_3 vdout1_3ck91 = 0 time = 920
* CHECK dout1_4 vdout1_4ck91 = 1.7 time = 920
* CHECK dout1_5 vdout1_5ck91 = 1.7 time = 920
* CHECK dout1_6 vdout1_6ck91 = 1.7 time = 920
* CHECK dout1_7 vdout1_7ck91 = 1.7 time = 920
* CHECK dout1_8 vdout1_8ck91 = 1.7 time = 920
* CHECK dout1_9 vdout1_9ck91 = 0 time = 920
* CHECK dout1_10 vdout1_10ck91 = 1.7 time = 920
* CHECK dout1_11 vdout1_11ck91 = 0 time = 920
* CHECK dout1_12 vdout1_12ck91 = 1.7 time = 920
* CHECK dout1_13 vdout1_13ck91 = 1.7 time = 920
* CHECK dout1_14 vdout1_14ck91 = 1.7 time = 920
* CHECK dout1_15 vdout1_15ck91 = 1.7 time = 920
* CHECK dout1_16 vdout1_16ck91 = 1.7 time = 920
* CHECK dout1_17 vdout1_17ck91 = 0 time = 920
* CHECK dout1_18 vdout1_18ck91 = 0 time = 920
* CHECK dout1_19 vdout1_19ck91 = 0 time = 920
* CHECK dout1_20 vdout1_20ck91 = 0 time = 920
* CHECK dout1_21 vdout1_21ck91 = 1.7 time = 920
* CHECK dout1_22 vdout1_22ck91 = 1.7 time = 920
* CHECK dout1_23 vdout1_23ck91 = 1.7 time = 920
* CHECK dout1_24 vdout1_24ck91 = 0 time = 920
* CHECK dout1_25 vdout1_25ck91 = 0 time = 920
* CHECK dout1_26 vdout1_26ck91 = 0 time = 920
* CHECK dout1_27 vdout1_27ck91 = 0 time = 920
* CHECK dout1_28 vdout1_28ck91 = 0 time = 920
* CHECK dout1_29 vdout1_29ck91 = 1.7 time = 920
* CHECK dout1_30 vdout1_30ck91 = 0 time = 920
* CHECK dout1_31 vdout1_31ck91 = 1.7 time = 920
* CHECK dout1_32 vdout1_32ck91 = 0 time = 920
* CHECK dout1_0 vdout1_0ck94 = 0 time = 950
* CHECK dout1_1 vdout1_1ck94 = 0 time = 950
* CHECK dout1_2 vdout1_2ck94 = 0 time = 950
* CHECK dout1_3 vdout1_3ck94 = 0 time = 950
* CHECK dout1_4 vdout1_4ck94 = 1.7 time = 950
* CHECK dout1_5 vdout1_5ck94 = 0 time = 950
* CHECK dout1_6 vdout1_6ck94 = 0 time = 950
* CHECK dout1_7 vdout1_7ck94 = 1.7 time = 950
* CHECK dout1_8 vdout1_8ck94 = 0 time = 950
* CHECK dout1_9 vdout1_9ck94 = 0 time = 950
* CHECK dout1_10 vdout1_10ck94 = 0 time = 950
* CHECK dout1_11 vdout1_11ck94 = 1.7 time = 950
* CHECK dout1_12 vdout1_12ck94 = 0 time = 950
* CHECK dout1_13 vdout1_13ck94 = 1.7 time = 950
* CHECK dout1_14 vdout1_14ck94 = 0 time = 950
* CHECK dout1_15 vdout1_15ck94 = 0 time = 950
* CHECK dout1_16 vdout1_16ck94 = 1.7 time = 950
* CHECK dout1_17 vdout1_17ck94 = 0 time = 950
* CHECK dout1_18 vdout1_18ck94 = 0 time = 950
* CHECK dout1_19 vdout1_19ck94 = 0 time = 950
* CHECK dout1_20 vdout1_20ck94 = 1.7 time = 950
* CHECK dout1_21 vdout1_21ck94 = 0 time = 950
* CHECK dout1_22 vdout1_22ck94 = 1.7 time = 950
* CHECK dout1_23 vdout1_23ck94 = 0 time = 950
* CHECK dout1_24 vdout1_24ck94 = 0 time = 950
* CHECK dout1_25 vdout1_25ck94 = 0 time = 950
* CHECK dout1_26 vdout1_26ck94 = 1.7 time = 950
* CHECK dout1_27 vdout1_27ck94 = 0 time = 950
* CHECK dout1_28 vdout1_28ck94 = 1.7 time = 950
* CHECK dout1_29 vdout1_29ck94 = 1.7 time = 950
* CHECK dout1_30 vdout1_30ck94 = 0 time = 950
* CHECK dout1_31 vdout1_31ck94 = 0 time = 950
* CHECK dout1_32 vdout1_32ck94 = 0 time = 950
* CHECK dout1_0 vdout1_0ck95 = 0 time = 960
* CHECK dout1_1 vdout1_1ck95 = 1.7 time = 960
* CHECK dout1_2 vdout1_2ck95 = 0 time = 960
* CHECK dout1_3 vdout1_3ck95 = 0 time = 960
* CHECK dout1_4 vdout1_4ck95 = 0 time = 960
* CHECK dout1_5 vdout1_5ck95 = 0 time = 960
* CHECK dout1_6 vdout1_6ck95 = 1.7 time = 960
* CHECK dout1_7 vdout1_7ck95 = 1.7 time = 960
* CHECK dout1_8 vdout1_8ck95 = 1.7 time = 960
* CHECK dout1_9 vdout1_9ck95 = 1.7 time = 960
* CHECK dout1_10 vdout1_10ck95 = 0 time = 960
* CHECK dout1_11 vdout1_11ck95 = 0 time = 960
* CHECK dout1_12 vdout1_12ck95 = 1.7 time = 960
* CHECK dout1_13 vdout1_13ck95 = 0 time = 960
* CHECK dout1_14 vdout1_14ck95 = 0 time = 960
* CHECK dout1_15 vdout1_15ck95 = 1.7 time = 960
* CHECK dout1_16 vdout1_16ck95 = 0 time = 960
* CHECK dout1_17 vdout1_17ck95 = 0 time = 960
* CHECK dout1_18 vdout1_18ck95 = 1.7 time = 960
* CHECK dout1_19 vdout1_19ck95 = 0 time = 960
* CHECK dout1_20 vdout1_20ck95 = 1.7 time = 960
* CHECK dout1_21 vdout1_21ck95 = 0 time = 960
* CHECK dout1_22 vdout1_22ck95 = 0 time = 960
* CHECK dout1_23 vdout1_23ck95 = 0 time = 960
* CHECK dout1_24 vdout1_24ck95 = 0 time = 960
* CHECK dout1_25 vdout1_25ck95 = 1.7 time = 960
* CHECK dout1_26 vdout1_26ck95 = 1.7 time = 960
* CHECK dout1_27 vdout1_27ck95 = 0 time = 960
* CHECK dout1_28 vdout1_28ck95 = 0 time = 960
* CHECK dout1_29 vdout1_29ck95 = 1.7 time = 960
* CHECK dout1_30 vdout1_30ck95 = 1.7 time = 960
* CHECK dout1_31 vdout1_31ck95 = 0 time = 960
* CHECK dout1_32 vdout1_32ck95 = 0 time = 960
* CHECK dout1_0 vdout1_0ck98 = 1.7 time = 990
* CHECK dout1_1 vdout1_1ck98 = 1.7 time = 990
* CHECK dout1_2 vdout1_2ck98 = 1.7 time = 990
* CHECK dout1_3 vdout1_3ck98 = 1.7 time = 990
* CHECK dout1_4 vdout1_4ck98 = 0 time = 990
* CHECK dout1_5 vdout1_5ck98 = 1.7 time = 990
* CHECK dout1_6 vdout1_6ck98 = 1.7 time = 990
* CHECK dout1_7 vdout1_7ck98 = 0 time = 990
* CHECK dout1_8 vdout1_8ck98 = 0 time = 990
* CHECK dout1_9 vdout1_9ck98 = 0 time = 990
* CHECK dout1_10 vdout1_10ck98 = 0 time = 990
* CHECK dout1_11 vdout1_11ck98 = 1.7 time = 990
* CHECK dout1_12 vdout1_12ck98 = 1.7 time = 990
* CHECK dout1_13 vdout1_13ck98 = 0 time = 990
* CHECK dout1_14 vdout1_14ck98 = 0 time = 990
* CHECK dout1_15 vdout1_15ck98 = 1.7 time = 990
* CHECK dout1_16 vdout1_16ck98 = 1.7 time = 990
* CHECK dout1_17 vdout1_17ck98 = 0 time = 990
* CHECK dout1_18 vdout1_18ck98 = 0 time = 990
* CHECK dout1_19 vdout1_19ck98 = 0 time = 990
* CHECK dout1_20 vdout1_20ck98 = 0 time = 990
* CHECK dout1_21 vdout1_21ck98 = 0 time = 990
* CHECK dout1_22 vdout1_22ck98 = 0 time = 990
* CHECK dout1_23 vdout1_23ck98 = 0 time = 990
* CHECK dout1_24 vdout1_24ck98 = 0 time = 990
* CHECK dout1_25 vdout1_25ck98 = 0 time = 990
* CHECK dout1_26 vdout1_26ck98 = 0 time = 990
* CHECK dout1_27 vdout1_27ck98 = 0 time = 990
* CHECK dout1_28 vdout1_28ck98 = 1.7 time = 990
* CHECK dout1_29 vdout1_29ck98 = 0 time = 990
* CHECK dout1_30 vdout1_30ck98 = 1.7 time = 990
* CHECK dout1_31 vdout1_31ck98 = 1.7 time = 990
* CHECK dout1_32 vdout1_32ck98 = 0 time = 990
* CHECK dout1_0 vdout1_0ck99 = 1.7 time = 1000
* CHECK dout1_1 vdout1_1ck99 = 1.7 time = 1000
* CHECK dout1_2 vdout1_2ck99 = 1.7 time = 1000
* CHECK dout1_3 vdout1_3ck99 = 0 time = 1000
* CHECK dout1_4 vdout1_4ck99 = 1.7 time = 1000
* CHECK dout1_5 vdout1_5ck99 = 1.7 time = 1000
* CHECK dout1_6 vdout1_6ck99 = 0 time = 1000
* CHECK dout1_7 vdout1_7ck99 = 0 time = 1000
* CHECK dout1_8 vdout1_8ck99 = 0 time = 1000
* CHECK dout1_9 vdout1_9ck99 = 1.7 time = 1000
* CHECK dout1_10 vdout1_10ck99 = 1.7 time = 1000
* CHECK dout1_11 vdout1_11ck99 = 0 time = 1000
* CHECK dout1_12 vdout1_12ck99 = 0 time = 1000
* CHECK dout1_13 vdout1_13ck99 = 0 time = 1000
* CHECK dout1_14 vdout1_14ck99 = 1.7 time = 1000
* CHECK dout1_15 vdout1_15ck99 = 0 time = 1000
* CHECK dout1_16 vdout1_16ck99 = 1.7 time = 1000
* CHECK dout1_17 vdout1_17ck99 = 1.7 time = 1000
* CHECK dout1_18 vdout1_18ck99 = 1.7 time = 1000
* CHECK dout1_19 vdout1_19ck99 = 1.7 time = 1000
* CHECK dout1_20 vdout1_20ck99 = 1.7 time = 1000
* CHECK dout1_21 vdout1_21ck99 = 1.7 time = 1000
* CHECK dout1_22 vdout1_22ck99 = 0 time = 1000
* CHECK dout1_23 vdout1_23ck99 = 1.7 time = 1000
* CHECK dout1_24 vdout1_24ck99 = 1.7 time = 1000
* CHECK dout1_25 vdout1_25ck99 = 0 time = 1000
* CHECK dout1_26 vdout1_26ck99 = 0 time = 1000
* CHECK dout1_27 vdout1_27ck99 = 1.7 time = 1000
* CHECK dout1_28 vdout1_28ck99 = 1.7 time = 1000
* CHECK dout1_29 vdout1_29ck99 = 0 time = 1000
* CHECK dout1_30 vdout1_30ck99 = 1.7 time = 1000
* CHECK dout1_31 vdout1_31ck99 = 0 time = 1000
* CHECK dout1_32 vdout1_32ck99 = 0 time = 1000
* CHECK dout1_0 vdout1_0ck103 = 0 time = 1040
* CHECK dout1_1 vdout1_1ck103 = 0 time = 1040
* CHECK dout1_2 vdout1_2ck103 = 1.7 time = 1040
* CHECK dout1_3 vdout1_3ck103 = 1.7 time = 1040
* CHECK dout1_4 vdout1_4ck103 = 1.7 time = 1040
* CHECK dout1_5 vdout1_5ck103 = 1.7 time = 1040
* CHECK dout1_6 vdout1_6ck103 = 0 time = 1040
* CHECK dout1_7 vdout1_7ck103 = 1.7 time = 1040
* CHECK dout1_8 vdout1_8ck103 = 0 time = 1040
* CHECK dout1_9 vdout1_9ck103 = 0 time = 1040
* CHECK dout1_10 vdout1_10ck103 = 0 time = 1040
* CHECK dout1_11 vdout1_11ck103 = 1.7 time = 1040
* CHECK dout1_12 vdout1_12ck103 = 1.7 time = 1040
* CHECK dout1_13 vdout1_13ck103 = 0 time = 1040
* CHECK dout1_14 vdout1_14ck103 = 0 time = 1040
* CHECK dout1_15 vdout1_15ck103 = 1.7 time = 1040
* CHECK dout1_16 vdout1_16ck103 = 1.7 time = 1040
* CHECK dout1_17 vdout1_17ck103 = 1.7 time = 1040
* CHECK dout1_18 vdout1_18ck103 = 1.7 time = 1040
* CHECK dout1_19 vdout1_19ck103 = 1.7 time = 1040
* CHECK dout1_20 vdout1_20ck103 = 1.7 time = 1040
* CHECK dout1_21 vdout1_21ck103 = 1.7 time = 1040
* CHECK dout1_22 vdout1_22ck103 = 0 time = 1040
* CHECK dout1_23 vdout1_23ck103 = 0 time = 1040
* CHECK dout1_24 vdout1_24ck103 = 1.7 time = 1040
* CHECK dout1_25 vdout1_25ck103 = 0 time = 1040
* CHECK dout1_26 vdout1_26ck103 = 1.7 time = 1040
* CHECK dout1_27 vdout1_27ck103 = 0 time = 1040
* CHECK dout1_28 vdout1_28ck103 = 1.7 time = 1040
* CHECK dout1_29 vdout1_29ck103 = 0 time = 1040
* CHECK dout1_30 vdout1_30ck103 = 0 time = 1040
* CHECK dout1_31 vdout1_31ck103 = 1.7 time = 1040
* CHECK dout1_32 vdout1_32ck103 = 0 time = 1040
* CHECK dout1_0 vdout1_0ck106 = 0 time = 1070
* CHECK dout1_1 vdout1_1ck106 = 0 time = 1070
* CHECK dout1_2 vdout1_2ck106 = 1.7 time = 1070
* CHECK dout1_3 vdout1_3ck106 = 1.7 time = 1070
* CHECK dout1_4 vdout1_4ck106 = 1.7 time = 1070
* CHECK dout1_5 vdout1_5ck106 = 1.7 time = 1070
* CHECK dout1_6 vdout1_6ck106 = 0 time = 1070
* CHECK dout1_7 vdout1_7ck106 = 1.7 time = 1070
* CHECK dout1_8 vdout1_8ck106 = 0 time = 1070
* CHECK dout1_9 vdout1_9ck106 = 0 time = 1070
* CHECK dout1_10 vdout1_10ck106 = 0 time = 1070
* CHECK dout1_11 vdout1_11ck106 = 1.7 time = 1070
* CHECK dout1_12 vdout1_12ck106 = 1.7 time = 1070
* CHECK dout1_13 vdout1_13ck106 = 0 time = 1070
* CHECK dout1_14 vdout1_14ck106 = 0 time = 1070
* CHECK dout1_15 vdout1_15ck106 = 1.7 time = 1070
* CHECK dout1_16 vdout1_16ck106 = 1.7 time = 1070
* CHECK dout1_17 vdout1_17ck106 = 1.7 time = 1070
* CHECK dout1_18 vdout1_18ck106 = 1.7 time = 1070
* CHECK dout1_19 vdout1_19ck106 = 1.7 time = 1070
* CHECK dout1_20 vdout1_20ck106 = 1.7 time = 1070
* CHECK dout1_21 vdout1_21ck106 = 1.7 time = 1070
* CHECK dout1_22 vdout1_22ck106 = 0 time = 1070
* CHECK dout1_23 vdout1_23ck106 = 0 time = 1070
* CHECK dout1_24 vdout1_24ck106 = 1.7 time = 1070
* CHECK dout1_25 vdout1_25ck106 = 0 time = 1070
* CHECK dout1_26 vdout1_26ck106 = 1.7 time = 1070
* CHECK dout1_27 vdout1_27ck106 = 0 time = 1070
* CHECK dout1_28 vdout1_28ck106 = 1.7 time = 1070
* CHECK dout1_29 vdout1_29ck106 = 0 time = 1070
* CHECK dout1_30 vdout1_30ck106 = 0 time = 1070
* CHECK dout1_31 vdout1_31ck106 = 1.7 time = 1070
* CHECK dout1_32 vdout1_32ck106 = 0 time = 1070
* CHECK dout1_0 vdout1_0ck107 = 0 time = 1080
* CHECK dout1_1 vdout1_1ck107 = 0 time = 1080
* CHECK dout1_2 vdout1_2ck107 = 1.7 time = 1080
* CHECK dout1_3 vdout1_3ck107 = 0 time = 1080
* CHECK dout1_4 vdout1_4ck107 = 0 time = 1080
* CHECK dout1_5 vdout1_5ck107 = 1.7 time = 1080
* CHECK dout1_6 vdout1_6ck107 = 1.7 time = 1080
* CHECK dout1_7 vdout1_7ck107 = 0 time = 1080
* CHECK dout1_8 vdout1_8ck107 = 1.7 time = 1080
* CHECK dout1_9 vdout1_9ck107 = 0 time = 1080
* CHECK dout1_10 vdout1_10ck107 = 0 time = 1080
* CHECK dout1_11 vdout1_11ck107 = 1.7 time = 1080
* CHECK dout1_12 vdout1_12ck107 = 0 time = 1080
* CHECK dout1_13 vdout1_13ck107 = 1.7 time = 1080
* CHECK dout1_14 vdout1_14ck107 = 1.7 time = 1080
* CHECK dout1_15 vdout1_15ck107 = 1.7 time = 1080
* CHECK dout1_16 vdout1_16ck107 = 0 time = 1080
* CHECK dout1_17 vdout1_17ck107 = 0 time = 1080
* CHECK dout1_18 vdout1_18ck107 = 0 time = 1080
* CHECK dout1_19 vdout1_19ck107 = 1.7 time = 1080
* CHECK dout1_20 vdout1_20ck107 = 1.7 time = 1080
* CHECK dout1_21 vdout1_21ck107 = 0 time = 1080
* CHECK dout1_22 vdout1_22ck107 = 0 time = 1080
* CHECK dout1_23 vdout1_23ck107 = 1.7 time = 1080
* CHECK dout1_24 vdout1_24ck107 = 1.7 time = 1080
* CHECK dout1_25 vdout1_25ck107 = 0 time = 1080
* CHECK dout1_26 vdout1_26ck107 = 0 time = 1080
* CHECK dout1_27 vdout1_27ck107 = 1.7 time = 1080
* CHECK dout1_28 vdout1_28ck107 = 1.7 time = 1080
* CHECK dout1_29 vdout1_29ck107 = 0 time = 1080
* CHECK dout1_30 vdout1_30ck107 = 1.7 time = 1080
* CHECK dout1_31 vdout1_31ck107 = 1.7 time = 1080
* CHECK dout1_32 vdout1_32ck107 = 0 time = 1080
* CHECK dout1_0 vdout1_0ck112 = 0 time = 1130
* CHECK dout1_1 vdout1_1ck112 = 0 time = 1130
* CHECK dout1_2 vdout1_2ck112 = 1.7 time = 1130
* CHECK dout1_3 vdout1_3ck112 = 0 time = 1130
* CHECK dout1_4 vdout1_4ck112 = 0 time = 1130
* CHECK dout1_5 vdout1_5ck112 = 1.7 time = 1130
* CHECK dout1_6 vdout1_6ck112 = 0 time = 1130
* CHECK dout1_7 vdout1_7ck112 = 1.7 time = 1130
* CHECK dout1_8 vdout1_8ck112 = 1.7 time = 1130
* CHECK dout1_9 vdout1_9ck112 = 0 time = 1130
* CHECK dout1_10 vdout1_10ck112 = 0 time = 1130
* CHECK dout1_11 vdout1_11ck112 = 1.7 time = 1130
* CHECK dout1_12 vdout1_12ck112 = 1.7 time = 1130
* CHECK dout1_13 vdout1_13ck112 = 1.7 time = 1130
* CHECK dout1_14 vdout1_14ck112 = 0 time = 1130
* CHECK dout1_15 vdout1_15ck112 = 1.7 time = 1130
* CHECK dout1_16 vdout1_16ck112 = 1.7 time = 1130
* CHECK dout1_17 vdout1_17ck112 = 0 time = 1130
* CHECK dout1_18 vdout1_18ck112 = 1.7 time = 1130
* CHECK dout1_19 vdout1_19ck112 = 0 time = 1130
* CHECK dout1_20 vdout1_20ck112 = 0 time = 1130
* CHECK dout1_21 vdout1_21ck112 = 1.7 time = 1130
* CHECK dout1_22 vdout1_22ck112 = 0 time = 1130
* CHECK dout1_23 vdout1_23ck112 = 1.7 time = 1130
* CHECK dout1_24 vdout1_24ck112 = 0 time = 1130
* CHECK dout1_25 vdout1_25ck112 = 1.7 time = 1130
* CHECK dout1_26 vdout1_26ck112 = 0 time = 1130
* CHECK dout1_27 vdout1_27ck112 = 1.7 time = 1130
* CHECK dout1_28 vdout1_28ck112 = 0 time = 1130
* CHECK dout1_29 vdout1_29ck112 = 0 time = 1130
* CHECK dout1_30 vdout1_30ck112 = 1.7 time = 1130
* CHECK dout1_31 vdout1_31ck112 = 1.7 time = 1130
* CHECK dout1_32 vdout1_32ck112 = 0 time = 1130
* CHECK dout1_0 vdout1_0ck114 = 0 time = 1150
* CHECK dout1_1 vdout1_1ck114 = 0 time = 1150
* CHECK dout1_2 vdout1_2ck114 = 1.7 time = 1150
* CHECK dout1_3 vdout1_3ck114 = 0 time = 1150
* CHECK dout1_4 vdout1_4ck114 = 1.7 time = 1150
* CHECK dout1_5 vdout1_5ck114 = 1.7 time = 1150
* CHECK dout1_6 vdout1_6ck114 = 0 time = 1150
* CHECK dout1_7 vdout1_7ck114 = 1.7 time = 1150
* CHECK dout1_8 vdout1_8ck114 = 0 time = 1150
* CHECK dout1_9 vdout1_9ck114 = 1.7 time = 1150
* CHECK dout1_10 vdout1_10ck114 = 0 time = 1150
* CHECK dout1_11 vdout1_11ck114 = 0 time = 1150
* CHECK dout1_12 vdout1_12ck114 = 0 time = 1150
* CHECK dout1_13 vdout1_13ck114 = 1.7 time = 1150
* CHECK dout1_14 vdout1_14ck114 = 1.7 time = 1150
* CHECK dout1_15 vdout1_15ck114 = 0 time = 1150
* CHECK dout1_16 vdout1_16ck114 = 0 time = 1150
* CHECK dout1_17 vdout1_17ck114 = 0 time = 1150
* CHECK dout1_18 vdout1_18ck114 = 0 time = 1150
* CHECK dout1_19 vdout1_19ck114 = 1.7 time = 1150
* CHECK dout1_20 vdout1_20ck114 = 0 time = 1150
* CHECK dout1_21 vdout1_21ck114 = 1.7 time = 1150
* CHECK dout1_22 vdout1_22ck114 = 0 time = 1150
* CHECK dout1_23 vdout1_23ck114 = 1.7 time = 1150
* CHECK dout1_24 vdout1_24ck114 = 0 time = 1150
* CHECK dout1_25 vdout1_25ck114 = 0 time = 1150
* CHECK dout1_26 vdout1_26ck114 = 1.7 time = 1150
* CHECK dout1_27 vdout1_27ck114 = 0 time = 1150
* CHECK dout1_28 vdout1_28ck114 = 1.7 time = 1150
* CHECK dout1_29 vdout1_29ck114 = 0 time = 1150
* CHECK dout1_30 vdout1_30ck114 = 1.7 time = 1150
* CHECK dout1_31 vdout1_31ck114 = 1.7 time = 1150
* CHECK dout1_32 vdout1_32ck114 = 0 time = 1150
* CHECK dout1_0 vdout1_0ck115 = 1.7 time = 1160
* CHECK dout1_1 vdout1_1ck115 = 0 time = 1160
* CHECK dout1_2 vdout1_2ck115 = 1.7 time = 1160
* CHECK dout1_3 vdout1_3ck115 = 1.7 time = 1160
* CHECK dout1_4 vdout1_4ck115 = 1.7 time = 1160
* CHECK dout1_5 vdout1_5ck115 = 0 time = 1160
* CHECK dout1_6 vdout1_6ck115 = 1.7 time = 1160
* CHECK dout1_7 vdout1_7ck115 = 0 time = 1160
* CHECK dout1_8 vdout1_8ck115 = 1.7 time = 1160
* CHECK dout1_9 vdout1_9ck115 = 1.7 time = 1160
* CHECK dout1_10 vdout1_10ck115 = 0 time = 1160
* CHECK dout1_11 vdout1_11ck115 = 0 time = 1160
* CHECK dout1_12 vdout1_12ck115 = 1.7 time = 1160
* CHECK dout1_13 vdout1_13ck115 = 0 time = 1160
* CHECK dout1_14 vdout1_14ck115 = 1.7 time = 1160
* CHECK dout1_15 vdout1_15ck115 = 0 time = 1160
* CHECK dout1_16 vdout1_16ck115 = 1.7 time = 1160
* CHECK dout1_17 vdout1_17ck115 = 1.7 time = 1160
* CHECK dout1_18 vdout1_18ck115 = 1.7 time = 1160
* CHECK dout1_19 vdout1_19ck115 = 0 time = 1160
* CHECK dout1_20 vdout1_20ck115 = 0 time = 1160
* CHECK dout1_21 vdout1_21ck115 = 0 time = 1160
* CHECK dout1_22 vdout1_22ck115 = 0 time = 1160
* CHECK dout1_23 vdout1_23ck115 = 1.7 time = 1160
* CHECK dout1_24 vdout1_24ck115 = 0 time = 1160
* CHECK dout1_25 vdout1_25ck115 = 1.7 time = 1160
* CHECK dout1_26 vdout1_26ck115 = 1.7 time = 1160
* CHECK dout1_27 vdout1_27ck115 = 1.7 time = 1160
* CHECK dout1_28 vdout1_28ck115 = 1.7 time = 1160
* CHECK dout1_29 vdout1_29ck115 = 1.7 time = 1160
* CHECK dout1_30 vdout1_30ck115 = 0 time = 1160
* CHECK dout1_31 vdout1_31ck115 = 0 time = 1160
* CHECK dout1_32 vdout1_32ck115 = 0 time = 1160
* CHECK dout1_0 vdout1_0ck116 = 1.7 time = 1170
* CHECK dout1_1 vdout1_1ck116 = 1.7 time = 1170
* CHECK dout1_2 vdout1_2ck116 = 0 time = 1170
* CHECK dout1_3 vdout1_3ck116 = 0 time = 1170
* CHECK dout1_4 vdout1_4ck116 = 1.7 time = 1170
* CHECK dout1_5 vdout1_5ck116 = 1.7 time = 1170
* CHECK dout1_6 vdout1_6ck116 = 0 time = 1170
* CHECK dout1_7 vdout1_7ck116 = 1.7 time = 1170
* CHECK dout1_8 vdout1_8ck116 = 1.7 time = 1170
* CHECK dout1_9 vdout1_9ck116 = 0 time = 1170
* CHECK dout1_10 vdout1_10ck116 = 1.7 time = 1170
* CHECK dout1_11 vdout1_11ck116 = 0 time = 1170
* CHECK dout1_12 vdout1_12ck116 = 1.7 time = 1170
* CHECK dout1_13 vdout1_13ck116 = 0 time = 1170
* CHECK dout1_14 vdout1_14ck116 = 1.7 time = 1170
* CHECK dout1_15 vdout1_15ck116 = 1.7 time = 1170
* CHECK dout1_16 vdout1_16ck116 = 0 time = 1170
* CHECK dout1_17 vdout1_17ck116 = 0 time = 1170
* CHECK dout1_18 vdout1_18ck116 = 0 time = 1170
* CHECK dout1_19 vdout1_19ck116 = 1.7 time = 1170
* CHECK dout1_20 vdout1_20ck116 = 1.7 time = 1170
* CHECK dout1_21 vdout1_21ck116 = 1.7 time = 1170
* CHECK dout1_22 vdout1_22ck116 = 0 time = 1170
* CHECK dout1_23 vdout1_23ck116 = 0 time = 1170
* CHECK dout1_24 vdout1_24ck116 = 1.7 time = 1170
* CHECK dout1_25 vdout1_25ck116 = 1.7 time = 1170
* CHECK dout1_26 vdout1_26ck116 = 0 time = 1170
* CHECK dout1_27 vdout1_27ck116 = 0 time = 1170
* CHECK dout1_28 vdout1_28ck116 = 1.7 time = 1170
* CHECK dout1_29 vdout1_29ck116 = 0 time = 1170
* CHECK dout1_30 vdout1_30ck116 = 1.7 time = 1170
* CHECK dout1_31 vdout1_31ck116 = 1.7 time = 1170
* CHECK dout1_32 vdout1_32ck116 = 0 time = 1170
* CHECK dout1_0 vdout1_0ck119 = 1.7 time = 1200
* CHECK dout1_1 vdout1_1ck119 = 0 time = 1200
* CHECK dout1_2 vdout1_2ck119 = 0 time = 1200
* CHECK dout1_3 vdout1_3ck119 = 1.7 time = 1200
* CHECK dout1_4 vdout1_4ck119 = 0 time = 1200
* CHECK dout1_5 vdout1_5ck119 = 1.7 time = 1200
* CHECK dout1_6 vdout1_6ck119 = 0 time = 1200
* CHECK dout1_7 vdout1_7ck119 = 1.7 time = 1200
* CHECK dout1_8 vdout1_8ck119 = 0 time = 1200
* CHECK dout1_9 vdout1_9ck119 = 1.7 time = 1200
* CHECK dout1_10 vdout1_10ck119 = 0 time = 1200
* CHECK dout1_11 vdout1_11ck119 = 1.7 time = 1200
* CHECK dout1_12 vdout1_12ck119 = 1.7 time = 1200
* CHECK dout1_13 vdout1_13ck119 = 0 time = 1200
* CHECK dout1_14 vdout1_14ck119 = 1.7 time = 1200
* CHECK dout1_15 vdout1_15ck119 = 0 time = 1200
* CHECK dout1_16 vdout1_16ck119 = 1.7 time = 1200
* CHECK dout1_17 vdout1_17ck119 = 1.7 time = 1200
* CHECK dout1_18 vdout1_18ck119 = 1.7 time = 1200
* CHECK dout1_19 vdout1_19ck119 = 0 time = 1200
* CHECK dout1_20 vdout1_20ck119 = 0 time = 1200
* CHECK dout1_21 vdout1_21ck119 = 0 time = 1200
* CHECK dout1_22 vdout1_22ck119 = 0 time = 1200
* CHECK dout1_23 vdout1_23ck119 = 1.7 time = 1200
* CHECK dout1_24 vdout1_24ck119 = 1.7 time = 1200
* CHECK dout1_25 vdout1_25ck119 = 1.7 time = 1200
* CHECK dout1_26 vdout1_26ck119 = 1.7 time = 1200
* CHECK dout1_27 vdout1_27ck119 = 0 time = 1200
* CHECK dout1_28 vdout1_28ck119 = 1.7 time = 1200
* CHECK dout1_29 vdout1_29ck119 = 0 time = 1200
* CHECK dout1_30 vdout1_30ck119 = 0 time = 1200
* CHECK dout1_31 vdout1_31ck119 = 1.7 time = 1200
* CHECK dout1_32 vdout1_32ck119 = 0 time = 1200
* CHECK dout1_0 vdout1_0ck122 = 1.7 time = 1230
* CHECK dout1_1 vdout1_1ck122 = 1.7 time = 1230
* CHECK dout1_2 vdout1_2ck122 = 1.7 time = 1230
* CHECK dout1_3 vdout1_3ck122 = 1.7 time = 1230
* CHECK dout1_4 vdout1_4ck122 = 1.7 time = 1230
* CHECK dout1_5 vdout1_5ck122 = 0 time = 1230
* CHECK dout1_6 vdout1_6ck122 = 0 time = 1230
* CHECK dout1_7 vdout1_7ck122 = 1.7 time = 1230
* CHECK dout1_8 vdout1_8ck122 = 0 time = 1230
* CHECK dout1_9 vdout1_9ck122 = 0 time = 1230
* CHECK dout1_10 vdout1_10ck122 = 1.7 time = 1230
* CHECK dout1_11 vdout1_11ck122 = 1.7 time = 1230
* CHECK dout1_12 vdout1_12ck122 = 0 time = 1230
* CHECK dout1_13 vdout1_13ck122 = 0 time = 1230
* CHECK dout1_14 vdout1_14ck122 = 1.7 time = 1230
* CHECK dout1_15 vdout1_15ck122 = 0 time = 1230
* CHECK dout1_16 vdout1_16ck122 = 1.7 time = 1230
* CHECK dout1_17 vdout1_17ck122 = 0 time = 1230
* CHECK dout1_18 vdout1_18ck122 = 0 time = 1230
* CHECK dout1_19 vdout1_19ck122 = 0 time = 1230
* CHECK dout1_20 vdout1_20ck122 = 1.7 time = 1230
* CHECK dout1_21 vdout1_21ck122 = 0 time = 1230
* CHECK dout1_22 vdout1_22ck122 = 1.7 time = 1230
* CHECK dout1_23 vdout1_23ck122 = 1.7 time = 1230
* CHECK dout1_24 vdout1_24ck122 = 1.7 time = 1230
* CHECK dout1_25 vdout1_25ck122 = 0 time = 1230
* CHECK dout1_26 vdout1_26ck122 = 1.7 time = 1230
* CHECK dout1_27 vdout1_27ck122 = 0 time = 1230
* CHECK dout1_28 vdout1_28ck122 = 1.7 time = 1230
* CHECK dout1_29 vdout1_29ck122 = 0 time = 1230
* CHECK dout1_30 vdout1_30ck122 = 1.7 time = 1230
* CHECK dout1_31 vdout1_31ck122 = 1.7 time = 1230
* CHECK dout1_32 vdout1_32ck122 = 0 time = 1230
* CHECK dout1_0 vdout1_0ck123 = 1.7 time = 1240
* CHECK dout1_1 vdout1_1ck123 = 0 time = 1240
* CHECK dout1_2 vdout1_2ck123 = 0 time = 1240
* CHECK dout1_3 vdout1_3ck123 = 1.7 time = 1240
* CHECK dout1_4 vdout1_4ck123 = 0 time = 1240
* CHECK dout1_5 vdout1_5ck123 = 1.7 time = 1240
* CHECK dout1_6 vdout1_6ck123 = 0 time = 1240
* CHECK dout1_7 vdout1_7ck123 = 1.7 time = 1240
* CHECK dout1_8 vdout1_8ck123 = 0 time = 1240
* CHECK dout1_9 vdout1_9ck123 = 1.7 time = 1240
* CHECK dout1_10 vdout1_10ck123 = 0 time = 1240
* CHECK dout1_11 vdout1_11ck123 = 1.7 time = 1240
* CHECK dout1_12 vdout1_12ck123 = 1.7 time = 1240
* CHECK dout1_13 vdout1_13ck123 = 0 time = 1240
* CHECK dout1_14 vdout1_14ck123 = 1.7 time = 1240
* CHECK dout1_15 vdout1_15ck123 = 0 time = 1240
* CHECK dout1_16 vdout1_16ck123 = 1.7 time = 1240
* CHECK dout1_17 vdout1_17ck123 = 1.7 time = 1240
* CHECK dout1_18 vdout1_18ck123 = 1.7 time = 1240
* CHECK dout1_19 vdout1_19ck123 = 0 time = 1240
* CHECK dout1_20 vdout1_20ck123 = 0 time = 1240
* CHECK dout1_21 vdout1_21ck123 = 0 time = 1240
* CHECK dout1_22 vdout1_22ck123 = 0 time = 1240
* CHECK dout1_23 vdout1_23ck123 = 1.7 time = 1240
* CHECK dout1_24 vdout1_24ck123 = 1.7 time = 1240
* CHECK dout1_25 vdout1_25ck123 = 1.7 time = 1240
* CHECK dout1_26 vdout1_26ck123 = 1.7 time = 1240
* CHECK dout1_27 vdout1_27ck123 = 0 time = 1240
* CHECK dout1_28 vdout1_28ck123 = 1.7 time = 1240
* CHECK dout1_29 vdout1_29ck123 = 0 time = 1240
* CHECK dout1_30 vdout1_30ck123 = 0 time = 1240
* CHECK dout1_31 vdout1_31ck123 = 1.7 time = 1240
* CHECK dout1_32 vdout1_32ck123 = 0 time = 1240
* CHECK dout1_0 vdout1_0ck126 = 0 time = 1270
* CHECK dout1_1 vdout1_1ck126 = 0 time = 1270
* CHECK dout1_2 vdout1_2ck126 = 0 time = 1270
* CHECK dout1_3 vdout1_3ck126 = 1.7 time = 1270
* CHECK dout1_4 vdout1_4ck126 = 1.7 time = 1270
* CHECK dout1_5 vdout1_5ck126 = 1.7 time = 1270
* CHECK dout1_6 vdout1_6ck126 = 0 time = 1270
* CHECK dout1_7 vdout1_7ck126 = 0 time = 1270
* CHECK dout1_8 vdout1_8ck126 = 1.7 time = 1270
* CHECK dout1_9 vdout1_9ck126 = 0 time = 1270
* CHECK dout1_10 vdout1_10ck126 = 0 time = 1270
* CHECK dout1_11 vdout1_11ck126 = 1.7 time = 1270
* CHECK dout1_12 vdout1_12ck126 = 1.7 time = 1270
* CHECK dout1_13 vdout1_13ck126 = 0 time = 1270
* CHECK dout1_14 vdout1_14ck126 = 0 time = 1270
* CHECK dout1_15 vdout1_15ck126 = 0 time = 1270
* CHECK dout1_16 vdout1_16ck126 = 1.7 time = 1270
* CHECK dout1_17 vdout1_17ck126 = 0 time = 1270
* CHECK dout1_18 vdout1_18ck126 = 0 time = 1270
* CHECK dout1_19 vdout1_19ck126 = 0 time = 1270
* CHECK dout1_20 vdout1_20ck126 = 0 time = 1270
* CHECK dout1_21 vdout1_21ck126 = 0 time = 1270
* CHECK dout1_22 vdout1_22ck126 = 0 time = 1270
* CHECK dout1_23 vdout1_23ck126 = 0 time = 1270
* CHECK dout1_24 vdout1_24ck126 = 1.7 time = 1270
* CHECK dout1_25 vdout1_25ck126 = 0 time = 1270
* CHECK dout1_26 vdout1_26ck126 = 1.7 time = 1270
* CHECK dout1_27 vdout1_27ck126 = 1.7 time = 1270
* CHECK dout1_28 vdout1_28ck126 = 0 time = 1270
* CHECK dout1_29 vdout1_29ck126 = 0 time = 1270
* CHECK dout1_30 vdout1_30ck126 = 0 time = 1270
* CHECK dout1_31 vdout1_31ck126 = 0 time = 1270
* CHECK dout1_32 vdout1_32ck126 = 0 time = 1270
* CHECK dout1_0 vdout1_0ck127 = 1.7 time = 1280
* CHECK dout1_1 vdout1_1ck127 = 1.7 time = 1280
* CHECK dout1_2 vdout1_2ck127 = 0 time = 1280
* CHECK dout1_3 vdout1_3ck127 = 0 time = 1280
* CHECK dout1_4 vdout1_4ck127 = 1.7 time = 1280
* CHECK dout1_5 vdout1_5ck127 = 1.7 time = 1280
* CHECK dout1_6 vdout1_6ck127 = 1.7 time = 1280
* CHECK dout1_7 vdout1_7ck127 = 1.7 time = 1280
* CHECK dout1_8 vdout1_8ck127 = 0 time = 1280
* CHECK dout1_9 vdout1_9ck127 = 1.7 time = 1280
* CHECK dout1_10 vdout1_10ck127 = 1.7 time = 1280
* CHECK dout1_11 vdout1_11ck127 = 1.7 time = 1280
* CHECK dout1_12 vdout1_12ck127 = 0 time = 1280
* CHECK dout1_13 vdout1_13ck127 = 0 time = 1280
* CHECK dout1_14 vdout1_14ck127 = 1.7 time = 1280
* CHECK dout1_15 vdout1_15ck127 = 0 time = 1280
* CHECK dout1_16 vdout1_16ck127 = 1.7 time = 1280
* CHECK dout1_17 vdout1_17ck127 = 1.7 time = 1280
* CHECK dout1_18 vdout1_18ck127 = 1.7 time = 1280
* CHECK dout1_19 vdout1_19ck127 = 0 time = 1280
* CHECK dout1_20 vdout1_20ck127 = 0 time = 1280
* CHECK dout1_21 vdout1_21ck127 = 0 time = 1280
* CHECK dout1_22 vdout1_22ck127 = 1.7 time = 1280
* CHECK dout1_23 vdout1_23ck127 = 1.7 time = 1280
* CHECK dout1_24 vdout1_24ck127 = 1.7 time = 1280
* CHECK dout1_25 vdout1_25ck127 = 0 time = 1280
* CHECK dout1_26 vdout1_26ck127 = 0 time = 1280
* CHECK dout1_27 vdout1_27ck127 = 1.7 time = 1280
* CHECK dout1_28 vdout1_28ck127 = 1.7 time = 1280
* CHECK dout1_29 vdout1_29ck127 = 0 time = 1280
* CHECK dout1_30 vdout1_30ck127 = 0 time = 1280
* CHECK dout1_31 vdout1_31ck127 = 1.7 time = 1280
* CHECK dout1_32 vdout1_32ck127 = 0 time = 1280
* CHECK dout1_0 vdout1_0ck128 = 0 time = 1290
* CHECK dout1_1 vdout1_1ck128 = 0 time = 1290
* CHECK dout1_2 vdout1_2ck128 = 0 time = 1290
* CHECK dout1_3 vdout1_3ck128 = 1.7 time = 1290
* CHECK dout1_4 vdout1_4ck128 = 1.7 time = 1290
* CHECK dout1_5 vdout1_5ck128 = 1.7 time = 1290
* CHECK dout1_6 vdout1_6ck128 = 0 time = 1290
* CHECK dout1_7 vdout1_7ck128 = 0 time = 1290
* CHECK dout1_8 vdout1_8ck128 = 1.7 time = 1290
* CHECK dout1_9 vdout1_9ck128 = 0 time = 1290
* CHECK dout1_10 vdout1_10ck128 = 0 time = 1290
* CHECK dout1_11 vdout1_11ck128 = 1.7 time = 1290
* CHECK dout1_12 vdout1_12ck128 = 1.7 time = 1290
* CHECK dout1_13 vdout1_13ck128 = 0 time = 1290
* CHECK dout1_14 vdout1_14ck128 = 0 time = 1290
* CHECK dout1_15 vdout1_15ck128 = 0 time = 1290
* CHECK dout1_16 vdout1_16ck128 = 1.7 time = 1290
* CHECK dout1_17 vdout1_17ck128 = 0 time = 1290
* CHECK dout1_18 vdout1_18ck128 = 0 time = 1290
* CHECK dout1_19 vdout1_19ck128 = 0 time = 1290
* CHECK dout1_20 vdout1_20ck128 = 0 time = 1290
* CHECK dout1_21 vdout1_21ck128 = 0 time = 1290
* CHECK dout1_22 vdout1_22ck128 = 0 time = 1290
* CHECK dout1_23 vdout1_23ck128 = 0 time = 1290
* CHECK dout1_24 vdout1_24ck128 = 1.7 time = 1290
* CHECK dout1_25 vdout1_25ck128 = 0 time = 1290
* CHECK dout1_26 vdout1_26ck128 = 1.7 time = 1290
* CHECK dout1_27 vdout1_27ck128 = 1.7 time = 1290
* CHECK dout1_28 vdout1_28ck128 = 0 time = 1290
* CHECK dout1_29 vdout1_29ck128 = 0 time = 1290
* CHECK dout1_30 vdout1_30ck128 = 0 time = 1290
* CHECK dout1_31 vdout1_31ck128 = 0 time = 1290
* CHECK dout1_32 vdout1_32ck128 = 0 time = 1290
* CHECK dout1_0 vdout1_0ck130 = 0 time = 1310
* CHECK dout1_1 vdout1_1ck130 = 0 time = 1310
* CHECK dout1_2 vdout1_2ck130 = 1.7 time = 1310
* CHECK dout1_3 vdout1_3ck130 = 0 time = 1310
* CHECK dout1_4 vdout1_4ck130 = 0 time = 1310
* CHECK dout1_5 vdout1_5ck130 = 1.7 time = 1310
* CHECK dout1_6 vdout1_6ck130 = 0 time = 1310
* CHECK dout1_7 vdout1_7ck130 = 1.7 time = 1310
* CHECK dout1_8 vdout1_8ck130 = 1.7 time = 1310
* CHECK dout1_9 vdout1_9ck130 = 0 time = 1310
* CHECK dout1_10 vdout1_10ck130 = 0 time = 1310
* CHECK dout1_11 vdout1_11ck130 = 1.7 time = 1310
* CHECK dout1_12 vdout1_12ck130 = 1.7 time = 1310
* CHECK dout1_13 vdout1_13ck130 = 1.7 time = 1310
* CHECK dout1_14 vdout1_14ck130 = 0 time = 1310
* CHECK dout1_15 vdout1_15ck130 = 1.7 time = 1310
* CHECK dout1_16 vdout1_16ck130 = 1.7 time = 1310
* CHECK dout1_17 vdout1_17ck130 = 0 time = 1310
* CHECK dout1_18 vdout1_18ck130 = 1.7 time = 1310
* CHECK dout1_19 vdout1_19ck130 = 0 time = 1310
* CHECK dout1_20 vdout1_20ck130 = 0 time = 1310
* CHECK dout1_21 vdout1_21ck130 = 1.7 time = 1310
* CHECK dout1_22 vdout1_22ck130 = 0 time = 1310
* CHECK dout1_23 vdout1_23ck130 = 1.7 time = 1310
* CHECK dout1_24 vdout1_24ck130 = 0 time = 1310
* CHECK dout1_25 vdout1_25ck130 = 1.7 time = 1310
* CHECK dout1_26 vdout1_26ck130 = 0 time = 1310
* CHECK dout1_27 vdout1_27ck130 = 1.7 time = 1310
* CHECK dout1_28 vdout1_28ck130 = 0 time = 1310
* CHECK dout1_29 vdout1_29ck130 = 0 time = 1310
* CHECK dout1_30 vdout1_30ck130 = 1.7 time = 1310
* CHECK dout1_31 vdout1_31ck130 = 1.7 time = 1310
* CHECK dout1_32 vdout1_32ck130 = 0 time = 1310
* CHECK dout1_0 vdout1_0ck131 = 0 time = 1320
* CHECK dout1_1 vdout1_1ck131 = 0 time = 1320
* CHECK dout1_2 vdout1_2ck131 = 1.7 time = 1320
* CHECK dout1_3 vdout1_3ck131 = 0 time = 1320
* CHECK dout1_4 vdout1_4ck131 = 0 time = 1320
* CHECK dout1_5 vdout1_5ck131 = 1.7 time = 1320
* CHECK dout1_6 vdout1_6ck131 = 0 time = 1320
* CHECK dout1_7 vdout1_7ck131 = 1.7 time = 1320
* CHECK dout1_8 vdout1_8ck131 = 1.7 time = 1320
* CHECK dout1_9 vdout1_9ck131 = 0 time = 1320
* CHECK dout1_10 vdout1_10ck131 = 0 time = 1320
* CHECK dout1_11 vdout1_11ck131 = 1.7 time = 1320
* CHECK dout1_12 vdout1_12ck131 = 1.7 time = 1320
* CHECK dout1_13 vdout1_13ck131 = 1.7 time = 1320
* CHECK dout1_14 vdout1_14ck131 = 0 time = 1320
* CHECK dout1_15 vdout1_15ck131 = 1.7 time = 1320
* CHECK dout1_16 vdout1_16ck131 = 1.7 time = 1320
* CHECK dout1_17 vdout1_17ck131 = 0 time = 1320
* CHECK dout1_18 vdout1_18ck131 = 1.7 time = 1320
* CHECK dout1_19 vdout1_19ck131 = 0 time = 1320
* CHECK dout1_20 vdout1_20ck131 = 0 time = 1320
* CHECK dout1_21 vdout1_21ck131 = 1.7 time = 1320
* CHECK dout1_22 vdout1_22ck131 = 0 time = 1320
* CHECK dout1_23 vdout1_23ck131 = 1.7 time = 1320
* CHECK dout1_24 vdout1_24ck131 = 0 time = 1320
* CHECK dout1_25 vdout1_25ck131 = 1.7 time = 1320
* CHECK dout1_26 vdout1_26ck131 = 0 time = 1320
* CHECK dout1_27 vdout1_27ck131 = 1.7 time = 1320
* CHECK dout1_28 vdout1_28ck131 = 0 time = 1320
* CHECK dout1_29 vdout1_29ck131 = 0 time = 1320
* CHECK dout1_30 vdout1_30ck131 = 1.7 time = 1320
* CHECK dout1_31 vdout1_31ck131 = 1.7 time = 1320
* CHECK dout1_32 vdout1_32ck131 = 0 time = 1320
* CHECK dout1_0 vdout1_0ck132 = 0 time = 1330
* CHECK dout1_1 vdout1_1ck132 = 0 time = 1330
* CHECK dout1_2 vdout1_2ck132 = 1.7 time = 1330
* CHECK dout1_3 vdout1_3ck132 = 0 time = 1330
* CHECK dout1_4 vdout1_4ck132 = 0 time = 1330
* CHECK dout1_5 vdout1_5ck132 = 1.7 time = 1330
* CHECK dout1_6 vdout1_6ck132 = 0 time = 1330
* CHECK dout1_7 vdout1_7ck132 = 1.7 time = 1330
* CHECK dout1_8 vdout1_8ck132 = 1.7 time = 1330
* CHECK dout1_9 vdout1_9ck132 = 0 time = 1330
* CHECK dout1_10 vdout1_10ck132 = 0 time = 1330
* CHECK dout1_11 vdout1_11ck132 = 1.7 time = 1330
* CHECK dout1_12 vdout1_12ck132 = 1.7 time = 1330
* CHECK dout1_13 vdout1_13ck132 = 1.7 time = 1330
* CHECK dout1_14 vdout1_14ck132 = 0 time = 1330
* CHECK dout1_15 vdout1_15ck132 = 1.7 time = 1330
* CHECK dout1_16 vdout1_16ck132 = 1.7 time = 1330
* CHECK dout1_17 vdout1_17ck132 = 0 time = 1330
* CHECK dout1_18 vdout1_18ck132 = 1.7 time = 1330
* CHECK dout1_19 vdout1_19ck132 = 0 time = 1330
* CHECK dout1_20 vdout1_20ck132 = 0 time = 1330
* CHECK dout1_21 vdout1_21ck132 = 1.7 time = 1330
* CHECK dout1_22 vdout1_22ck132 = 0 time = 1330
* CHECK dout1_23 vdout1_23ck132 = 1.7 time = 1330
* CHECK dout1_24 vdout1_24ck132 = 0 time = 1330
* CHECK dout1_25 vdout1_25ck132 = 1.7 time = 1330
* CHECK dout1_26 vdout1_26ck132 = 0 time = 1330
* CHECK dout1_27 vdout1_27ck132 = 1.7 time = 1330
* CHECK dout1_28 vdout1_28ck132 = 0 time = 1330
* CHECK dout1_29 vdout1_29ck132 = 0 time = 1330
* CHECK dout1_30 vdout1_30ck132 = 1.7 time = 1330
* CHECK dout1_31 vdout1_31ck132 = 1.7 time = 1330
* CHECK dout1_32 vdout1_32ck132 = 0 time = 1330
* CHECK dout1_0 vdout1_0ck135 = 1.7 time = 1360
* CHECK dout1_1 vdout1_1ck135 = 1.7 time = 1360
* CHECK dout1_2 vdout1_2ck135 = 0 time = 1360
* CHECK dout1_3 vdout1_3ck135 = 0 time = 1360
* CHECK dout1_4 vdout1_4ck135 = 1.7 time = 1360
* CHECK dout1_5 vdout1_5ck135 = 1.7 time = 1360
* CHECK dout1_6 vdout1_6ck135 = 1.7 time = 1360
* CHECK dout1_7 vdout1_7ck135 = 1.7 time = 1360
* CHECK dout1_8 vdout1_8ck135 = 0 time = 1360
* CHECK dout1_9 vdout1_9ck135 = 1.7 time = 1360
* CHECK dout1_10 vdout1_10ck135 = 1.7 time = 1360
* CHECK dout1_11 vdout1_11ck135 = 1.7 time = 1360
* CHECK dout1_12 vdout1_12ck135 = 0 time = 1360
* CHECK dout1_13 vdout1_13ck135 = 0 time = 1360
* CHECK dout1_14 vdout1_14ck135 = 1.7 time = 1360
* CHECK dout1_15 vdout1_15ck135 = 0 time = 1360
* CHECK dout1_16 vdout1_16ck135 = 1.7 time = 1360
* CHECK dout1_17 vdout1_17ck135 = 1.7 time = 1360
* CHECK dout1_18 vdout1_18ck135 = 1.7 time = 1360
* CHECK dout1_19 vdout1_19ck135 = 0 time = 1360
* CHECK dout1_20 vdout1_20ck135 = 0 time = 1360
* CHECK dout1_21 vdout1_21ck135 = 0 time = 1360
* CHECK dout1_22 vdout1_22ck135 = 1.7 time = 1360
* CHECK dout1_23 vdout1_23ck135 = 1.7 time = 1360
* CHECK dout1_24 vdout1_24ck135 = 1.7 time = 1360
* CHECK dout1_25 vdout1_25ck135 = 0 time = 1360
* CHECK dout1_26 vdout1_26ck135 = 0 time = 1360
* CHECK dout1_27 vdout1_27ck135 = 1.7 time = 1360
* CHECK dout1_28 vdout1_28ck135 = 1.7 time = 1360
* CHECK dout1_29 vdout1_29ck135 = 0 time = 1360
* CHECK dout1_30 vdout1_30ck135 = 0 time = 1360
* CHECK dout1_31 vdout1_31ck135 = 1.7 time = 1360
* CHECK dout1_32 vdout1_32ck135 = 0 time = 1360
* CHECK dout1_0 vdout1_0ck136 = 1.7 time = 1370
* CHECK dout1_1 vdout1_1ck136 = 1.7 time = 1370
* CHECK dout1_2 vdout1_2ck136 = 0 time = 1370
* CHECK dout1_3 vdout1_3ck136 = 0 time = 1370
* CHECK dout1_4 vdout1_4ck136 = 1.7 time = 1370
* CHECK dout1_5 vdout1_5ck136 = 1.7 time = 1370
* CHECK dout1_6 vdout1_6ck136 = 1.7 time = 1370
* CHECK dout1_7 vdout1_7ck136 = 1.7 time = 1370
* CHECK dout1_8 vdout1_8ck136 = 0 time = 1370
* CHECK dout1_9 vdout1_9ck136 = 1.7 time = 1370
* CHECK dout1_10 vdout1_10ck136 = 1.7 time = 1370
* CHECK dout1_11 vdout1_11ck136 = 1.7 time = 1370
* CHECK dout1_12 vdout1_12ck136 = 0 time = 1370
* CHECK dout1_13 vdout1_13ck136 = 0 time = 1370
* CHECK dout1_14 vdout1_14ck136 = 1.7 time = 1370
* CHECK dout1_15 vdout1_15ck136 = 0 time = 1370
* CHECK dout1_16 vdout1_16ck136 = 1.7 time = 1370
* CHECK dout1_17 vdout1_17ck136 = 1.7 time = 1370
* CHECK dout1_18 vdout1_18ck136 = 1.7 time = 1370
* CHECK dout1_19 vdout1_19ck136 = 0 time = 1370
* CHECK dout1_20 vdout1_20ck136 = 0 time = 1370
* CHECK dout1_21 vdout1_21ck136 = 0 time = 1370
* CHECK dout1_22 vdout1_22ck136 = 1.7 time = 1370
* CHECK dout1_23 vdout1_23ck136 = 1.7 time = 1370
* CHECK dout1_24 vdout1_24ck136 = 1.7 time = 1370
* CHECK dout1_25 vdout1_25ck136 = 0 time = 1370
* CHECK dout1_26 vdout1_26ck136 = 0 time = 1370
* CHECK dout1_27 vdout1_27ck136 = 1.7 time = 1370
* CHECK dout1_28 vdout1_28ck136 = 1.7 time = 1370
* CHECK dout1_29 vdout1_29ck136 = 0 time = 1370
* CHECK dout1_30 vdout1_30ck136 = 0 time = 1370
* CHECK dout1_31 vdout1_31ck136 = 1.7 time = 1370
* CHECK dout1_32 vdout1_32ck136 = 0 time = 1370
* CHECK dout1_0 vdout1_0ck137 = 0 time = 1380
* CHECK dout1_1 vdout1_1ck137 = 1.7 time = 1380
* CHECK dout1_2 vdout1_2ck137 = 0 time = 1380
* CHECK dout1_3 vdout1_3ck137 = 1.7 time = 1380
* CHECK dout1_4 vdout1_4ck137 = 1.7 time = 1380
* CHECK dout1_5 vdout1_5ck137 = 0 time = 1380
* CHECK dout1_6 vdout1_6ck137 = 1.7 time = 1380
* CHECK dout1_7 vdout1_7ck137 = 0 time = 1380
* CHECK dout1_8 vdout1_8ck137 = 0 time = 1380
* CHECK dout1_9 vdout1_9ck137 = 0 time = 1380
* CHECK dout1_10 vdout1_10ck137 = 0 time = 1380
* CHECK dout1_11 vdout1_11ck137 = 1.7 time = 1380
* CHECK dout1_12 vdout1_12ck137 = 0 time = 1380
* CHECK dout1_13 vdout1_13ck137 = 0 time = 1380
* CHECK dout1_14 vdout1_14ck137 = 1.7 time = 1380
* CHECK dout1_15 vdout1_15ck137 = 0 time = 1380
* CHECK dout1_16 vdout1_16ck137 = 0 time = 1380
* CHECK dout1_17 vdout1_17ck137 = 1.7 time = 1380
* CHECK dout1_18 vdout1_18ck137 = 0 time = 1380
* CHECK dout1_19 vdout1_19ck137 = 0 time = 1380
* CHECK dout1_20 vdout1_20ck137 = 0 time = 1380
* CHECK dout1_21 vdout1_21ck137 = 1.7 time = 1380
* CHECK dout1_22 vdout1_22ck137 = 0 time = 1380
* CHECK dout1_23 vdout1_23ck137 = 1.7 time = 1380
* CHECK dout1_24 vdout1_24ck137 = 0 time = 1380
* CHECK dout1_25 vdout1_25ck137 = 1.7 time = 1380
* CHECK dout1_26 vdout1_26ck137 = 0 time = 1380
* CHECK dout1_27 vdout1_27ck137 = 1.7 time = 1380
* CHECK dout1_28 vdout1_28ck137 = 0 time = 1380
* CHECK dout1_29 vdout1_29ck137 = 0 time = 1380
* CHECK dout1_30 vdout1_30ck137 = 1.7 time = 1380
* CHECK dout1_31 vdout1_31ck137 = 1.7 time = 1380
* CHECK dout1_32 vdout1_32ck137 = 0 time = 1380
* CHECK dout1_0 vdout1_0ck139 = 0 time = 1400
* CHECK dout1_1 vdout1_1ck139 = 0 time = 1400
* CHECK dout1_2 vdout1_2ck139 = 0 time = 1400
* CHECK dout1_3 vdout1_3ck139 = 1.7 time = 1400
* CHECK dout1_4 vdout1_4ck139 = 1.7 time = 1400
* CHECK dout1_5 vdout1_5ck139 = 1.7 time = 1400
* CHECK dout1_6 vdout1_6ck139 = 1.7 time = 1400
* CHECK dout1_7 vdout1_7ck139 = 1.7 time = 1400
* CHECK dout1_8 vdout1_8ck139 = 0 time = 1400
* CHECK dout1_9 vdout1_9ck139 = 1.7 time = 1400
* CHECK dout1_10 vdout1_10ck139 = 1.7 time = 1400
* CHECK dout1_11 vdout1_11ck139 = 1.7 time = 1400
* CHECK dout1_12 vdout1_12ck139 = 0 time = 1400
* CHECK dout1_13 vdout1_13ck139 = 1.7 time = 1400
* CHECK dout1_14 vdout1_14ck139 = 1.7 time = 1400
* CHECK dout1_15 vdout1_15ck139 = 1.7 time = 1400
* CHECK dout1_16 vdout1_16ck139 = 1.7 time = 1400
* CHECK dout1_17 vdout1_17ck139 = 1.7 time = 1400
* CHECK dout1_18 vdout1_18ck139 = 1.7 time = 1400
* CHECK dout1_19 vdout1_19ck139 = 1.7 time = 1400
* CHECK dout1_20 vdout1_20ck139 = 1.7 time = 1400
* CHECK dout1_21 vdout1_21ck139 = 0 time = 1400
* CHECK dout1_22 vdout1_22ck139 = 1.7 time = 1400
* CHECK dout1_23 vdout1_23ck139 = 0 time = 1400
* CHECK dout1_24 vdout1_24ck139 = 1.7 time = 1400
* CHECK dout1_25 vdout1_25ck139 = 1.7 time = 1400
* CHECK dout1_26 vdout1_26ck139 = 1.7 time = 1400
* CHECK dout1_27 vdout1_27ck139 = 0 time = 1400
* CHECK dout1_28 vdout1_28ck139 = 0 time = 1400
* CHECK dout1_29 vdout1_29ck139 = 0 time = 1400
* CHECK dout1_30 vdout1_30ck139 = 1.7 time = 1400
* CHECK dout1_31 vdout1_31ck139 = 1.7 time = 1400
* CHECK dout1_32 vdout1_32ck139 = 0 time = 1400
* CHECK dout1_0 vdout1_0ck142 = 0 time = 1430
* CHECK dout1_1 vdout1_1ck142 = 1.7 time = 1430
* CHECK dout1_2 vdout1_2ck142 = 0 time = 1430
* CHECK dout1_3 vdout1_3ck142 = 1.7 time = 1430
* CHECK dout1_4 vdout1_4ck142 = 1.7 time = 1430
* CHECK dout1_5 vdout1_5ck142 = 0 time = 1430
* CHECK dout1_6 vdout1_6ck142 = 0 time = 1430
* CHECK dout1_7 vdout1_7ck142 = 1.7 time = 1430
* CHECK dout1_8 vdout1_8ck142 = 1.7 time = 1430
* CHECK dout1_9 vdout1_9ck142 = 0 time = 1430
* CHECK dout1_10 vdout1_10ck142 = 1.7 time = 1430
* CHECK dout1_11 vdout1_11ck142 = 1.7 time = 1430
* CHECK dout1_12 vdout1_12ck142 = 0 time = 1430
* CHECK dout1_13 vdout1_13ck142 = 1.7 time = 1430
* CHECK dout1_14 vdout1_14ck142 = 0 time = 1430
* CHECK dout1_15 vdout1_15ck142 = 0 time = 1430
* CHECK dout1_16 vdout1_16ck142 = 1.7 time = 1430
* CHECK dout1_17 vdout1_17ck142 = 0 time = 1430
* CHECK dout1_18 vdout1_18ck142 = 0 time = 1430
* CHECK dout1_19 vdout1_19ck142 = 1.7 time = 1430
* CHECK dout1_20 vdout1_20ck142 = 0 time = 1430
* CHECK dout1_21 vdout1_21ck142 = 1.7 time = 1430
* CHECK dout1_22 vdout1_22ck142 = 0 time = 1430
* CHECK dout1_23 vdout1_23ck142 = 0 time = 1430
* CHECK dout1_24 vdout1_24ck142 = 0 time = 1430
* CHECK dout1_25 vdout1_25ck142 = 0 time = 1430
* CHECK dout1_26 vdout1_26ck142 = 0 time = 1430
* CHECK dout1_27 vdout1_27ck142 = 0 time = 1430
* CHECK dout1_28 vdout1_28ck142 = 1.7 time = 1430
* CHECK dout1_29 vdout1_29ck142 = 1.7 time = 1430
* CHECK dout1_30 vdout1_30ck142 = 1.7 time = 1430
* CHECK dout1_31 vdout1_31ck142 = 0 time = 1430
* CHECK dout1_32 vdout1_32ck142 = 0 time = 1430
* CHECK dout1_0 vdout1_0ck145 = 1.7 time = 1460
* CHECK dout1_1 vdout1_1ck145 = 1.7 time = 1460
* CHECK dout1_2 vdout1_2ck145 = 1.7 time = 1460
* CHECK dout1_3 vdout1_3ck145 = 0 time = 1460
* CHECK dout1_4 vdout1_4ck145 = 0 time = 1460
* CHECK dout1_5 vdout1_5ck145 = 1.7 time = 1460
* CHECK dout1_6 vdout1_6ck145 = 1.7 time = 1460
* CHECK dout1_7 vdout1_7ck145 = 1.7 time = 1460
* CHECK dout1_8 vdout1_8ck145 = 1.7 time = 1460
* CHECK dout1_9 vdout1_9ck145 = 0 time = 1460
* CHECK dout1_10 vdout1_10ck145 = 0 time = 1460
* CHECK dout1_11 vdout1_11ck145 = 1.7 time = 1460
* CHECK dout1_12 vdout1_12ck145 = 1.7 time = 1460
* CHECK dout1_13 vdout1_13ck145 = 1.7 time = 1460
* CHECK dout1_14 vdout1_14ck145 = 1.7 time = 1460
* CHECK dout1_15 vdout1_15ck145 = 0 time = 1460
* CHECK dout1_16 vdout1_16ck145 = 0 time = 1460
* CHECK dout1_17 vdout1_17ck145 = 0 time = 1460
* CHECK dout1_18 vdout1_18ck145 = 1.7 time = 1460
* CHECK dout1_19 vdout1_19ck145 = 0 time = 1460
* CHECK dout1_20 vdout1_20ck145 = 0 time = 1460
* CHECK dout1_21 vdout1_21ck145 = 1.7 time = 1460
* CHECK dout1_22 vdout1_22ck145 = 1.7 time = 1460
* CHECK dout1_23 vdout1_23ck145 = 1.7 time = 1460
* CHECK dout1_24 vdout1_24ck145 = 0 time = 1460
* CHECK dout1_25 vdout1_25ck145 = 0 time = 1460
* CHECK dout1_26 vdout1_26ck145 = 1.7 time = 1460
* CHECK dout1_27 vdout1_27ck145 = 1.7 time = 1460
* CHECK dout1_28 vdout1_28ck145 = 0 time = 1460
* CHECK dout1_29 vdout1_29ck145 = 1.7 time = 1460
* CHECK dout1_30 vdout1_30ck145 = 0 time = 1460
* CHECK dout1_31 vdout1_31ck145 = 1.7 time = 1460
* CHECK dout1_32 vdout1_32ck145 = 0 time = 1460
* CHECK dout1_0 vdout1_0ck146 = 1.7 time = 1470
* CHECK dout1_1 vdout1_1ck146 = 1.7 time = 1470
* CHECK dout1_2 vdout1_2ck146 = 1.7 time = 1470
* CHECK dout1_3 vdout1_3ck146 = 0 time = 1470
* CHECK dout1_4 vdout1_4ck146 = 0 time = 1470
* CHECK dout1_5 vdout1_5ck146 = 1.7 time = 1470
* CHECK dout1_6 vdout1_6ck146 = 1.7 time = 1470
* CHECK dout1_7 vdout1_7ck146 = 1.7 time = 1470
* CHECK dout1_8 vdout1_8ck146 = 1.7 time = 1470
* CHECK dout1_9 vdout1_9ck146 = 0 time = 1470
* CHECK dout1_10 vdout1_10ck146 = 0 time = 1470
* CHECK dout1_11 vdout1_11ck146 = 1.7 time = 1470
* CHECK dout1_12 vdout1_12ck146 = 1.7 time = 1470
* CHECK dout1_13 vdout1_13ck146 = 1.7 time = 1470
* CHECK dout1_14 vdout1_14ck146 = 1.7 time = 1470
* CHECK dout1_15 vdout1_15ck146 = 0 time = 1470
* CHECK dout1_16 vdout1_16ck146 = 0 time = 1470
* CHECK dout1_17 vdout1_17ck146 = 0 time = 1470
* CHECK dout1_18 vdout1_18ck146 = 1.7 time = 1470
* CHECK dout1_19 vdout1_19ck146 = 0 time = 1470
* CHECK dout1_20 vdout1_20ck146 = 0 time = 1470
* CHECK dout1_21 vdout1_21ck146 = 1.7 time = 1470
* CHECK dout1_22 vdout1_22ck146 = 1.7 time = 1470
* CHECK dout1_23 vdout1_23ck146 = 1.7 time = 1470
* CHECK dout1_24 vdout1_24ck146 = 0 time = 1470
* CHECK dout1_25 vdout1_25ck146 = 0 time = 1470
* CHECK dout1_26 vdout1_26ck146 = 1.7 time = 1470
* CHECK dout1_27 vdout1_27ck146 = 1.7 time = 1470
* CHECK dout1_28 vdout1_28ck146 = 0 time = 1470
* CHECK dout1_29 vdout1_29ck146 = 1.7 time = 1470
* CHECK dout1_30 vdout1_30ck146 = 0 time = 1470
* CHECK dout1_31 vdout1_31ck146 = 1.7 time = 1470
* CHECK dout1_32 vdout1_32ck146 = 0 time = 1470
* CHECK dout1_0 vdout1_0ck149 = 0 time = 1500
* CHECK dout1_1 vdout1_1ck149 = 0 time = 1500
* CHECK dout1_2 vdout1_2ck149 = 0 time = 1500
* CHECK dout1_3 vdout1_3ck149 = 1.7 time = 1500
* CHECK dout1_4 vdout1_4ck149 = 1.7 time = 1500
* CHECK dout1_5 vdout1_5ck149 = 1.7 time = 1500
* CHECK dout1_6 vdout1_6ck149 = 1.7 time = 1500
* CHECK dout1_7 vdout1_7ck149 = 1.7 time = 1500
* CHECK dout1_8 vdout1_8ck149 = 0 time = 1500
* CHECK dout1_9 vdout1_9ck149 = 1.7 time = 1500
* CHECK dout1_10 vdout1_10ck149 = 1.7 time = 1500
* CHECK dout1_11 vdout1_11ck149 = 1.7 time = 1500
* CHECK dout1_12 vdout1_12ck149 = 0 time = 1500
* CHECK dout1_13 vdout1_13ck149 = 1.7 time = 1500
* CHECK dout1_14 vdout1_14ck149 = 1.7 time = 1500
* CHECK dout1_15 vdout1_15ck149 = 1.7 time = 1500
* CHECK dout1_16 vdout1_16ck149 = 1.7 time = 1500
* CHECK dout1_17 vdout1_17ck149 = 1.7 time = 1500
* CHECK dout1_18 vdout1_18ck149 = 1.7 time = 1500
* CHECK dout1_19 vdout1_19ck149 = 1.7 time = 1500
* CHECK dout1_20 vdout1_20ck149 = 1.7 time = 1500
* CHECK dout1_21 vdout1_21ck149 = 0 time = 1500
* CHECK dout1_22 vdout1_22ck149 = 1.7 time = 1500
* CHECK dout1_23 vdout1_23ck149 = 0 time = 1500
* CHECK dout1_24 vdout1_24ck149 = 1.7 time = 1500
* CHECK dout1_25 vdout1_25ck149 = 1.7 time = 1500
* CHECK dout1_26 vdout1_26ck149 = 1.7 time = 1500
* CHECK dout1_27 vdout1_27ck149 = 0 time = 1500
* CHECK dout1_28 vdout1_28ck149 = 0 time = 1500
* CHECK dout1_29 vdout1_29ck149 = 0 time = 1500
* CHECK dout1_30 vdout1_30ck149 = 1.7 time = 1500
* CHECK dout1_31 vdout1_31ck149 = 1.7 time = 1500
* CHECK dout1_32 vdout1_32ck149 = 0 time = 1500
* CHECK dout1_0 vdout1_0ck152 = 0 time = 1530
* CHECK dout1_1 vdout1_1ck152 = 1.7 time = 1530
* CHECK dout1_2 vdout1_2ck152 = 0 time = 1530
* CHECK dout1_3 vdout1_3ck152 = 0 time = 1530
* CHECK dout1_4 vdout1_4ck152 = 0 time = 1530
* CHECK dout1_5 vdout1_5ck152 = 0 time = 1530
* CHECK dout1_6 vdout1_6ck152 = 0 time = 1530
* CHECK dout1_7 vdout1_7ck152 = 1.7 time = 1530
* CHECK dout1_8 vdout1_8ck152 = 0 time = 1530
* CHECK dout1_9 vdout1_9ck152 = 0 time = 1530
* CHECK dout1_10 vdout1_10ck152 = 0 time = 1530
* CHECK dout1_11 vdout1_11ck152 = 1.7 time = 1530
* CHECK dout1_12 vdout1_12ck152 = 1.7 time = 1530
* CHECK dout1_13 vdout1_13ck152 = 0 time = 1530
* CHECK dout1_14 vdout1_14ck152 = 1.7 time = 1530
* CHECK dout1_15 vdout1_15ck152 = 1.7 time = 1530
* CHECK dout1_16 vdout1_16ck152 = 0 time = 1530
* CHECK dout1_17 vdout1_17ck152 = 0 time = 1530
* CHECK dout1_18 vdout1_18ck152 = 0 time = 1530
* CHECK dout1_19 vdout1_19ck152 = 0 time = 1530
* CHECK dout1_20 vdout1_20ck152 = 0 time = 1530
* CHECK dout1_21 vdout1_21ck152 = 0 time = 1530
* CHECK dout1_22 vdout1_22ck152 = 0 time = 1530
* CHECK dout1_23 vdout1_23ck152 = 1.7 time = 1530
* CHECK dout1_24 vdout1_24ck152 = 1.7 time = 1530
* CHECK dout1_25 vdout1_25ck152 = 1.7 time = 1530
* CHECK dout1_26 vdout1_26ck152 = 0 time = 1530
* CHECK dout1_27 vdout1_27ck152 = 1.7 time = 1530
* CHECK dout1_28 vdout1_28ck152 = 1.7 time = 1530
* CHECK dout1_29 vdout1_29ck152 = 1.7 time = 1530
* CHECK dout1_30 vdout1_30ck152 = 1.7 time = 1530
* CHECK dout1_31 vdout1_31ck152 = 1.7 time = 1530
* CHECK dout1_32 vdout1_32ck152 = 0 time = 1530
* CHECK dout1_0 vdout1_0ck155 = 0 time = 1560
* CHECK dout1_1 vdout1_1ck155 = 0 time = 1560
* CHECK dout1_2 vdout1_2ck155 = 0 time = 1560
* CHECK dout1_3 vdout1_3ck155 = 1.7 time = 1560
* CHECK dout1_4 vdout1_4ck155 = 1.7 time = 1560
* CHECK dout1_5 vdout1_5ck155 = 1.7 time = 1560
* CHECK dout1_6 vdout1_6ck155 = 1.7 time = 1560
* CHECK dout1_7 vdout1_7ck155 = 1.7 time = 1560
* CHECK dout1_8 vdout1_8ck155 = 0 time = 1560
* CHECK dout1_9 vdout1_9ck155 = 1.7 time = 1560
* CHECK dout1_10 vdout1_10ck155 = 1.7 time = 1560
* CHECK dout1_11 vdout1_11ck155 = 1.7 time = 1560
* CHECK dout1_12 vdout1_12ck155 = 0 time = 1560
* CHECK dout1_13 vdout1_13ck155 = 1.7 time = 1560
* CHECK dout1_14 vdout1_14ck155 = 1.7 time = 1560
* CHECK dout1_15 vdout1_15ck155 = 1.7 time = 1560
* CHECK dout1_16 vdout1_16ck155 = 1.7 time = 1560
* CHECK dout1_17 vdout1_17ck155 = 1.7 time = 1560
* CHECK dout1_18 vdout1_18ck155 = 1.7 time = 1560
* CHECK dout1_19 vdout1_19ck155 = 1.7 time = 1560
* CHECK dout1_20 vdout1_20ck155 = 1.7 time = 1560
* CHECK dout1_21 vdout1_21ck155 = 0 time = 1560
* CHECK dout1_22 vdout1_22ck155 = 1.7 time = 1560
* CHECK dout1_23 vdout1_23ck155 = 0 time = 1560
* CHECK dout1_24 vdout1_24ck155 = 1.7 time = 1560
* CHECK dout1_25 vdout1_25ck155 = 1.7 time = 1560
* CHECK dout1_26 vdout1_26ck155 = 1.7 time = 1560
* CHECK dout1_27 vdout1_27ck155 = 0 time = 1560
* CHECK dout1_28 vdout1_28ck155 = 0 time = 1560
* CHECK dout1_29 vdout1_29ck155 = 0 time = 1560
* CHECK dout1_30 vdout1_30ck155 = 1.7 time = 1560
* CHECK dout1_31 vdout1_31ck155 = 1.7 time = 1560
* CHECK dout1_32 vdout1_32ck155 = 0 time = 1560
* CHECK dout1_0 vdout1_0ck157 = 1.7 time = 1580
* CHECK dout1_1 vdout1_1ck157 = 0 time = 1580
* CHECK dout1_2 vdout1_2ck157 = 0 time = 1580
* CHECK dout1_3 vdout1_3ck157 = 0 time = 1580
* CHECK dout1_4 vdout1_4ck157 = 0 time = 1580
* CHECK dout1_5 vdout1_5ck157 = 0 time = 1580
* CHECK dout1_6 vdout1_6ck157 = 0 time = 1580
* CHECK dout1_7 vdout1_7ck157 = 0 time = 1580
* CHECK dout1_8 vdout1_8ck157 = 0 time = 1580
* CHECK dout1_9 vdout1_9ck157 = 1.7 time = 1580
* CHECK dout1_10 vdout1_10ck157 = 1.7 time = 1580
* CHECK dout1_11 vdout1_11ck157 = 1.7 time = 1580
* CHECK dout1_12 vdout1_12ck157 = 1.7 time = 1580
* CHECK dout1_13 vdout1_13ck157 = 1.7 time = 1580
* CHECK dout1_14 vdout1_14ck157 = 1.7 time = 1580
* CHECK dout1_15 vdout1_15ck157 = 1.7 time = 1580
* CHECK dout1_16 vdout1_16ck157 = 1.7 time = 1580
* CHECK dout1_17 vdout1_17ck157 = 1.7 time = 1580
* CHECK dout1_18 vdout1_18ck157 = 0 time = 1580
* CHECK dout1_19 vdout1_19ck157 = 0 time = 1580
* CHECK dout1_20 vdout1_20ck157 = 1.7 time = 1580
* CHECK dout1_21 vdout1_21ck157 = 0 time = 1580
* CHECK dout1_22 vdout1_22ck157 = 0 time = 1580
* CHECK dout1_23 vdout1_23ck157 = 0 time = 1580
* CHECK dout1_24 vdout1_24ck157 = 0 time = 1580
* CHECK dout1_25 vdout1_25ck157 = 1.7 time = 1580
* CHECK dout1_26 vdout1_26ck157 = 0 time = 1580
* CHECK dout1_27 vdout1_27ck157 = 0 time = 1580
* CHECK dout1_28 vdout1_28ck157 = 1.7 time = 1580
* CHECK dout1_29 vdout1_29ck157 = 1.7 time = 1580
* CHECK dout1_30 vdout1_30ck157 = 0 time = 1580
* CHECK dout1_31 vdout1_31ck157 = 1.7 time = 1580
* CHECK dout1_32 vdout1_32ck157 = 0 time = 1580
* CHECK dout1_0 vdout1_0ck159 = 0 time = 1600
* CHECK dout1_1 vdout1_1ck159 = 1.7 time = 1600
* CHECK dout1_2 vdout1_2ck159 = 0 time = 1600
* CHECK dout1_3 vdout1_3ck159 = 0 time = 1600
* CHECK dout1_4 vdout1_4ck159 = 0 time = 1600
* CHECK dout1_5 vdout1_5ck159 = 0 time = 1600
* CHECK dout1_6 vdout1_6ck159 = 0 time = 1600
* CHECK dout1_7 vdout1_7ck159 = 1.7 time = 1600
* CHECK dout1_8 vdout1_8ck159 = 0 time = 1600
* CHECK dout1_9 vdout1_9ck159 = 0 time = 1600
* CHECK dout1_10 vdout1_10ck159 = 0 time = 1600
* CHECK dout1_11 vdout1_11ck159 = 1.7 time = 1600
* CHECK dout1_12 vdout1_12ck159 = 1.7 time = 1600
* CHECK dout1_13 vdout1_13ck159 = 0 time = 1600
* CHECK dout1_14 vdout1_14ck159 = 1.7 time = 1600
* CHECK dout1_15 vdout1_15ck159 = 1.7 time = 1600
* CHECK dout1_16 vdout1_16ck159 = 0 time = 1600
* CHECK dout1_17 vdout1_17ck159 = 0 time = 1600
* CHECK dout1_18 vdout1_18ck159 = 0 time = 1600
* CHECK dout1_19 vdout1_19ck159 = 0 time = 1600
* CHECK dout1_20 vdout1_20ck159 = 0 time = 1600
* CHECK dout1_21 vdout1_21ck159 = 0 time = 1600
* CHECK dout1_22 vdout1_22ck159 = 0 time = 1600
* CHECK dout1_23 vdout1_23ck159 = 1.7 time = 1600
* CHECK dout1_24 vdout1_24ck159 = 1.7 time = 1600
* CHECK dout1_25 vdout1_25ck159 = 1.7 time = 1600
* CHECK dout1_26 vdout1_26ck159 = 0 time = 1600
* CHECK dout1_27 vdout1_27ck159 = 1.7 time = 1600
* CHECK dout1_28 vdout1_28ck159 = 1.7 time = 1600
* CHECK dout1_29 vdout1_29ck159 = 1.7 time = 1600
* CHECK dout1_30 vdout1_30ck159 = 1.7 time = 1600
* CHECK dout1_31 vdout1_31ck159 = 1.7 time = 1600
* CHECK dout1_32 vdout1_32ck159 = 0 time = 1600
* CHECK dout1_0 vdout1_0ck160 = 1.7 time = 1610
* CHECK dout1_1 vdout1_1ck160 = 0 time = 1610
* CHECK dout1_2 vdout1_2ck160 = 0 time = 1610
* CHECK dout1_3 vdout1_3ck160 = 0 time = 1610
* CHECK dout1_4 vdout1_4ck160 = 0 time = 1610
* CHECK dout1_5 vdout1_5ck160 = 1.7 time = 1610
* CHECK dout1_6 vdout1_6ck160 = 1.7 time = 1610
* CHECK dout1_7 vdout1_7ck160 = 1.7 time = 1610
* CHECK dout1_8 vdout1_8ck160 = 1.7 time = 1610
* CHECK dout1_9 vdout1_9ck160 = 1.7 time = 1610
* CHECK dout1_10 vdout1_10ck160 = 0 time = 1610
* CHECK dout1_11 vdout1_11ck160 = 1.7 time = 1610
* CHECK dout1_12 vdout1_12ck160 = 1.7 time = 1610
* CHECK dout1_13 vdout1_13ck160 = 0 time = 1610
* CHECK dout1_14 vdout1_14ck160 = 1.7 time = 1610
* CHECK dout1_15 vdout1_15ck160 = 1.7 time = 1610
* CHECK dout1_16 vdout1_16ck160 = 1.7 time = 1610
* CHECK dout1_17 vdout1_17ck160 = 1.7 time = 1610
* CHECK dout1_18 vdout1_18ck160 = 0 time = 1610
* CHECK dout1_19 vdout1_19ck160 = 1.7 time = 1610
* CHECK dout1_20 vdout1_20ck160 = 0 time = 1610
* CHECK dout1_21 vdout1_21ck160 = 0 time = 1610
* CHECK dout1_22 vdout1_22ck160 = 1.7 time = 1610
* CHECK dout1_23 vdout1_23ck160 = 1.7 time = 1610
* CHECK dout1_24 vdout1_24ck160 = 0 time = 1610
* CHECK dout1_25 vdout1_25ck160 = 0 time = 1610
* CHECK dout1_26 vdout1_26ck160 = 1.7 time = 1610
* CHECK dout1_27 vdout1_27ck160 = 1.7 time = 1610
* CHECK dout1_28 vdout1_28ck160 = 0 time = 1610
* CHECK dout1_29 vdout1_29ck160 = 0 time = 1610
* CHECK dout1_30 vdout1_30ck160 = 0 time = 1610
* CHECK dout1_31 vdout1_31ck160 = 0 time = 1610
* CHECK dout1_32 vdout1_32ck160 = 0 time = 1610
* CHECK dout1_0 vdout1_0ck161 = 0 time = 1620
* CHECK dout1_1 vdout1_1ck161 = 1.7 time = 1620
* CHECK dout1_2 vdout1_2ck161 = 0 time = 1620
* CHECK dout1_3 vdout1_3ck161 = 0 time = 1620
* CHECK dout1_4 vdout1_4ck161 = 0 time = 1620
* CHECK dout1_5 vdout1_5ck161 = 0 time = 1620
* CHECK dout1_6 vdout1_6ck161 = 0 time = 1620
* CHECK dout1_7 vdout1_7ck161 = 1.7 time = 1620
* CHECK dout1_8 vdout1_8ck161 = 0 time = 1620
* CHECK dout1_9 vdout1_9ck161 = 0 time = 1620
* CHECK dout1_10 vdout1_10ck161 = 0 time = 1620
* CHECK dout1_11 vdout1_11ck161 = 1.7 time = 1620
* CHECK dout1_12 vdout1_12ck161 = 1.7 time = 1620
* CHECK dout1_13 vdout1_13ck161 = 0 time = 1620
* CHECK dout1_14 vdout1_14ck161 = 1.7 time = 1620
* CHECK dout1_15 vdout1_15ck161 = 1.7 time = 1620
* CHECK dout1_16 vdout1_16ck161 = 0 time = 1620
* CHECK dout1_17 vdout1_17ck161 = 0 time = 1620
* CHECK dout1_18 vdout1_18ck161 = 0 time = 1620
* CHECK dout1_19 vdout1_19ck161 = 0 time = 1620
* CHECK dout1_20 vdout1_20ck161 = 0 time = 1620
* CHECK dout1_21 vdout1_21ck161 = 0 time = 1620
* CHECK dout1_22 vdout1_22ck161 = 0 time = 1620
* CHECK dout1_23 vdout1_23ck161 = 1.7 time = 1620
* CHECK dout1_24 vdout1_24ck161 = 1.7 time = 1620
* CHECK dout1_25 vdout1_25ck161 = 1.7 time = 1620
* CHECK dout1_26 vdout1_26ck161 = 0 time = 1620
* CHECK dout1_27 vdout1_27ck161 = 1.7 time = 1620
* CHECK dout1_28 vdout1_28ck161 = 1.7 time = 1620
* CHECK dout1_29 vdout1_29ck161 = 1.7 time = 1620
* CHECK dout1_30 vdout1_30ck161 = 1.7 time = 1620
* CHECK dout1_31 vdout1_31ck161 = 1.7 time = 1620
* CHECK dout1_32 vdout1_32ck161 = 0 time = 1620
* CHECK dout1_0 vdout1_0ck163 = 0 time = 1640
* CHECK dout1_1 vdout1_1ck163 = 0 time = 1640
* CHECK dout1_2 vdout1_2ck163 = 1.7 time = 1640
* CHECK dout1_3 vdout1_3ck163 = 1.7 time = 1640
* CHECK dout1_4 vdout1_4ck163 = 0 time = 1640
* CHECK dout1_5 vdout1_5ck163 = 1.7 time = 1640
* CHECK dout1_6 vdout1_6ck163 = 0 time = 1640
* CHECK dout1_7 vdout1_7ck163 = 1.7 time = 1640
* CHECK dout1_8 vdout1_8ck163 = 1.7 time = 1640
* CHECK dout1_9 vdout1_9ck163 = 0 time = 1640
* CHECK dout1_10 vdout1_10ck163 = 0 time = 1640
* CHECK dout1_11 vdout1_11ck163 = 0 time = 1640
* CHECK dout1_12 vdout1_12ck163 = 1.7 time = 1640
* CHECK dout1_13 vdout1_13ck163 = 1.7 time = 1640
* CHECK dout1_14 vdout1_14ck163 = 0 time = 1640
* CHECK dout1_15 vdout1_15ck163 = 1.7 time = 1640
* CHECK dout1_16 vdout1_16ck163 = 1.7 time = 1640
* CHECK dout1_17 vdout1_17ck163 = 1.7 time = 1640
* CHECK dout1_18 vdout1_18ck163 = 0 time = 1640
* CHECK dout1_19 vdout1_19ck163 = 1.7 time = 1640
* CHECK dout1_20 vdout1_20ck163 = 1.7 time = 1640
* CHECK dout1_21 vdout1_21ck163 = 0 time = 1640
* CHECK dout1_22 vdout1_22ck163 = 1.7 time = 1640
* CHECK dout1_23 vdout1_23ck163 = 0 time = 1640
* CHECK dout1_24 vdout1_24ck163 = 0 time = 1640
* CHECK dout1_25 vdout1_25ck163 = 0 time = 1640
* CHECK dout1_26 vdout1_26ck163 = 0 time = 1640
* CHECK dout1_27 vdout1_27ck163 = 1.7 time = 1640
* CHECK dout1_28 vdout1_28ck163 = 1.7 time = 1640
* CHECK dout1_29 vdout1_29ck163 = 0 time = 1640
* CHECK dout1_30 vdout1_30ck163 = 1.7 time = 1640
* CHECK dout1_31 vdout1_31ck163 = 0 time = 1640
* CHECK dout1_32 vdout1_32ck163 = 0 time = 1640
* CHECK dout1_0 vdout1_0ck164 = 0 time = 1650
* CHECK dout1_1 vdout1_1ck164 = 0 time = 1650
* CHECK dout1_2 vdout1_2ck164 = 1.7 time = 1650
* CHECK dout1_3 vdout1_3ck164 = 1.7 time = 1650
* CHECK dout1_4 vdout1_4ck164 = 0 time = 1650
* CHECK dout1_5 vdout1_5ck164 = 1.7 time = 1650
* CHECK dout1_6 vdout1_6ck164 = 0 time = 1650
* CHECK dout1_7 vdout1_7ck164 = 1.7 time = 1650
* CHECK dout1_8 vdout1_8ck164 = 1.7 time = 1650
* CHECK dout1_9 vdout1_9ck164 = 0 time = 1650
* CHECK dout1_10 vdout1_10ck164 = 0 time = 1650
* CHECK dout1_11 vdout1_11ck164 = 0 time = 1650
* CHECK dout1_12 vdout1_12ck164 = 1.7 time = 1650
* CHECK dout1_13 vdout1_13ck164 = 1.7 time = 1650
* CHECK dout1_14 vdout1_14ck164 = 0 time = 1650
* CHECK dout1_15 vdout1_15ck164 = 1.7 time = 1650
* CHECK dout1_16 vdout1_16ck164 = 1.7 time = 1650
* CHECK dout1_17 vdout1_17ck164 = 1.7 time = 1650
* CHECK dout1_18 vdout1_18ck164 = 0 time = 1650
* CHECK dout1_19 vdout1_19ck164 = 1.7 time = 1650
* CHECK dout1_20 vdout1_20ck164 = 1.7 time = 1650
* CHECK dout1_21 vdout1_21ck164 = 0 time = 1650
* CHECK dout1_22 vdout1_22ck164 = 1.7 time = 1650
* CHECK dout1_23 vdout1_23ck164 = 0 time = 1650
* CHECK dout1_24 vdout1_24ck164 = 0 time = 1650
* CHECK dout1_25 vdout1_25ck164 = 0 time = 1650
* CHECK dout1_26 vdout1_26ck164 = 0 time = 1650
* CHECK dout1_27 vdout1_27ck164 = 1.7 time = 1650
* CHECK dout1_28 vdout1_28ck164 = 1.7 time = 1650
* CHECK dout1_29 vdout1_29ck164 = 0 time = 1650
* CHECK dout1_30 vdout1_30ck164 = 1.7 time = 1650
* CHECK dout1_31 vdout1_31ck164 = 0 time = 1650
* CHECK dout1_32 vdout1_32ck164 = 0 time = 1650
* CHECK dout1_0 vdout1_0ck165 = 1.7 time = 1660
* CHECK dout1_1 vdout1_1ck165 = 0 time = 1660
* CHECK dout1_2 vdout1_2ck165 = 0 time = 1660
* CHECK dout1_3 vdout1_3ck165 = 0 time = 1660
* CHECK dout1_4 vdout1_4ck165 = 0 time = 1660
* CHECK dout1_5 vdout1_5ck165 = 1.7 time = 1660
* CHECK dout1_6 vdout1_6ck165 = 1.7 time = 1660
* CHECK dout1_7 vdout1_7ck165 = 1.7 time = 1660
* CHECK dout1_8 vdout1_8ck165 = 1.7 time = 1660
* CHECK dout1_9 vdout1_9ck165 = 1.7 time = 1660
* CHECK dout1_10 vdout1_10ck165 = 0 time = 1660
* CHECK dout1_11 vdout1_11ck165 = 1.7 time = 1660
* CHECK dout1_12 vdout1_12ck165 = 1.7 time = 1660
* CHECK dout1_13 vdout1_13ck165 = 0 time = 1660
* CHECK dout1_14 vdout1_14ck165 = 1.7 time = 1660
* CHECK dout1_15 vdout1_15ck165 = 1.7 time = 1660
* CHECK dout1_16 vdout1_16ck165 = 1.7 time = 1660
* CHECK dout1_17 vdout1_17ck165 = 1.7 time = 1660
* CHECK dout1_18 vdout1_18ck165 = 0 time = 1660
* CHECK dout1_19 vdout1_19ck165 = 1.7 time = 1660
* CHECK dout1_20 vdout1_20ck165 = 0 time = 1660
* CHECK dout1_21 vdout1_21ck165 = 0 time = 1660
* CHECK dout1_22 vdout1_22ck165 = 1.7 time = 1660
* CHECK dout1_23 vdout1_23ck165 = 1.7 time = 1660
* CHECK dout1_24 vdout1_24ck165 = 0 time = 1660
* CHECK dout1_25 vdout1_25ck165 = 0 time = 1660
* CHECK dout1_26 vdout1_26ck165 = 1.7 time = 1660
* CHECK dout1_27 vdout1_27ck165 = 1.7 time = 1660
* CHECK dout1_28 vdout1_28ck165 = 0 time = 1660
* CHECK dout1_29 vdout1_29ck165 = 0 time = 1660
* CHECK dout1_30 vdout1_30ck165 = 0 time = 1660
* CHECK dout1_31 vdout1_31ck165 = 0 time = 1660
* CHECK dout1_32 vdout1_32ck165 = 0 time = 1660
* CHECK dout1_0 vdout1_0ck166 = 1.7 time = 1670
* CHECK dout1_1 vdout1_1ck166 = 0 time = 1670
* CHECK dout1_2 vdout1_2ck166 = 0 time = 1670
* CHECK dout1_3 vdout1_3ck166 = 0 time = 1670
* CHECK dout1_4 vdout1_4ck166 = 0 time = 1670
* CHECK dout1_5 vdout1_5ck166 = 1.7 time = 1670
* CHECK dout1_6 vdout1_6ck166 = 1.7 time = 1670
* CHECK dout1_7 vdout1_7ck166 = 1.7 time = 1670
* CHECK dout1_8 vdout1_8ck166 = 1.7 time = 1670
* CHECK dout1_9 vdout1_9ck166 = 1.7 time = 1670
* CHECK dout1_10 vdout1_10ck166 = 0 time = 1670
* CHECK dout1_11 vdout1_11ck166 = 1.7 time = 1670
* CHECK dout1_12 vdout1_12ck166 = 1.7 time = 1670
* CHECK dout1_13 vdout1_13ck166 = 0 time = 1670
* CHECK dout1_14 vdout1_14ck166 = 1.7 time = 1670
* CHECK dout1_15 vdout1_15ck166 = 1.7 time = 1670
* CHECK dout1_16 vdout1_16ck166 = 1.7 time = 1670
* CHECK dout1_17 vdout1_17ck166 = 1.7 time = 1670
* CHECK dout1_18 vdout1_18ck166 = 0 time = 1670
* CHECK dout1_19 vdout1_19ck166 = 1.7 time = 1670
* CHECK dout1_20 vdout1_20ck166 = 0 time = 1670
* CHECK dout1_21 vdout1_21ck166 = 0 time = 1670
* CHECK dout1_22 vdout1_22ck166 = 1.7 time = 1670
* CHECK dout1_23 vdout1_23ck166 = 1.7 time = 1670
* CHECK dout1_24 vdout1_24ck166 = 0 time = 1670
* CHECK dout1_25 vdout1_25ck166 = 0 time = 1670
* CHECK dout1_26 vdout1_26ck166 = 1.7 time = 1670
* CHECK dout1_27 vdout1_27ck166 = 1.7 time = 1670
* CHECK dout1_28 vdout1_28ck166 = 0 time = 1670
* CHECK dout1_29 vdout1_29ck166 = 0 time = 1670
* CHECK dout1_30 vdout1_30ck166 = 0 time = 1670
* CHECK dout1_31 vdout1_31ck166 = 0 time = 1670
* CHECK dout1_32 vdout1_32ck166 = 0 time = 1670
* CHECK dout1_0 vdout1_0ck167 = 0 time = 1680
* CHECK dout1_1 vdout1_1ck167 = 0 time = 1680
* CHECK dout1_2 vdout1_2ck167 = 1.7 time = 1680
* CHECK dout1_3 vdout1_3ck167 = 1.7 time = 1680
* CHECK dout1_4 vdout1_4ck167 = 1.7 time = 1680
* CHECK dout1_5 vdout1_5ck167 = 1.7 time = 1680
* CHECK dout1_6 vdout1_6ck167 = 0 time = 1680
* CHECK dout1_7 vdout1_7ck167 = 1.7 time = 1680
* CHECK dout1_8 vdout1_8ck167 = 0 time = 1680
* CHECK dout1_9 vdout1_9ck167 = 0 time = 1680
* CHECK dout1_10 vdout1_10ck167 = 0 time = 1680
* CHECK dout1_11 vdout1_11ck167 = 0 time = 1680
* CHECK dout1_12 vdout1_12ck167 = 1.7 time = 1680
* CHECK dout1_13 vdout1_13ck167 = 1.7 time = 1680
* CHECK dout1_14 vdout1_14ck167 = 1.7 time = 1680
* CHECK dout1_15 vdout1_15ck167 = 0 time = 1680
* CHECK dout1_16 vdout1_16ck167 = 1.7 time = 1680
* CHECK dout1_17 vdout1_17ck167 = 1.7 time = 1680
* CHECK dout1_18 vdout1_18ck167 = 0 time = 1680
* CHECK dout1_19 vdout1_19ck167 = 1.7 time = 1680
* CHECK dout1_20 vdout1_20ck167 = 0 time = 1680
* CHECK dout1_21 vdout1_21ck167 = 0 time = 1680
* CHECK dout1_22 vdout1_22ck167 = 1.7 time = 1680
* CHECK dout1_23 vdout1_23ck167 = 0 time = 1680
* CHECK dout1_24 vdout1_24ck167 = 1.7 time = 1680
* CHECK dout1_25 vdout1_25ck167 = 1.7 time = 1680
* CHECK dout1_26 vdout1_26ck167 = 1.7 time = 1680
* CHECK dout1_27 vdout1_27ck167 = 0 time = 1680
* CHECK dout1_28 vdout1_28ck167 = 1.7 time = 1680
* CHECK dout1_29 vdout1_29ck167 = 1.7 time = 1680
* CHECK dout1_30 vdout1_30ck167 = 0 time = 1680
* CHECK dout1_31 vdout1_31ck167 = 0 time = 1680
* CHECK dout1_32 vdout1_32ck167 = 0 time = 1680
* CHECK dout1_0 vdout1_0ck168 = 1.7 time = 1690
* CHECK dout1_1 vdout1_1ck168 = 0 time = 1690
* CHECK dout1_2 vdout1_2ck168 = 0 time = 1690
* CHECK dout1_3 vdout1_3ck168 = 0 time = 1690
* CHECK dout1_4 vdout1_4ck168 = 0 time = 1690
* CHECK dout1_5 vdout1_5ck168 = 1.7 time = 1690
* CHECK dout1_6 vdout1_6ck168 = 1.7 time = 1690
* CHECK dout1_7 vdout1_7ck168 = 1.7 time = 1690
* CHECK dout1_8 vdout1_8ck168 = 1.7 time = 1690
* CHECK dout1_9 vdout1_9ck168 = 1.7 time = 1690
* CHECK dout1_10 vdout1_10ck168 = 0 time = 1690
* CHECK dout1_11 vdout1_11ck168 = 1.7 time = 1690
* CHECK dout1_12 vdout1_12ck168 = 1.7 time = 1690
* CHECK dout1_13 vdout1_13ck168 = 0 time = 1690
* CHECK dout1_14 vdout1_14ck168 = 1.7 time = 1690
* CHECK dout1_15 vdout1_15ck168 = 1.7 time = 1690
* CHECK dout1_16 vdout1_16ck168 = 1.7 time = 1690
* CHECK dout1_17 vdout1_17ck168 = 1.7 time = 1690
* CHECK dout1_18 vdout1_18ck168 = 0 time = 1690
* CHECK dout1_19 vdout1_19ck168 = 1.7 time = 1690
* CHECK dout1_20 vdout1_20ck168 = 0 time = 1690
* CHECK dout1_21 vdout1_21ck168 = 0 time = 1690
* CHECK dout1_22 vdout1_22ck168 = 1.7 time = 1690
* CHECK dout1_23 vdout1_23ck168 = 1.7 time = 1690
* CHECK dout1_24 vdout1_24ck168 = 0 time = 1690
* CHECK dout1_25 vdout1_25ck168 = 0 time = 1690
* CHECK dout1_26 vdout1_26ck168 = 1.7 time = 1690
* CHECK dout1_27 vdout1_27ck168 = 1.7 time = 1690
* CHECK dout1_28 vdout1_28ck168 = 0 time = 1690
* CHECK dout1_29 vdout1_29ck168 = 0 time = 1690
* CHECK dout1_30 vdout1_30ck168 = 0 time = 1690
* CHECK dout1_31 vdout1_31ck168 = 0 time = 1690
* CHECK dout1_32 vdout1_32ck168 = 0 time = 1690
* CHECK dout1_0 vdout1_0ck170 = 0 time = 1710
* CHECK dout1_1 vdout1_1ck170 = 0 time = 1710
* CHECK dout1_2 vdout1_2ck170 = 1.7 time = 1710
* CHECK dout1_3 vdout1_3ck170 = 1.7 time = 1710
* CHECK dout1_4 vdout1_4ck170 = 0 time = 1710
* CHECK dout1_5 vdout1_5ck170 = 1.7 time = 1710
* CHECK dout1_6 vdout1_6ck170 = 0 time = 1710
* CHECK dout1_7 vdout1_7ck170 = 1.7 time = 1710
* CHECK dout1_8 vdout1_8ck170 = 1.7 time = 1710
* CHECK dout1_9 vdout1_9ck170 = 0 time = 1710
* CHECK dout1_10 vdout1_10ck170 = 0 time = 1710
* CHECK dout1_11 vdout1_11ck170 = 0 time = 1710
* CHECK dout1_12 vdout1_12ck170 = 1.7 time = 1710
* CHECK dout1_13 vdout1_13ck170 = 1.7 time = 1710
* CHECK dout1_14 vdout1_14ck170 = 0 time = 1710
* CHECK dout1_15 vdout1_15ck170 = 1.7 time = 1710
* CHECK dout1_16 vdout1_16ck170 = 1.7 time = 1710
* CHECK dout1_17 vdout1_17ck170 = 1.7 time = 1710
* CHECK dout1_18 vdout1_18ck170 = 0 time = 1710
* CHECK dout1_19 vdout1_19ck170 = 1.7 time = 1710
* CHECK dout1_20 vdout1_20ck170 = 1.7 time = 1710
* CHECK dout1_21 vdout1_21ck170 = 0 time = 1710
* CHECK dout1_22 vdout1_22ck170 = 1.7 time = 1710
* CHECK dout1_23 vdout1_23ck170 = 0 time = 1710
* CHECK dout1_24 vdout1_24ck170 = 0 time = 1710
* CHECK dout1_25 vdout1_25ck170 = 0 time = 1710
* CHECK dout1_26 vdout1_26ck170 = 0 time = 1710
* CHECK dout1_27 vdout1_27ck170 = 1.7 time = 1710
* CHECK dout1_28 vdout1_28ck170 = 1.7 time = 1710
* CHECK dout1_29 vdout1_29ck170 = 0 time = 1710
* CHECK dout1_30 vdout1_30ck170 = 1.7 time = 1710
* CHECK dout1_31 vdout1_31ck170 = 0 time = 1710
* CHECK dout1_32 vdout1_32ck170 = 0 time = 1710
* CHECK dout1_0 vdout1_0ck176 = 0 time = 1770
* CHECK dout1_1 vdout1_1ck176 = 0 time = 1770
* CHECK dout1_2 vdout1_2ck176 = 1.7 time = 1770
* CHECK dout1_3 vdout1_3ck176 = 1.7 time = 1770
* CHECK dout1_4 vdout1_4ck176 = 1.7 time = 1770
* CHECK dout1_5 vdout1_5ck176 = 1.7 time = 1770
* CHECK dout1_6 vdout1_6ck176 = 0 time = 1770
* CHECK dout1_7 vdout1_7ck176 = 1.7 time = 1770
* CHECK dout1_8 vdout1_8ck176 = 0 time = 1770
* CHECK dout1_9 vdout1_9ck176 = 0 time = 1770
* CHECK dout1_10 vdout1_10ck176 = 0 time = 1770
* CHECK dout1_11 vdout1_11ck176 = 0 time = 1770
* CHECK dout1_12 vdout1_12ck176 = 1.7 time = 1770
* CHECK dout1_13 vdout1_13ck176 = 1.7 time = 1770
* CHECK dout1_14 vdout1_14ck176 = 1.7 time = 1770
* CHECK dout1_15 vdout1_15ck176 = 0 time = 1770
* CHECK dout1_16 vdout1_16ck176 = 1.7 time = 1770
* CHECK dout1_17 vdout1_17ck176 = 1.7 time = 1770
* CHECK dout1_18 vdout1_18ck176 = 0 time = 1770
* CHECK dout1_19 vdout1_19ck176 = 1.7 time = 1770
* CHECK dout1_20 vdout1_20ck176 = 0 time = 1770
* CHECK dout1_21 vdout1_21ck176 = 0 time = 1770
* CHECK dout1_22 vdout1_22ck176 = 1.7 time = 1770
* CHECK dout1_23 vdout1_23ck176 = 0 time = 1770
* CHECK dout1_24 vdout1_24ck176 = 1.7 time = 1770
* CHECK dout1_25 vdout1_25ck176 = 1.7 time = 1770
* CHECK dout1_26 vdout1_26ck176 = 1.7 time = 1770
* CHECK dout1_27 vdout1_27ck176 = 0 time = 1770
* CHECK dout1_28 vdout1_28ck176 = 1.7 time = 1770
* CHECK dout1_29 vdout1_29ck176 = 1.7 time = 1770
* CHECK dout1_30 vdout1_30ck176 = 0 time = 1770
* CHECK dout1_31 vdout1_31ck176 = 0 time = 1770
* CHECK dout1_32 vdout1_32ck176 = 0 time = 1770
* CHECK dout1_0 vdout1_0ck177 = 0 time = 1780
* CHECK dout1_1 vdout1_1ck177 = 0 time = 1780
* CHECK dout1_2 vdout1_2ck177 = 1.7 time = 1780
* CHECK dout1_3 vdout1_3ck177 = 1.7 time = 1780
* CHECK dout1_4 vdout1_4ck177 = 1.7 time = 1780
* CHECK dout1_5 vdout1_5ck177 = 1.7 time = 1780
* CHECK dout1_6 vdout1_6ck177 = 0 time = 1780
* CHECK dout1_7 vdout1_7ck177 = 1.7 time = 1780
* CHECK dout1_8 vdout1_8ck177 = 0 time = 1780
* CHECK dout1_9 vdout1_9ck177 = 0 time = 1780
* CHECK dout1_10 vdout1_10ck177 = 0 time = 1780
* CHECK dout1_11 vdout1_11ck177 = 0 time = 1780
* CHECK dout1_12 vdout1_12ck177 = 1.7 time = 1780
* CHECK dout1_13 vdout1_13ck177 = 1.7 time = 1780
* CHECK dout1_14 vdout1_14ck177 = 1.7 time = 1780
* CHECK dout1_15 vdout1_15ck177 = 0 time = 1780
* CHECK dout1_16 vdout1_16ck177 = 1.7 time = 1780
* CHECK dout1_17 vdout1_17ck177 = 1.7 time = 1780
* CHECK dout1_18 vdout1_18ck177 = 0 time = 1780
* CHECK dout1_19 vdout1_19ck177 = 1.7 time = 1780
* CHECK dout1_20 vdout1_20ck177 = 0 time = 1780
* CHECK dout1_21 vdout1_21ck177 = 0 time = 1780
* CHECK dout1_22 vdout1_22ck177 = 1.7 time = 1780
* CHECK dout1_23 vdout1_23ck177 = 0 time = 1780
* CHECK dout1_24 vdout1_24ck177 = 1.7 time = 1780
* CHECK dout1_25 vdout1_25ck177 = 1.7 time = 1780
* CHECK dout1_26 vdout1_26ck177 = 1.7 time = 1780
* CHECK dout1_27 vdout1_27ck177 = 0 time = 1780
* CHECK dout1_28 vdout1_28ck177 = 1.7 time = 1780
* CHECK dout1_29 vdout1_29ck177 = 1.7 time = 1780
* CHECK dout1_30 vdout1_30ck177 = 0 time = 1780
* CHECK dout1_31 vdout1_31ck177 = 0 time = 1780
* CHECK dout1_32 vdout1_32ck177 = 0 time = 1780
* CHECK dout1_0 vdout1_0ck178 = 0 time = 1790
* CHECK dout1_1 vdout1_1ck178 = 0 time = 1790
* CHECK dout1_2 vdout1_2ck178 = 0 time = 1790
* CHECK dout1_3 vdout1_3ck178 = 0 time = 1790
* CHECK dout1_4 vdout1_4ck178 = 0 time = 1790
* CHECK dout1_5 vdout1_5ck178 = 0 time = 1790
* CHECK dout1_6 vdout1_6ck178 = 0 time = 1790
* CHECK dout1_7 vdout1_7ck178 = 1.7 time = 1790
* CHECK dout1_8 vdout1_8ck178 = 1.7 time = 1790
* CHECK dout1_9 vdout1_9ck178 = 0 time = 1790
* CHECK dout1_10 vdout1_10ck178 = 1.7 time = 1790
* CHECK dout1_11 vdout1_11ck178 = 1.7 time = 1790
* CHECK dout1_12 vdout1_12ck178 = 1.7 time = 1790
* CHECK dout1_13 vdout1_13ck178 = 1.7 time = 1790
* CHECK dout1_14 vdout1_14ck178 = 1.7 time = 1790
* CHECK dout1_15 vdout1_15ck178 = 1.7 time = 1790
* CHECK dout1_16 vdout1_16ck178 = 0 time = 1790
* CHECK dout1_17 vdout1_17ck178 = 1.7 time = 1790
* CHECK dout1_18 vdout1_18ck178 = 0 time = 1790
* CHECK dout1_19 vdout1_19ck178 = 0 time = 1790
* CHECK dout1_20 vdout1_20ck178 = 1.7 time = 1790
* CHECK dout1_21 vdout1_21ck178 = 0 time = 1790
* CHECK dout1_22 vdout1_22ck178 = 1.7 time = 1790
* CHECK dout1_23 vdout1_23ck178 = 1.7 time = 1790
* CHECK dout1_24 vdout1_24ck178 = 1.7 time = 1790
* CHECK dout1_25 vdout1_25ck178 = 0 time = 1790
* CHECK dout1_26 vdout1_26ck178 = 1.7 time = 1790
* CHECK dout1_27 vdout1_27ck178 = 1.7 time = 1790
* CHECK dout1_28 vdout1_28ck178 = 0 time = 1790
* CHECK dout1_29 vdout1_29ck178 = 1.7 time = 1790
* CHECK dout1_30 vdout1_30ck178 = 0 time = 1790
* CHECK dout1_31 vdout1_31ck178 = 1.7 time = 1790
* CHECK dout1_32 vdout1_32ck178 = 0 time = 1790
* CHECK dout1_0 vdout1_0ck183 = 1.7 time = 1840
* CHECK dout1_1 vdout1_1ck183 = 1.7 time = 1840
* CHECK dout1_2 vdout1_2ck183 = 1.7 time = 1840
* CHECK dout1_3 vdout1_3ck183 = 1.7 time = 1840
* CHECK dout1_4 vdout1_4ck183 = 1.7 time = 1840
* CHECK dout1_5 vdout1_5ck183 = 0 time = 1840
* CHECK dout1_6 vdout1_6ck183 = 1.7 time = 1840
* CHECK dout1_7 vdout1_7ck183 = 1.7 time = 1840
* CHECK dout1_8 vdout1_8ck183 = 1.7 time = 1840
* CHECK dout1_9 vdout1_9ck183 = 1.7 time = 1840
* CHECK dout1_10 vdout1_10ck183 = 0 time = 1840
* CHECK dout1_11 vdout1_11ck183 = 1.7 time = 1840
* CHECK dout1_12 vdout1_12ck183 = 0 time = 1840
* CHECK dout1_13 vdout1_13ck183 = 0 time = 1840
* CHECK dout1_14 vdout1_14ck183 = 1.7 time = 1840
* CHECK dout1_15 vdout1_15ck183 = 0 time = 1840
* CHECK dout1_16 vdout1_16ck183 = 0 time = 1840
* CHECK dout1_17 vdout1_17ck183 = 0 time = 1840
* CHECK dout1_18 vdout1_18ck183 = 1.7 time = 1840
* CHECK dout1_19 vdout1_19ck183 = 1.7 time = 1840
* CHECK dout1_20 vdout1_20ck183 = 0 time = 1840
* CHECK dout1_21 vdout1_21ck183 = 1.7 time = 1840
* CHECK dout1_22 vdout1_22ck183 = 1.7 time = 1840
* CHECK dout1_23 vdout1_23ck183 = 0 time = 1840
* CHECK dout1_24 vdout1_24ck183 = 1.7 time = 1840
* CHECK dout1_25 vdout1_25ck183 = 0 time = 1840
* CHECK dout1_26 vdout1_26ck183 = 0 time = 1840
* CHECK dout1_27 vdout1_27ck183 = 0 time = 1840
* CHECK dout1_28 vdout1_28ck183 = 1.7 time = 1840
* CHECK dout1_29 vdout1_29ck183 = 0 time = 1840
* CHECK dout1_30 vdout1_30ck183 = 0 time = 1840
* CHECK dout1_31 vdout1_31ck183 = 0 time = 1840
* CHECK dout1_32 vdout1_32ck183 = 0 time = 1840
* CHECK dout1_0 vdout1_0ck188 = 0 time = 1890
* CHECK dout1_1 vdout1_1ck188 = 0 time = 1890
* CHECK dout1_2 vdout1_2ck188 = 1.7 time = 1890
* CHECK dout1_3 vdout1_3ck188 = 1.7 time = 1890
* CHECK dout1_4 vdout1_4ck188 = 0 time = 1890
* CHECK dout1_5 vdout1_5ck188 = 1.7 time = 1890
* CHECK dout1_6 vdout1_6ck188 = 1.7 time = 1890
* CHECK dout1_7 vdout1_7ck188 = 0 time = 1890
* CHECK dout1_8 vdout1_8ck188 = 0 time = 1890
* CHECK dout1_9 vdout1_9ck188 = 1.7 time = 1890
* CHECK dout1_10 vdout1_10ck188 = 1.7 time = 1890
* CHECK dout1_11 vdout1_11ck188 = 0 time = 1890
* CHECK dout1_12 vdout1_12ck188 = 1.7 time = 1890
* CHECK dout1_13 vdout1_13ck188 = 1.7 time = 1890
* CHECK dout1_14 vdout1_14ck188 = 1.7 time = 1890
* CHECK dout1_15 vdout1_15ck188 = 1.7 time = 1890
* CHECK dout1_16 vdout1_16ck188 = 1.7 time = 1890
* CHECK dout1_17 vdout1_17ck188 = 1.7 time = 1890
* CHECK dout1_18 vdout1_18ck188 = 0 time = 1890
* CHECK dout1_19 vdout1_19ck188 = 0 time = 1890
* CHECK dout1_20 vdout1_20ck188 = 0 time = 1890
* CHECK dout1_21 vdout1_21ck188 = 0 time = 1890
* CHECK dout1_22 vdout1_22ck188 = 0 time = 1890
* CHECK dout1_23 vdout1_23ck188 = 0 time = 1890
* CHECK dout1_24 vdout1_24ck188 = 0 time = 1890
* CHECK dout1_25 vdout1_25ck188 = 0 time = 1890
* CHECK dout1_26 vdout1_26ck188 = 1.7 time = 1890
* CHECK dout1_27 vdout1_27ck188 = 1.7 time = 1890
* CHECK dout1_28 vdout1_28ck188 = 1.7 time = 1890
* CHECK dout1_29 vdout1_29ck188 = 0 time = 1890
* CHECK dout1_30 vdout1_30ck188 = 0 time = 1890
* CHECK dout1_31 vdout1_31ck188 = 0 time = 1890
* CHECK dout1_32 vdout1_32ck188 = 0 time = 1890
* CHECK dout1_0 vdout1_0ck194 = 0 time = 1950
* CHECK dout1_1 vdout1_1ck194 = 0 time = 1950
* CHECK dout1_2 vdout1_2ck194 = 1.7 time = 1950
* CHECK dout1_3 vdout1_3ck194 = 1.7 time = 1950
* CHECK dout1_4 vdout1_4ck194 = 1.7 time = 1950
* CHECK dout1_5 vdout1_5ck194 = 1.7 time = 1950
* CHECK dout1_6 vdout1_6ck194 = 0 time = 1950
* CHECK dout1_7 vdout1_7ck194 = 1.7 time = 1950
* CHECK dout1_8 vdout1_8ck194 = 0 time = 1950
* CHECK dout1_9 vdout1_9ck194 = 0 time = 1950
* CHECK dout1_10 vdout1_10ck194 = 0 time = 1950
* CHECK dout1_11 vdout1_11ck194 = 0 time = 1950
* CHECK dout1_12 vdout1_12ck194 = 1.7 time = 1950
* CHECK dout1_13 vdout1_13ck194 = 1.7 time = 1950
* CHECK dout1_14 vdout1_14ck194 = 1.7 time = 1950
* CHECK dout1_15 vdout1_15ck194 = 0 time = 1950
* CHECK dout1_16 vdout1_16ck194 = 1.7 time = 1950
* CHECK dout1_17 vdout1_17ck194 = 1.7 time = 1950
* CHECK dout1_18 vdout1_18ck194 = 0 time = 1950
* CHECK dout1_19 vdout1_19ck194 = 1.7 time = 1950
* CHECK dout1_20 vdout1_20ck194 = 0 time = 1950
* CHECK dout1_21 vdout1_21ck194 = 0 time = 1950
* CHECK dout1_22 vdout1_22ck194 = 1.7 time = 1950
* CHECK dout1_23 vdout1_23ck194 = 0 time = 1950
* CHECK dout1_24 vdout1_24ck194 = 1.7 time = 1950
* CHECK dout1_25 vdout1_25ck194 = 1.7 time = 1950
* CHECK dout1_26 vdout1_26ck194 = 1.7 time = 1950
* CHECK dout1_27 vdout1_27ck194 = 0 time = 1950
* CHECK dout1_28 vdout1_28ck194 = 1.7 time = 1950
* CHECK dout1_29 vdout1_29ck194 = 1.7 time = 1950
* CHECK dout1_30 vdout1_30ck194 = 0 time = 1950
* CHECK dout1_31 vdout1_31ck194 = 0 time = 1950
* CHECK dout1_32 vdout1_32ck194 = 0 time = 1950
* CHECK dout1_0 vdout1_0ck196 = 0 time = 1970
* CHECK dout1_1 vdout1_1ck196 = 0 time = 1970
* CHECK dout1_2 vdout1_2ck196 = 1.7 time = 1970
* CHECK dout1_3 vdout1_3ck196 = 1.7 time = 1970
* CHECK dout1_4 vdout1_4ck196 = 1.7 time = 1970
* CHECK dout1_5 vdout1_5ck196 = 1.7 time = 1970
* CHECK dout1_6 vdout1_6ck196 = 0 time = 1970
* CHECK dout1_7 vdout1_7ck196 = 1.7 time = 1970
* CHECK dout1_8 vdout1_8ck196 = 0 time = 1970
* CHECK dout1_9 vdout1_9ck196 = 0 time = 1970
* CHECK dout1_10 vdout1_10ck196 = 0 time = 1970
* CHECK dout1_11 vdout1_11ck196 = 0 time = 1970
* CHECK dout1_12 vdout1_12ck196 = 1.7 time = 1970
* CHECK dout1_13 vdout1_13ck196 = 1.7 time = 1970
* CHECK dout1_14 vdout1_14ck196 = 1.7 time = 1970
* CHECK dout1_15 vdout1_15ck196 = 0 time = 1970
* CHECK dout1_16 vdout1_16ck196 = 1.7 time = 1970
* CHECK dout1_17 vdout1_17ck196 = 1.7 time = 1970
* CHECK dout1_18 vdout1_18ck196 = 0 time = 1970
* CHECK dout1_19 vdout1_19ck196 = 1.7 time = 1970
* CHECK dout1_20 vdout1_20ck196 = 0 time = 1970
* CHECK dout1_21 vdout1_21ck196 = 0 time = 1970
* CHECK dout1_22 vdout1_22ck196 = 1.7 time = 1970
* CHECK dout1_23 vdout1_23ck196 = 0 time = 1970
* CHECK dout1_24 vdout1_24ck196 = 1.7 time = 1970
* CHECK dout1_25 vdout1_25ck196 = 1.7 time = 1970
* CHECK dout1_26 vdout1_26ck196 = 1.7 time = 1970
* CHECK dout1_27 vdout1_27ck196 = 0 time = 1970
* CHECK dout1_28 vdout1_28ck196 = 1.7 time = 1970
* CHECK dout1_29 vdout1_29ck196 = 1.7 time = 1970
* CHECK dout1_30 vdout1_30ck196 = 0 time = 1970
* CHECK dout1_31 vdout1_31ck196 = 0 time = 1970
* CHECK dout1_32 vdout1_32ck196 = 0 time = 1970
* CHECK dout1_0 vdout1_0ck199 = 0 time = 2000
* CHECK dout1_1 vdout1_1ck199 = 1.7 time = 2000
* CHECK dout1_2 vdout1_2ck199 = 0 time = 2000
* CHECK dout1_3 vdout1_3ck199 = 1.7 time = 2000
* CHECK dout1_4 vdout1_4ck199 = 1.7 time = 2000
* CHECK dout1_5 vdout1_5ck199 = 0 time = 2000
* CHECK dout1_6 vdout1_6ck199 = 0 time = 2000
* CHECK dout1_7 vdout1_7ck199 = 0 time = 2000
* CHECK dout1_8 vdout1_8ck199 = 1.7 time = 2000
* CHECK dout1_9 vdout1_9ck199 = 1.7 time = 2000
* CHECK dout1_10 vdout1_10ck199 = 0 time = 2000
* CHECK dout1_11 vdout1_11ck199 = 1.7 time = 2000
* CHECK dout1_12 vdout1_12ck199 = 1.7 time = 2000
* CHECK dout1_13 vdout1_13ck199 = 0 time = 2000
* CHECK dout1_14 vdout1_14ck199 = 1.7 time = 2000
* CHECK dout1_15 vdout1_15ck199 = 1.7 time = 2000
* CHECK dout1_16 vdout1_16ck199 = 1.7 time = 2000
* CHECK dout1_17 vdout1_17ck199 = 0 time = 2000
* CHECK dout1_18 vdout1_18ck199 = 1.7 time = 2000
* CHECK dout1_19 vdout1_19ck199 = 0 time = 2000
* CHECK dout1_20 vdout1_20ck199 = 1.7 time = 2000
* CHECK dout1_21 vdout1_21ck199 = 0 time = 2000
* CHECK dout1_22 vdout1_22ck199 = 1.7 time = 2000
* CHECK dout1_23 vdout1_23ck199 = 0 time = 2000
* CHECK dout1_24 vdout1_24ck199 = 0 time = 2000
* CHECK dout1_25 vdout1_25ck199 = 1.7 time = 2000
* CHECK dout1_26 vdout1_26ck199 = 1.7 time = 2000
* CHECK dout1_27 vdout1_27ck199 = 1.7 time = 2000
* CHECK dout1_28 vdout1_28ck199 = 0 time = 2000
* CHECK dout1_29 vdout1_29ck199 = 0 time = 2000
* CHECK dout1_30 vdout1_30ck199 = 0 time = 2000
* CHECK dout1_31 vdout1_31ck199 = 0 time = 2000
* CHECK dout1_32 vdout1_32ck199 = 0 time = 2000
.include /Sky130_memory/work/openram_builds/v20260612_1r1w_full/sky130_sram_512bytes_1r1w_32x128/functional_meas.sp
.TEMP 0
.TRAN 10p 2060n 0n 10p UIC
.OPTIONS POST=1 RELTOL=0.001 PROBE method=gear ACCT
* probe is used for hspice/xa, while plot is used in ngspice
*.probe V(*)
*.plot V(*)
.end
