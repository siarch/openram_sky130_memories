.meas tran vdout0_0ck40 FIND v(dout0_0) AT=50.05n

.meas tran vdout0_1ck40 FIND v(dout0_1) AT=50.05n

.meas tran vdout0_2ck40 FIND v(dout0_2) AT=50.05n

.meas tran vdout0_3ck40 FIND v(dout0_3) AT=50.05n

.meas tran vdout0_4ck40 FIND v(dout0_4) AT=50.05n

.meas tran vdout0_5ck40 FIND v(dout0_5) AT=50.05n

.meas tran vdout0_6ck40 FIND v(dout0_6) AT=50.05n

.meas tran vdout0_7ck40 FIND v(dout0_7) AT=50.05n

.meas tran vdout0_8ck40 FIND v(dout0_8) AT=50.05n

.meas tran vdout0_9ck40 FIND v(dout0_9) AT=50.05n

.meas tran vdout0_10ck40 FIND v(dout0_10) AT=50.05n

.meas tran vdout0_11ck40 FIND v(dout0_11) AT=50.05n

.meas tran vdout0_12ck40 FIND v(dout0_12) AT=50.05n

.meas tran vdout0_13ck40 FIND v(dout0_13) AT=50.05n

.meas tran vdout0_14ck40 FIND v(dout0_14) AT=50.05n

.meas tran vdout0_15ck40 FIND v(dout0_15) AT=50.05n

.meas tran vdout0_16ck40 FIND v(dout0_16) AT=50.05n

.meas tran vdout0_17ck40 FIND v(dout0_17) AT=50.05n

.meas tran vdout0_18ck40 FIND v(dout0_18) AT=50.05n

.meas tran vdout0_19ck40 FIND v(dout0_19) AT=50.05n

.meas tran vdout0_20ck40 FIND v(dout0_20) AT=50.05n

.meas tran vdout0_21ck40 FIND v(dout0_21) AT=50.05n

.meas tran vdout0_22ck40 FIND v(dout0_22) AT=50.05n

.meas tran vdout0_23ck40 FIND v(dout0_23) AT=50.05n

.meas tran vdout0_24ck40 FIND v(dout0_24) AT=50.05n

.meas tran vdout0_25ck40 FIND v(dout0_25) AT=50.05n

.meas tran vdout0_26ck40 FIND v(dout0_26) AT=50.05n

.meas tran vdout0_27ck40 FIND v(dout0_27) AT=50.05n

.meas tran vdout0_28ck40 FIND v(dout0_28) AT=50.05n

.meas tran vdout0_29ck40 FIND v(dout0_29) AT=50.05n

.meas tran vdout0_30ck40 FIND v(dout0_30) AT=50.05n

.meas tran vdout0_31ck40 FIND v(dout0_31) AT=50.05n

.meas tran vdout0_32ck40 FIND v(dout0_32) AT=50.05n

.meas tran vdout0_33ck40 FIND v(dout0_33) AT=50.05n

.meas tran vdout0_34ck40 FIND v(dout0_34) AT=50.05n

.meas tran vdout0_35ck40 FIND v(dout0_35) AT=50.05n

.meas tran vdout0_36ck40 FIND v(dout0_36) AT=50.05n

.meas tran vdout0_37ck40 FIND v(dout0_37) AT=50.05n

.meas tran vdout0_38ck40 FIND v(dout0_38) AT=50.05n

.meas tran vdout0_39ck40 FIND v(dout0_39) AT=50.05n

.meas tran vdout0_40ck40 FIND v(dout0_40) AT=50.05n

.meas tran vdout0_41ck40 FIND v(dout0_41) AT=50.05n

.meas tran vdout0_42ck40 FIND v(dout0_42) AT=50.05n

.meas tran vdout0_43ck40 FIND v(dout0_43) AT=50.05n

.meas tran vdout0_44ck40 FIND v(dout0_44) AT=50.05n

.meas tran vdout0_45ck40 FIND v(dout0_45) AT=50.05n

.meas tran vdout0_46ck40 FIND v(dout0_46) AT=50.05n

.meas tran vdout0_47ck40 FIND v(dout0_47) AT=50.05n

.meas tran vdout0_48ck40 FIND v(dout0_48) AT=50.05n

.meas tran vdout0_49ck40 FIND v(dout0_49) AT=50.05n

.meas tran vdout0_50ck40 FIND v(dout0_50) AT=50.05n

.meas tran vdout0_51ck40 FIND v(dout0_51) AT=50.05n

.meas tran vdout0_52ck40 FIND v(dout0_52) AT=50.05n

.meas tran vdout0_53ck40 FIND v(dout0_53) AT=50.05n

.meas tran vdout0_54ck40 FIND v(dout0_54) AT=50.05n

.meas tran vdout0_55ck40 FIND v(dout0_55) AT=50.05n

.meas tran vdout0_56ck40 FIND v(dout0_56) AT=50.05n

.meas tran vdout0_57ck40 FIND v(dout0_57) AT=50.05n

.meas tran vdout0_58ck40 FIND v(dout0_58) AT=50.05n

.meas tran vdout0_59ck40 FIND v(dout0_59) AT=50.05n

.meas tran vdout0_60ck40 FIND v(dout0_60) AT=50.05n

.meas tran vdout0_61ck40 FIND v(dout0_61) AT=50.05n

.meas tran vdout0_62ck40 FIND v(dout0_62) AT=50.05n

.meas tran vdout0_63ck40 FIND v(dout0_63) AT=50.05n

.meas tran vdout0_64ck40 FIND v(dout0_64) AT=50.05n

.meas tran vdout0_0ck70 FIND v(dout0_0) AT=80.05n

.meas tran vdout0_1ck70 FIND v(dout0_1) AT=80.05n

.meas tran vdout0_2ck70 FIND v(dout0_2) AT=80.05n

.meas tran vdout0_3ck70 FIND v(dout0_3) AT=80.05n

.meas tran vdout0_4ck70 FIND v(dout0_4) AT=80.05n

.meas tran vdout0_5ck70 FIND v(dout0_5) AT=80.05n

.meas tran vdout0_6ck70 FIND v(dout0_6) AT=80.05n

.meas tran vdout0_7ck70 FIND v(dout0_7) AT=80.05n

.meas tran vdout0_8ck70 FIND v(dout0_8) AT=80.05n

.meas tran vdout0_9ck70 FIND v(dout0_9) AT=80.05n

.meas tran vdout0_10ck70 FIND v(dout0_10) AT=80.05n

.meas tran vdout0_11ck70 FIND v(dout0_11) AT=80.05n

.meas tran vdout0_12ck70 FIND v(dout0_12) AT=80.05n

.meas tran vdout0_13ck70 FIND v(dout0_13) AT=80.05n

.meas tran vdout0_14ck70 FIND v(dout0_14) AT=80.05n

.meas tran vdout0_15ck70 FIND v(dout0_15) AT=80.05n

.meas tran vdout0_16ck70 FIND v(dout0_16) AT=80.05n

.meas tran vdout0_17ck70 FIND v(dout0_17) AT=80.05n

.meas tran vdout0_18ck70 FIND v(dout0_18) AT=80.05n

.meas tran vdout0_19ck70 FIND v(dout0_19) AT=80.05n

.meas tran vdout0_20ck70 FIND v(dout0_20) AT=80.05n

.meas tran vdout0_21ck70 FIND v(dout0_21) AT=80.05n

.meas tran vdout0_22ck70 FIND v(dout0_22) AT=80.05n

.meas tran vdout0_23ck70 FIND v(dout0_23) AT=80.05n

.meas tran vdout0_24ck70 FIND v(dout0_24) AT=80.05n

.meas tran vdout0_25ck70 FIND v(dout0_25) AT=80.05n

.meas tran vdout0_26ck70 FIND v(dout0_26) AT=80.05n

.meas tran vdout0_27ck70 FIND v(dout0_27) AT=80.05n

.meas tran vdout0_28ck70 FIND v(dout0_28) AT=80.05n

.meas tran vdout0_29ck70 FIND v(dout0_29) AT=80.05n

.meas tran vdout0_30ck70 FIND v(dout0_30) AT=80.05n

.meas tran vdout0_31ck70 FIND v(dout0_31) AT=80.05n

.meas tran vdout0_32ck70 FIND v(dout0_32) AT=80.05n

.meas tran vdout0_33ck70 FIND v(dout0_33) AT=80.05n

.meas tran vdout0_34ck70 FIND v(dout0_34) AT=80.05n

.meas tran vdout0_35ck70 FIND v(dout0_35) AT=80.05n

.meas tran vdout0_36ck70 FIND v(dout0_36) AT=80.05n

.meas tran vdout0_37ck70 FIND v(dout0_37) AT=80.05n

.meas tran vdout0_38ck70 FIND v(dout0_38) AT=80.05n

.meas tran vdout0_39ck70 FIND v(dout0_39) AT=80.05n

.meas tran vdout0_40ck70 FIND v(dout0_40) AT=80.05n

.meas tran vdout0_41ck70 FIND v(dout0_41) AT=80.05n

.meas tran vdout0_42ck70 FIND v(dout0_42) AT=80.05n

.meas tran vdout0_43ck70 FIND v(dout0_43) AT=80.05n

.meas tran vdout0_44ck70 FIND v(dout0_44) AT=80.05n

.meas tran vdout0_45ck70 FIND v(dout0_45) AT=80.05n

.meas tran vdout0_46ck70 FIND v(dout0_46) AT=80.05n

.meas tran vdout0_47ck70 FIND v(dout0_47) AT=80.05n

.meas tran vdout0_48ck70 FIND v(dout0_48) AT=80.05n

.meas tran vdout0_49ck70 FIND v(dout0_49) AT=80.05n

.meas tran vdout0_50ck70 FIND v(dout0_50) AT=80.05n

.meas tran vdout0_51ck70 FIND v(dout0_51) AT=80.05n

.meas tran vdout0_52ck70 FIND v(dout0_52) AT=80.05n

.meas tran vdout0_53ck70 FIND v(dout0_53) AT=80.05n

.meas tran vdout0_54ck70 FIND v(dout0_54) AT=80.05n

.meas tran vdout0_55ck70 FIND v(dout0_55) AT=80.05n

.meas tran vdout0_56ck70 FIND v(dout0_56) AT=80.05n

.meas tran vdout0_57ck70 FIND v(dout0_57) AT=80.05n

.meas tran vdout0_58ck70 FIND v(dout0_58) AT=80.05n

.meas tran vdout0_59ck70 FIND v(dout0_59) AT=80.05n

.meas tran vdout0_60ck70 FIND v(dout0_60) AT=80.05n

.meas tran vdout0_61ck70 FIND v(dout0_61) AT=80.05n

.meas tran vdout0_62ck70 FIND v(dout0_62) AT=80.05n

.meas tran vdout0_63ck70 FIND v(dout0_63) AT=80.05n

.meas tran vdout0_64ck70 FIND v(dout0_64) AT=80.05n

.meas tran vdout0_0ck90 FIND v(dout0_0) AT=100.05n

.meas tran vdout0_1ck90 FIND v(dout0_1) AT=100.05n

.meas tran vdout0_2ck90 FIND v(dout0_2) AT=100.05n

.meas tran vdout0_3ck90 FIND v(dout0_3) AT=100.05n

.meas tran vdout0_4ck90 FIND v(dout0_4) AT=100.05n

.meas tran vdout0_5ck90 FIND v(dout0_5) AT=100.05n

.meas tran vdout0_6ck90 FIND v(dout0_6) AT=100.05n

.meas tran vdout0_7ck90 FIND v(dout0_7) AT=100.05n

.meas tran vdout0_8ck90 FIND v(dout0_8) AT=100.05n

.meas tran vdout0_9ck90 FIND v(dout0_9) AT=100.05n

.meas tran vdout0_10ck90 FIND v(dout0_10) AT=100.05n

.meas tran vdout0_11ck90 FIND v(dout0_11) AT=100.05n

.meas tran vdout0_12ck90 FIND v(dout0_12) AT=100.05n

.meas tran vdout0_13ck90 FIND v(dout0_13) AT=100.05n

.meas tran vdout0_14ck90 FIND v(dout0_14) AT=100.05n

.meas tran vdout0_15ck90 FIND v(dout0_15) AT=100.05n

.meas tran vdout0_16ck90 FIND v(dout0_16) AT=100.05n

.meas tran vdout0_17ck90 FIND v(dout0_17) AT=100.05n

.meas tran vdout0_18ck90 FIND v(dout0_18) AT=100.05n

.meas tran vdout0_19ck90 FIND v(dout0_19) AT=100.05n

.meas tran vdout0_20ck90 FIND v(dout0_20) AT=100.05n

.meas tran vdout0_21ck90 FIND v(dout0_21) AT=100.05n

.meas tran vdout0_22ck90 FIND v(dout0_22) AT=100.05n

.meas tran vdout0_23ck90 FIND v(dout0_23) AT=100.05n

.meas tran vdout0_24ck90 FIND v(dout0_24) AT=100.05n

.meas tran vdout0_25ck90 FIND v(dout0_25) AT=100.05n

.meas tran vdout0_26ck90 FIND v(dout0_26) AT=100.05n

.meas tran vdout0_27ck90 FIND v(dout0_27) AT=100.05n

.meas tran vdout0_28ck90 FIND v(dout0_28) AT=100.05n

.meas tran vdout0_29ck90 FIND v(dout0_29) AT=100.05n

.meas tran vdout0_30ck90 FIND v(dout0_30) AT=100.05n

.meas tran vdout0_31ck90 FIND v(dout0_31) AT=100.05n

.meas tran vdout0_32ck90 FIND v(dout0_32) AT=100.05n

.meas tran vdout0_33ck90 FIND v(dout0_33) AT=100.05n

.meas tran vdout0_34ck90 FIND v(dout0_34) AT=100.05n

.meas tran vdout0_35ck90 FIND v(dout0_35) AT=100.05n

.meas tran vdout0_36ck90 FIND v(dout0_36) AT=100.05n

.meas tran vdout0_37ck90 FIND v(dout0_37) AT=100.05n

.meas tran vdout0_38ck90 FIND v(dout0_38) AT=100.05n

.meas tran vdout0_39ck90 FIND v(dout0_39) AT=100.05n

.meas tran vdout0_40ck90 FIND v(dout0_40) AT=100.05n

.meas tran vdout0_41ck90 FIND v(dout0_41) AT=100.05n

.meas tran vdout0_42ck90 FIND v(dout0_42) AT=100.05n

.meas tran vdout0_43ck90 FIND v(dout0_43) AT=100.05n

.meas tran vdout0_44ck90 FIND v(dout0_44) AT=100.05n

.meas tran vdout0_45ck90 FIND v(dout0_45) AT=100.05n

.meas tran vdout0_46ck90 FIND v(dout0_46) AT=100.05n

.meas tran vdout0_47ck90 FIND v(dout0_47) AT=100.05n

.meas tran vdout0_48ck90 FIND v(dout0_48) AT=100.05n

.meas tran vdout0_49ck90 FIND v(dout0_49) AT=100.05n

.meas tran vdout0_50ck90 FIND v(dout0_50) AT=100.05n

.meas tran vdout0_51ck90 FIND v(dout0_51) AT=100.05n

.meas tran vdout0_52ck90 FIND v(dout0_52) AT=100.05n

.meas tran vdout0_53ck90 FIND v(dout0_53) AT=100.05n

.meas tran vdout0_54ck90 FIND v(dout0_54) AT=100.05n

.meas tran vdout0_55ck90 FIND v(dout0_55) AT=100.05n

.meas tran vdout0_56ck90 FIND v(dout0_56) AT=100.05n

.meas tran vdout0_57ck90 FIND v(dout0_57) AT=100.05n

.meas tran vdout0_58ck90 FIND v(dout0_58) AT=100.05n

.meas tran vdout0_59ck90 FIND v(dout0_59) AT=100.05n

.meas tran vdout0_60ck90 FIND v(dout0_60) AT=100.05n

.meas tran vdout0_61ck90 FIND v(dout0_61) AT=100.05n

.meas tran vdout0_62ck90 FIND v(dout0_62) AT=100.05n

.meas tran vdout0_63ck90 FIND v(dout0_63) AT=100.05n

.meas tran vdout0_64ck90 FIND v(dout0_64) AT=100.05n

.meas tran vdout0_0ck100 FIND v(dout0_0) AT=110.05n

.meas tran vdout0_1ck100 FIND v(dout0_1) AT=110.05n

.meas tran vdout0_2ck100 FIND v(dout0_2) AT=110.05n

.meas tran vdout0_3ck100 FIND v(dout0_3) AT=110.05n

.meas tran vdout0_4ck100 FIND v(dout0_4) AT=110.05n

.meas tran vdout0_5ck100 FIND v(dout0_5) AT=110.05n

.meas tran vdout0_6ck100 FIND v(dout0_6) AT=110.05n

.meas tran vdout0_7ck100 FIND v(dout0_7) AT=110.05n

.meas tran vdout0_8ck100 FIND v(dout0_8) AT=110.05n

.meas tran vdout0_9ck100 FIND v(dout0_9) AT=110.05n

.meas tran vdout0_10ck100 FIND v(dout0_10) AT=110.05n

.meas tran vdout0_11ck100 FIND v(dout0_11) AT=110.05n

.meas tran vdout0_12ck100 FIND v(dout0_12) AT=110.05n

.meas tran vdout0_13ck100 FIND v(dout0_13) AT=110.05n

.meas tran vdout0_14ck100 FIND v(dout0_14) AT=110.05n

.meas tran vdout0_15ck100 FIND v(dout0_15) AT=110.05n

.meas tran vdout0_16ck100 FIND v(dout0_16) AT=110.05n

.meas tran vdout0_17ck100 FIND v(dout0_17) AT=110.05n

.meas tran vdout0_18ck100 FIND v(dout0_18) AT=110.05n

.meas tran vdout0_19ck100 FIND v(dout0_19) AT=110.05n

.meas tran vdout0_20ck100 FIND v(dout0_20) AT=110.05n

.meas tran vdout0_21ck100 FIND v(dout0_21) AT=110.05n

.meas tran vdout0_22ck100 FIND v(dout0_22) AT=110.05n

.meas tran vdout0_23ck100 FIND v(dout0_23) AT=110.05n

.meas tran vdout0_24ck100 FIND v(dout0_24) AT=110.05n

.meas tran vdout0_25ck100 FIND v(dout0_25) AT=110.05n

.meas tran vdout0_26ck100 FIND v(dout0_26) AT=110.05n

.meas tran vdout0_27ck100 FIND v(dout0_27) AT=110.05n

.meas tran vdout0_28ck100 FIND v(dout0_28) AT=110.05n

.meas tran vdout0_29ck100 FIND v(dout0_29) AT=110.05n

.meas tran vdout0_30ck100 FIND v(dout0_30) AT=110.05n

.meas tran vdout0_31ck100 FIND v(dout0_31) AT=110.05n

.meas tran vdout0_32ck100 FIND v(dout0_32) AT=110.05n

.meas tran vdout0_33ck100 FIND v(dout0_33) AT=110.05n

.meas tran vdout0_34ck100 FIND v(dout0_34) AT=110.05n

.meas tran vdout0_35ck100 FIND v(dout0_35) AT=110.05n

.meas tran vdout0_36ck100 FIND v(dout0_36) AT=110.05n

.meas tran vdout0_37ck100 FIND v(dout0_37) AT=110.05n

.meas tran vdout0_38ck100 FIND v(dout0_38) AT=110.05n

.meas tran vdout0_39ck100 FIND v(dout0_39) AT=110.05n

.meas tran vdout0_40ck100 FIND v(dout0_40) AT=110.05n

.meas tran vdout0_41ck100 FIND v(dout0_41) AT=110.05n

.meas tran vdout0_42ck100 FIND v(dout0_42) AT=110.05n

.meas tran vdout0_43ck100 FIND v(dout0_43) AT=110.05n

.meas tran vdout0_44ck100 FIND v(dout0_44) AT=110.05n

.meas tran vdout0_45ck100 FIND v(dout0_45) AT=110.05n

.meas tran vdout0_46ck100 FIND v(dout0_46) AT=110.05n

.meas tran vdout0_47ck100 FIND v(dout0_47) AT=110.05n

.meas tran vdout0_48ck100 FIND v(dout0_48) AT=110.05n

.meas tran vdout0_49ck100 FIND v(dout0_49) AT=110.05n

.meas tran vdout0_50ck100 FIND v(dout0_50) AT=110.05n

.meas tran vdout0_51ck100 FIND v(dout0_51) AT=110.05n

.meas tran vdout0_52ck100 FIND v(dout0_52) AT=110.05n

.meas tran vdout0_53ck100 FIND v(dout0_53) AT=110.05n

.meas tran vdout0_54ck100 FIND v(dout0_54) AT=110.05n

.meas tran vdout0_55ck100 FIND v(dout0_55) AT=110.05n

.meas tran vdout0_56ck100 FIND v(dout0_56) AT=110.05n

.meas tran vdout0_57ck100 FIND v(dout0_57) AT=110.05n

.meas tran vdout0_58ck100 FIND v(dout0_58) AT=110.05n

.meas tran vdout0_59ck100 FIND v(dout0_59) AT=110.05n

.meas tran vdout0_60ck100 FIND v(dout0_60) AT=110.05n

.meas tran vdout0_61ck100 FIND v(dout0_61) AT=110.05n

.meas tran vdout0_62ck100 FIND v(dout0_62) AT=110.05n

.meas tran vdout0_63ck100 FIND v(dout0_63) AT=110.05n

.meas tran vdout0_64ck100 FIND v(dout0_64) AT=110.05n

.meas tran vdout0_0ck110 FIND v(dout0_0) AT=120.05n

.meas tran vdout0_1ck110 FIND v(dout0_1) AT=120.05n

.meas tran vdout0_2ck110 FIND v(dout0_2) AT=120.05n

.meas tran vdout0_3ck110 FIND v(dout0_3) AT=120.05n

.meas tran vdout0_4ck110 FIND v(dout0_4) AT=120.05n

.meas tran vdout0_5ck110 FIND v(dout0_5) AT=120.05n

.meas tran vdout0_6ck110 FIND v(dout0_6) AT=120.05n

.meas tran vdout0_7ck110 FIND v(dout0_7) AT=120.05n

.meas tran vdout0_8ck110 FIND v(dout0_8) AT=120.05n

.meas tran vdout0_9ck110 FIND v(dout0_9) AT=120.05n

.meas tran vdout0_10ck110 FIND v(dout0_10) AT=120.05n

.meas tran vdout0_11ck110 FIND v(dout0_11) AT=120.05n

.meas tran vdout0_12ck110 FIND v(dout0_12) AT=120.05n

.meas tran vdout0_13ck110 FIND v(dout0_13) AT=120.05n

.meas tran vdout0_14ck110 FIND v(dout0_14) AT=120.05n

.meas tran vdout0_15ck110 FIND v(dout0_15) AT=120.05n

.meas tran vdout0_16ck110 FIND v(dout0_16) AT=120.05n

.meas tran vdout0_17ck110 FIND v(dout0_17) AT=120.05n

.meas tran vdout0_18ck110 FIND v(dout0_18) AT=120.05n

.meas tran vdout0_19ck110 FIND v(dout0_19) AT=120.05n

.meas tran vdout0_20ck110 FIND v(dout0_20) AT=120.05n

.meas tran vdout0_21ck110 FIND v(dout0_21) AT=120.05n

.meas tran vdout0_22ck110 FIND v(dout0_22) AT=120.05n

.meas tran vdout0_23ck110 FIND v(dout0_23) AT=120.05n

.meas tran vdout0_24ck110 FIND v(dout0_24) AT=120.05n

.meas tran vdout0_25ck110 FIND v(dout0_25) AT=120.05n

.meas tran vdout0_26ck110 FIND v(dout0_26) AT=120.05n

.meas tran vdout0_27ck110 FIND v(dout0_27) AT=120.05n

.meas tran vdout0_28ck110 FIND v(dout0_28) AT=120.05n

.meas tran vdout0_29ck110 FIND v(dout0_29) AT=120.05n

.meas tran vdout0_30ck110 FIND v(dout0_30) AT=120.05n

.meas tran vdout0_31ck110 FIND v(dout0_31) AT=120.05n

.meas tran vdout0_32ck110 FIND v(dout0_32) AT=120.05n

.meas tran vdout0_33ck110 FIND v(dout0_33) AT=120.05n

.meas tran vdout0_34ck110 FIND v(dout0_34) AT=120.05n

.meas tran vdout0_35ck110 FIND v(dout0_35) AT=120.05n

.meas tran vdout0_36ck110 FIND v(dout0_36) AT=120.05n

.meas tran vdout0_37ck110 FIND v(dout0_37) AT=120.05n

.meas tran vdout0_38ck110 FIND v(dout0_38) AT=120.05n

.meas tran vdout0_39ck110 FIND v(dout0_39) AT=120.05n

.meas tran vdout0_40ck110 FIND v(dout0_40) AT=120.05n

.meas tran vdout0_41ck110 FIND v(dout0_41) AT=120.05n

.meas tran vdout0_42ck110 FIND v(dout0_42) AT=120.05n

.meas tran vdout0_43ck110 FIND v(dout0_43) AT=120.05n

.meas tran vdout0_44ck110 FIND v(dout0_44) AT=120.05n

.meas tran vdout0_45ck110 FIND v(dout0_45) AT=120.05n

.meas tran vdout0_46ck110 FIND v(dout0_46) AT=120.05n

.meas tran vdout0_47ck110 FIND v(dout0_47) AT=120.05n

.meas tran vdout0_48ck110 FIND v(dout0_48) AT=120.05n

.meas tran vdout0_49ck110 FIND v(dout0_49) AT=120.05n

.meas tran vdout0_50ck110 FIND v(dout0_50) AT=120.05n

.meas tran vdout0_51ck110 FIND v(dout0_51) AT=120.05n

.meas tran vdout0_52ck110 FIND v(dout0_52) AT=120.05n

.meas tran vdout0_53ck110 FIND v(dout0_53) AT=120.05n

.meas tran vdout0_54ck110 FIND v(dout0_54) AT=120.05n

.meas tran vdout0_55ck110 FIND v(dout0_55) AT=120.05n

.meas tran vdout0_56ck110 FIND v(dout0_56) AT=120.05n

.meas tran vdout0_57ck110 FIND v(dout0_57) AT=120.05n

.meas tran vdout0_58ck110 FIND v(dout0_58) AT=120.05n

.meas tran vdout0_59ck110 FIND v(dout0_59) AT=120.05n

.meas tran vdout0_60ck110 FIND v(dout0_60) AT=120.05n

.meas tran vdout0_61ck110 FIND v(dout0_61) AT=120.05n

.meas tran vdout0_62ck110 FIND v(dout0_62) AT=120.05n

.meas tran vdout0_63ck110 FIND v(dout0_63) AT=120.05n

.meas tran vdout0_64ck110 FIND v(dout0_64) AT=120.05n

.meas tran vdout0_0ck120 FIND v(dout0_0) AT=130.05n

.meas tran vdout0_1ck120 FIND v(dout0_1) AT=130.05n

.meas tran vdout0_2ck120 FIND v(dout0_2) AT=130.05n

.meas tran vdout0_3ck120 FIND v(dout0_3) AT=130.05n

.meas tran vdout0_4ck120 FIND v(dout0_4) AT=130.05n

.meas tran vdout0_5ck120 FIND v(dout0_5) AT=130.05n

.meas tran vdout0_6ck120 FIND v(dout0_6) AT=130.05n

.meas tran vdout0_7ck120 FIND v(dout0_7) AT=130.05n

.meas tran vdout0_8ck120 FIND v(dout0_8) AT=130.05n

.meas tran vdout0_9ck120 FIND v(dout0_9) AT=130.05n

.meas tran vdout0_10ck120 FIND v(dout0_10) AT=130.05n

.meas tran vdout0_11ck120 FIND v(dout0_11) AT=130.05n

.meas tran vdout0_12ck120 FIND v(dout0_12) AT=130.05n

.meas tran vdout0_13ck120 FIND v(dout0_13) AT=130.05n

.meas tran vdout0_14ck120 FIND v(dout0_14) AT=130.05n

.meas tran vdout0_15ck120 FIND v(dout0_15) AT=130.05n

.meas tran vdout0_16ck120 FIND v(dout0_16) AT=130.05n

.meas tran vdout0_17ck120 FIND v(dout0_17) AT=130.05n

.meas tran vdout0_18ck120 FIND v(dout0_18) AT=130.05n

.meas tran vdout0_19ck120 FIND v(dout0_19) AT=130.05n

.meas tran vdout0_20ck120 FIND v(dout0_20) AT=130.05n

.meas tran vdout0_21ck120 FIND v(dout0_21) AT=130.05n

.meas tran vdout0_22ck120 FIND v(dout0_22) AT=130.05n

.meas tran vdout0_23ck120 FIND v(dout0_23) AT=130.05n

.meas tran vdout0_24ck120 FIND v(dout0_24) AT=130.05n

.meas tran vdout0_25ck120 FIND v(dout0_25) AT=130.05n

.meas tran vdout0_26ck120 FIND v(dout0_26) AT=130.05n

.meas tran vdout0_27ck120 FIND v(dout0_27) AT=130.05n

.meas tran vdout0_28ck120 FIND v(dout0_28) AT=130.05n

.meas tran vdout0_29ck120 FIND v(dout0_29) AT=130.05n

.meas tran vdout0_30ck120 FIND v(dout0_30) AT=130.05n

.meas tran vdout0_31ck120 FIND v(dout0_31) AT=130.05n

.meas tran vdout0_32ck120 FIND v(dout0_32) AT=130.05n

.meas tran vdout0_33ck120 FIND v(dout0_33) AT=130.05n

.meas tran vdout0_34ck120 FIND v(dout0_34) AT=130.05n

.meas tran vdout0_35ck120 FIND v(dout0_35) AT=130.05n

.meas tran vdout0_36ck120 FIND v(dout0_36) AT=130.05n

.meas tran vdout0_37ck120 FIND v(dout0_37) AT=130.05n

.meas tran vdout0_38ck120 FIND v(dout0_38) AT=130.05n

.meas tran vdout0_39ck120 FIND v(dout0_39) AT=130.05n

.meas tran vdout0_40ck120 FIND v(dout0_40) AT=130.05n

.meas tran vdout0_41ck120 FIND v(dout0_41) AT=130.05n

.meas tran vdout0_42ck120 FIND v(dout0_42) AT=130.05n

.meas tran vdout0_43ck120 FIND v(dout0_43) AT=130.05n

.meas tran vdout0_44ck120 FIND v(dout0_44) AT=130.05n

.meas tran vdout0_45ck120 FIND v(dout0_45) AT=130.05n

.meas tran vdout0_46ck120 FIND v(dout0_46) AT=130.05n

.meas tran vdout0_47ck120 FIND v(dout0_47) AT=130.05n

.meas tran vdout0_48ck120 FIND v(dout0_48) AT=130.05n

.meas tran vdout0_49ck120 FIND v(dout0_49) AT=130.05n

.meas tran vdout0_50ck120 FIND v(dout0_50) AT=130.05n

.meas tran vdout0_51ck120 FIND v(dout0_51) AT=130.05n

.meas tran vdout0_52ck120 FIND v(dout0_52) AT=130.05n

.meas tran vdout0_53ck120 FIND v(dout0_53) AT=130.05n

.meas tran vdout0_54ck120 FIND v(dout0_54) AT=130.05n

.meas tran vdout0_55ck120 FIND v(dout0_55) AT=130.05n

.meas tran vdout0_56ck120 FIND v(dout0_56) AT=130.05n

.meas tran vdout0_57ck120 FIND v(dout0_57) AT=130.05n

.meas tran vdout0_58ck120 FIND v(dout0_58) AT=130.05n

.meas tran vdout0_59ck120 FIND v(dout0_59) AT=130.05n

.meas tran vdout0_60ck120 FIND v(dout0_60) AT=130.05n

.meas tran vdout0_61ck120 FIND v(dout0_61) AT=130.05n

.meas tran vdout0_62ck120 FIND v(dout0_62) AT=130.05n

.meas tran vdout0_63ck120 FIND v(dout0_63) AT=130.05n

.meas tran vdout0_64ck120 FIND v(dout0_64) AT=130.05n

.meas tran vdout0_0ck150 FIND v(dout0_0) AT=160.05n

.meas tran vdout0_1ck150 FIND v(dout0_1) AT=160.05n

.meas tran vdout0_2ck150 FIND v(dout0_2) AT=160.05n

.meas tran vdout0_3ck150 FIND v(dout0_3) AT=160.05n

.meas tran vdout0_4ck150 FIND v(dout0_4) AT=160.05n

.meas tran vdout0_5ck150 FIND v(dout0_5) AT=160.05n

.meas tran vdout0_6ck150 FIND v(dout0_6) AT=160.05n

.meas tran vdout0_7ck150 FIND v(dout0_7) AT=160.05n

.meas tran vdout0_8ck150 FIND v(dout0_8) AT=160.05n

.meas tran vdout0_9ck150 FIND v(dout0_9) AT=160.05n

.meas tran vdout0_10ck150 FIND v(dout0_10) AT=160.05n

.meas tran vdout0_11ck150 FIND v(dout0_11) AT=160.05n

.meas tran vdout0_12ck150 FIND v(dout0_12) AT=160.05n

.meas tran vdout0_13ck150 FIND v(dout0_13) AT=160.05n

.meas tran vdout0_14ck150 FIND v(dout0_14) AT=160.05n

.meas tran vdout0_15ck150 FIND v(dout0_15) AT=160.05n

.meas tran vdout0_16ck150 FIND v(dout0_16) AT=160.05n

.meas tran vdout0_17ck150 FIND v(dout0_17) AT=160.05n

.meas tran vdout0_18ck150 FIND v(dout0_18) AT=160.05n

.meas tran vdout0_19ck150 FIND v(dout0_19) AT=160.05n

.meas tran vdout0_20ck150 FIND v(dout0_20) AT=160.05n

.meas tran vdout0_21ck150 FIND v(dout0_21) AT=160.05n

.meas tran vdout0_22ck150 FIND v(dout0_22) AT=160.05n

.meas tran vdout0_23ck150 FIND v(dout0_23) AT=160.05n

.meas tran vdout0_24ck150 FIND v(dout0_24) AT=160.05n

.meas tran vdout0_25ck150 FIND v(dout0_25) AT=160.05n

.meas tran vdout0_26ck150 FIND v(dout0_26) AT=160.05n

.meas tran vdout0_27ck150 FIND v(dout0_27) AT=160.05n

.meas tran vdout0_28ck150 FIND v(dout0_28) AT=160.05n

.meas tran vdout0_29ck150 FIND v(dout0_29) AT=160.05n

.meas tran vdout0_30ck150 FIND v(dout0_30) AT=160.05n

.meas tran vdout0_31ck150 FIND v(dout0_31) AT=160.05n

.meas tran vdout0_32ck150 FIND v(dout0_32) AT=160.05n

.meas tran vdout0_33ck150 FIND v(dout0_33) AT=160.05n

.meas tran vdout0_34ck150 FIND v(dout0_34) AT=160.05n

.meas tran vdout0_35ck150 FIND v(dout0_35) AT=160.05n

.meas tran vdout0_36ck150 FIND v(dout0_36) AT=160.05n

.meas tran vdout0_37ck150 FIND v(dout0_37) AT=160.05n

.meas tran vdout0_38ck150 FIND v(dout0_38) AT=160.05n

.meas tran vdout0_39ck150 FIND v(dout0_39) AT=160.05n

.meas tran vdout0_40ck150 FIND v(dout0_40) AT=160.05n

.meas tran vdout0_41ck150 FIND v(dout0_41) AT=160.05n

.meas tran vdout0_42ck150 FIND v(dout0_42) AT=160.05n

.meas tran vdout0_43ck150 FIND v(dout0_43) AT=160.05n

.meas tran vdout0_44ck150 FIND v(dout0_44) AT=160.05n

.meas tran vdout0_45ck150 FIND v(dout0_45) AT=160.05n

.meas tran vdout0_46ck150 FIND v(dout0_46) AT=160.05n

.meas tran vdout0_47ck150 FIND v(dout0_47) AT=160.05n

.meas tran vdout0_48ck150 FIND v(dout0_48) AT=160.05n

.meas tran vdout0_49ck150 FIND v(dout0_49) AT=160.05n

.meas tran vdout0_50ck150 FIND v(dout0_50) AT=160.05n

.meas tran vdout0_51ck150 FIND v(dout0_51) AT=160.05n

.meas tran vdout0_52ck150 FIND v(dout0_52) AT=160.05n

.meas tran vdout0_53ck150 FIND v(dout0_53) AT=160.05n

.meas tran vdout0_54ck150 FIND v(dout0_54) AT=160.05n

.meas tran vdout0_55ck150 FIND v(dout0_55) AT=160.05n

.meas tran vdout0_56ck150 FIND v(dout0_56) AT=160.05n

.meas tran vdout0_57ck150 FIND v(dout0_57) AT=160.05n

.meas tran vdout0_58ck150 FIND v(dout0_58) AT=160.05n

.meas tran vdout0_59ck150 FIND v(dout0_59) AT=160.05n

.meas tran vdout0_60ck150 FIND v(dout0_60) AT=160.05n

.meas tran vdout0_61ck150 FIND v(dout0_61) AT=160.05n

.meas tran vdout0_62ck150 FIND v(dout0_62) AT=160.05n

.meas tran vdout0_63ck150 FIND v(dout0_63) AT=160.05n

.meas tran vdout0_64ck150 FIND v(dout0_64) AT=160.05n

.meas tran vdout0_0ck170 FIND v(dout0_0) AT=180.05n

.meas tran vdout0_1ck170 FIND v(dout0_1) AT=180.05n

.meas tran vdout0_2ck170 FIND v(dout0_2) AT=180.05n

.meas tran vdout0_3ck170 FIND v(dout0_3) AT=180.05n

.meas tran vdout0_4ck170 FIND v(dout0_4) AT=180.05n

.meas tran vdout0_5ck170 FIND v(dout0_5) AT=180.05n

.meas tran vdout0_6ck170 FIND v(dout0_6) AT=180.05n

.meas tran vdout0_7ck170 FIND v(dout0_7) AT=180.05n

.meas tran vdout0_8ck170 FIND v(dout0_8) AT=180.05n

.meas tran vdout0_9ck170 FIND v(dout0_9) AT=180.05n

.meas tran vdout0_10ck170 FIND v(dout0_10) AT=180.05n

.meas tran vdout0_11ck170 FIND v(dout0_11) AT=180.05n

.meas tran vdout0_12ck170 FIND v(dout0_12) AT=180.05n

.meas tran vdout0_13ck170 FIND v(dout0_13) AT=180.05n

.meas tran vdout0_14ck170 FIND v(dout0_14) AT=180.05n

.meas tran vdout0_15ck170 FIND v(dout0_15) AT=180.05n

.meas tran vdout0_16ck170 FIND v(dout0_16) AT=180.05n

.meas tran vdout0_17ck170 FIND v(dout0_17) AT=180.05n

.meas tran vdout0_18ck170 FIND v(dout0_18) AT=180.05n

.meas tran vdout0_19ck170 FIND v(dout0_19) AT=180.05n

.meas tran vdout0_20ck170 FIND v(dout0_20) AT=180.05n

.meas tran vdout0_21ck170 FIND v(dout0_21) AT=180.05n

.meas tran vdout0_22ck170 FIND v(dout0_22) AT=180.05n

.meas tran vdout0_23ck170 FIND v(dout0_23) AT=180.05n

.meas tran vdout0_24ck170 FIND v(dout0_24) AT=180.05n

.meas tran vdout0_25ck170 FIND v(dout0_25) AT=180.05n

.meas tran vdout0_26ck170 FIND v(dout0_26) AT=180.05n

.meas tran vdout0_27ck170 FIND v(dout0_27) AT=180.05n

.meas tran vdout0_28ck170 FIND v(dout0_28) AT=180.05n

.meas tran vdout0_29ck170 FIND v(dout0_29) AT=180.05n

.meas tran vdout0_30ck170 FIND v(dout0_30) AT=180.05n

.meas tran vdout0_31ck170 FIND v(dout0_31) AT=180.05n

.meas tran vdout0_32ck170 FIND v(dout0_32) AT=180.05n

.meas tran vdout0_33ck170 FIND v(dout0_33) AT=180.05n

.meas tran vdout0_34ck170 FIND v(dout0_34) AT=180.05n

.meas tran vdout0_35ck170 FIND v(dout0_35) AT=180.05n

.meas tran vdout0_36ck170 FIND v(dout0_36) AT=180.05n

.meas tran vdout0_37ck170 FIND v(dout0_37) AT=180.05n

.meas tran vdout0_38ck170 FIND v(dout0_38) AT=180.05n

.meas tran vdout0_39ck170 FIND v(dout0_39) AT=180.05n

.meas tran vdout0_40ck170 FIND v(dout0_40) AT=180.05n

.meas tran vdout0_41ck170 FIND v(dout0_41) AT=180.05n

.meas tran vdout0_42ck170 FIND v(dout0_42) AT=180.05n

.meas tran vdout0_43ck170 FIND v(dout0_43) AT=180.05n

.meas tran vdout0_44ck170 FIND v(dout0_44) AT=180.05n

.meas tran vdout0_45ck170 FIND v(dout0_45) AT=180.05n

.meas tran vdout0_46ck170 FIND v(dout0_46) AT=180.05n

.meas tran vdout0_47ck170 FIND v(dout0_47) AT=180.05n

.meas tran vdout0_48ck170 FIND v(dout0_48) AT=180.05n

.meas tran vdout0_49ck170 FIND v(dout0_49) AT=180.05n

.meas tran vdout0_50ck170 FIND v(dout0_50) AT=180.05n

.meas tran vdout0_51ck170 FIND v(dout0_51) AT=180.05n

.meas tran vdout0_52ck170 FIND v(dout0_52) AT=180.05n

.meas tran vdout0_53ck170 FIND v(dout0_53) AT=180.05n

.meas tran vdout0_54ck170 FIND v(dout0_54) AT=180.05n

.meas tran vdout0_55ck170 FIND v(dout0_55) AT=180.05n

.meas tran vdout0_56ck170 FIND v(dout0_56) AT=180.05n

.meas tran vdout0_57ck170 FIND v(dout0_57) AT=180.05n

.meas tran vdout0_58ck170 FIND v(dout0_58) AT=180.05n

.meas tran vdout0_59ck170 FIND v(dout0_59) AT=180.05n

.meas tran vdout0_60ck170 FIND v(dout0_60) AT=180.05n

.meas tran vdout0_61ck170 FIND v(dout0_61) AT=180.05n

.meas tran vdout0_62ck170 FIND v(dout0_62) AT=180.05n

.meas tran vdout0_63ck170 FIND v(dout0_63) AT=180.05n

.meas tran vdout0_64ck170 FIND v(dout0_64) AT=180.05n

.meas tran vdout0_0ck190 FIND v(dout0_0) AT=200.05n

.meas tran vdout0_1ck190 FIND v(dout0_1) AT=200.05n

.meas tran vdout0_2ck190 FIND v(dout0_2) AT=200.05n

.meas tran vdout0_3ck190 FIND v(dout0_3) AT=200.05n

.meas tran vdout0_4ck190 FIND v(dout0_4) AT=200.05n

.meas tran vdout0_5ck190 FIND v(dout0_5) AT=200.05n

.meas tran vdout0_6ck190 FIND v(dout0_6) AT=200.05n

.meas tran vdout0_7ck190 FIND v(dout0_7) AT=200.05n

.meas tran vdout0_8ck190 FIND v(dout0_8) AT=200.05n

.meas tran vdout0_9ck190 FIND v(dout0_9) AT=200.05n

.meas tran vdout0_10ck190 FIND v(dout0_10) AT=200.05n

.meas tran vdout0_11ck190 FIND v(dout0_11) AT=200.05n

.meas tran vdout0_12ck190 FIND v(dout0_12) AT=200.05n

.meas tran vdout0_13ck190 FIND v(dout0_13) AT=200.05n

.meas tran vdout0_14ck190 FIND v(dout0_14) AT=200.05n

.meas tran vdout0_15ck190 FIND v(dout0_15) AT=200.05n

.meas tran vdout0_16ck190 FIND v(dout0_16) AT=200.05n

.meas tran vdout0_17ck190 FIND v(dout0_17) AT=200.05n

.meas tran vdout0_18ck190 FIND v(dout0_18) AT=200.05n

.meas tran vdout0_19ck190 FIND v(dout0_19) AT=200.05n

.meas tran vdout0_20ck190 FIND v(dout0_20) AT=200.05n

.meas tran vdout0_21ck190 FIND v(dout0_21) AT=200.05n

.meas tran vdout0_22ck190 FIND v(dout0_22) AT=200.05n

.meas tran vdout0_23ck190 FIND v(dout0_23) AT=200.05n

.meas tran vdout0_24ck190 FIND v(dout0_24) AT=200.05n

.meas tran vdout0_25ck190 FIND v(dout0_25) AT=200.05n

.meas tran vdout0_26ck190 FIND v(dout0_26) AT=200.05n

.meas tran vdout0_27ck190 FIND v(dout0_27) AT=200.05n

.meas tran vdout0_28ck190 FIND v(dout0_28) AT=200.05n

.meas tran vdout0_29ck190 FIND v(dout0_29) AT=200.05n

.meas tran vdout0_30ck190 FIND v(dout0_30) AT=200.05n

.meas tran vdout0_31ck190 FIND v(dout0_31) AT=200.05n

.meas tran vdout0_32ck190 FIND v(dout0_32) AT=200.05n

.meas tran vdout0_33ck190 FIND v(dout0_33) AT=200.05n

.meas tran vdout0_34ck190 FIND v(dout0_34) AT=200.05n

.meas tran vdout0_35ck190 FIND v(dout0_35) AT=200.05n

.meas tran vdout0_36ck190 FIND v(dout0_36) AT=200.05n

.meas tran vdout0_37ck190 FIND v(dout0_37) AT=200.05n

.meas tran vdout0_38ck190 FIND v(dout0_38) AT=200.05n

.meas tran vdout0_39ck190 FIND v(dout0_39) AT=200.05n

.meas tran vdout0_40ck190 FIND v(dout0_40) AT=200.05n

.meas tran vdout0_41ck190 FIND v(dout0_41) AT=200.05n

.meas tran vdout0_42ck190 FIND v(dout0_42) AT=200.05n

.meas tran vdout0_43ck190 FIND v(dout0_43) AT=200.05n

.meas tran vdout0_44ck190 FIND v(dout0_44) AT=200.05n

.meas tran vdout0_45ck190 FIND v(dout0_45) AT=200.05n

.meas tran vdout0_46ck190 FIND v(dout0_46) AT=200.05n

.meas tran vdout0_47ck190 FIND v(dout0_47) AT=200.05n

.meas tran vdout0_48ck190 FIND v(dout0_48) AT=200.05n

.meas tran vdout0_49ck190 FIND v(dout0_49) AT=200.05n

.meas tran vdout0_50ck190 FIND v(dout0_50) AT=200.05n

.meas tran vdout0_51ck190 FIND v(dout0_51) AT=200.05n

.meas tran vdout0_52ck190 FIND v(dout0_52) AT=200.05n

.meas tran vdout0_53ck190 FIND v(dout0_53) AT=200.05n

.meas tran vdout0_54ck190 FIND v(dout0_54) AT=200.05n

.meas tran vdout0_55ck190 FIND v(dout0_55) AT=200.05n

.meas tran vdout0_56ck190 FIND v(dout0_56) AT=200.05n

.meas tran vdout0_57ck190 FIND v(dout0_57) AT=200.05n

.meas tran vdout0_58ck190 FIND v(dout0_58) AT=200.05n

.meas tran vdout0_59ck190 FIND v(dout0_59) AT=200.05n

.meas tran vdout0_60ck190 FIND v(dout0_60) AT=200.05n

.meas tran vdout0_61ck190 FIND v(dout0_61) AT=200.05n

.meas tran vdout0_62ck190 FIND v(dout0_62) AT=200.05n

.meas tran vdout0_63ck190 FIND v(dout0_63) AT=200.05n

.meas tran vdout0_64ck190 FIND v(dout0_64) AT=200.05n

.meas tran vdout0_0ck200 FIND v(dout0_0) AT=210.05n

.meas tran vdout0_1ck200 FIND v(dout0_1) AT=210.05n

.meas tran vdout0_2ck200 FIND v(dout0_2) AT=210.05n

.meas tran vdout0_3ck200 FIND v(dout0_3) AT=210.05n

.meas tran vdout0_4ck200 FIND v(dout0_4) AT=210.05n

.meas tran vdout0_5ck200 FIND v(dout0_5) AT=210.05n

.meas tran vdout0_6ck200 FIND v(dout0_6) AT=210.05n

.meas tran vdout0_7ck200 FIND v(dout0_7) AT=210.05n

.meas tran vdout0_8ck200 FIND v(dout0_8) AT=210.05n

.meas tran vdout0_9ck200 FIND v(dout0_9) AT=210.05n

.meas tran vdout0_10ck200 FIND v(dout0_10) AT=210.05n

.meas tran vdout0_11ck200 FIND v(dout0_11) AT=210.05n

.meas tran vdout0_12ck200 FIND v(dout0_12) AT=210.05n

.meas tran vdout0_13ck200 FIND v(dout0_13) AT=210.05n

.meas tran vdout0_14ck200 FIND v(dout0_14) AT=210.05n

.meas tran vdout0_15ck200 FIND v(dout0_15) AT=210.05n

.meas tran vdout0_16ck200 FIND v(dout0_16) AT=210.05n

.meas tran vdout0_17ck200 FIND v(dout0_17) AT=210.05n

.meas tran vdout0_18ck200 FIND v(dout0_18) AT=210.05n

.meas tran vdout0_19ck200 FIND v(dout0_19) AT=210.05n

.meas tran vdout0_20ck200 FIND v(dout0_20) AT=210.05n

.meas tran vdout0_21ck200 FIND v(dout0_21) AT=210.05n

.meas tran vdout0_22ck200 FIND v(dout0_22) AT=210.05n

.meas tran vdout0_23ck200 FIND v(dout0_23) AT=210.05n

.meas tran vdout0_24ck200 FIND v(dout0_24) AT=210.05n

.meas tran vdout0_25ck200 FIND v(dout0_25) AT=210.05n

.meas tran vdout0_26ck200 FIND v(dout0_26) AT=210.05n

.meas tran vdout0_27ck200 FIND v(dout0_27) AT=210.05n

.meas tran vdout0_28ck200 FIND v(dout0_28) AT=210.05n

.meas tran vdout0_29ck200 FIND v(dout0_29) AT=210.05n

.meas tran vdout0_30ck200 FIND v(dout0_30) AT=210.05n

.meas tran vdout0_31ck200 FIND v(dout0_31) AT=210.05n

.meas tran vdout0_32ck200 FIND v(dout0_32) AT=210.05n

.meas tran vdout0_33ck200 FIND v(dout0_33) AT=210.05n

.meas tran vdout0_34ck200 FIND v(dout0_34) AT=210.05n

.meas tran vdout0_35ck200 FIND v(dout0_35) AT=210.05n

.meas tran vdout0_36ck200 FIND v(dout0_36) AT=210.05n

.meas tran vdout0_37ck200 FIND v(dout0_37) AT=210.05n

.meas tran vdout0_38ck200 FIND v(dout0_38) AT=210.05n

.meas tran vdout0_39ck200 FIND v(dout0_39) AT=210.05n

.meas tran vdout0_40ck200 FIND v(dout0_40) AT=210.05n

.meas tran vdout0_41ck200 FIND v(dout0_41) AT=210.05n

.meas tran vdout0_42ck200 FIND v(dout0_42) AT=210.05n

.meas tran vdout0_43ck200 FIND v(dout0_43) AT=210.05n

.meas tran vdout0_44ck200 FIND v(dout0_44) AT=210.05n

.meas tran vdout0_45ck200 FIND v(dout0_45) AT=210.05n

.meas tran vdout0_46ck200 FIND v(dout0_46) AT=210.05n

.meas tran vdout0_47ck200 FIND v(dout0_47) AT=210.05n

.meas tran vdout0_48ck200 FIND v(dout0_48) AT=210.05n

.meas tran vdout0_49ck200 FIND v(dout0_49) AT=210.05n

.meas tran vdout0_50ck200 FIND v(dout0_50) AT=210.05n

.meas tran vdout0_51ck200 FIND v(dout0_51) AT=210.05n

.meas tran vdout0_52ck200 FIND v(dout0_52) AT=210.05n

.meas tran vdout0_53ck200 FIND v(dout0_53) AT=210.05n

.meas tran vdout0_54ck200 FIND v(dout0_54) AT=210.05n

.meas tran vdout0_55ck200 FIND v(dout0_55) AT=210.05n

.meas tran vdout0_56ck200 FIND v(dout0_56) AT=210.05n

.meas tran vdout0_57ck200 FIND v(dout0_57) AT=210.05n

.meas tran vdout0_58ck200 FIND v(dout0_58) AT=210.05n

.meas tran vdout0_59ck200 FIND v(dout0_59) AT=210.05n

.meas tran vdout0_60ck200 FIND v(dout0_60) AT=210.05n

.meas tran vdout0_61ck200 FIND v(dout0_61) AT=210.05n

.meas tran vdout0_62ck200 FIND v(dout0_62) AT=210.05n

.meas tran vdout0_63ck200 FIND v(dout0_63) AT=210.05n

.meas tran vdout0_64ck200 FIND v(dout0_64) AT=210.05n

.meas tran vdout0_0ck210 FIND v(dout0_0) AT=220.05n

.meas tran vdout0_1ck210 FIND v(dout0_1) AT=220.05n

.meas tran vdout0_2ck210 FIND v(dout0_2) AT=220.05n

.meas tran vdout0_3ck210 FIND v(dout0_3) AT=220.05n

.meas tran vdout0_4ck210 FIND v(dout0_4) AT=220.05n

.meas tran vdout0_5ck210 FIND v(dout0_5) AT=220.05n

.meas tran vdout0_6ck210 FIND v(dout0_6) AT=220.05n

.meas tran vdout0_7ck210 FIND v(dout0_7) AT=220.05n

.meas tran vdout0_8ck210 FIND v(dout0_8) AT=220.05n

.meas tran vdout0_9ck210 FIND v(dout0_9) AT=220.05n

.meas tran vdout0_10ck210 FIND v(dout0_10) AT=220.05n

.meas tran vdout0_11ck210 FIND v(dout0_11) AT=220.05n

.meas tran vdout0_12ck210 FIND v(dout0_12) AT=220.05n

.meas tran vdout0_13ck210 FIND v(dout0_13) AT=220.05n

.meas tran vdout0_14ck210 FIND v(dout0_14) AT=220.05n

.meas tran vdout0_15ck210 FIND v(dout0_15) AT=220.05n

.meas tran vdout0_16ck210 FIND v(dout0_16) AT=220.05n

.meas tran vdout0_17ck210 FIND v(dout0_17) AT=220.05n

.meas tran vdout0_18ck210 FIND v(dout0_18) AT=220.05n

.meas tran vdout0_19ck210 FIND v(dout0_19) AT=220.05n

.meas tran vdout0_20ck210 FIND v(dout0_20) AT=220.05n

.meas tran vdout0_21ck210 FIND v(dout0_21) AT=220.05n

.meas tran vdout0_22ck210 FIND v(dout0_22) AT=220.05n

.meas tran vdout0_23ck210 FIND v(dout0_23) AT=220.05n

.meas tran vdout0_24ck210 FIND v(dout0_24) AT=220.05n

.meas tran vdout0_25ck210 FIND v(dout0_25) AT=220.05n

.meas tran vdout0_26ck210 FIND v(dout0_26) AT=220.05n

.meas tran vdout0_27ck210 FIND v(dout0_27) AT=220.05n

.meas tran vdout0_28ck210 FIND v(dout0_28) AT=220.05n

.meas tran vdout0_29ck210 FIND v(dout0_29) AT=220.05n

.meas tran vdout0_30ck210 FIND v(dout0_30) AT=220.05n

.meas tran vdout0_31ck210 FIND v(dout0_31) AT=220.05n

.meas tran vdout0_32ck210 FIND v(dout0_32) AT=220.05n

.meas tran vdout0_33ck210 FIND v(dout0_33) AT=220.05n

.meas tran vdout0_34ck210 FIND v(dout0_34) AT=220.05n

.meas tran vdout0_35ck210 FIND v(dout0_35) AT=220.05n

.meas tran vdout0_36ck210 FIND v(dout0_36) AT=220.05n

.meas tran vdout0_37ck210 FIND v(dout0_37) AT=220.05n

.meas tran vdout0_38ck210 FIND v(dout0_38) AT=220.05n

.meas tran vdout0_39ck210 FIND v(dout0_39) AT=220.05n

.meas tran vdout0_40ck210 FIND v(dout0_40) AT=220.05n

.meas tran vdout0_41ck210 FIND v(dout0_41) AT=220.05n

.meas tran vdout0_42ck210 FIND v(dout0_42) AT=220.05n

.meas tran vdout0_43ck210 FIND v(dout0_43) AT=220.05n

.meas tran vdout0_44ck210 FIND v(dout0_44) AT=220.05n

.meas tran vdout0_45ck210 FIND v(dout0_45) AT=220.05n

.meas tran vdout0_46ck210 FIND v(dout0_46) AT=220.05n

.meas tran vdout0_47ck210 FIND v(dout0_47) AT=220.05n

.meas tran vdout0_48ck210 FIND v(dout0_48) AT=220.05n

.meas tran vdout0_49ck210 FIND v(dout0_49) AT=220.05n

.meas tran vdout0_50ck210 FIND v(dout0_50) AT=220.05n

.meas tran vdout0_51ck210 FIND v(dout0_51) AT=220.05n

.meas tran vdout0_52ck210 FIND v(dout0_52) AT=220.05n

.meas tran vdout0_53ck210 FIND v(dout0_53) AT=220.05n

.meas tran vdout0_54ck210 FIND v(dout0_54) AT=220.05n

.meas tran vdout0_55ck210 FIND v(dout0_55) AT=220.05n

.meas tran vdout0_56ck210 FIND v(dout0_56) AT=220.05n

.meas tran vdout0_57ck210 FIND v(dout0_57) AT=220.05n

.meas tran vdout0_58ck210 FIND v(dout0_58) AT=220.05n

.meas tran vdout0_59ck210 FIND v(dout0_59) AT=220.05n

.meas tran vdout0_60ck210 FIND v(dout0_60) AT=220.05n

.meas tran vdout0_61ck210 FIND v(dout0_61) AT=220.05n

.meas tran vdout0_62ck210 FIND v(dout0_62) AT=220.05n

.meas tran vdout0_63ck210 FIND v(dout0_63) AT=220.05n

.meas tran vdout0_64ck210 FIND v(dout0_64) AT=220.05n

.meas tran vdout0_0ck220 FIND v(dout0_0) AT=230.05n

.meas tran vdout0_1ck220 FIND v(dout0_1) AT=230.05n

.meas tran vdout0_2ck220 FIND v(dout0_2) AT=230.05n

.meas tran vdout0_3ck220 FIND v(dout0_3) AT=230.05n

.meas tran vdout0_4ck220 FIND v(dout0_4) AT=230.05n

.meas tran vdout0_5ck220 FIND v(dout0_5) AT=230.05n

.meas tran vdout0_6ck220 FIND v(dout0_6) AT=230.05n

.meas tran vdout0_7ck220 FIND v(dout0_7) AT=230.05n

.meas tran vdout0_8ck220 FIND v(dout0_8) AT=230.05n

.meas tran vdout0_9ck220 FIND v(dout0_9) AT=230.05n

.meas tran vdout0_10ck220 FIND v(dout0_10) AT=230.05n

.meas tran vdout0_11ck220 FIND v(dout0_11) AT=230.05n

.meas tran vdout0_12ck220 FIND v(dout0_12) AT=230.05n

.meas tran vdout0_13ck220 FIND v(dout0_13) AT=230.05n

.meas tran vdout0_14ck220 FIND v(dout0_14) AT=230.05n

.meas tran vdout0_15ck220 FIND v(dout0_15) AT=230.05n

.meas tran vdout0_16ck220 FIND v(dout0_16) AT=230.05n

.meas tran vdout0_17ck220 FIND v(dout0_17) AT=230.05n

.meas tran vdout0_18ck220 FIND v(dout0_18) AT=230.05n

.meas tran vdout0_19ck220 FIND v(dout0_19) AT=230.05n

.meas tran vdout0_20ck220 FIND v(dout0_20) AT=230.05n

.meas tran vdout0_21ck220 FIND v(dout0_21) AT=230.05n

.meas tran vdout0_22ck220 FIND v(dout0_22) AT=230.05n

.meas tran vdout0_23ck220 FIND v(dout0_23) AT=230.05n

.meas tran vdout0_24ck220 FIND v(dout0_24) AT=230.05n

.meas tran vdout0_25ck220 FIND v(dout0_25) AT=230.05n

.meas tran vdout0_26ck220 FIND v(dout0_26) AT=230.05n

.meas tran vdout0_27ck220 FIND v(dout0_27) AT=230.05n

.meas tran vdout0_28ck220 FIND v(dout0_28) AT=230.05n

.meas tran vdout0_29ck220 FIND v(dout0_29) AT=230.05n

.meas tran vdout0_30ck220 FIND v(dout0_30) AT=230.05n

.meas tran vdout0_31ck220 FIND v(dout0_31) AT=230.05n

.meas tran vdout0_32ck220 FIND v(dout0_32) AT=230.05n

.meas tran vdout0_33ck220 FIND v(dout0_33) AT=230.05n

.meas tran vdout0_34ck220 FIND v(dout0_34) AT=230.05n

.meas tran vdout0_35ck220 FIND v(dout0_35) AT=230.05n

.meas tran vdout0_36ck220 FIND v(dout0_36) AT=230.05n

.meas tran vdout0_37ck220 FIND v(dout0_37) AT=230.05n

.meas tran vdout0_38ck220 FIND v(dout0_38) AT=230.05n

.meas tran vdout0_39ck220 FIND v(dout0_39) AT=230.05n

.meas tran vdout0_40ck220 FIND v(dout0_40) AT=230.05n

.meas tran vdout0_41ck220 FIND v(dout0_41) AT=230.05n

.meas tran vdout0_42ck220 FIND v(dout0_42) AT=230.05n

.meas tran vdout0_43ck220 FIND v(dout0_43) AT=230.05n

.meas tran vdout0_44ck220 FIND v(dout0_44) AT=230.05n

.meas tran vdout0_45ck220 FIND v(dout0_45) AT=230.05n

.meas tran vdout0_46ck220 FIND v(dout0_46) AT=230.05n

.meas tran vdout0_47ck220 FIND v(dout0_47) AT=230.05n

.meas tran vdout0_48ck220 FIND v(dout0_48) AT=230.05n

.meas tran vdout0_49ck220 FIND v(dout0_49) AT=230.05n

.meas tran vdout0_50ck220 FIND v(dout0_50) AT=230.05n

.meas tran vdout0_51ck220 FIND v(dout0_51) AT=230.05n

.meas tran vdout0_52ck220 FIND v(dout0_52) AT=230.05n

.meas tran vdout0_53ck220 FIND v(dout0_53) AT=230.05n

.meas tran vdout0_54ck220 FIND v(dout0_54) AT=230.05n

.meas tran vdout0_55ck220 FIND v(dout0_55) AT=230.05n

.meas tran vdout0_56ck220 FIND v(dout0_56) AT=230.05n

.meas tran vdout0_57ck220 FIND v(dout0_57) AT=230.05n

.meas tran vdout0_58ck220 FIND v(dout0_58) AT=230.05n

.meas tran vdout0_59ck220 FIND v(dout0_59) AT=230.05n

.meas tran vdout0_60ck220 FIND v(dout0_60) AT=230.05n

.meas tran vdout0_61ck220 FIND v(dout0_61) AT=230.05n

.meas tran vdout0_62ck220 FIND v(dout0_62) AT=230.05n

.meas tran vdout0_63ck220 FIND v(dout0_63) AT=230.05n

.meas tran vdout0_64ck220 FIND v(dout0_64) AT=230.05n

.meas tran vdout0_0ck240 FIND v(dout0_0) AT=250.05n

.meas tran vdout0_1ck240 FIND v(dout0_1) AT=250.05n

.meas tran vdout0_2ck240 FIND v(dout0_2) AT=250.05n

.meas tran vdout0_3ck240 FIND v(dout0_3) AT=250.05n

.meas tran vdout0_4ck240 FIND v(dout0_4) AT=250.05n

.meas tran vdout0_5ck240 FIND v(dout0_5) AT=250.05n

.meas tran vdout0_6ck240 FIND v(dout0_6) AT=250.05n

.meas tran vdout0_7ck240 FIND v(dout0_7) AT=250.05n

.meas tran vdout0_8ck240 FIND v(dout0_8) AT=250.05n

.meas tran vdout0_9ck240 FIND v(dout0_9) AT=250.05n

.meas tran vdout0_10ck240 FIND v(dout0_10) AT=250.05n

.meas tran vdout0_11ck240 FIND v(dout0_11) AT=250.05n

.meas tran vdout0_12ck240 FIND v(dout0_12) AT=250.05n

.meas tran vdout0_13ck240 FIND v(dout0_13) AT=250.05n

.meas tran vdout0_14ck240 FIND v(dout0_14) AT=250.05n

.meas tran vdout0_15ck240 FIND v(dout0_15) AT=250.05n

.meas tran vdout0_16ck240 FIND v(dout0_16) AT=250.05n

.meas tran vdout0_17ck240 FIND v(dout0_17) AT=250.05n

.meas tran vdout0_18ck240 FIND v(dout0_18) AT=250.05n

.meas tran vdout0_19ck240 FIND v(dout0_19) AT=250.05n

.meas tran vdout0_20ck240 FIND v(dout0_20) AT=250.05n

.meas tran vdout0_21ck240 FIND v(dout0_21) AT=250.05n

.meas tran vdout0_22ck240 FIND v(dout0_22) AT=250.05n

.meas tran vdout0_23ck240 FIND v(dout0_23) AT=250.05n

.meas tran vdout0_24ck240 FIND v(dout0_24) AT=250.05n

.meas tran vdout0_25ck240 FIND v(dout0_25) AT=250.05n

.meas tran vdout0_26ck240 FIND v(dout0_26) AT=250.05n

.meas tran vdout0_27ck240 FIND v(dout0_27) AT=250.05n

.meas tran vdout0_28ck240 FIND v(dout0_28) AT=250.05n

.meas tran vdout0_29ck240 FIND v(dout0_29) AT=250.05n

.meas tran vdout0_30ck240 FIND v(dout0_30) AT=250.05n

.meas tran vdout0_31ck240 FIND v(dout0_31) AT=250.05n

.meas tran vdout0_32ck240 FIND v(dout0_32) AT=250.05n

.meas tran vdout0_33ck240 FIND v(dout0_33) AT=250.05n

.meas tran vdout0_34ck240 FIND v(dout0_34) AT=250.05n

.meas tran vdout0_35ck240 FIND v(dout0_35) AT=250.05n

.meas tran vdout0_36ck240 FIND v(dout0_36) AT=250.05n

.meas tran vdout0_37ck240 FIND v(dout0_37) AT=250.05n

.meas tran vdout0_38ck240 FIND v(dout0_38) AT=250.05n

.meas tran vdout0_39ck240 FIND v(dout0_39) AT=250.05n

.meas tran vdout0_40ck240 FIND v(dout0_40) AT=250.05n

.meas tran vdout0_41ck240 FIND v(dout0_41) AT=250.05n

.meas tran vdout0_42ck240 FIND v(dout0_42) AT=250.05n

.meas tran vdout0_43ck240 FIND v(dout0_43) AT=250.05n

.meas tran vdout0_44ck240 FIND v(dout0_44) AT=250.05n

.meas tran vdout0_45ck240 FIND v(dout0_45) AT=250.05n

.meas tran vdout0_46ck240 FIND v(dout0_46) AT=250.05n

.meas tran vdout0_47ck240 FIND v(dout0_47) AT=250.05n

.meas tran vdout0_48ck240 FIND v(dout0_48) AT=250.05n

.meas tran vdout0_49ck240 FIND v(dout0_49) AT=250.05n

.meas tran vdout0_50ck240 FIND v(dout0_50) AT=250.05n

.meas tran vdout0_51ck240 FIND v(dout0_51) AT=250.05n

.meas tran vdout0_52ck240 FIND v(dout0_52) AT=250.05n

.meas tran vdout0_53ck240 FIND v(dout0_53) AT=250.05n

.meas tran vdout0_54ck240 FIND v(dout0_54) AT=250.05n

.meas tran vdout0_55ck240 FIND v(dout0_55) AT=250.05n

.meas tran vdout0_56ck240 FIND v(dout0_56) AT=250.05n

.meas tran vdout0_57ck240 FIND v(dout0_57) AT=250.05n

.meas tran vdout0_58ck240 FIND v(dout0_58) AT=250.05n

.meas tran vdout0_59ck240 FIND v(dout0_59) AT=250.05n

.meas tran vdout0_60ck240 FIND v(dout0_60) AT=250.05n

.meas tran vdout0_61ck240 FIND v(dout0_61) AT=250.05n

.meas tran vdout0_62ck240 FIND v(dout0_62) AT=250.05n

.meas tran vdout0_63ck240 FIND v(dout0_63) AT=250.05n

.meas tran vdout0_64ck240 FIND v(dout0_64) AT=250.05n

.meas tran vdout0_0ck250 FIND v(dout0_0) AT=260.05n

.meas tran vdout0_1ck250 FIND v(dout0_1) AT=260.05n

.meas tran vdout0_2ck250 FIND v(dout0_2) AT=260.05n

.meas tran vdout0_3ck250 FIND v(dout0_3) AT=260.05n

.meas tran vdout0_4ck250 FIND v(dout0_4) AT=260.05n

.meas tran vdout0_5ck250 FIND v(dout0_5) AT=260.05n

.meas tran vdout0_6ck250 FIND v(dout0_6) AT=260.05n

.meas tran vdout0_7ck250 FIND v(dout0_7) AT=260.05n

.meas tran vdout0_8ck250 FIND v(dout0_8) AT=260.05n

.meas tran vdout0_9ck250 FIND v(dout0_9) AT=260.05n

.meas tran vdout0_10ck250 FIND v(dout0_10) AT=260.05n

.meas tran vdout0_11ck250 FIND v(dout0_11) AT=260.05n

.meas tran vdout0_12ck250 FIND v(dout0_12) AT=260.05n

.meas tran vdout0_13ck250 FIND v(dout0_13) AT=260.05n

.meas tran vdout0_14ck250 FIND v(dout0_14) AT=260.05n

.meas tran vdout0_15ck250 FIND v(dout0_15) AT=260.05n

.meas tran vdout0_16ck250 FIND v(dout0_16) AT=260.05n

.meas tran vdout0_17ck250 FIND v(dout0_17) AT=260.05n

.meas tran vdout0_18ck250 FIND v(dout0_18) AT=260.05n

.meas tran vdout0_19ck250 FIND v(dout0_19) AT=260.05n

.meas tran vdout0_20ck250 FIND v(dout0_20) AT=260.05n

.meas tran vdout0_21ck250 FIND v(dout0_21) AT=260.05n

.meas tran vdout0_22ck250 FIND v(dout0_22) AT=260.05n

.meas tran vdout0_23ck250 FIND v(dout0_23) AT=260.05n

.meas tran vdout0_24ck250 FIND v(dout0_24) AT=260.05n

.meas tran vdout0_25ck250 FIND v(dout0_25) AT=260.05n

.meas tran vdout0_26ck250 FIND v(dout0_26) AT=260.05n

.meas tran vdout0_27ck250 FIND v(dout0_27) AT=260.05n

.meas tran vdout0_28ck250 FIND v(dout0_28) AT=260.05n

.meas tran vdout0_29ck250 FIND v(dout0_29) AT=260.05n

.meas tran vdout0_30ck250 FIND v(dout0_30) AT=260.05n

.meas tran vdout0_31ck250 FIND v(dout0_31) AT=260.05n

.meas tran vdout0_32ck250 FIND v(dout0_32) AT=260.05n

.meas tran vdout0_33ck250 FIND v(dout0_33) AT=260.05n

.meas tran vdout0_34ck250 FIND v(dout0_34) AT=260.05n

.meas tran vdout0_35ck250 FIND v(dout0_35) AT=260.05n

.meas tran vdout0_36ck250 FIND v(dout0_36) AT=260.05n

.meas tran vdout0_37ck250 FIND v(dout0_37) AT=260.05n

.meas tran vdout0_38ck250 FIND v(dout0_38) AT=260.05n

.meas tran vdout0_39ck250 FIND v(dout0_39) AT=260.05n

.meas tran vdout0_40ck250 FIND v(dout0_40) AT=260.05n

.meas tran vdout0_41ck250 FIND v(dout0_41) AT=260.05n

.meas tran vdout0_42ck250 FIND v(dout0_42) AT=260.05n

.meas tran vdout0_43ck250 FIND v(dout0_43) AT=260.05n

.meas tran vdout0_44ck250 FIND v(dout0_44) AT=260.05n

.meas tran vdout0_45ck250 FIND v(dout0_45) AT=260.05n

.meas tran vdout0_46ck250 FIND v(dout0_46) AT=260.05n

.meas tran vdout0_47ck250 FIND v(dout0_47) AT=260.05n

.meas tran vdout0_48ck250 FIND v(dout0_48) AT=260.05n

.meas tran vdout0_49ck250 FIND v(dout0_49) AT=260.05n

.meas tran vdout0_50ck250 FIND v(dout0_50) AT=260.05n

.meas tran vdout0_51ck250 FIND v(dout0_51) AT=260.05n

.meas tran vdout0_52ck250 FIND v(dout0_52) AT=260.05n

.meas tran vdout0_53ck250 FIND v(dout0_53) AT=260.05n

.meas tran vdout0_54ck250 FIND v(dout0_54) AT=260.05n

.meas tran vdout0_55ck250 FIND v(dout0_55) AT=260.05n

.meas tran vdout0_56ck250 FIND v(dout0_56) AT=260.05n

.meas tran vdout0_57ck250 FIND v(dout0_57) AT=260.05n

.meas tran vdout0_58ck250 FIND v(dout0_58) AT=260.05n

.meas tran vdout0_59ck250 FIND v(dout0_59) AT=260.05n

.meas tran vdout0_60ck250 FIND v(dout0_60) AT=260.05n

.meas tran vdout0_61ck250 FIND v(dout0_61) AT=260.05n

.meas tran vdout0_62ck250 FIND v(dout0_62) AT=260.05n

.meas tran vdout0_63ck250 FIND v(dout0_63) AT=260.05n

.meas tran vdout0_64ck250 FIND v(dout0_64) AT=260.05n

.meas tran vdout0_0ck260 FIND v(dout0_0) AT=270.05n

.meas tran vdout0_1ck260 FIND v(dout0_1) AT=270.05n

.meas tran vdout0_2ck260 FIND v(dout0_2) AT=270.05n

.meas tran vdout0_3ck260 FIND v(dout0_3) AT=270.05n

.meas tran vdout0_4ck260 FIND v(dout0_4) AT=270.05n

.meas tran vdout0_5ck260 FIND v(dout0_5) AT=270.05n

.meas tran vdout0_6ck260 FIND v(dout0_6) AT=270.05n

.meas tran vdout0_7ck260 FIND v(dout0_7) AT=270.05n

.meas tran vdout0_8ck260 FIND v(dout0_8) AT=270.05n

.meas tran vdout0_9ck260 FIND v(dout0_9) AT=270.05n

.meas tran vdout0_10ck260 FIND v(dout0_10) AT=270.05n

.meas tran vdout0_11ck260 FIND v(dout0_11) AT=270.05n

.meas tran vdout0_12ck260 FIND v(dout0_12) AT=270.05n

.meas tran vdout0_13ck260 FIND v(dout0_13) AT=270.05n

.meas tran vdout0_14ck260 FIND v(dout0_14) AT=270.05n

.meas tran vdout0_15ck260 FIND v(dout0_15) AT=270.05n

.meas tran vdout0_16ck260 FIND v(dout0_16) AT=270.05n

.meas tran vdout0_17ck260 FIND v(dout0_17) AT=270.05n

.meas tran vdout0_18ck260 FIND v(dout0_18) AT=270.05n

.meas tran vdout0_19ck260 FIND v(dout0_19) AT=270.05n

.meas tran vdout0_20ck260 FIND v(dout0_20) AT=270.05n

.meas tran vdout0_21ck260 FIND v(dout0_21) AT=270.05n

.meas tran vdout0_22ck260 FIND v(dout0_22) AT=270.05n

.meas tran vdout0_23ck260 FIND v(dout0_23) AT=270.05n

.meas tran vdout0_24ck260 FIND v(dout0_24) AT=270.05n

.meas tran vdout0_25ck260 FIND v(dout0_25) AT=270.05n

.meas tran vdout0_26ck260 FIND v(dout0_26) AT=270.05n

.meas tran vdout0_27ck260 FIND v(dout0_27) AT=270.05n

.meas tran vdout0_28ck260 FIND v(dout0_28) AT=270.05n

.meas tran vdout0_29ck260 FIND v(dout0_29) AT=270.05n

.meas tran vdout0_30ck260 FIND v(dout0_30) AT=270.05n

.meas tran vdout0_31ck260 FIND v(dout0_31) AT=270.05n

.meas tran vdout0_32ck260 FIND v(dout0_32) AT=270.05n

.meas tran vdout0_33ck260 FIND v(dout0_33) AT=270.05n

.meas tran vdout0_34ck260 FIND v(dout0_34) AT=270.05n

.meas tran vdout0_35ck260 FIND v(dout0_35) AT=270.05n

.meas tran vdout0_36ck260 FIND v(dout0_36) AT=270.05n

.meas tran vdout0_37ck260 FIND v(dout0_37) AT=270.05n

.meas tran vdout0_38ck260 FIND v(dout0_38) AT=270.05n

.meas tran vdout0_39ck260 FIND v(dout0_39) AT=270.05n

.meas tran vdout0_40ck260 FIND v(dout0_40) AT=270.05n

.meas tran vdout0_41ck260 FIND v(dout0_41) AT=270.05n

.meas tran vdout0_42ck260 FIND v(dout0_42) AT=270.05n

.meas tran vdout0_43ck260 FIND v(dout0_43) AT=270.05n

.meas tran vdout0_44ck260 FIND v(dout0_44) AT=270.05n

.meas tran vdout0_45ck260 FIND v(dout0_45) AT=270.05n

.meas tran vdout0_46ck260 FIND v(dout0_46) AT=270.05n

.meas tran vdout0_47ck260 FIND v(dout0_47) AT=270.05n

.meas tran vdout0_48ck260 FIND v(dout0_48) AT=270.05n

.meas tran vdout0_49ck260 FIND v(dout0_49) AT=270.05n

.meas tran vdout0_50ck260 FIND v(dout0_50) AT=270.05n

.meas tran vdout0_51ck260 FIND v(dout0_51) AT=270.05n

.meas tran vdout0_52ck260 FIND v(dout0_52) AT=270.05n

.meas tran vdout0_53ck260 FIND v(dout0_53) AT=270.05n

.meas tran vdout0_54ck260 FIND v(dout0_54) AT=270.05n

.meas tran vdout0_55ck260 FIND v(dout0_55) AT=270.05n

.meas tran vdout0_56ck260 FIND v(dout0_56) AT=270.05n

.meas tran vdout0_57ck260 FIND v(dout0_57) AT=270.05n

.meas tran vdout0_58ck260 FIND v(dout0_58) AT=270.05n

.meas tran vdout0_59ck260 FIND v(dout0_59) AT=270.05n

.meas tran vdout0_60ck260 FIND v(dout0_60) AT=270.05n

.meas tran vdout0_61ck260 FIND v(dout0_61) AT=270.05n

.meas tran vdout0_62ck260 FIND v(dout0_62) AT=270.05n

.meas tran vdout0_63ck260 FIND v(dout0_63) AT=270.05n

.meas tran vdout0_64ck260 FIND v(dout0_64) AT=270.05n

.meas tran vdout0_0ck270 FIND v(dout0_0) AT=280.05n

.meas tran vdout0_1ck270 FIND v(dout0_1) AT=280.05n

.meas tran vdout0_2ck270 FIND v(dout0_2) AT=280.05n

.meas tran vdout0_3ck270 FIND v(dout0_3) AT=280.05n

.meas tran vdout0_4ck270 FIND v(dout0_4) AT=280.05n

.meas tran vdout0_5ck270 FIND v(dout0_5) AT=280.05n

.meas tran vdout0_6ck270 FIND v(dout0_6) AT=280.05n

.meas tran vdout0_7ck270 FIND v(dout0_7) AT=280.05n

.meas tran vdout0_8ck270 FIND v(dout0_8) AT=280.05n

.meas tran vdout0_9ck270 FIND v(dout0_9) AT=280.05n

.meas tran vdout0_10ck270 FIND v(dout0_10) AT=280.05n

.meas tran vdout0_11ck270 FIND v(dout0_11) AT=280.05n

.meas tran vdout0_12ck270 FIND v(dout0_12) AT=280.05n

.meas tran vdout0_13ck270 FIND v(dout0_13) AT=280.05n

.meas tran vdout0_14ck270 FIND v(dout0_14) AT=280.05n

.meas tran vdout0_15ck270 FIND v(dout0_15) AT=280.05n

.meas tran vdout0_16ck270 FIND v(dout0_16) AT=280.05n

.meas tran vdout0_17ck270 FIND v(dout0_17) AT=280.05n

.meas tran vdout0_18ck270 FIND v(dout0_18) AT=280.05n

.meas tran vdout0_19ck270 FIND v(dout0_19) AT=280.05n

.meas tran vdout0_20ck270 FIND v(dout0_20) AT=280.05n

.meas tran vdout0_21ck270 FIND v(dout0_21) AT=280.05n

.meas tran vdout0_22ck270 FIND v(dout0_22) AT=280.05n

.meas tran vdout0_23ck270 FIND v(dout0_23) AT=280.05n

.meas tran vdout0_24ck270 FIND v(dout0_24) AT=280.05n

.meas tran vdout0_25ck270 FIND v(dout0_25) AT=280.05n

.meas tran vdout0_26ck270 FIND v(dout0_26) AT=280.05n

.meas tran vdout0_27ck270 FIND v(dout0_27) AT=280.05n

.meas tran vdout0_28ck270 FIND v(dout0_28) AT=280.05n

.meas tran vdout0_29ck270 FIND v(dout0_29) AT=280.05n

.meas tran vdout0_30ck270 FIND v(dout0_30) AT=280.05n

.meas tran vdout0_31ck270 FIND v(dout0_31) AT=280.05n

.meas tran vdout0_32ck270 FIND v(dout0_32) AT=280.05n

.meas tran vdout0_33ck270 FIND v(dout0_33) AT=280.05n

.meas tran vdout0_34ck270 FIND v(dout0_34) AT=280.05n

.meas tran vdout0_35ck270 FIND v(dout0_35) AT=280.05n

.meas tran vdout0_36ck270 FIND v(dout0_36) AT=280.05n

.meas tran vdout0_37ck270 FIND v(dout0_37) AT=280.05n

.meas tran vdout0_38ck270 FIND v(dout0_38) AT=280.05n

.meas tran vdout0_39ck270 FIND v(dout0_39) AT=280.05n

.meas tran vdout0_40ck270 FIND v(dout0_40) AT=280.05n

.meas tran vdout0_41ck270 FIND v(dout0_41) AT=280.05n

.meas tran vdout0_42ck270 FIND v(dout0_42) AT=280.05n

.meas tran vdout0_43ck270 FIND v(dout0_43) AT=280.05n

.meas tran vdout0_44ck270 FIND v(dout0_44) AT=280.05n

.meas tran vdout0_45ck270 FIND v(dout0_45) AT=280.05n

.meas tran vdout0_46ck270 FIND v(dout0_46) AT=280.05n

.meas tran vdout0_47ck270 FIND v(dout0_47) AT=280.05n

.meas tran vdout0_48ck270 FIND v(dout0_48) AT=280.05n

.meas tran vdout0_49ck270 FIND v(dout0_49) AT=280.05n

.meas tran vdout0_50ck270 FIND v(dout0_50) AT=280.05n

.meas tran vdout0_51ck270 FIND v(dout0_51) AT=280.05n

.meas tran vdout0_52ck270 FIND v(dout0_52) AT=280.05n

.meas tran vdout0_53ck270 FIND v(dout0_53) AT=280.05n

.meas tran vdout0_54ck270 FIND v(dout0_54) AT=280.05n

.meas tran vdout0_55ck270 FIND v(dout0_55) AT=280.05n

.meas tran vdout0_56ck270 FIND v(dout0_56) AT=280.05n

.meas tran vdout0_57ck270 FIND v(dout0_57) AT=280.05n

.meas tran vdout0_58ck270 FIND v(dout0_58) AT=280.05n

.meas tran vdout0_59ck270 FIND v(dout0_59) AT=280.05n

.meas tran vdout0_60ck270 FIND v(dout0_60) AT=280.05n

.meas tran vdout0_61ck270 FIND v(dout0_61) AT=280.05n

.meas tran vdout0_62ck270 FIND v(dout0_62) AT=280.05n

.meas tran vdout0_63ck270 FIND v(dout0_63) AT=280.05n

.meas tran vdout0_64ck270 FIND v(dout0_64) AT=280.05n

.meas tran vdout0_0ck310 FIND v(dout0_0) AT=320.05n

.meas tran vdout0_1ck310 FIND v(dout0_1) AT=320.05n

.meas tran vdout0_2ck310 FIND v(dout0_2) AT=320.05n

.meas tran vdout0_3ck310 FIND v(dout0_3) AT=320.05n

.meas tran vdout0_4ck310 FIND v(dout0_4) AT=320.05n

.meas tran vdout0_5ck310 FIND v(dout0_5) AT=320.05n

.meas tran vdout0_6ck310 FIND v(dout0_6) AT=320.05n

.meas tran vdout0_7ck310 FIND v(dout0_7) AT=320.05n

.meas tran vdout0_8ck310 FIND v(dout0_8) AT=320.05n

.meas tran vdout0_9ck310 FIND v(dout0_9) AT=320.05n

.meas tran vdout0_10ck310 FIND v(dout0_10) AT=320.05n

.meas tran vdout0_11ck310 FIND v(dout0_11) AT=320.05n

.meas tran vdout0_12ck310 FIND v(dout0_12) AT=320.05n

.meas tran vdout0_13ck310 FIND v(dout0_13) AT=320.05n

.meas tran vdout0_14ck310 FIND v(dout0_14) AT=320.05n

.meas tran vdout0_15ck310 FIND v(dout0_15) AT=320.05n

.meas tran vdout0_16ck310 FIND v(dout0_16) AT=320.05n

.meas tran vdout0_17ck310 FIND v(dout0_17) AT=320.05n

.meas tran vdout0_18ck310 FIND v(dout0_18) AT=320.05n

.meas tran vdout0_19ck310 FIND v(dout0_19) AT=320.05n

.meas tran vdout0_20ck310 FIND v(dout0_20) AT=320.05n

.meas tran vdout0_21ck310 FIND v(dout0_21) AT=320.05n

.meas tran vdout0_22ck310 FIND v(dout0_22) AT=320.05n

.meas tran vdout0_23ck310 FIND v(dout0_23) AT=320.05n

.meas tran vdout0_24ck310 FIND v(dout0_24) AT=320.05n

.meas tran vdout0_25ck310 FIND v(dout0_25) AT=320.05n

.meas tran vdout0_26ck310 FIND v(dout0_26) AT=320.05n

.meas tran vdout0_27ck310 FIND v(dout0_27) AT=320.05n

.meas tran vdout0_28ck310 FIND v(dout0_28) AT=320.05n

.meas tran vdout0_29ck310 FIND v(dout0_29) AT=320.05n

.meas tran vdout0_30ck310 FIND v(dout0_30) AT=320.05n

.meas tran vdout0_31ck310 FIND v(dout0_31) AT=320.05n

.meas tran vdout0_32ck310 FIND v(dout0_32) AT=320.05n

.meas tran vdout0_33ck310 FIND v(dout0_33) AT=320.05n

.meas tran vdout0_34ck310 FIND v(dout0_34) AT=320.05n

.meas tran vdout0_35ck310 FIND v(dout0_35) AT=320.05n

.meas tran vdout0_36ck310 FIND v(dout0_36) AT=320.05n

.meas tran vdout0_37ck310 FIND v(dout0_37) AT=320.05n

.meas tran vdout0_38ck310 FIND v(dout0_38) AT=320.05n

.meas tran vdout0_39ck310 FIND v(dout0_39) AT=320.05n

.meas tran vdout0_40ck310 FIND v(dout0_40) AT=320.05n

.meas tran vdout0_41ck310 FIND v(dout0_41) AT=320.05n

.meas tran vdout0_42ck310 FIND v(dout0_42) AT=320.05n

.meas tran vdout0_43ck310 FIND v(dout0_43) AT=320.05n

.meas tran vdout0_44ck310 FIND v(dout0_44) AT=320.05n

.meas tran vdout0_45ck310 FIND v(dout0_45) AT=320.05n

.meas tran vdout0_46ck310 FIND v(dout0_46) AT=320.05n

.meas tran vdout0_47ck310 FIND v(dout0_47) AT=320.05n

.meas tran vdout0_48ck310 FIND v(dout0_48) AT=320.05n

.meas tran vdout0_49ck310 FIND v(dout0_49) AT=320.05n

.meas tran vdout0_50ck310 FIND v(dout0_50) AT=320.05n

.meas tran vdout0_51ck310 FIND v(dout0_51) AT=320.05n

.meas tran vdout0_52ck310 FIND v(dout0_52) AT=320.05n

.meas tran vdout0_53ck310 FIND v(dout0_53) AT=320.05n

.meas tran vdout0_54ck310 FIND v(dout0_54) AT=320.05n

.meas tran vdout0_55ck310 FIND v(dout0_55) AT=320.05n

.meas tran vdout0_56ck310 FIND v(dout0_56) AT=320.05n

.meas tran vdout0_57ck310 FIND v(dout0_57) AT=320.05n

.meas tran vdout0_58ck310 FIND v(dout0_58) AT=320.05n

.meas tran vdout0_59ck310 FIND v(dout0_59) AT=320.05n

.meas tran vdout0_60ck310 FIND v(dout0_60) AT=320.05n

.meas tran vdout0_61ck310 FIND v(dout0_61) AT=320.05n

.meas tran vdout0_62ck310 FIND v(dout0_62) AT=320.05n

.meas tran vdout0_63ck310 FIND v(dout0_63) AT=320.05n

.meas tran vdout0_64ck310 FIND v(dout0_64) AT=320.05n

.meas tran vdout0_0ck330 FIND v(dout0_0) AT=340.05n

.meas tran vdout0_1ck330 FIND v(dout0_1) AT=340.05n

.meas tran vdout0_2ck330 FIND v(dout0_2) AT=340.05n

.meas tran vdout0_3ck330 FIND v(dout0_3) AT=340.05n

.meas tran vdout0_4ck330 FIND v(dout0_4) AT=340.05n

.meas tran vdout0_5ck330 FIND v(dout0_5) AT=340.05n

.meas tran vdout0_6ck330 FIND v(dout0_6) AT=340.05n

.meas tran vdout0_7ck330 FIND v(dout0_7) AT=340.05n

.meas tran vdout0_8ck330 FIND v(dout0_8) AT=340.05n

.meas tran vdout0_9ck330 FIND v(dout0_9) AT=340.05n

.meas tran vdout0_10ck330 FIND v(dout0_10) AT=340.05n

.meas tran vdout0_11ck330 FIND v(dout0_11) AT=340.05n

.meas tran vdout0_12ck330 FIND v(dout0_12) AT=340.05n

.meas tran vdout0_13ck330 FIND v(dout0_13) AT=340.05n

.meas tran vdout0_14ck330 FIND v(dout0_14) AT=340.05n

.meas tran vdout0_15ck330 FIND v(dout0_15) AT=340.05n

.meas tran vdout0_16ck330 FIND v(dout0_16) AT=340.05n

.meas tran vdout0_17ck330 FIND v(dout0_17) AT=340.05n

.meas tran vdout0_18ck330 FIND v(dout0_18) AT=340.05n

.meas tran vdout0_19ck330 FIND v(dout0_19) AT=340.05n

.meas tran vdout0_20ck330 FIND v(dout0_20) AT=340.05n

.meas tran vdout0_21ck330 FIND v(dout0_21) AT=340.05n

.meas tran vdout0_22ck330 FIND v(dout0_22) AT=340.05n

.meas tran vdout0_23ck330 FIND v(dout0_23) AT=340.05n

.meas tran vdout0_24ck330 FIND v(dout0_24) AT=340.05n

.meas tran vdout0_25ck330 FIND v(dout0_25) AT=340.05n

.meas tran vdout0_26ck330 FIND v(dout0_26) AT=340.05n

.meas tran vdout0_27ck330 FIND v(dout0_27) AT=340.05n

.meas tran vdout0_28ck330 FIND v(dout0_28) AT=340.05n

.meas tran vdout0_29ck330 FIND v(dout0_29) AT=340.05n

.meas tran vdout0_30ck330 FIND v(dout0_30) AT=340.05n

.meas tran vdout0_31ck330 FIND v(dout0_31) AT=340.05n

.meas tran vdout0_32ck330 FIND v(dout0_32) AT=340.05n

.meas tran vdout0_33ck330 FIND v(dout0_33) AT=340.05n

.meas tran vdout0_34ck330 FIND v(dout0_34) AT=340.05n

.meas tran vdout0_35ck330 FIND v(dout0_35) AT=340.05n

.meas tran vdout0_36ck330 FIND v(dout0_36) AT=340.05n

.meas tran vdout0_37ck330 FIND v(dout0_37) AT=340.05n

.meas tran vdout0_38ck330 FIND v(dout0_38) AT=340.05n

.meas tran vdout0_39ck330 FIND v(dout0_39) AT=340.05n

.meas tran vdout0_40ck330 FIND v(dout0_40) AT=340.05n

.meas tran vdout0_41ck330 FIND v(dout0_41) AT=340.05n

.meas tran vdout0_42ck330 FIND v(dout0_42) AT=340.05n

.meas tran vdout0_43ck330 FIND v(dout0_43) AT=340.05n

.meas tran vdout0_44ck330 FIND v(dout0_44) AT=340.05n

.meas tran vdout0_45ck330 FIND v(dout0_45) AT=340.05n

.meas tran vdout0_46ck330 FIND v(dout0_46) AT=340.05n

.meas tran vdout0_47ck330 FIND v(dout0_47) AT=340.05n

.meas tran vdout0_48ck330 FIND v(dout0_48) AT=340.05n

.meas tran vdout0_49ck330 FIND v(dout0_49) AT=340.05n

.meas tran vdout0_50ck330 FIND v(dout0_50) AT=340.05n

.meas tran vdout0_51ck330 FIND v(dout0_51) AT=340.05n

.meas tran vdout0_52ck330 FIND v(dout0_52) AT=340.05n

.meas tran vdout0_53ck330 FIND v(dout0_53) AT=340.05n

.meas tran vdout0_54ck330 FIND v(dout0_54) AT=340.05n

.meas tran vdout0_55ck330 FIND v(dout0_55) AT=340.05n

.meas tran vdout0_56ck330 FIND v(dout0_56) AT=340.05n

.meas tran vdout0_57ck330 FIND v(dout0_57) AT=340.05n

.meas tran vdout0_58ck330 FIND v(dout0_58) AT=340.05n

.meas tran vdout0_59ck330 FIND v(dout0_59) AT=340.05n

.meas tran vdout0_60ck330 FIND v(dout0_60) AT=340.05n

.meas tran vdout0_61ck330 FIND v(dout0_61) AT=340.05n

.meas tran vdout0_62ck330 FIND v(dout0_62) AT=340.05n

.meas tran vdout0_63ck330 FIND v(dout0_63) AT=340.05n

.meas tran vdout0_64ck330 FIND v(dout0_64) AT=340.05n

.meas tran vdout0_0ck350 FIND v(dout0_0) AT=360.05n

.meas tran vdout0_1ck350 FIND v(dout0_1) AT=360.05n

.meas tran vdout0_2ck350 FIND v(dout0_2) AT=360.05n

.meas tran vdout0_3ck350 FIND v(dout0_3) AT=360.05n

.meas tran vdout0_4ck350 FIND v(dout0_4) AT=360.05n

.meas tran vdout0_5ck350 FIND v(dout0_5) AT=360.05n

.meas tran vdout0_6ck350 FIND v(dout0_6) AT=360.05n

.meas tran vdout0_7ck350 FIND v(dout0_7) AT=360.05n

.meas tran vdout0_8ck350 FIND v(dout0_8) AT=360.05n

.meas tran vdout0_9ck350 FIND v(dout0_9) AT=360.05n

.meas tran vdout0_10ck350 FIND v(dout0_10) AT=360.05n

.meas tran vdout0_11ck350 FIND v(dout0_11) AT=360.05n

.meas tran vdout0_12ck350 FIND v(dout0_12) AT=360.05n

.meas tran vdout0_13ck350 FIND v(dout0_13) AT=360.05n

.meas tran vdout0_14ck350 FIND v(dout0_14) AT=360.05n

.meas tran vdout0_15ck350 FIND v(dout0_15) AT=360.05n

.meas tran vdout0_16ck350 FIND v(dout0_16) AT=360.05n

.meas tran vdout0_17ck350 FIND v(dout0_17) AT=360.05n

.meas tran vdout0_18ck350 FIND v(dout0_18) AT=360.05n

.meas tran vdout0_19ck350 FIND v(dout0_19) AT=360.05n

.meas tran vdout0_20ck350 FIND v(dout0_20) AT=360.05n

.meas tran vdout0_21ck350 FIND v(dout0_21) AT=360.05n

.meas tran vdout0_22ck350 FIND v(dout0_22) AT=360.05n

.meas tran vdout0_23ck350 FIND v(dout0_23) AT=360.05n

.meas tran vdout0_24ck350 FIND v(dout0_24) AT=360.05n

.meas tran vdout0_25ck350 FIND v(dout0_25) AT=360.05n

.meas tran vdout0_26ck350 FIND v(dout0_26) AT=360.05n

.meas tran vdout0_27ck350 FIND v(dout0_27) AT=360.05n

.meas tran vdout0_28ck350 FIND v(dout0_28) AT=360.05n

.meas tran vdout0_29ck350 FIND v(dout0_29) AT=360.05n

.meas tran vdout0_30ck350 FIND v(dout0_30) AT=360.05n

.meas tran vdout0_31ck350 FIND v(dout0_31) AT=360.05n

.meas tran vdout0_32ck350 FIND v(dout0_32) AT=360.05n

.meas tran vdout0_33ck350 FIND v(dout0_33) AT=360.05n

.meas tran vdout0_34ck350 FIND v(dout0_34) AT=360.05n

.meas tran vdout0_35ck350 FIND v(dout0_35) AT=360.05n

.meas tran vdout0_36ck350 FIND v(dout0_36) AT=360.05n

.meas tran vdout0_37ck350 FIND v(dout0_37) AT=360.05n

.meas tran vdout0_38ck350 FIND v(dout0_38) AT=360.05n

.meas tran vdout0_39ck350 FIND v(dout0_39) AT=360.05n

.meas tran vdout0_40ck350 FIND v(dout0_40) AT=360.05n

.meas tran vdout0_41ck350 FIND v(dout0_41) AT=360.05n

.meas tran vdout0_42ck350 FIND v(dout0_42) AT=360.05n

.meas tran vdout0_43ck350 FIND v(dout0_43) AT=360.05n

.meas tran vdout0_44ck350 FIND v(dout0_44) AT=360.05n

.meas tran vdout0_45ck350 FIND v(dout0_45) AT=360.05n

.meas tran vdout0_46ck350 FIND v(dout0_46) AT=360.05n

.meas tran vdout0_47ck350 FIND v(dout0_47) AT=360.05n

.meas tran vdout0_48ck350 FIND v(dout0_48) AT=360.05n

.meas tran vdout0_49ck350 FIND v(dout0_49) AT=360.05n

.meas tran vdout0_50ck350 FIND v(dout0_50) AT=360.05n

.meas tran vdout0_51ck350 FIND v(dout0_51) AT=360.05n

.meas tran vdout0_52ck350 FIND v(dout0_52) AT=360.05n

.meas tran vdout0_53ck350 FIND v(dout0_53) AT=360.05n

.meas tran vdout0_54ck350 FIND v(dout0_54) AT=360.05n

.meas tran vdout0_55ck350 FIND v(dout0_55) AT=360.05n

.meas tran vdout0_56ck350 FIND v(dout0_56) AT=360.05n

.meas tran vdout0_57ck350 FIND v(dout0_57) AT=360.05n

.meas tran vdout0_58ck350 FIND v(dout0_58) AT=360.05n

.meas tran vdout0_59ck350 FIND v(dout0_59) AT=360.05n

.meas tran vdout0_60ck350 FIND v(dout0_60) AT=360.05n

.meas tran vdout0_61ck350 FIND v(dout0_61) AT=360.05n

.meas tran vdout0_62ck350 FIND v(dout0_62) AT=360.05n

.meas tran vdout0_63ck350 FIND v(dout0_63) AT=360.05n

.meas tran vdout0_64ck350 FIND v(dout0_64) AT=360.05n

.meas tran vdout0_0ck360 FIND v(dout0_0) AT=370.05n

.meas tran vdout0_1ck360 FIND v(dout0_1) AT=370.05n

.meas tran vdout0_2ck360 FIND v(dout0_2) AT=370.05n

.meas tran vdout0_3ck360 FIND v(dout0_3) AT=370.05n

.meas tran vdout0_4ck360 FIND v(dout0_4) AT=370.05n

.meas tran vdout0_5ck360 FIND v(dout0_5) AT=370.05n

.meas tran vdout0_6ck360 FIND v(dout0_6) AT=370.05n

.meas tran vdout0_7ck360 FIND v(dout0_7) AT=370.05n

.meas tran vdout0_8ck360 FIND v(dout0_8) AT=370.05n

.meas tran vdout0_9ck360 FIND v(dout0_9) AT=370.05n

.meas tran vdout0_10ck360 FIND v(dout0_10) AT=370.05n

.meas tran vdout0_11ck360 FIND v(dout0_11) AT=370.05n

.meas tran vdout0_12ck360 FIND v(dout0_12) AT=370.05n

.meas tran vdout0_13ck360 FIND v(dout0_13) AT=370.05n

.meas tran vdout0_14ck360 FIND v(dout0_14) AT=370.05n

.meas tran vdout0_15ck360 FIND v(dout0_15) AT=370.05n

.meas tran vdout0_16ck360 FIND v(dout0_16) AT=370.05n

.meas tran vdout0_17ck360 FIND v(dout0_17) AT=370.05n

.meas tran vdout0_18ck360 FIND v(dout0_18) AT=370.05n

.meas tran vdout0_19ck360 FIND v(dout0_19) AT=370.05n

.meas tran vdout0_20ck360 FIND v(dout0_20) AT=370.05n

.meas tran vdout0_21ck360 FIND v(dout0_21) AT=370.05n

.meas tran vdout0_22ck360 FIND v(dout0_22) AT=370.05n

.meas tran vdout0_23ck360 FIND v(dout0_23) AT=370.05n

.meas tran vdout0_24ck360 FIND v(dout0_24) AT=370.05n

.meas tran vdout0_25ck360 FIND v(dout0_25) AT=370.05n

.meas tran vdout0_26ck360 FIND v(dout0_26) AT=370.05n

.meas tran vdout0_27ck360 FIND v(dout0_27) AT=370.05n

.meas tran vdout0_28ck360 FIND v(dout0_28) AT=370.05n

.meas tran vdout0_29ck360 FIND v(dout0_29) AT=370.05n

.meas tran vdout0_30ck360 FIND v(dout0_30) AT=370.05n

.meas tran vdout0_31ck360 FIND v(dout0_31) AT=370.05n

.meas tran vdout0_32ck360 FIND v(dout0_32) AT=370.05n

.meas tran vdout0_33ck360 FIND v(dout0_33) AT=370.05n

.meas tran vdout0_34ck360 FIND v(dout0_34) AT=370.05n

.meas tran vdout0_35ck360 FIND v(dout0_35) AT=370.05n

.meas tran vdout0_36ck360 FIND v(dout0_36) AT=370.05n

.meas tran vdout0_37ck360 FIND v(dout0_37) AT=370.05n

.meas tran vdout0_38ck360 FIND v(dout0_38) AT=370.05n

.meas tran vdout0_39ck360 FIND v(dout0_39) AT=370.05n

.meas tran vdout0_40ck360 FIND v(dout0_40) AT=370.05n

.meas tran vdout0_41ck360 FIND v(dout0_41) AT=370.05n

.meas tran vdout0_42ck360 FIND v(dout0_42) AT=370.05n

.meas tran vdout0_43ck360 FIND v(dout0_43) AT=370.05n

.meas tran vdout0_44ck360 FIND v(dout0_44) AT=370.05n

.meas tran vdout0_45ck360 FIND v(dout0_45) AT=370.05n

.meas tran vdout0_46ck360 FIND v(dout0_46) AT=370.05n

.meas tran vdout0_47ck360 FIND v(dout0_47) AT=370.05n

.meas tran vdout0_48ck360 FIND v(dout0_48) AT=370.05n

.meas tran vdout0_49ck360 FIND v(dout0_49) AT=370.05n

.meas tran vdout0_50ck360 FIND v(dout0_50) AT=370.05n

.meas tran vdout0_51ck360 FIND v(dout0_51) AT=370.05n

.meas tran vdout0_52ck360 FIND v(dout0_52) AT=370.05n

.meas tran vdout0_53ck360 FIND v(dout0_53) AT=370.05n

.meas tran vdout0_54ck360 FIND v(dout0_54) AT=370.05n

.meas tran vdout0_55ck360 FIND v(dout0_55) AT=370.05n

.meas tran vdout0_56ck360 FIND v(dout0_56) AT=370.05n

.meas tran vdout0_57ck360 FIND v(dout0_57) AT=370.05n

.meas tran vdout0_58ck360 FIND v(dout0_58) AT=370.05n

.meas tran vdout0_59ck360 FIND v(dout0_59) AT=370.05n

.meas tran vdout0_60ck360 FIND v(dout0_60) AT=370.05n

.meas tran vdout0_61ck360 FIND v(dout0_61) AT=370.05n

.meas tran vdout0_62ck360 FIND v(dout0_62) AT=370.05n

.meas tran vdout0_63ck360 FIND v(dout0_63) AT=370.05n

.meas tran vdout0_64ck360 FIND v(dout0_64) AT=370.05n

.meas tran vdout0_0ck370 FIND v(dout0_0) AT=380.05n

.meas tran vdout0_1ck370 FIND v(dout0_1) AT=380.05n

.meas tran vdout0_2ck370 FIND v(dout0_2) AT=380.05n

.meas tran vdout0_3ck370 FIND v(dout0_3) AT=380.05n

.meas tran vdout0_4ck370 FIND v(dout0_4) AT=380.05n

.meas tran vdout0_5ck370 FIND v(dout0_5) AT=380.05n

.meas tran vdout0_6ck370 FIND v(dout0_6) AT=380.05n

.meas tran vdout0_7ck370 FIND v(dout0_7) AT=380.05n

.meas tran vdout0_8ck370 FIND v(dout0_8) AT=380.05n

.meas tran vdout0_9ck370 FIND v(dout0_9) AT=380.05n

.meas tran vdout0_10ck370 FIND v(dout0_10) AT=380.05n

.meas tran vdout0_11ck370 FIND v(dout0_11) AT=380.05n

.meas tran vdout0_12ck370 FIND v(dout0_12) AT=380.05n

.meas tran vdout0_13ck370 FIND v(dout0_13) AT=380.05n

.meas tran vdout0_14ck370 FIND v(dout0_14) AT=380.05n

.meas tran vdout0_15ck370 FIND v(dout0_15) AT=380.05n

.meas tran vdout0_16ck370 FIND v(dout0_16) AT=380.05n

.meas tran vdout0_17ck370 FIND v(dout0_17) AT=380.05n

.meas tran vdout0_18ck370 FIND v(dout0_18) AT=380.05n

.meas tran vdout0_19ck370 FIND v(dout0_19) AT=380.05n

.meas tran vdout0_20ck370 FIND v(dout0_20) AT=380.05n

.meas tran vdout0_21ck370 FIND v(dout0_21) AT=380.05n

.meas tran vdout0_22ck370 FIND v(dout0_22) AT=380.05n

.meas tran vdout0_23ck370 FIND v(dout0_23) AT=380.05n

.meas tran vdout0_24ck370 FIND v(dout0_24) AT=380.05n

.meas tran vdout0_25ck370 FIND v(dout0_25) AT=380.05n

.meas tran vdout0_26ck370 FIND v(dout0_26) AT=380.05n

.meas tran vdout0_27ck370 FIND v(dout0_27) AT=380.05n

.meas tran vdout0_28ck370 FIND v(dout0_28) AT=380.05n

.meas tran vdout0_29ck370 FIND v(dout0_29) AT=380.05n

.meas tran vdout0_30ck370 FIND v(dout0_30) AT=380.05n

.meas tran vdout0_31ck370 FIND v(dout0_31) AT=380.05n

.meas tran vdout0_32ck370 FIND v(dout0_32) AT=380.05n

.meas tran vdout0_33ck370 FIND v(dout0_33) AT=380.05n

.meas tran vdout0_34ck370 FIND v(dout0_34) AT=380.05n

.meas tran vdout0_35ck370 FIND v(dout0_35) AT=380.05n

.meas tran vdout0_36ck370 FIND v(dout0_36) AT=380.05n

.meas tran vdout0_37ck370 FIND v(dout0_37) AT=380.05n

.meas tran vdout0_38ck370 FIND v(dout0_38) AT=380.05n

.meas tran vdout0_39ck370 FIND v(dout0_39) AT=380.05n

.meas tran vdout0_40ck370 FIND v(dout0_40) AT=380.05n

.meas tran vdout0_41ck370 FIND v(dout0_41) AT=380.05n

.meas tran vdout0_42ck370 FIND v(dout0_42) AT=380.05n

.meas tran vdout0_43ck370 FIND v(dout0_43) AT=380.05n

.meas tran vdout0_44ck370 FIND v(dout0_44) AT=380.05n

.meas tran vdout0_45ck370 FIND v(dout0_45) AT=380.05n

.meas tran vdout0_46ck370 FIND v(dout0_46) AT=380.05n

.meas tran vdout0_47ck370 FIND v(dout0_47) AT=380.05n

.meas tran vdout0_48ck370 FIND v(dout0_48) AT=380.05n

.meas tran vdout0_49ck370 FIND v(dout0_49) AT=380.05n

.meas tran vdout0_50ck370 FIND v(dout0_50) AT=380.05n

.meas tran vdout0_51ck370 FIND v(dout0_51) AT=380.05n

.meas tran vdout0_52ck370 FIND v(dout0_52) AT=380.05n

.meas tran vdout0_53ck370 FIND v(dout0_53) AT=380.05n

.meas tran vdout0_54ck370 FIND v(dout0_54) AT=380.05n

.meas tran vdout0_55ck370 FIND v(dout0_55) AT=380.05n

.meas tran vdout0_56ck370 FIND v(dout0_56) AT=380.05n

.meas tran vdout0_57ck370 FIND v(dout0_57) AT=380.05n

.meas tran vdout0_58ck370 FIND v(dout0_58) AT=380.05n

.meas tran vdout0_59ck370 FIND v(dout0_59) AT=380.05n

.meas tran vdout0_60ck370 FIND v(dout0_60) AT=380.05n

.meas tran vdout0_61ck370 FIND v(dout0_61) AT=380.05n

.meas tran vdout0_62ck370 FIND v(dout0_62) AT=380.05n

.meas tran vdout0_63ck370 FIND v(dout0_63) AT=380.05n

.meas tran vdout0_64ck370 FIND v(dout0_64) AT=380.05n

.meas tran vdout0_0ck410 FIND v(dout0_0) AT=420.05n

.meas tran vdout0_1ck410 FIND v(dout0_1) AT=420.05n

.meas tran vdout0_2ck410 FIND v(dout0_2) AT=420.05n

.meas tran vdout0_3ck410 FIND v(dout0_3) AT=420.05n

.meas tran vdout0_4ck410 FIND v(dout0_4) AT=420.05n

.meas tran vdout0_5ck410 FIND v(dout0_5) AT=420.05n

.meas tran vdout0_6ck410 FIND v(dout0_6) AT=420.05n

.meas tran vdout0_7ck410 FIND v(dout0_7) AT=420.05n

.meas tran vdout0_8ck410 FIND v(dout0_8) AT=420.05n

.meas tran vdout0_9ck410 FIND v(dout0_9) AT=420.05n

.meas tran vdout0_10ck410 FIND v(dout0_10) AT=420.05n

.meas tran vdout0_11ck410 FIND v(dout0_11) AT=420.05n

.meas tran vdout0_12ck410 FIND v(dout0_12) AT=420.05n

.meas tran vdout0_13ck410 FIND v(dout0_13) AT=420.05n

.meas tran vdout0_14ck410 FIND v(dout0_14) AT=420.05n

.meas tran vdout0_15ck410 FIND v(dout0_15) AT=420.05n

.meas tran vdout0_16ck410 FIND v(dout0_16) AT=420.05n

.meas tran vdout0_17ck410 FIND v(dout0_17) AT=420.05n

.meas tran vdout0_18ck410 FIND v(dout0_18) AT=420.05n

.meas tran vdout0_19ck410 FIND v(dout0_19) AT=420.05n

.meas tran vdout0_20ck410 FIND v(dout0_20) AT=420.05n

.meas tran vdout0_21ck410 FIND v(dout0_21) AT=420.05n

.meas tran vdout0_22ck410 FIND v(dout0_22) AT=420.05n

.meas tran vdout0_23ck410 FIND v(dout0_23) AT=420.05n

.meas tran vdout0_24ck410 FIND v(dout0_24) AT=420.05n

.meas tran vdout0_25ck410 FIND v(dout0_25) AT=420.05n

.meas tran vdout0_26ck410 FIND v(dout0_26) AT=420.05n

.meas tran vdout0_27ck410 FIND v(dout0_27) AT=420.05n

.meas tran vdout0_28ck410 FIND v(dout0_28) AT=420.05n

.meas tran vdout0_29ck410 FIND v(dout0_29) AT=420.05n

.meas tran vdout0_30ck410 FIND v(dout0_30) AT=420.05n

.meas tran vdout0_31ck410 FIND v(dout0_31) AT=420.05n

.meas tran vdout0_32ck410 FIND v(dout0_32) AT=420.05n

.meas tran vdout0_33ck410 FIND v(dout0_33) AT=420.05n

.meas tran vdout0_34ck410 FIND v(dout0_34) AT=420.05n

.meas tran vdout0_35ck410 FIND v(dout0_35) AT=420.05n

.meas tran vdout0_36ck410 FIND v(dout0_36) AT=420.05n

.meas tran vdout0_37ck410 FIND v(dout0_37) AT=420.05n

.meas tran vdout0_38ck410 FIND v(dout0_38) AT=420.05n

.meas tran vdout0_39ck410 FIND v(dout0_39) AT=420.05n

.meas tran vdout0_40ck410 FIND v(dout0_40) AT=420.05n

.meas tran vdout0_41ck410 FIND v(dout0_41) AT=420.05n

.meas tran vdout0_42ck410 FIND v(dout0_42) AT=420.05n

.meas tran vdout0_43ck410 FIND v(dout0_43) AT=420.05n

.meas tran vdout0_44ck410 FIND v(dout0_44) AT=420.05n

.meas tran vdout0_45ck410 FIND v(dout0_45) AT=420.05n

.meas tran vdout0_46ck410 FIND v(dout0_46) AT=420.05n

.meas tran vdout0_47ck410 FIND v(dout0_47) AT=420.05n

.meas tran vdout0_48ck410 FIND v(dout0_48) AT=420.05n

.meas tran vdout0_49ck410 FIND v(dout0_49) AT=420.05n

.meas tran vdout0_50ck410 FIND v(dout0_50) AT=420.05n

.meas tran vdout0_51ck410 FIND v(dout0_51) AT=420.05n

.meas tran vdout0_52ck410 FIND v(dout0_52) AT=420.05n

.meas tran vdout0_53ck410 FIND v(dout0_53) AT=420.05n

.meas tran vdout0_54ck410 FIND v(dout0_54) AT=420.05n

.meas tran vdout0_55ck410 FIND v(dout0_55) AT=420.05n

.meas tran vdout0_56ck410 FIND v(dout0_56) AT=420.05n

.meas tran vdout0_57ck410 FIND v(dout0_57) AT=420.05n

.meas tran vdout0_58ck410 FIND v(dout0_58) AT=420.05n

.meas tran vdout0_59ck410 FIND v(dout0_59) AT=420.05n

.meas tran vdout0_60ck410 FIND v(dout0_60) AT=420.05n

.meas tran vdout0_61ck410 FIND v(dout0_61) AT=420.05n

.meas tran vdout0_62ck410 FIND v(dout0_62) AT=420.05n

.meas tran vdout0_63ck410 FIND v(dout0_63) AT=420.05n

.meas tran vdout0_64ck410 FIND v(dout0_64) AT=420.05n

.meas tran vdout0_0ck460 FIND v(dout0_0) AT=470.05n

.meas tran vdout0_1ck460 FIND v(dout0_1) AT=470.05n

.meas tran vdout0_2ck460 FIND v(dout0_2) AT=470.05n

.meas tran vdout0_3ck460 FIND v(dout0_3) AT=470.05n

.meas tran vdout0_4ck460 FIND v(dout0_4) AT=470.05n

.meas tran vdout0_5ck460 FIND v(dout0_5) AT=470.05n

.meas tran vdout0_6ck460 FIND v(dout0_6) AT=470.05n

.meas tran vdout0_7ck460 FIND v(dout0_7) AT=470.05n

.meas tran vdout0_8ck460 FIND v(dout0_8) AT=470.05n

.meas tran vdout0_9ck460 FIND v(dout0_9) AT=470.05n

.meas tran vdout0_10ck460 FIND v(dout0_10) AT=470.05n

.meas tran vdout0_11ck460 FIND v(dout0_11) AT=470.05n

.meas tran vdout0_12ck460 FIND v(dout0_12) AT=470.05n

.meas tran vdout0_13ck460 FIND v(dout0_13) AT=470.05n

.meas tran vdout0_14ck460 FIND v(dout0_14) AT=470.05n

.meas tran vdout0_15ck460 FIND v(dout0_15) AT=470.05n

.meas tran vdout0_16ck460 FIND v(dout0_16) AT=470.05n

.meas tran vdout0_17ck460 FIND v(dout0_17) AT=470.05n

.meas tran vdout0_18ck460 FIND v(dout0_18) AT=470.05n

.meas tran vdout0_19ck460 FIND v(dout0_19) AT=470.05n

.meas tran vdout0_20ck460 FIND v(dout0_20) AT=470.05n

.meas tran vdout0_21ck460 FIND v(dout0_21) AT=470.05n

.meas tran vdout0_22ck460 FIND v(dout0_22) AT=470.05n

.meas tran vdout0_23ck460 FIND v(dout0_23) AT=470.05n

.meas tran vdout0_24ck460 FIND v(dout0_24) AT=470.05n

.meas tran vdout0_25ck460 FIND v(dout0_25) AT=470.05n

.meas tran vdout0_26ck460 FIND v(dout0_26) AT=470.05n

.meas tran vdout0_27ck460 FIND v(dout0_27) AT=470.05n

.meas tran vdout0_28ck460 FIND v(dout0_28) AT=470.05n

.meas tran vdout0_29ck460 FIND v(dout0_29) AT=470.05n

.meas tran vdout0_30ck460 FIND v(dout0_30) AT=470.05n

.meas tran vdout0_31ck460 FIND v(dout0_31) AT=470.05n

.meas tran vdout0_32ck460 FIND v(dout0_32) AT=470.05n

.meas tran vdout0_33ck460 FIND v(dout0_33) AT=470.05n

.meas tran vdout0_34ck460 FIND v(dout0_34) AT=470.05n

.meas tran vdout0_35ck460 FIND v(dout0_35) AT=470.05n

.meas tran vdout0_36ck460 FIND v(dout0_36) AT=470.05n

.meas tran vdout0_37ck460 FIND v(dout0_37) AT=470.05n

.meas tran vdout0_38ck460 FIND v(dout0_38) AT=470.05n

.meas tran vdout0_39ck460 FIND v(dout0_39) AT=470.05n

.meas tran vdout0_40ck460 FIND v(dout0_40) AT=470.05n

.meas tran vdout0_41ck460 FIND v(dout0_41) AT=470.05n

.meas tran vdout0_42ck460 FIND v(dout0_42) AT=470.05n

.meas tran vdout0_43ck460 FIND v(dout0_43) AT=470.05n

.meas tran vdout0_44ck460 FIND v(dout0_44) AT=470.05n

.meas tran vdout0_45ck460 FIND v(dout0_45) AT=470.05n

.meas tran vdout0_46ck460 FIND v(dout0_46) AT=470.05n

.meas tran vdout0_47ck460 FIND v(dout0_47) AT=470.05n

.meas tran vdout0_48ck460 FIND v(dout0_48) AT=470.05n

.meas tran vdout0_49ck460 FIND v(dout0_49) AT=470.05n

.meas tran vdout0_50ck460 FIND v(dout0_50) AT=470.05n

.meas tran vdout0_51ck460 FIND v(dout0_51) AT=470.05n

.meas tran vdout0_52ck460 FIND v(dout0_52) AT=470.05n

.meas tran vdout0_53ck460 FIND v(dout0_53) AT=470.05n

.meas tran vdout0_54ck460 FIND v(dout0_54) AT=470.05n

.meas tran vdout0_55ck460 FIND v(dout0_55) AT=470.05n

.meas tran vdout0_56ck460 FIND v(dout0_56) AT=470.05n

.meas tran vdout0_57ck460 FIND v(dout0_57) AT=470.05n

.meas tran vdout0_58ck460 FIND v(dout0_58) AT=470.05n

.meas tran vdout0_59ck460 FIND v(dout0_59) AT=470.05n

.meas tran vdout0_60ck460 FIND v(dout0_60) AT=470.05n

.meas tran vdout0_61ck460 FIND v(dout0_61) AT=470.05n

.meas tran vdout0_62ck460 FIND v(dout0_62) AT=470.05n

.meas tran vdout0_63ck460 FIND v(dout0_63) AT=470.05n

.meas tran vdout0_64ck460 FIND v(dout0_64) AT=470.05n

.meas tran vdout0_0ck480 FIND v(dout0_0) AT=490.05n

.meas tran vdout0_1ck480 FIND v(dout0_1) AT=490.05n

.meas tran vdout0_2ck480 FIND v(dout0_2) AT=490.05n

.meas tran vdout0_3ck480 FIND v(dout0_3) AT=490.05n

.meas tran vdout0_4ck480 FIND v(dout0_4) AT=490.05n

.meas tran vdout0_5ck480 FIND v(dout0_5) AT=490.05n

.meas tran vdout0_6ck480 FIND v(dout0_6) AT=490.05n

.meas tran vdout0_7ck480 FIND v(dout0_7) AT=490.05n

.meas tran vdout0_8ck480 FIND v(dout0_8) AT=490.05n

.meas tran vdout0_9ck480 FIND v(dout0_9) AT=490.05n

.meas tran vdout0_10ck480 FIND v(dout0_10) AT=490.05n

.meas tran vdout0_11ck480 FIND v(dout0_11) AT=490.05n

.meas tran vdout0_12ck480 FIND v(dout0_12) AT=490.05n

.meas tran vdout0_13ck480 FIND v(dout0_13) AT=490.05n

.meas tran vdout0_14ck480 FIND v(dout0_14) AT=490.05n

.meas tran vdout0_15ck480 FIND v(dout0_15) AT=490.05n

.meas tran vdout0_16ck480 FIND v(dout0_16) AT=490.05n

.meas tran vdout0_17ck480 FIND v(dout0_17) AT=490.05n

.meas tran vdout0_18ck480 FIND v(dout0_18) AT=490.05n

.meas tran vdout0_19ck480 FIND v(dout0_19) AT=490.05n

.meas tran vdout0_20ck480 FIND v(dout0_20) AT=490.05n

.meas tran vdout0_21ck480 FIND v(dout0_21) AT=490.05n

.meas tran vdout0_22ck480 FIND v(dout0_22) AT=490.05n

.meas tran vdout0_23ck480 FIND v(dout0_23) AT=490.05n

.meas tran vdout0_24ck480 FIND v(dout0_24) AT=490.05n

.meas tran vdout0_25ck480 FIND v(dout0_25) AT=490.05n

.meas tran vdout0_26ck480 FIND v(dout0_26) AT=490.05n

.meas tran vdout0_27ck480 FIND v(dout0_27) AT=490.05n

.meas tran vdout0_28ck480 FIND v(dout0_28) AT=490.05n

.meas tran vdout0_29ck480 FIND v(dout0_29) AT=490.05n

.meas tran vdout0_30ck480 FIND v(dout0_30) AT=490.05n

.meas tran vdout0_31ck480 FIND v(dout0_31) AT=490.05n

.meas tran vdout0_32ck480 FIND v(dout0_32) AT=490.05n

.meas tran vdout0_33ck480 FIND v(dout0_33) AT=490.05n

.meas tran vdout0_34ck480 FIND v(dout0_34) AT=490.05n

.meas tran vdout0_35ck480 FIND v(dout0_35) AT=490.05n

.meas tran vdout0_36ck480 FIND v(dout0_36) AT=490.05n

.meas tran vdout0_37ck480 FIND v(dout0_37) AT=490.05n

.meas tran vdout0_38ck480 FIND v(dout0_38) AT=490.05n

.meas tran vdout0_39ck480 FIND v(dout0_39) AT=490.05n

.meas tran vdout0_40ck480 FIND v(dout0_40) AT=490.05n

.meas tran vdout0_41ck480 FIND v(dout0_41) AT=490.05n

.meas tran vdout0_42ck480 FIND v(dout0_42) AT=490.05n

.meas tran vdout0_43ck480 FIND v(dout0_43) AT=490.05n

.meas tran vdout0_44ck480 FIND v(dout0_44) AT=490.05n

.meas tran vdout0_45ck480 FIND v(dout0_45) AT=490.05n

.meas tran vdout0_46ck480 FIND v(dout0_46) AT=490.05n

.meas tran vdout0_47ck480 FIND v(dout0_47) AT=490.05n

.meas tran vdout0_48ck480 FIND v(dout0_48) AT=490.05n

.meas tran vdout0_49ck480 FIND v(dout0_49) AT=490.05n

.meas tran vdout0_50ck480 FIND v(dout0_50) AT=490.05n

.meas tran vdout0_51ck480 FIND v(dout0_51) AT=490.05n

.meas tran vdout0_52ck480 FIND v(dout0_52) AT=490.05n

.meas tran vdout0_53ck480 FIND v(dout0_53) AT=490.05n

.meas tran vdout0_54ck480 FIND v(dout0_54) AT=490.05n

.meas tran vdout0_55ck480 FIND v(dout0_55) AT=490.05n

.meas tran vdout0_56ck480 FIND v(dout0_56) AT=490.05n

.meas tran vdout0_57ck480 FIND v(dout0_57) AT=490.05n

.meas tran vdout0_58ck480 FIND v(dout0_58) AT=490.05n

.meas tran vdout0_59ck480 FIND v(dout0_59) AT=490.05n

.meas tran vdout0_60ck480 FIND v(dout0_60) AT=490.05n

.meas tran vdout0_61ck480 FIND v(dout0_61) AT=490.05n

.meas tran vdout0_62ck480 FIND v(dout0_62) AT=490.05n

.meas tran vdout0_63ck480 FIND v(dout0_63) AT=490.05n

.meas tran vdout0_64ck480 FIND v(dout0_64) AT=490.05n

.meas tran vdout0_0ck490 FIND v(dout0_0) AT=500.05n

.meas tran vdout0_1ck490 FIND v(dout0_1) AT=500.05n

.meas tran vdout0_2ck490 FIND v(dout0_2) AT=500.05n

.meas tran vdout0_3ck490 FIND v(dout0_3) AT=500.05n

.meas tran vdout0_4ck490 FIND v(dout0_4) AT=500.05n

.meas tran vdout0_5ck490 FIND v(dout0_5) AT=500.05n

.meas tran vdout0_6ck490 FIND v(dout0_6) AT=500.05n

.meas tran vdout0_7ck490 FIND v(dout0_7) AT=500.05n

.meas tran vdout0_8ck490 FIND v(dout0_8) AT=500.05n

.meas tran vdout0_9ck490 FIND v(dout0_9) AT=500.05n

.meas tran vdout0_10ck490 FIND v(dout0_10) AT=500.05n

.meas tran vdout0_11ck490 FIND v(dout0_11) AT=500.05n

.meas tran vdout0_12ck490 FIND v(dout0_12) AT=500.05n

.meas tran vdout0_13ck490 FIND v(dout0_13) AT=500.05n

.meas tran vdout0_14ck490 FIND v(dout0_14) AT=500.05n

.meas tran vdout0_15ck490 FIND v(dout0_15) AT=500.05n

.meas tran vdout0_16ck490 FIND v(dout0_16) AT=500.05n

.meas tran vdout0_17ck490 FIND v(dout0_17) AT=500.05n

.meas tran vdout0_18ck490 FIND v(dout0_18) AT=500.05n

.meas tran vdout0_19ck490 FIND v(dout0_19) AT=500.05n

.meas tran vdout0_20ck490 FIND v(dout0_20) AT=500.05n

.meas tran vdout0_21ck490 FIND v(dout0_21) AT=500.05n

.meas tran vdout0_22ck490 FIND v(dout0_22) AT=500.05n

.meas tran vdout0_23ck490 FIND v(dout0_23) AT=500.05n

.meas tran vdout0_24ck490 FIND v(dout0_24) AT=500.05n

.meas tran vdout0_25ck490 FIND v(dout0_25) AT=500.05n

.meas tran vdout0_26ck490 FIND v(dout0_26) AT=500.05n

.meas tran vdout0_27ck490 FIND v(dout0_27) AT=500.05n

.meas tran vdout0_28ck490 FIND v(dout0_28) AT=500.05n

.meas tran vdout0_29ck490 FIND v(dout0_29) AT=500.05n

.meas tran vdout0_30ck490 FIND v(dout0_30) AT=500.05n

.meas tran vdout0_31ck490 FIND v(dout0_31) AT=500.05n

.meas tran vdout0_32ck490 FIND v(dout0_32) AT=500.05n

.meas tran vdout0_33ck490 FIND v(dout0_33) AT=500.05n

.meas tran vdout0_34ck490 FIND v(dout0_34) AT=500.05n

.meas tran vdout0_35ck490 FIND v(dout0_35) AT=500.05n

.meas tran vdout0_36ck490 FIND v(dout0_36) AT=500.05n

.meas tran vdout0_37ck490 FIND v(dout0_37) AT=500.05n

.meas tran vdout0_38ck490 FIND v(dout0_38) AT=500.05n

.meas tran vdout0_39ck490 FIND v(dout0_39) AT=500.05n

.meas tran vdout0_40ck490 FIND v(dout0_40) AT=500.05n

.meas tran vdout0_41ck490 FIND v(dout0_41) AT=500.05n

.meas tran vdout0_42ck490 FIND v(dout0_42) AT=500.05n

.meas tran vdout0_43ck490 FIND v(dout0_43) AT=500.05n

.meas tran vdout0_44ck490 FIND v(dout0_44) AT=500.05n

.meas tran vdout0_45ck490 FIND v(dout0_45) AT=500.05n

.meas tran vdout0_46ck490 FIND v(dout0_46) AT=500.05n

.meas tran vdout0_47ck490 FIND v(dout0_47) AT=500.05n

.meas tran vdout0_48ck490 FIND v(dout0_48) AT=500.05n

.meas tran vdout0_49ck490 FIND v(dout0_49) AT=500.05n

.meas tran vdout0_50ck490 FIND v(dout0_50) AT=500.05n

.meas tran vdout0_51ck490 FIND v(dout0_51) AT=500.05n

.meas tran vdout0_52ck490 FIND v(dout0_52) AT=500.05n

.meas tran vdout0_53ck490 FIND v(dout0_53) AT=500.05n

.meas tran vdout0_54ck490 FIND v(dout0_54) AT=500.05n

.meas tran vdout0_55ck490 FIND v(dout0_55) AT=500.05n

.meas tran vdout0_56ck490 FIND v(dout0_56) AT=500.05n

.meas tran vdout0_57ck490 FIND v(dout0_57) AT=500.05n

.meas tran vdout0_58ck490 FIND v(dout0_58) AT=500.05n

.meas tran vdout0_59ck490 FIND v(dout0_59) AT=500.05n

.meas tran vdout0_60ck490 FIND v(dout0_60) AT=500.05n

.meas tran vdout0_61ck490 FIND v(dout0_61) AT=500.05n

.meas tran vdout0_62ck490 FIND v(dout0_62) AT=500.05n

.meas tran vdout0_63ck490 FIND v(dout0_63) AT=500.05n

.meas tran vdout0_64ck490 FIND v(dout0_64) AT=500.05n

.meas tran vdout0_0ck570 FIND v(dout0_0) AT=580.05n

.meas tran vdout0_1ck570 FIND v(dout0_1) AT=580.05n

.meas tran vdout0_2ck570 FIND v(dout0_2) AT=580.05n

.meas tran vdout0_3ck570 FIND v(dout0_3) AT=580.05n

.meas tran vdout0_4ck570 FIND v(dout0_4) AT=580.05n

.meas tran vdout0_5ck570 FIND v(dout0_5) AT=580.05n

.meas tran vdout0_6ck570 FIND v(dout0_6) AT=580.05n

.meas tran vdout0_7ck570 FIND v(dout0_7) AT=580.05n

.meas tran vdout0_8ck570 FIND v(dout0_8) AT=580.05n

.meas tran vdout0_9ck570 FIND v(dout0_9) AT=580.05n

.meas tran vdout0_10ck570 FIND v(dout0_10) AT=580.05n

.meas tran vdout0_11ck570 FIND v(dout0_11) AT=580.05n

.meas tran vdout0_12ck570 FIND v(dout0_12) AT=580.05n

.meas tran vdout0_13ck570 FIND v(dout0_13) AT=580.05n

.meas tran vdout0_14ck570 FIND v(dout0_14) AT=580.05n

.meas tran vdout0_15ck570 FIND v(dout0_15) AT=580.05n

.meas tran vdout0_16ck570 FIND v(dout0_16) AT=580.05n

.meas tran vdout0_17ck570 FIND v(dout0_17) AT=580.05n

.meas tran vdout0_18ck570 FIND v(dout0_18) AT=580.05n

.meas tran vdout0_19ck570 FIND v(dout0_19) AT=580.05n

.meas tran vdout0_20ck570 FIND v(dout0_20) AT=580.05n

.meas tran vdout0_21ck570 FIND v(dout0_21) AT=580.05n

.meas tran vdout0_22ck570 FIND v(dout0_22) AT=580.05n

.meas tran vdout0_23ck570 FIND v(dout0_23) AT=580.05n

.meas tran vdout0_24ck570 FIND v(dout0_24) AT=580.05n

.meas tran vdout0_25ck570 FIND v(dout0_25) AT=580.05n

.meas tran vdout0_26ck570 FIND v(dout0_26) AT=580.05n

.meas tran vdout0_27ck570 FIND v(dout0_27) AT=580.05n

.meas tran vdout0_28ck570 FIND v(dout0_28) AT=580.05n

.meas tran vdout0_29ck570 FIND v(dout0_29) AT=580.05n

.meas tran vdout0_30ck570 FIND v(dout0_30) AT=580.05n

.meas tran vdout0_31ck570 FIND v(dout0_31) AT=580.05n

.meas tran vdout0_32ck570 FIND v(dout0_32) AT=580.05n

.meas tran vdout0_33ck570 FIND v(dout0_33) AT=580.05n

.meas tran vdout0_34ck570 FIND v(dout0_34) AT=580.05n

.meas tran vdout0_35ck570 FIND v(dout0_35) AT=580.05n

.meas tran vdout0_36ck570 FIND v(dout0_36) AT=580.05n

.meas tran vdout0_37ck570 FIND v(dout0_37) AT=580.05n

.meas tran vdout0_38ck570 FIND v(dout0_38) AT=580.05n

.meas tran vdout0_39ck570 FIND v(dout0_39) AT=580.05n

.meas tran vdout0_40ck570 FIND v(dout0_40) AT=580.05n

.meas tran vdout0_41ck570 FIND v(dout0_41) AT=580.05n

.meas tran vdout0_42ck570 FIND v(dout0_42) AT=580.05n

.meas tran vdout0_43ck570 FIND v(dout0_43) AT=580.05n

.meas tran vdout0_44ck570 FIND v(dout0_44) AT=580.05n

.meas tran vdout0_45ck570 FIND v(dout0_45) AT=580.05n

.meas tran vdout0_46ck570 FIND v(dout0_46) AT=580.05n

.meas tran vdout0_47ck570 FIND v(dout0_47) AT=580.05n

.meas tran vdout0_48ck570 FIND v(dout0_48) AT=580.05n

.meas tran vdout0_49ck570 FIND v(dout0_49) AT=580.05n

.meas tran vdout0_50ck570 FIND v(dout0_50) AT=580.05n

.meas tran vdout0_51ck570 FIND v(dout0_51) AT=580.05n

.meas tran vdout0_52ck570 FIND v(dout0_52) AT=580.05n

.meas tran vdout0_53ck570 FIND v(dout0_53) AT=580.05n

.meas tran vdout0_54ck570 FIND v(dout0_54) AT=580.05n

.meas tran vdout0_55ck570 FIND v(dout0_55) AT=580.05n

.meas tran vdout0_56ck570 FIND v(dout0_56) AT=580.05n

.meas tran vdout0_57ck570 FIND v(dout0_57) AT=580.05n

.meas tran vdout0_58ck570 FIND v(dout0_58) AT=580.05n

.meas tran vdout0_59ck570 FIND v(dout0_59) AT=580.05n

.meas tran vdout0_60ck570 FIND v(dout0_60) AT=580.05n

.meas tran vdout0_61ck570 FIND v(dout0_61) AT=580.05n

.meas tran vdout0_62ck570 FIND v(dout0_62) AT=580.05n

.meas tran vdout0_63ck570 FIND v(dout0_63) AT=580.05n

.meas tran vdout0_64ck570 FIND v(dout0_64) AT=580.05n

.meas tran vdout0_0ck580 FIND v(dout0_0) AT=590.05n

.meas tran vdout0_1ck580 FIND v(dout0_1) AT=590.05n

.meas tran vdout0_2ck580 FIND v(dout0_2) AT=590.05n

.meas tran vdout0_3ck580 FIND v(dout0_3) AT=590.05n

.meas tran vdout0_4ck580 FIND v(dout0_4) AT=590.05n

.meas tran vdout0_5ck580 FIND v(dout0_5) AT=590.05n

.meas tran vdout0_6ck580 FIND v(dout0_6) AT=590.05n

.meas tran vdout0_7ck580 FIND v(dout0_7) AT=590.05n

.meas tran vdout0_8ck580 FIND v(dout0_8) AT=590.05n

.meas tran vdout0_9ck580 FIND v(dout0_9) AT=590.05n

.meas tran vdout0_10ck580 FIND v(dout0_10) AT=590.05n

.meas tran vdout0_11ck580 FIND v(dout0_11) AT=590.05n

.meas tran vdout0_12ck580 FIND v(dout0_12) AT=590.05n

.meas tran vdout0_13ck580 FIND v(dout0_13) AT=590.05n

.meas tran vdout0_14ck580 FIND v(dout0_14) AT=590.05n

.meas tran vdout0_15ck580 FIND v(dout0_15) AT=590.05n

.meas tran vdout0_16ck580 FIND v(dout0_16) AT=590.05n

.meas tran vdout0_17ck580 FIND v(dout0_17) AT=590.05n

.meas tran vdout0_18ck580 FIND v(dout0_18) AT=590.05n

.meas tran vdout0_19ck580 FIND v(dout0_19) AT=590.05n

.meas tran vdout0_20ck580 FIND v(dout0_20) AT=590.05n

.meas tran vdout0_21ck580 FIND v(dout0_21) AT=590.05n

.meas tran vdout0_22ck580 FIND v(dout0_22) AT=590.05n

.meas tran vdout0_23ck580 FIND v(dout0_23) AT=590.05n

.meas tran vdout0_24ck580 FIND v(dout0_24) AT=590.05n

.meas tran vdout0_25ck580 FIND v(dout0_25) AT=590.05n

.meas tran vdout0_26ck580 FIND v(dout0_26) AT=590.05n

.meas tran vdout0_27ck580 FIND v(dout0_27) AT=590.05n

.meas tran vdout0_28ck580 FIND v(dout0_28) AT=590.05n

.meas tran vdout0_29ck580 FIND v(dout0_29) AT=590.05n

.meas tran vdout0_30ck580 FIND v(dout0_30) AT=590.05n

.meas tran vdout0_31ck580 FIND v(dout0_31) AT=590.05n

.meas tran vdout0_32ck580 FIND v(dout0_32) AT=590.05n

.meas tran vdout0_33ck580 FIND v(dout0_33) AT=590.05n

.meas tran vdout0_34ck580 FIND v(dout0_34) AT=590.05n

.meas tran vdout0_35ck580 FIND v(dout0_35) AT=590.05n

.meas tran vdout0_36ck580 FIND v(dout0_36) AT=590.05n

.meas tran vdout0_37ck580 FIND v(dout0_37) AT=590.05n

.meas tran vdout0_38ck580 FIND v(dout0_38) AT=590.05n

.meas tran vdout0_39ck580 FIND v(dout0_39) AT=590.05n

.meas tran vdout0_40ck580 FIND v(dout0_40) AT=590.05n

.meas tran vdout0_41ck580 FIND v(dout0_41) AT=590.05n

.meas tran vdout0_42ck580 FIND v(dout0_42) AT=590.05n

.meas tran vdout0_43ck580 FIND v(dout0_43) AT=590.05n

.meas tran vdout0_44ck580 FIND v(dout0_44) AT=590.05n

.meas tran vdout0_45ck580 FIND v(dout0_45) AT=590.05n

.meas tran vdout0_46ck580 FIND v(dout0_46) AT=590.05n

.meas tran vdout0_47ck580 FIND v(dout0_47) AT=590.05n

.meas tran vdout0_48ck580 FIND v(dout0_48) AT=590.05n

.meas tran vdout0_49ck580 FIND v(dout0_49) AT=590.05n

.meas tran vdout0_50ck580 FIND v(dout0_50) AT=590.05n

.meas tran vdout0_51ck580 FIND v(dout0_51) AT=590.05n

.meas tran vdout0_52ck580 FIND v(dout0_52) AT=590.05n

.meas tran vdout0_53ck580 FIND v(dout0_53) AT=590.05n

.meas tran vdout0_54ck580 FIND v(dout0_54) AT=590.05n

.meas tran vdout0_55ck580 FIND v(dout0_55) AT=590.05n

.meas tran vdout0_56ck580 FIND v(dout0_56) AT=590.05n

.meas tran vdout0_57ck580 FIND v(dout0_57) AT=590.05n

.meas tran vdout0_58ck580 FIND v(dout0_58) AT=590.05n

.meas tran vdout0_59ck580 FIND v(dout0_59) AT=590.05n

.meas tran vdout0_60ck580 FIND v(dout0_60) AT=590.05n

.meas tran vdout0_61ck580 FIND v(dout0_61) AT=590.05n

.meas tran vdout0_62ck580 FIND v(dout0_62) AT=590.05n

.meas tran vdout0_63ck580 FIND v(dout0_63) AT=590.05n

.meas tran vdout0_64ck580 FIND v(dout0_64) AT=590.05n

.meas tran vdout0_0ck600 FIND v(dout0_0) AT=610.05n

.meas tran vdout0_1ck600 FIND v(dout0_1) AT=610.05n

.meas tran vdout0_2ck600 FIND v(dout0_2) AT=610.05n

.meas tran vdout0_3ck600 FIND v(dout0_3) AT=610.05n

.meas tran vdout0_4ck600 FIND v(dout0_4) AT=610.05n

.meas tran vdout0_5ck600 FIND v(dout0_5) AT=610.05n

.meas tran vdout0_6ck600 FIND v(dout0_6) AT=610.05n

.meas tran vdout0_7ck600 FIND v(dout0_7) AT=610.05n

.meas tran vdout0_8ck600 FIND v(dout0_8) AT=610.05n

.meas tran vdout0_9ck600 FIND v(dout0_9) AT=610.05n

.meas tran vdout0_10ck600 FIND v(dout0_10) AT=610.05n

.meas tran vdout0_11ck600 FIND v(dout0_11) AT=610.05n

.meas tran vdout0_12ck600 FIND v(dout0_12) AT=610.05n

.meas tran vdout0_13ck600 FIND v(dout0_13) AT=610.05n

.meas tran vdout0_14ck600 FIND v(dout0_14) AT=610.05n

.meas tran vdout0_15ck600 FIND v(dout0_15) AT=610.05n

.meas tran vdout0_16ck600 FIND v(dout0_16) AT=610.05n

.meas tran vdout0_17ck600 FIND v(dout0_17) AT=610.05n

.meas tran vdout0_18ck600 FIND v(dout0_18) AT=610.05n

.meas tran vdout0_19ck600 FIND v(dout0_19) AT=610.05n

.meas tran vdout0_20ck600 FIND v(dout0_20) AT=610.05n

.meas tran vdout0_21ck600 FIND v(dout0_21) AT=610.05n

.meas tran vdout0_22ck600 FIND v(dout0_22) AT=610.05n

.meas tran vdout0_23ck600 FIND v(dout0_23) AT=610.05n

.meas tran vdout0_24ck600 FIND v(dout0_24) AT=610.05n

.meas tran vdout0_25ck600 FIND v(dout0_25) AT=610.05n

.meas tran vdout0_26ck600 FIND v(dout0_26) AT=610.05n

.meas tran vdout0_27ck600 FIND v(dout0_27) AT=610.05n

.meas tran vdout0_28ck600 FIND v(dout0_28) AT=610.05n

.meas tran vdout0_29ck600 FIND v(dout0_29) AT=610.05n

.meas tran vdout0_30ck600 FIND v(dout0_30) AT=610.05n

.meas tran vdout0_31ck600 FIND v(dout0_31) AT=610.05n

.meas tran vdout0_32ck600 FIND v(dout0_32) AT=610.05n

.meas tran vdout0_33ck600 FIND v(dout0_33) AT=610.05n

.meas tran vdout0_34ck600 FIND v(dout0_34) AT=610.05n

.meas tran vdout0_35ck600 FIND v(dout0_35) AT=610.05n

.meas tran vdout0_36ck600 FIND v(dout0_36) AT=610.05n

.meas tran vdout0_37ck600 FIND v(dout0_37) AT=610.05n

.meas tran vdout0_38ck600 FIND v(dout0_38) AT=610.05n

.meas tran vdout0_39ck600 FIND v(dout0_39) AT=610.05n

.meas tran vdout0_40ck600 FIND v(dout0_40) AT=610.05n

.meas tran vdout0_41ck600 FIND v(dout0_41) AT=610.05n

.meas tran vdout0_42ck600 FIND v(dout0_42) AT=610.05n

.meas tran vdout0_43ck600 FIND v(dout0_43) AT=610.05n

.meas tran vdout0_44ck600 FIND v(dout0_44) AT=610.05n

.meas tran vdout0_45ck600 FIND v(dout0_45) AT=610.05n

.meas tran vdout0_46ck600 FIND v(dout0_46) AT=610.05n

.meas tran vdout0_47ck600 FIND v(dout0_47) AT=610.05n

.meas tran vdout0_48ck600 FIND v(dout0_48) AT=610.05n

.meas tran vdout0_49ck600 FIND v(dout0_49) AT=610.05n

.meas tran vdout0_50ck600 FIND v(dout0_50) AT=610.05n

.meas tran vdout0_51ck600 FIND v(dout0_51) AT=610.05n

.meas tran vdout0_52ck600 FIND v(dout0_52) AT=610.05n

.meas tran vdout0_53ck600 FIND v(dout0_53) AT=610.05n

.meas tran vdout0_54ck600 FIND v(dout0_54) AT=610.05n

.meas tran vdout0_55ck600 FIND v(dout0_55) AT=610.05n

.meas tran vdout0_56ck600 FIND v(dout0_56) AT=610.05n

.meas tran vdout0_57ck600 FIND v(dout0_57) AT=610.05n

.meas tran vdout0_58ck600 FIND v(dout0_58) AT=610.05n

.meas tran vdout0_59ck600 FIND v(dout0_59) AT=610.05n

.meas tran vdout0_60ck600 FIND v(dout0_60) AT=610.05n

.meas tran vdout0_61ck600 FIND v(dout0_61) AT=610.05n

.meas tran vdout0_62ck600 FIND v(dout0_62) AT=610.05n

.meas tran vdout0_63ck600 FIND v(dout0_63) AT=610.05n

.meas tran vdout0_64ck600 FIND v(dout0_64) AT=610.05n

.meas tran vdout0_0ck640 FIND v(dout0_0) AT=650.05n

.meas tran vdout0_1ck640 FIND v(dout0_1) AT=650.05n

.meas tran vdout0_2ck640 FIND v(dout0_2) AT=650.05n

.meas tran vdout0_3ck640 FIND v(dout0_3) AT=650.05n

.meas tran vdout0_4ck640 FIND v(dout0_4) AT=650.05n

.meas tran vdout0_5ck640 FIND v(dout0_5) AT=650.05n

.meas tran vdout0_6ck640 FIND v(dout0_6) AT=650.05n

.meas tran vdout0_7ck640 FIND v(dout0_7) AT=650.05n

.meas tran vdout0_8ck640 FIND v(dout0_8) AT=650.05n

.meas tran vdout0_9ck640 FIND v(dout0_9) AT=650.05n

.meas tran vdout0_10ck640 FIND v(dout0_10) AT=650.05n

.meas tran vdout0_11ck640 FIND v(dout0_11) AT=650.05n

.meas tran vdout0_12ck640 FIND v(dout0_12) AT=650.05n

.meas tran vdout0_13ck640 FIND v(dout0_13) AT=650.05n

.meas tran vdout0_14ck640 FIND v(dout0_14) AT=650.05n

.meas tran vdout0_15ck640 FIND v(dout0_15) AT=650.05n

.meas tran vdout0_16ck640 FIND v(dout0_16) AT=650.05n

.meas tran vdout0_17ck640 FIND v(dout0_17) AT=650.05n

.meas tran vdout0_18ck640 FIND v(dout0_18) AT=650.05n

.meas tran vdout0_19ck640 FIND v(dout0_19) AT=650.05n

.meas tran vdout0_20ck640 FIND v(dout0_20) AT=650.05n

.meas tran vdout0_21ck640 FIND v(dout0_21) AT=650.05n

.meas tran vdout0_22ck640 FIND v(dout0_22) AT=650.05n

.meas tran vdout0_23ck640 FIND v(dout0_23) AT=650.05n

.meas tran vdout0_24ck640 FIND v(dout0_24) AT=650.05n

.meas tran vdout0_25ck640 FIND v(dout0_25) AT=650.05n

.meas tran vdout0_26ck640 FIND v(dout0_26) AT=650.05n

.meas tran vdout0_27ck640 FIND v(dout0_27) AT=650.05n

.meas tran vdout0_28ck640 FIND v(dout0_28) AT=650.05n

.meas tran vdout0_29ck640 FIND v(dout0_29) AT=650.05n

.meas tran vdout0_30ck640 FIND v(dout0_30) AT=650.05n

.meas tran vdout0_31ck640 FIND v(dout0_31) AT=650.05n

.meas tran vdout0_32ck640 FIND v(dout0_32) AT=650.05n

.meas tran vdout0_33ck640 FIND v(dout0_33) AT=650.05n

.meas tran vdout0_34ck640 FIND v(dout0_34) AT=650.05n

.meas tran vdout0_35ck640 FIND v(dout0_35) AT=650.05n

.meas tran vdout0_36ck640 FIND v(dout0_36) AT=650.05n

.meas tran vdout0_37ck640 FIND v(dout0_37) AT=650.05n

.meas tran vdout0_38ck640 FIND v(dout0_38) AT=650.05n

.meas tran vdout0_39ck640 FIND v(dout0_39) AT=650.05n

.meas tran vdout0_40ck640 FIND v(dout0_40) AT=650.05n

.meas tran vdout0_41ck640 FIND v(dout0_41) AT=650.05n

.meas tran vdout0_42ck640 FIND v(dout0_42) AT=650.05n

.meas tran vdout0_43ck640 FIND v(dout0_43) AT=650.05n

.meas tran vdout0_44ck640 FIND v(dout0_44) AT=650.05n

.meas tran vdout0_45ck640 FIND v(dout0_45) AT=650.05n

.meas tran vdout0_46ck640 FIND v(dout0_46) AT=650.05n

.meas tran vdout0_47ck640 FIND v(dout0_47) AT=650.05n

.meas tran vdout0_48ck640 FIND v(dout0_48) AT=650.05n

.meas tran vdout0_49ck640 FIND v(dout0_49) AT=650.05n

.meas tran vdout0_50ck640 FIND v(dout0_50) AT=650.05n

.meas tran vdout0_51ck640 FIND v(dout0_51) AT=650.05n

.meas tran vdout0_52ck640 FIND v(dout0_52) AT=650.05n

.meas tran vdout0_53ck640 FIND v(dout0_53) AT=650.05n

.meas tran vdout0_54ck640 FIND v(dout0_54) AT=650.05n

.meas tran vdout0_55ck640 FIND v(dout0_55) AT=650.05n

.meas tran vdout0_56ck640 FIND v(dout0_56) AT=650.05n

.meas tran vdout0_57ck640 FIND v(dout0_57) AT=650.05n

.meas tran vdout0_58ck640 FIND v(dout0_58) AT=650.05n

.meas tran vdout0_59ck640 FIND v(dout0_59) AT=650.05n

.meas tran vdout0_60ck640 FIND v(dout0_60) AT=650.05n

.meas tran vdout0_61ck640 FIND v(dout0_61) AT=650.05n

.meas tran vdout0_62ck640 FIND v(dout0_62) AT=650.05n

.meas tran vdout0_63ck640 FIND v(dout0_63) AT=650.05n

.meas tran vdout0_64ck640 FIND v(dout0_64) AT=650.05n

.meas tran vdout0_0ck660 FIND v(dout0_0) AT=670.05n

.meas tran vdout0_1ck660 FIND v(dout0_1) AT=670.05n

.meas tran vdout0_2ck660 FIND v(dout0_2) AT=670.05n

.meas tran vdout0_3ck660 FIND v(dout0_3) AT=670.05n

.meas tran vdout0_4ck660 FIND v(dout0_4) AT=670.05n

.meas tran vdout0_5ck660 FIND v(dout0_5) AT=670.05n

.meas tran vdout0_6ck660 FIND v(dout0_6) AT=670.05n

.meas tran vdout0_7ck660 FIND v(dout0_7) AT=670.05n

.meas tran vdout0_8ck660 FIND v(dout0_8) AT=670.05n

.meas tran vdout0_9ck660 FIND v(dout0_9) AT=670.05n

.meas tran vdout0_10ck660 FIND v(dout0_10) AT=670.05n

.meas tran vdout0_11ck660 FIND v(dout0_11) AT=670.05n

.meas tran vdout0_12ck660 FIND v(dout0_12) AT=670.05n

.meas tran vdout0_13ck660 FIND v(dout0_13) AT=670.05n

.meas tran vdout0_14ck660 FIND v(dout0_14) AT=670.05n

.meas tran vdout0_15ck660 FIND v(dout0_15) AT=670.05n

.meas tran vdout0_16ck660 FIND v(dout0_16) AT=670.05n

.meas tran vdout0_17ck660 FIND v(dout0_17) AT=670.05n

.meas tran vdout0_18ck660 FIND v(dout0_18) AT=670.05n

.meas tran vdout0_19ck660 FIND v(dout0_19) AT=670.05n

.meas tran vdout0_20ck660 FIND v(dout0_20) AT=670.05n

.meas tran vdout0_21ck660 FIND v(dout0_21) AT=670.05n

.meas tran vdout0_22ck660 FIND v(dout0_22) AT=670.05n

.meas tran vdout0_23ck660 FIND v(dout0_23) AT=670.05n

.meas tran vdout0_24ck660 FIND v(dout0_24) AT=670.05n

.meas tran vdout0_25ck660 FIND v(dout0_25) AT=670.05n

.meas tran vdout0_26ck660 FIND v(dout0_26) AT=670.05n

.meas tran vdout0_27ck660 FIND v(dout0_27) AT=670.05n

.meas tran vdout0_28ck660 FIND v(dout0_28) AT=670.05n

.meas tran vdout0_29ck660 FIND v(dout0_29) AT=670.05n

.meas tran vdout0_30ck660 FIND v(dout0_30) AT=670.05n

.meas tran vdout0_31ck660 FIND v(dout0_31) AT=670.05n

.meas tran vdout0_32ck660 FIND v(dout0_32) AT=670.05n

.meas tran vdout0_33ck660 FIND v(dout0_33) AT=670.05n

.meas tran vdout0_34ck660 FIND v(dout0_34) AT=670.05n

.meas tran vdout0_35ck660 FIND v(dout0_35) AT=670.05n

.meas tran vdout0_36ck660 FIND v(dout0_36) AT=670.05n

.meas tran vdout0_37ck660 FIND v(dout0_37) AT=670.05n

.meas tran vdout0_38ck660 FIND v(dout0_38) AT=670.05n

.meas tran vdout0_39ck660 FIND v(dout0_39) AT=670.05n

.meas tran vdout0_40ck660 FIND v(dout0_40) AT=670.05n

.meas tran vdout0_41ck660 FIND v(dout0_41) AT=670.05n

.meas tran vdout0_42ck660 FIND v(dout0_42) AT=670.05n

.meas tran vdout0_43ck660 FIND v(dout0_43) AT=670.05n

.meas tran vdout0_44ck660 FIND v(dout0_44) AT=670.05n

.meas tran vdout0_45ck660 FIND v(dout0_45) AT=670.05n

.meas tran vdout0_46ck660 FIND v(dout0_46) AT=670.05n

.meas tran vdout0_47ck660 FIND v(dout0_47) AT=670.05n

.meas tran vdout0_48ck660 FIND v(dout0_48) AT=670.05n

.meas tran vdout0_49ck660 FIND v(dout0_49) AT=670.05n

.meas tran vdout0_50ck660 FIND v(dout0_50) AT=670.05n

.meas tran vdout0_51ck660 FIND v(dout0_51) AT=670.05n

.meas tran vdout0_52ck660 FIND v(dout0_52) AT=670.05n

.meas tran vdout0_53ck660 FIND v(dout0_53) AT=670.05n

.meas tran vdout0_54ck660 FIND v(dout0_54) AT=670.05n

.meas tran vdout0_55ck660 FIND v(dout0_55) AT=670.05n

.meas tran vdout0_56ck660 FIND v(dout0_56) AT=670.05n

.meas tran vdout0_57ck660 FIND v(dout0_57) AT=670.05n

.meas tran vdout0_58ck660 FIND v(dout0_58) AT=670.05n

.meas tran vdout0_59ck660 FIND v(dout0_59) AT=670.05n

.meas tran vdout0_60ck660 FIND v(dout0_60) AT=670.05n

.meas tran vdout0_61ck660 FIND v(dout0_61) AT=670.05n

.meas tran vdout0_62ck660 FIND v(dout0_62) AT=670.05n

.meas tran vdout0_63ck660 FIND v(dout0_63) AT=670.05n

.meas tran vdout0_64ck660 FIND v(dout0_64) AT=670.05n

.meas tran vdout0_0ck670 FIND v(dout0_0) AT=680.05n

.meas tran vdout0_1ck670 FIND v(dout0_1) AT=680.05n

.meas tran vdout0_2ck670 FIND v(dout0_2) AT=680.05n

.meas tran vdout0_3ck670 FIND v(dout0_3) AT=680.05n

.meas tran vdout0_4ck670 FIND v(dout0_4) AT=680.05n

.meas tran vdout0_5ck670 FIND v(dout0_5) AT=680.05n

.meas tran vdout0_6ck670 FIND v(dout0_6) AT=680.05n

.meas tran vdout0_7ck670 FIND v(dout0_7) AT=680.05n

.meas tran vdout0_8ck670 FIND v(dout0_8) AT=680.05n

.meas tran vdout0_9ck670 FIND v(dout0_9) AT=680.05n

.meas tran vdout0_10ck670 FIND v(dout0_10) AT=680.05n

.meas tran vdout0_11ck670 FIND v(dout0_11) AT=680.05n

.meas tran vdout0_12ck670 FIND v(dout0_12) AT=680.05n

.meas tran vdout0_13ck670 FIND v(dout0_13) AT=680.05n

.meas tran vdout0_14ck670 FIND v(dout0_14) AT=680.05n

.meas tran vdout0_15ck670 FIND v(dout0_15) AT=680.05n

.meas tran vdout0_16ck670 FIND v(dout0_16) AT=680.05n

.meas tran vdout0_17ck670 FIND v(dout0_17) AT=680.05n

.meas tran vdout0_18ck670 FIND v(dout0_18) AT=680.05n

.meas tran vdout0_19ck670 FIND v(dout0_19) AT=680.05n

.meas tran vdout0_20ck670 FIND v(dout0_20) AT=680.05n

.meas tran vdout0_21ck670 FIND v(dout0_21) AT=680.05n

.meas tran vdout0_22ck670 FIND v(dout0_22) AT=680.05n

.meas tran vdout0_23ck670 FIND v(dout0_23) AT=680.05n

.meas tran vdout0_24ck670 FIND v(dout0_24) AT=680.05n

.meas tran vdout0_25ck670 FIND v(dout0_25) AT=680.05n

.meas tran vdout0_26ck670 FIND v(dout0_26) AT=680.05n

.meas tran vdout0_27ck670 FIND v(dout0_27) AT=680.05n

.meas tran vdout0_28ck670 FIND v(dout0_28) AT=680.05n

.meas tran vdout0_29ck670 FIND v(dout0_29) AT=680.05n

.meas tran vdout0_30ck670 FIND v(dout0_30) AT=680.05n

.meas tran vdout0_31ck670 FIND v(dout0_31) AT=680.05n

.meas tran vdout0_32ck670 FIND v(dout0_32) AT=680.05n

.meas tran vdout0_33ck670 FIND v(dout0_33) AT=680.05n

.meas tran vdout0_34ck670 FIND v(dout0_34) AT=680.05n

.meas tran vdout0_35ck670 FIND v(dout0_35) AT=680.05n

.meas tran vdout0_36ck670 FIND v(dout0_36) AT=680.05n

.meas tran vdout0_37ck670 FIND v(dout0_37) AT=680.05n

.meas tran vdout0_38ck670 FIND v(dout0_38) AT=680.05n

.meas tran vdout0_39ck670 FIND v(dout0_39) AT=680.05n

.meas tran vdout0_40ck670 FIND v(dout0_40) AT=680.05n

.meas tran vdout0_41ck670 FIND v(dout0_41) AT=680.05n

.meas tran vdout0_42ck670 FIND v(dout0_42) AT=680.05n

.meas tran vdout0_43ck670 FIND v(dout0_43) AT=680.05n

.meas tran vdout0_44ck670 FIND v(dout0_44) AT=680.05n

.meas tran vdout0_45ck670 FIND v(dout0_45) AT=680.05n

.meas tran vdout0_46ck670 FIND v(dout0_46) AT=680.05n

.meas tran vdout0_47ck670 FIND v(dout0_47) AT=680.05n

.meas tran vdout0_48ck670 FIND v(dout0_48) AT=680.05n

.meas tran vdout0_49ck670 FIND v(dout0_49) AT=680.05n

.meas tran vdout0_50ck670 FIND v(dout0_50) AT=680.05n

.meas tran vdout0_51ck670 FIND v(dout0_51) AT=680.05n

.meas tran vdout0_52ck670 FIND v(dout0_52) AT=680.05n

.meas tran vdout0_53ck670 FIND v(dout0_53) AT=680.05n

.meas tran vdout0_54ck670 FIND v(dout0_54) AT=680.05n

.meas tran vdout0_55ck670 FIND v(dout0_55) AT=680.05n

.meas tran vdout0_56ck670 FIND v(dout0_56) AT=680.05n

.meas tran vdout0_57ck670 FIND v(dout0_57) AT=680.05n

.meas tran vdout0_58ck670 FIND v(dout0_58) AT=680.05n

.meas tran vdout0_59ck670 FIND v(dout0_59) AT=680.05n

.meas tran vdout0_60ck670 FIND v(dout0_60) AT=680.05n

.meas tran vdout0_61ck670 FIND v(dout0_61) AT=680.05n

.meas tran vdout0_62ck670 FIND v(dout0_62) AT=680.05n

.meas tran vdout0_63ck670 FIND v(dout0_63) AT=680.05n

.meas tran vdout0_64ck670 FIND v(dout0_64) AT=680.05n

.meas tran vdout0_0ck680 FIND v(dout0_0) AT=690.05n

.meas tran vdout0_1ck680 FIND v(dout0_1) AT=690.05n

.meas tran vdout0_2ck680 FIND v(dout0_2) AT=690.05n

.meas tran vdout0_3ck680 FIND v(dout0_3) AT=690.05n

.meas tran vdout0_4ck680 FIND v(dout0_4) AT=690.05n

.meas tran vdout0_5ck680 FIND v(dout0_5) AT=690.05n

.meas tran vdout0_6ck680 FIND v(dout0_6) AT=690.05n

.meas tran vdout0_7ck680 FIND v(dout0_7) AT=690.05n

.meas tran vdout0_8ck680 FIND v(dout0_8) AT=690.05n

.meas tran vdout0_9ck680 FIND v(dout0_9) AT=690.05n

.meas tran vdout0_10ck680 FIND v(dout0_10) AT=690.05n

.meas tran vdout0_11ck680 FIND v(dout0_11) AT=690.05n

.meas tran vdout0_12ck680 FIND v(dout0_12) AT=690.05n

.meas tran vdout0_13ck680 FIND v(dout0_13) AT=690.05n

.meas tran vdout0_14ck680 FIND v(dout0_14) AT=690.05n

.meas tran vdout0_15ck680 FIND v(dout0_15) AT=690.05n

.meas tran vdout0_16ck680 FIND v(dout0_16) AT=690.05n

.meas tran vdout0_17ck680 FIND v(dout0_17) AT=690.05n

.meas tran vdout0_18ck680 FIND v(dout0_18) AT=690.05n

.meas tran vdout0_19ck680 FIND v(dout0_19) AT=690.05n

.meas tran vdout0_20ck680 FIND v(dout0_20) AT=690.05n

.meas tran vdout0_21ck680 FIND v(dout0_21) AT=690.05n

.meas tran vdout0_22ck680 FIND v(dout0_22) AT=690.05n

.meas tran vdout0_23ck680 FIND v(dout0_23) AT=690.05n

.meas tran vdout0_24ck680 FIND v(dout0_24) AT=690.05n

.meas tran vdout0_25ck680 FIND v(dout0_25) AT=690.05n

.meas tran vdout0_26ck680 FIND v(dout0_26) AT=690.05n

.meas tran vdout0_27ck680 FIND v(dout0_27) AT=690.05n

.meas tran vdout0_28ck680 FIND v(dout0_28) AT=690.05n

.meas tran vdout0_29ck680 FIND v(dout0_29) AT=690.05n

.meas tran vdout0_30ck680 FIND v(dout0_30) AT=690.05n

.meas tran vdout0_31ck680 FIND v(dout0_31) AT=690.05n

.meas tran vdout0_32ck680 FIND v(dout0_32) AT=690.05n

.meas tran vdout0_33ck680 FIND v(dout0_33) AT=690.05n

.meas tran vdout0_34ck680 FIND v(dout0_34) AT=690.05n

.meas tran vdout0_35ck680 FIND v(dout0_35) AT=690.05n

.meas tran vdout0_36ck680 FIND v(dout0_36) AT=690.05n

.meas tran vdout0_37ck680 FIND v(dout0_37) AT=690.05n

.meas tran vdout0_38ck680 FIND v(dout0_38) AT=690.05n

.meas tran vdout0_39ck680 FIND v(dout0_39) AT=690.05n

.meas tran vdout0_40ck680 FIND v(dout0_40) AT=690.05n

.meas tran vdout0_41ck680 FIND v(dout0_41) AT=690.05n

.meas tran vdout0_42ck680 FIND v(dout0_42) AT=690.05n

.meas tran vdout0_43ck680 FIND v(dout0_43) AT=690.05n

.meas tran vdout0_44ck680 FIND v(dout0_44) AT=690.05n

.meas tran vdout0_45ck680 FIND v(dout0_45) AT=690.05n

.meas tran vdout0_46ck680 FIND v(dout0_46) AT=690.05n

.meas tran vdout0_47ck680 FIND v(dout0_47) AT=690.05n

.meas tran vdout0_48ck680 FIND v(dout0_48) AT=690.05n

.meas tran vdout0_49ck680 FIND v(dout0_49) AT=690.05n

.meas tran vdout0_50ck680 FIND v(dout0_50) AT=690.05n

.meas tran vdout0_51ck680 FIND v(dout0_51) AT=690.05n

.meas tran vdout0_52ck680 FIND v(dout0_52) AT=690.05n

.meas tran vdout0_53ck680 FIND v(dout0_53) AT=690.05n

.meas tran vdout0_54ck680 FIND v(dout0_54) AT=690.05n

.meas tran vdout0_55ck680 FIND v(dout0_55) AT=690.05n

.meas tran vdout0_56ck680 FIND v(dout0_56) AT=690.05n

.meas tran vdout0_57ck680 FIND v(dout0_57) AT=690.05n

.meas tran vdout0_58ck680 FIND v(dout0_58) AT=690.05n

.meas tran vdout0_59ck680 FIND v(dout0_59) AT=690.05n

.meas tran vdout0_60ck680 FIND v(dout0_60) AT=690.05n

.meas tran vdout0_61ck680 FIND v(dout0_61) AT=690.05n

.meas tran vdout0_62ck680 FIND v(dout0_62) AT=690.05n

.meas tran vdout0_63ck680 FIND v(dout0_63) AT=690.05n

.meas tran vdout0_64ck680 FIND v(dout0_64) AT=690.05n

.meas tran vdout0_0ck700 FIND v(dout0_0) AT=710.05n

.meas tran vdout0_1ck700 FIND v(dout0_1) AT=710.05n

.meas tran vdout0_2ck700 FIND v(dout0_2) AT=710.05n

.meas tran vdout0_3ck700 FIND v(dout0_3) AT=710.05n

.meas tran vdout0_4ck700 FIND v(dout0_4) AT=710.05n

.meas tran vdout0_5ck700 FIND v(dout0_5) AT=710.05n

.meas tran vdout0_6ck700 FIND v(dout0_6) AT=710.05n

.meas tran vdout0_7ck700 FIND v(dout0_7) AT=710.05n

.meas tran vdout0_8ck700 FIND v(dout0_8) AT=710.05n

.meas tran vdout0_9ck700 FIND v(dout0_9) AT=710.05n

.meas tran vdout0_10ck700 FIND v(dout0_10) AT=710.05n

.meas tran vdout0_11ck700 FIND v(dout0_11) AT=710.05n

.meas tran vdout0_12ck700 FIND v(dout0_12) AT=710.05n

.meas tran vdout0_13ck700 FIND v(dout0_13) AT=710.05n

.meas tran vdout0_14ck700 FIND v(dout0_14) AT=710.05n

.meas tran vdout0_15ck700 FIND v(dout0_15) AT=710.05n

.meas tran vdout0_16ck700 FIND v(dout0_16) AT=710.05n

.meas tran vdout0_17ck700 FIND v(dout0_17) AT=710.05n

.meas tran vdout0_18ck700 FIND v(dout0_18) AT=710.05n

.meas tran vdout0_19ck700 FIND v(dout0_19) AT=710.05n

.meas tran vdout0_20ck700 FIND v(dout0_20) AT=710.05n

.meas tran vdout0_21ck700 FIND v(dout0_21) AT=710.05n

.meas tran vdout0_22ck700 FIND v(dout0_22) AT=710.05n

.meas tran vdout0_23ck700 FIND v(dout0_23) AT=710.05n

.meas tran vdout0_24ck700 FIND v(dout0_24) AT=710.05n

.meas tran vdout0_25ck700 FIND v(dout0_25) AT=710.05n

.meas tran vdout0_26ck700 FIND v(dout0_26) AT=710.05n

.meas tran vdout0_27ck700 FIND v(dout0_27) AT=710.05n

.meas tran vdout0_28ck700 FIND v(dout0_28) AT=710.05n

.meas tran vdout0_29ck700 FIND v(dout0_29) AT=710.05n

.meas tran vdout0_30ck700 FIND v(dout0_30) AT=710.05n

.meas tran vdout0_31ck700 FIND v(dout0_31) AT=710.05n

.meas tran vdout0_32ck700 FIND v(dout0_32) AT=710.05n

.meas tran vdout0_33ck700 FIND v(dout0_33) AT=710.05n

.meas tran vdout0_34ck700 FIND v(dout0_34) AT=710.05n

.meas tran vdout0_35ck700 FIND v(dout0_35) AT=710.05n

.meas tran vdout0_36ck700 FIND v(dout0_36) AT=710.05n

.meas tran vdout0_37ck700 FIND v(dout0_37) AT=710.05n

.meas tran vdout0_38ck700 FIND v(dout0_38) AT=710.05n

.meas tran vdout0_39ck700 FIND v(dout0_39) AT=710.05n

.meas tran vdout0_40ck700 FIND v(dout0_40) AT=710.05n

.meas tran vdout0_41ck700 FIND v(dout0_41) AT=710.05n

.meas tran vdout0_42ck700 FIND v(dout0_42) AT=710.05n

.meas tran vdout0_43ck700 FIND v(dout0_43) AT=710.05n

.meas tran vdout0_44ck700 FIND v(dout0_44) AT=710.05n

.meas tran vdout0_45ck700 FIND v(dout0_45) AT=710.05n

.meas tran vdout0_46ck700 FIND v(dout0_46) AT=710.05n

.meas tran vdout0_47ck700 FIND v(dout0_47) AT=710.05n

.meas tran vdout0_48ck700 FIND v(dout0_48) AT=710.05n

.meas tran vdout0_49ck700 FIND v(dout0_49) AT=710.05n

.meas tran vdout0_50ck700 FIND v(dout0_50) AT=710.05n

.meas tran vdout0_51ck700 FIND v(dout0_51) AT=710.05n

.meas tran vdout0_52ck700 FIND v(dout0_52) AT=710.05n

.meas tran vdout0_53ck700 FIND v(dout0_53) AT=710.05n

.meas tran vdout0_54ck700 FIND v(dout0_54) AT=710.05n

.meas tran vdout0_55ck700 FIND v(dout0_55) AT=710.05n

.meas tran vdout0_56ck700 FIND v(dout0_56) AT=710.05n

.meas tran vdout0_57ck700 FIND v(dout0_57) AT=710.05n

.meas tran vdout0_58ck700 FIND v(dout0_58) AT=710.05n

.meas tran vdout0_59ck700 FIND v(dout0_59) AT=710.05n

.meas tran vdout0_60ck700 FIND v(dout0_60) AT=710.05n

.meas tran vdout0_61ck700 FIND v(dout0_61) AT=710.05n

.meas tran vdout0_62ck700 FIND v(dout0_62) AT=710.05n

.meas tran vdout0_63ck700 FIND v(dout0_63) AT=710.05n

.meas tran vdout0_64ck700 FIND v(dout0_64) AT=710.05n

.meas tran vdout0_0ck770 FIND v(dout0_0) AT=780.05n

.meas tran vdout0_1ck770 FIND v(dout0_1) AT=780.05n

.meas tran vdout0_2ck770 FIND v(dout0_2) AT=780.05n

.meas tran vdout0_3ck770 FIND v(dout0_3) AT=780.05n

.meas tran vdout0_4ck770 FIND v(dout0_4) AT=780.05n

.meas tran vdout0_5ck770 FIND v(dout0_5) AT=780.05n

.meas tran vdout0_6ck770 FIND v(dout0_6) AT=780.05n

.meas tran vdout0_7ck770 FIND v(dout0_7) AT=780.05n

.meas tran vdout0_8ck770 FIND v(dout0_8) AT=780.05n

.meas tran vdout0_9ck770 FIND v(dout0_9) AT=780.05n

.meas tran vdout0_10ck770 FIND v(dout0_10) AT=780.05n

.meas tran vdout0_11ck770 FIND v(dout0_11) AT=780.05n

.meas tran vdout0_12ck770 FIND v(dout0_12) AT=780.05n

.meas tran vdout0_13ck770 FIND v(dout0_13) AT=780.05n

.meas tran vdout0_14ck770 FIND v(dout0_14) AT=780.05n

.meas tran vdout0_15ck770 FIND v(dout0_15) AT=780.05n

.meas tran vdout0_16ck770 FIND v(dout0_16) AT=780.05n

.meas tran vdout0_17ck770 FIND v(dout0_17) AT=780.05n

.meas tran vdout0_18ck770 FIND v(dout0_18) AT=780.05n

.meas tran vdout0_19ck770 FIND v(dout0_19) AT=780.05n

.meas tran vdout0_20ck770 FIND v(dout0_20) AT=780.05n

.meas tran vdout0_21ck770 FIND v(dout0_21) AT=780.05n

.meas tran vdout0_22ck770 FIND v(dout0_22) AT=780.05n

.meas tran vdout0_23ck770 FIND v(dout0_23) AT=780.05n

.meas tran vdout0_24ck770 FIND v(dout0_24) AT=780.05n

.meas tran vdout0_25ck770 FIND v(dout0_25) AT=780.05n

.meas tran vdout0_26ck770 FIND v(dout0_26) AT=780.05n

.meas tran vdout0_27ck770 FIND v(dout0_27) AT=780.05n

.meas tran vdout0_28ck770 FIND v(dout0_28) AT=780.05n

.meas tran vdout0_29ck770 FIND v(dout0_29) AT=780.05n

.meas tran vdout0_30ck770 FIND v(dout0_30) AT=780.05n

.meas tran vdout0_31ck770 FIND v(dout0_31) AT=780.05n

.meas tran vdout0_32ck770 FIND v(dout0_32) AT=780.05n

.meas tran vdout0_33ck770 FIND v(dout0_33) AT=780.05n

.meas tran vdout0_34ck770 FIND v(dout0_34) AT=780.05n

.meas tran vdout0_35ck770 FIND v(dout0_35) AT=780.05n

.meas tran vdout0_36ck770 FIND v(dout0_36) AT=780.05n

.meas tran vdout0_37ck770 FIND v(dout0_37) AT=780.05n

.meas tran vdout0_38ck770 FIND v(dout0_38) AT=780.05n

.meas tran vdout0_39ck770 FIND v(dout0_39) AT=780.05n

.meas tran vdout0_40ck770 FIND v(dout0_40) AT=780.05n

.meas tran vdout0_41ck770 FIND v(dout0_41) AT=780.05n

.meas tran vdout0_42ck770 FIND v(dout0_42) AT=780.05n

.meas tran vdout0_43ck770 FIND v(dout0_43) AT=780.05n

.meas tran vdout0_44ck770 FIND v(dout0_44) AT=780.05n

.meas tran vdout0_45ck770 FIND v(dout0_45) AT=780.05n

.meas tran vdout0_46ck770 FIND v(dout0_46) AT=780.05n

.meas tran vdout0_47ck770 FIND v(dout0_47) AT=780.05n

.meas tran vdout0_48ck770 FIND v(dout0_48) AT=780.05n

.meas tran vdout0_49ck770 FIND v(dout0_49) AT=780.05n

.meas tran vdout0_50ck770 FIND v(dout0_50) AT=780.05n

.meas tran vdout0_51ck770 FIND v(dout0_51) AT=780.05n

.meas tran vdout0_52ck770 FIND v(dout0_52) AT=780.05n

.meas tran vdout0_53ck770 FIND v(dout0_53) AT=780.05n

.meas tran vdout0_54ck770 FIND v(dout0_54) AT=780.05n

.meas tran vdout0_55ck770 FIND v(dout0_55) AT=780.05n

.meas tran vdout0_56ck770 FIND v(dout0_56) AT=780.05n

.meas tran vdout0_57ck770 FIND v(dout0_57) AT=780.05n

.meas tran vdout0_58ck770 FIND v(dout0_58) AT=780.05n

.meas tran vdout0_59ck770 FIND v(dout0_59) AT=780.05n

.meas tran vdout0_60ck770 FIND v(dout0_60) AT=780.05n

.meas tran vdout0_61ck770 FIND v(dout0_61) AT=780.05n

.meas tran vdout0_62ck770 FIND v(dout0_62) AT=780.05n

.meas tran vdout0_63ck770 FIND v(dout0_63) AT=780.05n

.meas tran vdout0_64ck770 FIND v(dout0_64) AT=780.05n

.meas tran vdout0_0ck780 FIND v(dout0_0) AT=790.05n

.meas tran vdout0_1ck780 FIND v(dout0_1) AT=790.05n

.meas tran vdout0_2ck780 FIND v(dout0_2) AT=790.05n

.meas tran vdout0_3ck780 FIND v(dout0_3) AT=790.05n

.meas tran vdout0_4ck780 FIND v(dout0_4) AT=790.05n

.meas tran vdout0_5ck780 FIND v(dout0_5) AT=790.05n

.meas tran vdout0_6ck780 FIND v(dout0_6) AT=790.05n

.meas tran vdout0_7ck780 FIND v(dout0_7) AT=790.05n

.meas tran vdout0_8ck780 FIND v(dout0_8) AT=790.05n

.meas tran vdout0_9ck780 FIND v(dout0_9) AT=790.05n

.meas tran vdout0_10ck780 FIND v(dout0_10) AT=790.05n

.meas tran vdout0_11ck780 FIND v(dout0_11) AT=790.05n

.meas tran vdout0_12ck780 FIND v(dout0_12) AT=790.05n

.meas tran vdout0_13ck780 FIND v(dout0_13) AT=790.05n

.meas tran vdout0_14ck780 FIND v(dout0_14) AT=790.05n

.meas tran vdout0_15ck780 FIND v(dout0_15) AT=790.05n

.meas tran vdout0_16ck780 FIND v(dout0_16) AT=790.05n

.meas tran vdout0_17ck780 FIND v(dout0_17) AT=790.05n

.meas tran vdout0_18ck780 FIND v(dout0_18) AT=790.05n

.meas tran vdout0_19ck780 FIND v(dout0_19) AT=790.05n

.meas tran vdout0_20ck780 FIND v(dout0_20) AT=790.05n

.meas tran vdout0_21ck780 FIND v(dout0_21) AT=790.05n

.meas tran vdout0_22ck780 FIND v(dout0_22) AT=790.05n

.meas tran vdout0_23ck780 FIND v(dout0_23) AT=790.05n

.meas tran vdout0_24ck780 FIND v(dout0_24) AT=790.05n

.meas tran vdout0_25ck780 FIND v(dout0_25) AT=790.05n

.meas tran vdout0_26ck780 FIND v(dout0_26) AT=790.05n

.meas tran vdout0_27ck780 FIND v(dout0_27) AT=790.05n

.meas tran vdout0_28ck780 FIND v(dout0_28) AT=790.05n

.meas tran vdout0_29ck780 FIND v(dout0_29) AT=790.05n

.meas tran vdout0_30ck780 FIND v(dout0_30) AT=790.05n

.meas tran vdout0_31ck780 FIND v(dout0_31) AT=790.05n

.meas tran vdout0_32ck780 FIND v(dout0_32) AT=790.05n

.meas tran vdout0_33ck780 FIND v(dout0_33) AT=790.05n

.meas tran vdout0_34ck780 FIND v(dout0_34) AT=790.05n

.meas tran vdout0_35ck780 FIND v(dout0_35) AT=790.05n

.meas tran vdout0_36ck780 FIND v(dout0_36) AT=790.05n

.meas tran vdout0_37ck780 FIND v(dout0_37) AT=790.05n

.meas tran vdout0_38ck780 FIND v(dout0_38) AT=790.05n

.meas tran vdout0_39ck780 FIND v(dout0_39) AT=790.05n

.meas tran vdout0_40ck780 FIND v(dout0_40) AT=790.05n

.meas tran vdout0_41ck780 FIND v(dout0_41) AT=790.05n

.meas tran vdout0_42ck780 FIND v(dout0_42) AT=790.05n

.meas tran vdout0_43ck780 FIND v(dout0_43) AT=790.05n

.meas tran vdout0_44ck780 FIND v(dout0_44) AT=790.05n

.meas tran vdout0_45ck780 FIND v(dout0_45) AT=790.05n

.meas tran vdout0_46ck780 FIND v(dout0_46) AT=790.05n

.meas tran vdout0_47ck780 FIND v(dout0_47) AT=790.05n

.meas tran vdout0_48ck780 FIND v(dout0_48) AT=790.05n

.meas tran vdout0_49ck780 FIND v(dout0_49) AT=790.05n

.meas tran vdout0_50ck780 FIND v(dout0_50) AT=790.05n

.meas tran vdout0_51ck780 FIND v(dout0_51) AT=790.05n

.meas tran vdout0_52ck780 FIND v(dout0_52) AT=790.05n

.meas tran vdout0_53ck780 FIND v(dout0_53) AT=790.05n

.meas tran vdout0_54ck780 FIND v(dout0_54) AT=790.05n

.meas tran vdout0_55ck780 FIND v(dout0_55) AT=790.05n

.meas tran vdout0_56ck780 FIND v(dout0_56) AT=790.05n

.meas tran vdout0_57ck780 FIND v(dout0_57) AT=790.05n

.meas tran vdout0_58ck780 FIND v(dout0_58) AT=790.05n

.meas tran vdout0_59ck780 FIND v(dout0_59) AT=790.05n

.meas tran vdout0_60ck780 FIND v(dout0_60) AT=790.05n

.meas tran vdout0_61ck780 FIND v(dout0_61) AT=790.05n

.meas tran vdout0_62ck780 FIND v(dout0_62) AT=790.05n

.meas tran vdout0_63ck780 FIND v(dout0_63) AT=790.05n

.meas tran vdout0_64ck780 FIND v(dout0_64) AT=790.05n

.meas tran vdout0_0ck790 FIND v(dout0_0) AT=800.05n

.meas tran vdout0_1ck790 FIND v(dout0_1) AT=800.05n

.meas tran vdout0_2ck790 FIND v(dout0_2) AT=800.05n

.meas tran vdout0_3ck790 FIND v(dout0_3) AT=800.05n

.meas tran vdout0_4ck790 FIND v(dout0_4) AT=800.05n

.meas tran vdout0_5ck790 FIND v(dout0_5) AT=800.05n

.meas tran vdout0_6ck790 FIND v(dout0_6) AT=800.05n

.meas tran vdout0_7ck790 FIND v(dout0_7) AT=800.05n

.meas tran vdout0_8ck790 FIND v(dout0_8) AT=800.05n

.meas tran vdout0_9ck790 FIND v(dout0_9) AT=800.05n

.meas tran vdout0_10ck790 FIND v(dout0_10) AT=800.05n

.meas tran vdout0_11ck790 FIND v(dout0_11) AT=800.05n

.meas tran vdout0_12ck790 FIND v(dout0_12) AT=800.05n

.meas tran vdout0_13ck790 FIND v(dout0_13) AT=800.05n

.meas tran vdout0_14ck790 FIND v(dout0_14) AT=800.05n

.meas tran vdout0_15ck790 FIND v(dout0_15) AT=800.05n

.meas tran vdout0_16ck790 FIND v(dout0_16) AT=800.05n

.meas tran vdout0_17ck790 FIND v(dout0_17) AT=800.05n

.meas tran vdout0_18ck790 FIND v(dout0_18) AT=800.05n

.meas tran vdout0_19ck790 FIND v(dout0_19) AT=800.05n

.meas tran vdout0_20ck790 FIND v(dout0_20) AT=800.05n

.meas tran vdout0_21ck790 FIND v(dout0_21) AT=800.05n

.meas tran vdout0_22ck790 FIND v(dout0_22) AT=800.05n

.meas tran vdout0_23ck790 FIND v(dout0_23) AT=800.05n

.meas tran vdout0_24ck790 FIND v(dout0_24) AT=800.05n

.meas tran vdout0_25ck790 FIND v(dout0_25) AT=800.05n

.meas tran vdout0_26ck790 FIND v(dout0_26) AT=800.05n

.meas tran vdout0_27ck790 FIND v(dout0_27) AT=800.05n

.meas tran vdout0_28ck790 FIND v(dout0_28) AT=800.05n

.meas tran vdout0_29ck790 FIND v(dout0_29) AT=800.05n

.meas tran vdout0_30ck790 FIND v(dout0_30) AT=800.05n

.meas tran vdout0_31ck790 FIND v(dout0_31) AT=800.05n

.meas tran vdout0_32ck790 FIND v(dout0_32) AT=800.05n

.meas tran vdout0_33ck790 FIND v(dout0_33) AT=800.05n

.meas tran vdout0_34ck790 FIND v(dout0_34) AT=800.05n

.meas tran vdout0_35ck790 FIND v(dout0_35) AT=800.05n

.meas tran vdout0_36ck790 FIND v(dout0_36) AT=800.05n

.meas tran vdout0_37ck790 FIND v(dout0_37) AT=800.05n

.meas tran vdout0_38ck790 FIND v(dout0_38) AT=800.05n

.meas tran vdout0_39ck790 FIND v(dout0_39) AT=800.05n

.meas tran vdout0_40ck790 FIND v(dout0_40) AT=800.05n

.meas tran vdout0_41ck790 FIND v(dout0_41) AT=800.05n

.meas tran vdout0_42ck790 FIND v(dout0_42) AT=800.05n

.meas tran vdout0_43ck790 FIND v(dout0_43) AT=800.05n

.meas tran vdout0_44ck790 FIND v(dout0_44) AT=800.05n

.meas tran vdout0_45ck790 FIND v(dout0_45) AT=800.05n

.meas tran vdout0_46ck790 FIND v(dout0_46) AT=800.05n

.meas tran vdout0_47ck790 FIND v(dout0_47) AT=800.05n

.meas tran vdout0_48ck790 FIND v(dout0_48) AT=800.05n

.meas tran vdout0_49ck790 FIND v(dout0_49) AT=800.05n

.meas tran vdout0_50ck790 FIND v(dout0_50) AT=800.05n

.meas tran vdout0_51ck790 FIND v(dout0_51) AT=800.05n

.meas tran vdout0_52ck790 FIND v(dout0_52) AT=800.05n

.meas tran vdout0_53ck790 FIND v(dout0_53) AT=800.05n

.meas tran vdout0_54ck790 FIND v(dout0_54) AT=800.05n

.meas tran vdout0_55ck790 FIND v(dout0_55) AT=800.05n

.meas tran vdout0_56ck790 FIND v(dout0_56) AT=800.05n

.meas tran vdout0_57ck790 FIND v(dout0_57) AT=800.05n

.meas tran vdout0_58ck790 FIND v(dout0_58) AT=800.05n

.meas tran vdout0_59ck790 FIND v(dout0_59) AT=800.05n

.meas tran vdout0_60ck790 FIND v(dout0_60) AT=800.05n

.meas tran vdout0_61ck790 FIND v(dout0_61) AT=800.05n

.meas tran vdout0_62ck790 FIND v(dout0_62) AT=800.05n

.meas tran vdout0_63ck790 FIND v(dout0_63) AT=800.05n

.meas tran vdout0_64ck790 FIND v(dout0_64) AT=800.05n

.meas tran vdout0_0ck800 FIND v(dout0_0) AT=810.05n

.meas tran vdout0_1ck800 FIND v(dout0_1) AT=810.05n

.meas tran vdout0_2ck800 FIND v(dout0_2) AT=810.05n

.meas tran vdout0_3ck800 FIND v(dout0_3) AT=810.05n

.meas tran vdout0_4ck800 FIND v(dout0_4) AT=810.05n

.meas tran vdout0_5ck800 FIND v(dout0_5) AT=810.05n

.meas tran vdout0_6ck800 FIND v(dout0_6) AT=810.05n

.meas tran vdout0_7ck800 FIND v(dout0_7) AT=810.05n

.meas tran vdout0_8ck800 FIND v(dout0_8) AT=810.05n

.meas tran vdout0_9ck800 FIND v(dout0_9) AT=810.05n

.meas tran vdout0_10ck800 FIND v(dout0_10) AT=810.05n

.meas tran vdout0_11ck800 FIND v(dout0_11) AT=810.05n

.meas tran vdout0_12ck800 FIND v(dout0_12) AT=810.05n

.meas tran vdout0_13ck800 FIND v(dout0_13) AT=810.05n

.meas tran vdout0_14ck800 FIND v(dout0_14) AT=810.05n

.meas tran vdout0_15ck800 FIND v(dout0_15) AT=810.05n

.meas tran vdout0_16ck800 FIND v(dout0_16) AT=810.05n

.meas tran vdout0_17ck800 FIND v(dout0_17) AT=810.05n

.meas tran vdout0_18ck800 FIND v(dout0_18) AT=810.05n

.meas tran vdout0_19ck800 FIND v(dout0_19) AT=810.05n

.meas tran vdout0_20ck800 FIND v(dout0_20) AT=810.05n

.meas tran vdout0_21ck800 FIND v(dout0_21) AT=810.05n

.meas tran vdout0_22ck800 FIND v(dout0_22) AT=810.05n

.meas tran vdout0_23ck800 FIND v(dout0_23) AT=810.05n

.meas tran vdout0_24ck800 FIND v(dout0_24) AT=810.05n

.meas tran vdout0_25ck800 FIND v(dout0_25) AT=810.05n

.meas tran vdout0_26ck800 FIND v(dout0_26) AT=810.05n

.meas tran vdout0_27ck800 FIND v(dout0_27) AT=810.05n

.meas tran vdout0_28ck800 FIND v(dout0_28) AT=810.05n

.meas tran vdout0_29ck800 FIND v(dout0_29) AT=810.05n

.meas tran vdout0_30ck800 FIND v(dout0_30) AT=810.05n

.meas tran vdout0_31ck800 FIND v(dout0_31) AT=810.05n

.meas tran vdout0_32ck800 FIND v(dout0_32) AT=810.05n

.meas tran vdout0_33ck800 FIND v(dout0_33) AT=810.05n

.meas tran vdout0_34ck800 FIND v(dout0_34) AT=810.05n

.meas tran vdout0_35ck800 FIND v(dout0_35) AT=810.05n

.meas tran vdout0_36ck800 FIND v(dout0_36) AT=810.05n

.meas tran vdout0_37ck800 FIND v(dout0_37) AT=810.05n

.meas tran vdout0_38ck800 FIND v(dout0_38) AT=810.05n

.meas tran vdout0_39ck800 FIND v(dout0_39) AT=810.05n

.meas tran vdout0_40ck800 FIND v(dout0_40) AT=810.05n

.meas tran vdout0_41ck800 FIND v(dout0_41) AT=810.05n

.meas tran vdout0_42ck800 FIND v(dout0_42) AT=810.05n

.meas tran vdout0_43ck800 FIND v(dout0_43) AT=810.05n

.meas tran vdout0_44ck800 FIND v(dout0_44) AT=810.05n

.meas tran vdout0_45ck800 FIND v(dout0_45) AT=810.05n

.meas tran vdout0_46ck800 FIND v(dout0_46) AT=810.05n

.meas tran vdout0_47ck800 FIND v(dout0_47) AT=810.05n

.meas tran vdout0_48ck800 FIND v(dout0_48) AT=810.05n

.meas tran vdout0_49ck800 FIND v(dout0_49) AT=810.05n

.meas tran vdout0_50ck800 FIND v(dout0_50) AT=810.05n

.meas tran vdout0_51ck800 FIND v(dout0_51) AT=810.05n

.meas tran vdout0_52ck800 FIND v(dout0_52) AT=810.05n

.meas tran vdout0_53ck800 FIND v(dout0_53) AT=810.05n

.meas tran vdout0_54ck800 FIND v(dout0_54) AT=810.05n

.meas tran vdout0_55ck800 FIND v(dout0_55) AT=810.05n

.meas tran vdout0_56ck800 FIND v(dout0_56) AT=810.05n

.meas tran vdout0_57ck800 FIND v(dout0_57) AT=810.05n

.meas tran vdout0_58ck800 FIND v(dout0_58) AT=810.05n

.meas tran vdout0_59ck800 FIND v(dout0_59) AT=810.05n

.meas tran vdout0_60ck800 FIND v(dout0_60) AT=810.05n

.meas tran vdout0_61ck800 FIND v(dout0_61) AT=810.05n

.meas tran vdout0_62ck800 FIND v(dout0_62) AT=810.05n

.meas tran vdout0_63ck800 FIND v(dout0_63) AT=810.05n

.meas tran vdout0_64ck800 FIND v(dout0_64) AT=810.05n

.meas tran vdout0_0ck830 FIND v(dout0_0) AT=840.05n

.meas tran vdout0_1ck830 FIND v(dout0_1) AT=840.05n

.meas tran vdout0_2ck830 FIND v(dout0_2) AT=840.05n

.meas tran vdout0_3ck830 FIND v(dout0_3) AT=840.05n

.meas tran vdout0_4ck830 FIND v(dout0_4) AT=840.05n

.meas tran vdout0_5ck830 FIND v(dout0_5) AT=840.05n

.meas tran vdout0_6ck830 FIND v(dout0_6) AT=840.05n

.meas tran vdout0_7ck830 FIND v(dout0_7) AT=840.05n

.meas tran vdout0_8ck830 FIND v(dout0_8) AT=840.05n

.meas tran vdout0_9ck830 FIND v(dout0_9) AT=840.05n

.meas tran vdout0_10ck830 FIND v(dout0_10) AT=840.05n

.meas tran vdout0_11ck830 FIND v(dout0_11) AT=840.05n

.meas tran vdout0_12ck830 FIND v(dout0_12) AT=840.05n

.meas tran vdout0_13ck830 FIND v(dout0_13) AT=840.05n

.meas tran vdout0_14ck830 FIND v(dout0_14) AT=840.05n

.meas tran vdout0_15ck830 FIND v(dout0_15) AT=840.05n

.meas tran vdout0_16ck830 FIND v(dout0_16) AT=840.05n

.meas tran vdout0_17ck830 FIND v(dout0_17) AT=840.05n

.meas tran vdout0_18ck830 FIND v(dout0_18) AT=840.05n

.meas tran vdout0_19ck830 FIND v(dout0_19) AT=840.05n

.meas tran vdout0_20ck830 FIND v(dout0_20) AT=840.05n

.meas tran vdout0_21ck830 FIND v(dout0_21) AT=840.05n

.meas tran vdout0_22ck830 FIND v(dout0_22) AT=840.05n

.meas tran vdout0_23ck830 FIND v(dout0_23) AT=840.05n

.meas tran vdout0_24ck830 FIND v(dout0_24) AT=840.05n

.meas tran vdout0_25ck830 FIND v(dout0_25) AT=840.05n

.meas tran vdout0_26ck830 FIND v(dout0_26) AT=840.05n

.meas tran vdout0_27ck830 FIND v(dout0_27) AT=840.05n

.meas tran vdout0_28ck830 FIND v(dout0_28) AT=840.05n

.meas tran vdout0_29ck830 FIND v(dout0_29) AT=840.05n

.meas tran vdout0_30ck830 FIND v(dout0_30) AT=840.05n

.meas tran vdout0_31ck830 FIND v(dout0_31) AT=840.05n

.meas tran vdout0_32ck830 FIND v(dout0_32) AT=840.05n

.meas tran vdout0_33ck830 FIND v(dout0_33) AT=840.05n

.meas tran vdout0_34ck830 FIND v(dout0_34) AT=840.05n

.meas tran vdout0_35ck830 FIND v(dout0_35) AT=840.05n

.meas tran vdout0_36ck830 FIND v(dout0_36) AT=840.05n

.meas tran vdout0_37ck830 FIND v(dout0_37) AT=840.05n

.meas tran vdout0_38ck830 FIND v(dout0_38) AT=840.05n

.meas tran vdout0_39ck830 FIND v(dout0_39) AT=840.05n

.meas tran vdout0_40ck830 FIND v(dout0_40) AT=840.05n

.meas tran vdout0_41ck830 FIND v(dout0_41) AT=840.05n

.meas tran vdout0_42ck830 FIND v(dout0_42) AT=840.05n

.meas tran vdout0_43ck830 FIND v(dout0_43) AT=840.05n

.meas tran vdout0_44ck830 FIND v(dout0_44) AT=840.05n

.meas tran vdout0_45ck830 FIND v(dout0_45) AT=840.05n

.meas tran vdout0_46ck830 FIND v(dout0_46) AT=840.05n

.meas tran vdout0_47ck830 FIND v(dout0_47) AT=840.05n

.meas tran vdout0_48ck830 FIND v(dout0_48) AT=840.05n

.meas tran vdout0_49ck830 FIND v(dout0_49) AT=840.05n

.meas tran vdout0_50ck830 FIND v(dout0_50) AT=840.05n

.meas tran vdout0_51ck830 FIND v(dout0_51) AT=840.05n

.meas tran vdout0_52ck830 FIND v(dout0_52) AT=840.05n

.meas tran vdout0_53ck830 FIND v(dout0_53) AT=840.05n

.meas tran vdout0_54ck830 FIND v(dout0_54) AT=840.05n

.meas tran vdout0_55ck830 FIND v(dout0_55) AT=840.05n

.meas tran vdout0_56ck830 FIND v(dout0_56) AT=840.05n

.meas tran vdout0_57ck830 FIND v(dout0_57) AT=840.05n

.meas tran vdout0_58ck830 FIND v(dout0_58) AT=840.05n

.meas tran vdout0_59ck830 FIND v(dout0_59) AT=840.05n

.meas tran vdout0_60ck830 FIND v(dout0_60) AT=840.05n

.meas tran vdout0_61ck830 FIND v(dout0_61) AT=840.05n

.meas tran vdout0_62ck830 FIND v(dout0_62) AT=840.05n

.meas tran vdout0_63ck830 FIND v(dout0_63) AT=840.05n

.meas tran vdout0_64ck830 FIND v(dout0_64) AT=840.05n

.meas tran vdout0_0ck850 FIND v(dout0_0) AT=860.05n

.meas tran vdout0_1ck850 FIND v(dout0_1) AT=860.05n

.meas tran vdout0_2ck850 FIND v(dout0_2) AT=860.05n

.meas tran vdout0_3ck850 FIND v(dout0_3) AT=860.05n

.meas tran vdout0_4ck850 FIND v(dout0_4) AT=860.05n

.meas tran vdout0_5ck850 FIND v(dout0_5) AT=860.05n

.meas tran vdout0_6ck850 FIND v(dout0_6) AT=860.05n

.meas tran vdout0_7ck850 FIND v(dout0_7) AT=860.05n

.meas tran vdout0_8ck850 FIND v(dout0_8) AT=860.05n

.meas tran vdout0_9ck850 FIND v(dout0_9) AT=860.05n

.meas tran vdout0_10ck850 FIND v(dout0_10) AT=860.05n

.meas tran vdout0_11ck850 FIND v(dout0_11) AT=860.05n

.meas tran vdout0_12ck850 FIND v(dout0_12) AT=860.05n

.meas tran vdout0_13ck850 FIND v(dout0_13) AT=860.05n

.meas tran vdout0_14ck850 FIND v(dout0_14) AT=860.05n

.meas tran vdout0_15ck850 FIND v(dout0_15) AT=860.05n

.meas tran vdout0_16ck850 FIND v(dout0_16) AT=860.05n

.meas tran vdout0_17ck850 FIND v(dout0_17) AT=860.05n

.meas tran vdout0_18ck850 FIND v(dout0_18) AT=860.05n

.meas tran vdout0_19ck850 FIND v(dout0_19) AT=860.05n

.meas tran vdout0_20ck850 FIND v(dout0_20) AT=860.05n

.meas tran vdout0_21ck850 FIND v(dout0_21) AT=860.05n

.meas tran vdout0_22ck850 FIND v(dout0_22) AT=860.05n

.meas tran vdout0_23ck850 FIND v(dout0_23) AT=860.05n

.meas tran vdout0_24ck850 FIND v(dout0_24) AT=860.05n

.meas tran vdout0_25ck850 FIND v(dout0_25) AT=860.05n

.meas tran vdout0_26ck850 FIND v(dout0_26) AT=860.05n

.meas tran vdout0_27ck850 FIND v(dout0_27) AT=860.05n

.meas tran vdout0_28ck850 FIND v(dout0_28) AT=860.05n

.meas tran vdout0_29ck850 FIND v(dout0_29) AT=860.05n

.meas tran vdout0_30ck850 FIND v(dout0_30) AT=860.05n

.meas tran vdout0_31ck850 FIND v(dout0_31) AT=860.05n

.meas tran vdout0_32ck850 FIND v(dout0_32) AT=860.05n

.meas tran vdout0_33ck850 FIND v(dout0_33) AT=860.05n

.meas tran vdout0_34ck850 FIND v(dout0_34) AT=860.05n

.meas tran vdout0_35ck850 FIND v(dout0_35) AT=860.05n

.meas tran vdout0_36ck850 FIND v(dout0_36) AT=860.05n

.meas tran vdout0_37ck850 FIND v(dout0_37) AT=860.05n

.meas tran vdout0_38ck850 FIND v(dout0_38) AT=860.05n

.meas tran vdout0_39ck850 FIND v(dout0_39) AT=860.05n

.meas tran vdout0_40ck850 FIND v(dout0_40) AT=860.05n

.meas tran vdout0_41ck850 FIND v(dout0_41) AT=860.05n

.meas tran vdout0_42ck850 FIND v(dout0_42) AT=860.05n

.meas tran vdout0_43ck850 FIND v(dout0_43) AT=860.05n

.meas tran vdout0_44ck850 FIND v(dout0_44) AT=860.05n

.meas tran vdout0_45ck850 FIND v(dout0_45) AT=860.05n

.meas tran vdout0_46ck850 FIND v(dout0_46) AT=860.05n

.meas tran vdout0_47ck850 FIND v(dout0_47) AT=860.05n

.meas tran vdout0_48ck850 FIND v(dout0_48) AT=860.05n

.meas tran vdout0_49ck850 FIND v(dout0_49) AT=860.05n

.meas tran vdout0_50ck850 FIND v(dout0_50) AT=860.05n

.meas tran vdout0_51ck850 FIND v(dout0_51) AT=860.05n

.meas tran vdout0_52ck850 FIND v(dout0_52) AT=860.05n

.meas tran vdout0_53ck850 FIND v(dout0_53) AT=860.05n

.meas tran vdout0_54ck850 FIND v(dout0_54) AT=860.05n

.meas tran vdout0_55ck850 FIND v(dout0_55) AT=860.05n

.meas tran vdout0_56ck850 FIND v(dout0_56) AT=860.05n

.meas tran vdout0_57ck850 FIND v(dout0_57) AT=860.05n

.meas tran vdout0_58ck850 FIND v(dout0_58) AT=860.05n

.meas tran vdout0_59ck850 FIND v(dout0_59) AT=860.05n

.meas tran vdout0_60ck850 FIND v(dout0_60) AT=860.05n

.meas tran vdout0_61ck850 FIND v(dout0_61) AT=860.05n

.meas tran vdout0_62ck850 FIND v(dout0_62) AT=860.05n

.meas tran vdout0_63ck850 FIND v(dout0_63) AT=860.05n

.meas tran vdout0_64ck850 FIND v(dout0_64) AT=860.05n

.meas tran vdout0_0ck860 FIND v(dout0_0) AT=870.05n

.meas tran vdout0_1ck860 FIND v(dout0_1) AT=870.05n

.meas tran vdout0_2ck860 FIND v(dout0_2) AT=870.05n

.meas tran vdout0_3ck860 FIND v(dout0_3) AT=870.05n

.meas tran vdout0_4ck860 FIND v(dout0_4) AT=870.05n

.meas tran vdout0_5ck860 FIND v(dout0_5) AT=870.05n

.meas tran vdout0_6ck860 FIND v(dout0_6) AT=870.05n

.meas tran vdout0_7ck860 FIND v(dout0_7) AT=870.05n

.meas tran vdout0_8ck860 FIND v(dout0_8) AT=870.05n

.meas tran vdout0_9ck860 FIND v(dout0_9) AT=870.05n

.meas tran vdout0_10ck860 FIND v(dout0_10) AT=870.05n

.meas tran vdout0_11ck860 FIND v(dout0_11) AT=870.05n

.meas tran vdout0_12ck860 FIND v(dout0_12) AT=870.05n

.meas tran vdout0_13ck860 FIND v(dout0_13) AT=870.05n

.meas tran vdout0_14ck860 FIND v(dout0_14) AT=870.05n

.meas tran vdout0_15ck860 FIND v(dout0_15) AT=870.05n

.meas tran vdout0_16ck860 FIND v(dout0_16) AT=870.05n

.meas tran vdout0_17ck860 FIND v(dout0_17) AT=870.05n

.meas tran vdout0_18ck860 FIND v(dout0_18) AT=870.05n

.meas tran vdout0_19ck860 FIND v(dout0_19) AT=870.05n

.meas tran vdout0_20ck860 FIND v(dout0_20) AT=870.05n

.meas tran vdout0_21ck860 FIND v(dout0_21) AT=870.05n

.meas tran vdout0_22ck860 FIND v(dout0_22) AT=870.05n

.meas tran vdout0_23ck860 FIND v(dout0_23) AT=870.05n

.meas tran vdout0_24ck860 FIND v(dout0_24) AT=870.05n

.meas tran vdout0_25ck860 FIND v(dout0_25) AT=870.05n

.meas tran vdout0_26ck860 FIND v(dout0_26) AT=870.05n

.meas tran vdout0_27ck860 FIND v(dout0_27) AT=870.05n

.meas tran vdout0_28ck860 FIND v(dout0_28) AT=870.05n

.meas tran vdout0_29ck860 FIND v(dout0_29) AT=870.05n

.meas tran vdout0_30ck860 FIND v(dout0_30) AT=870.05n

.meas tran vdout0_31ck860 FIND v(dout0_31) AT=870.05n

.meas tran vdout0_32ck860 FIND v(dout0_32) AT=870.05n

.meas tran vdout0_33ck860 FIND v(dout0_33) AT=870.05n

.meas tran vdout0_34ck860 FIND v(dout0_34) AT=870.05n

.meas tran vdout0_35ck860 FIND v(dout0_35) AT=870.05n

.meas tran vdout0_36ck860 FIND v(dout0_36) AT=870.05n

.meas tran vdout0_37ck860 FIND v(dout0_37) AT=870.05n

.meas tran vdout0_38ck860 FIND v(dout0_38) AT=870.05n

.meas tran vdout0_39ck860 FIND v(dout0_39) AT=870.05n

.meas tran vdout0_40ck860 FIND v(dout0_40) AT=870.05n

.meas tran vdout0_41ck860 FIND v(dout0_41) AT=870.05n

.meas tran vdout0_42ck860 FIND v(dout0_42) AT=870.05n

.meas tran vdout0_43ck860 FIND v(dout0_43) AT=870.05n

.meas tran vdout0_44ck860 FIND v(dout0_44) AT=870.05n

.meas tran vdout0_45ck860 FIND v(dout0_45) AT=870.05n

.meas tran vdout0_46ck860 FIND v(dout0_46) AT=870.05n

.meas tran vdout0_47ck860 FIND v(dout0_47) AT=870.05n

.meas tran vdout0_48ck860 FIND v(dout0_48) AT=870.05n

.meas tran vdout0_49ck860 FIND v(dout0_49) AT=870.05n

.meas tran vdout0_50ck860 FIND v(dout0_50) AT=870.05n

.meas tran vdout0_51ck860 FIND v(dout0_51) AT=870.05n

.meas tran vdout0_52ck860 FIND v(dout0_52) AT=870.05n

.meas tran vdout0_53ck860 FIND v(dout0_53) AT=870.05n

.meas tran vdout0_54ck860 FIND v(dout0_54) AT=870.05n

.meas tran vdout0_55ck860 FIND v(dout0_55) AT=870.05n

.meas tran vdout0_56ck860 FIND v(dout0_56) AT=870.05n

.meas tran vdout0_57ck860 FIND v(dout0_57) AT=870.05n

.meas tran vdout0_58ck860 FIND v(dout0_58) AT=870.05n

.meas tran vdout0_59ck860 FIND v(dout0_59) AT=870.05n

.meas tran vdout0_60ck860 FIND v(dout0_60) AT=870.05n

.meas tran vdout0_61ck860 FIND v(dout0_61) AT=870.05n

.meas tran vdout0_62ck860 FIND v(dout0_62) AT=870.05n

.meas tran vdout0_63ck860 FIND v(dout0_63) AT=870.05n

.meas tran vdout0_64ck860 FIND v(dout0_64) AT=870.05n

.meas tran vdout0_0ck880 FIND v(dout0_0) AT=890.05n

.meas tran vdout0_1ck880 FIND v(dout0_1) AT=890.05n

.meas tran vdout0_2ck880 FIND v(dout0_2) AT=890.05n

.meas tran vdout0_3ck880 FIND v(dout0_3) AT=890.05n

.meas tran vdout0_4ck880 FIND v(dout0_4) AT=890.05n

.meas tran vdout0_5ck880 FIND v(dout0_5) AT=890.05n

.meas tran vdout0_6ck880 FIND v(dout0_6) AT=890.05n

.meas tran vdout0_7ck880 FIND v(dout0_7) AT=890.05n

.meas tran vdout0_8ck880 FIND v(dout0_8) AT=890.05n

.meas tran vdout0_9ck880 FIND v(dout0_9) AT=890.05n

.meas tran vdout0_10ck880 FIND v(dout0_10) AT=890.05n

.meas tran vdout0_11ck880 FIND v(dout0_11) AT=890.05n

.meas tran vdout0_12ck880 FIND v(dout0_12) AT=890.05n

.meas tran vdout0_13ck880 FIND v(dout0_13) AT=890.05n

.meas tran vdout0_14ck880 FIND v(dout0_14) AT=890.05n

.meas tran vdout0_15ck880 FIND v(dout0_15) AT=890.05n

.meas tran vdout0_16ck880 FIND v(dout0_16) AT=890.05n

.meas tran vdout0_17ck880 FIND v(dout0_17) AT=890.05n

.meas tran vdout0_18ck880 FIND v(dout0_18) AT=890.05n

.meas tran vdout0_19ck880 FIND v(dout0_19) AT=890.05n

.meas tran vdout0_20ck880 FIND v(dout0_20) AT=890.05n

.meas tran vdout0_21ck880 FIND v(dout0_21) AT=890.05n

.meas tran vdout0_22ck880 FIND v(dout0_22) AT=890.05n

.meas tran vdout0_23ck880 FIND v(dout0_23) AT=890.05n

.meas tran vdout0_24ck880 FIND v(dout0_24) AT=890.05n

.meas tran vdout0_25ck880 FIND v(dout0_25) AT=890.05n

.meas tran vdout0_26ck880 FIND v(dout0_26) AT=890.05n

.meas tran vdout0_27ck880 FIND v(dout0_27) AT=890.05n

.meas tran vdout0_28ck880 FIND v(dout0_28) AT=890.05n

.meas tran vdout0_29ck880 FIND v(dout0_29) AT=890.05n

.meas tran vdout0_30ck880 FIND v(dout0_30) AT=890.05n

.meas tran vdout0_31ck880 FIND v(dout0_31) AT=890.05n

.meas tran vdout0_32ck880 FIND v(dout0_32) AT=890.05n

.meas tran vdout0_33ck880 FIND v(dout0_33) AT=890.05n

.meas tran vdout0_34ck880 FIND v(dout0_34) AT=890.05n

.meas tran vdout0_35ck880 FIND v(dout0_35) AT=890.05n

.meas tran vdout0_36ck880 FIND v(dout0_36) AT=890.05n

.meas tran vdout0_37ck880 FIND v(dout0_37) AT=890.05n

.meas tran vdout0_38ck880 FIND v(dout0_38) AT=890.05n

.meas tran vdout0_39ck880 FIND v(dout0_39) AT=890.05n

.meas tran vdout0_40ck880 FIND v(dout0_40) AT=890.05n

.meas tran vdout0_41ck880 FIND v(dout0_41) AT=890.05n

.meas tran vdout0_42ck880 FIND v(dout0_42) AT=890.05n

.meas tran vdout0_43ck880 FIND v(dout0_43) AT=890.05n

.meas tran vdout0_44ck880 FIND v(dout0_44) AT=890.05n

.meas tran vdout0_45ck880 FIND v(dout0_45) AT=890.05n

.meas tran vdout0_46ck880 FIND v(dout0_46) AT=890.05n

.meas tran vdout0_47ck880 FIND v(dout0_47) AT=890.05n

.meas tran vdout0_48ck880 FIND v(dout0_48) AT=890.05n

.meas tran vdout0_49ck880 FIND v(dout0_49) AT=890.05n

.meas tran vdout0_50ck880 FIND v(dout0_50) AT=890.05n

.meas tran vdout0_51ck880 FIND v(dout0_51) AT=890.05n

.meas tran vdout0_52ck880 FIND v(dout0_52) AT=890.05n

.meas tran vdout0_53ck880 FIND v(dout0_53) AT=890.05n

.meas tran vdout0_54ck880 FIND v(dout0_54) AT=890.05n

.meas tran vdout0_55ck880 FIND v(dout0_55) AT=890.05n

.meas tran vdout0_56ck880 FIND v(dout0_56) AT=890.05n

.meas tran vdout0_57ck880 FIND v(dout0_57) AT=890.05n

.meas tran vdout0_58ck880 FIND v(dout0_58) AT=890.05n

.meas tran vdout0_59ck880 FIND v(dout0_59) AT=890.05n

.meas tran vdout0_60ck880 FIND v(dout0_60) AT=890.05n

.meas tran vdout0_61ck880 FIND v(dout0_61) AT=890.05n

.meas tran vdout0_62ck880 FIND v(dout0_62) AT=890.05n

.meas tran vdout0_63ck880 FIND v(dout0_63) AT=890.05n

.meas tran vdout0_64ck880 FIND v(dout0_64) AT=890.05n

.meas tran vdout0_0ck910 FIND v(dout0_0) AT=920.05n

.meas tran vdout0_1ck910 FIND v(dout0_1) AT=920.05n

.meas tran vdout0_2ck910 FIND v(dout0_2) AT=920.05n

.meas tran vdout0_3ck910 FIND v(dout0_3) AT=920.05n

.meas tran vdout0_4ck910 FIND v(dout0_4) AT=920.05n

.meas tran vdout0_5ck910 FIND v(dout0_5) AT=920.05n

.meas tran vdout0_6ck910 FIND v(dout0_6) AT=920.05n

.meas tran vdout0_7ck910 FIND v(dout0_7) AT=920.05n

.meas tran vdout0_8ck910 FIND v(dout0_8) AT=920.05n

.meas tran vdout0_9ck910 FIND v(dout0_9) AT=920.05n

.meas tran vdout0_10ck910 FIND v(dout0_10) AT=920.05n

.meas tran vdout0_11ck910 FIND v(dout0_11) AT=920.05n

.meas tran vdout0_12ck910 FIND v(dout0_12) AT=920.05n

.meas tran vdout0_13ck910 FIND v(dout0_13) AT=920.05n

.meas tran vdout0_14ck910 FIND v(dout0_14) AT=920.05n

.meas tran vdout0_15ck910 FIND v(dout0_15) AT=920.05n

.meas tran vdout0_16ck910 FIND v(dout0_16) AT=920.05n

.meas tran vdout0_17ck910 FIND v(dout0_17) AT=920.05n

.meas tran vdout0_18ck910 FIND v(dout0_18) AT=920.05n

.meas tran vdout0_19ck910 FIND v(dout0_19) AT=920.05n

.meas tran vdout0_20ck910 FIND v(dout0_20) AT=920.05n

.meas tran vdout0_21ck910 FIND v(dout0_21) AT=920.05n

.meas tran vdout0_22ck910 FIND v(dout0_22) AT=920.05n

.meas tran vdout0_23ck910 FIND v(dout0_23) AT=920.05n

.meas tran vdout0_24ck910 FIND v(dout0_24) AT=920.05n

.meas tran vdout0_25ck910 FIND v(dout0_25) AT=920.05n

.meas tran vdout0_26ck910 FIND v(dout0_26) AT=920.05n

.meas tran vdout0_27ck910 FIND v(dout0_27) AT=920.05n

.meas tran vdout0_28ck910 FIND v(dout0_28) AT=920.05n

.meas tran vdout0_29ck910 FIND v(dout0_29) AT=920.05n

.meas tran vdout0_30ck910 FIND v(dout0_30) AT=920.05n

.meas tran vdout0_31ck910 FIND v(dout0_31) AT=920.05n

.meas tran vdout0_32ck910 FIND v(dout0_32) AT=920.05n

.meas tran vdout0_33ck910 FIND v(dout0_33) AT=920.05n

.meas tran vdout0_34ck910 FIND v(dout0_34) AT=920.05n

.meas tran vdout0_35ck910 FIND v(dout0_35) AT=920.05n

.meas tran vdout0_36ck910 FIND v(dout0_36) AT=920.05n

.meas tran vdout0_37ck910 FIND v(dout0_37) AT=920.05n

.meas tran vdout0_38ck910 FIND v(dout0_38) AT=920.05n

.meas tran vdout0_39ck910 FIND v(dout0_39) AT=920.05n

.meas tran vdout0_40ck910 FIND v(dout0_40) AT=920.05n

.meas tran vdout0_41ck910 FIND v(dout0_41) AT=920.05n

.meas tran vdout0_42ck910 FIND v(dout0_42) AT=920.05n

.meas tran vdout0_43ck910 FIND v(dout0_43) AT=920.05n

.meas tran vdout0_44ck910 FIND v(dout0_44) AT=920.05n

.meas tran vdout0_45ck910 FIND v(dout0_45) AT=920.05n

.meas tran vdout0_46ck910 FIND v(dout0_46) AT=920.05n

.meas tran vdout0_47ck910 FIND v(dout0_47) AT=920.05n

.meas tran vdout0_48ck910 FIND v(dout0_48) AT=920.05n

.meas tran vdout0_49ck910 FIND v(dout0_49) AT=920.05n

.meas tran vdout0_50ck910 FIND v(dout0_50) AT=920.05n

.meas tran vdout0_51ck910 FIND v(dout0_51) AT=920.05n

.meas tran vdout0_52ck910 FIND v(dout0_52) AT=920.05n

.meas tran vdout0_53ck910 FIND v(dout0_53) AT=920.05n

.meas tran vdout0_54ck910 FIND v(dout0_54) AT=920.05n

.meas tran vdout0_55ck910 FIND v(dout0_55) AT=920.05n

.meas tran vdout0_56ck910 FIND v(dout0_56) AT=920.05n

.meas tran vdout0_57ck910 FIND v(dout0_57) AT=920.05n

.meas tran vdout0_58ck910 FIND v(dout0_58) AT=920.05n

.meas tran vdout0_59ck910 FIND v(dout0_59) AT=920.05n

.meas tran vdout0_60ck910 FIND v(dout0_60) AT=920.05n

.meas tran vdout0_61ck910 FIND v(dout0_61) AT=920.05n

.meas tran vdout0_62ck910 FIND v(dout0_62) AT=920.05n

.meas tran vdout0_63ck910 FIND v(dout0_63) AT=920.05n

.meas tran vdout0_64ck910 FIND v(dout0_64) AT=920.05n

.meas tran vdout0_0ck950 FIND v(dout0_0) AT=960.05n

.meas tran vdout0_1ck950 FIND v(dout0_1) AT=960.05n

.meas tran vdout0_2ck950 FIND v(dout0_2) AT=960.05n

.meas tran vdout0_3ck950 FIND v(dout0_3) AT=960.05n

.meas tran vdout0_4ck950 FIND v(dout0_4) AT=960.05n

.meas tran vdout0_5ck950 FIND v(dout0_5) AT=960.05n

.meas tran vdout0_6ck950 FIND v(dout0_6) AT=960.05n

.meas tran vdout0_7ck950 FIND v(dout0_7) AT=960.05n

.meas tran vdout0_8ck950 FIND v(dout0_8) AT=960.05n

.meas tran vdout0_9ck950 FIND v(dout0_9) AT=960.05n

.meas tran vdout0_10ck950 FIND v(dout0_10) AT=960.05n

.meas tran vdout0_11ck950 FIND v(dout0_11) AT=960.05n

.meas tran vdout0_12ck950 FIND v(dout0_12) AT=960.05n

.meas tran vdout0_13ck950 FIND v(dout0_13) AT=960.05n

.meas tran vdout0_14ck950 FIND v(dout0_14) AT=960.05n

.meas tran vdout0_15ck950 FIND v(dout0_15) AT=960.05n

.meas tran vdout0_16ck950 FIND v(dout0_16) AT=960.05n

.meas tran vdout0_17ck950 FIND v(dout0_17) AT=960.05n

.meas tran vdout0_18ck950 FIND v(dout0_18) AT=960.05n

.meas tran vdout0_19ck950 FIND v(dout0_19) AT=960.05n

.meas tran vdout0_20ck950 FIND v(dout0_20) AT=960.05n

.meas tran vdout0_21ck950 FIND v(dout0_21) AT=960.05n

.meas tran vdout0_22ck950 FIND v(dout0_22) AT=960.05n

.meas tran vdout0_23ck950 FIND v(dout0_23) AT=960.05n

.meas tran vdout0_24ck950 FIND v(dout0_24) AT=960.05n

.meas tran vdout0_25ck950 FIND v(dout0_25) AT=960.05n

.meas tran vdout0_26ck950 FIND v(dout0_26) AT=960.05n

.meas tran vdout0_27ck950 FIND v(dout0_27) AT=960.05n

.meas tran vdout0_28ck950 FIND v(dout0_28) AT=960.05n

.meas tran vdout0_29ck950 FIND v(dout0_29) AT=960.05n

.meas tran vdout0_30ck950 FIND v(dout0_30) AT=960.05n

.meas tran vdout0_31ck950 FIND v(dout0_31) AT=960.05n

.meas tran vdout0_32ck950 FIND v(dout0_32) AT=960.05n

.meas tran vdout0_33ck950 FIND v(dout0_33) AT=960.05n

.meas tran vdout0_34ck950 FIND v(dout0_34) AT=960.05n

.meas tran vdout0_35ck950 FIND v(dout0_35) AT=960.05n

.meas tran vdout0_36ck950 FIND v(dout0_36) AT=960.05n

.meas tran vdout0_37ck950 FIND v(dout0_37) AT=960.05n

.meas tran vdout0_38ck950 FIND v(dout0_38) AT=960.05n

.meas tran vdout0_39ck950 FIND v(dout0_39) AT=960.05n

.meas tran vdout0_40ck950 FIND v(dout0_40) AT=960.05n

.meas tran vdout0_41ck950 FIND v(dout0_41) AT=960.05n

.meas tran vdout0_42ck950 FIND v(dout0_42) AT=960.05n

.meas tran vdout0_43ck950 FIND v(dout0_43) AT=960.05n

.meas tran vdout0_44ck950 FIND v(dout0_44) AT=960.05n

.meas tran vdout0_45ck950 FIND v(dout0_45) AT=960.05n

.meas tran vdout0_46ck950 FIND v(dout0_46) AT=960.05n

.meas tran vdout0_47ck950 FIND v(dout0_47) AT=960.05n

.meas tran vdout0_48ck950 FIND v(dout0_48) AT=960.05n

.meas tran vdout0_49ck950 FIND v(dout0_49) AT=960.05n

.meas tran vdout0_50ck950 FIND v(dout0_50) AT=960.05n

.meas tran vdout0_51ck950 FIND v(dout0_51) AT=960.05n

.meas tran vdout0_52ck950 FIND v(dout0_52) AT=960.05n

.meas tran vdout0_53ck950 FIND v(dout0_53) AT=960.05n

.meas tran vdout0_54ck950 FIND v(dout0_54) AT=960.05n

.meas tran vdout0_55ck950 FIND v(dout0_55) AT=960.05n

.meas tran vdout0_56ck950 FIND v(dout0_56) AT=960.05n

.meas tran vdout0_57ck950 FIND v(dout0_57) AT=960.05n

.meas tran vdout0_58ck950 FIND v(dout0_58) AT=960.05n

.meas tran vdout0_59ck950 FIND v(dout0_59) AT=960.05n

.meas tran vdout0_60ck950 FIND v(dout0_60) AT=960.05n

.meas tran vdout0_61ck950 FIND v(dout0_61) AT=960.05n

.meas tran vdout0_62ck950 FIND v(dout0_62) AT=960.05n

.meas tran vdout0_63ck950 FIND v(dout0_63) AT=960.05n

.meas tran vdout0_64ck950 FIND v(dout0_64) AT=960.05n

.meas tran vdout0_0ck970 FIND v(dout0_0) AT=980.05n

.meas tran vdout0_1ck970 FIND v(dout0_1) AT=980.05n

.meas tran vdout0_2ck970 FIND v(dout0_2) AT=980.05n

.meas tran vdout0_3ck970 FIND v(dout0_3) AT=980.05n

.meas tran vdout0_4ck970 FIND v(dout0_4) AT=980.05n

.meas tran vdout0_5ck970 FIND v(dout0_5) AT=980.05n

.meas tran vdout0_6ck970 FIND v(dout0_6) AT=980.05n

.meas tran vdout0_7ck970 FIND v(dout0_7) AT=980.05n

.meas tran vdout0_8ck970 FIND v(dout0_8) AT=980.05n

.meas tran vdout0_9ck970 FIND v(dout0_9) AT=980.05n

.meas tran vdout0_10ck970 FIND v(dout0_10) AT=980.05n

.meas tran vdout0_11ck970 FIND v(dout0_11) AT=980.05n

.meas tran vdout0_12ck970 FIND v(dout0_12) AT=980.05n

.meas tran vdout0_13ck970 FIND v(dout0_13) AT=980.05n

.meas tran vdout0_14ck970 FIND v(dout0_14) AT=980.05n

.meas tran vdout0_15ck970 FIND v(dout0_15) AT=980.05n

.meas tran vdout0_16ck970 FIND v(dout0_16) AT=980.05n

.meas tran vdout0_17ck970 FIND v(dout0_17) AT=980.05n

.meas tran vdout0_18ck970 FIND v(dout0_18) AT=980.05n

.meas tran vdout0_19ck970 FIND v(dout0_19) AT=980.05n

.meas tran vdout0_20ck970 FIND v(dout0_20) AT=980.05n

.meas tran vdout0_21ck970 FIND v(dout0_21) AT=980.05n

.meas tran vdout0_22ck970 FIND v(dout0_22) AT=980.05n

.meas tran vdout0_23ck970 FIND v(dout0_23) AT=980.05n

.meas tran vdout0_24ck970 FIND v(dout0_24) AT=980.05n

.meas tran vdout0_25ck970 FIND v(dout0_25) AT=980.05n

.meas tran vdout0_26ck970 FIND v(dout0_26) AT=980.05n

.meas tran vdout0_27ck970 FIND v(dout0_27) AT=980.05n

.meas tran vdout0_28ck970 FIND v(dout0_28) AT=980.05n

.meas tran vdout0_29ck970 FIND v(dout0_29) AT=980.05n

.meas tran vdout0_30ck970 FIND v(dout0_30) AT=980.05n

.meas tran vdout0_31ck970 FIND v(dout0_31) AT=980.05n

.meas tran vdout0_32ck970 FIND v(dout0_32) AT=980.05n

.meas tran vdout0_33ck970 FIND v(dout0_33) AT=980.05n

.meas tran vdout0_34ck970 FIND v(dout0_34) AT=980.05n

.meas tran vdout0_35ck970 FIND v(dout0_35) AT=980.05n

.meas tran vdout0_36ck970 FIND v(dout0_36) AT=980.05n

.meas tran vdout0_37ck970 FIND v(dout0_37) AT=980.05n

.meas tran vdout0_38ck970 FIND v(dout0_38) AT=980.05n

.meas tran vdout0_39ck970 FIND v(dout0_39) AT=980.05n

.meas tran vdout0_40ck970 FIND v(dout0_40) AT=980.05n

.meas tran vdout0_41ck970 FIND v(dout0_41) AT=980.05n

.meas tran vdout0_42ck970 FIND v(dout0_42) AT=980.05n

.meas tran vdout0_43ck970 FIND v(dout0_43) AT=980.05n

.meas tran vdout0_44ck970 FIND v(dout0_44) AT=980.05n

.meas tran vdout0_45ck970 FIND v(dout0_45) AT=980.05n

.meas tran vdout0_46ck970 FIND v(dout0_46) AT=980.05n

.meas tran vdout0_47ck970 FIND v(dout0_47) AT=980.05n

.meas tran vdout0_48ck970 FIND v(dout0_48) AT=980.05n

.meas tran vdout0_49ck970 FIND v(dout0_49) AT=980.05n

.meas tran vdout0_50ck970 FIND v(dout0_50) AT=980.05n

.meas tran vdout0_51ck970 FIND v(dout0_51) AT=980.05n

.meas tran vdout0_52ck970 FIND v(dout0_52) AT=980.05n

.meas tran vdout0_53ck970 FIND v(dout0_53) AT=980.05n

.meas tran vdout0_54ck970 FIND v(dout0_54) AT=980.05n

.meas tran vdout0_55ck970 FIND v(dout0_55) AT=980.05n

.meas tran vdout0_56ck970 FIND v(dout0_56) AT=980.05n

.meas tran vdout0_57ck970 FIND v(dout0_57) AT=980.05n

.meas tran vdout0_58ck970 FIND v(dout0_58) AT=980.05n

.meas tran vdout0_59ck970 FIND v(dout0_59) AT=980.05n

.meas tran vdout0_60ck970 FIND v(dout0_60) AT=980.05n

.meas tran vdout0_61ck970 FIND v(dout0_61) AT=980.05n

.meas tran vdout0_62ck970 FIND v(dout0_62) AT=980.05n

.meas tran vdout0_63ck970 FIND v(dout0_63) AT=980.05n

.meas tran vdout0_64ck970 FIND v(dout0_64) AT=980.05n

.meas tran vdout0_0ck1020 FIND v(dout0_0) AT=1030.05n

.meas tran vdout0_1ck1020 FIND v(dout0_1) AT=1030.05n

.meas tran vdout0_2ck1020 FIND v(dout0_2) AT=1030.05n

.meas tran vdout0_3ck1020 FIND v(dout0_3) AT=1030.05n

.meas tran vdout0_4ck1020 FIND v(dout0_4) AT=1030.05n

.meas tran vdout0_5ck1020 FIND v(dout0_5) AT=1030.05n

.meas tran vdout0_6ck1020 FIND v(dout0_6) AT=1030.05n

.meas tran vdout0_7ck1020 FIND v(dout0_7) AT=1030.05n

.meas tran vdout0_8ck1020 FIND v(dout0_8) AT=1030.05n

.meas tran vdout0_9ck1020 FIND v(dout0_9) AT=1030.05n

.meas tran vdout0_10ck1020 FIND v(dout0_10) AT=1030.05n

.meas tran vdout0_11ck1020 FIND v(dout0_11) AT=1030.05n

.meas tran vdout0_12ck1020 FIND v(dout0_12) AT=1030.05n

.meas tran vdout0_13ck1020 FIND v(dout0_13) AT=1030.05n

.meas tran vdout0_14ck1020 FIND v(dout0_14) AT=1030.05n

.meas tran vdout0_15ck1020 FIND v(dout0_15) AT=1030.05n

.meas tran vdout0_16ck1020 FIND v(dout0_16) AT=1030.05n

.meas tran vdout0_17ck1020 FIND v(dout0_17) AT=1030.05n

.meas tran vdout0_18ck1020 FIND v(dout0_18) AT=1030.05n

.meas tran vdout0_19ck1020 FIND v(dout0_19) AT=1030.05n

.meas tran vdout0_20ck1020 FIND v(dout0_20) AT=1030.05n

.meas tran vdout0_21ck1020 FIND v(dout0_21) AT=1030.05n

.meas tran vdout0_22ck1020 FIND v(dout0_22) AT=1030.05n

.meas tran vdout0_23ck1020 FIND v(dout0_23) AT=1030.05n

.meas tran vdout0_24ck1020 FIND v(dout0_24) AT=1030.05n

.meas tran vdout0_25ck1020 FIND v(dout0_25) AT=1030.05n

.meas tran vdout0_26ck1020 FIND v(dout0_26) AT=1030.05n

.meas tran vdout0_27ck1020 FIND v(dout0_27) AT=1030.05n

.meas tran vdout0_28ck1020 FIND v(dout0_28) AT=1030.05n

.meas tran vdout0_29ck1020 FIND v(dout0_29) AT=1030.05n

.meas tran vdout0_30ck1020 FIND v(dout0_30) AT=1030.05n

.meas tran vdout0_31ck1020 FIND v(dout0_31) AT=1030.05n

.meas tran vdout0_32ck1020 FIND v(dout0_32) AT=1030.05n

.meas tran vdout0_33ck1020 FIND v(dout0_33) AT=1030.05n

.meas tran vdout0_34ck1020 FIND v(dout0_34) AT=1030.05n

.meas tran vdout0_35ck1020 FIND v(dout0_35) AT=1030.05n

.meas tran vdout0_36ck1020 FIND v(dout0_36) AT=1030.05n

.meas tran vdout0_37ck1020 FIND v(dout0_37) AT=1030.05n

.meas tran vdout0_38ck1020 FIND v(dout0_38) AT=1030.05n

.meas tran vdout0_39ck1020 FIND v(dout0_39) AT=1030.05n

.meas tran vdout0_40ck1020 FIND v(dout0_40) AT=1030.05n

.meas tran vdout0_41ck1020 FIND v(dout0_41) AT=1030.05n

.meas tran vdout0_42ck1020 FIND v(dout0_42) AT=1030.05n

.meas tran vdout0_43ck1020 FIND v(dout0_43) AT=1030.05n

.meas tran vdout0_44ck1020 FIND v(dout0_44) AT=1030.05n

.meas tran vdout0_45ck1020 FIND v(dout0_45) AT=1030.05n

.meas tran vdout0_46ck1020 FIND v(dout0_46) AT=1030.05n

.meas tran vdout0_47ck1020 FIND v(dout0_47) AT=1030.05n

.meas tran vdout0_48ck1020 FIND v(dout0_48) AT=1030.05n

.meas tran vdout0_49ck1020 FIND v(dout0_49) AT=1030.05n

.meas tran vdout0_50ck1020 FIND v(dout0_50) AT=1030.05n

.meas tran vdout0_51ck1020 FIND v(dout0_51) AT=1030.05n

.meas tran vdout0_52ck1020 FIND v(dout0_52) AT=1030.05n

.meas tran vdout0_53ck1020 FIND v(dout0_53) AT=1030.05n

.meas tran vdout0_54ck1020 FIND v(dout0_54) AT=1030.05n

.meas tran vdout0_55ck1020 FIND v(dout0_55) AT=1030.05n

.meas tran vdout0_56ck1020 FIND v(dout0_56) AT=1030.05n

.meas tran vdout0_57ck1020 FIND v(dout0_57) AT=1030.05n

.meas tran vdout0_58ck1020 FIND v(dout0_58) AT=1030.05n

.meas tran vdout0_59ck1020 FIND v(dout0_59) AT=1030.05n

.meas tran vdout0_60ck1020 FIND v(dout0_60) AT=1030.05n

.meas tran vdout0_61ck1020 FIND v(dout0_61) AT=1030.05n

.meas tran vdout0_62ck1020 FIND v(dout0_62) AT=1030.05n

.meas tran vdout0_63ck1020 FIND v(dout0_63) AT=1030.05n

.meas tran vdout0_64ck1020 FIND v(dout0_64) AT=1030.05n

.meas tran vdout0_0ck1050 FIND v(dout0_0) AT=1060.05n

.meas tran vdout0_1ck1050 FIND v(dout0_1) AT=1060.05n

.meas tran vdout0_2ck1050 FIND v(dout0_2) AT=1060.05n

.meas tran vdout0_3ck1050 FIND v(dout0_3) AT=1060.05n

.meas tran vdout0_4ck1050 FIND v(dout0_4) AT=1060.05n

.meas tran vdout0_5ck1050 FIND v(dout0_5) AT=1060.05n

.meas tran vdout0_6ck1050 FIND v(dout0_6) AT=1060.05n

.meas tran vdout0_7ck1050 FIND v(dout0_7) AT=1060.05n

.meas tran vdout0_8ck1050 FIND v(dout0_8) AT=1060.05n

.meas tran vdout0_9ck1050 FIND v(dout0_9) AT=1060.05n

.meas tran vdout0_10ck1050 FIND v(dout0_10) AT=1060.05n

.meas tran vdout0_11ck1050 FIND v(dout0_11) AT=1060.05n

.meas tran vdout0_12ck1050 FIND v(dout0_12) AT=1060.05n

.meas tran vdout0_13ck1050 FIND v(dout0_13) AT=1060.05n

.meas tran vdout0_14ck1050 FIND v(dout0_14) AT=1060.05n

.meas tran vdout0_15ck1050 FIND v(dout0_15) AT=1060.05n

.meas tran vdout0_16ck1050 FIND v(dout0_16) AT=1060.05n

.meas tran vdout0_17ck1050 FIND v(dout0_17) AT=1060.05n

.meas tran vdout0_18ck1050 FIND v(dout0_18) AT=1060.05n

.meas tran vdout0_19ck1050 FIND v(dout0_19) AT=1060.05n

.meas tran vdout0_20ck1050 FIND v(dout0_20) AT=1060.05n

.meas tran vdout0_21ck1050 FIND v(dout0_21) AT=1060.05n

.meas tran vdout0_22ck1050 FIND v(dout0_22) AT=1060.05n

.meas tran vdout0_23ck1050 FIND v(dout0_23) AT=1060.05n

.meas tran vdout0_24ck1050 FIND v(dout0_24) AT=1060.05n

.meas tran vdout0_25ck1050 FIND v(dout0_25) AT=1060.05n

.meas tran vdout0_26ck1050 FIND v(dout0_26) AT=1060.05n

.meas tran vdout0_27ck1050 FIND v(dout0_27) AT=1060.05n

.meas tran vdout0_28ck1050 FIND v(dout0_28) AT=1060.05n

.meas tran vdout0_29ck1050 FIND v(dout0_29) AT=1060.05n

.meas tran vdout0_30ck1050 FIND v(dout0_30) AT=1060.05n

.meas tran vdout0_31ck1050 FIND v(dout0_31) AT=1060.05n

.meas tran vdout0_32ck1050 FIND v(dout0_32) AT=1060.05n

.meas tran vdout0_33ck1050 FIND v(dout0_33) AT=1060.05n

.meas tran vdout0_34ck1050 FIND v(dout0_34) AT=1060.05n

.meas tran vdout0_35ck1050 FIND v(dout0_35) AT=1060.05n

.meas tran vdout0_36ck1050 FIND v(dout0_36) AT=1060.05n

.meas tran vdout0_37ck1050 FIND v(dout0_37) AT=1060.05n

.meas tran vdout0_38ck1050 FIND v(dout0_38) AT=1060.05n

.meas tran vdout0_39ck1050 FIND v(dout0_39) AT=1060.05n

.meas tran vdout0_40ck1050 FIND v(dout0_40) AT=1060.05n

.meas tran vdout0_41ck1050 FIND v(dout0_41) AT=1060.05n

.meas tran vdout0_42ck1050 FIND v(dout0_42) AT=1060.05n

.meas tran vdout0_43ck1050 FIND v(dout0_43) AT=1060.05n

.meas tran vdout0_44ck1050 FIND v(dout0_44) AT=1060.05n

.meas tran vdout0_45ck1050 FIND v(dout0_45) AT=1060.05n

.meas tran vdout0_46ck1050 FIND v(dout0_46) AT=1060.05n

.meas tran vdout0_47ck1050 FIND v(dout0_47) AT=1060.05n

.meas tran vdout0_48ck1050 FIND v(dout0_48) AT=1060.05n

.meas tran vdout0_49ck1050 FIND v(dout0_49) AT=1060.05n

.meas tran vdout0_50ck1050 FIND v(dout0_50) AT=1060.05n

.meas tran vdout0_51ck1050 FIND v(dout0_51) AT=1060.05n

.meas tran vdout0_52ck1050 FIND v(dout0_52) AT=1060.05n

.meas tran vdout0_53ck1050 FIND v(dout0_53) AT=1060.05n

.meas tran vdout0_54ck1050 FIND v(dout0_54) AT=1060.05n

.meas tran vdout0_55ck1050 FIND v(dout0_55) AT=1060.05n

.meas tran vdout0_56ck1050 FIND v(dout0_56) AT=1060.05n

.meas tran vdout0_57ck1050 FIND v(dout0_57) AT=1060.05n

.meas tran vdout0_58ck1050 FIND v(dout0_58) AT=1060.05n

.meas tran vdout0_59ck1050 FIND v(dout0_59) AT=1060.05n

.meas tran vdout0_60ck1050 FIND v(dout0_60) AT=1060.05n

.meas tran vdout0_61ck1050 FIND v(dout0_61) AT=1060.05n

.meas tran vdout0_62ck1050 FIND v(dout0_62) AT=1060.05n

.meas tran vdout0_63ck1050 FIND v(dout0_63) AT=1060.05n

.meas tran vdout0_64ck1050 FIND v(dout0_64) AT=1060.05n

.meas tran vdout0_0ck1060 FIND v(dout0_0) AT=1070.05n

.meas tran vdout0_1ck1060 FIND v(dout0_1) AT=1070.05n

.meas tran vdout0_2ck1060 FIND v(dout0_2) AT=1070.05n

.meas tran vdout0_3ck1060 FIND v(dout0_3) AT=1070.05n

.meas tran vdout0_4ck1060 FIND v(dout0_4) AT=1070.05n

.meas tran vdout0_5ck1060 FIND v(dout0_5) AT=1070.05n

.meas tran vdout0_6ck1060 FIND v(dout0_6) AT=1070.05n

.meas tran vdout0_7ck1060 FIND v(dout0_7) AT=1070.05n

.meas tran vdout0_8ck1060 FIND v(dout0_8) AT=1070.05n

.meas tran vdout0_9ck1060 FIND v(dout0_9) AT=1070.05n

.meas tran vdout0_10ck1060 FIND v(dout0_10) AT=1070.05n

.meas tran vdout0_11ck1060 FIND v(dout0_11) AT=1070.05n

.meas tran vdout0_12ck1060 FIND v(dout0_12) AT=1070.05n

.meas tran vdout0_13ck1060 FIND v(dout0_13) AT=1070.05n

.meas tran vdout0_14ck1060 FIND v(dout0_14) AT=1070.05n

.meas tran vdout0_15ck1060 FIND v(dout0_15) AT=1070.05n

.meas tran vdout0_16ck1060 FIND v(dout0_16) AT=1070.05n

.meas tran vdout0_17ck1060 FIND v(dout0_17) AT=1070.05n

.meas tran vdout0_18ck1060 FIND v(dout0_18) AT=1070.05n

.meas tran vdout0_19ck1060 FIND v(dout0_19) AT=1070.05n

.meas tran vdout0_20ck1060 FIND v(dout0_20) AT=1070.05n

.meas tran vdout0_21ck1060 FIND v(dout0_21) AT=1070.05n

.meas tran vdout0_22ck1060 FIND v(dout0_22) AT=1070.05n

.meas tran vdout0_23ck1060 FIND v(dout0_23) AT=1070.05n

.meas tran vdout0_24ck1060 FIND v(dout0_24) AT=1070.05n

.meas tran vdout0_25ck1060 FIND v(dout0_25) AT=1070.05n

.meas tran vdout0_26ck1060 FIND v(dout0_26) AT=1070.05n

.meas tran vdout0_27ck1060 FIND v(dout0_27) AT=1070.05n

.meas tran vdout0_28ck1060 FIND v(dout0_28) AT=1070.05n

.meas tran vdout0_29ck1060 FIND v(dout0_29) AT=1070.05n

.meas tran vdout0_30ck1060 FIND v(dout0_30) AT=1070.05n

.meas tran vdout0_31ck1060 FIND v(dout0_31) AT=1070.05n

.meas tran vdout0_32ck1060 FIND v(dout0_32) AT=1070.05n

.meas tran vdout0_33ck1060 FIND v(dout0_33) AT=1070.05n

.meas tran vdout0_34ck1060 FIND v(dout0_34) AT=1070.05n

.meas tran vdout0_35ck1060 FIND v(dout0_35) AT=1070.05n

.meas tran vdout0_36ck1060 FIND v(dout0_36) AT=1070.05n

.meas tran vdout0_37ck1060 FIND v(dout0_37) AT=1070.05n

.meas tran vdout0_38ck1060 FIND v(dout0_38) AT=1070.05n

.meas tran vdout0_39ck1060 FIND v(dout0_39) AT=1070.05n

.meas tran vdout0_40ck1060 FIND v(dout0_40) AT=1070.05n

.meas tran vdout0_41ck1060 FIND v(dout0_41) AT=1070.05n

.meas tran vdout0_42ck1060 FIND v(dout0_42) AT=1070.05n

.meas tran vdout0_43ck1060 FIND v(dout0_43) AT=1070.05n

.meas tran vdout0_44ck1060 FIND v(dout0_44) AT=1070.05n

.meas tran vdout0_45ck1060 FIND v(dout0_45) AT=1070.05n

.meas tran vdout0_46ck1060 FIND v(dout0_46) AT=1070.05n

.meas tran vdout0_47ck1060 FIND v(dout0_47) AT=1070.05n

.meas tran vdout0_48ck1060 FIND v(dout0_48) AT=1070.05n

.meas tran vdout0_49ck1060 FIND v(dout0_49) AT=1070.05n

.meas tran vdout0_50ck1060 FIND v(dout0_50) AT=1070.05n

.meas tran vdout0_51ck1060 FIND v(dout0_51) AT=1070.05n

.meas tran vdout0_52ck1060 FIND v(dout0_52) AT=1070.05n

.meas tran vdout0_53ck1060 FIND v(dout0_53) AT=1070.05n

.meas tran vdout0_54ck1060 FIND v(dout0_54) AT=1070.05n

.meas tran vdout0_55ck1060 FIND v(dout0_55) AT=1070.05n

.meas tran vdout0_56ck1060 FIND v(dout0_56) AT=1070.05n

.meas tran vdout0_57ck1060 FIND v(dout0_57) AT=1070.05n

.meas tran vdout0_58ck1060 FIND v(dout0_58) AT=1070.05n

.meas tran vdout0_59ck1060 FIND v(dout0_59) AT=1070.05n

.meas tran vdout0_60ck1060 FIND v(dout0_60) AT=1070.05n

.meas tran vdout0_61ck1060 FIND v(dout0_61) AT=1070.05n

.meas tran vdout0_62ck1060 FIND v(dout0_62) AT=1070.05n

.meas tran vdout0_63ck1060 FIND v(dout0_63) AT=1070.05n

.meas tran vdout0_64ck1060 FIND v(dout0_64) AT=1070.05n

.meas tran vdout0_0ck1140 FIND v(dout0_0) AT=1150.05n

.meas tran vdout0_1ck1140 FIND v(dout0_1) AT=1150.05n

.meas tran vdout0_2ck1140 FIND v(dout0_2) AT=1150.05n

.meas tran vdout0_3ck1140 FIND v(dout0_3) AT=1150.05n

.meas tran vdout0_4ck1140 FIND v(dout0_4) AT=1150.05n

.meas tran vdout0_5ck1140 FIND v(dout0_5) AT=1150.05n

.meas tran vdout0_6ck1140 FIND v(dout0_6) AT=1150.05n

.meas tran vdout0_7ck1140 FIND v(dout0_7) AT=1150.05n

.meas tran vdout0_8ck1140 FIND v(dout0_8) AT=1150.05n

.meas tran vdout0_9ck1140 FIND v(dout0_9) AT=1150.05n

.meas tran vdout0_10ck1140 FIND v(dout0_10) AT=1150.05n

.meas tran vdout0_11ck1140 FIND v(dout0_11) AT=1150.05n

.meas tran vdout0_12ck1140 FIND v(dout0_12) AT=1150.05n

.meas tran vdout0_13ck1140 FIND v(dout0_13) AT=1150.05n

.meas tran vdout0_14ck1140 FIND v(dout0_14) AT=1150.05n

.meas tran vdout0_15ck1140 FIND v(dout0_15) AT=1150.05n

.meas tran vdout0_16ck1140 FIND v(dout0_16) AT=1150.05n

.meas tran vdout0_17ck1140 FIND v(dout0_17) AT=1150.05n

.meas tran vdout0_18ck1140 FIND v(dout0_18) AT=1150.05n

.meas tran vdout0_19ck1140 FIND v(dout0_19) AT=1150.05n

.meas tran vdout0_20ck1140 FIND v(dout0_20) AT=1150.05n

.meas tran vdout0_21ck1140 FIND v(dout0_21) AT=1150.05n

.meas tran vdout0_22ck1140 FIND v(dout0_22) AT=1150.05n

.meas tran vdout0_23ck1140 FIND v(dout0_23) AT=1150.05n

.meas tran vdout0_24ck1140 FIND v(dout0_24) AT=1150.05n

.meas tran vdout0_25ck1140 FIND v(dout0_25) AT=1150.05n

.meas tran vdout0_26ck1140 FIND v(dout0_26) AT=1150.05n

.meas tran vdout0_27ck1140 FIND v(dout0_27) AT=1150.05n

.meas tran vdout0_28ck1140 FIND v(dout0_28) AT=1150.05n

.meas tran vdout0_29ck1140 FIND v(dout0_29) AT=1150.05n

.meas tran vdout0_30ck1140 FIND v(dout0_30) AT=1150.05n

.meas tran vdout0_31ck1140 FIND v(dout0_31) AT=1150.05n

.meas tran vdout0_32ck1140 FIND v(dout0_32) AT=1150.05n

.meas tran vdout0_33ck1140 FIND v(dout0_33) AT=1150.05n

.meas tran vdout0_34ck1140 FIND v(dout0_34) AT=1150.05n

.meas tran vdout0_35ck1140 FIND v(dout0_35) AT=1150.05n

.meas tran vdout0_36ck1140 FIND v(dout0_36) AT=1150.05n

.meas tran vdout0_37ck1140 FIND v(dout0_37) AT=1150.05n

.meas tran vdout0_38ck1140 FIND v(dout0_38) AT=1150.05n

.meas tran vdout0_39ck1140 FIND v(dout0_39) AT=1150.05n

.meas tran vdout0_40ck1140 FIND v(dout0_40) AT=1150.05n

.meas tran vdout0_41ck1140 FIND v(dout0_41) AT=1150.05n

.meas tran vdout0_42ck1140 FIND v(dout0_42) AT=1150.05n

.meas tran vdout0_43ck1140 FIND v(dout0_43) AT=1150.05n

.meas tran vdout0_44ck1140 FIND v(dout0_44) AT=1150.05n

.meas tran vdout0_45ck1140 FIND v(dout0_45) AT=1150.05n

.meas tran vdout0_46ck1140 FIND v(dout0_46) AT=1150.05n

.meas tran vdout0_47ck1140 FIND v(dout0_47) AT=1150.05n

.meas tran vdout0_48ck1140 FIND v(dout0_48) AT=1150.05n

.meas tran vdout0_49ck1140 FIND v(dout0_49) AT=1150.05n

.meas tran vdout0_50ck1140 FIND v(dout0_50) AT=1150.05n

.meas tran vdout0_51ck1140 FIND v(dout0_51) AT=1150.05n

.meas tran vdout0_52ck1140 FIND v(dout0_52) AT=1150.05n

.meas tran vdout0_53ck1140 FIND v(dout0_53) AT=1150.05n

.meas tran vdout0_54ck1140 FIND v(dout0_54) AT=1150.05n

.meas tran vdout0_55ck1140 FIND v(dout0_55) AT=1150.05n

.meas tran vdout0_56ck1140 FIND v(dout0_56) AT=1150.05n

.meas tran vdout0_57ck1140 FIND v(dout0_57) AT=1150.05n

.meas tran vdout0_58ck1140 FIND v(dout0_58) AT=1150.05n

.meas tran vdout0_59ck1140 FIND v(dout0_59) AT=1150.05n

.meas tran vdout0_60ck1140 FIND v(dout0_60) AT=1150.05n

.meas tran vdout0_61ck1140 FIND v(dout0_61) AT=1150.05n

.meas tran vdout0_62ck1140 FIND v(dout0_62) AT=1150.05n

.meas tran vdout0_63ck1140 FIND v(dout0_63) AT=1150.05n

.meas tran vdout0_64ck1140 FIND v(dout0_64) AT=1150.05n

.meas tran vdout0_0ck1150 FIND v(dout0_0) AT=1160.05n

.meas tran vdout0_1ck1150 FIND v(dout0_1) AT=1160.05n

.meas tran vdout0_2ck1150 FIND v(dout0_2) AT=1160.05n

.meas tran vdout0_3ck1150 FIND v(dout0_3) AT=1160.05n

.meas tran vdout0_4ck1150 FIND v(dout0_4) AT=1160.05n

.meas tran vdout0_5ck1150 FIND v(dout0_5) AT=1160.05n

.meas tran vdout0_6ck1150 FIND v(dout0_6) AT=1160.05n

.meas tran vdout0_7ck1150 FIND v(dout0_7) AT=1160.05n

.meas tran vdout0_8ck1150 FIND v(dout0_8) AT=1160.05n

.meas tran vdout0_9ck1150 FIND v(dout0_9) AT=1160.05n

.meas tran vdout0_10ck1150 FIND v(dout0_10) AT=1160.05n

.meas tran vdout0_11ck1150 FIND v(dout0_11) AT=1160.05n

.meas tran vdout0_12ck1150 FIND v(dout0_12) AT=1160.05n

.meas tran vdout0_13ck1150 FIND v(dout0_13) AT=1160.05n

.meas tran vdout0_14ck1150 FIND v(dout0_14) AT=1160.05n

.meas tran vdout0_15ck1150 FIND v(dout0_15) AT=1160.05n

.meas tran vdout0_16ck1150 FIND v(dout0_16) AT=1160.05n

.meas tran vdout0_17ck1150 FIND v(dout0_17) AT=1160.05n

.meas tran vdout0_18ck1150 FIND v(dout0_18) AT=1160.05n

.meas tran vdout0_19ck1150 FIND v(dout0_19) AT=1160.05n

.meas tran vdout0_20ck1150 FIND v(dout0_20) AT=1160.05n

.meas tran vdout0_21ck1150 FIND v(dout0_21) AT=1160.05n

.meas tran vdout0_22ck1150 FIND v(dout0_22) AT=1160.05n

.meas tran vdout0_23ck1150 FIND v(dout0_23) AT=1160.05n

.meas tran vdout0_24ck1150 FIND v(dout0_24) AT=1160.05n

.meas tran vdout0_25ck1150 FIND v(dout0_25) AT=1160.05n

.meas tran vdout0_26ck1150 FIND v(dout0_26) AT=1160.05n

.meas tran vdout0_27ck1150 FIND v(dout0_27) AT=1160.05n

.meas tran vdout0_28ck1150 FIND v(dout0_28) AT=1160.05n

.meas tran vdout0_29ck1150 FIND v(dout0_29) AT=1160.05n

.meas tran vdout0_30ck1150 FIND v(dout0_30) AT=1160.05n

.meas tran vdout0_31ck1150 FIND v(dout0_31) AT=1160.05n

.meas tran vdout0_32ck1150 FIND v(dout0_32) AT=1160.05n

.meas tran vdout0_33ck1150 FIND v(dout0_33) AT=1160.05n

.meas tran vdout0_34ck1150 FIND v(dout0_34) AT=1160.05n

.meas tran vdout0_35ck1150 FIND v(dout0_35) AT=1160.05n

.meas tran vdout0_36ck1150 FIND v(dout0_36) AT=1160.05n

.meas tran vdout0_37ck1150 FIND v(dout0_37) AT=1160.05n

.meas tran vdout0_38ck1150 FIND v(dout0_38) AT=1160.05n

.meas tran vdout0_39ck1150 FIND v(dout0_39) AT=1160.05n

.meas tran vdout0_40ck1150 FIND v(dout0_40) AT=1160.05n

.meas tran vdout0_41ck1150 FIND v(dout0_41) AT=1160.05n

.meas tran vdout0_42ck1150 FIND v(dout0_42) AT=1160.05n

.meas tran vdout0_43ck1150 FIND v(dout0_43) AT=1160.05n

.meas tran vdout0_44ck1150 FIND v(dout0_44) AT=1160.05n

.meas tran vdout0_45ck1150 FIND v(dout0_45) AT=1160.05n

.meas tran vdout0_46ck1150 FIND v(dout0_46) AT=1160.05n

.meas tran vdout0_47ck1150 FIND v(dout0_47) AT=1160.05n

.meas tran vdout0_48ck1150 FIND v(dout0_48) AT=1160.05n

.meas tran vdout0_49ck1150 FIND v(dout0_49) AT=1160.05n

.meas tran vdout0_50ck1150 FIND v(dout0_50) AT=1160.05n

.meas tran vdout0_51ck1150 FIND v(dout0_51) AT=1160.05n

.meas tran vdout0_52ck1150 FIND v(dout0_52) AT=1160.05n

.meas tran vdout0_53ck1150 FIND v(dout0_53) AT=1160.05n

.meas tran vdout0_54ck1150 FIND v(dout0_54) AT=1160.05n

.meas tran vdout0_55ck1150 FIND v(dout0_55) AT=1160.05n

.meas tran vdout0_56ck1150 FIND v(dout0_56) AT=1160.05n

.meas tran vdout0_57ck1150 FIND v(dout0_57) AT=1160.05n

.meas tran vdout0_58ck1150 FIND v(dout0_58) AT=1160.05n

.meas tran vdout0_59ck1150 FIND v(dout0_59) AT=1160.05n

.meas tran vdout0_60ck1150 FIND v(dout0_60) AT=1160.05n

.meas tran vdout0_61ck1150 FIND v(dout0_61) AT=1160.05n

.meas tran vdout0_62ck1150 FIND v(dout0_62) AT=1160.05n

.meas tran vdout0_63ck1150 FIND v(dout0_63) AT=1160.05n

.meas tran vdout0_64ck1150 FIND v(dout0_64) AT=1160.05n

.meas tran vdout0_0ck1170 FIND v(dout0_0) AT=1180.05n

.meas tran vdout0_1ck1170 FIND v(dout0_1) AT=1180.05n

.meas tran vdout0_2ck1170 FIND v(dout0_2) AT=1180.05n

.meas tran vdout0_3ck1170 FIND v(dout0_3) AT=1180.05n

.meas tran vdout0_4ck1170 FIND v(dout0_4) AT=1180.05n

.meas tran vdout0_5ck1170 FIND v(dout0_5) AT=1180.05n

.meas tran vdout0_6ck1170 FIND v(dout0_6) AT=1180.05n

.meas tran vdout0_7ck1170 FIND v(dout0_7) AT=1180.05n

.meas tran vdout0_8ck1170 FIND v(dout0_8) AT=1180.05n

.meas tran vdout0_9ck1170 FIND v(dout0_9) AT=1180.05n

.meas tran vdout0_10ck1170 FIND v(dout0_10) AT=1180.05n

.meas tran vdout0_11ck1170 FIND v(dout0_11) AT=1180.05n

.meas tran vdout0_12ck1170 FIND v(dout0_12) AT=1180.05n

.meas tran vdout0_13ck1170 FIND v(dout0_13) AT=1180.05n

.meas tran vdout0_14ck1170 FIND v(dout0_14) AT=1180.05n

.meas tran vdout0_15ck1170 FIND v(dout0_15) AT=1180.05n

.meas tran vdout0_16ck1170 FIND v(dout0_16) AT=1180.05n

.meas tran vdout0_17ck1170 FIND v(dout0_17) AT=1180.05n

.meas tran vdout0_18ck1170 FIND v(dout0_18) AT=1180.05n

.meas tran vdout0_19ck1170 FIND v(dout0_19) AT=1180.05n

.meas tran vdout0_20ck1170 FIND v(dout0_20) AT=1180.05n

.meas tran vdout0_21ck1170 FIND v(dout0_21) AT=1180.05n

.meas tran vdout0_22ck1170 FIND v(dout0_22) AT=1180.05n

.meas tran vdout0_23ck1170 FIND v(dout0_23) AT=1180.05n

.meas tran vdout0_24ck1170 FIND v(dout0_24) AT=1180.05n

.meas tran vdout0_25ck1170 FIND v(dout0_25) AT=1180.05n

.meas tran vdout0_26ck1170 FIND v(dout0_26) AT=1180.05n

.meas tran vdout0_27ck1170 FIND v(dout0_27) AT=1180.05n

.meas tran vdout0_28ck1170 FIND v(dout0_28) AT=1180.05n

.meas tran vdout0_29ck1170 FIND v(dout0_29) AT=1180.05n

.meas tran vdout0_30ck1170 FIND v(dout0_30) AT=1180.05n

.meas tran vdout0_31ck1170 FIND v(dout0_31) AT=1180.05n

.meas tran vdout0_32ck1170 FIND v(dout0_32) AT=1180.05n

.meas tran vdout0_33ck1170 FIND v(dout0_33) AT=1180.05n

.meas tran vdout0_34ck1170 FIND v(dout0_34) AT=1180.05n

.meas tran vdout0_35ck1170 FIND v(dout0_35) AT=1180.05n

.meas tran vdout0_36ck1170 FIND v(dout0_36) AT=1180.05n

.meas tran vdout0_37ck1170 FIND v(dout0_37) AT=1180.05n

.meas tran vdout0_38ck1170 FIND v(dout0_38) AT=1180.05n

.meas tran vdout0_39ck1170 FIND v(dout0_39) AT=1180.05n

.meas tran vdout0_40ck1170 FIND v(dout0_40) AT=1180.05n

.meas tran vdout0_41ck1170 FIND v(dout0_41) AT=1180.05n

.meas tran vdout0_42ck1170 FIND v(dout0_42) AT=1180.05n

.meas tran vdout0_43ck1170 FIND v(dout0_43) AT=1180.05n

.meas tran vdout0_44ck1170 FIND v(dout0_44) AT=1180.05n

.meas tran vdout0_45ck1170 FIND v(dout0_45) AT=1180.05n

.meas tran vdout0_46ck1170 FIND v(dout0_46) AT=1180.05n

.meas tran vdout0_47ck1170 FIND v(dout0_47) AT=1180.05n

.meas tran vdout0_48ck1170 FIND v(dout0_48) AT=1180.05n

.meas tran vdout0_49ck1170 FIND v(dout0_49) AT=1180.05n

.meas tran vdout0_50ck1170 FIND v(dout0_50) AT=1180.05n

.meas tran vdout0_51ck1170 FIND v(dout0_51) AT=1180.05n

.meas tran vdout0_52ck1170 FIND v(dout0_52) AT=1180.05n

.meas tran vdout0_53ck1170 FIND v(dout0_53) AT=1180.05n

.meas tran vdout0_54ck1170 FIND v(dout0_54) AT=1180.05n

.meas tran vdout0_55ck1170 FIND v(dout0_55) AT=1180.05n

.meas tran vdout0_56ck1170 FIND v(dout0_56) AT=1180.05n

.meas tran vdout0_57ck1170 FIND v(dout0_57) AT=1180.05n

.meas tran vdout0_58ck1170 FIND v(dout0_58) AT=1180.05n

.meas tran vdout0_59ck1170 FIND v(dout0_59) AT=1180.05n

.meas tran vdout0_60ck1170 FIND v(dout0_60) AT=1180.05n

.meas tran vdout0_61ck1170 FIND v(dout0_61) AT=1180.05n

.meas tran vdout0_62ck1170 FIND v(dout0_62) AT=1180.05n

.meas tran vdout0_63ck1170 FIND v(dout0_63) AT=1180.05n

.meas tran vdout0_64ck1170 FIND v(dout0_64) AT=1180.05n

.meas tran vdout0_0ck1190 FIND v(dout0_0) AT=1200.05n

.meas tran vdout0_1ck1190 FIND v(dout0_1) AT=1200.05n

.meas tran vdout0_2ck1190 FIND v(dout0_2) AT=1200.05n

.meas tran vdout0_3ck1190 FIND v(dout0_3) AT=1200.05n

.meas tran vdout0_4ck1190 FIND v(dout0_4) AT=1200.05n

.meas tran vdout0_5ck1190 FIND v(dout0_5) AT=1200.05n

.meas tran vdout0_6ck1190 FIND v(dout0_6) AT=1200.05n

.meas tran vdout0_7ck1190 FIND v(dout0_7) AT=1200.05n

.meas tran vdout0_8ck1190 FIND v(dout0_8) AT=1200.05n

.meas tran vdout0_9ck1190 FIND v(dout0_9) AT=1200.05n

.meas tran vdout0_10ck1190 FIND v(dout0_10) AT=1200.05n

.meas tran vdout0_11ck1190 FIND v(dout0_11) AT=1200.05n

.meas tran vdout0_12ck1190 FIND v(dout0_12) AT=1200.05n

.meas tran vdout0_13ck1190 FIND v(dout0_13) AT=1200.05n

.meas tran vdout0_14ck1190 FIND v(dout0_14) AT=1200.05n

.meas tran vdout0_15ck1190 FIND v(dout0_15) AT=1200.05n

.meas tran vdout0_16ck1190 FIND v(dout0_16) AT=1200.05n

.meas tran vdout0_17ck1190 FIND v(dout0_17) AT=1200.05n

.meas tran vdout0_18ck1190 FIND v(dout0_18) AT=1200.05n

.meas tran vdout0_19ck1190 FIND v(dout0_19) AT=1200.05n

.meas tran vdout0_20ck1190 FIND v(dout0_20) AT=1200.05n

.meas tran vdout0_21ck1190 FIND v(dout0_21) AT=1200.05n

.meas tran vdout0_22ck1190 FIND v(dout0_22) AT=1200.05n

.meas tran vdout0_23ck1190 FIND v(dout0_23) AT=1200.05n

.meas tran vdout0_24ck1190 FIND v(dout0_24) AT=1200.05n

.meas tran vdout0_25ck1190 FIND v(dout0_25) AT=1200.05n

.meas tran vdout0_26ck1190 FIND v(dout0_26) AT=1200.05n

.meas tran vdout0_27ck1190 FIND v(dout0_27) AT=1200.05n

.meas tran vdout0_28ck1190 FIND v(dout0_28) AT=1200.05n

.meas tran vdout0_29ck1190 FIND v(dout0_29) AT=1200.05n

.meas tran vdout0_30ck1190 FIND v(dout0_30) AT=1200.05n

.meas tran vdout0_31ck1190 FIND v(dout0_31) AT=1200.05n

.meas tran vdout0_32ck1190 FIND v(dout0_32) AT=1200.05n

.meas tran vdout0_33ck1190 FIND v(dout0_33) AT=1200.05n

.meas tran vdout0_34ck1190 FIND v(dout0_34) AT=1200.05n

.meas tran vdout0_35ck1190 FIND v(dout0_35) AT=1200.05n

.meas tran vdout0_36ck1190 FIND v(dout0_36) AT=1200.05n

.meas tran vdout0_37ck1190 FIND v(dout0_37) AT=1200.05n

.meas tran vdout0_38ck1190 FIND v(dout0_38) AT=1200.05n

.meas tran vdout0_39ck1190 FIND v(dout0_39) AT=1200.05n

.meas tran vdout0_40ck1190 FIND v(dout0_40) AT=1200.05n

.meas tran vdout0_41ck1190 FIND v(dout0_41) AT=1200.05n

.meas tran vdout0_42ck1190 FIND v(dout0_42) AT=1200.05n

.meas tran vdout0_43ck1190 FIND v(dout0_43) AT=1200.05n

.meas tran vdout0_44ck1190 FIND v(dout0_44) AT=1200.05n

.meas tran vdout0_45ck1190 FIND v(dout0_45) AT=1200.05n

.meas tran vdout0_46ck1190 FIND v(dout0_46) AT=1200.05n

.meas tran vdout0_47ck1190 FIND v(dout0_47) AT=1200.05n

.meas tran vdout0_48ck1190 FIND v(dout0_48) AT=1200.05n

.meas tran vdout0_49ck1190 FIND v(dout0_49) AT=1200.05n

.meas tran vdout0_50ck1190 FIND v(dout0_50) AT=1200.05n

.meas tran vdout0_51ck1190 FIND v(dout0_51) AT=1200.05n

.meas tran vdout0_52ck1190 FIND v(dout0_52) AT=1200.05n

.meas tran vdout0_53ck1190 FIND v(dout0_53) AT=1200.05n

.meas tran vdout0_54ck1190 FIND v(dout0_54) AT=1200.05n

.meas tran vdout0_55ck1190 FIND v(dout0_55) AT=1200.05n

.meas tran vdout0_56ck1190 FIND v(dout0_56) AT=1200.05n

.meas tran vdout0_57ck1190 FIND v(dout0_57) AT=1200.05n

.meas tran vdout0_58ck1190 FIND v(dout0_58) AT=1200.05n

.meas tran vdout0_59ck1190 FIND v(dout0_59) AT=1200.05n

.meas tran vdout0_60ck1190 FIND v(dout0_60) AT=1200.05n

.meas tran vdout0_61ck1190 FIND v(dout0_61) AT=1200.05n

.meas tran vdout0_62ck1190 FIND v(dout0_62) AT=1200.05n

.meas tran vdout0_63ck1190 FIND v(dout0_63) AT=1200.05n

.meas tran vdout0_64ck1190 FIND v(dout0_64) AT=1200.05n

.meas tran vdout0_0ck1200 FIND v(dout0_0) AT=1210.05n

.meas tran vdout0_1ck1200 FIND v(dout0_1) AT=1210.05n

.meas tran vdout0_2ck1200 FIND v(dout0_2) AT=1210.05n

.meas tran vdout0_3ck1200 FIND v(dout0_3) AT=1210.05n

.meas tran vdout0_4ck1200 FIND v(dout0_4) AT=1210.05n

.meas tran vdout0_5ck1200 FIND v(dout0_5) AT=1210.05n

.meas tran vdout0_6ck1200 FIND v(dout0_6) AT=1210.05n

.meas tran vdout0_7ck1200 FIND v(dout0_7) AT=1210.05n

.meas tran vdout0_8ck1200 FIND v(dout0_8) AT=1210.05n

.meas tran vdout0_9ck1200 FIND v(dout0_9) AT=1210.05n

.meas tran vdout0_10ck1200 FIND v(dout0_10) AT=1210.05n

.meas tran vdout0_11ck1200 FIND v(dout0_11) AT=1210.05n

.meas tran vdout0_12ck1200 FIND v(dout0_12) AT=1210.05n

.meas tran vdout0_13ck1200 FIND v(dout0_13) AT=1210.05n

.meas tran vdout0_14ck1200 FIND v(dout0_14) AT=1210.05n

.meas tran vdout0_15ck1200 FIND v(dout0_15) AT=1210.05n

.meas tran vdout0_16ck1200 FIND v(dout0_16) AT=1210.05n

.meas tran vdout0_17ck1200 FIND v(dout0_17) AT=1210.05n

.meas tran vdout0_18ck1200 FIND v(dout0_18) AT=1210.05n

.meas tran vdout0_19ck1200 FIND v(dout0_19) AT=1210.05n

.meas tran vdout0_20ck1200 FIND v(dout0_20) AT=1210.05n

.meas tran vdout0_21ck1200 FIND v(dout0_21) AT=1210.05n

.meas tran vdout0_22ck1200 FIND v(dout0_22) AT=1210.05n

.meas tran vdout0_23ck1200 FIND v(dout0_23) AT=1210.05n

.meas tran vdout0_24ck1200 FIND v(dout0_24) AT=1210.05n

.meas tran vdout0_25ck1200 FIND v(dout0_25) AT=1210.05n

.meas tran vdout0_26ck1200 FIND v(dout0_26) AT=1210.05n

.meas tran vdout0_27ck1200 FIND v(dout0_27) AT=1210.05n

.meas tran vdout0_28ck1200 FIND v(dout0_28) AT=1210.05n

.meas tran vdout0_29ck1200 FIND v(dout0_29) AT=1210.05n

.meas tran vdout0_30ck1200 FIND v(dout0_30) AT=1210.05n

.meas tran vdout0_31ck1200 FIND v(dout0_31) AT=1210.05n

.meas tran vdout0_32ck1200 FIND v(dout0_32) AT=1210.05n

.meas tran vdout0_33ck1200 FIND v(dout0_33) AT=1210.05n

.meas tran vdout0_34ck1200 FIND v(dout0_34) AT=1210.05n

.meas tran vdout0_35ck1200 FIND v(dout0_35) AT=1210.05n

.meas tran vdout0_36ck1200 FIND v(dout0_36) AT=1210.05n

.meas tran vdout0_37ck1200 FIND v(dout0_37) AT=1210.05n

.meas tran vdout0_38ck1200 FIND v(dout0_38) AT=1210.05n

.meas tran vdout0_39ck1200 FIND v(dout0_39) AT=1210.05n

.meas tran vdout0_40ck1200 FIND v(dout0_40) AT=1210.05n

.meas tran vdout0_41ck1200 FIND v(dout0_41) AT=1210.05n

.meas tran vdout0_42ck1200 FIND v(dout0_42) AT=1210.05n

.meas tran vdout0_43ck1200 FIND v(dout0_43) AT=1210.05n

.meas tran vdout0_44ck1200 FIND v(dout0_44) AT=1210.05n

.meas tran vdout0_45ck1200 FIND v(dout0_45) AT=1210.05n

.meas tran vdout0_46ck1200 FIND v(dout0_46) AT=1210.05n

.meas tran vdout0_47ck1200 FIND v(dout0_47) AT=1210.05n

.meas tran vdout0_48ck1200 FIND v(dout0_48) AT=1210.05n

.meas tran vdout0_49ck1200 FIND v(dout0_49) AT=1210.05n

.meas tran vdout0_50ck1200 FIND v(dout0_50) AT=1210.05n

.meas tran vdout0_51ck1200 FIND v(dout0_51) AT=1210.05n

.meas tran vdout0_52ck1200 FIND v(dout0_52) AT=1210.05n

.meas tran vdout0_53ck1200 FIND v(dout0_53) AT=1210.05n

.meas tran vdout0_54ck1200 FIND v(dout0_54) AT=1210.05n

.meas tran vdout0_55ck1200 FIND v(dout0_55) AT=1210.05n

.meas tran vdout0_56ck1200 FIND v(dout0_56) AT=1210.05n

.meas tran vdout0_57ck1200 FIND v(dout0_57) AT=1210.05n

.meas tran vdout0_58ck1200 FIND v(dout0_58) AT=1210.05n

.meas tran vdout0_59ck1200 FIND v(dout0_59) AT=1210.05n

.meas tran vdout0_60ck1200 FIND v(dout0_60) AT=1210.05n

.meas tran vdout0_61ck1200 FIND v(dout0_61) AT=1210.05n

.meas tran vdout0_62ck1200 FIND v(dout0_62) AT=1210.05n

.meas tran vdout0_63ck1200 FIND v(dout0_63) AT=1210.05n

.meas tran vdout0_64ck1200 FIND v(dout0_64) AT=1210.05n

.meas tran vdout0_0ck1210 FIND v(dout0_0) AT=1220.05n

.meas tran vdout0_1ck1210 FIND v(dout0_1) AT=1220.05n

.meas tran vdout0_2ck1210 FIND v(dout0_2) AT=1220.05n

.meas tran vdout0_3ck1210 FIND v(dout0_3) AT=1220.05n

.meas tran vdout0_4ck1210 FIND v(dout0_4) AT=1220.05n

.meas tran vdout0_5ck1210 FIND v(dout0_5) AT=1220.05n

.meas tran vdout0_6ck1210 FIND v(dout0_6) AT=1220.05n

.meas tran vdout0_7ck1210 FIND v(dout0_7) AT=1220.05n

.meas tran vdout0_8ck1210 FIND v(dout0_8) AT=1220.05n

.meas tran vdout0_9ck1210 FIND v(dout0_9) AT=1220.05n

.meas tran vdout0_10ck1210 FIND v(dout0_10) AT=1220.05n

.meas tran vdout0_11ck1210 FIND v(dout0_11) AT=1220.05n

.meas tran vdout0_12ck1210 FIND v(dout0_12) AT=1220.05n

.meas tran vdout0_13ck1210 FIND v(dout0_13) AT=1220.05n

.meas tran vdout0_14ck1210 FIND v(dout0_14) AT=1220.05n

.meas tran vdout0_15ck1210 FIND v(dout0_15) AT=1220.05n

.meas tran vdout0_16ck1210 FIND v(dout0_16) AT=1220.05n

.meas tran vdout0_17ck1210 FIND v(dout0_17) AT=1220.05n

.meas tran vdout0_18ck1210 FIND v(dout0_18) AT=1220.05n

.meas tran vdout0_19ck1210 FIND v(dout0_19) AT=1220.05n

.meas tran vdout0_20ck1210 FIND v(dout0_20) AT=1220.05n

.meas tran vdout0_21ck1210 FIND v(dout0_21) AT=1220.05n

.meas tran vdout0_22ck1210 FIND v(dout0_22) AT=1220.05n

.meas tran vdout0_23ck1210 FIND v(dout0_23) AT=1220.05n

.meas tran vdout0_24ck1210 FIND v(dout0_24) AT=1220.05n

.meas tran vdout0_25ck1210 FIND v(dout0_25) AT=1220.05n

.meas tran vdout0_26ck1210 FIND v(dout0_26) AT=1220.05n

.meas tran vdout0_27ck1210 FIND v(dout0_27) AT=1220.05n

.meas tran vdout0_28ck1210 FIND v(dout0_28) AT=1220.05n

.meas tran vdout0_29ck1210 FIND v(dout0_29) AT=1220.05n

.meas tran vdout0_30ck1210 FIND v(dout0_30) AT=1220.05n

.meas tran vdout0_31ck1210 FIND v(dout0_31) AT=1220.05n

.meas tran vdout0_32ck1210 FIND v(dout0_32) AT=1220.05n

.meas tran vdout0_33ck1210 FIND v(dout0_33) AT=1220.05n

.meas tran vdout0_34ck1210 FIND v(dout0_34) AT=1220.05n

.meas tran vdout0_35ck1210 FIND v(dout0_35) AT=1220.05n

.meas tran vdout0_36ck1210 FIND v(dout0_36) AT=1220.05n

.meas tran vdout0_37ck1210 FIND v(dout0_37) AT=1220.05n

.meas tran vdout0_38ck1210 FIND v(dout0_38) AT=1220.05n

.meas tran vdout0_39ck1210 FIND v(dout0_39) AT=1220.05n

.meas tran vdout0_40ck1210 FIND v(dout0_40) AT=1220.05n

.meas tran vdout0_41ck1210 FIND v(dout0_41) AT=1220.05n

.meas tran vdout0_42ck1210 FIND v(dout0_42) AT=1220.05n

.meas tran vdout0_43ck1210 FIND v(dout0_43) AT=1220.05n

.meas tran vdout0_44ck1210 FIND v(dout0_44) AT=1220.05n

.meas tran vdout0_45ck1210 FIND v(dout0_45) AT=1220.05n

.meas tran vdout0_46ck1210 FIND v(dout0_46) AT=1220.05n

.meas tran vdout0_47ck1210 FIND v(dout0_47) AT=1220.05n

.meas tran vdout0_48ck1210 FIND v(dout0_48) AT=1220.05n

.meas tran vdout0_49ck1210 FIND v(dout0_49) AT=1220.05n

.meas tran vdout0_50ck1210 FIND v(dout0_50) AT=1220.05n

.meas tran vdout0_51ck1210 FIND v(dout0_51) AT=1220.05n

.meas tran vdout0_52ck1210 FIND v(dout0_52) AT=1220.05n

.meas tran vdout0_53ck1210 FIND v(dout0_53) AT=1220.05n

.meas tran vdout0_54ck1210 FIND v(dout0_54) AT=1220.05n

.meas tran vdout0_55ck1210 FIND v(dout0_55) AT=1220.05n

.meas tran vdout0_56ck1210 FIND v(dout0_56) AT=1220.05n

.meas tran vdout0_57ck1210 FIND v(dout0_57) AT=1220.05n

.meas tran vdout0_58ck1210 FIND v(dout0_58) AT=1220.05n

.meas tran vdout0_59ck1210 FIND v(dout0_59) AT=1220.05n

.meas tran vdout0_60ck1210 FIND v(dout0_60) AT=1220.05n

.meas tran vdout0_61ck1210 FIND v(dout0_61) AT=1220.05n

.meas tran vdout0_62ck1210 FIND v(dout0_62) AT=1220.05n

.meas tran vdout0_63ck1210 FIND v(dout0_63) AT=1220.05n

.meas tran vdout0_64ck1210 FIND v(dout0_64) AT=1220.05n

.meas tran vdout0_0ck1240 FIND v(dout0_0) AT=1250.05n

.meas tran vdout0_1ck1240 FIND v(dout0_1) AT=1250.05n

.meas tran vdout0_2ck1240 FIND v(dout0_2) AT=1250.05n

.meas tran vdout0_3ck1240 FIND v(dout0_3) AT=1250.05n

.meas tran vdout0_4ck1240 FIND v(dout0_4) AT=1250.05n

.meas tran vdout0_5ck1240 FIND v(dout0_5) AT=1250.05n

.meas tran vdout0_6ck1240 FIND v(dout0_6) AT=1250.05n

.meas tran vdout0_7ck1240 FIND v(dout0_7) AT=1250.05n

.meas tran vdout0_8ck1240 FIND v(dout0_8) AT=1250.05n

.meas tran vdout0_9ck1240 FIND v(dout0_9) AT=1250.05n

.meas tran vdout0_10ck1240 FIND v(dout0_10) AT=1250.05n

.meas tran vdout0_11ck1240 FIND v(dout0_11) AT=1250.05n

.meas tran vdout0_12ck1240 FIND v(dout0_12) AT=1250.05n

.meas tran vdout0_13ck1240 FIND v(dout0_13) AT=1250.05n

.meas tran vdout0_14ck1240 FIND v(dout0_14) AT=1250.05n

.meas tran vdout0_15ck1240 FIND v(dout0_15) AT=1250.05n

.meas tran vdout0_16ck1240 FIND v(dout0_16) AT=1250.05n

.meas tran vdout0_17ck1240 FIND v(dout0_17) AT=1250.05n

.meas tran vdout0_18ck1240 FIND v(dout0_18) AT=1250.05n

.meas tran vdout0_19ck1240 FIND v(dout0_19) AT=1250.05n

.meas tran vdout0_20ck1240 FIND v(dout0_20) AT=1250.05n

.meas tran vdout0_21ck1240 FIND v(dout0_21) AT=1250.05n

.meas tran vdout0_22ck1240 FIND v(dout0_22) AT=1250.05n

.meas tran vdout0_23ck1240 FIND v(dout0_23) AT=1250.05n

.meas tran vdout0_24ck1240 FIND v(dout0_24) AT=1250.05n

.meas tran vdout0_25ck1240 FIND v(dout0_25) AT=1250.05n

.meas tran vdout0_26ck1240 FIND v(dout0_26) AT=1250.05n

.meas tran vdout0_27ck1240 FIND v(dout0_27) AT=1250.05n

.meas tran vdout0_28ck1240 FIND v(dout0_28) AT=1250.05n

.meas tran vdout0_29ck1240 FIND v(dout0_29) AT=1250.05n

.meas tran vdout0_30ck1240 FIND v(dout0_30) AT=1250.05n

.meas tran vdout0_31ck1240 FIND v(dout0_31) AT=1250.05n

.meas tran vdout0_32ck1240 FIND v(dout0_32) AT=1250.05n

.meas tran vdout0_33ck1240 FIND v(dout0_33) AT=1250.05n

.meas tran vdout0_34ck1240 FIND v(dout0_34) AT=1250.05n

.meas tran vdout0_35ck1240 FIND v(dout0_35) AT=1250.05n

.meas tran vdout0_36ck1240 FIND v(dout0_36) AT=1250.05n

.meas tran vdout0_37ck1240 FIND v(dout0_37) AT=1250.05n

.meas tran vdout0_38ck1240 FIND v(dout0_38) AT=1250.05n

.meas tran vdout0_39ck1240 FIND v(dout0_39) AT=1250.05n

.meas tran vdout0_40ck1240 FIND v(dout0_40) AT=1250.05n

.meas tran vdout0_41ck1240 FIND v(dout0_41) AT=1250.05n

.meas tran vdout0_42ck1240 FIND v(dout0_42) AT=1250.05n

.meas tran vdout0_43ck1240 FIND v(dout0_43) AT=1250.05n

.meas tran vdout0_44ck1240 FIND v(dout0_44) AT=1250.05n

.meas tran vdout0_45ck1240 FIND v(dout0_45) AT=1250.05n

.meas tran vdout0_46ck1240 FIND v(dout0_46) AT=1250.05n

.meas tran vdout0_47ck1240 FIND v(dout0_47) AT=1250.05n

.meas tran vdout0_48ck1240 FIND v(dout0_48) AT=1250.05n

.meas tran vdout0_49ck1240 FIND v(dout0_49) AT=1250.05n

.meas tran vdout0_50ck1240 FIND v(dout0_50) AT=1250.05n

.meas tran vdout0_51ck1240 FIND v(dout0_51) AT=1250.05n

.meas tran vdout0_52ck1240 FIND v(dout0_52) AT=1250.05n

.meas tran vdout0_53ck1240 FIND v(dout0_53) AT=1250.05n

.meas tran vdout0_54ck1240 FIND v(dout0_54) AT=1250.05n

.meas tran vdout0_55ck1240 FIND v(dout0_55) AT=1250.05n

.meas tran vdout0_56ck1240 FIND v(dout0_56) AT=1250.05n

.meas tran vdout0_57ck1240 FIND v(dout0_57) AT=1250.05n

.meas tran vdout0_58ck1240 FIND v(dout0_58) AT=1250.05n

.meas tran vdout0_59ck1240 FIND v(dout0_59) AT=1250.05n

.meas tran vdout0_60ck1240 FIND v(dout0_60) AT=1250.05n

.meas tran vdout0_61ck1240 FIND v(dout0_61) AT=1250.05n

.meas tran vdout0_62ck1240 FIND v(dout0_62) AT=1250.05n

.meas tran vdout0_63ck1240 FIND v(dout0_63) AT=1250.05n

.meas tran vdout0_64ck1240 FIND v(dout0_64) AT=1250.05n

.meas tran vdout0_0ck1260 FIND v(dout0_0) AT=1270.05n

.meas tran vdout0_1ck1260 FIND v(dout0_1) AT=1270.05n

.meas tran vdout0_2ck1260 FIND v(dout0_2) AT=1270.05n

.meas tran vdout0_3ck1260 FIND v(dout0_3) AT=1270.05n

.meas tran vdout0_4ck1260 FIND v(dout0_4) AT=1270.05n

.meas tran vdout0_5ck1260 FIND v(dout0_5) AT=1270.05n

.meas tran vdout0_6ck1260 FIND v(dout0_6) AT=1270.05n

.meas tran vdout0_7ck1260 FIND v(dout0_7) AT=1270.05n

.meas tran vdout0_8ck1260 FIND v(dout0_8) AT=1270.05n

.meas tran vdout0_9ck1260 FIND v(dout0_9) AT=1270.05n

.meas tran vdout0_10ck1260 FIND v(dout0_10) AT=1270.05n

.meas tran vdout0_11ck1260 FIND v(dout0_11) AT=1270.05n

.meas tran vdout0_12ck1260 FIND v(dout0_12) AT=1270.05n

.meas tran vdout0_13ck1260 FIND v(dout0_13) AT=1270.05n

.meas tran vdout0_14ck1260 FIND v(dout0_14) AT=1270.05n

.meas tran vdout0_15ck1260 FIND v(dout0_15) AT=1270.05n

.meas tran vdout0_16ck1260 FIND v(dout0_16) AT=1270.05n

.meas tran vdout0_17ck1260 FIND v(dout0_17) AT=1270.05n

.meas tran vdout0_18ck1260 FIND v(dout0_18) AT=1270.05n

.meas tran vdout0_19ck1260 FIND v(dout0_19) AT=1270.05n

.meas tran vdout0_20ck1260 FIND v(dout0_20) AT=1270.05n

.meas tran vdout0_21ck1260 FIND v(dout0_21) AT=1270.05n

.meas tran vdout0_22ck1260 FIND v(dout0_22) AT=1270.05n

.meas tran vdout0_23ck1260 FIND v(dout0_23) AT=1270.05n

.meas tran vdout0_24ck1260 FIND v(dout0_24) AT=1270.05n

.meas tran vdout0_25ck1260 FIND v(dout0_25) AT=1270.05n

.meas tran vdout0_26ck1260 FIND v(dout0_26) AT=1270.05n

.meas tran vdout0_27ck1260 FIND v(dout0_27) AT=1270.05n

.meas tran vdout0_28ck1260 FIND v(dout0_28) AT=1270.05n

.meas tran vdout0_29ck1260 FIND v(dout0_29) AT=1270.05n

.meas tran vdout0_30ck1260 FIND v(dout0_30) AT=1270.05n

.meas tran vdout0_31ck1260 FIND v(dout0_31) AT=1270.05n

.meas tran vdout0_32ck1260 FIND v(dout0_32) AT=1270.05n

.meas tran vdout0_33ck1260 FIND v(dout0_33) AT=1270.05n

.meas tran vdout0_34ck1260 FIND v(dout0_34) AT=1270.05n

.meas tran vdout0_35ck1260 FIND v(dout0_35) AT=1270.05n

.meas tran vdout0_36ck1260 FIND v(dout0_36) AT=1270.05n

.meas tran vdout0_37ck1260 FIND v(dout0_37) AT=1270.05n

.meas tran vdout0_38ck1260 FIND v(dout0_38) AT=1270.05n

.meas tran vdout0_39ck1260 FIND v(dout0_39) AT=1270.05n

.meas tran vdout0_40ck1260 FIND v(dout0_40) AT=1270.05n

.meas tran vdout0_41ck1260 FIND v(dout0_41) AT=1270.05n

.meas tran vdout0_42ck1260 FIND v(dout0_42) AT=1270.05n

.meas tran vdout0_43ck1260 FIND v(dout0_43) AT=1270.05n

.meas tran vdout0_44ck1260 FIND v(dout0_44) AT=1270.05n

.meas tran vdout0_45ck1260 FIND v(dout0_45) AT=1270.05n

.meas tran vdout0_46ck1260 FIND v(dout0_46) AT=1270.05n

.meas tran vdout0_47ck1260 FIND v(dout0_47) AT=1270.05n

.meas tran vdout0_48ck1260 FIND v(dout0_48) AT=1270.05n

.meas tran vdout0_49ck1260 FIND v(dout0_49) AT=1270.05n

.meas tran vdout0_50ck1260 FIND v(dout0_50) AT=1270.05n

.meas tran vdout0_51ck1260 FIND v(dout0_51) AT=1270.05n

.meas tran vdout0_52ck1260 FIND v(dout0_52) AT=1270.05n

.meas tran vdout0_53ck1260 FIND v(dout0_53) AT=1270.05n

.meas tran vdout0_54ck1260 FIND v(dout0_54) AT=1270.05n

.meas tran vdout0_55ck1260 FIND v(dout0_55) AT=1270.05n

.meas tran vdout0_56ck1260 FIND v(dout0_56) AT=1270.05n

.meas tran vdout0_57ck1260 FIND v(dout0_57) AT=1270.05n

.meas tran vdout0_58ck1260 FIND v(dout0_58) AT=1270.05n

.meas tran vdout0_59ck1260 FIND v(dout0_59) AT=1270.05n

.meas tran vdout0_60ck1260 FIND v(dout0_60) AT=1270.05n

.meas tran vdout0_61ck1260 FIND v(dout0_61) AT=1270.05n

.meas tran vdout0_62ck1260 FIND v(dout0_62) AT=1270.05n

.meas tran vdout0_63ck1260 FIND v(dout0_63) AT=1270.05n

.meas tran vdout0_64ck1260 FIND v(dout0_64) AT=1270.05n

.meas tran vdout0_0ck1270 FIND v(dout0_0) AT=1280.05n

.meas tran vdout0_1ck1270 FIND v(dout0_1) AT=1280.05n

.meas tran vdout0_2ck1270 FIND v(dout0_2) AT=1280.05n

.meas tran vdout0_3ck1270 FIND v(dout0_3) AT=1280.05n

.meas tran vdout0_4ck1270 FIND v(dout0_4) AT=1280.05n

.meas tran vdout0_5ck1270 FIND v(dout0_5) AT=1280.05n

.meas tran vdout0_6ck1270 FIND v(dout0_6) AT=1280.05n

.meas tran vdout0_7ck1270 FIND v(dout0_7) AT=1280.05n

.meas tran vdout0_8ck1270 FIND v(dout0_8) AT=1280.05n

.meas tran vdout0_9ck1270 FIND v(dout0_9) AT=1280.05n

.meas tran vdout0_10ck1270 FIND v(dout0_10) AT=1280.05n

.meas tran vdout0_11ck1270 FIND v(dout0_11) AT=1280.05n

.meas tran vdout0_12ck1270 FIND v(dout0_12) AT=1280.05n

.meas tran vdout0_13ck1270 FIND v(dout0_13) AT=1280.05n

.meas tran vdout0_14ck1270 FIND v(dout0_14) AT=1280.05n

.meas tran vdout0_15ck1270 FIND v(dout0_15) AT=1280.05n

.meas tran vdout0_16ck1270 FIND v(dout0_16) AT=1280.05n

.meas tran vdout0_17ck1270 FIND v(dout0_17) AT=1280.05n

.meas tran vdout0_18ck1270 FIND v(dout0_18) AT=1280.05n

.meas tran vdout0_19ck1270 FIND v(dout0_19) AT=1280.05n

.meas tran vdout0_20ck1270 FIND v(dout0_20) AT=1280.05n

.meas tran vdout0_21ck1270 FIND v(dout0_21) AT=1280.05n

.meas tran vdout0_22ck1270 FIND v(dout0_22) AT=1280.05n

.meas tran vdout0_23ck1270 FIND v(dout0_23) AT=1280.05n

.meas tran vdout0_24ck1270 FIND v(dout0_24) AT=1280.05n

.meas tran vdout0_25ck1270 FIND v(dout0_25) AT=1280.05n

.meas tran vdout0_26ck1270 FIND v(dout0_26) AT=1280.05n

.meas tran vdout0_27ck1270 FIND v(dout0_27) AT=1280.05n

.meas tran vdout0_28ck1270 FIND v(dout0_28) AT=1280.05n

.meas tran vdout0_29ck1270 FIND v(dout0_29) AT=1280.05n

.meas tran vdout0_30ck1270 FIND v(dout0_30) AT=1280.05n

.meas tran vdout0_31ck1270 FIND v(dout0_31) AT=1280.05n

.meas tran vdout0_32ck1270 FIND v(dout0_32) AT=1280.05n

.meas tran vdout0_33ck1270 FIND v(dout0_33) AT=1280.05n

.meas tran vdout0_34ck1270 FIND v(dout0_34) AT=1280.05n

.meas tran vdout0_35ck1270 FIND v(dout0_35) AT=1280.05n

.meas tran vdout0_36ck1270 FIND v(dout0_36) AT=1280.05n

.meas tran vdout0_37ck1270 FIND v(dout0_37) AT=1280.05n

.meas tran vdout0_38ck1270 FIND v(dout0_38) AT=1280.05n

.meas tran vdout0_39ck1270 FIND v(dout0_39) AT=1280.05n

.meas tran vdout0_40ck1270 FIND v(dout0_40) AT=1280.05n

.meas tran vdout0_41ck1270 FIND v(dout0_41) AT=1280.05n

.meas tran vdout0_42ck1270 FIND v(dout0_42) AT=1280.05n

.meas tran vdout0_43ck1270 FIND v(dout0_43) AT=1280.05n

.meas tran vdout0_44ck1270 FIND v(dout0_44) AT=1280.05n

.meas tran vdout0_45ck1270 FIND v(dout0_45) AT=1280.05n

.meas tran vdout0_46ck1270 FIND v(dout0_46) AT=1280.05n

.meas tran vdout0_47ck1270 FIND v(dout0_47) AT=1280.05n

.meas tran vdout0_48ck1270 FIND v(dout0_48) AT=1280.05n

.meas tran vdout0_49ck1270 FIND v(dout0_49) AT=1280.05n

.meas tran vdout0_50ck1270 FIND v(dout0_50) AT=1280.05n

.meas tran vdout0_51ck1270 FIND v(dout0_51) AT=1280.05n

.meas tran vdout0_52ck1270 FIND v(dout0_52) AT=1280.05n

.meas tran vdout0_53ck1270 FIND v(dout0_53) AT=1280.05n

.meas tran vdout0_54ck1270 FIND v(dout0_54) AT=1280.05n

.meas tran vdout0_55ck1270 FIND v(dout0_55) AT=1280.05n

.meas tran vdout0_56ck1270 FIND v(dout0_56) AT=1280.05n

.meas tran vdout0_57ck1270 FIND v(dout0_57) AT=1280.05n

.meas tran vdout0_58ck1270 FIND v(dout0_58) AT=1280.05n

.meas tran vdout0_59ck1270 FIND v(dout0_59) AT=1280.05n

.meas tran vdout0_60ck1270 FIND v(dout0_60) AT=1280.05n

.meas tran vdout0_61ck1270 FIND v(dout0_61) AT=1280.05n

.meas tran vdout0_62ck1270 FIND v(dout0_62) AT=1280.05n

.meas tran vdout0_63ck1270 FIND v(dout0_63) AT=1280.05n

.meas tran vdout0_64ck1270 FIND v(dout0_64) AT=1280.05n

.meas tran vdout0_0ck1280 FIND v(dout0_0) AT=1290.05n

.meas tran vdout0_1ck1280 FIND v(dout0_1) AT=1290.05n

.meas tran vdout0_2ck1280 FIND v(dout0_2) AT=1290.05n

.meas tran vdout0_3ck1280 FIND v(dout0_3) AT=1290.05n

.meas tran vdout0_4ck1280 FIND v(dout0_4) AT=1290.05n

.meas tran vdout0_5ck1280 FIND v(dout0_5) AT=1290.05n

.meas tran vdout0_6ck1280 FIND v(dout0_6) AT=1290.05n

.meas tran vdout0_7ck1280 FIND v(dout0_7) AT=1290.05n

.meas tran vdout0_8ck1280 FIND v(dout0_8) AT=1290.05n

.meas tran vdout0_9ck1280 FIND v(dout0_9) AT=1290.05n

.meas tran vdout0_10ck1280 FIND v(dout0_10) AT=1290.05n

.meas tran vdout0_11ck1280 FIND v(dout0_11) AT=1290.05n

.meas tran vdout0_12ck1280 FIND v(dout0_12) AT=1290.05n

.meas tran vdout0_13ck1280 FIND v(dout0_13) AT=1290.05n

.meas tran vdout0_14ck1280 FIND v(dout0_14) AT=1290.05n

.meas tran vdout0_15ck1280 FIND v(dout0_15) AT=1290.05n

.meas tran vdout0_16ck1280 FIND v(dout0_16) AT=1290.05n

.meas tran vdout0_17ck1280 FIND v(dout0_17) AT=1290.05n

.meas tran vdout0_18ck1280 FIND v(dout0_18) AT=1290.05n

.meas tran vdout0_19ck1280 FIND v(dout0_19) AT=1290.05n

.meas tran vdout0_20ck1280 FIND v(dout0_20) AT=1290.05n

.meas tran vdout0_21ck1280 FIND v(dout0_21) AT=1290.05n

.meas tran vdout0_22ck1280 FIND v(dout0_22) AT=1290.05n

.meas tran vdout0_23ck1280 FIND v(dout0_23) AT=1290.05n

.meas tran vdout0_24ck1280 FIND v(dout0_24) AT=1290.05n

.meas tran vdout0_25ck1280 FIND v(dout0_25) AT=1290.05n

.meas tran vdout0_26ck1280 FIND v(dout0_26) AT=1290.05n

.meas tran vdout0_27ck1280 FIND v(dout0_27) AT=1290.05n

.meas tran vdout0_28ck1280 FIND v(dout0_28) AT=1290.05n

.meas tran vdout0_29ck1280 FIND v(dout0_29) AT=1290.05n

.meas tran vdout0_30ck1280 FIND v(dout0_30) AT=1290.05n

.meas tran vdout0_31ck1280 FIND v(dout0_31) AT=1290.05n

.meas tran vdout0_32ck1280 FIND v(dout0_32) AT=1290.05n

.meas tran vdout0_33ck1280 FIND v(dout0_33) AT=1290.05n

.meas tran vdout0_34ck1280 FIND v(dout0_34) AT=1290.05n

.meas tran vdout0_35ck1280 FIND v(dout0_35) AT=1290.05n

.meas tran vdout0_36ck1280 FIND v(dout0_36) AT=1290.05n

.meas tran vdout0_37ck1280 FIND v(dout0_37) AT=1290.05n

.meas tran vdout0_38ck1280 FIND v(dout0_38) AT=1290.05n

.meas tran vdout0_39ck1280 FIND v(dout0_39) AT=1290.05n

.meas tran vdout0_40ck1280 FIND v(dout0_40) AT=1290.05n

.meas tran vdout0_41ck1280 FIND v(dout0_41) AT=1290.05n

.meas tran vdout0_42ck1280 FIND v(dout0_42) AT=1290.05n

.meas tran vdout0_43ck1280 FIND v(dout0_43) AT=1290.05n

.meas tran vdout0_44ck1280 FIND v(dout0_44) AT=1290.05n

.meas tran vdout0_45ck1280 FIND v(dout0_45) AT=1290.05n

.meas tran vdout0_46ck1280 FIND v(dout0_46) AT=1290.05n

.meas tran vdout0_47ck1280 FIND v(dout0_47) AT=1290.05n

.meas tran vdout0_48ck1280 FIND v(dout0_48) AT=1290.05n

.meas tran vdout0_49ck1280 FIND v(dout0_49) AT=1290.05n

.meas tran vdout0_50ck1280 FIND v(dout0_50) AT=1290.05n

.meas tran vdout0_51ck1280 FIND v(dout0_51) AT=1290.05n

.meas tran vdout0_52ck1280 FIND v(dout0_52) AT=1290.05n

.meas tran vdout0_53ck1280 FIND v(dout0_53) AT=1290.05n

.meas tran vdout0_54ck1280 FIND v(dout0_54) AT=1290.05n

.meas tran vdout0_55ck1280 FIND v(dout0_55) AT=1290.05n

.meas tran vdout0_56ck1280 FIND v(dout0_56) AT=1290.05n

.meas tran vdout0_57ck1280 FIND v(dout0_57) AT=1290.05n

.meas tran vdout0_58ck1280 FIND v(dout0_58) AT=1290.05n

.meas tran vdout0_59ck1280 FIND v(dout0_59) AT=1290.05n

.meas tran vdout0_60ck1280 FIND v(dout0_60) AT=1290.05n

.meas tran vdout0_61ck1280 FIND v(dout0_61) AT=1290.05n

.meas tran vdout0_62ck1280 FIND v(dout0_62) AT=1290.05n

.meas tran vdout0_63ck1280 FIND v(dout0_63) AT=1290.05n

.meas tran vdout0_64ck1280 FIND v(dout0_64) AT=1290.05n

.meas tran vdout0_0ck1290 FIND v(dout0_0) AT=1300.05n

.meas tran vdout0_1ck1290 FIND v(dout0_1) AT=1300.05n

.meas tran vdout0_2ck1290 FIND v(dout0_2) AT=1300.05n

.meas tran vdout0_3ck1290 FIND v(dout0_3) AT=1300.05n

.meas tran vdout0_4ck1290 FIND v(dout0_4) AT=1300.05n

.meas tran vdout0_5ck1290 FIND v(dout0_5) AT=1300.05n

.meas tran vdout0_6ck1290 FIND v(dout0_6) AT=1300.05n

.meas tran vdout0_7ck1290 FIND v(dout0_7) AT=1300.05n

.meas tran vdout0_8ck1290 FIND v(dout0_8) AT=1300.05n

.meas tran vdout0_9ck1290 FIND v(dout0_9) AT=1300.05n

.meas tran vdout0_10ck1290 FIND v(dout0_10) AT=1300.05n

.meas tran vdout0_11ck1290 FIND v(dout0_11) AT=1300.05n

.meas tran vdout0_12ck1290 FIND v(dout0_12) AT=1300.05n

.meas tran vdout0_13ck1290 FIND v(dout0_13) AT=1300.05n

.meas tran vdout0_14ck1290 FIND v(dout0_14) AT=1300.05n

.meas tran vdout0_15ck1290 FIND v(dout0_15) AT=1300.05n

.meas tran vdout0_16ck1290 FIND v(dout0_16) AT=1300.05n

.meas tran vdout0_17ck1290 FIND v(dout0_17) AT=1300.05n

.meas tran vdout0_18ck1290 FIND v(dout0_18) AT=1300.05n

.meas tran vdout0_19ck1290 FIND v(dout0_19) AT=1300.05n

.meas tran vdout0_20ck1290 FIND v(dout0_20) AT=1300.05n

.meas tran vdout0_21ck1290 FIND v(dout0_21) AT=1300.05n

.meas tran vdout0_22ck1290 FIND v(dout0_22) AT=1300.05n

.meas tran vdout0_23ck1290 FIND v(dout0_23) AT=1300.05n

.meas tran vdout0_24ck1290 FIND v(dout0_24) AT=1300.05n

.meas tran vdout0_25ck1290 FIND v(dout0_25) AT=1300.05n

.meas tran vdout0_26ck1290 FIND v(dout0_26) AT=1300.05n

.meas tran vdout0_27ck1290 FIND v(dout0_27) AT=1300.05n

.meas tran vdout0_28ck1290 FIND v(dout0_28) AT=1300.05n

.meas tran vdout0_29ck1290 FIND v(dout0_29) AT=1300.05n

.meas tran vdout0_30ck1290 FIND v(dout0_30) AT=1300.05n

.meas tran vdout0_31ck1290 FIND v(dout0_31) AT=1300.05n

.meas tran vdout0_32ck1290 FIND v(dout0_32) AT=1300.05n

.meas tran vdout0_33ck1290 FIND v(dout0_33) AT=1300.05n

.meas tran vdout0_34ck1290 FIND v(dout0_34) AT=1300.05n

.meas tran vdout0_35ck1290 FIND v(dout0_35) AT=1300.05n

.meas tran vdout0_36ck1290 FIND v(dout0_36) AT=1300.05n

.meas tran vdout0_37ck1290 FIND v(dout0_37) AT=1300.05n

.meas tran vdout0_38ck1290 FIND v(dout0_38) AT=1300.05n

.meas tran vdout0_39ck1290 FIND v(dout0_39) AT=1300.05n

.meas tran vdout0_40ck1290 FIND v(dout0_40) AT=1300.05n

.meas tran vdout0_41ck1290 FIND v(dout0_41) AT=1300.05n

.meas tran vdout0_42ck1290 FIND v(dout0_42) AT=1300.05n

.meas tran vdout0_43ck1290 FIND v(dout0_43) AT=1300.05n

.meas tran vdout0_44ck1290 FIND v(dout0_44) AT=1300.05n

.meas tran vdout0_45ck1290 FIND v(dout0_45) AT=1300.05n

.meas tran vdout0_46ck1290 FIND v(dout0_46) AT=1300.05n

.meas tran vdout0_47ck1290 FIND v(dout0_47) AT=1300.05n

.meas tran vdout0_48ck1290 FIND v(dout0_48) AT=1300.05n

.meas tran vdout0_49ck1290 FIND v(dout0_49) AT=1300.05n

.meas tran vdout0_50ck1290 FIND v(dout0_50) AT=1300.05n

.meas tran vdout0_51ck1290 FIND v(dout0_51) AT=1300.05n

.meas tran vdout0_52ck1290 FIND v(dout0_52) AT=1300.05n

.meas tran vdout0_53ck1290 FIND v(dout0_53) AT=1300.05n

.meas tran vdout0_54ck1290 FIND v(dout0_54) AT=1300.05n

.meas tran vdout0_55ck1290 FIND v(dout0_55) AT=1300.05n

.meas tran vdout0_56ck1290 FIND v(dout0_56) AT=1300.05n

.meas tran vdout0_57ck1290 FIND v(dout0_57) AT=1300.05n

.meas tran vdout0_58ck1290 FIND v(dout0_58) AT=1300.05n

.meas tran vdout0_59ck1290 FIND v(dout0_59) AT=1300.05n

.meas tran vdout0_60ck1290 FIND v(dout0_60) AT=1300.05n

.meas tran vdout0_61ck1290 FIND v(dout0_61) AT=1300.05n

.meas tran vdout0_62ck1290 FIND v(dout0_62) AT=1300.05n

.meas tran vdout0_63ck1290 FIND v(dout0_63) AT=1300.05n

.meas tran vdout0_64ck1290 FIND v(dout0_64) AT=1300.05n

.meas tran vdout0_0ck1300 FIND v(dout0_0) AT=1310.05n

.meas tran vdout0_1ck1300 FIND v(dout0_1) AT=1310.05n

.meas tran vdout0_2ck1300 FIND v(dout0_2) AT=1310.05n

.meas tran vdout0_3ck1300 FIND v(dout0_3) AT=1310.05n

.meas tran vdout0_4ck1300 FIND v(dout0_4) AT=1310.05n

.meas tran vdout0_5ck1300 FIND v(dout0_5) AT=1310.05n

.meas tran vdout0_6ck1300 FIND v(dout0_6) AT=1310.05n

.meas tran vdout0_7ck1300 FIND v(dout0_7) AT=1310.05n

.meas tran vdout0_8ck1300 FIND v(dout0_8) AT=1310.05n

.meas tran vdout0_9ck1300 FIND v(dout0_9) AT=1310.05n

.meas tran vdout0_10ck1300 FIND v(dout0_10) AT=1310.05n

.meas tran vdout0_11ck1300 FIND v(dout0_11) AT=1310.05n

.meas tran vdout0_12ck1300 FIND v(dout0_12) AT=1310.05n

.meas tran vdout0_13ck1300 FIND v(dout0_13) AT=1310.05n

.meas tran vdout0_14ck1300 FIND v(dout0_14) AT=1310.05n

.meas tran vdout0_15ck1300 FIND v(dout0_15) AT=1310.05n

.meas tran vdout0_16ck1300 FIND v(dout0_16) AT=1310.05n

.meas tran vdout0_17ck1300 FIND v(dout0_17) AT=1310.05n

.meas tran vdout0_18ck1300 FIND v(dout0_18) AT=1310.05n

.meas tran vdout0_19ck1300 FIND v(dout0_19) AT=1310.05n

.meas tran vdout0_20ck1300 FIND v(dout0_20) AT=1310.05n

.meas tran vdout0_21ck1300 FIND v(dout0_21) AT=1310.05n

.meas tran vdout0_22ck1300 FIND v(dout0_22) AT=1310.05n

.meas tran vdout0_23ck1300 FIND v(dout0_23) AT=1310.05n

.meas tran vdout0_24ck1300 FIND v(dout0_24) AT=1310.05n

.meas tran vdout0_25ck1300 FIND v(dout0_25) AT=1310.05n

.meas tran vdout0_26ck1300 FIND v(dout0_26) AT=1310.05n

.meas tran vdout0_27ck1300 FIND v(dout0_27) AT=1310.05n

.meas tran vdout0_28ck1300 FIND v(dout0_28) AT=1310.05n

.meas tran vdout0_29ck1300 FIND v(dout0_29) AT=1310.05n

.meas tran vdout0_30ck1300 FIND v(dout0_30) AT=1310.05n

.meas tran vdout0_31ck1300 FIND v(dout0_31) AT=1310.05n

.meas tran vdout0_32ck1300 FIND v(dout0_32) AT=1310.05n

.meas tran vdout0_33ck1300 FIND v(dout0_33) AT=1310.05n

.meas tran vdout0_34ck1300 FIND v(dout0_34) AT=1310.05n

.meas tran vdout0_35ck1300 FIND v(dout0_35) AT=1310.05n

.meas tran vdout0_36ck1300 FIND v(dout0_36) AT=1310.05n

.meas tran vdout0_37ck1300 FIND v(dout0_37) AT=1310.05n

.meas tran vdout0_38ck1300 FIND v(dout0_38) AT=1310.05n

.meas tran vdout0_39ck1300 FIND v(dout0_39) AT=1310.05n

.meas tran vdout0_40ck1300 FIND v(dout0_40) AT=1310.05n

.meas tran vdout0_41ck1300 FIND v(dout0_41) AT=1310.05n

.meas tran vdout0_42ck1300 FIND v(dout0_42) AT=1310.05n

.meas tran vdout0_43ck1300 FIND v(dout0_43) AT=1310.05n

.meas tran vdout0_44ck1300 FIND v(dout0_44) AT=1310.05n

.meas tran vdout0_45ck1300 FIND v(dout0_45) AT=1310.05n

.meas tran vdout0_46ck1300 FIND v(dout0_46) AT=1310.05n

.meas tran vdout0_47ck1300 FIND v(dout0_47) AT=1310.05n

.meas tran vdout0_48ck1300 FIND v(dout0_48) AT=1310.05n

.meas tran vdout0_49ck1300 FIND v(dout0_49) AT=1310.05n

.meas tran vdout0_50ck1300 FIND v(dout0_50) AT=1310.05n

.meas tran vdout0_51ck1300 FIND v(dout0_51) AT=1310.05n

.meas tran vdout0_52ck1300 FIND v(dout0_52) AT=1310.05n

.meas tran vdout0_53ck1300 FIND v(dout0_53) AT=1310.05n

.meas tran vdout0_54ck1300 FIND v(dout0_54) AT=1310.05n

.meas tran vdout0_55ck1300 FIND v(dout0_55) AT=1310.05n

.meas tran vdout0_56ck1300 FIND v(dout0_56) AT=1310.05n

.meas tran vdout0_57ck1300 FIND v(dout0_57) AT=1310.05n

.meas tran vdout0_58ck1300 FIND v(dout0_58) AT=1310.05n

.meas tran vdout0_59ck1300 FIND v(dout0_59) AT=1310.05n

.meas tran vdout0_60ck1300 FIND v(dout0_60) AT=1310.05n

.meas tran vdout0_61ck1300 FIND v(dout0_61) AT=1310.05n

.meas tran vdout0_62ck1300 FIND v(dout0_62) AT=1310.05n

.meas tran vdout0_63ck1300 FIND v(dout0_63) AT=1310.05n

.meas tran vdout0_64ck1300 FIND v(dout0_64) AT=1310.05n

.meas tran vdout0_0ck1310 FIND v(dout0_0) AT=1320.05n

.meas tran vdout0_1ck1310 FIND v(dout0_1) AT=1320.05n

.meas tran vdout0_2ck1310 FIND v(dout0_2) AT=1320.05n

.meas tran vdout0_3ck1310 FIND v(dout0_3) AT=1320.05n

.meas tran vdout0_4ck1310 FIND v(dout0_4) AT=1320.05n

.meas tran vdout0_5ck1310 FIND v(dout0_5) AT=1320.05n

.meas tran vdout0_6ck1310 FIND v(dout0_6) AT=1320.05n

.meas tran vdout0_7ck1310 FIND v(dout0_7) AT=1320.05n

.meas tran vdout0_8ck1310 FIND v(dout0_8) AT=1320.05n

.meas tran vdout0_9ck1310 FIND v(dout0_9) AT=1320.05n

.meas tran vdout0_10ck1310 FIND v(dout0_10) AT=1320.05n

.meas tran vdout0_11ck1310 FIND v(dout0_11) AT=1320.05n

.meas tran vdout0_12ck1310 FIND v(dout0_12) AT=1320.05n

.meas tran vdout0_13ck1310 FIND v(dout0_13) AT=1320.05n

.meas tran vdout0_14ck1310 FIND v(dout0_14) AT=1320.05n

.meas tran vdout0_15ck1310 FIND v(dout0_15) AT=1320.05n

.meas tran vdout0_16ck1310 FIND v(dout0_16) AT=1320.05n

.meas tran vdout0_17ck1310 FIND v(dout0_17) AT=1320.05n

.meas tran vdout0_18ck1310 FIND v(dout0_18) AT=1320.05n

.meas tran vdout0_19ck1310 FIND v(dout0_19) AT=1320.05n

.meas tran vdout0_20ck1310 FIND v(dout0_20) AT=1320.05n

.meas tran vdout0_21ck1310 FIND v(dout0_21) AT=1320.05n

.meas tran vdout0_22ck1310 FIND v(dout0_22) AT=1320.05n

.meas tran vdout0_23ck1310 FIND v(dout0_23) AT=1320.05n

.meas tran vdout0_24ck1310 FIND v(dout0_24) AT=1320.05n

.meas tran vdout0_25ck1310 FIND v(dout0_25) AT=1320.05n

.meas tran vdout0_26ck1310 FIND v(dout0_26) AT=1320.05n

.meas tran vdout0_27ck1310 FIND v(dout0_27) AT=1320.05n

.meas tran vdout0_28ck1310 FIND v(dout0_28) AT=1320.05n

.meas tran vdout0_29ck1310 FIND v(dout0_29) AT=1320.05n

.meas tran vdout0_30ck1310 FIND v(dout0_30) AT=1320.05n

.meas tran vdout0_31ck1310 FIND v(dout0_31) AT=1320.05n

.meas tran vdout0_32ck1310 FIND v(dout0_32) AT=1320.05n

.meas tran vdout0_33ck1310 FIND v(dout0_33) AT=1320.05n

.meas tran vdout0_34ck1310 FIND v(dout0_34) AT=1320.05n

.meas tran vdout0_35ck1310 FIND v(dout0_35) AT=1320.05n

.meas tran vdout0_36ck1310 FIND v(dout0_36) AT=1320.05n

.meas tran vdout0_37ck1310 FIND v(dout0_37) AT=1320.05n

.meas tran vdout0_38ck1310 FIND v(dout0_38) AT=1320.05n

.meas tran vdout0_39ck1310 FIND v(dout0_39) AT=1320.05n

.meas tran vdout0_40ck1310 FIND v(dout0_40) AT=1320.05n

.meas tran vdout0_41ck1310 FIND v(dout0_41) AT=1320.05n

.meas tran vdout0_42ck1310 FIND v(dout0_42) AT=1320.05n

.meas tran vdout0_43ck1310 FIND v(dout0_43) AT=1320.05n

.meas tran vdout0_44ck1310 FIND v(dout0_44) AT=1320.05n

.meas tran vdout0_45ck1310 FIND v(dout0_45) AT=1320.05n

.meas tran vdout0_46ck1310 FIND v(dout0_46) AT=1320.05n

.meas tran vdout0_47ck1310 FIND v(dout0_47) AT=1320.05n

.meas tran vdout0_48ck1310 FIND v(dout0_48) AT=1320.05n

.meas tran vdout0_49ck1310 FIND v(dout0_49) AT=1320.05n

.meas tran vdout0_50ck1310 FIND v(dout0_50) AT=1320.05n

.meas tran vdout0_51ck1310 FIND v(dout0_51) AT=1320.05n

.meas tran vdout0_52ck1310 FIND v(dout0_52) AT=1320.05n

.meas tran vdout0_53ck1310 FIND v(dout0_53) AT=1320.05n

.meas tran vdout0_54ck1310 FIND v(dout0_54) AT=1320.05n

.meas tran vdout0_55ck1310 FIND v(dout0_55) AT=1320.05n

.meas tran vdout0_56ck1310 FIND v(dout0_56) AT=1320.05n

.meas tran vdout0_57ck1310 FIND v(dout0_57) AT=1320.05n

.meas tran vdout0_58ck1310 FIND v(dout0_58) AT=1320.05n

.meas tran vdout0_59ck1310 FIND v(dout0_59) AT=1320.05n

.meas tran vdout0_60ck1310 FIND v(dout0_60) AT=1320.05n

.meas tran vdout0_61ck1310 FIND v(dout0_61) AT=1320.05n

.meas tran vdout0_62ck1310 FIND v(dout0_62) AT=1320.05n

.meas tran vdout0_63ck1310 FIND v(dout0_63) AT=1320.05n

.meas tran vdout0_64ck1310 FIND v(dout0_64) AT=1320.05n

.meas tran vdout0_0ck1350 FIND v(dout0_0) AT=1360.05n

.meas tran vdout0_1ck1350 FIND v(dout0_1) AT=1360.05n

.meas tran vdout0_2ck1350 FIND v(dout0_2) AT=1360.05n

.meas tran vdout0_3ck1350 FIND v(dout0_3) AT=1360.05n

.meas tran vdout0_4ck1350 FIND v(dout0_4) AT=1360.05n

.meas tran vdout0_5ck1350 FIND v(dout0_5) AT=1360.05n

.meas tran vdout0_6ck1350 FIND v(dout0_6) AT=1360.05n

.meas tran vdout0_7ck1350 FIND v(dout0_7) AT=1360.05n

.meas tran vdout0_8ck1350 FIND v(dout0_8) AT=1360.05n

.meas tran vdout0_9ck1350 FIND v(dout0_9) AT=1360.05n

.meas tran vdout0_10ck1350 FIND v(dout0_10) AT=1360.05n

.meas tran vdout0_11ck1350 FIND v(dout0_11) AT=1360.05n

.meas tran vdout0_12ck1350 FIND v(dout0_12) AT=1360.05n

.meas tran vdout0_13ck1350 FIND v(dout0_13) AT=1360.05n

.meas tran vdout0_14ck1350 FIND v(dout0_14) AT=1360.05n

.meas tran vdout0_15ck1350 FIND v(dout0_15) AT=1360.05n

.meas tran vdout0_16ck1350 FIND v(dout0_16) AT=1360.05n

.meas tran vdout0_17ck1350 FIND v(dout0_17) AT=1360.05n

.meas tran vdout0_18ck1350 FIND v(dout0_18) AT=1360.05n

.meas tran vdout0_19ck1350 FIND v(dout0_19) AT=1360.05n

.meas tran vdout0_20ck1350 FIND v(dout0_20) AT=1360.05n

.meas tran vdout0_21ck1350 FIND v(dout0_21) AT=1360.05n

.meas tran vdout0_22ck1350 FIND v(dout0_22) AT=1360.05n

.meas tran vdout0_23ck1350 FIND v(dout0_23) AT=1360.05n

.meas tran vdout0_24ck1350 FIND v(dout0_24) AT=1360.05n

.meas tran vdout0_25ck1350 FIND v(dout0_25) AT=1360.05n

.meas tran vdout0_26ck1350 FIND v(dout0_26) AT=1360.05n

.meas tran vdout0_27ck1350 FIND v(dout0_27) AT=1360.05n

.meas tran vdout0_28ck1350 FIND v(dout0_28) AT=1360.05n

.meas tran vdout0_29ck1350 FIND v(dout0_29) AT=1360.05n

.meas tran vdout0_30ck1350 FIND v(dout0_30) AT=1360.05n

.meas tran vdout0_31ck1350 FIND v(dout0_31) AT=1360.05n

.meas tran vdout0_32ck1350 FIND v(dout0_32) AT=1360.05n

.meas tran vdout0_33ck1350 FIND v(dout0_33) AT=1360.05n

.meas tran vdout0_34ck1350 FIND v(dout0_34) AT=1360.05n

.meas tran vdout0_35ck1350 FIND v(dout0_35) AT=1360.05n

.meas tran vdout0_36ck1350 FIND v(dout0_36) AT=1360.05n

.meas tran vdout0_37ck1350 FIND v(dout0_37) AT=1360.05n

.meas tran vdout0_38ck1350 FIND v(dout0_38) AT=1360.05n

.meas tran vdout0_39ck1350 FIND v(dout0_39) AT=1360.05n

.meas tran vdout0_40ck1350 FIND v(dout0_40) AT=1360.05n

.meas tran vdout0_41ck1350 FIND v(dout0_41) AT=1360.05n

.meas tran vdout0_42ck1350 FIND v(dout0_42) AT=1360.05n

.meas tran vdout0_43ck1350 FIND v(dout0_43) AT=1360.05n

.meas tran vdout0_44ck1350 FIND v(dout0_44) AT=1360.05n

.meas tran vdout0_45ck1350 FIND v(dout0_45) AT=1360.05n

.meas tran vdout0_46ck1350 FIND v(dout0_46) AT=1360.05n

.meas tran vdout0_47ck1350 FIND v(dout0_47) AT=1360.05n

.meas tran vdout0_48ck1350 FIND v(dout0_48) AT=1360.05n

.meas tran vdout0_49ck1350 FIND v(dout0_49) AT=1360.05n

.meas tran vdout0_50ck1350 FIND v(dout0_50) AT=1360.05n

.meas tran vdout0_51ck1350 FIND v(dout0_51) AT=1360.05n

.meas tran vdout0_52ck1350 FIND v(dout0_52) AT=1360.05n

.meas tran vdout0_53ck1350 FIND v(dout0_53) AT=1360.05n

.meas tran vdout0_54ck1350 FIND v(dout0_54) AT=1360.05n

.meas tran vdout0_55ck1350 FIND v(dout0_55) AT=1360.05n

.meas tran vdout0_56ck1350 FIND v(dout0_56) AT=1360.05n

.meas tran vdout0_57ck1350 FIND v(dout0_57) AT=1360.05n

.meas tran vdout0_58ck1350 FIND v(dout0_58) AT=1360.05n

.meas tran vdout0_59ck1350 FIND v(dout0_59) AT=1360.05n

.meas tran vdout0_60ck1350 FIND v(dout0_60) AT=1360.05n

.meas tran vdout0_61ck1350 FIND v(dout0_61) AT=1360.05n

.meas tran vdout0_62ck1350 FIND v(dout0_62) AT=1360.05n

.meas tran vdout0_63ck1350 FIND v(dout0_63) AT=1360.05n

.meas tran vdout0_64ck1350 FIND v(dout0_64) AT=1360.05n

.meas tran vdout0_0ck1360 FIND v(dout0_0) AT=1370.05n

.meas tran vdout0_1ck1360 FIND v(dout0_1) AT=1370.05n

.meas tran vdout0_2ck1360 FIND v(dout0_2) AT=1370.05n

.meas tran vdout0_3ck1360 FIND v(dout0_3) AT=1370.05n

.meas tran vdout0_4ck1360 FIND v(dout0_4) AT=1370.05n

.meas tran vdout0_5ck1360 FIND v(dout0_5) AT=1370.05n

.meas tran vdout0_6ck1360 FIND v(dout0_6) AT=1370.05n

.meas tran vdout0_7ck1360 FIND v(dout0_7) AT=1370.05n

.meas tran vdout0_8ck1360 FIND v(dout0_8) AT=1370.05n

.meas tran vdout0_9ck1360 FIND v(dout0_9) AT=1370.05n

.meas tran vdout0_10ck1360 FIND v(dout0_10) AT=1370.05n

.meas tran vdout0_11ck1360 FIND v(dout0_11) AT=1370.05n

.meas tran vdout0_12ck1360 FIND v(dout0_12) AT=1370.05n

.meas tran vdout0_13ck1360 FIND v(dout0_13) AT=1370.05n

.meas tran vdout0_14ck1360 FIND v(dout0_14) AT=1370.05n

.meas tran vdout0_15ck1360 FIND v(dout0_15) AT=1370.05n

.meas tran vdout0_16ck1360 FIND v(dout0_16) AT=1370.05n

.meas tran vdout0_17ck1360 FIND v(dout0_17) AT=1370.05n

.meas tran vdout0_18ck1360 FIND v(dout0_18) AT=1370.05n

.meas tran vdout0_19ck1360 FIND v(dout0_19) AT=1370.05n

.meas tran vdout0_20ck1360 FIND v(dout0_20) AT=1370.05n

.meas tran vdout0_21ck1360 FIND v(dout0_21) AT=1370.05n

.meas tran vdout0_22ck1360 FIND v(dout0_22) AT=1370.05n

.meas tran vdout0_23ck1360 FIND v(dout0_23) AT=1370.05n

.meas tran vdout0_24ck1360 FIND v(dout0_24) AT=1370.05n

.meas tran vdout0_25ck1360 FIND v(dout0_25) AT=1370.05n

.meas tran vdout0_26ck1360 FIND v(dout0_26) AT=1370.05n

.meas tran vdout0_27ck1360 FIND v(dout0_27) AT=1370.05n

.meas tran vdout0_28ck1360 FIND v(dout0_28) AT=1370.05n

.meas tran vdout0_29ck1360 FIND v(dout0_29) AT=1370.05n

.meas tran vdout0_30ck1360 FIND v(dout0_30) AT=1370.05n

.meas tran vdout0_31ck1360 FIND v(dout0_31) AT=1370.05n

.meas tran vdout0_32ck1360 FIND v(dout0_32) AT=1370.05n

.meas tran vdout0_33ck1360 FIND v(dout0_33) AT=1370.05n

.meas tran vdout0_34ck1360 FIND v(dout0_34) AT=1370.05n

.meas tran vdout0_35ck1360 FIND v(dout0_35) AT=1370.05n

.meas tran vdout0_36ck1360 FIND v(dout0_36) AT=1370.05n

.meas tran vdout0_37ck1360 FIND v(dout0_37) AT=1370.05n

.meas tran vdout0_38ck1360 FIND v(dout0_38) AT=1370.05n

.meas tran vdout0_39ck1360 FIND v(dout0_39) AT=1370.05n

.meas tran vdout0_40ck1360 FIND v(dout0_40) AT=1370.05n

.meas tran vdout0_41ck1360 FIND v(dout0_41) AT=1370.05n

.meas tran vdout0_42ck1360 FIND v(dout0_42) AT=1370.05n

.meas tran vdout0_43ck1360 FIND v(dout0_43) AT=1370.05n

.meas tran vdout0_44ck1360 FIND v(dout0_44) AT=1370.05n

.meas tran vdout0_45ck1360 FIND v(dout0_45) AT=1370.05n

.meas tran vdout0_46ck1360 FIND v(dout0_46) AT=1370.05n

.meas tran vdout0_47ck1360 FIND v(dout0_47) AT=1370.05n

.meas tran vdout0_48ck1360 FIND v(dout0_48) AT=1370.05n

.meas tran vdout0_49ck1360 FIND v(dout0_49) AT=1370.05n

.meas tran vdout0_50ck1360 FIND v(dout0_50) AT=1370.05n

.meas tran vdout0_51ck1360 FIND v(dout0_51) AT=1370.05n

.meas tran vdout0_52ck1360 FIND v(dout0_52) AT=1370.05n

.meas tran vdout0_53ck1360 FIND v(dout0_53) AT=1370.05n

.meas tran vdout0_54ck1360 FIND v(dout0_54) AT=1370.05n

.meas tran vdout0_55ck1360 FIND v(dout0_55) AT=1370.05n

.meas tran vdout0_56ck1360 FIND v(dout0_56) AT=1370.05n

.meas tran vdout0_57ck1360 FIND v(dout0_57) AT=1370.05n

.meas tran vdout0_58ck1360 FIND v(dout0_58) AT=1370.05n

.meas tran vdout0_59ck1360 FIND v(dout0_59) AT=1370.05n

.meas tran vdout0_60ck1360 FIND v(dout0_60) AT=1370.05n

.meas tran vdout0_61ck1360 FIND v(dout0_61) AT=1370.05n

.meas tran vdout0_62ck1360 FIND v(dout0_62) AT=1370.05n

.meas tran vdout0_63ck1360 FIND v(dout0_63) AT=1370.05n

.meas tran vdout0_64ck1360 FIND v(dout0_64) AT=1370.05n

.meas tran vdout0_0ck1440 FIND v(dout0_0) AT=1450.05n

.meas tran vdout0_1ck1440 FIND v(dout0_1) AT=1450.05n

.meas tran vdout0_2ck1440 FIND v(dout0_2) AT=1450.05n

.meas tran vdout0_3ck1440 FIND v(dout0_3) AT=1450.05n

.meas tran vdout0_4ck1440 FIND v(dout0_4) AT=1450.05n

.meas tran vdout0_5ck1440 FIND v(dout0_5) AT=1450.05n

.meas tran vdout0_6ck1440 FIND v(dout0_6) AT=1450.05n

.meas tran vdout0_7ck1440 FIND v(dout0_7) AT=1450.05n

.meas tran vdout0_8ck1440 FIND v(dout0_8) AT=1450.05n

.meas tran vdout0_9ck1440 FIND v(dout0_9) AT=1450.05n

.meas tran vdout0_10ck1440 FIND v(dout0_10) AT=1450.05n

.meas tran vdout0_11ck1440 FIND v(dout0_11) AT=1450.05n

.meas tran vdout0_12ck1440 FIND v(dout0_12) AT=1450.05n

.meas tran vdout0_13ck1440 FIND v(dout0_13) AT=1450.05n

.meas tran vdout0_14ck1440 FIND v(dout0_14) AT=1450.05n

.meas tran vdout0_15ck1440 FIND v(dout0_15) AT=1450.05n

.meas tran vdout0_16ck1440 FIND v(dout0_16) AT=1450.05n

.meas tran vdout0_17ck1440 FIND v(dout0_17) AT=1450.05n

.meas tran vdout0_18ck1440 FIND v(dout0_18) AT=1450.05n

.meas tran vdout0_19ck1440 FIND v(dout0_19) AT=1450.05n

.meas tran vdout0_20ck1440 FIND v(dout0_20) AT=1450.05n

.meas tran vdout0_21ck1440 FIND v(dout0_21) AT=1450.05n

.meas tran vdout0_22ck1440 FIND v(dout0_22) AT=1450.05n

.meas tran vdout0_23ck1440 FIND v(dout0_23) AT=1450.05n

.meas tran vdout0_24ck1440 FIND v(dout0_24) AT=1450.05n

.meas tran vdout0_25ck1440 FIND v(dout0_25) AT=1450.05n

.meas tran vdout0_26ck1440 FIND v(dout0_26) AT=1450.05n

.meas tran vdout0_27ck1440 FIND v(dout0_27) AT=1450.05n

.meas tran vdout0_28ck1440 FIND v(dout0_28) AT=1450.05n

.meas tran vdout0_29ck1440 FIND v(dout0_29) AT=1450.05n

.meas tran vdout0_30ck1440 FIND v(dout0_30) AT=1450.05n

.meas tran vdout0_31ck1440 FIND v(dout0_31) AT=1450.05n

.meas tran vdout0_32ck1440 FIND v(dout0_32) AT=1450.05n

.meas tran vdout0_33ck1440 FIND v(dout0_33) AT=1450.05n

.meas tran vdout0_34ck1440 FIND v(dout0_34) AT=1450.05n

.meas tran vdout0_35ck1440 FIND v(dout0_35) AT=1450.05n

.meas tran vdout0_36ck1440 FIND v(dout0_36) AT=1450.05n

.meas tran vdout0_37ck1440 FIND v(dout0_37) AT=1450.05n

.meas tran vdout0_38ck1440 FIND v(dout0_38) AT=1450.05n

.meas tran vdout0_39ck1440 FIND v(dout0_39) AT=1450.05n

.meas tran vdout0_40ck1440 FIND v(dout0_40) AT=1450.05n

.meas tran vdout0_41ck1440 FIND v(dout0_41) AT=1450.05n

.meas tran vdout0_42ck1440 FIND v(dout0_42) AT=1450.05n

.meas tran vdout0_43ck1440 FIND v(dout0_43) AT=1450.05n

.meas tran vdout0_44ck1440 FIND v(dout0_44) AT=1450.05n

.meas tran vdout0_45ck1440 FIND v(dout0_45) AT=1450.05n

.meas tran vdout0_46ck1440 FIND v(dout0_46) AT=1450.05n

.meas tran vdout0_47ck1440 FIND v(dout0_47) AT=1450.05n

.meas tran vdout0_48ck1440 FIND v(dout0_48) AT=1450.05n

.meas tran vdout0_49ck1440 FIND v(dout0_49) AT=1450.05n

.meas tran vdout0_50ck1440 FIND v(dout0_50) AT=1450.05n

.meas tran vdout0_51ck1440 FIND v(dout0_51) AT=1450.05n

.meas tran vdout0_52ck1440 FIND v(dout0_52) AT=1450.05n

.meas tran vdout0_53ck1440 FIND v(dout0_53) AT=1450.05n

.meas tran vdout0_54ck1440 FIND v(dout0_54) AT=1450.05n

.meas tran vdout0_55ck1440 FIND v(dout0_55) AT=1450.05n

.meas tran vdout0_56ck1440 FIND v(dout0_56) AT=1450.05n

.meas tran vdout0_57ck1440 FIND v(dout0_57) AT=1450.05n

.meas tran vdout0_58ck1440 FIND v(dout0_58) AT=1450.05n

.meas tran vdout0_59ck1440 FIND v(dout0_59) AT=1450.05n

.meas tran vdout0_60ck1440 FIND v(dout0_60) AT=1450.05n

.meas tran vdout0_61ck1440 FIND v(dout0_61) AT=1450.05n

.meas tran vdout0_62ck1440 FIND v(dout0_62) AT=1450.05n

.meas tran vdout0_63ck1440 FIND v(dout0_63) AT=1450.05n

.meas tran vdout0_64ck1440 FIND v(dout0_64) AT=1450.05n

.meas tran vdout0_0ck1460 FIND v(dout0_0) AT=1470.05n

.meas tran vdout0_1ck1460 FIND v(dout0_1) AT=1470.05n

.meas tran vdout0_2ck1460 FIND v(dout0_2) AT=1470.05n

.meas tran vdout0_3ck1460 FIND v(dout0_3) AT=1470.05n

.meas tran vdout0_4ck1460 FIND v(dout0_4) AT=1470.05n

.meas tran vdout0_5ck1460 FIND v(dout0_5) AT=1470.05n

.meas tran vdout0_6ck1460 FIND v(dout0_6) AT=1470.05n

.meas tran vdout0_7ck1460 FIND v(dout0_7) AT=1470.05n

.meas tran vdout0_8ck1460 FIND v(dout0_8) AT=1470.05n

.meas tran vdout0_9ck1460 FIND v(dout0_9) AT=1470.05n

.meas tran vdout0_10ck1460 FIND v(dout0_10) AT=1470.05n

.meas tran vdout0_11ck1460 FIND v(dout0_11) AT=1470.05n

.meas tran vdout0_12ck1460 FIND v(dout0_12) AT=1470.05n

.meas tran vdout0_13ck1460 FIND v(dout0_13) AT=1470.05n

.meas tran vdout0_14ck1460 FIND v(dout0_14) AT=1470.05n

.meas tran vdout0_15ck1460 FIND v(dout0_15) AT=1470.05n

.meas tran vdout0_16ck1460 FIND v(dout0_16) AT=1470.05n

.meas tran vdout0_17ck1460 FIND v(dout0_17) AT=1470.05n

.meas tran vdout0_18ck1460 FIND v(dout0_18) AT=1470.05n

.meas tran vdout0_19ck1460 FIND v(dout0_19) AT=1470.05n

.meas tran vdout0_20ck1460 FIND v(dout0_20) AT=1470.05n

.meas tran vdout0_21ck1460 FIND v(dout0_21) AT=1470.05n

.meas tran vdout0_22ck1460 FIND v(dout0_22) AT=1470.05n

.meas tran vdout0_23ck1460 FIND v(dout0_23) AT=1470.05n

.meas tran vdout0_24ck1460 FIND v(dout0_24) AT=1470.05n

.meas tran vdout0_25ck1460 FIND v(dout0_25) AT=1470.05n

.meas tran vdout0_26ck1460 FIND v(dout0_26) AT=1470.05n

.meas tran vdout0_27ck1460 FIND v(dout0_27) AT=1470.05n

.meas tran vdout0_28ck1460 FIND v(dout0_28) AT=1470.05n

.meas tran vdout0_29ck1460 FIND v(dout0_29) AT=1470.05n

.meas tran vdout0_30ck1460 FIND v(dout0_30) AT=1470.05n

.meas tran vdout0_31ck1460 FIND v(dout0_31) AT=1470.05n

.meas tran vdout0_32ck1460 FIND v(dout0_32) AT=1470.05n

.meas tran vdout0_33ck1460 FIND v(dout0_33) AT=1470.05n

.meas tran vdout0_34ck1460 FIND v(dout0_34) AT=1470.05n

.meas tran vdout0_35ck1460 FIND v(dout0_35) AT=1470.05n

.meas tran vdout0_36ck1460 FIND v(dout0_36) AT=1470.05n

.meas tran vdout0_37ck1460 FIND v(dout0_37) AT=1470.05n

.meas tran vdout0_38ck1460 FIND v(dout0_38) AT=1470.05n

.meas tran vdout0_39ck1460 FIND v(dout0_39) AT=1470.05n

.meas tran vdout0_40ck1460 FIND v(dout0_40) AT=1470.05n

.meas tran vdout0_41ck1460 FIND v(dout0_41) AT=1470.05n

.meas tran vdout0_42ck1460 FIND v(dout0_42) AT=1470.05n

.meas tran vdout0_43ck1460 FIND v(dout0_43) AT=1470.05n

.meas tran vdout0_44ck1460 FIND v(dout0_44) AT=1470.05n

.meas tran vdout0_45ck1460 FIND v(dout0_45) AT=1470.05n

.meas tran vdout0_46ck1460 FIND v(dout0_46) AT=1470.05n

.meas tran vdout0_47ck1460 FIND v(dout0_47) AT=1470.05n

.meas tran vdout0_48ck1460 FIND v(dout0_48) AT=1470.05n

.meas tran vdout0_49ck1460 FIND v(dout0_49) AT=1470.05n

.meas tran vdout0_50ck1460 FIND v(dout0_50) AT=1470.05n

.meas tran vdout0_51ck1460 FIND v(dout0_51) AT=1470.05n

.meas tran vdout0_52ck1460 FIND v(dout0_52) AT=1470.05n

.meas tran vdout0_53ck1460 FIND v(dout0_53) AT=1470.05n

.meas tran vdout0_54ck1460 FIND v(dout0_54) AT=1470.05n

.meas tran vdout0_55ck1460 FIND v(dout0_55) AT=1470.05n

.meas tran vdout0_56ck1460 FIND v(dout0_56) AT=1470.05n

.meas tran vdout0_57ck1460 FIND v(dout0_57) AT=1470.05n

.meas tran vdout0_58ck1460 FIND v(dout0_58) AT=1470.05n

.meas tran vdout0_59ck1460 FIND v(dout0_59) AT=1470.05n

.meas tran vdout0_60ck1460 FIND v(dout0_60) AT=1470.05n

.meas tran vdout0_61ck1460 FIND v(dout0_61) AT=1470.05n

.meas tran vdout0_62ck1460 FIND v(dout0_62) AT=1470.05n

.meas tran vdout0_63ck1460 FIND v(dout0_63) AT=1470.05n

.meas tran vdout0_64ck1460 FIND v(dout0_64) AT=1470.05n

.meas tran vdout0_0ck1470 FIND v(dout0_0) AT=1480.05n

.meas tran vdout0_1ck1470 FIND v(dout0_1) AT=1480.05n

.meas tran vdout0_2ck1470 FIND v(dout0_2) AT=1480.05n

.meas tran vdout0_3ck1470 FIND v(dout0_3) AT=1480.05n

.meas tran vdout0_4ck1470 FIND v(dout0_4) AT=1480.05n

.meas tran vdout0_5ck1470 FIND v(dout0_5) AT=1480.05n

.meas tran vdout0_6ck1470 FIND v(dout0_6) AT=1480.05n

.meas tran vdout0_7ck1470 FIND v(dout0_7) AT=1480.05n

.meas tran vdout0_8ck1470 FIND v(dout0_8) AT=1480.05n

.meas tran vdout0_9ck1470 FIND v(dout0_9) AT=1480.05n

.meas tran vdout0_10ck1470 FIND v(dout0_10) AT=1480.05n

.meas tran vdout0_11ck1470 FIND v(dout0_11) AT=1480.05n

.meas tran vdout0_12ck1470 FIND v(dout0_12) AT=1480.05n

.meas tran vdout0_13ck1470 FIND v(dout0_13) AT=1480.05n

.meas tran vdout0_14ck1470 FIND v(dout0_14) AT=1480.05n

.meas tran vdout0_15ck1470 FIND v(dout0_15) AT=1480.05n

.meas tran vdout0_16ck1470 FIND v(dout0_16) AT=1480.05n

.meas tran vdout0_17ck1470 FIND v(dout0_17) AT=1480.05n

.meas tran vdout0_18ck1470 FIND v(dout0_18) AT=1480.05n

.meas tran vdout0_19ck1470 FIND v(dout0_19) AT=1480.05n

.meas tran vdout0_20ck1470 FIND v(dout0_20) AT=1480.05n

.meas tran vdout0_21ck1470 FIND v(dout0_21) AT=1480.05n

.meas tran vdout0_22ck1470 FIND v(dout0_22) AT=1480.05n

.meas tran vdout0_23ck1470 FIND v(dout0_23) AT=1480.05n

.meas tran vdout0_24ck1470 FIND v(dout0_24) AT=1480.05n

.meas tran vdout0_25ck1470 FIND v(dout0_25) AT=1480.05n

.meas tran vdout0_26ck1470 FIND v(dout0_26) AT=1480.05n

.meas tran vdout0_27ck1470 FIND v(dout0_27) AT=1480.05n

.meas tran vdout0_28ck1470 FIND v(dout0_28) AT=1480.05n

.meas tran vdout0_29ck1470 FIND v(dout0_29) AT=1480.05n

.meas tran vdout0_30ck1470 FIND v(dout0_30) AT=1480.05n

.meas tran vdout0_31ck1470 FIND v(dout0_31) AT=1480.05n

.meas tran vdout0_32ck1470 FIND v(dout0_32) AT=1480.05n

.meas tran vdout0_33ck1470 FIND v(dout0_33) AT=1480.05n

.meas tran vdout0_34ck1470 FIND v(dout0_34) AT=1480.05n

.meas tran vdout0_35ck1470 FIND v(dout0_35) AT=1480.05n

.meas tran vdout0_36ck1470 FIND v(dout0_36) AT=1480.05n

.meas tran vdout0_37ck1470 FIND v(dout0_37) AT=1480.05n

.meas tran vdout0_38ck1470 FIND v(dout0_38) AT=1480.05n

.meas tran vdout0_39ck1470 FIND v(dout0_39) AT=1480.05n

.meas tran vdout0_40ck1470 FIND v(dout0_40) AT=1480.05n

.meas tran vdout0_41ck1470 FIND v(dout0_41) AT=1480.05n

.meas tran vdout0_42ck1470 FIND v(dout0_42) AT=1480.05n

.meas tran vdout0_43ck1470 FIND v(dout0_43) AT=1480.05n

.meas tran vdout0_44ck1470 FIND v(dout0_44) AT=1480.05n

.meas tran vdout0_45ck1470 FIND v(dout0_45) AT=1480.05n

.meas tran vdout0_46ck1470 FIND v(dout0_46) AT=1480.05n

.meas tran vdout0_47ck1470 FIND v(dout0_47) AT=1480.05n

.meas tran vdout0_48ck1470 FIND v(dout0_48) AT=1480.05n

.meas tran vdout0_49ck1470 FIND v(dout0_49) AT=1480.05n

.meas tran vdout0_50ck1470 FIND v(dout0_50) AT=1480.05n

.meas tran vdout0_51ck1470 FIND v(dout0_51) AT=1480.05n

.meas tran vdout0_52ck1470 FIND v(dout0_52) AT=1480.05n

.meas tran vdout0_53ck1470 FIND v(dout0_53) AT=1480.05n

.meas tran vdout0_54ck1470 FIND v(dout0_54) AT=1480.05n

.meas tran vdout0_55ck1470 FIND v(dout0_55) AT=1480.05n

.meas tran vdout0_56ck1470 FIND v(dout0_56) AT=1480.05n

.meas tran vdout0_57ck1470 FIND v(dout0_57) AT=1480.05n

.meas tran vdout0_58ck1470 FIND v(dout0_58) AT=1480.05n

.meas tran vdout0_59ck1470 FIND v(dout0_59) AT=1480.05n

.meas tran vdout0_60ck1470 FIND v(dout0_60) AT=1480.05n

.meas tran vdout0_61ck1470 FIND v(dout0_61) AT=1480.05n

.meas tran vdout0_62ck1470 FIND v(dout0_62) AT=1480.05n

.meas tran vdout0_63ck1470 FIND v(dout0_63) AT=1480.05n

.meas tran vdout0_64ck1470 FIND v(dout0_64) AT=1480.05n

.meas tran vdout0_0ck1500 FIND v(dout0_0) AT=1510.05n

.meas tran vdout0_1ck1500 FIND v(dout0_1) AT=1510.05n

.meas tran vdout0_2ck1500 FIND v(dout0_2) AT=1510.05n

.meas tran vdout0_3ck1500 FIND v(dout0_3) AT=1510.05n

.meas tran vdout0_4ck1500 FIND v(dout0_4) AT=1510.05n

.meas tran vdout0_5ck1500 FIND v(dout0_5) AT=1510.05n

.meas tran vdout0_6ck1500 FIND v(dout0_6) AT=1510.05n

.meas tran vdout0_7ck1500 FIND v(dout0_7) AT=1510.05n

.meas tran vdout0_8ck1500 FIND v(dout0_8) AT=1510.05n

.meas tran vdout0_9ck1500 FIND v(dout0_9) AT=1510.05n

.meas tran vdout0_10ck1500 FIND v(dout0_10) AT=1510.05n

.meas tran vdout0_11ck1500 FIND v(dout0_11) AT=1510.05n

.meas tran vdout0_12ck1500 FIND v(dout0_12) AT=1510.05n

.meas tran vdout0_13ck1500 FIND v(dout0_13) AT=1510.05n

.meas tran vdout0_14ck1500 FIND v(dout0_14) AT=1510.05n

.meas tran vdout0_15ck1500 FIND v(dout0_15) AT=1510.05n

.meas tran vdout0_16ck1500 FIND v(dout0_16) AT=1510.05n

.meas tran vdout0_17ck1500 FIND v(dout0_17) AT=1510.05n

.meas tran vdout0_18ck1500 FIND v(dout0_18) AT=1510.05n

.meas tran vdout0_19ck1500 FIND v(dout0_19) AT=1510.05n

.meas tran vdout0_20ck1500 FIND v(dout0_20) AT=1510.05n

.meas tran vdout0_21ck1500 FIND v(dout0_21) AT=1510.05n

.meas tran vdout0_22ck1500 FIND v(dout0_22) AT=1510.05n

.meas tran vdout0_23ck1500 FIND v(dout0_23) AT=1510.05n

.meas tran vdout0_24ck1500 FIND v(dout0_24) AT=1510.05n

.meas tran vdout0_25ck1500 FIND v(dout0_25) AT=1510.05n

.meas tran vdout0_26ck1500 FIND v(dout0_26) AT=1510.05n

.meas tran vdout0_27ck1500 FIND v(dout0_27) AT=1510.05n

.meas tran vdout0_28ck1500 FIND v(dout0_28) AT=1510.05n

.meas tran vdout0_29ck1500 FIND v(dout0_29) AT=1510.05n

.meas tran vdout0_30ck1500 FIND v(dout0_30) AT=1510.05n

.meas tran vdout0_31ck1500 FIND v(dout0_31) AT=1510.05n

.meas tran vdout0_32ck1500 FIND v(dout0_32) AT=1510.05n

.meas tran vdout0_33ck1500 FIND v(dout0_33) AT=1510.05n

.meas tran vdout0_34ck1500 FIND v(dout0_34) AT=1510.05n

.meas tran vdout0_35ck1500 FIND v(dout0_35) AT=1510.05n

.meas tran vdout0_36ck1500 FIND v(dout0_36) AT=1510.05n

.meas tran vdout0_37ck1500 FIND v(dout0_37) AT=1510.05n

.meas tran vdout0_38ck1500 FIND v(dout0_38) AT=1510.05n

.meas tran vdout0_39ck1500 FIND v(dout0_39) AT=1510.05n

.meas tran vdout0_40ck1500 FIND v(dout0_40) AT=1510.05n

.meas tran vdout0_41ck1500 FIND v(dout0_41) AT=1510.05n

.meas tran vdout0_42ck1500 FIND v(dout0_42) AT=1510.05n

.meas tran vdout0_43ck1500 FIND v(dout0_43) AT=1510.05n

.meas tran vdout0_44ck1500 FIND v(dout0_44) AT=1510.05n

.meas tran vdout0_45ck1500 FIND v(dout0_45) AT=1510.05n

.meas tran vdout0_46ck1500 FIND v(dout0_46) AT=1510.05n

.meas tran vdout0_47ck1500 FIND v(dout0_47) AT=1510.05n

.meas tran vdout0_48ck1500 FIND v(dout0_48) AT=1510.05n

.meas tran vdout0_49ck1500 FIND v(dout0_49) AT=1510.05n

.meas tran vdout0_50ck1500 FIND v(dout0_50) AT=1510.05n

.meas tran vdout0_51ck1500 FIND v(dout0_51) AT=1510.05n

.meas tran vdout0_52ck1500 FIND v(dout0_52) AT=1510.05n

.meas tran vdout0_53ck1500 FIND v(dout0_53) AT=1510.05n

.meas tran vdout0_54ck1500 FIND v(dout0_54) AT=1510.05n

.meas tran vdout0_55ck1500 FIND v(dout0_55) AT=1510.05n

.meas tran vdout0_56ck1500 FIND v(dout0_56) AT=1510.05n

.meas tran vdout0_57ck1500 FIND v(dout0_57) AT=1510.05n

.meas tran vdout0_58ck1500 FIND v(dout0_58) AT=1510.05n

.meas tran vdout0_59ck1500 FIND v(dout0_59) AT=1510.05n

.meas tran vdout0_60ck1500 FIND v(dout0_60) AT=1510.05n

.meas tran vdout0_61ck1500 FIND v(dout0_61) AT=1510.05n

.meas tran vdout0_62ck1500 FIND v(dout0_62) AT=1510.05n

.meas tran vdout0_63ck1500 FIND v(dout0_63) AT=1510.05n

.meas tran vdout0_64ck1500 FIND v(dout0_64) AT=1510.05n

.meas tran vdout0_0ck1520 FIND v(dout0_0) AT=1530.05n

.meas tran vdout0_1ck1520 FIND v(dout0_1) AT=1530.05n

.meas tran vdout0_2ck1520 FIND v(dout0_2) AT=1530.05n

.meas tran vdout0_3ck1520 FIND v(dout0_3) AT=1530.05n

.meas tran vdout0_4ck1520 FIND v(dout0_4) AT=1530.05n

.meas tran vdout0_5ck1520 FIND v(dout0_5) AT=1530.05n

.meas tran vdout0_6ck1520 FIND v(dout0_6) AT=1530.05n

.meas tran vdout0_7ck1520 FIND v(dout0_7) AT=1530.05n

.meas tran vdout0_8ck1520 FIND v(dout0_8) AT=1530.05n

.meas tran vdout0_9ck1520 FIND v(dout0_9) AT=1530.05n

.meas tran vdout0_10ck1520 FIND v(dout0_10) AT=1530.05n

.meas tran vdout0_11ck1520 FIND v(dout0_11) AT=1530.05n

.meas tran vdout0_12ck1520 FIND v(dout0_12) AT=1530.05n

.meas tran vdout0_13ck1520 FIND v(dout0_13) AT=1530.05n

.meas tran vdout0_14ck1520 FIND v(dout0_14) AT=1530.05n

.meas tran vdout0_15ck1520 FIND v(dout0_15) AT=1530.05n

.meas tran vdout0_16ck1520 FIND v(dout0_16) AT=1530.05n

.meas tran vdout0_17ck1520 FIND v(dout0_17) AT=1530.05n

.meas tran vdout0_18ck1520 FIND v(dout0_18) AT=1530.05n

.meas tran vdout0_19ck1520 FIND v(dout0_19) AT=1530.05n

.meas tran vdout0_20ck1520 FIND v(dout0_20) AT=1530.05n

.meas tran vdout0_21ck1520 FIND v(dout0_21) AT=1530.05n

.meas tran vdout0_22ck1520 FIND v(dout0_22) AT=1530.05n

.meas tran vdout0_23ck1520 FIND v(dout0_23) AT=1530.05n

.meas tran vdout0_24ck1520 FIND v(dout0_24) AT=1530.05n

.meas tran vdout0_25ck1520 FIND v(dout0_25) AT=1530.05n

.meas tran vdout0_26ck1520 FIND v(dout0_26) AT=1530.05n

.meas tran vdout0_27ck1520 FIND v(dout0_27) AT=1530.05n

.meas tran vdout0_28ck1520 FIND v(dout0_28) AT=1530.05n

.meas tran vdout0_29ck1520 FIND v(dout0_29) AT=1530.05n

.meas tran vdout0_30ck1520 FIND v(dout0_30) AT=1530.05n

.meas tran vdout0_31ck1520 FIND v(dout0_31) AT=1530.05n

.meas tran vdout0_32ck1520 FIND v(dout0_32) AT=1530.05n

.meas tran vdout0_33ck1520 FIND v(dout0_33) AT=1530.05n

.meas tran vdout0_34ck1520 FIND v(dout0_34) AT=1530.05n

.meas tran vdout0_35ck1520 FIND v(dout0_35) AT=1530.05n

.meas tran vdout0_36ck1520 FIND v(dout0_36) AT=1530.05n

.meas tran vdout0_37ck1520 FIND v(dout0_37) AT=1530.05n

.meas tran vdout0_38ck1520 FIND v(dout0_38) AT=1530.05n

.meas tran vdout0_39ck1520 FIND v(dout0_39) AT=1530.05n

.meas tran vdout0_40ck1520 FIND v(dout0_40) AT=1530.05n

.meas tran vdout0_41ck1520 FIND v(dout0_41) AT=1530.05n

.meas tran vdout0_42ck1520 FIND v(dout0_42) AT=1530.05n

.meas tran vdout0_43ck1520 FIND v(dout0_43) AT=1530.05n

.meas tran vdout0_44ck1520 FIND v(dout0_44) AT=1530.05n

.meas tran vdout0_45ck1520 FIND v(dout0_45) AT=1530.05n

.meas tran vdout0_46ck1520 FIND v(dout0_46) AT=1530.05n

.meas tran vdout0_47ck1520 FIND v(dout0_47) AT=1530.05n

.meas tran vdout0_48ck1520 FIND v(dout0_48) AT=1530.05n

.meas tran vdout0_49ck1520 FIND v(dout0_49) AT=1530.05n

.meas tran vdout0_50ck1520 FIND v(dout0_50) AT=1530.05n

.meas tran vdout0_51ck1520 FIND v(dout0_51) AT=1530.05n

.meas tran vdout0_52ck1520 FIND v(dout0_52) AT=1530.05n

.meas tran vdout0_53ck1520 FIND v(dout0_53) AT=1530.05n

.meas tran vdout0_54ck1520 FIND v(dout0_54) AT=1530.05n

.meas tran vdout0_55ck1520 FIND v(dout0_55) AT=1530.05n

.meas tran vdout0_56ck1520 FIND v(dout0_56) AT=1530.05n

.meas tran vdout0_57ck1520 FIND v(dout0_57) AT=1530.05n

.meas tran vdout0_58ck1520 FIND v(dout0_58) AT=1530.05n

.meas tran vdout0_59ck1520 FIND v(dout0_59) AT=1530.05n

.meas tran vdout0_60ck1520 FIND v(dout0_60) AT=1530.05n

.meas tran vdout0_61ck1520 FIND v(dout0_61) AT=1530.05n

.meas tran vdout0_62ck1520 FIND v(dout0_62) AT=1530.05n

.meas tran vdout0_63ck1520 FIND v(dout0_63) AT=1530.05n

.meas tran vdout0_64ck1520 FIND v(dout0_64) AT=1530.05n

.meas tran vdout0_0ck1580 FIND v(dout0_0) AT=1590.05n

.meas tran vdout0_1ck1580 FIND v(dout0_1) AT=1590.05n

.meas tran vdout0_2ck1580 FIND v(dout0_2) AT=1590.05n

.meas tran vdout0_3ck1580 FIND v(dout0_3) AT=1590.05n

.meas tran vdout0_4ck1580 FIND v(dout0_4) AT=1590.05n

.meas tran vdout0_5ck1580 FIND v(dout0_5) AT=1590.05n

.meas tran vdout0_6ck1580 FIND v(dout0_6) AT=1590.05n

.meas tran vdout0_7ck1580 FIND v(dout0_7) AT=1590.05n

.meas tran vdout0_8ck1580 FIND v(dout0_8) AT=1590.05n

.meas tran vdout0_9ck1580 FIND v(dout0_9) AT=1590.05n

.meas tran vdout0_10ck1580 FIND v(dout0_10) AT=1590.05n

.meas tran vdout0_11ck1580 FIND v(dout0_11) AT=1590.05n

.meas tran vdout0_12ck1580 FIND v(dout0_12) AT=1590.05n

.meas tran vdout0_13ck1580 FIND v(dout0_13) AT=1590.05n

.meas tran vdout0_14ck1580 FIND v(dout0_14) AT=1590.05n

.meas tran vdout0_15ck1580 FIND v(dout0_15) AT=1590.05n

.meas tran vdout0_16ck1580 FIND v(dout0_16) AT=1590.05n

.meas tran vdout0_17ck1580 FIND v(dout0_17) AT=1590.05n

.meas tran vdout0_18ck1580 FIND v(dout0_18) AT=1590.05n

.meas tran vdout0_19ck1580 FIND v(dout0_19) AT=1590.05n

.meas tran vdout0_20ck1580 FIND v(dout0_20) AT=1590.05n

.meas tran vdout0_21ck1580 FIND v(dout0_21) AT=1590.05n

.meas tran vdout0_22ck1580 FIND v(dout0_22) AT=1590.05n

.meas tran vdout0_23ck1580 FIND v(dout0_23) AT=1590.05n

.meas tran vdout0_24ck1580 FIND v(dout0_24) AT=1590.05n

.meas tran vdout0_25ck1580 FIND v(dout0_25) AT=1590.05n

.meas tran vdout0_26ck1580 FIND v(dout0_26) AT=1590.05n

.meas tran vdout0_27ck1580 FIND v(dout0_27) AT=1590.05n

.meas tran vdout0_28ck1580 FIND v(dout0_28) AT=1590.05n

.meas tran vdout0_29ck1580 FIND v(dout0_29) AT=1590.05n

.meas tran vdout0_30ck1580 FIND v(dout0_30) AT=1590.05n

.meas tran vdout0_31ck1580 FIND v(dout0_31) AT=1590.05n

.meas tran vdout0_32ck1580 FIND v(dout0_32) AT=1590.05n

.meas tran vdout0_33ck1580 FIND v(dout0_33) AT=1590.05n

.meas tran vdout0_34ck1580 FIND v(dout0_34) AT=1590.05n

.meas tran vdout0_35ck1580 FIND v(dout0_35) AT=1590.05n

.meas tran vdout0_36ck1580 FIND v(dout0_36) AT=1590.05n

.meas tran vdout0_37ck1580 FIND v(dout0_37) AT=1590.05n

.meas tran vdout0_38ck1580 FIND v(dout0_38) AT=1590.05n

.meas tran vdout0_39ck1580 FIND v(dout0_39) AT=1590.05n

.meas tran vdout0_40ck1580 FIND v(dout0_40) AT=1590.05n

.meas tran vdout0_41ck1580 FIND v(dout0_41) AT=1590.05n

.meas tran vdout0_42ck1580 FIND v(dout0_42) AT=1590.05n

.meas tran vdout0_43ck1580 FIND v(dout0_43) AT=1590.05n

.meas tran vdout0_44ck1580 FIND v(dout0_44) AT=1590.05n

.meas tran vdout0_45ck1580 FIND v(dout0_45) AT=1590.05n

.meas tran vdout0_46ck1580 FIND v(dout0_46) AT=1590.05n

.meas tran vdout0_47ck1580 FIND v(dout0_47) AT=1590.05n

.meas tran vdout0_48ck1580 FIND v(dout0_48) AT=1590.05n

.meas tran vdout0_49ck1580 FIND v(dout0_49) AT=1590.05n

.meas tran vdout0_50ck1580 FIND v(dout0_50) AT=1590.05n

.meas tran vdout0_51ck1580 FIND v(dout0_51) AT=1590.05n

.meas tran vdout0_52ck1580 FIND v(dout0_52) AT=1590.05n

.meas tran vdout0_53ck1580 FIND v(dout0_53) AT=1590.05n

.meas tran vdout0_54ck1580 FIND v(dout0_54) AT=1590.05n

.meas tran vdout0_55ck1580 FIND v(dout0_55) AT=1590.05n

.meas tran vdout0_56ck1580 FIND v(dout0_56) AT=1590.05n

.meas tran vdout0_57ck1580 FIND v(dout0_57) AT=1590.05n

.meas tran vdout0_58ck1580 FIND v(dout0_58) AT=1590.05n

.meas tran vdout0_59ck1580 FIND v(dout0_59) AT=1590.05n

.meas tran vdout0_60ck1580 FIND v(dout0_60) AT=1590.05n

.meas tran vdout0_61ck1580 FIND v(dout0_61) AT=1590.05n

.meas tran vdout0_62ck1580 FIND v(dout0_62) AT=1590.05n

.meas tran vdout0_63ck1580 FIND v(dout0_63) AT=1590.05n

.meas tran vdout0_64ck1580 FIND v(dout0_64) AT=1590.05n

.meas tran vdout0_0ck1610 FIND v(dout0_0) AT=1620.05n

.meas tran vdout0_1ck1610 FIND v(dout0_1) AT=1620.05n

.meas tran vdout0_2ck1610 FIND v(dout0_2) AT=1620.05n

.meas tran vdout0_3ck1610 FIND v(dout0_3) AT=1620.05n

.meas tran vdout0_4ck1610 FIND v(dout0_4) AT=1620.05n

.meas tran vdout0_5ck1610 FIND v(dout0_5) AT=1620.05n

.meas tran vdout0_6ck1610 FIND v(dout0_6) AT=1620.05n

.meas tran vdout0_7ck1610 FIND v(dout0_7) AT=1620.05n

.meas tran vdout0_8ck1610 FIND v(dout0_8) AT=1620.05n

.meas tran vdout0_9ck1610 FIND v(dout0_9) AT=1620.05n

.meas tran vdout0_10ck1610 FIND v(dout0_10) AT=1620.05n

.meas tran vdout0_11ck1610 FIND v(dout0_11) AT=1620.05n

.meas tran vdout0_12ck1610 FIND v(dout0_12) AT=1620.05n

.meas tran vdout0_13ck1610 FIND v(dout0_13) AT=1620.05n

.meas tran vdout0_14ck1610 FIND v(dout0_14) AT=1620.05n

.meas tran vdout0_15ck1610 FIND v(dout0_15) AT=1620.05n

.meas tran vdout0_16ck1610 FIND v(dout0_16) AT=1620.05n

.meas tran vdout0_17ck1610 FIND v(dout0_17) AT=1620.05n

.meas tran vdout0_18ck1610 FIND v(dout0_18) AT=1620.05n

.meas tran vdout0_19ck1610 FIND v(dout0_19) AT=1620.05n

.meas tran vdout0_20ck1610 FIND v(dout0_20) AT=1620.05n

.meas tran vdout0_21ck1610 FIND v(dout0_21) AT=1620.05n

.meas tran vdout0_22ck1610 FIND v(dout0_22) AT=1620.05n

.meas tran vdout0_23ck1610 FIND v(dout0_23) AT=1620.05n

.meas tran vdout0_24ck1610 FIND v(dout0_24) AT=1620.05n

.meas tran vdout0_25ck1610 FIND v(dout0_25) AT=1620.05n

.meas tran vdout0_26ck1610 FIND v(dout0_26) AT=1620.05n

.meas tran vdout0_27ck1610 FIND v(dout0_27) AT=1620.05n

.meas tran vdout0_28ck1610 FIND v(dout0_28) AT=1620.05n

.meas tran vdout0_29ck1610 FIND v(dout0_29) AT=1620.05n

.meas tran vdout0_30ck1610 FIND v(dout0_30) AT=1620.05n

.meas tran vdout0_31ck1610 FIND v(dout0_31) AT=1620.05n

.meas tran vdout0_32ck1610 FIND v(dout0_32) AT=1620.05n

.meas tran vdout0_33ck1610 FIND v(dout0_33) AT=1620.05n

.meas tran vdout0_34ck1610 FIND v(dout0_34) AT=1620.05n

.meas tran vdout0_35ck1610 FIND v(dout0_35) AT=1620.05n

.meas tran vdout0_36ck1610 FIND v(dout0_36) AT=1620.05n

.meas tran vdout0_37ck1610 FIND v(dout0_37) AT=1620.05n

.meas tran vdout0_38ck1610 FIND v(dout0_38) AT=1620.05n

.meas tran vdout0_39ck1610 FIND v(dout0_39) AT=1620.05n

.meas tran vdout0_40ck1610 FIND v(dout0_40) AT=1620.05n

.meas tran vdout0_41ck1610 FIND v(dout0_41) AT=1620.05n

.meas tran vdout0_42ck1610 FIND v(dout0_42) AT=1620.05n

.meas tran vdout0_43ck1610 FIND v(dout0_43) AT=1620.05n

.meas tran vdout0_44ck1610 FIND v(dout0_44) AT=1620.05n

.meas tran vdout0_45ck1610 FIND v(dout0_45) AT=1620.05n

.meas tran vdout0_46ck1610 FIND v(dout0_46) AT=1620.05n

.meas tran vdout0_47ck1610 FIND v(dout0_47) AT=1620.05n

.meas tran vdout0_48ck1610 FIND v(dout0_48) AT=1620.05n

.meas tran vdout0_49ck1610 FIND v(dout0_49) AT=1620.05n

.meas tran vdout0_50ck1610 FIND v(dout0_50) AT=1620.05n

.meas tran vdout0_51ck1610 FIND v(dout0_51) AT=1620.05n

.meas tran vdout0_52ck1610 FIND v(dout0_52) AT=1620.05n

.meas tran vdout0_53ck1610 FIND v(dout0_53) AT=1620.05n

.meas tran vdout0_54ck1610 FIND v(dout0_54) AT=1620.05n

.meas tran vdout0_55ck1610 FIND v(dout0_55) AT=1620.05n

.meas tran vdout0_56ck1610 FIND v(dout0_56) AT=1620.05n

.meas tran vdout0_57ck1610 FIND v(dout0_57) AT=1620.05n

.meas tran vdout0_58ck1610 FIND v(dout0_58) AT=1620.05n

.meas tran vdout0_59ck1610 FIND v(dout0_59) AT=1620.05n

.meas tran vdout0_60ck1610 FIND v(dout0_60) AT=1620.05n

.meas tran vdout0_61ck1610 FIND v(dout0_61) AT=1620.05n

.meas tran vdout0_62ck1610 FIND v(dout0_62) AT=1620.05n

.meas tran vdout0_63ck1610 FIND v(dout0_63) AT=1620.05n

.meas tran vdout0_64ck1610 FIND v(dout0_64) AT=1620.05n

.meas tran vdout0_0ck1650 FIND v(dout0_0) AT=1660.05n

.meas tran vdout0_1ck1650 FIND v(dout0_1) AT=1660.05n

.meas tran vdout0_2ck1650 FIND v(dout0_2) AT=1660.05n

.meas tran vdout0_3ck1650 FIND v(dout0_3) AT=1660.05n

.meas tran vdout0_4ck1650 FIND v(dout0_4) AT=1660.05n

.meas tran vdout0_5ck1650 FIND v(dout0_5) AT=1660.05n

.meas tran vdout0_6ck1650 FIND v(dout0_6) AT=1660.05n

.meas tran vdout0_7ck1650 FIND v(dout0_7) AT=1660.05n

.meas tran vdout0_8ck1650 FIND v(dout0_8) AT=1660.05n

.meas tran vdout0_9ck1650 FIND v(dout0_9) AT=1660.05n

.meas tran vdout0_10ck1650 FIND v(dout0_10) AT=1660.05n

.meas tran vdout0_11ck1650 FIND v(dout0_11) AT=1660.05n

.meas tran vdout0_12ck1650 FIND v(dout0_12) AT=1660.05n

.meas tran vdout0_13ck1650 FIND v(dout0_13) AT=1660.05n

.meas tran vdout0_14ck1650 FIND v(dout0_14) AT=1660.05n

.meas tran vdout0_15ck1650 FIND v(dout0_15) AT=1660.05n

.meas tran vdout0_16ck1650 FIND v(dout0_16) AT=1660.05n

.meas tran vdout0_17ck1650 FIND v(dout0_17) AT=1660.05n

.meas tran vdout0_18ck1650 FIND v(dout0_18) AT=1660.05n

.meas tran vdout0_19ck1650 FIND v(dout0_19) AT=1660.05n

.meas tran vdout0_20ck1650 FIND v(dout0_20) AT=1660.05n

.meas tran vdout0_21ck1650 FIND v(dout0_21) AT=1660.05n

.meas tran vdout0_22ck1650 FIND v(dout0_22) AT=1660.05n

.meas tran vdout0_23ck1650 FIND v(dout0_23) AT=1660.05n

.meas tran vdout0_24ck1650 FIND v(dout0_24) AT=1660.05n

.meas tran vdout0_25ck1650 FIND v(dout0_25) AT=1660.05n

.meas tran vdout0_26ck1650 FIND v(dout0_26) AT=1660.05n

.meas tran vdout0_27ck1650 FIND v(dout0_27) AT=1660.05n

.meas tran vdout0_28ck1650 FIND v(dout0_28) AT=1660.05n

.meas tran vdout0_29ck1650 FIND v(dout0_29) AT=1660.05n

.meas tran vdout0_30ck1650 FIND v(dout0_30) AT=1660.05n

.meas tran vdout0_31ck1650 FIND v(dout0_31) AT=1660.05n

.meas tran vdout0_32ck1650 FIND v(dout0_32) AT=1660.05n

.meas tran vdout0_33ck1650 FIND v(dout0_33) AT=1660.05n

.meas tran vdout0_34ck1650 FIND v(dout0_34) AT=1660.05n

.meas tran vdout0_35ck1650 FIND v(dout0_35) AT=1660.05n

.meas tran vdout0_36ck1650 FIND v(dout0_36) AT=1660.05n

.meas tran vdout0_37ck1650 FIND v(dout0_37) AT=1660.05n

.meas tran vdout0_38ck1650 FIND v(dout0_38) AT=1660.05n

.meas tran vdout0_39ck1650 FIND v(dout0_39) AT=1660.05n

.meas tran vdout0_40ck1650 FIND v(dout0_40) AT=1660.05n

.meas tran vdout0_41ck1650 FIND v(dout0_41) AT=1660.05n

.meas tran vdout0_42ck1650 FIND v(dout0_42) AT=1660.05n

.meas tran vdout0_43ck1650 FIND v(dout0_43) AT=1660.05n

.meas tran vdout0_44ck1650 FIND v(dout0_44) AT=1660.05n

.meas tran vdout0_45ck1650 FIND v(dout0_45) AT=1660.05n

.meas tran vdout0_46ck1650 FIND v(dout0_46) AT=1660.05n

.meas tran vdout0_47ck1650 FIND v(dout0_47) AT=1660.05n

.meas tran vdout0_48ck1650 FIND v(dout0_48) AT=1660.05n

.meas tran vdout0_49ck1650 FIND v(dout0_49) AT=1660.05n

.meas tran vdout0_50ck1650 FIND v(dout0_50) AT=1660.05n

.meas tran vdout0_51ck1650 FIND v(dout0_51) AT=1660.05n

.meas tran vdout0_52ck1650 FIND v(dout0_52) AT=1660.05n

.meas tran vdout0_53ck1650 FIND v(dout0_53) AT=1660.05n

.meas tran vdout0_54ck1650 FIND v(dout0_54) AT=1660.05n

.meas tran vdout0_55ck1650 FIND v(dout0_55) AT=1660.05n

.meas tran vdout0_56ck1650 FIND v(dout0_56) AT=1660.05n

.meas tran vdout0_57ck1650 FIND v(dout0_57) AT=1660.05n

.meas tran vdout0_58ck1650 FIND v(dout0_58) AT=1660.05n

.meas tran vdout0_59ck1650 FIND v(dout0_59) AT=1660.05n

.meas tran vdout0_60ck1650 FIND v(dout0_60) AT=1660.05n

.meas tran vdout0_61ck1650 FIND v(dout0_61) AT=1660.05n

.meas tran vdout0_62ck1650 FIND v(dout0_62) AT=1660.05n

.meas tran vdout0_63ck1650 FIND v(dout0_63) AT=1660.05n

.meas tran vdout0_64ck1650 FIND v(dout0_64) AT=1660.05n

.meas tran vdout0_0ck1660 FIND v(dout0_0) AT=1670.05n

.meas tran vdout0_1ck1660 FIND v(dout0_1) AT=1670.05n

.meas tran vdout0_2ck1660 FIND v(dout0_2) AT=1670.05n

.meas tran vdout0_3ck1660 FIND v(dout0_3) AT=1670.05n

.meas tran vdout0_4ck1660 FIND v(dout0_4) AT=1670.05n

.meas tran vdout0_5ck1660 FIND v(dout0_5) AT=1670.05n

.meas tran vdout0_6ck1660 FIND v(dout0_6) AT=1670.05n

.meas tran vdout0_7ck1660 FIND v(dout0_7) AT=1670.05n

.meas tran vdout0_8ck1660 FIND v(dout0_8) AT=1670.05n

.meas tran vdout0_9ck1660 FIND v(dout0_9) AT=1670.05n

.meas tran vdout0_10ck1660 FIND v(dout0_10) AT=1670.05n

.meas tran vdout0_11ck1660 FIND v(dout0_11) AT=1670.05n

.meas tran vdout0_12ck1660 FIND v(dout0_12) AT=1670.05n

.meas tran vdout0_13ck1660 FIND v(dout0_13) AT=1670.05n

.meas tran vdout0_14ck1660 FIND v(dout0_14) AT=1670.05n

.meas tran vdout0_15ck1660 FIND v(dout0_15) AT=1670.05n

.meas tran vdout0_16ck1660 FIND v(dout0_16) AT=1670.05n

.meas tran vdout0_17ck1660 FIND v(dout0_17) AT=1670.05n

.meas tran vdout0_18ck1660 FIND v(dout0_18) AT=1670.05n

.meas tran vdout0_19ck1660 FIND v(dout0_19) AT=1670.05n

.meas tran vdout0_20ck1660 FIND v(dout0_20) AT=1670.05n

.meas tran vdout0_21ck1660 FIND v(dout0_21) AT=1670.05n

.meas tran vdout0_22ck1660 FIND v(dout0_22) AT=1670.05n

.meas tran vdout0_23ck1660 FIND v(dout0_23) AT=1670.05n

.meas tran vdout0_24ck1660 FIND v(dout0_24) AT=1670.05n

.meas tran vdout0_25ck1660 FIND v(dout0_25) AT=1670.05n

.meas tran vdout0_26ck1660 FIND v(dout0_26) AT=1670.05n

.meas tran vdout0_27ck1660 FIND v(dout0_27) AT=1670.05n

.meas tran vdout0_28ck1660 FIND v(dout0_28) AT=1670.05n

.meas tran vdout0_29ck1660 FIND v(dout0_29) AT=1670.05n

.meas tran vdout0_30ck1660 FIND v(dout0_30) AT=1670.05n

.meas tran vdout0_31ck1660 FIND v(dout0_31) AT=1670.05n

.meas tran vdout0_32ck1660 FIND v(dout0_32) AT=1670.05n

.meas tran vdout0_33ck1660 FIND v(dout0_33) AT=1670.05n

.meas tran vdout0_34ck1660 FIND v(dout0_34) AT=1670.05n

.meas tran vdout0_35ck1660 FIND v(dout0_35) AT=1670.05n

.meas tran vdout0_36ck1660 FIND v(dout0_36) AT=1670.05n

.meas tran vdout0_37ck1660 FIND v(dout0_37) AT=1670.05n

.meas tran vdout0_38ck1660 FIND v(dout0_38) AT=1670.05n

.meas tran vdout0_39ck1660 FIND v(dout0_39) AT=1670.05n

.meas tran vdout0_40ck1660 FIND v(dout0_40) AT=1670.05n

.meas tran vdout0_41ck1660 FIND v(dout0_41) AT=1670.05n

.meas tran vdout0_42ck1660 FIND v(dout0_42) AT=1670.05n

.meas tran vdout0_43ck1660 FIND v(dout0_43) AT=1670.05n

.meas tran vdout0_44ck1660 FIND v(dout0_44) AT=1670.05n

.meas tran vdout0_45ck1660 FIND v(dout0_45) AT=1670.05n

.meas tran vdout0_46ck1660 FIND v(dout0_46) AT=1670.05n

.meas tran vdout0_47ck1660 FIND v(dout0_47) AT=1670.05n

.meas tran vdout0_48ck1660 FIND v(dout0_48) AT=1670.05n

.meas tran vdout0_49ck1660 FIND v(dout0_49) AT=1670.05n

.meas tran vdout0_50ck1660 FIND v(dout0_50) AT=1670.05n

.meas tran vdout0_51ck1660 FIND v(dout0_51) AT=1670.05n

.meas tran vdout0_52ck1660 FIND v(dout0_52) AT=1670.05n

.meas tran vdout0_53ck1660 FIND v(dout0_53) AT=1670.05n

.meas tran vdout0_54ck1660 FIND v(dout0_54) AT=1670.05n

.meas tran vdout0_55ck1660 FIND v(dout0_55) AT=1670.05n

.meas tran vdout0_56ck1660 FIND v(dout0_56) AT=1670.05n

.meas tran vdout0_57ck1660 FIND v(dout0_57) AT=1670.05n

.meas tran vdout0_58ck1660 FIND v(dout0_58) AT=1670.05n

.meas tran vdout0_59ck1660 FIND v(dout0_59) AT=1670.05n

.meas tran vdout0_60ck1660 FIND v(dout0_60) AT=1670.05n

.meas tran vdout0_61ck1660 FIND v(dout0_61) AT=1670.05n

.meas tran vdout0_62ck1660 FIND v(dout0_62) AT=1670.05n

.meas tran vdout0_63ck1660 FIND v(dout0_63) AT=1670.05n

.meas tran vdout0_64ck1660 FIND v(dout0_64) AT=1670.05n

.meas tran vdout0_0ck1670 FIND v(dout0_0) AT=1680.05n

.meas tran vdout0_1ck1670 FIND v(dout0_1) AT=1680.05n

.meas tran vdout0_2ck1670 FIND v(dout0_2) AT=1680.05n

.meas tran vdout0_3ck1670 FIND v(dout0_3) AT=1680.05n

.meas tran vdout0_4ck1670 FIND v(dout0_4) AT=1680.05n

.meas tran vdout0_5ck1670 FIND v(dout0_5) AT=1680.05n

.meas tran vdout0_6ck1670 FIND v(dout0_6) AT=1680.05n

.meas tran vdout0_7ck1670 FIND v(dout0_7) AT=1680.05n

.meas tran vdout0_8ck1670 FIND v(dout0_8) AT=1680.05n

.meas tran vdout0_9ck1670 FIND v(dout0_9) AT=1680.05n

.meas tran vdout0_10ck1670 FIND v(dout0_10) AT=1680.05n

.meas tran vdout0_11ck1670 FIND v(dout0_11) AT=1680.05n

.meas tran vdout0_12ck1670 FIND v(dout0_12) AT=1680.05n

.meas tran vdout0_13ck1670 FIND v(dout0_13) AT=1680.05n

.meas tran vdout0_14ck1670 FIND v(dout0_14) AT=1680.05n

.meas tran vdout0_15ck1670 FIND v(dout0_15) AT=1680.05n

.meas tran vdout0_16ck1670 FIND v(dout0_16) AT=1680.05n

.meas tran vdout0_17ck1670 FIND v(dout0_17) AT=1680.05n

.meas tran vdout0_18ck1670 FIND v(dout0_18) AT=1680.05n

.meas tran vdout0_19ck1670 FIND v(dout0_19) AT=1680.05n

.meas tran vdout0_20ck1670 FIND v(dout0_20) AT=1680.05n

.meas tran vdout0_21ck1670 FIND v(dout0_21) AT=1680.05n

.meas tran vdout0_22ck1670 FIND v(dout0_22) AT=1680.05n

.meas tran vdout0_23ck1670 FIND v(dout0_23) AT=1680.05n

.meas tran vdout0_24ck1670 FIND v(dout0_24) AT=1680.05n

.meas tran vdout0_25ck1670 FIND v(dout0_25) AT=1680.05n

.meas tran vdout0_26ck1670 FIND v(dout0_26) AT=1680.05n

.meas tran vdout0_27ck1670 FIND v(dout0_27) AT=1680.05n

.meas tran vdout0_28ck1670 FIND v(dout0_28) AT=1680.05n

.meas tran vdout0_29ck1670 FIND v(dout0_29) AT=1680.05n

.meas tran vdout0_30ck1670 FIND v(dout0_30) AT=1680.05n

.meas tran vdout0_31ck1670 FIND v(dout0_31) AT=1680.05n

.meas tran vdout0_32ck1670 FIND v(dout0_32) AT=1680.05n

.meas tran vdout0_33ck1670 FIND v(dout0_33) AT=1680.05n

.meas tran vdout0_34ck1670 FIND v(dout0_34) AT=1680.05n

.meas tran vdout0_35ck1670 FIND v(dout0_35) AT=1680.05n

.meas tran vdout0_36ck1670 FIND v(dout0_36) AT=1680.05n

.meas tran vdout0_37ck1670 FIND v(dout0_37) AT=1680.05n

.meas tran vdout0_38ck1670 FIND v(dout0_38) AT=1680.05n

.meas tran vdout0_39ck1670 FIND v(dout0_39) AT=1680.05n

.meas tran vdout0_40ck1670 FIND v(dout0_40) AT=1680.05n

.meas tran vdout0_41ck1670 FIND v(dout0_41) AT=1680.05n

.meas tran vdout0_42ck1670 FIND v(dout0_42) AT=1680.05n

.meas tran vdout0_43ck1670 FIND v(dout0_43) AT=1680.05n

.meas tran vdout0_44ck1670 FIND v(dout0_44) AT=1680.05n

.meas tran vdout0_45ck1670 FIND v(dout0_45) AT=1680.05n

.meas tran vdout0_46ck1670 FIND v(dout0_46) AT=1680.05n

.meas tran vdout0_47ck1670 FIND v(dout0_47) AT=1680.05n

.meas tran vdout0_48ck1670 FIND v(dout0_48) AT=1680.05n

.meas tran vdout0_49ck1670 FIND v(dout0_49) AT=1680.05n

.meas tran vdout0_50ck1670 FIND v(dout0_50) AT=1680.05n

.meas tran vdout0_51ck1670 FIND v(dout0_51) AT=1680.05n

.meas tran vdout0_52ck1670 FIND v(dout0_52) AT=1680.05n

.meas tran vdout0_53ck1670 FIND v(dout0_53) AT=1680.05n

.meas tran vdout0_54ck1670 FIND v(dout0_54) AT=1680.05n

.meas tran vdout0_55ck1670 FIND v(dout0_55) AT=1680.05n

.meas tran vdout0_56ck1670 FIND v(dout0_56) AT=1680.05n

.meas tran vdout0_57ck1670 FIND v(dout0_57) AT=1680.05n

.meas tran vdout0_58ck1670 FIND v(dout0_58) AT=1680.05n

.meas tran vdout0_59ck1670 FIND v(dout0_59) AT=1680.05n

.meas tran vdout0_60ck1670 FIND v(dout0_60) AT=1680.05n

.meas tran vdout0_61ck1670 FIND v(dout0_61) AT=1680.05n

.meas tran vdout0_62ck1670 FIND v(dout0_62) AT=1680.05n

.meas tran vdout0_63ck1670 FIND v(dout0_63) AT=1680.05n

.meas tran vdout0_64ck1670 FIND v(dout0_64) AT=1680.05n

.meas tran vdout0_0ck1710 FIND v(dout0_0) AT=1720.05n

.meas tran vdout0_1ck1710 FIND v(dout0_1) AT=1720.05n

.meas tran vdout0_2ck1710 FIND v(dout0_2) AT=1720.05n

.meas tran vdout0_3ck1710 FIND v(dout0_3) AT=1720.05n

.meas tran vdout0_4ck1710 FIND v(dout0_4) AT=1720.05n

.meas tran vdout0_5ck1710 FIND v(dout0_5) AT=1720.05n

.meas tran vdout0_6ck1710 FIND v(dout0_6) AT=1720.05n

.meas tran vdout0_7ck1710 FIND v(dout0_7) AT=1720.05n

.meas tran vdout0_8ck1710 FIND v(dout0_8) AT=1720.05n

.meas tran vdout0_9ck1710 FIND v(dout0_9) AT=1720.05n

.meas tran vdout0_10ck1710 FIND v(dout0_10) AT=1720.05n

.meas tran vdout0_11ck1710 FIND v(dout0_11) AT=1720.05n

.meas tran vdout0_12ck1710 FIND v(dout0_12) AT=1720.05n

.meas tran vdout0_13ck1710 FIND v(dout0_13) AT=1720.05n

.meas tran vdout0_14ck1710 FIND v(dout0_14) AT=1720.05n

.meas tran vdout0_15ck1710 FIND v(dout0_15) AT=1720.05n

.meas tran vdout0_16ck1710 FIND v(dout0_16) AT=1720.05n

.meas tran vdout0_17ck1710 FIND v(dout0_17) AT=1720.05n

.meas tran vdout0_18ck1710 FIND v(dout0_18) AT=1720.05n

.meas tran vdout0_19ck1710 FIND v(dout0_19) AT=1720.05n

.meas tran vdout0_20ck1710 FIND v(dout0_20) AT=1720.05n

.meas tran vdout0_21ck1710 FIND v(dout0_21) AT=1720.05n

.meas tran vdout0_22ck1710 FIND v(dout0_22) AT=1720.05n

.meas tran vdout0_23ck1710 FIND v(dout0_23) AT=1720.05n

.meas tran vdout0_24ck1710 FIND v(dout0_24) AT=1720.05n

.meas tran vdout0_25ck1710 FIND v(dout0_25) AT=1720.05n

.meas tran vdout0_26ck1710 FIND v(dout0_26) AT=1720.05n

.meas tran vdout0_27ck1710 FIND v(dout0_27) AT=1720.05n

.meas tran vdout0_28ck1710 FIND v(dout0_28) AT=1720.05n

.meas tran vdout0_29ck1710 FIND v(dout0_29) AT=1720.05n

.meas tran vdout0_30ck1710 FIND v(dout0_30) AT=1720.05n

.meas tran vdout0_31ck1710 FIND v(dout0_31) AT=1720.05n

.meas tran vdout0_32ck1710 FIND v(dout0_32) AT=1720.05n

.meas tran vdout0_33ck1710 FIND v(dout0_33) AT=1720.05n

.meas tran vdout0_34ck1710 FIND v(dout0_34) AT=1720.05n

.meas tran vdout0_35ck1710 FIND v(dout0_35) AT=1720.05n

.meas tran vdout0_36ck1710 FIND v(dout0_36) AT=1720.05n

.meas tran vdout0_37ck1710 FIND v(dout0_37) AT=1720.05n

.meas tran vdout0_38ck1710 FIND v(dout0_38) AT=1720.05n

.meas tran vdout0_39ck1710 FIND v(dout0_39) AT=1720.05n

.meas tran vdout0_40ck1710 FIND v(dout0_40) AT=1720.05n

.meas tran vdout0_41ck1710 FIND v(dout0_41) AT=1720.05n

.meas tran vdout0_42ck1710 FIND v(dout0_42) AT=1720.05n

.meas tran vdout0_43ck1710 FIND v(dout0_43) AT=1720.05n

.meas tran vdout0_44ck1710 FIND v(dout0_44) AT=1720.05n

.meas tran vdout0_45ck1710 FIND v(dout0_45) AT=1720.05n

.meas tran vdout0_46ck1710 FIND v(dout0_46) AT=1720.05n

.meas tran vdout0_47ck1710 FIND v(dout0_47) AT=1720.05n

.meas tran vdout0_48ck1710 FIND v(dout0_48) AT=1720.05n

.meas tran vdout0_49ck1710 FIND v(dout0_49) AT=1720.05n

.meas tran vdout0_50ck1710 FIND v(dout0_50) AT=1720.05n

.meas tran vdout0_51ck1710 FIND v(dout0_51) AT=1720.05n

.meas tran vdout0_52ck1710 FIND v(dout0_52) AT=1720.05n

.meas tran vdout0_53ck1710 FIND v(dout0_53) AT=1720.05n

.meas tran vdout0_54ck1710 FIND v(dout0_54) AT=1720.05n

.meas tran vdout0_55ck1710 FIND v(dout0_55) AT=1720.05n

.meas tran vdout0_56ck1710 FIND v(dout0_56) AT=1720.05n

.meas tran vdout0_57ck1710 FIND v(dout0_57) AT=1720.05n

.meas tran vdout0_58ck1710 FIND v(dout0_58) AT=1720.05n

.meas tran vdout0_59ck1710 FIND v(dout0_59) AT=1720.05n

.meas tran vdout0_60ck1710 FIND v(dout0_60) AT=1720.05n

.meas tran vdout0_61ck1710 FIND v(dout0_61) AT=1720.05n

.meas tran vdout0_62ck1710 FIND v(dout0_62) AT=1720.05n

.meas tran vdout0_63ck1710 FIND v(dout0_63) AT=1720.05n

.meas tran vdout0_64ck1710 FIND v(dout0_64) AT=1720.05n

.meas tran vdout0_0ck1720 FIND v(dout0_0) AT=1730.05n

.meas tran vdout0_1ck1720 FIND v(dout0_1) AT=1730.05n

.meas tran vdout0_2ck1720 FIND v(dout0_2) AT=1730.05n

.meas tran vdout0_3ck1720 FIND v(dout0_3) AT=1730.05n

.meas tran vdout0_4ck1720 FIND v(dout0_4) AT=1730.05n

.meas tran vdout0_5ck1720 FIND v(dout0_5) AT=1730.05n

.meas tran vdout0_6ck1720 FIND v(dout0_6) AT=1730.05n

.meas tran vdout0_7ck1720 FIND v(dout0_7) AT=1730.05n

.meas tran vdout0_8ck1720 FIND v(dout0_8) AT=1730.05n

.meas tran vdout0_9ck1720 FIND v(dout0_9) AT=1730.05n

.meas tran vdout0_10ck1720 FIND v(dout0_10) AT=1730.05n

.meas tran vdout0_11ck1720 FIND v(dout0_11) AT=1730.05n

.meas tran vdout0_12ck1720 FIND v(dout0_12) AT=1730.05n

.meas tran vdout0_13ck1720 FIND v(dout0_13) AT=1730.05n

.meas tran vdout0_14ck1720 FIND v(dout0_14) AT=1730.05n

.meas tran vdout0_15ck1720 FIND v(dout0_15) AT=1730.05n

.meas tran vdout0_16ck1720 FIND v(dout0_16) AT=1730.05n

.meas tran vdout0_17ck1720 FIND v(dout0_17) AT=1730.05n

.meas tran vdout0_18ck1720 FIND v(dout0_18) AT=1730.05n

.meas tran vdout0_19ck1720 FIND v(dout0_19) AT=1730.05n

.meas tran vdout0_20ck1720 FIND v(dout0_20) AT=1730.05n

.meas tran vdout0_21ck1720 FIND v(dout0_21) AT=1730.05n

.meas tran vdout0_22ck1720 FIND v(dout0_22) AT=1730.05n

.meas tran vdout0_23ck1720 FIND v(dout0_23) AT=1730.05n

.meas tran vdout0_24ck1720 FIND v(dout0_24) AT=1730.05n

.meas tran vdout0_25ck1720 FIND v(dout0_25) AT=1730.05n

.meas tran vdout0_26ck1720 FIND v(dout0_26) AT=1730.05n

.meas tran vdout0_27ck1720 FIND v(dout0_27) AT=1730.05n

.meas tran vdout0_28ck1720 FIND v(dout0_28) AT=1730.05n

.meas tran vdout0_29ck1720 FIND v(dout0_29) AT=1730.05n

.meas tran vdout0_30ck1720 FIND v(dout0_30) AT=1730.05n

.meas tran vdout0_31ck1720 FIND v(dout0_31) AT=1730.05n

.meas tran vdout0_32ck1720 FIND v(dout0_32) AT=1730.05n

.meas tran vdout0_33ck1720 FIND v(dout0_33) AT=1730.05n

.meas tran vdout0_34ck1720 FIND v(dout0_34) AT=1730.05n

.meas tran vdout0_35ck1720 FIND v(dout0_35) AT=1730.05n

.meas tran vdout0_36ck1720 FIND v(dout0_36) AT=1730.05n

.meas tran vdout0_37ck1720 FIND v(dout0_37) AT=1730.05n

.meas tran vdout0_38ck1720 FIND v(dout0_38) AT=1730.05n

.meas tran vdout0_39ck1720 FIND v(dout0_39) AT=1730.05n

.meas tran vdout0_40ck1720 FIND v(dout0_40) AT=1730.05n

.meas tran vdout0_41ck1720 FIND v(dout0_41) AT=1730.05n

.meas tran vdout0_42ck1720 FIND v(dout0_42) AT=1730.05n

.meas tran vdout0_43ck1720 FIND v(dout0_43) AT=1730.05n

.meas tran vdout0_44ck1720 FIND v(dout0_44) AT=1730.05n

.meas tran vdout0_45ck1720 FIND v(dout0_45) AT=1730.05n

.meas tran vdout0_46ck1720 FIND v(dout0_46) AT=1730.05n

.meas tran vdout0_47ck1720 FIND v(dout0_47) AT=1730.05n

.meas tran vdout0_48ck1720 FIND v(dout0_48) AT=1730.05n

.meas tran vdout0_49ck1720 FIND v(dout0_49) AT=1730.05n

.meas tran vdout0_50ck1720 FIND v(dout0_50) AT=1730.05n

.meas tran vdout0_51ck1720 FIND v(dout0_51) AT=1730.05n

.meas tran vdout0_52ck1720 FIND v(dout0_52) AT=1730.05n

.meas tran vdout0_53ck1720 FIND v(dout0_53) AT=1730.05n

.meas tran vdout0_54ck1720 FIND v(dout0_54) AT=1730.05n

.meas tran vdout0_55ck1720 FIND v(dout0_55) AT=1730.05n

.meas tran vdout0_56ck1720 FIND v(dout0_56) AT=1730.05n

.meas tran vdout0_57ck1720 FIND v(dout0_57) AT=1730.05n

.meas tran vdout0_58ck1720 FIND v(dout0_58) AT=1730.05n

.meas tran vdout0_59ck1720 FIND v(dout0_59) AT=1730.05n

.meas tran vdout0_60ck1720 FIND v(dout0_60) AT=1730.05n

.meas tran vdout0_61ck1720 FIND v(dout0_61) AT=1730.05n

.meas tran vdout0_62ck1720 FIND v(dout0_62) AT=1730.05n

.meas tran vdout0_63ck1720 FIND v(dout0_63) AT=1730.05n

.meas tran vdout0_64ck1720 FIND v(dout0_64) AT=1730.05n

.meas tran vdout0_0ck1740 FIND v(dout0_0) AT=1750.05n

.meas tran vdout0_1ck1740 FIND v(dout0_1) AT=1750.05n

.meas tran vdout0_2ck1740 FIND v(dout0_2) AT=1750.05n

.meas tran vdout0_3ck1740 FIND v(dout0_3) AT=1750.05n

.meas tran vdout0_4ck1740 FIND v(dout0_4) AT=1750.05n

.meas tran vdout0_5ck1740 FIND v(dout0_5) AT=1750.05n

.meas tran vdout0_6ck1740 FIND v(dout0_6) AT=1750.05n

.meas tran vdout0_7ck1740 FIND v(dout0_7) AT=1750.05n

.meas tran vdout0_8ck1740 FIND v(dout0_8) AT=1750.05n

.meas tran vdout0_9ck1740 FIND v(dout0_9) AT=1750.05n

.meas tran vdout0_10ck1740 FIND v(dout0_10) AT=1750.05n

.meas tran vdout0_11ck1740 FIND v(dout0_11) AT=1750.05n

.meas tran vdout0_12ck1740 FIND v(dout0_12) AT=1750.05n

.meas tran vdout0_13ck1740 FIND v(dout0_13) AT=1750.05n

.meas tran vdout0_14ck1740 FIND v(dout0_14) AT=1750.05n

.meas tran vdout0_15ck1740 FIND v(dout0_15) AT=1750.05n

.meas tran vdout0_16ck1740 FIND v(dout0_16) AT=1750.05n

.meas tran vdout0_17ck1740 FIND v(dout0_17) AT=1750.05n

.meas tran vdout0_18ck1740 FIND v(dout0_18) AT=1750.05n

.meas tran vdout0_19ck1740 FIND v(dout0_19) AT=1750.05n

.meas tran vdout0_20ck1740 FIND v(dout0_20) AT=1750.05n

.meas tran vdout0_21ck1740 FIND v(dout0_21) AT=1750.05n

.meas tran vdout0_22ck1740 FIND v(dout0_22) AT=1750.05n

.meas tran vdout0_23ck1740 FIND v(dout0_23) AT=1750.05n

.meas tran vdout0_24ck1740 FIND v(dout0_24) AT=1750.05n

.meas tran vdout0_25ck1740 FIND v(dout0_25) AT=1750.05n

.meas tran vdout0_26ck1740 FIND v(dout0_26) AT=1750.05n

.meas tran vdout0_27ck1740 FIND v(dout0_27) AT=1750.05n

.meas tran vdout0_28ck1740 FIND v(dout0_28) AT=1750.05n

.meas tran vdout0_29ck1740 FIND v(dout0_29) AT=1750.05n

.meas tran vdout0_30ck1740 FIND v(dout0_30) AT=1750.05n

.meas tran vdout0_31ck1740 FIND v(dout0_31) AT=1750.05n

.meas tran vdout0_32ck1740 FIND v(dout0_32) AT=1750.05n

.meas tran vdout0_33ck1740 FIND v(dout0_33) AT=1750.05n

.meas tran vdout0_34ck1740 FIND v(dout0_34) AT=1750.05n

.meas tran vdout0_35ck1740 FIND v(dout0_35) AT=1750.05n

.meas tran vdout0_36ck1740 FIND v(dout0_36) AT=1750.05n

.meas tran vdout0_37ck1740 FIND v(dout0_37) AT=1750.05n

.meas tran vdout0_38ck1740 FIND v(dout0_38) AT=1750.05n

.meas tran vdout0_39ck1740 FIND v(dout0_39) AT=1750.05n

.meas tran vdout0_40ck1740 FIND v(dout0_40) AT=1750.05n

.meas tran vdout0_41ck1740 FIND v(dout0_41) AT=1750.05n

.meas tran vdout0_42ck1740 FIND v(dout0_42) AT=1750.05n

.meas tran vdout0_43ck1740 FIND v(dout0_43) AT=1750.05n

.meas tran vdout0_44ck1740 FIND v(dout0_44) AT=1750.05n

.meas tran vdout0_45ck1740 FIND v(dout0_45) AT=1750.05n

.meas tran vdout0_46ck1740 FIND v(dout0_46) AT=1750.05n

.meas tran vdout0_47ck1740 FIND v(dout0_47) AT=1750.05n

.meas tran vdout0_48ck1740 FIND v(dout0_48) AT=1750.05n

.meas tran vdout0_49ck1740 FIND v(dout0_49) AT=1750.05n

.meas tran vdout0_50ck1740 FIND v(dout0_50) AT=1750.05n

.meas tran vdout0_51ck1740 FIND v(dout0_51) AT=1750.05n

.meas tran vdout0_52ck1740 FIND v(dout0_52) AT=1750.05n

.meas tran vdout0_53ck1740 FIND v(dout0_53) AT=1750.05n

.meas tran vdout0_54ck1740 FIND v(dout0_54) AT=1750.05n

.meas tran vdout0_55ck1740 FIND v(dout0_55) AT=1750.05n

.meas tran vdout0_56ck1740 FIND v(dout0_56) AT=1750.05n

.meas tran vdout0_57ck1740 FIND v(dout0_57) AT=1750.05n

.meas tran vdout0_58ck1740 FIND v(dout0_58) AT=1750.05n

.meas tran vdout0_59ck1740 FIND v(dout0_59) AT=1750.05n

.meas tran vdout0_60ck1740 FIND v(dout0_60) AT=1750.05n

.meas tran vdout0_61ck1740 FIND v(dout0_61) AT=1750.05n

.meas tran vdout0_62ck1740 FIND v(dout0_62) AT=1750.05n

.meas tran vdout0_63ck1740 FIND v(dout0_63) AT=1750.05n

.meas tran vdout0_64ck1740 FIND v(dout0_64) AT=1750.05n

.meas tran vdout0_0ck1760 FIND v(dout0_0) AT=1770.05n

.meas tran vdout0_1ck1760 FIND v(dout0_1) AT=1770.05n

.meas tran vdout0_2ck1760 FIND v(dout0_2) AT=1770.05n

.meas tran vdout0_3ck1760 FIND v(dout0_3) AT=1770.05n

.meas tran vdout0_4ck1760 FIND v(dout0_4) AT=1770.05n

.meas tran vdout0_5ck1760 FIND v(dout0_5) AT=1770.05n

.meas tran vdout0_6ck1760 FIND v(dout0_6) AT=1770.05n

.meas tran vdout0_7ck1760 FIND v(dout0_7) AT=1770.05n

.meas tran vdout0_8ck1760 FIND v(dout0_8) AT=1770.05n

.meas tran vdout0_9ck1760 FIND v(dout0_9) AT=1770.05n

.meas tran vdout0_10ck1760 FIND v(dout0_10) AT=1770.05n

.meas tran vdout0_11ck1760 FIND v(dout0_11) AT=1770.05n

.meas tran vdout0_12ck1760 FIND v(dout0_12) AT=1770.05n

.meas tran vdout0_13ck1760 FIND v(dout0_13) AT=1770.05n

.meas tran vdout0_14ck1760 FIND v(dout0_14) AT=1770.05n

.meas tran vdout0_15ck1760 FIND v(dout0_15) AT=1770.05n

.meas tran vdout0_16ck1760 FIND v(dout0_16) AT=1770.05n

.meas tran vdout0_17ck1760 FIND v(dout0_17) AT=1770.05n

.meas tran vdout0_18ck1760 FIND v(dout0_18) AT=1770.05n

.meas tran vdout0_19ck1760 FIND v(dout0_19) AT=1770.05n

.meas tran vdout0_20ck1760 FIND v(dout0_20) AT=1770.05n

.meas tran vdout0_21ck1760 FIND v(dout0_21) AT=1770.05n

.meas tran vdout0_22ck1760 FIND v(dout0_22) AT=1770.05n

.meas tran vdout0_23ck1760 FIND v(dout0_23) AT=1770.05n

.meas tran vdout0_24ck1760 FIND v(dout0_24) AT=1770.05n

.meas tran vdout0_25ck1760 FIND v(dout0_25) AT=1770.05n

.meas tran vdout0_26ck1760 FIND v(dout0_26) AT=1770.05n

.meas tran vdout0_27ck1760 FIND v(dout0_27) AT=1770.05n

.meas tran vdout0_28ck1760 FIND v(dout0_28) AT=1770.05n

.meas tran vdout0_29ck1760 FIND v(dout0_29) AT=1770.05n

.meas tran vdout0_30ck1760 FIND v(dout0_30) AT=1770.05n

.meas tran vdout0_31ck1760 FIND v(dout0_31) AT=1770.05n

.meas tran vdout0_32ck1760 FIND v(dout0_32) AT=1770.05n

.meas tran vdout0_33ck1760 FIND v(dout0_33) AT=1770.05n

.meas tran vdout0_34ck1760 FIND v(dout0_34) AT=1770.05n

.meas tran vdout0_35ck1760 FIND v(dout0_35) AT=1770.05n

.meas tran vdout0_36ck1760 FIND v(dout0_36) AT=1770.05n

.meas tran vdout0_37ck1760 FIND v(dout0_37) AT=1770.05n

.meas tran vdout0_38ck1760 FIND v(dout0_38) AT=1770.05n

.meas tran vdout0_39ck1760 FIND v(dout0_39) AT=1770.05n

.meas tran vdout0_40ck1760 FIND v(dout0_40) AT=1770.05n

.meas tran vdout0_41ck1760 FIND v(dout0_41) AT=1770.05n

.meas tran vdout0_42ck1760 FIND v(dout0_42) AT=1770.05n

.meas tran vdout0_43ck1760 FIND v(dout0_43) AT=1770.05n

.meas tran vdout0_44ck1760 FIND v(dout0_44) AT=1770.05n

.meas tran vdout0_45ck1760 FIND v(dout0_45) AT=1770.05n

.meas tran vdout0_46ck1760 FIND v(dout0_46) AT=1770.05n

.meas tran vdout0_47ck1760 FIND v(dout0_47) AT=1770.05n

.meas tran vdout0_48ck1760 FIND v(dout0_48) AT=1770.05n

.meas tran vdout0_49ck1760 FIND v(dout0_49) AT=1770.05n

.meas tran vdout0_50ck1760 FIND v(dout0_50) AT=1770.05n

.meas tran vdout0_51ck1760 FIND v(dout0_51) AT=1770.05n

.meas tran vdout0_52ck1760 FIND v(dout0_52) AT=1770.05n

.meas tran vdout0_53ck1760 FIND v(dout0_53) AT=1770.05n

.meas tran vdout0_54ck1760 FIND v(dout0_54) AT=1770.05n

.meas tran vdout0_55ck1760 FIND v(dout0_55) AT=1770.05n

.meas tran vdout0_56ck1760 FIND v(dout0_56) AT=1770.05n

.meas tran vdout0_57ck1760 FIND v(dout0_57) AT=1770.05n

.meas tran vdout0_58ck1760 FIND v(dout0_58) AT=1770.05n

.meas tran vdout0_59ck1760 FIND v(dout0_59) AT=1770.05n

.meas tran vdout0_60ck1760 FIND v(dout0_60) AT=1770.05n

.meas tran vdout0_61ck1760 FIND v(dout0_61) AT=1770.05n

.meas tran vdout0_62ck1760 FIND v(dout0_62) AT=1770.05n

.meas tran vdout0_63ck1760 FIND v(dout0_63) AT=1770.05n

.meas tran vdout0_64ck1760 FIND v(dout0_64) AT=1770.05n

.meas tran vdout0_0ck1770 FIND v(dout0_0) AT=1780.05n

.meas tran vdout0_1ck1770 FIND v(dout0_1) AT=1780.05n

.meas tran vdout0_2ck1770 FIND v(dout0_2) AT=1780.05n

.meas tran vdout0_3ck1770 FIND v(dout0_3) AT=1780.05n

.meas tran vdout0_4ck1770 FIND v(dout0_4) AT=1780.05n

.meas tran vdout0_5ck1770 FIND v(dout0_5) AT=1780.05n

.meas tran vdout0_6ck1770 FIND v(dout0_6) AT=1780.05n

.meas tran vdout0_7ck1770 FIND v(dout0_7) AT=1780.05n

.meas tran vdout0_8ck1770 FIND v(dout0_8) AT=1780.05n

.meas tran vdout0_9ck1770 FIND v(dout0_9) AT=1780.05n

.meas tran vdout0_10ck1770 FIND v(dout0_10) AT=1780.05n

.meas tran vdout0_11ck1770 FIND v(dout0_11) AT=1780.05n

.meas tran vdout0_12ck1770 FIND v(dout0_12) AT=1780.05n

.meas tran vdout0_13ck1770 FIND v(dout0_13) AT=1780.05n

.meas tran vdout0_14ck1770 FIND v(dout0_14) AT=1780.05n

.meas tran vdout0_15ck1770 FIND v(dout0_15) AT=1780.05n

.meas tran vdout0_16ck1770 FIND v(dout0_16) AT=1780.05n

.meas tran vdout0_17ck1770 FIND v(dout0_17) AT=1780.05n

.meas tran vdout0_18ck1770 FIND v(dout0_18) AT=1780.05n

.meas tran vdout0_19ck1770 FIND v(dout0_19) AT=1780.05n

.meas tran vdout0_20ck1770 FIND v(dout0_20) AT=1780.05n

.meas tran vdout0_21ck1770 FIND v(dout0_21) AT=1780.05n

.meas tran vdout0_22ck1770 FIND v(dout0_22) AT=1780.05n

.meas tran vdout0_23ck1770 FIND v(dout0_23) AT=1780.05n

.meas tran vdout0_24ck1770 FIND v(dout0_24) AT=1780.05n

.meas tran vdout0_25ck1770 FIND v(dout0_25) AT=1780.05n

.meas tran vdout0_26ck1770 FIND v(dout0_26) AT=1780.05n

.meas tran vdout0_27ck1770 FIND v(dout0_27) AT=1780.05n

.meas tran vdout0_28ck1770 FIND v(dout0_28) AT=1780.05n

.meas tran vdout0_29ck1770 FIND v(dout0_29) AT=1780.05n

.meas tran vdout0_30ck1770 FIND v(dout0_30) AT=1780.05n

.meas tran vdout0_31ck1770 FIND v(dout0_31) AT=1780.05n

.meas tran vdout0_32ck1770 FIND v(dout0_32) AT=1780.05n

.meas tran vdout0_33ck1770 FIND v(dout0_33) AT=1780.05n

.meas tran vdout0_34ck1770 FIND v(dout0_34) AT=1780.05n

.meas tran vdout0_35ck1770 FIND v(dout0_35) AT=1780.05n

.meas tran vdout0_36ck1770 FIND v(dout0_36) AT=1780.05n

.meas tran vdout0_37ck1770 FIND v(dout0_37) AT=1780.05n

.meas tran vdout0_38ck1770 FIND v(dout0_38) AT=1780.05n

.meas tran vdout0_39ck1770 FIND v(dout0_39) AT=1780.05n

.meas tran vdout0_40ck1770 FIND v(dout0_40) AT=1780.05n

.meas tran vdout0_41ck1770 FIND v(dout0_41) AT=1780.05n

.meas tran vdout0_42ck1770 FIND v(dout0_42) AT=1780.05n

.meas tran vdout0_43ck1770 FIND v(dout0_43) AT=1780.05n

.meas tran vdout0_44ck1770 FIND v(dout0_44) AT=1780.05n

.meas tran vdout0_45ck1770 FIND v(dout0_45) AT=1780.05n

.meas tran vdout0_46ck1770 FIND v(dout0_46) AT=1780.05n

.meas tran vdout0_47ck1770 FIND v(dout0_47) AT=1780.05n

.meas tran vdout0_48ck1770 FIND v(dout0_48) AT=1780.05n

.meas tran vdout0_49ck1770 FIND v(dout0_49) AT=1780.05n

.meas tran vdout0_50ck1770 FIND v(dout0_50) AT=1780.05n

.meas tran vdout0_51ck1770 FIND v(dout0_51) AT=1780.05n

.meas tran vdout0_52ck1770 FIND v(dout0_52) AT=1780.05n

.meas tran vdout0_53ck1770 FIND v(dout0_53) AT=1780.05n

.meas tran vdout0_54ck1770 FIND v(dout0_54) AT=1780.05n

.meas tran vdout0_55ck1770 FIND v(dout0_55) AT=1780.05n

.meas tran vdout0_56ck1770 FIND v(dout0_56) AT=1780.05n

.meas tran vdout0_57ck1770 FIND v(dout0_57) AT=1780.05n

.meas tran vdout0_58ck1770 FIND v(dout0_58) AT=1780.05n

.meas tran vdout0_59ck1770 FIND v(dout0_59) AT=1780.05n

.meas tran vdout0_60ck1770 FIND v(dout0_60) AT=1780.05n

.meas tran vdout0_61ck1770 FIND v(dout0_61) AT=1780.05n

.meas tran vdout0_62ck1770 FIND v(dout0_62) AT=1780.05n

.meas tran vdout0_63ck1770 FIND v(dout0_63) AT=1780.05n

.meas tran vdout0_64ck1770 FIND v(dout0_64) AT=1780.05n

.meas tran vdout0_0ck1810 FIND v(dout0_0) AT=1820.05n

.meas tran vdout0_1ck1810 FIND v(dout0_1) AT=1820.05n

.meas tran vdout0_2ck1810 FIND v(dout0_2) AT=1820.05n

.meas tran vdout0_3ck1810 FIND v(dout0_3) AT=1820.05n

.meas tran vdout0_4ck1810 FIND v(dout0_4) AT=1820.05n

.meas tran vdout0_5ck1810 FIND v(dout0_5) AT=1820.05n

.meas tran vdout0_6ck1810 FIND v(dout0_6) AT=1820.05n

.meas tran vdout0_7ck1810 FIND v(dout0_7) AT=1820.05n

.meas tran vdout0_8ck1810 FIND v(dout0_8) AT=1820.05n

.meas tran vdout0_9ck1810 FIND v(dout0_9) AT=1820.05n

.meas tran vdout0_10ck1810 FIND v(dout0_10) AT=1820.05n

.meas tran vdout0_11ck1810 FIND v(dout0_11) AT=1820.05n

.meas tran vdout0_12ck1810 FIND v(dout0_12) AT=1820.05n

.meas tran vdout0_13ck1810 FIND v(dout0_13) AT=1820.05n

.meas tran vdout0_14ck1810 FIND v(dout0_14) AT=1820.05n

.meas tran vdout0_15ck1810 FIND v(dout0_15) AT=1820.05n

.meas tran vdout0_16ck1810 FIND v(dout0_16) AT=1820.05n

.meas tran vdout0_17ck1810 FIND v(dout0_17) AT=1820.05n

.meas tran vdout0_18ck1810 FIND v(dout0_18) AT=1820.05n

.meas tran vdout0_19ck1810 FIND v(dout0_19) AT=1820.05n

.meas tran vdout0_20ck1810 FIND v(dout0_20) AT=1820.05n

.meas tran vdout0_21ck1810 FIND v(dout0_21) AT=1820.05n

.meas tran vdout0_22ck1810 FIND v(dout0_22) AT=1820.05n

.meas tran vdout0_23ck1810 FIND v(dout0_23) AT=1820.05n

.meas tran vdout0_24ck1810 FIND v(dout0_24) AT=1820.05n

.meas tran vdout0_25ck1810 FIND v(dout0_25) AT=1820.05n

.meas tran vdout0_26ck1810 FIND v(dout0_26) AT=1820.05n

.meas tran vdout0_27ck1810 FIND v(dout0_27) AT=1820.05n

.meas tran vdout0_28ck1810 FIND v(dout0_28) AT=1820.05n

.meas tran vdout0_29ck1810 FIND v(dout0_29) AT=1820.05n

.meas tran vdout0_30ck1810 FIND v(dout0_30) AT=1820.05n

.meas tran vdout0_31ck1810 FIND v(dout0_31) AT=1820.05n

.meas tran vdout0_32ck1810 FIND v(dout0_32) AT=1820.05n

.meas tran vdout0_33ck1810 FIND v(dout0_33) AT=1820.05n

.meas tran vdout0_34ck1810 FIND v(dout0_34) AT=1820.05n

.meas tran vdout0_35ck1810 FIND v(dout0_35) AT=1820.05n

.meas tran vdout0_36ck1810 FIND v(dout0_36) AT=1820.05n

.meas tran vdout0_37ck1810 FIND v(dout0_37) AT=1820.05n

.meas tran vdout0_38ck1810 FIND v(dout0_38) AT=1820.05n

.meas tran vdout0_39ck1810 FIND v(dout0_39) AT=1820.05n

.meas tran vdout0_40ck1810 FIND v(dout0_40) AT=1820.05n

.meas tran vdout0_41ck1810 FIND v(dout0_41) AT=1820.05n

.meas tran vdout0_42ck1810 FIND v(dout0_42) AT=1820.05n

.meas tran vdout0_43ck1810 FIND v(dout0_43) AT=1820.05n

.meas tran vdout0_44ck1810 FIND v(dout0_44) AT=1820.05n

.meas tran vdout0_45ck1810 FIND v(dout0_45) AT=1820.05n

.meas tran vdout0_46ck1810 FIND v(dout0_46) AT=1820.05n

.meas tran vdout0_47ck1810 FIND v(dout0_47) AT=1820.05n

.meas tran vdout0_48ck1810 FIND v(dout0_48) AT=1820.05n

.meas tran vdout0_49ck1810 FIND v(dout0_49) AT=1820.05n

.meas tran vdout0_50ck1810 FIND v(dout0_50) AT=1820.05n

.meas tran vdout0_51ck1810 FIND v(dout0_51) AT=1820.05n

.meas tran vdout0_52ck1810 FIND v(dout0_52) AT=1820.05n

.meas tran vdout0_53ck1810 FIND v(dout0_53) AT=1820.05n

.meas tran vdout0_54ck1810 FIND v(dout0_54) AT=1820.05n

.meas tran vdout0_55ck1810 FIND v(dout0_55) AT=1820.05n

.meas tran vdout0_56ck1810 FIND v(dout0_56) AT=1820.05n

.meas tran vdout0_57ck1810 FIND v(dout0_57) AT=1820.05n

.meas tran vdout0_58ck1810 FIND v(dout0_58) AT=1820.05n

.meas tran vdout0_59ck1810 FIND v(dout0_59) AT=1820.05n

.meas tran vdout0_60ck1810 FIND v(dout0_60) AT=1820.05n

.meas tran vdout0_61ck1810 FIND v(dout0_61) AT=1820.05n

.meas tran vdout0_62ck1810 FIND v(dout0_62) AT=1820.05n

.meas tran vdout0_63ck1810 FIND v(dout0_63) AT=1820.05n

.meas tran vdout0_64ck1810 FIND v(dout0_64) AT=1820.05n

.meas tran vdout0_0ck1820 FIND v(dout0_0) AT=1830.05n

.meas tran vdout0_1ck1820 FIND v(dout0_1) AT=1830.05n

.meas tran vdout0_2ck1820 FIND v(dout0_2) AT=1830.05n

.meas tran vdout0_3ck1820 FIND v(dout0_3) AT=1830.05n

.meas tran vdout0_4ck1820 FIND v(dout0_4) AT=1830.05n

.meas tran vdout0_5ck1820 FIND v(dout0_5) AT=1830.05n

.meas tran vdout0_6ck1820 FIND v(dout0_6) AT=1830.05n

.meas tran vdout0_7ck1820 FIND v(dout0_7) AT=1830.05n

.meas tran vdout0_8ck1820 FIND v(dout0_8) AT=1830.05n

.meas tran vdout0_9ck1820 FIND v(dout0_9) AT=1830.05n

.meas tran vdout0_10ck1820 FIND v(dout0_10) AT=1830.05n

.meas tran vdout0_11ck1820 FIND v(dout0_11) AT=1830.05n

.meas tran vdout0_12ck1820 FIND v(dout0_12) AT=1830.05n

.meas tran vdout0_13ck1820 FIND v(dout0_13) AT=1830.05n

.meas tran vdout0_14ck1820 FIND v(dout0_14) AT=1830.05n

.meas tran vdout0_15ck1820 FIND v(dout0_15) AT=1830.05n

.meas tran vdout0_16ck1820 FIND v(dout0_16) AT=1830.05n

.meas tran vdout0_17ck1820 FIND v(dout0_17) AT=1830.05n

.meas tran vdout0_18ck1820 FIND v(dout0_18) AT=1830.05n

.meas tran vdout0_19ck1820 FIND v(dout0_19) AT=1830.05n

.meas tran vdout0_20ck1820 FIND v(dout0_20) AT=1830.05n

.meas tran vdout0_21ck1820 FIND v(dout0_21) AT=1830.05n

.meas tran vdout0_22ck1820 FIND v(dout0_22) AT=1830.05n

.meas tran vdout0_23ck1820 FIND v(dout0_23) AT=1830.05n

.meas tran vdout0_24ck1820 FIND v(dout0_24) AT=1830.05n

.meas tran vdout0_25ck1820 FIND v(dout0_25) AT=1830.05n

.meas tran vdout0_26ck1820 FIND v(dout0_26) AT=1830.05n

.meas tran vdout0_27ck1820 FIND v(dout0_27) AT=1830.05n

.meas tran vdout0_28ck1820 FIND v(dout0_28) AT=1830.05n

.meas tran vdout0_29ck1820 FIND v(dout0_29) AT=1830.05n

.meas tran vdout0_30ck1820 FIND v(dout0_30) AT=1830.05n

.meas tran vdout0_31ck1820 FIND v(dout0_31) AT=1830.05n

.meas tran vdout0_32ck1820 FIND v(dout0_32) AT=1830.05n

.meas tran vdout0_33ck1820 FIND v(dout0_33) AT=1830.05n

.meas tran vdout0_34ck1820 FIND v(dout0_34) AT=1830.05n

.meas tran vdout0_35ck1820 FIND v(dout0_35) AT=1830.05n

.meas tran vdout0_36ck1820 FIND v(dout0_36) AT=1830.05n

.meas tran vdout0_37ck1820 FIND v(dout0_37) AT=1830.05n

.meas tran vdout0_38ck1820 FIND v(dout0_38) AT=1830.05n

.meas tran vdout0_39ck1820 FIND v(dout0_39) AT=1830.05n

.meas tran vdout0_40ck1820 FIND v(dout0_40) AT=1830.05n

.meas tran vdout0_41ck1820 FIND v(dout0_41) AT=1830.05n

.meas tran vdout0_42ck1820 FIND v(dout0_42) AT=1830.05n

.meas tran vdout0_43ck1820 FIND v(dout0_43) AT=1830.05n

.meas tran vdout0_44ck1820 FIND v(dout0_44) AT=1830.05n

.meas tran vdout0_45ck1820 FIND v(dout0_45) AT=1830.05n

.meas tran vdout0_46ck1820 FIND v(dout0_46) AT=1830.05n

.meas tran vdout0_47ck1820 FIND v(dout0_47) AT=1830.05n

.meas tran vdout0_48ck1820 FIND v(dout0_48) AT=1830.05n

.meas tran vdout0_49ck1820 FIND v(dout0_49) AT=1830.05n

.meas tran vdout0_50ck1820 FIND v(dout0_50) AT=1830.05n

.meas tran vdout0_51ck1820 FIND v(dout0_51) AT=1830.05n

.meas tran vdout0_52ck1820 FIND v(dout0_52) AT=1830.05n

.meas tran vdout0_53ck1820 FIND v(dout0_53) AT=1830.05n

.meas tran vdout0_54ck1820 FIND v(dout0_54) AT=1830.05n

.meas tran vdout0_55ck1820 FIND v(dout0_55) AT=1830.05n

.meas tran vdout0_56ck1820 FIND v(dout0_56) AT=1830.05n

.meas tran vdout0_57ck1820 FIND v(dout0_57) AT=1830.05n

.meas tran vdout0_58ck1820 FIND v(dout0_58) AT=1830.05n

.meas tran vdout0_59ck1820 FIND v(dout0_59) AT=1830.05n

.meas tran vdout0_60ck1820 FIND v(dout0_60) AT=1830.05n

.meas tran vdout0_61ck1820 FIND v(dout0_61) AT=1830.05n

.meas tran vdout0_62ck1820 FIND v(dout0_62) AT=1830.05n

.meas tran vdout0_63ck1820 FIND v(dout0_63) AT=1830.05n

.meas tran vdout0_64ck1820 FIND v(dout0_64) AT=1830.05n

.meas tran vdout0_0ck1840 FIND v(dout0_0) AT=1850.05n

.meas tran vdout0_1ck1840 FIND v(dout0_1) AT=1850.05n

.meas tran vdout0_2ck1840 FIND v(dout0_2) AT=1850.05n

.meas tran vdout0_3ck1840 FIND v(dout0_3) AT=1850.05n

.meas tran vdout0_4ck1840 FIND v(dout0_4) AT=1850.05n

.meas tran vdout0_5ck1840 FIND v(dout0_5) AT=1850.05n

.meas tran vdout0_6ck1840 FIND v(dout0_6) AT=1850.05n

.meas tran vdout0_7ck1840 FIND v(dout0_7) AT=1850.05n

.meas tran vdout0_8ck1840 FIND v(dout0_8) AT=1850.05n

.meas tran vdout0_9ck1840 FIND v(dout0_9) AT=1850.05n

.meas tran vdout0_10ck1840 FIND v(dout0_10) AT=1850.05n

.meas tran vdout0_11ck1840 FIND v(dout0_11) AT=1850.05n

.meas tran vdout0_12ck1840 FIND v(dout0_12) AT=1850.05n

.meas tran vdout0_13ck1840 FIND v(dout0_13) AT=1850.05n

.meas tran vdout0_14ck1840 FIND v(dout0_14) AT=1850.05n

.meas tran vdout0_15ck1840 FIND v(dout0_15) AT=1850.05n

.meas tran vdout0_16ck1840 FIND v(dout0_16) AT=1850.05n

.meas tran vdout0_17ck1840 FIND v(dout0_17) AT=1850.05n

.meas tran vdout0_18ck1840 FIND v(dout0_18) AT=1850.05n

.meas tran vdout0_19ck1840 FIND v(dout0_19) AT=1850.05n

.meas tran vdout0_20ck1840 FIND v(dout0_20) AT=1850.05n

.meas tran vdout0_21ck1840 FIND v(dout0_21) AT=1850.05n

.meas tran vdout0_22ck1840 FIND v(dout0_22) AT=1850.05n

.meas tran vdout0_23ck1840 FIND v(dout0_23) AT=1850.05n

.meas tran vdout0_24ck1840 FIND v(dout0_24) AT=1850.05n

.meas tran vdout0_25ck1840 FIND v(dout0_25) AT=1850.05n

.meas tran vdout0_26ck1840 FIND v(dout0_26) AT=1850.05n

.meas tran vdout0_27ck1840 FIND v(dout0_27) AT=1850.05n

.meas tran vdout0_28ck1840 FIND v(dout0_28) AT=1850.05n

.meas tran vdout0_29ck1840 FIND v(dout0_29) AT=1850.05n

.meas tran vdout0_30ck1840 FIND v(dout0_30) AT=1850.05n

.meas tran vdout0_31ck1840 FIND v(dout0_31) AT=1850.05n

.meas tran vdout0_32ck1840 FIND v(dout0_32) AT=1850.05n

.meas tran vdout0_33ck1840 FIND v(dout0_33) AT=1850.05n

.meas tran vdout0_34ck1840 FIND v(dout0_34) AT=1850.05n

.meas tran vdout0_35ck1840 FIND v(dout0_35) AT=1850.05n

.meas tran vdout0_36ck1840 FIND v(dout0_36) AT=1850.05n

.meas tran vdout0_37ck1840 FIND v(dout0_37) AT=1850.05n

.meas tran vdout0_38ck1840 FIND v(dout0_38) AT=1850.05n

.meas tran vdout0_39ck1840 FIND v(dout0_39) AT=1850.05n

.meas tran vdout0_40ck1840 FIND v(dout0_40) AT=1850.05n

.meas tran vdout0_41ck1840 FIND v(dout0_41) AT=1850.05n

.meas tran vdout0_42ck1840 FIND v(dout0_42) AT=1850.05n

.meas tran vdout0_43ck1840 FIND v(dout0_43) AT=1850.05n

.meas tran vdout0_44ck1840 FIND v(dout0_44) AT=1850.05n

.meas tran vdout0_45ck1840 FIND v(dout0_45) AT=1850.05n

.meas tran vdout0_46ck1840 FIND v(dout0_46) AT=1850.05n

.meas tran vdout0_47ck1840 FIND v(dout0_47) AT=1850.05n

.meas tran vdout0_48ck1840 FIND v(dout0_48) AT=1850.05n

.meas tran vdout0_49ck1840 FIND v(dout0_49) AT=1850.05n

.meas tran vdout0_50ck1840 FIND v(dout0_50) AT=1850.05n

.meas tran vdout0_51ck1840 FIND v(dout0_51) AT=1850.05n

.meas tran vdout0_52ck1840 FIND v(dout0_52) AT=1850.05n

.meas tran vdout0_53ck1840 FIND v(dout0_53) AT=1850.05n

.meas tran vdout0_54ck1840 FIND v(dout0_54) AT=1850.05n

.meas tran vdout0_55ck1840 FIND v(dout0_55) AT=1850.05n

.meas tran vdout0_56ck1840 FIND v(dout0_56) AT=1850.05n

.meas tran vdout0_57ck1840 FIND v(dout0_57) AT=1850.05n

.meas tran vdout0_58ck1840 FIND v(dout0_58) AT=1850.05n

.meas tran vdout0_59ck1840 FIND v(dout0_59) AT=1850.05n

.meas tran vdout0_60ck1840 FIND v(dout0_60) AT=1850.05n

.meas tran vdout0_61ck1840 FIND v(dout0_61) AT=1850.05n

.meas tran vdout0_62ck1840 FIND v(dout0_62) AT=1850.05n

.meas tran vdout0_63ck1840 FIND v(dout0_63) AT=1850.05n

.meas tran vdout0_64ck1840 FIND v(dout0_64) AT=1850.05n

.meas tran vdout0_0ck1850 FIND v(dout0_0) AT=1860.05n

.meas tran vdout0_1ck1850 FIND v(dout0_1) AT=1860.05n

.meas tran vdout0_2ck1850 FIND v(dout0_2) AT=1860.05n

.meas tran vdout0_3ck1850 FIND v(dout0_3) AT=1860.05n

.meas tran vdout0_4ck1850 FIND v(dout0_4) AT=1860.05n

.meas tran vdout0_5ck1850 FIND v(dout0_5) AT=1860.05n

.meas tran vdout0_6ck1850 FIND v(dout0_6) AT=1860.05n

.meas tran vdout0_7ck1850 FIND v(dout0_7) AT=1860.05n

.meas tran vdout0_8ck1850 FIND v(dout0_8) AT=1860.05n

.meas tran vdout0_9ck1850 FIND v(dout0_9) AT=1860.05n

.meas tran vdout0_10ck1850 FIND v(dout0_10) AT=1860.05n

.meas tran vdout0_11ck1850 FIND v(dout0_11) AT=1860.05n

.meas tran vdout0_12ck1850 FIND v(dout0_12) AT=1860.05n

.meas tran vdout0_13ck1850 FIND v(dout0_13) AT=1860.05n

.meas tran vdout0_14ck1850 FIND v(dout0_14) AT=1860.05n

.meas tran vdout0_15ck1850 FIND v(dout0_15) AT=1860.05n

.meas tran vdout0_16ck1850 FIND v(dout0_16) AT=1860.05n

.meas tran vdout0_17ck1850 FIND v(dout0_17) AT=1860.05n

.meas tran vdout0_18ck1850 FIND v(dout0_18) AT=1860.05n

.meas tran vdout0_19ck1850 FIND v(dout0_19) AT=1860.05n

.meas tran vdout0_20ck1850 FIND v(dout0_20) AT=1860.05n

.meas tran vdout0_21ck1850 FIND v(dout0_21) AT=1860.05n

.meas tran vdout0_22ck1850 FIND v(dout0_22) AT=1860.05n

.meas tran vdout0_23ck1850 FIND v(dout0_23) AT=1860.05n

.meas tran vdout0_24ck1850 FIND v(dout0_24) AT=1860.05n

.meas tran vdout0_25ck1850 FIND v(dout0_25) AT=1860.05n

.meas tran vdout0_26ck1850 FIND v(dout0_26) AT=1860.05n

.meas tran vdout0_27ck1850 FIND v(dout0_27) AT=1860.05n

.meas tran vdout0_28ck1850 FIND v(dout0_28) AT=1860.05n

.meas tran vdout0_29ck1850 FIND v(dout0_29) AT=1860.05n

.meas tran vdout0_30ck1850 FIND v(dout0_30) AT=1860.05n

.meas tran vdout0_31ck1850 FIND v(dout0_31) AT=1860.05n

.meas tran vdout0_32ck1850 FIND v(dout0_32) AT=1860.05n

.meas tran vdout0_33ck1850 FIND v(dout0_33) AT=1860.05n

.meas tran vdout0_34ck1850 FIND v(dout0_34) AT=1860.05n

.meas tran vdout0_35ck1850 FIND v(dout0_35) AT=1860.05n

.meas tran vdout0_36ck1850 FIND v(dout0_36) AT=1860.05n

.meas tran vdout0_37ck1850 FIND v(dout0_37) AT=1860.05n

.meas tran vdout0_38ck1850 FIND v(dout0_38) AT=1860.05n

.meas tran vdout0_39ck1850 FIND v(dout0_39) AT=1860.05n

.meas tran vdout0_40ck1850 FIND v(dout0_40) AT=1860.05n

.meas tran vdout0_41ck1850 FIND v(dout0_41) AT=1860.05n

.meas tran vdout0_42ck1850 FIND v(dout0_42) AT=1860.05n

.meas tran vdout0_43ck1850 FIND v(dout0_43) AT=1860.05n

.meas tran vdout0_44ck1850 FIND v(dout0_44) AT=1860.05n

.meas tran vdout0_45ck1850 FIND v(dout0_45) AT=1860.05n

.meas tran vdout0_46ck1850 FIND v(dout0_46) AT=1860.05n

.meas tran vdout0_47ck1850 FIND v(dout0_47) AT=1860.05n

.meas tran vdout0_48ck1850 FIND v(dout0_48) AT=1860.05n

.meas tran vdout0_49ck1850 FIND v(dout0_49) AT=1860.05n

.meas tran vdout0_50ck1850 FIND v(dout0_50) AT=1860.05n

.meas tran vdout0_51ck1850 FIND v(dout0_51) AT=1860.05n

.meas tran vdout0_52ck1850 FIND v(dout0_52) AT=1860.05n

.meas tran vdout0_53ck1850 FIND v(dout0_53) AT=1860.05n

.meas tran vdout0_54ck1850 FIND v(dout0_54) AT=1860.05n

.meas tran vdout0_55ck1850 FIND v(dout0_55) AT=1860.05n

.meas tran vdout0_56ck1850 FIND v(dout0_56) AT=1860.05n

.meas tran vdout0_57ck1850 FIND v(dout0_57) AT=1860.05n

.meas tran vdout0_58ck1850 FIND v(dout0_58) AT=1860.05n

.meas tran vdout0_59ck1850 FIND v(dout0_59) AT=1860.05n

.meas tran vdout0_60ck1850 FIND v(dout0_60) AT=1860.05n

.meas tran vdout0_61ck1850 FIND v(dout0_61) AT=1860.05n

.meas tran vdout0_62ck1850 FIND v(dout0_62) AT=1860.05n

.meas tran vdout0_63ck1850 FIND v(dout0_63) AT=1860.05n

.meas tran vdout0_64ck1850 FIND v(dout0_64) AT=1860.05n

.meas tran vdout0_0ck1860 FIND v(dout0_0) AT=1870.05n

.meas tran vdout0_1ck1860 FIND v(dout0_1) AT=1870.05n

.meas tran vdout0_2ck1860 FIND v(dout0_2) AT=1870.05n

.meas tran vdout0_3ck1860 FIND v(dout0_3) AT=1870.05n

.meas tran vdout0_4ck1860 FIND v(dout0_4) AT=1870.05n

.meas tran vdout0_5ck1860 FIND v(dout0_5) AT=1870.05n

.meas tran vdout0_6ck1860 FIND v(dout0_6) AT=1870.05n

.meas tran vdout0_7ck1860 FIND v(dout0_7) AT=1870.05n

.meas tran vdout0_8ck1860 FIND v(dout0_8) AT=1870.05n

.meas tran vdout0_9ck1860 FIND v(dout0_9) AT=1870.05n

.meas tran vdout0_10ck1860 FIND v(dout0_10) AT=1870.05n

.meas tran vdout0_11ck1860 FIND v(dout0_11) AT=1870.05n

.meas tran vdout0_12ck1860 FIND v(dout0_12) AT=1870.05n

.meas tran vdout0_13ck1860 FIND v(dout0_13) AT=1870.05n

.meas tran vdout0_14ck1860 FIND v(dout0_14) AT=1870.05n

.meas tran vdout0_15ck1860 FIND v(dout0_15) AT=1870.05n

.meas tran vdout0_16ck1860 FIND v(dout0_16) AT=1870.05n

.meas tran vdout0_17ck1860 FIND v(dout0_17) AT=1870.05n

.meas tran vdout0_18ck1860 FIND v(dout0_18) AT=1870.05n

.meas tran vdout0_19ck1860 FIND v(dout0_19) AT=1870.05n

.meas tran vdout0_20ck1860 FIND v(dout0_20) AT=1870.05n

.meas tran vdout0_21ck1860 FIND v(dout0_21) AT=1870.05n

.meas tran vdout0_22ck1860 FIND v(dout0_22) AT=1870.05n

.meas tran vdout0_23ck1860 FIND v(dout0_23) AT=1870.05n

.meas tran vdout0_24ck1860 FIND v(dout0_24) AT=1870.05n

.meas tran vdout0_25ck1860 FIND v(dout0_25) AT=1870.05n

.meas tran vdout0_26ck1860 FIND v(dout0_26) AT=1870.05n

.meas tran vdout0_27ck1860 FIND v(dout0_27) AT=1870.05n

.meas tran vdout0_28ck1860 FIND v(dout0_28) AT=1870.05n

.meas tran vdout0_29ck1860 FIND v(dout0_29) AT=1870.05n

.meas tran vdout0_30ck1860 FIND v(dout0_30) AT=1870.05n

.meas tran vdout0_31ck1860 FIND v(dout0_31) AT=1870.05n

.meas tran vdout0_32ck1860 FIND v(dout0_32) AT=1870.05n

.meas tran vdout0_33ck1860 FIND v(dout0_33) AT=1870.05n

.meas tran vdout0_34ck1860 FIND v(dout0_34) AT=1870.05n

.meas tran vdout0_35ck1860 FIND v(dout0_35) AT=1870.05n

.meas tran vdout0_36ck1860 FIND v(dout0_36) AT=1870.05n

.meas tran vdout0_37ck1860 FIND v(dout0_37) AT=1870.05n

.meas tran vdout0_38ck1860 FIND v(dout0_38) AT=1870.05n

.meas tran vdout0_39ck1860 FIND v(dout0_39) AT=1870.05n

.meas tran vdout0_40ck1860 FIND v(dout0_40) AT=1870.05n

.meas tran vdout0_41ck1860 FIND v(dout0_41) AT=1870.05n

.meas tran vdout0_42ck1860 FIND v(dout0_42) AT=1870.05n

.meas tran vdout0_43ck1860 FIND v(dout0_43) AT=1870.05n

.meas tran vdout0_44ck1860 FIND v(dout0_44) AT=1870.05n

.meas tran vdout0_45ck1860 FIND v(dout0_45) AT=1870.05n

.meas tran vdout0_46ck1860 FIND v(dout0_46) AT=1870.05n

.meas tran vdout0_47ck1860 FIND v(dout0_47) AT=1870.05n

.meas tran vdout0_48ck1860 FIND v(dout0_48) AT=1870.05n

.meas tran vdout0_49ck1860 FIND v(dout0_49) AT=1870.05n

.meas tran vdout0_50ck1860 FIND v(dout0_50) AT=1870.05n

.meas tran vdout0_51ck1860 FIND v(dout0_51) AT=1870.05n

.meas tran vdout0_52ck1860 FIND v(dout0_52) AT=1870.05n

.meas tran vdout0_53ck1860 FIND v(dout0_53) AT=1870.05n

.meas tran vdout0_54ck1860 FIND v(dout0_54) AT=1870.05n

.meas tran vdout0_55ck1860 FIND v(dout0_55) AT=1870.05n

.meas tran vdout0_56ck1860 FIND v(dout0_56) AT=1870.05n

.meas tran vdout0_57ck1860 FIND v(dout0_57) AT=1870.05n

.meas tran vdout0_58ck1860 FIND v(dout0_58) AT=1870.05n

.meas tran vdout0_59ck1860 FIND v(dout0_59) AT=1870.05n

.meas tran vdout0_60ck1860 FIND v(dout0_60) AT=1870.05n

.meas tran vdout0_61ck1860 FIND v(dout0_61) AT=1870.05n

.meas tran vdout0_62ck1860 FIND v(dout0_62) AT=1870.05n

.meas tran vdout0_63ck1860 FIND v(dout0_63) AT=1870.05n

.meas tran vdout0_64ck1860 FIND v(dout0_64) AT=1870.05n

.meas tran vdout0_0ck1900 FIND v(dout0_0) AT=1910.05n

.meas tran vdout0_1ck1900 FIND v(dout0_1) AT=1910.05n

.meas tran vdout0_2ck1900 FIND v(dout0_2) AT=1910.05n

.meas tran vdout0_3ck1900 FIND v(dout0_3) AT=1910.05n

.meas tran vdout0_4ck1900 FIND v(dout0_4) AT=1910.05n

.meas tran vdout0_5ck1900 FIND v(dout0_5) AT=1910.05n

.meas tran vdout0_6ck1900 FIND v(dout0_6) AT=1910.05n

.meas tran vdout0_7ck1900 FIND v(dout0_7) AT=1910.05n

.meas tran vdout0_8ck1900 FIND v(dout0_8) AT=1910.05n

.meas tran vdout0_9ck1900 FIND v(dout0_9) AT=1910.05n

.meas tran vdout0_10ck1900 FIND v(dout0_10) AT=1910.05n

.meas tran vdout0_11ck1900 FIND v(dout0_11) AT=1910.05n

.meas tran vdout0_12ck1900 FIND v(dout0_12) AT=1910.05n

.meas tran vdout0_13ck1900 FIND v(dout0_13) AT=1910.05n

.meas tran vdout0_14ck1900 FIND v(dout0_14) AT=1910.05n

.meas tran vdout0_15ck1900 FIND v(dout0_15) AT=1910.05n

.meas tran vdout0_16ck1900 FIND v(dout0_16) AT=1910.05n

.meas tran vdout0_17ck1900 FIND v(dout0_17) AT=1910.05n

.meas tran vdout0_18ck1900 FIND v(dout0_18) AT=1910.05n

.meas tran vdout0_19ck1900 FIND v(dout0_19) AT=1910.05n

.meas tran vdout0_20ck1900 FIND v(dout0_20) AT=1910.05n

.meas tran vdout0_21ck1900 FIND v(dout0_21) AT=1910.05n

.meas tran vdout0_22ck1900 FIND v(dout0_22) AT=1910.05n

.meas tran vdout0_23ck1900 FIND v(dout0_23) AT=1910.05n

.meas tran vdout0_24ck1900 FIND v(dout0_24) AT=1910.05n

.meas tran vdout0_25ck1900 FIND v(dout0_25) AT=1910.05n

.meas tran vdout0_26ck1900 FIND v(dout0_26) AT=1910.05n

.meas tran vdout0_27ck1900 FIND v(dout0_27) AT=1910.05n

.meas tran vdout0_28ck1900 FIND v(dout0_28) AT=1910.05n

.meas tran vdout0_29ck1900 FIND v(dout0_29) AT=1910.05n

.meas tran vdout0_30ck1900 FIND v(dout0_30) AT=1910.05n

.meas tran vdout0_31ck1900 FIND v(dout0_31) AT=1910.05n

.meas tran vdout0_32ck1900 FIND v(dout0_32) AT=1910.05n

.meas tran vdout0_33ck1900 FIND v(dout0_33) AT=1910.05n

.meas tran vdout0_34ck1900 FIND v(dout0_34) AT=1910.05n

.meas tran vdout0_35ck1900 FIND v(dout0_35) AT=1910.05n

.meas tran vdout0_36ck1900 FIND v(dout0_36) AT=1910.05n

.meas tran vdout0_37ck1900 FIND v(dout0_37) AT=1910.05n

.meas tran vdout0_38ck1900 FIND v(dout0_38) AT=1910.05n

.meas tran vdout0_39ck1900 FIND v(dout0_39) AT=1910.05n

.meas tran vdout0_40ck1900 FIND v(dout0_40) AT=1910.05n

.meas tran vdout0_41ck1900 FIND v(dout0_41) AT=1910.05n

.meas tran vdout0_42ck1900 FIND v(dout0_42) AT=1910.05n

.meas tran vdout0_43ck1900 FIND v(dout0_43) AT=1910.05n

.meas tran vdout0_44ck1900 FIND v(dout0_44) AT=1910.05n

.meas tran vdout0_45ck1900 FIND v(dout0_45) AT=1910.05n

.meas tran vdout0_46ck1900 FIND v(dout0_46) AT=1910.05n

.meas tran vdout0_47ck1900 FIND v(dout0_47) AT=1910.05n

.meas tran vdout0_48ck1900 FIND v(dout0_48) AT=1910.05n

.meas tran vdout0_49ck1900 FIND v(dout0_49) AT=1910.05n

.meas tran vdout0_50ck1900 FIND v(dout0_50) AT=1910.05n

.meas tran vdout0_51ck1900 FIND v(dout0_51) AT=1910.05n

.meas tran vdout0_52ck1900 FIND v(dout0_52) AT=1910.05n

.meas tran vdout0_53ck1900 FIND v(dout0_53) AT=1910.05n

.meas tran vdout0_54ck1900 FIND v(dout0_54) AT=1910.05n

.meas tran vdout0_55ck1900 FIND v(dout0_55) AT=1910.05n

.meas tran vdout0_56ck1900 FIND v(dout0_56) AT=1910.05n

.meas tran vdout0_57ck1900 FIND v(dout0_57) AT=1910.05n

.meas tran vdout0_58ck1900 FIND v(dout0_58) AT=1910.05n

.meas tran vdout0_59ck1900 FIND v(dout0_59) AT=1910.05n

.meas tran vdout0_60ck1900 FIND v(dout0_60) AT=1910.05n

.meas tran vdout0_61ck1900 FIND v(dout0_61) AT=1910.05n

.meas tran vdout0_62ck1900 FIND v(dout0_62) AT=1910.05n

.meas tran vdout0_63ck1900 FIND v(dout0_63) AT=1910.05n

.meas tran vdout0_64ck1900 FIND v(dout0_64) AT=1910.05n

.meas tran vdout0_0ck1910 FIND v(dout0_0) AT=1920.05n

.meas tran vdout0_1ck1910 FIND v(dout0_1) AT=1920.05n

.meas tran vdout0_2ck1910 FIND v(dout0_2) AT=1920.05n

.meas tran vdout0_3ck1910 FIND v(dout0_3) AT=1920.05n

.meas tran vdout0_4ck1910 FIND v(dout0_4) AT=1920.05n

.meas tran vdout0_5ck1910 FIND v(dout0_5) AT=1920.05n

.meas tran vdout0_6ck1910 FIND v(dout0_6) AT=1920.05n

.meas tran vdout0_7ck1910 FIND v(dout0_7) AT=1920.05n

.meas tran vdout0_8ck1910 FIND v(dout0_8) AT=1920.05n

.meas tran vdout0_9ck1910 FIND v(dout0_9) AT=1920.05n

.meas tran vdout0_10ck1910 FIND v(dout0_10) AT=1920.05n

.meas tran vdout0_11ck1910 FIND v(dout0_11) AT=1920.05n

.meas tran vdout0_12ck1910 FIND v(dout0_12) AT=1920.05n

.meas tran vdout0_13ck1910 FIND v(dout0_13) AT=1920.05n

.meas tran vdout0_14ck1910 FIND v(dout0_14) AT=1920.05n

.meas tran vdout0_15ck1910 FIND v(dout0_15) AT=1920.05n

.meas tran vdout0_16ck1910 FIND v(dout0_16) AT=1920.05n

.meas tran vdout0_17ck1910 FIND v(dout0_17) AT=1920.05n

.meas tran vdout0_18ck1910 FIND v(dout0_18) AT=1920.05n

.meas tran vdout0_19ck1910 FIND v(dout0_19) AT=1920.05n

.meas tran vdout0_20ck1910 FIND v(dout0_20) AT=1920.05n

.meas tran vdout0_21ck1910 FIND v(dout0_21) AT=1920.05n

.meas tran vdout0_22ck1910 FIND v(dout0_22) AT=1920.05n

.meas tran vdout0_23ck1910 FIND v(dout0_23) AT=1920.05n

.meas tran vdout0_24ck1910 FIND v(dout0_24) AT=1920.05n

.meas tran vdout0_25ck1910 FIND v(dout0_25) AT=1920.05n

.meas tran vdout0_26ck1910 FIND v(dout0_26) AT=1920.05n

.meas tran vdout0_27ck1910 FIND v(dout0_27) AT=1920.05n

.meas tran vdout0_28ck1910 FIND v(dout0_28) AT=1920.05n

.meas tran vdout0_29ck1910 FIND v(dout0_29) AT=1920.05n

.meas tran vdout0_30ck1910 FIND v(dout0_30) AT=1920.05n

.meas tran vdout0_31ck1910 FIND v(dout0_31) AT=1920.05n

.meas tran vdout0_32ck1910 FIND v(dout0_32) AT=1920.05n

.meas tran vdout0_33ck1910 FIND v(dout0_33) AT=1920.05n

.meas tran vdout0_34ck1910 FIND v(dout0_34) AT=1920.05n

.meas tran vdout0_35ck1910 FIND v(dout0_35) AT=1920.05n

.meas tran vdout0_36ck1910 FIND v(dout0_36) AT=1920.05n

.meas tran vdout0_37ck1910 FIND v(dout0_37) AT=1920.05n

.meas tran vdout0_38ck1910 FIND v(dout0_38) AT=1920.05n

.meas tran vdout0_39ck1910 FIND v(dout0_39) AT=1920.05n

.meas tran vdout0_40ck1910 FIND v(dout0_40) AT=1920.05n

.meas tran vdout0_41ck1910 FIND v(dout0_41) AT=1920.05n

.meas tran vdout0_42ck1910 FIND v(dout0_42) AT=1920.05n

.meas tran vdout0_43ck1910 FIND v(dout0_43) AT=1920.05n

.meas tran vdout0_44ck1910 FIND v(dout0_44) AT=1920.05n

.meas tran vdout0_45ck1910 FIND v(dout0_45) AT=1920.05n

.meas tran vdout0_46ck1910 FIND v(dout0_46) AT=1920.05n

.meas tran vdout0_47ck1910 FIND v(dout0_47) AT=1920.05n

.meas tran vdout0_48ck1910 FIND v(dout0_48) AT=1920.05n

.meas tran vdout0_49ck1910 FIND v(dout0_49) AT=1920.05n

.meas tran vdout0_50ck1910 FIND v(dout0_50) AT=1920.05n

.meas tran vdout0_51ck1910 FIND v(dout0_51) AT=1920.05n

.meas tran vdout0_52ck1910 FIND v(dout0_52) AT=1920.05n

.meas tran vdout0_53ck1910 FIND v(dout0_53) AT=1920.05n

.meas tran vdout0_54ck1910 FIND v(dout0_54) AT=1920.05n

.meas tran vdout0_55ck1910 FIND v(dout0_55) AT=1920.05n

.meas tran vdout0_56ck1910 FIND v(dout0_56) AT=1920.05n

.meas tran vdout0_57ck1910 FIND v(dout0_57) AT=1920.05n

.meas tran vdout0_58ck1910 FIND v(dout0_58) AT=1920.05n

.meas tran vdout0_59ck1910 FIND v(dout0_59) AT=1920.05n

.meas tran vdout0_60ck1910 FIND v(dout0_60) AT=1920.05n

.meas tran vdout0_61ck1910 FIND v(dout0_61) AT=1920.05n

.meas tran vdout0_62ck1910 FIND v(dout0_62) AT=1920.05n

.meas tran vdout0_63ck1910 FIND v(dout0_63) AT=1920.05n

.meas tran vdout0_64ck1910 FIND v(dout0_64) AT=1920.05n

.meas tran vdout0_0ck1940 FIND v(dout0_0) AT=1950.05n

.meas tran vdout0_1ck1940 FIND v(dout0_1) AT=1950.05n

.meas tran vdout0_2ck1940 FIND v(dout0_2) AT=1950.05n

.meas tran vdout0_3ck1940 FIND v(dout0_3) AT=1950.05n

.meas tran vdout0_4ck1940 FIND v(dout0_4) AT=1950.05n

.meas tran vdout0_5ck1940 FIND v(dout0_5) AT=1950.05n

.meas tran vdout0_6ck1940 FIND v(dout0_6) AT=1950.05n

.meas tran vdout0_7ck1940 FIND v(dout0_7) AT=1950.05n

.meas tran vdout0_8ck1940 FIND v(dout0_8) AT=1950.05n

.meas tran vdout0_9ck1940 FIND v(dout0_9) AT=1950.05n

.meas tran vdout0_10ck1940 FIND v(dout0_10) AT=1950.05n

.meas tran vdout0_11ck1940 FIND v(dout0_11) AT=1950.05n

.meas tran vdout0_12ck1940 FIND v(dout0_12) AT=1950.05n

.meas tran vdout0_13ck1940 FIND v(dout0_13) AT=1950.05n

.meas tran vdout0_14ck1940 FIND v(dout0_14) AT=1950.05n

.meas tran vdout0_15ck1940 FIND v(dout0_15) AT=1950.05n

.meas tran vdout0_16ck1940 FIND v(dout0_16) AT=1950.05n

.meas tran vdout0_17ck1940 FIND v(dout0_17) AT=1950.05n

.meas tran vdout0_18ck1940 FIND v(dout0_18) AT=1950.05n

.meas tran vdout0_19ck1940 FIND v(dout0_19) AT=1950.05n

.meas tran vdout0_20ck1940 FIND v(dout0_20) AT=1950.05n

.meas tran vdout0_21ck1940 FIND v(dout0_21) AT=1950.05n

.meas tran vdout0_22ck1940 FIND v(dout0_22) AT=1950.05n

.meas tran vdout0_23ck1940 FIND v(dout0_23) AT=1950.05n

.meas tran vdout0_24ck1940 FIND v(dout0_24) AT=1950.05n

.meas tran vdout0_25ck1940 FIND v(dout0_25) AT=1950.05n

.meas tran vdout0_26ck1940 FIND v(dout0_26) AT=1950.05n

.meas tran vdout0_27ck1940 FIND v(dout0_27) AT=1950.05n

.meas tran vdout0_28ck1940 FIND v(dout0_28) AT=1950.05n

.meas tran vdout0_29ck1940 FIND v(dout0_29) AT=1950.05n

.meas tran vdout0_30ck1940 FIND v(dout0_30) AT=1950.05n

.meas tran vdout0_31ck1940 FIND v(dout0_31) AT=1950.05n

.meas tran vdout0_32ck1940 FIND v(dout0_32) AT=1950.05n

.meas tran vdout0_33ck1940 FIND v(dout0_33) AT=1950.05n

.meas tran vdout0_34ck1940 FIND v(dout0_34) AT=1950.05n

.meas tran vdout0_35ck1940 FIND v(dout0_35) AT=1950.05n

.meas tran vdout0_36ck1940 FIND v(dout0_36) AT=1950.05n

.meas tran vdout0_37ck1940 FIND v(dout0_37) AT=1950.05n

.meas tran vdout0_38ck1940 FIND v(dout0_38) AT=1950.05n

.meas tran vdout0_39ck1940 FIND v(dout0_39) AT=1950.05n

.meas tran vdout0_40ck1940 FIND v(dout0_40) AT=1950.05n

.meas tran vdout0_41ck1940 FIND v(dout0_41) AT=1950.05n

.meas tran vdout0_42ck1940 FIND v(dout0_42) AT=1950.05n

.meas tran vdout0_43ck1940 FIND v(dout0_43) AT=1950.05n

.meas tran vdout0_44ck1940 FIND v(dout0_44) AT=1950.05n

.meas tran vdout0_45ck1940 FIND v(dout0_45) AT=1950.05n

.meas tran vdout0_46ck1940 FIND v(dout0_46) AT=1950.05n

.meas tran vdout0_47ck1940 FIND v(dout0_47) AT=1950.05n

.meas tran vdout0_48ck1940 FIND v(dout0_48) AT=1950.05n

.meas tran vdout0_49ck1940 FIND v(dout0_49) AT=1950.05n

.meas tran vdout0_50ck1940 FIND v(dout0_50) AT=1950.05n

.meas tran vdout0_51ck1940 FIND v(dout0_51) AT=1950.05n

.meas tran vdout0_52ck1940 FIND v(dout0_52) AT=1950.05n

.meas tran vdout0_53ck1940 FIND v(dout0_53) AT=1950.05n

.meas tran vdout0_54ck1940 FIND v(dout0_54) AT=1950.05n

.meas tran vdout0_55ck1940 FIND v(dout0_55) AT=1950.05n

.meas tran vdout0_56ck1940 FIND v(dout0_56) AT=1950.05n

.meas tran vdout0_57ck1940 FIND v(dout0_57) AT=1950.05n

.meas tran vdout0_58ck1940 FIND v(dout0_58) AT=1950.05n

.meas tran vdout0_59ck1940 FIND v(dout0_59) AT=1950.05n

.meas tran vdout0_60ck1940 FIND v(dout0_60) AT=1950.05n

.meas tran vdout0_61ck1940 FIND v(dout0_61) AT=1950.05n

.meas tran vdout0_62ck1940 FIND v(dout0_62) AT=1950.05n

.meas tran vdout0_63ck1940 FIND v(dout0_63) AT=1950.05n

.meas tran vdout0_64ck1940 FIND v(dout0_64) AT=1950.05n

.meas tran vdout0_0ck1950 FIND v(dout0_0) AT=1960.05n

.meas tran vdout0_1ck1950 FIND v(dout0_1) AT=1960.05n

.meas tran vdout0_2ck1950 FIND v(dout0_2) AT=1960.05n

.meas tran vdout0_3ck1950 FIND v(dout0_3) AT=1960.05n

.meas tran vdout0_4ck1950 FIND v(dout0_4) AT=1960.05n

.meas tran vdout0_5ck1950 FIND v(dout0_5) AT=1960.05n

.meas tran vdout0_6ck1950 FIND v(dout0_6) AT=1960.05n

.meas tran vdout0_7ck1950 FIND v(dout0_7) AT=1960.05n

.meas tran vdout0_8ck1950 FIND v(dout0_8) AT=1960.05n

.meas tran vdout0_9ck1950 FIND v(dout0_9) AT=1960.05n

.meas tran vdout0_10ck1950 FIND v(dout0_10) AT=1960.05n

.meas tran vdout0_11ck1950 FIND v(dout0_11) AT=1960.05n

.meas tran vdout0_12ck1950 FIND v(dout0_12) AT=1960.05n

.meas tran vdout0_13ck1950 FIND v(dout0_13) AT=1960.05n

.meas tran vdout0_14ck1950 FIND v(dout0_14) AT=1960.05n

.meas tran vdout0_15ck1950 FIND v(dout0_15) AT=1960.05n

.meas tran vdout0_16ck1950 FIND v(dout0_16) AT=1960.05n

.meas tran vdout0_17ck1950 FIND v(dout0_17) AT=1960.05n

.meas tran vdout0_18ck1950 FIND v(dout0_18) AT=1960.05n

.meas tran vdout0_19ck1950 FIND v(dout0_19) AT=1960.05n

.meas tran vdout0_20ck1950 FIND v(dout0_20) AT=1960.05n

.meas tran vdout0_21ck1950 FIND v(dout0_21) AT=1960.05n

.meas tran vdout0_22ck1950 FIND v(dout0_22) AT=1960.05n

.meas tran vdout0_23ck1950 FIND v(dout0_23) AT=1960.05n

.meas tran vdout0_24ck1950 FIND v(dout0_24) AT=1960.05n

.meas tran vdout0_25ck1950 FIND v(dout0_25) AT=1960.05n

.meas tran vdout0_26ck1950 FIND v(dout0_26) AT=1960.05n

.meas tran vdout0_27ck1950 FIND v(dout0_27) AT=1960.05n

.meas tran vdout0_28ck1950 FIND v(dout0_28) AT=1960.05n

.meas tran vdout0_29ck1950 FIND v(dout0_29) AT=1960.05n

.meas tran vdout0_30ck1950 FIND v(dout0_30) AT=1960.05n

.meas tran vdout0_31ck1950 FIND v(dout0_31) AT=1960.05n

.meas tran vdout0_32ck1950 FIND v(dout0_32) AT=1960.05n

.meas tran vdout0_33ck1950 FIND v(dout0_33) AT=1960.05n

.meas tran vdout0_34ck1950 FIND v(dout0_34) AT=1960.05n

.meas tran vdout0_35ck1950 FIND v(dout0_35) AT=1960.05n

.meas tran vdout0_36ck1950 FIND v(dout0_36) AT=1960.05n

.meas tran vdout0_37ck1950 FIND v(dout0_37) AT=1960.05n

.meas tran vdout0_38ck1950 FIND v(dout0_38) AT=1960.05n

.meas tran vdout0_39ck1950 FIND v(dout0_39) AT=1960.05n

.meas tran vdout0_40ck1950 FIND v(dout0_40) AT=1960.05n

.meas tran vdout0_41ck1950 FIND v(dout0_41) AT=1960.05n

.meas tran vdout0_42ck1950 FIND v(dout0_42) AT=1960.05n

.meas tran vdout0_43ck1950 FIND v(dout0_43) AT=1960.05n

.meas tran vdout0_44ck1950 FIND v(dout0_44) AT=1960.05n

.meas tran vdout0_45ck1950 FIND v(dout0_45) AT=1960.05n

.meas tran vdout0_46ck1950 FIND v(dout0_46) AT=1960.05n

.meas tran vdout0_47ck1950 FIND v(dout0_47) AT=1960.05n

.meas tran vdout0_48ck1950 FIND v(dout0_48) AT=1960.05n

.meas tran vdout0_49ck1950 FIND v(dout0_49) AT=1960.05n

.meas tran vdout0_50ck1950 FIND v(dout0_50) AT=1960.05n

.meas tran vdout0_51ck1950 FIND v(dout0_51) AT=1960.05n

.meas tran vdout0_52ck1950 FIND v(dout0_52) AT=1960.05n

.meas tran vdout0_53ck1950 FIND v(dout0_53) AT=1960.05n

.meas tran vdout0_54ck1950 FIND v(dout0_54) AT=1960.05n

.meas tran vdout0_55ck1950 FIND v(dout0_55) AT=1960.05n

.meas tran vdout0_56ck1950 FIND v(dout0_56) AT=1960.05n

.meas tran vdout0_57ck1950 FIND v(dout0_57) AT=1960.05n

.meas tran vdout0_58ck1950 FIND v(dout0_58) AT=1960.05n

.meas tran vdout0_59ck1950 FIND v(dout0_59) AT=1960.05n

.meas tran vdout0_60ck1950 FIND v(dout0_60) AT=1960.05n

.meas tran vdout0_61ck1950 FIND v(dout0_61) AT=1960.05n

.meas tran vdout0_62ck1950 FIND v(dout0_62) AT=1960.05n

.meas tran vdout0_63ck1950 FIND v(dout0_63) AT=1960.05n

.meas tran vdout0_64ck1950 FIND v(dout0_64) AT=1960.05n

.meas tran vdout0_0ck1980 FIND v(dout0_0) AT=1990.05n

.meas tran vdout0_1ck1980 FIND v(dout0_1) AT=1990.05n

.meas tran vdout0_2ck1980 FIND v(dout0_2) AT=1990.05n

.meas tran vdout0_3ck1980 FIND v(dout0_3) AT=1990.05n

.meas tran vdout0_4ck1980 FIND v(dout0_4) AT=1990.05n

.meas tran vdout0_5ck1980 FIND v(dout0_5) AT=1990.05n

.meas tran vdout0_6ck1980 FIND v(dout0_6) AT=1990.05n

.meas tran vdout0_7ck1980 FIND v(dout0_7) AT=1990.05n

.meas tran vdout0_8ck1980 FIND v(dout0_8) AT=1990.05n

.meas tran vdout0_9ck1980 FIND v(dout0_9) AT=1990.05n

.meas tran vdout0_10ck1980 FIND v(dout0_10) AT=1990.05n

.meas tran vdout0_11ck1980 FIND v(dout0_11) AT=1990.05n

.meas tran vdout0_12ck1980 FIND v(dout0_12) AT=1990.05n

.meas tran vdout0_13ck1980 FIND v(dout0_13) AT=1990.05n

.meas tran vdout0_14ck1980 FIND v(dout0_14) AT=1990.05n

.meas tran vdout0_15ck1980 FIND v(dout0_15) AT=1990.05n

.meas tran vdout0_16ck1980 FIND v(dout0_16) AT=1990.05n

.meas tran vdout0_17ck1980 FIND v(dout0_17) AT=1990.05n

.meas tran vdout0_18ck1980 FIND v(dout0_18) AT=1990.05n

.meas tran vdout0_19ck1980 FIND v(dout0_19) AT=1990.05n

.meas tran vdout0_20ck1980 FIND v(dout0_20) AT=1990.05n

.meas tran vdout0_21ck1980 FIND v(dout0_21) AT=1990.05n

.meas tran vdout0_22ck1980 FIND v(dout0_22) AT=1990.05n

.meas tran vdout0_23ck1980 FIND v(dout0_23) AT=1990.05n

.meas tran vdout0_24ck1980 FIND v(dout0_24) AT=1990.05n

.meas tran vdout0_25ck1980 FIND v(dout0_25) AT=1990.05n

.meas tran vdout0_26ck1980 FIND v(dout0_26) AT=1990.05n

.meas tran vdout0_27ck1980 FIND v(dout0_27) AT=1990.05n

.meas tran vdout0_28ck1980 FIND v(dout0_28) AT=1990.05n

.meas tran vdout0_29ck1980 FIND v(dout0_29) AT=1990.05n

.meas tran vdout0_30ck1980 FIND v(dout0_30) AT=1990.05n

.meas tran vdout0_31ck1980 FIND v(dout0_31) AT=1990.05n

.meas tran vdout0_32ck1980 FIND v(dout0_32) AT=1990.05n

.meas tran vdout0_33ck1980 FIND v(dout0_33) AT=1990.05n

.meas tran vdout0_34ck1980 FIND v(dout0_34) AT=1990.05n

.meas tran vdout0_35ck1980 FIND v(dout0_35) AT=1990.05n

.meas tran vdout0_36ck1980 FIND v(dout0_36) AT=1990.05n

.meas tran vdout0_37ck1980 FIND v(dout0_37) AT=1990.05n

.meas tran vdout0_38ck1980 FIND v(dout0_38) AT=1990.05n

.meas tran vdout0_39ck1980 FIND v(dout0_39) AT=1990.05n

.meas tran vdout0_40ck1980 FIND v(dout0_40) AT=1990.05n

.meas tran vdout0_41ck1980 FIND v(dout0_41) AT=1990.05n

.meas tran vdout0_42ck1980 FIND v(dout0_42) AT=1990.05n

.meas tran vdout0_43ck1980 FIND v(dout0_43) AT=1990.05n

.meas tran vdout0_44ck1980 FIND v(dout0_44) AT=1990.05n

.meas tran vdout0_45ck1980 FIND v(dout0_45) AT=1990.05n

.meas tran vdout0_46ck1980 FIND v(dout0_46) AT=1990.05n

.meas tran vdout0_47ck1980 FIND v(dout0_47) AT=1990.05n

.meas tran vdout0_48ck1980 FIND v(dout0_48) AT=1990.05n

.meas tran vdout0_49ck1980 FIND v(dout0_49) AT=1990.05n

.meas tran vdout0_50ck1980 FIND v(dout0_50) AT=1990.05n

.meas tran vdout0_51ck1980 FIND v(dout0_51) AT=1990.05n

.meas tran vdout0_52ck1980 FIND v(dout0_52) AT=1990.05n

.meas tran vdout0_53ck1980 FIND v(dout0_53) AT=1990.05n

.meas tran vdout0_54ck1980 FIND v(dout0_54) AT=1990.05n

.meas tran vdout0_55ck1980 FIND v(dout0_55) AT=1990.05n

.meas tran vdout0_56ck1980 FIND v(dout0_56) AT=1990.05n

.meas tran vdout0_57ck1980 FIND v(dout0_57) AT=1990.05n

.meas tran vdout0_58ck1980 FIND v(dout0_58) AT=1990.05n

.meas tran vdout0_59ck1980 FIND v(dout0_59) AT=1990.05n

.meas tran vdout0_60ck1980 FIND v(dout0_60) AT=1990.05n

.meas tran vdout0_61ck1980 FIND v(dout0_61) AT=1990.05n

.meas tran vdout0_62ck1980 FIND v(dout0_62) AT=1990.05n

.meas tran vdout0_63ck1980 FIND v(dout0_63) AT=1990.05n

.meas tran vdout0_64ck1980 FIND v(dout0_64) AT=1990.05n

.meas tran vdout0_0ck1990 FIND v(dout0_0) AT=2000.05n

.meas tran vdout0_1ck1990 FIND v(dout0_1) AT=2000.05n

.meas tran vdout0_2ck1990 FIND v(dout0_2) AT=2000.05n

.meas tran vdout0_3ck1990 FIND v(dout0_3) AT=2000.05n

.meas tran vdout0_4ck1990 FIND v(dout0_4) AT=2000.05n

.meas tran vdout0_5ck1990 FIND v(dout0_5) AT=2000.05n

.meas tran vdout0_6ck1990 FIND v(dout0_6) AT=2000.05n

.meas tran vdout0_7ck1990 FIND v(dout0_7) AT=2000.05n

.meas tran vdout0_8ck1990 FIND v(dout0_8) AT=2000.05n

.meas tran vdout0_9ck1990 FIND v(dout0_9) AT=2000.05n

.meas tran vdout0_10ck1990 FIND v(dout0_10) AT=2000.05n

.meas tran vdout0_11ck1990 FIND v(dout0_11) AT=2000.05n

.meas tran vdout0_12ck1990 FIND v(dout0_12) AT=2000.05n

.meas tran vdout0_13ck1990 FIND v(dout0_13) AT=2000.05n

.meas tran vdout0_14ck1990 FIND v(dout0_14) AT=2000.05n

.meas tran vdout0_15ck1990 FIND v(dout0_15) AT=2000.05n

.meas tran vdout0_16ck1990 FIND v(dout0_16) AT=2000.05n

.meas tran vdout0_17ck1990 FIND v(dout0_17) AT=2000.05n

.meas tran vdout0_18ck1990 FIND v(dout0_18) AT=2000.05n

.meas tran vdout0_19ck1990 FIND v(dout0_19) AT=2000.05n

.meas tran vdout0_20ck1990 FIND v(dout0_20) AT=2000.05n

.meas tran vdout0_21ck1990 FIND v(dout0_21) AT=2000.05n

.meas tran vdout0_22ck1990 FIND v(dout0_22) AT=2000.05n

.meas tran vdout0_23ck1990 FIND v(dout0_23) AT=2000.05n

.meas tran vdout0_24ck1990 FIND v(dout0_24) AT=2000.05n

.meas tran vdout0_25ck1990 FIND v(dout0_25) AT=2000.05n

.meas tran vdout0_26ck1990 FIND v(dout0_26) AT=2000.05n

.meas tran vdout0_27ck1990 FIND v(dout0_27) AT=2000.05n

.meas tran vdout0_28ck1990 FIND v(dout0_28) AT=2000.05n

.meas tran vdout0_29ck1990 FIND v(dout0_29) AT=2000.05n

.meas tran vdout0_30ck1990 FIND v(dout0_30) AT=2000.05n

.meas tran vdout0_31ck1990 FIND v(dout0_31) AT=2000.05n

.meas tran vdout0_32ck1990 FIND v(dout0_32) AT=2000.05n

.meas tran vdout0_33ck1990 FIND v(dout0_33) AT=2000.05n

.meas tran vdout0_34ck1990 FIND v(dout0_34) AT=2000.05n

.meas tran vdout0_35ck1990 FIND v(dout0_35) AT=2000.05n

.meas tran vdout0_36ck1990 FIND v(dout0_36) AT=2000.05n

.meas tran vdout0_37ck1990 FIND v(dout0_37) AT=2000.05n

.meas tran vdout0_38ck1990 FIND v(dout0_38) AT=2000.05n

.meas tran vdout0_39ck1990 FIND v(dout0_39) AT=2000.05n

.meas tran vdout0_40ck1990 FIND v(dout0_40) AT=2000.05n

.meas tran vdout0_41ck1990 FIND v(dout0_41) AT=2000.05n

.meas tran vdout0_42ck1990 FIND v(dout0_42) AT=2000.05n

.meas tran vdout0_43ck1990 FIND v(dout0_43) AT=2000.05n

.meas tran vdout0_44ck1990 FIND v(dout0_44) AT=2000.05n

.meas tran vdout0_45ck1990 FIND v(dout0_45) AT=2000.05n

.meas tran vdout0_46ck1990 FIND v(dout0_46) AT=2000.05n

.meas tran vdout0_47ck1990 FIND v(dout0_47) AT=2000.05n

.meas tran vdout0_48ck1990 FIND v(dout0_48) AT=2000.05n

.meas tran vdout0_49ck1990 FIND v(dout0_49) AT=2000.05n

.meas tran vdout0_50ck1990 FIND v(dout0_50) AT=2000.05n

.meas tran vdout0_51ck1990 FIND v(dout0_51) AT=2000.05n

.meas tran vdout0_52ck1990 FIND v(dout0_52) AT=2000.05n

.meas tran vdout0_53ck1990 FIND v(dout0_53) AT=2000.05n

.meas tran vdout0_54ck1990 FIND v(dout0_54) AT=2000.05n

.meas tran vdout0_55ck1990 FIND v(dout0_55) AT=2000.05n

.meas tran vdout0_56ck1990 FIND v(dout0_56) AT=2000.05n

.meas tran vdout0_57ck1990 FIND v(dout0_57) AT=2000.05n

.meas tran vdout0_58ck1990 FIND v(dout0_58) AT=2000.05n

.meas tran vdout0_59ck1990 FIND v(dout0_59) AT=2000.05n

.meas tran vdout0_60ck1990 FIND v(dout0_60) AT=2000.05n

.meas tran vdout0_61ck1990 FIND v(dout0_61) AT=2000.05n

.meas tran vdout0_62ck1990 FIND v(dout0_62) AT=2000.05n

.meas tran vdout0_63ck1990 FIND v(dout0_63) AT=2000.05n

.meas tran vdout0_64ck1990 FIND v(dout0_64) AT=2000.05n

.meas tran vdout0_0ck2010 FIND v(dout0_0) AT=2020.05n

.meas tran vdout0_1ck2010 FIND v(dout0_1) AT=2020.05n

.meas tran vdout0_2ck2010 FIND v(dout0_2) AT=2020.05n

.meas tran vdout0_3ck2010 FIND v(dout0_3) AT=2020.05n

.meas tran vdout0_4ck2010 FIND v(dout0_4) AT=2020.05n

.meas tran vdout0_5ck2010 FIND v(dout0_5) AT=2020.05n

.meas tran vdout0_6ck2010 FIND v(dout0_6) AT=2020.05n

.meas tran vdout0_7ck2010 FIND v(dout0_7) AT=2020.05n

.meas tran vdout0_8ck2010 FIND v(dout0_8) AT=2020.05n

.meas tran vdout0_9ck2010 FIND v(dout0_9) AT=2020.05n

.meas tran vdout0_10ck2010 FIND v(dout0_10) AT=2020.05n

.meas tran vdout0_11ck2010 FIND v(dout0_11) AT=2020.05n

.meas tran vdout0_12ck2010 FIND v(dout0_12) AT=2020.05n

.meas tran vdout0_13ck2010 FIND v(dout0_13) AT=2020.05n

.meas tran vdout0_14ck2010 FIND v(dout0_14) AT=2020.05n

.meas tran vdout0_15ck2010 FIND v(dout0_15) AT=2020.05n

.meas tran vdout0_16ck2010 FIND v(dout0_16) AT=2020.05n

.meas tran vdout0_17ck2010 FIND v(dout0_17) AT=2020.05n

.meas tran vdout0_18ck2010 FIND v(dout0_18) AT=2020.05n

.meas tran vdout0_19ck2010 FIND v(dout0_19) AT=2020.05n

.meas tran vdout0_20ck2010 FIND v(dout0_20) AT=2020.05n

.meas tran vdout0_21ck2010 FIND v(dout0_21) AT=2020.05n

.meas tran vdout0_22ck2010 FIND v(dout0_22) AT=2020.05n

.meas tran vdout0_23ck2010 FIND v(dout0_23) AT=2020.05n

.meas tran vdout0_24ck2010 FIND v(dout0_24) AT=2020.05n

.meas tran vdout0_25ck2010 FIND v(dout0_25) AT=2020.05n

.meas tran vdout0_26ck2010 FIND v(dout0_26) AT=2020.05n

.meas tran vdout0_27ck2010 FIND v(dout0_27) AT=2020.05n

.meas tran vdout0_28ck2010 FIND v(dout0_28) AT=2020.05n

.meas tran vdout0_29ck2010 FIND v(dout0_29) AT=2020.05n

.meas tran vdout0_30ck2010 FIND v(dout0_30) AT=2020.05n

.meas tran vdout0_31ck2010 FIND v(dout0_31) AT=2020.05n

.meas tran vdout0_32ck2010 FIND v(dout0_32) AT=2020.05n

.meas tran vdout0_33ck2010 FIND v(dout0_33) AT=2020.05n

.meas tran vdout0_34ck2010 FIND v(dout0_34) AT=2020.05n

.meas tran vdout0_35ck2010 FIND v(dout0_35) AT=2020.05n

.meas tran vdout0_36ck2010 FIND v(dout0_36) AT=2020.05n

.meas tran vdout0_37ck2010 FIND v(dout0_37) AT=2020.05n

.meas tran vdout0_38ck2010 FIND v(dout0_38) AT=2020.05n

.meas tran vdout0_39ck2010 FIND v(dout0_39) AT=2020.05n

.meas tran vdout0_40ck2010 FIND v(dout0_40) AT=2020.05n

.meas tran vdout0_41ck2010 FIND v(dout0_41) AT=2020.05n

.meas tran vdout0_42ck2010 FIND v(dout0_42) AT=2020.05n

.meas tran vdout0_43ck2010 FIND v(dout0_43) AT=2020.05n

.meas tran vdout0_44ck2010 FIND v(dout0_44) AT=2020.05n

.meas tran vdout0_45ck2010 FIND v(dout0_45) AT=2020.05n

.meas tran vdout0_46ck2010 FIND v(dout0_46) AT=2020.05n

.meas tran vdout0_47ck2010 FIND v(dout0_47) AT=2020.05n

.meas tran vdout0_48ck2010 FIND v(dout0_48) AT=2020.05n

.meas tran vdout0_49ck2010 FIND v(dout0_49) AT=2020.05n

.meas tran vdout0_50ck2010 FIND v(dout0_50) AT=2020.05n

.meas tran vdout0_51ck2010 FIND v(dout0_51) AT=2020.05n

.meas tran vdout0_52ck2010 FIND v(dout0_52) AT=2020.05n

.meas tran vdout0_53ck2010 FIND v(dout0_53) AT=2020.05n

.meas tran vdout0_54ck2010 FIND v(dout0_54) AT=2020.05n

.meas tran vdout0_55ck2010 FIND v(dout0_55) AT=2020.05n

.meas tran vdout0_56ck2010 FIND v(dout0_56) AT=2020.05n

.meas tran vdout0_57ck2010 FIND v(dout0_57) AT=2020.05n

.meas tran vdout0_58ck2010 FIND v(dout0_58) AT=2020.05n

.meas tran vdout0_59ck2010 FIND v(dout0_59) AT=2020.05n

.meas tran vdout0_60ck2010 FIND v(dout0_60) AT=2020.05n

.meas tran vdout0_61ck2010 FIND v(dout0_61) AT=2020.05n

.meas tran vdout0_62ck2010 FIND v(dout0_62) AT=2020.05n

.meas tran vdout0_63ck2010 FIND v(dout0_63) AT=2020.05n

.meas tran vdout0_64ck2010 FIND v(dout0_64) AT=2020.05n

.meas tran vdout0_0ck2030 FIND v(dout0_0) AT=2040.05n

.meas tran vdout0_1ck2030 FIND v(dout0_1) AT=2040.05n

.meas tran vdout0_2ck2030 FIND v(dout0_2) AT=2040.05n

.meas tran vdout0_3ck2030 FIND v(dout0_3) AT=2040.05n

.meas tran vdout0_4ck2030 FIND v(dout0_4) AT=2040.05n

.meas tran vdout0_5ck2030 FIND v(dout0_5) AT=2040.05n

.meas tran vdout0_6ck2030 FIND v(dout0_6) AT=2040.05n

.meas tran vdout0_7ck2030 FIND v(dout0_7) AT=2040.05n

.meas tran vdout0_8ck2030 FIND v(dout0_8) AT=2040.05n

.meas tran vdout0_9ck2030 FIND v(dout0_9) AT=2040.05n

.meas tran vdout0_10ck2030 FIND v(dout0_10) AT=2040.05n

.meas tran vdout0_11ck2030 FIND v(dout0_11) AT=2040.05n

.meas tran vdout0_12ck2030 FIND v(dout0_12) AT=2040.05n

.meas tran vdout0_13ck2030 FIND v(dout0_13) AT=2040.05n

.meas tran vdout0_14ck2030 FIND v(dout0_14) AT=2040.05n

.meas tran vdout0_15ck2030 FIND v(dout0_15) AT=2040.05n

.meas tran vdout0_16ck2030 FIND v(dout0_16) AT=2040.05n

.meas tran vdout0_17ck2030 FIND v(dout0_17) AT=2040.05n

.meas tran vdout0_18ck2030 FIND v(dout0_18) AT=2040.05n

.meas tran vdout0_19ck2030 FIND v(dout0_19) AT=2040.05n

.meas tran vdout0_20ck2030 FIND v(dout0_20) AT=2040.05n

.meas tran vdout0_21ck2030 FIND v(dout0_21) AT=2040.05n

.meas tran vdout0_22ck2030 FIND v(dout0_22) AT=2040.05n

.meas tran vdout0_23ck2030 FIND v(dout0_23) AT=2040.05n

.meas tran vdout0_24ck2030 FIND v(dout0_24) AT=2040.05n

.meas tran vdout0_25ck2030 FIND v(dout0_25) AT=2040.05n

.meas tran vdout0_26ck2030 FIND v(dout0_26) AT=2040.05n

.meas tran vdout0_27ck2030 FIND v(dout0_27) AT=2040.05n

.meas tran vdout0_28ck2030 FIND v(dout0_28) AT=2040.05n

.meas tran vdout0_29ck2030 FIND v(dout0_29) AT=2040.05n

.meas tran vdout0_30ck2030 FIND v(dout0_30) AT=2040.05n

.meas tran vdout0_31ck2030 FIND v(dout0_31) AT=2040.05n

.meas tran vdout0_32ck2030 FIND v(dout0_32) AT=2040.05n

.meas tran vdout0_33ck2030 FIND v(dout0_33) AT=2040.05n

.meas tran vdout0_34ck2030 FIND v(dout0_34) AT=2040.05n

.meas tran vdout0_35ck2030 FIND v(dout0_35) AT=2040.05n

.meas tran vdout0_36ck2030 FIND v(dout0_36) AT=2040.05n

.meas tran vdout0_37ck2030 FIND v(dout0_37) AT=2040.05n

.meas tran vdout0_38ck2030 FIND v(dout0_38) AT=2040.05n

.meas tran vdout0_39ck2030 FIND v(dout0_39) AT=2040.05n

.meas tran vdout0_40ck2030 FIND v(dout0_40) AT=2040.05n

.meas tran vdout0_41ck2030 FIND v(dout0_41) AT=2040.05n

.meas tran vdout0_42ck2030 FIND v(dout0_42) AT=2040.05n

.meas tran vdout0_43ck2030 FIND v(dout0_43) AT=2040.05n

.meas tran vdout0_44ck2030 FIND v(dout0_44) AT=2040.05n

.meas tran vdout0_45ck2030 FIND v(dout0_45) AT=2040.05n

.meas tran vdout0_46ck2030 FIND v(dout0_46) AT=2040.05n

.meas tran vdout0_47ck2030 FIND v(dout0_47) AT=2040.05n

.meas tran vdout0_48ck2030 FIND v(dout0_48) AT=2040.05n

.meas tran vdout0_49ck2030 FIND v(dout0_49) AT=2040.05n

.meas tran vdout0_50ck2030 FIND v(dout0_50) AT=2040.05n

.meas tran vdout0_51ck2030 FIND v(dout0_51) AT=2040.05n

.meas tran vdout0_52ck2030 FIND v(dout0_52) AT=2040.05n

.meas tran vdout0_53ck2030 FIND v(dout0_53) AT=2040.05n

.meas tran vdout0_54ck2030 FIND v(dout0_54) AT=2040.05n

.meas tran vdout0_55ck2030 FIND v(dout0_55) AT=2040.05n

.meas tran vdout0_56ck2030 FIND v(dout0_56) AT=2040.05n

.meas tran vdout0_57ck2030 FIND v(dout0_57) AT=2040.05n

.meas tran vdout0_58ck2030 FIND v(dout0_58) AT=2040.05n

.meas tran vdout0_59ck2030 FIND v(dout0_59) AT=2040.05n

.meas tran vdout0_60ck2030 FIND v(dout0_60) AT=2040.05n

.meas tran vdout0_61ck2030 FIND v(dout0_61) AT=2040.05n

.meas tran vdout0_62ck2030 FIND v(dout0_62) AT=2040.05n

.meas tran vdout0_63ck2030 FIND v(dout0_63) AT=2040.05n

.meas tran vdout0_64ck2030 FIND v(dout0_64) AT=2040.05n

.meas tran vdout0_0ck2040 FIND v(dout0_0) AT=2050.05n

.meas tran vdout0_1ck2040 FIND v(dout0_1) AT=2050.05n

.meas tran vdout0_2ck2040 FIND v(dout0_2) AT=2050.05n

.meas tran vdout0_3ck2040 FIND v(dout0_3) AT=2050.05n

.meas tran vdout0_4ck2040 FIND v(dout0_4) AT=2050.05n

.meas tran vdout0_5ck2040 FIND v(dout0_5) AT=2050.05n

.meas tran vdout0_6ck2040 FIND v(dout0_6) AT=2050.05n

.meas tran vdout0_7ck2040 FIND v(dout0_7) AT=2050.05n

.meas tran vdout0_8ck2040 FIND v(dout0_8) AT=2050.05n

.meas tran vdout0_9ck2040 FIND v(dout0_9) AT=2050.05n

.meas tran vdout0_10ck2040 FIND v(dout0_10) AT=2050.05n

.meas tran vdout0_11ck2040 FIND v(dout0_11) AT=2050.05n

.meas tran vdout0_12ck2040 FIND v(dout0_12) AT=2050.05n

.meas tran vdout0_13ck2040 FIND v(dout0_13) AT=2050.05n

.meas tran vdout0_14ck2040 FIND v(dout0_14) AT=2050.05n

.meas tran vdout0_15ck2040 FIND v(dout0_15) AT=2050.05n

.meas tran vdout0_16ck2040 FIND v(dout0_16) AT=2050.05n

.meas tran vdout0_17ck2040 FIND v(dout0_17) AT=2050.05n

.meas tran vdout0_18ck2040 FIND v(dout0_18) AT=2050.05n

.meas tran vdout0_19ck2040 FIND v(dout0_19) AT=2050.05n

.meas tran vdout0_20ck2040 FIND v(dout0_20) AT=2050.05n

.meas tran vdout0_21ck2040 FIND v(dout0_21) AT=2050.05n

.meas tran vdout0_22ck2040 FIND v(dout0_22) AT=2050.05n

.meas tran vdout0_23ck2040 FIND v(dout0_23) AT=2050.05n

.meas tran vdout0_24ck2040 FIND v(dout0_24) AT=2050.05n

.meas tran vdout0_25ck2040 FIND v(dout0_25) AT=2050.05n

.meas tran vdout0_26ck2040 FIND v(dout0_26) AT=2050.05n

.meas tran vdout0_27ck2040 FIND v(dout0_27) AT=2050.05n

.meas tran vdout0_28ck2040 FIND v(dout0_28) AT=2050.05n

.meas tran vdout0_29ck2040 FIND v(dout0_29) AT=2050.05n

.meas tran vdout0_30ck2040 FIND v(dout0_30) AT=2050.05n

.meas tran vdout0_31ck2040 FIND v(dout0_31) AT=2050.05n

.meas tran vdout0_32ck2040 FIND v(dout0_32) AT=2050.05n

.meas tran vdout0_33ck2040 FIND v(dout0_33) AT=2050.05n

.meas tran vdout0_34ck2040 FIND v(dout0_34) AT=2050.05n

.meas tran vdout0_35ck2040 FIND v(dout0_35) AT=2050.05n

.meas tran vdout0_36ck2040 FIND v(dout0_36) AT=2050.05n

.meas tran vdout0_37ck2040 FIND v(dout0_37) AT=2050.05n

.meas tran vdout0_38ck2040 FIND v(dout0_38) AT=2050.05n

.meas tran vdout0_39ck2040 FIND v(dout0_39) AT=2050.05n

.meas tran vdout0_40ck2040 FIND v(dout0_40) AT=2050.05n

.meas tran vdout0_41ck2040 FIND v(dout0_41) AT=2050.05n

.meas tran vdout0_42ck2040 FIND v(dout0_42) AT=2050.05n

.meas tran vdout0_43ck2040 FIND v(dout0_43) AT=2050.05n

.meas tran vdout0_44ck2040 FIND v(dout0_44) AT=2050.05n

.meas tran vdout0_45ck2040 FIND v(dout0_45) AT=2050.05n

.meas tran vdout0_46ck2040 FIND v(dout0_46) AT=2050.05n

.meas tran vdout0_47ck2040 FIND v(dout0_47) AT=2050.05n

.meas tran vdout0_48ck2040 FIND v(dout0_48) AT=2050.05n

.meas tran vdout0_49ck2040 FIND v(dout0_49) AT=2050.05n

.meas tran vdout0_50ck2040 FIND v(dout0_50) AT=2050.05n

.meas tran vdout0_51ck2040 FIND v(dout0_51) AT=2050.05n

.meas tran vdout0_52ck2040 FIND v(dout0_52) AT=2050.05n

.meas tran vdout0_53ck2040 FIND v(dout0_53) AT=2050.05n

.meas tran vdout0_54ck2040 FIND v(dout0_54) AT=2050.05n

.meas tran vdout0_55ck2040 FIND v(dout0_55) AT=2050.05n

.meas tran vdout0_56ck2040 FIND v(dout0_56) AT=2050.05n

.meas tran vdout0_57ck2040 FIND v(dout0_57) AT=2050.05n

.meas tran vdout0_58ck2040 FIND v(dout0_58) AT=2050.05n

.meas tran vdout0_59ck2040 FIND v(dout0_59) AT=2050.05n

.meas tran vdout0_60ck2040 FIND v(dout0_60) AT=2050.05n

.meas tran vdout0_61ck2040 FIND v(dout0_61) AT=2050.05n

.meas tran vdout0_62ck2040 FIND v(dout0_62) AT=2050.05n

.meas tran vdout0_63ck2040 FIND v(dout0_63) AT=2050.05n

.meas tran vdout0_64ck2040 FIND v(dout0_64) AT=2050.05n
