.meas tran vdout0_0ck40 FIND v(dout0_0) AT=50.05n

.meas tran vdout0_1ck40 FIND v(dout0_1) AT=50.05n

.meas tran vdout0_2ck40 FIND v(dout0_2) AT=50.05n

.meas tran vdout0_3ck40 FIND v(dout0_3) AT=50.05n

.meas tran vdout0_4ck40 FIND v(dout0_4) AT=50.05n

.meas tran vdout0_5ck40 FIND v(dout0_5) AT=50.05n

.meas tran vdout0_6ck40 FIND v(dout0_6) AT=50.05n

.meas tran vdout0_7ck40 FIND v(dout0_7) AT=50.05n

.meas tran vdout0_8ck40 FIND v(dout0_8) AT=50.05n

.meas tran vdout0_9ck40 FIND v(dout0_9) AT=50.05n

.meas tran vdout0_10ck40 FIND v(dout0_10) AT=50.05n

.meas tran vdout0_11ck40 FIND v(dout0_11) AT=50.05n

.meas tran vdout0_12ck40 FIND v(dout0_12) AT=50.05n

.meas tran vdout0_13ck40 FIND v(dout0_13) AT=50.05n

.meas tran vdout0_14ck40 FIND v(dout0_14) AT=50.05n

.meas tran vdout0_15ck40 FIND v(dout0_15) AT=50.05n

.meas tran vdout0_16ck40 FIND v(dout0_16) AT=50.05n

.meas tran vdout0_17ck40 FIND v(dout0_17) AT=50.05n

.meas tran vdout0_18ck40 FIND v(dout0_18) AT=50.05n

.meas tran vdout0_19ck40 FIND v(dout0_19) AT=50.05n

.meas tran vdout0_20ck40 FIND v(dout0_20) AT=50.05n

.meas tran vdout0_21ck40 FIND v(dout0_21) AT=50.05n

.meas tran vdout0_22ck40 FIND v(dout0_22) AT=50.05n

.meas tran vdout0_23ck40 FIND v(dout0_23) AT=50.05n

.meas tran vdout0_24ck40 FIND v(dout0_24) AT=50.05n

.meas tran vdout0_25ck40 FIND v(dout0_25) AT=50.05n

.meas tran vdout0_26ck40 FIND v(dout0_26) AT=50.05n

.meas tran vdout0_27ck40 FIND v(dout0_27) AT=50.05n

.meas tran vdout0_28ck40 FIND v(dout0_28) AT=50.05n

.meas tran vdout0_29ck40 FIND v(dout0_29) AT=50.05n

.meas tran vdout0_30ck40 FIND v(dout0_30) AT=50.05n

.meas tran vdout0_31ck40 FIND v(dout0_31) AT=50.05n

.meas tran vdout0_32ck40 FIND v(dout0_32) AT=50.05n

.meas tran vdout0_0ck50 FIND v(dout0_0) AT=60.05n

.meas tran vdout0_1ck50 FIND v(dout0_1) AT=60.05n

.meas tran vdout0_2ck50 FIND v(dout0_2) AT=60.05n

.meas tran vdout0_3ck50 FIND v(dout0_3) AT=60.05n

.meas tran vdout0_4ck50 FIND v(dout0_4) AT=60.05n

.meas tran vdout0_5ck50 FIND v(dout0_5) AT=60.05n

.meas tran vdout0_6ck50 FIND v(dout0_6) AT=60.05n

.meas tran vdout0_7ck50 FIND v(dout0_7) AT=60.05n

.meas tran vdout0_8ck50 FIND v(dout0_8) AT=60.05n

.meas tran vdout0_9ck50 FIND v(dout0_9) AT=60.05n

.meas tran vdout0_10ck50 FIND v(dout0_10) AT=60.05n

.meas tran vdout0_11ck50 FIND v(dout0_11) AT=60.05n

.meas tran vdout0_12ck50 FIND v(dout0_12) AT=60.05n

.meas tran vdout0_13ck50 FIND v(dout0_13) AT=60.05n

.meas tran vdout0_14ck50 FIND v(dout0_14) AT=60.05n

.meas tran vdout0_15ck50 FIND v(dout0_15) AT=60.05n

.meas tran vdout0_16ck50 FIND v(dout0_16) AT=60.05n

.meas tran vdout0_17ck50 FIND v(dout0_17) AT=60.05n

.meas tran vdout0_18ck50 FIND v(dout0_18) AT=60.05n

.meas tran vdout0_19ck50 FIND v(dout0_19) AT=60.05n

.meas tran vdout0_20ck50 FIND v(dout0_20) AT=60.05n

.meas tran vdout0_21ck50 FIND v(dout0_21) AT=60.05n

.meas tran vdout0_22ck50 FIND v(dout0_22) AT=60.05n

.meas tran vdout0_23ck50 FIND v(dout0_23) AT=60.05n

.meas tran vdout0_24ck50 FIND v(dout0_24) AT=60.05n

.meas tran vdout0_25ck50 FIND v(dout0_25) AT=60.05n

.meas tran vdout0_26ck50 FIND v(dout0_26) AT=60.05n

.meas tran vdout0_27ck50 FIND v(dout0_27) AT=60.05n

.meas tran vdout0_28ck50 FIND v(dout0_28) AT=60.05n

.meas tran vdout0_29ck50 FIND v(dout0_29) AT=60.05n

.meas tran vdout0_30ck50 FIND v(dout0_30) AT=60.05n

.meas tran vdout0_31ck50 FIND v(dout0_31) AT=60.05n

.meas tran vdout0_32ck50 FIND v(dout0_32) AT=60.05n

.meas tran vdout0_0ck60 FIND v(dout0_0) AT=70.05n

.meas tran vdout0_1ck60 FIND v(dout0_1) AT=70.05n

.meas tran vdout0_2ck60 FIND v(dout0_2) AT=70.05n

.meas tran vdout0_3ck60 FIND v(dout0_3) AT=70.05n

.meas tran vdout0_4ck60 FIND v(dout0_4) AT=70.05n

.meas tran vdout0_5ck60 FIND v(dout0_5) AT=70.05n

.meas tran vdout0_6ck60 FIND v(dout0_6) AT=70.05n

.meas tran vdout0_7ck60 FIND v(dout0_7) AT=70.05n

.meas tran vdout0_8ck60 FIND v(dout0_8) AT=70.05n

.meas tran vdout0_9ck60 FIND v(dout0_9) AT=70.05n

.meas tran vdout0_10ck60 FIND v(dout0_10) AT=70.05n

.meas tran vdout0_11ck60 FIND v(dout0_11) AT=70.05n

.meas tran vdout0_12ck60 FIND v(dout0_12) AT=70.05n

.meas tran vdout0_13ck60 FIND v(dout0_13) AT=70.05n

.meas tran vdout0_14ck60 FIND v(dout0_14) AT=70.05n

.meas tran vdout0_15ck60 FIND v(dout0_15) AT=70.05n

.meas tran vdout0_16ck60 FIND v(dout0_16) AT=70.05n

.meas tran vdout0_17ck60 FIND v(dout0_17) AT=70.05n

.meas tran vdout0_18ck60 FIND v(dout0_18) AT=70.05n

.meas tran vdout0_19ck60 FIND v(dout0_19) AT=70.05n

.meas tran vdout0_20ck60 FIND v(dout0_20) AT=70.05n

.meas tran vdout0_21ck60 FIND v(dout0_21) AT=70.05n

.meas tran vdout0_22ck60 FIND v(dout0_22) AT=70.05n

.meas tran vdout0_23ck60 FIND v(dout0_23) AT=70.05n

.meas tran vdout0_24ck60 FIND v(dout0_24) AT=70.05n

.meas tran vdout0_25ck60 FIND v(dout0_25) AT=70.05n

.meas tran vdout0_26ck60 FIND v(dout0_26) AT=70.05n

.meas tran vdout0_27ck60 FIND v(dout0_27) AT=70.05n

.meas tran vdout0_28ck60 FIND v(dout0_28) AT=70.05n

.meas tran vdout0_29ck60 FIND v(dout0_29) AT=70.05n

.meas tran vdout0_30ck60 FIND v(dout0_30) AT=70.05n

.meas tran vdout0_31ck60 FIND v(dout0_31) AT=70.05n

.meas tran vdout0_32ck60 FIND v(dout0_32) AT=70.05n

.meas tran vdout0_0ck80 FIND v(dout0_0) AT=90.05n

.meas tran vdout0_1ck80 FIND v(dout0_1) AT=90.05n

.meas tran vdout0_2ck80 FIND v(dout0_2) AT=90.05n

.meas tran vdout0_3ck80 FIND v(dout0_3) AT=90.05n

.meas tran vdout0_4ck80 FIND v(dout0_4) AT=90.05n

.meas tran vdout0_5ck80 FIND v(dout0_5) AT=90.05n

.meas tran vdout0_6ck80 FIND v(dout0_6) AT=90.05n

.meas tran vdout0_7ck80 FIND v(dout0_7) AT=90.05n

.meas tran vdout0_8ck80 FIND v(dout0_8) AT=90.05n

.meas tran vdout0_9ck80 FIND v(dout0_9) AT=90.05n

.meas tran vdout0_10ck80 FIND v(dout0_10) AT=90.05n

.meas tran vdout0_11ck80 FIND v(dout0_11) AT=90.05n

.meas tran vdout0_12ck80 FIND v(dout0_12) AT=90.05n

.meas tran vdout0_13ck80 FIND v(dout0_13) AT=90.05n

.meas tran vdout0_14ck80 FIND v(dout0_14) AT=90.05n

.meas tran vdout0_15ck80 FIND v(dout0_15) AT=90.05n

.meas tran vdout0_16ck80 FIND v(dout0_16) AT=90.05n

.meas tran vdout0_17ck80 FIND v(dout0_17) AT=90.05n

.meas tran vdout0_18ck80 FIND v(dout0_18) AT=90.05n

.meas tran vdout0_19ck80 FIND v(dout0_19) AT=90.05n

.meas tran vdout0_20ck80 FIND v(dout0_20) AT=90.05n

.meas tran vdout0_21ck80 FIND v(dout0_21) AT=90.05n

.meas tran vdout0_22ck80 FIND v(dout0_22) AT=90.05n

.meas tran vdout0_23ck80 FIND v(dout0_23) AT=90.05n

.meas tran vdout0_24ck80 FIND v(dout0_24) AT=90.05n

.meas tran vdout0_25ck80 FIND v(dout0_25) AT=90.05n

.meas tran vdout0_26ck80 FIND v(dout0_26) AT=90.05n

.meas tran vdout0_27ck80 FIND v(dout0_27) AT=90.05n

.meas tran vdout0_28ck80 FIND v(dout0_28) AT=90.05n

.meas tran vdout0_29ck80 FIND v(dout0_29) AT=90.05n

.meas tran vdout0_30ck80 FIND v(dout0_30) AT=90.05n

.meas tran vdout0_31ck80 FIND v(dout0_31) AT=90.05n

.meas tran vdout0_32ck80 FIND v(dout0_32) AT=90.05n

.meas tran vdout0_0ck90 FIND v(dout0_0) AT=100.05n

.meas tran vdout0_1ck90 FIND v(dout0_1) AT=100.05n

.meas tran vdout0_2ck90 FIND v(dout0_2) AT=100.05n

.meas tran vdout0_3ck90 FIND v(dout0_3) AT=100.05n

.meas tran vdout0_4ck90 FIND v(dout0_4) AT=100.05n

.meas tran vdout0_5ck90 FIND v(dout0_5) AT=100.05n

.meas tran vdout0_6ck90 FIND v(dout0_6) AT=100.05n

.meas tran vdout0_7ck90 FIND v(dout0_7) AT=100.05n

.meas tran vdout0_8ck90 FIND v(dout0_8) AT=100.05n

.meas tran vdout0_9ck90 FIND v(dout0_9) AT=100.05n

.meas tran vdout0_10ck90 FIND v(dout0_10) AT=100.05n

.meas tran vdout0_11ck90 FIND v(dout0_11) AT=100.05n

.meas tran vdout0_12ck90 FIND v(dout0_12) AT=100.05n

.meas tran vdout0_13ck90 FIND v(dout0_13) AT=100.05n

.meas tran vdout0_14ck90 FIND v(dout0_14) AT=100.05n

.meas tran vdout0_15ck90 FIND v(dout0_15) AT=100.05n

.meas tran vdout0_16ck90 FIND v(dout0_16) AT=100.05n

.meas tran vdout0_17ck90 FIND v(dout0_17) AT=100.05n

.meas tran vdout0_18ck90 FIND v(dout0_18) AT=100.05n

.meas tran vdout0_19ck90 FIND v(dout0_19) AT=100.05n

.meas tran vdout0_20ck90 FIND v(dout0_20) AT=100.05n

.meas tran vdout0_21ck90 FIND v(dout0_21) AT=100.05n

.meas tran vdout0_22ck90 FIND v(dout0_22) AT=100.05n

.meas tran vdout0_23ck90 FIND v(dout0_23) AT=100.05n

.meas tran vdout0_24ck90 FIND v(dout0_24) AT=100.05n

.meas tran vdout0_25ck90 FIND v(dout0_25) AT=100.05n

.meas tran vdout0_26ck90 FIND v(dout0_26) AT=100.05n

.meas tran vdout0_27ck90 FIND v(dout0_27) AT=100.05n

.meas tran vdout0_28ck90 FIND v(dout0_28) AT=100.05n

.meas tran vdout0_29ck90 FIND v(dout0_29) AT=100.05n

.meas tran vdout0_30ck90 FIND v(dout0_30) AT=100.05n

.meas tran vdout0_31ck90 FIND v(dout0_31) AT=100.05n

.meas tran vdout0_32ck90 FIND v(dout0_32) AT=100.05n

.meas tran vdout0_0ck100 FIND v(dout0_0) AT=110.05n

.meas tran vdout0_1ck100 FIND v(dout0_1) AT=110.05n

.meas tran vdout0_2ck100 FIND v(dout0_2) AT=110.05n

.meas tran vdout0_3ck100 FIND v(dout0_3) AT=110.05n

.meas tran vdout0_4ck100 FIND v(dout0_4) AT=110.05n

.meas tran vdout0_5ck100 FIND v(dout0_5) AT=110.05n

.meas tran vdout0_6ck100 FIND v(dout0_6) AT=110.05n

.meas tran vdout0_7ck100 FIND v(dout0_7) AT=110.05n

.meas tran vdout0_8ck100 FIND v(dout0_8) AT=110.05n

.meas tran vdout0_9ck100 FIND v(dout0_9) AT=110.05n

.meas tran vdout0_10ck100 FIND v(dout0_10) AT=110.05n

.meas tran vdout0_11ck100 FIND v(dout0_11) AT=110.05n

.meas tran vdout0_12ck100 FIND v(dout0_12) AT=110.05n

.meas tran vdout0_13ck100 FIND v(dout0_13) AT=110.05n

.meas tran vdout0_14ck100 FIND v(dout0_14) AT=110.05n

.meas tran vdout0_15ck100 FIND v(dout0_15) AT=110.05n

.meas tran vdout0_16ck100 FIND v(dout0_16) AT=110.05n

.meas tran vdout0_17ck100 FIND v(dout0_17) AT=110.05n

.meas tran vdout0_18ck100 FIND v(dout0_18) AT=110.05n

.meas tran vdout0_19ck100 FIND v(dout0_19) AT=110.05n

.meas tran vdout0_20ck100 FIND v(dout0_20) AT=110.05n

.meas tran vdout0_21ck100 FIND v(dout0_21) AT=110.05n

.meas tran vdout0_22ck100 FIND v(dout0_22) AT=110.05n

.meas tran vdout0_23ck100 FIND v(dout0_23) AT=110.05n

.meas tran vdout0_24ck100 FIND v(dout0_24) AT=110.05n

.meas tran vdout0_25ck100 FIND v(dout0_25) AT=110.05n

.meas tran vdout0_26ck100 FIND v(dout0_26) AT=110.05n

.meas tran vdout0_27ck100 FIND v(dout0_27) AT=110.05n

.meas tran vdout0_28ck100 FIND v(dout0_28) AT=110.05n

.meas tran vdout0_29ck100 FIND v(dout0_29) AT=110.05n

.meas tran vdout0_30ck100 FIND v(dout0_30) AT=110.05n

.meas tran vdout0_31ck100 FIND v(dout0_31) AT=110.05n

.meas tran vdout0_32ck100 FIND v(dout0_32) AT=110.05n

.meas tran vdout0_0ck120 FIND v(dout0_0) AT=130.05n

.meas tran vdout0_1ck120 FIND v(dout0_1) AT=130.05n

.meas tran vdout0_2ck120 FIND v(dout0_2) AT=130.05n

.meas tran vdout0_3ck120 FIND v(dout0_3) AT=130.05n

.meas tran vdout0_4ck120 FIND v(dout0_4) AT=130.05n

.meas tran vdout0_5ck120 FIND v(dout0_5) AT=130.05n

.meas tran vdout0_6ck120 FIND v(dout0_6) AT=130.05n

.meas tran vdout0_7ck120 FIND v(dout0_7) AT=130.05n

.meas tran vdout0_8ck120 FIND v(dout0_8) AT=130.05n

.meas tran vdout0_9ck120 FIND v(dout0_9) AT=130.05n

.meas tran vdout0_10ck120 FIND v(dout0_10) AT=130.05n

.meas tran vdout0_11ck120 FIND v(dout0_11) AT=130.05n

.meas tran vdout0_12ck120 FIND v(dout0_12) AT=130.05n

.meas tran vdout0_13ck120 FIND v(dout0_13) AT=130.05n

.meas tran vdout0_14ck120 FIND v(dout0_14) AT=130.05n

.meas tran vdout0_15ck120 FIND v(dout0_15) AT=130.05n

.meas tran vdout0_16ck120 FIND v(dout0_16) AT=130.05n

.meas tran vdout0_17ck120 FIND v(dout0_17) AT=130.05n

.meas tran vdout0_18ck120 FIND v(dout0_18) AT=130.05n

.meas tran vdout0_19ck120 FIND v(dout0_19) AT=130.05n

.meas tran vdout0_20ck120 FIND v(dout0_20) AT=130.05n

.meas tran vdout0_21ck120 FIND v(dout0_21) AT=130.05n

.meas tran vdout0_22ck120 FIND v(dout0_22) AT=130.05n

.meas tran vdout0_23ck120 FIND v(dout0_23) AT=130.05n

.meas tran vdout0_24ck120 FIND v(dout0_24) AT=130.05n

.meas tran vdout0_25ck120 FIND v(dout0_25) AT=130.05n

.meas tran vdout0_26ck120 FIND v(dout0_26) AT=130.05n

.meas tran vdout0_27ck120 FIND v(dout0_27) AT=130.05n

.meas tran vdout0_28ck120 FIND v(dout0_28) AT=130.05n

.meas tran vdout0_29ck120 FIND v(dout0_29) AT=130.05n

.meas tran vdout0_30ck120 FIND v(dout0_30) AT=130.05n

.meas tran vdout0_31ck120 FIND v(dout0_31) AT=130.05n

.meas tran vdout0_32ck120 FIND v(dout0_32) AT=130.05n

.meas tran vdout0_0ck140 FIND v(dout0_0) AT=150.05n

.meas tran vdout0_1ck140 FIND v(dout0_1) AT=150.05n

.meas tran vdout0_2ck140 FIND v(dout0_2) AT=150.05n

.meas tran vdout0_3ck140 FIND v(dout0_3) AT=150.05n

.meas tran vdout0_4ck140 FIND v(dout0_4) AT=150.05n

.meas tran vdout0_5ck140 FIND v(dout0_5) AT=150.05n

.meas tran vdout0_6ck140 FIND v(dout0_6) AT=150.05n

.meas tran vdout0_7ck140 FIND v(dout0_7) AT=150.05n

.meas tran vdout0_8ck140 FIND v(dout0_8) AT=150.05n

.meas tran vdout0_9ck140 FIND v(dout0_9) AT=150.05n

.meas tran vdout0_10ck140 FIND v(dout0_10) AT=150.05n

.meas tran vdout0_11ck140 FIND v(dout0_11) AT=150.05n

.meas tran vdout0_12ck140 FIND v(dout0_12) AT=150.05n

.meas tran vdout0_13ck140 FIND v(dout0_13) AT=150.05n

.meas tran vdout0_14ck140 FIND v(dout0_14) AT=150.05n

.meas tran vdout0_15ck140 FIND v(dout0_15) AT=150.05n

.meas tran vdout0_16ck140 FIND v(dout0_16) AT=150.05n

.meas tran vdout0_17ck140 FIND v(dout0_17) AT=150.05n

.meas tran vdout0_18ck140 FIND v(dout0_18) AT=150.05n

.meas tran vdout0_19ck140 FIND v(dout0_19) AT=150.05n

.meas tran vdout0_20ck140 FIND v(dout0_20) AT=150.05n

.meas tran vdout0_21ck140 FIND v(dout0_21) AT=150.05n

.meas tran vdout0_22ck140 FIND v(dout0_22) AT=150.05n

.meas tran vdout0_23ck140 FIND v(dout0_23) AT=150.05n

.meas tran vdout0_24ck140 FIND v(dout0_24) AT=150.05n

.meas tran vdout0_25ck140 FIND v(dout0_25) AT=150.05n

.meas tran vdout0_26ck140 FIND v(dout0_26) AT=150.05n

.meas tran vdout0_27ck140 FIND v(dout0_27) AT=150.05n

.meas tran vdout0_28ck140 FIND v(dout0_28) AT=150.05n

.meas tran vdout0_29ck140 FIND v(dout0_29) AT=150.05n

.meas tran vdout0_30ck140 FIND v(dout0_30) AT=150.05n

.meas tran vdout0_31ck140 FIND v(dout0_31) AT=150.05n

.meas tran vdout0_32ck140 FIND v(dout0_32) AT=150.05n

.meas tran vdout0_0ck180 FIND v(dout0_0) AT=190.05n

.meas tran vdout0_1ck180 FIND v(dout0_1) AT=190.05n

.meas tran vdout0_2ck180 FIND v(dout0_2) AT=190.05n

.meas tran vdout0_3ck180 FIND v(dout0_3) AT=190.05n

.meas tran vdout0_4ck180 FIND v(dout0_4) AT=190.05n

.meas tran vdout0_5ck180 FIND v(dout0_5) AT=190.05n

.meas tran vdout0_6ck180 FIND v(dout0_6) AT=190.05n

.meas tran vdout0_7ck180 FIND v(dout0_7) AT=190.05n

.meas tran vdout0_8ck180 FIND v(dout0_8) AT=190.05n

.meas tran vdout0_9ck180 FIND v(dout0_9) AT=190.05n

.meas tran vdout0_10ck180 FIND v(dout0_10) AT=190.05n

.meas tran vdout0_11ck180 FIND v(dout0_11) AT=190.05n

.meas tran vdout0_12ck180 FIND v(dout0_12) AT=190.05n

.meas tran vdout0_13ck180 FIND v(dout0_13) AT=190.05n

.meas tran vdout0_14ck180 FIND v(dout0_14) AT=190.05n

.meas tran vdout0_15ck180 FIND v(dout0_15) AT=190.05n

.meas tran vdout0_16ck180 FIND v(dout0_16) AT=190.05n

.meas tran vdout0_17ck180 FIND v(dout0_17) AT=190.05n

.meas tran vdout0_18ck180 FIND v(dout0_18) AT=190.05n

.meas tran vdout0_19ck180 FIND v(dout0_19) AT=190.05n

.meas tran vdout0_20ck180 FIND v(dout0_20) AT=190.05n

.meas tran vdout0_21ck180 FIND v(dout0_21) AT=190.05n

.meas tran vdout0_22ck180 FIND v(dout0_22) AT=190.05n

.meas tran vdout0_23ck180 FIND v(dout0_23) AT=190.05n

.meas tran vdout0_24ck180 FIND v(dout0_24) AT=190.05n

.meas tran vdout0_25ck180 FIND v(dout0_25) AT=190.05n

.meas tran vdout0_26ck180 FIND v(dout0_26) AT=190.05n

.meas tran vdout0_27ck180 FIND v(dout0_27) AT=190.05n

.meas tran vdout0_28ck180 FIND v(dout0_28) AT=190.05n

.meas tran vdout0_29ck180 FIND v(dout0_29) AT=190.05n

.meas tran vdout0_30ck180 FIND v(dout0_30) AT=190.05n

.meas tran vdout0_31ck180 FIND v(dout0_31) AT=190.05n

.meas tran vdout0_32ck180 FIND v(dout0_32) AT=190.05n

.meas tran vdout0_0ck190 FIND v(dout0_0) AT=200.05n

.meas tran vdout0_1ck190 FIND v(dout0_1) AT=200.05n

.meas tran vdout0_2ck190 FIND v(dout0_2) AT=200.05n

.meas tran vdout0_3ck190 FIND v(dout0_3) AT=200.05n

.meas tran vdout0_4ck190 FIND v(dout0_4) AT=200.05n

.meas tran vdout0_5ck190 FIND v(dout0_5) AT=200.05n

.meas tran vdout0_6ck190 FIND v(dout0_6) AT=200.05n

.meas tran vdout0_7ck190 FIND v(dout0_7) AT=200.05n

.meas tran vdout0_8ck190 FIND v(dout0_8) AT=200.05n

.meas tran vdout0_9ck190 FIND v(dout0_9) AT=200.05n

.meas tran vdout0_10ck190 FIND v(dout0_10) AT=200.05n

.meas tran vdout0_11ck190 FIND v(dout0_11) AT=200.05n

.meas tran vdout0_12ck190 FIND v(dout0_12) AT=200.05n

.meas tran vdout0_13ck190 FIND v(dout0_13) AT=200.05n

.meas tran vdout0_14ck190 FIND v(dout0_14) AT=200.05n

.meas tran vdout0_15ck190 FIND v(dout0_15) AT=200.05n

.meas tran vdout0_16ck190 FIND v(dout0_16) AT=200.05n

.meas tran vdout0_17ck190 FIND v(dout0_17) AT=200.05n

.meas tran vdout0_18ck190 FIND v(dout0_18) AT=200.05n

.meas tran vdout0_19ck190 FIND v(dout0_19) AT=200.05n

.meas tran vdout0_20ck190 FIND v(dout0_20) AT=200.05n

.meas tran vdout0_21ck190 FIND v(dout0_21) AT=200.05n

.meas tran vdout0_22ck190 FIND v(dout0_22) AT=200.05n

.meas tran vdout0_23ck190 FIND v(dout0_23) AT=200.05n

.meas tran vdout0_24ck190 FIND v(dout0_24) AT=200.05n

.meas tran vdout0_25ck190 FIND v(dout0_25) AT=200.05n

.meas tran vdout0_26ck190 FIND v(dout0_26) AT=200.05n

.meas tran vdout0_27ck190 FIND v(dout0_27) AT=200.05n

.meas tran vdout0_28ck190 FIND v(dout0_28) AT=200.05n

.meas tran vdout0_29ck190 FIND v(dout0_29) AT=200.05n

.meas tran vdout0_30ck190 FIND v(dout0_30) AT=200.05n

.meas tran vdout0_31ck190 FIND v(dout0_31) AT=200.05n

.meas tran vdout0_32ck190 FIND v(dout0_32) AT=200.05n

.meas tran vdout0_0ck220 FIND v(dout0_0) AT=230.05n

.meas tran vdout0_1ck220 FIND v(dout0_1) AT=230.05n

.meas tran vdout0_2ck220 FIND v(dout0_2) AT=230.05n

.meas tran vdout0_3ck220 FIND v(dout0_3) AT=230.05n

.meas tran vdout0_4ck220 FIND v(dout0_4) AT=230.05n

.meas tran vdout0_5ck220 FIND v(dout0_5) AT=230.05n

.meas tran vdout0_6ck220 FIND v(dout0_6) AT=230.05n

.meas tran vdout0_7ck220 FIND v(dout0_7) AT=230.05n

.meas tran vdout0_8ck220 FIND v(dout0_8) AT=230.05n

.meas tran vdout0_9ck220 FIND v(dout0_9) AT=230.05n

.meas tran vdout0_10ck220 FIND v(dout0_10) AT=230.05n

.meas tran vdout0_11ck220 FIND v(dout0_11) AT=230.05n

.meas tran vdout0_12ck220 FIND v(dout0_12) AT=230.05n

.meas tran vdout0_13ck220 FIND v(dout0_13) AT=230.05n

.meas tran vdout0_14ck220 FIND v(dout0_14) AT=230.05n

.meas tran vdout0_15ck220 FIND v(dout0_15) AT=230.05n

.meas tran vdout0_16ck220 FIND v(dout0_16) AT=230.05n

.meas tran vdout0_17ck220 FIND v(dout0_17) AT=230.05n

.meas tran vdout0_18ck220 FIND v(dout0_18) AT=230.05n

.meas tran vdout0_19ck220 FIND v(dout0_19) AT=230.05n

.meas tran vdout0_20ck220 FIND v(dout0_20) AT=230.05n

.meas tran vdout0_21ck220 FIND v(dout0_21) AT=230.05n

.meas tran vdout0_22ck220 FIND v(dout0_22) AT=230.05n

.meas tran vdout0_23ck220 FIND v(dout0_23) AT=230.05n

.meas tran vdout0_24ck220 FIND v(dout0_24) AT=230.05n

.meas tran vdout0_25ck220 FIND v(dout0_25) AT=230.05n

.meas tran vdout0_26ck220 FIND v(dout0_26) AT=230.05n

.meas tran vdout0_27ck220 FIND v(dout0_27) AT=230.05n

.meas tran vdout0_28ck220 FIND v(dout0_28) AT=230.05n

.meas tran vdout0_29ck220 FIND v(dout0_29) AT=230.05n

.meas tran vdout0_30ck220 FIND v(dout0_30) AT=230.05n

.meas tran vdout0_31ck220 FIND v(dout0_31) AT=230.05n

.meas tran vdout0_32ck220 FIND v(dout0_32) AT=230.05n

.meas tran vdout0_0ck230 FIND v(dout0_0) AT=240.05n

.meas tran vdout0_1ck230 FIND v(dout0_1) AT=240.05n

.meas tran vdout0_2ck230 FIND v(dout0_2) AT=240.05n

.meas tran vdout0_3ck230 FIND v(dout0_3) AT=240.05n

.meas tran vdout0_4ck230 FIND v(dout0_4) AT=240.05n

.meas tran vdout0_5ck230 FIND v(dout0_5) AT=240.05n

.meas tran vdout0_6ck230 FIND v(dout0_6) AT=240.05n

.meas tran vdout0_7ck230 FIND v(dout0_7) AT=240.05n

.meas tran vdout0_8ck230 FIND v(dout0_8) AT=240.05n

.meas tran vdout0_9ck230 FIND v(dout0_9) AT=240.05n

.meas tran vdout0_10ck230 FIND v(dout0_10) AT=240.05n

.meas tran vdout0_11ck230 FIND v(dout0_11) AT=240.05n

.meas tran vdout0_12ck230 FIND v(dout0_12) AT=240.05n

.meas tran vdout0_13ck230 FIND v(dout0_13) AT=240.05n

.meas tran vdout0_14ck230 FIND v(dout0_14) AT=240.05n

.meas tran vdout0_15ck230 FIND v(dout0_15) AT=240.05n

.meas tran vdout0_16ck230 FIND v(dout0_16) AT=240.05n

.meas tran vdout0_17ck230 FIND v(dout0_17) AT=240.05n

.meas tran vdout0_18ck230 FIND v(dout0_18) AT=240.05n

.meas tran vdout0_19ck230 FIND v(dout0_19) AT=240.05n

.meas tran vdout0_20ck230 FIND v(dout0_20) AT=240.05n

.meas tran vdout0_21ck230 FIND v(dout0_21) AT=240.05n

.meas tran vdout0_22ck230 FIND v(dout0_22) AT=240.05n

.meas tran vdout0_23ck230 FIND v(dout0_23) AT=240.05n

.meas tran vdout0_24ck230 FIND v(dout0_24) AT=240.05n

.meas tran vdout0_25ck230 FIND v(dout0_25) AT=240.05n

.meas tran vdout0_26ck230 FIND v(dout0_26) AT=240.05n

.meas tran vdout0_27ck230 FIND v(dout0_27) AT=240.05n

.meas tran vdout0_28ck230 FIND v(dout0_28) AT=240.05n

.meas tran vdout0_29ck230 FIND v(dout0_29) AT=240.05n

.meas tran vdout0_30ck230 FIND v(dout0_30) AT=240.05n

.meas tran vdout0_31ck230 FIND v(dout0_31) AT=240.05n

.meas tran vdout0_32ck230 FIND v(dout0_32) AT=240.05n

.meas tran vdout0_0ck270 FIND v(dout0_0) AT=280.05n

.meas tran vdout0_1ck270 FIND v(dout0_1) AT=280.05n

.meas tran vdout0_2ck270 FIND v(dout0_2) AT=280.05n

.meas tran vdout0_3ck270 FIND v(dout0_3) AT=280.05n

.meas tran vdout0_4ck270 FIND v(dout0_4) AT=280.05n

.meas tran vdout0_5ck270 FIND v(dout0_5) AT=280.05n

.meas tran vdout0_6ck270 FIND v(dout0_6) AT=280.05n

.meas tran vdout0_7ck270 FIND v(dout0_7) AT=280.05n

.meas tran vdout0_8ck270 FIND v(dout0_8) AT=280.05n

.meas tran vdout0_9ck270 FIND v(dout0_9) AT=280.05n

.meas tran vdout0_10ck270 FIND v(dout0_10) AT=280.05n

.meas tran vdout0_11ck270 FIND v(dout0_11) AT=280.05n

.meas tran vdout0_12ck270 FIND v(dout0_12) AT=280.05n

.meas tran vdout0_13ck270 FIND v(dout0_13) AT=280.05n

.meas tran vdout0_14ck270 FIND v(dout0_14) AT=280.05n

.meas tran vdout0_15ck270 FIND v(dout0_15) AT=280.05n

.meas tran vdout0_16ck270 FIND v(dout0_16) AT=280.05n

.meas tran vdout0_17ck270 FIND v(dout0_17) AT=280.05n

.meas tran vdout0_18ck270 FIND v(dout0_18) AT=280.05n

.meas tran vdout0_19ck270 FIND v(dout0_19) AT=280.05n

.meas tran vdout0_20ck270 FIND v(dout0_20) AT=280.05n

.meas tran vdout0_21ck270 FIND v(dout0_21) AT=280.05n

.meas tran vdout0_22ck270 FIND v(dout0_22) AT=280.05n

.meas tran vdout0_23ck270 FIND v(dout0_23) AT=280.05n

.meas tran vdout0_24ck270 FIND v(dout0_24) AT=280.05n

.meas tran vdout0_25ck270 FIND v(dout0_25) AT=280.05n

.meas tran vdout0_26ck270 FIND v(dout0_26) AT=280.05n

.meas tran vdout0_27ck270 FIND v(dout0_27) AT=280.05n

.meas tran vdout0_28ck270 FIND v(dout0_28) AT=280.05n

.meas tran vdout0_29ck270 FIND v(dout0_29) AT=280.05n

.meas tran vdout0_30ck270 FIND v(dout0_30) AT=280.05n

.meas tran vdout0_31ck270 FIND v(dout0_31) AT=280.05n

.meas tran vdout0_32ck270 FIND v(dout0_32) AT=280.05n

.meas tran vdout0_0ck310 FIND v(dout0_0) AT=320.05n

.meas tran vdout0_1ck310 FIND v(dout0_1) AT=320.05n

.meas tran vdout0_2ck310 FIND v(dout0_2) AT=320.05n

.meas tran vdout0_3ck310 FIND v(dout0_3) AT=320.05n

.meas tran vdout0_4ck310 FIND v(dout0_4) AT=320.05n

.meas tran vdout0_5ck310 FIND v(dout0_5) AT=320.05n

.meas tran vdout0_6ck310 FIND v(dout0_6) AT=320.05n

.meas tran vdout0_7ck310 FIND v(dout0_7) AT=320.05n

.meas tran vdout0_8ck310 FIND v(dout0_8) AT=320.05n

.meas tran vdout0_9ck310 FIND v(dout0_9) AT=320.05n

.meas tran vdout0_10ck310 FIND v(dout0_10) AT=320.05n

.meas tran vdout0_11ck310 FIND v(dout0_11) AT=320.05n

.meas tran vdout0_12ck310 FIND v(dout0_12) AT=320.05n

.meas tran vdout0_13ck310 FIND v(dout0_13) AT=320.05n

.meas tran vdout0_14ck310 FIND v(dout0_14) AT=320.05n

.meas tran vdout0_15ck310 FIND v(dout0_15) AT=320.05n

.meas tran vdout0_16ck310 FIND v(dout0_16) AT=320.05n

.meas tran vdout0_17ck310 FIND v(dout0_17) AT=320.05n

.meas tran vdout0_18ck310 FIND v(dout0_18) AT=320.05n

.meas tran vdout0_19ck310 FIND v(dout0_19) AT=320.05n

.meas tran vdout0_20ck310 FIND v(dout0_20) AT=320.05n

.meas tran vdout0_21ck310 FIND v(dout0_21) AT=320.05n

.meas tran vdout0_22ck310 FIND v(dout0_22) AT=320.05n

.meas tran vdout0_23ck310 FIND v(dout0_23) AT=320.05n

.meas tran vdout0_24ck310 FIND v(dout0_24) AT=320.05n

.meas tran vdout0_25ck310 FIND v(dout0_25) AT=320.05n

.meas tran vdout0_26ck310 FIND v(dout0_26) AT=320.05n

.meas tran vdout0_27ck310 FIND v(dout0_27) AT=320.05n

.meas tran vdout0_28ck310 FIND v(dout0_28) AT=320.05n

.meas tran vdout0_29ck310 FIND v(dout0_29) AT=320.05n

.meas tran vdout0_30ck310 FIND v(dout0_30) AT=320.05n

.meas tran vdout0_31ck310 FIND v(dout0_31) AT=320.05n

.meas tran vdout0_32ck310 FIND v(dout0_32) AT=320.05n

.meas tran vdout0_0ck340 FIND v(dout0_0) AT=350.05n

.meas tran vdout0_1ck340 FIND v(dout0_1) AT=350.05n

.meas tran vdout0_2ck340 FIND v(dout0_2) AT=350.05n

.meas tran vdout0_3ck340 FIND v(dout0_3) AT=350.05n

.meas tran vdout0_4ck340 FIND v(dout0_4) AT=350.05n

.meas tran vdout0_5ck340 FIND v(dout0_5) AT=350.05n

.meas tran vdout0_6ck340 FIND v(dout0_6) AT=350.05n

.meas tran vdout0_7ck340 FIND v(dout0_7) AT=350.05n

.meas tran vdout0_8ck340 FIND v(dout0_8) AT=350.05n

.meas tran vdout0_9ck340 FIND v(dout0_9) AT=350.05n

.meas tran vdout0_10ck340 FIND v(dout0_10) AT=350.05n

.meas tran vdout0_11ck340 FIND v(dout0_11) AT=350.05n

.meas tran vdout0_12ck340 FIND v(dout0_12) AT=350.05n

.meas tran vdout0_13ck340 FIND v(dout0_13) AT=350.05n

.meas tran vdout0_14ck340 FIND v(dout0_14) AT=350.05n

.meas tran vdout0_15ck340 FIND v(dout0_15) AT=350.05n

.meas tran vdout0_16ck340 FIND v(dout0_16) AT=350.05n

.meas tran vdout0_17ck340 FIND v(dout0_17) AT=350.05n

.meas tran vdout0_18ck340 FIND v(dout0_18) AT=350.05n

.meas tran vdout0_19ck340 FIND v(dout0_19) AT=350.05n

.meas tran vdout0_20ck340 FIND v(dout0_20) AT=350.05n

.meas tran vdout0_21ck340 FIND v(dout0_21) AT=350.05n

.meas tran vdout0_22ck340 FIND v(dout0_22) AT=350.05n

.meas tran vdout0_23ck340 FIND v(dout0_23) AT=350.05n

.meas tran vdout0_24ck340 FIND v(dout0_24) AT=350.05n

.meas tran vdout0_25ck340 FIND v(dout0_25) AT=350.05n

.meas tran vdout0_26ck340 FIND v(dout0_26) AT=350.05n

.meas tran vdout0_27ck340 FIND v(dout0_27) AT=350.05n

.meas tran vdout0_28ck340 FIND v(dout0_28) AT=350.05n

.meas tran vdout0_29ck340 FIND v(dout0_29) AT=350.05n

.meas tran vdout0_30ck340 FIND v(dout0_30) AT=350.05n

.meas tran vdout0_31ck340 FIND v(dout0_31) AT=350.05n

.meas tran vdout0_32ck340 FIND v(dout0_32) AT=350.05n

.meas tran vdout0_0ck350 FIND v(dout0_0) AT=360.05n

.meas tran vdout0_1ck350 FIND v(dout0_1) AT=360.05n

.meas tran vdout0_2ck350 FIND v(dout0_2) AT=360.05n

.meas tran vdout0_3ck350 FIND v(dout0_3) AT=360.05n

.meas tran vdout0_4ck350 FIND v(dout0_4) AT=360.05n

.meas tran vdout0_5ck350 FIND v(dout0_5) AT=360.05n

.meas tran vdout0_6ck350 FIND v(dout0_6) AT=360.05n

.meas tran vdout0_7ck350 FIND v(dout0_7) AT=360.05n

.meas tran vdout0_8ck350 FIND v(dout0_8) AT=360.05n

.meas tran vdout0_9ck350 FIND v(dout0_9) AT=360.05n

.meas tran vdout0_10ck350 FIND v(dout0_10) AT=360.05n

.meas tran vdout0_11ck350 FIND v(dout0_11) AT=360.05n

.meas tran vdout0_12ck350 FIND v(dout0_12) AT=360.05n

.meas tran vdout0_13ck350 FIND v(dout0_13) AT=360.05n

.meas tran vdout0_14ck350 FIND v(dout0_14) AT=360.05n

.meas tran vdout0_15ck350 FIND v(dout0_15) AT=360.05n

.meas tran vdout0_16ck350 FIND v(dout0_16) AT=360.05n

.meas tran vdout0_17ck350 FIND v(dout0_17) AT=360.05n

.meas tran vdout0_18ck350 FIND v(dout0_18) AT=360.05n

.meas tran vdout0_19ck350 FIND v(dout0_19) AT=360.05n

.meas tran vdout0_20ck350 FIND v(dout0_20) AT=360.05n

.meas tran vdout0_21ck350 FIND v(dout0_21) AT=360.05n

.meas tran vdout0_22ck350 FIND v(dout0_22) AT=360.05n

.meas tran vdout0_23ck350 FIND v(dout0_23) AT=360.05n

.meas tran vdout0_24ck350 FIND v(dout0_24) AT=360.05n

.meas tran vdout0_25ck350 FIND v(dout0_25) AT=360.05n

.meas tran vdout0_26ck350 FIND v(dout0_26) AT=360.05n

.meas tran vdout0_27ck350 FIND v(dout0_27) AT=360.05n

.meas tran vdout0_28ck350 FIND v(dout0_28) AT=360.05n

.meas tran vdout0_29ck350 FIND v(dout0_29) AT=360.05n

.meas tran vdout0_30ck350 FIND v(dout0_30) AT=360.05n

.meas tran vdout0_31ck350 FIND v(dout0_31) AT=360.05n

.meas tran vdout0_32ck350 FIND v(dout0_32) AT=360.05n

.meas tran vdout0_0ck360 FIND v(dout0_0) AT=370.05n

.meas tran vdout0_1ck360 FIND v(dout0_1) AT=370.05n

.meas tran vdout0_2ck360 FIND v(dout0_2) AT=370.05n

.meas tran vdout0_3ck360 FIND v(dout0_3) AT=370.05n

.meas tran vdout0_4ck360 FIND v(dout0_4) AT=370.05n

.meas tran vdout0_5ck360 FIND v(dout0_5) AT=370.05n

.meas tran vdout0_6ck360 FIND v(dout0_6) AT=370.05n

.meas tran vdout0_7ck360 FIND v(dout0_7) AT=370.05n

.meas tran vdout0_8ck360 FIND v(dout0_8) AT=370.05n

.meas tran vdout0_9ck360 FIND v(dout0_9) AT=370.05n

.meas tran vdout0_10ck360 FIND v(dout0_10) AT=370.05n

.meas tran vdout0_11ck360 FIND v(dout0_11) AT=370.05n

.meas tran vdout0_12ck360 FIND v(dout0_12) AT=370.05n

.meas tran vdout0_13ck360 FIND v(dout0_13) AT=370.05n

.meas tran vdout0_14ck360 FIND v(dout0_14) AT=370.05n

.meas tran vdout0_15ck360 FIND v(dout0_15) AT=370.05n

.meas tran vdout0_16ck360 FIND v(dout0_16) AT=370.05n

.meas tran vdout0_17ck360 FIND v(dout0_17) AT=370.05n

.meas tran vdout0_18ck360 FIND v(dout0_18) AT=370.05n

.meas tran vdout0_19ck360 FIND v(dout0_19) AT=370.05n

.meas tran vdout0_20ck360 FIND v(dout0_20) AT=370.05n

.meas tran vdout0_21ck360 FIND v(dout0_21) AT=370.05n

.meas tran vdout0_22ck360 FIND v(dout0_22) AT=370.05n

.meas tran vdout0_23ck360 FIND v(dout0_23) AT=370.05n

.meas tran vdout0_24ck360 FIND v(dout0_24) AT=370.05n

.meas tran vdout0_25ck360 FIND v(dout0_25) AT=370.05n

.meas tran vdout0_26ck360 FIND v(dout0_26) AT=370.05n

.meas tran vdout0_27ck360 FIND v(dout0_27) AT=370.05n

.meas tran vdout0_28ck360 FIND v(dout0_28) AT=370.05n

.meas tran vdout0_29ck360 FIND v(dout0_29) AT=370.05n

.meas tran vdout0_30ck360 FIND v(dout0_30) AT=370.05n

.meas tran vdout0_31ck360 FIND v(dout0_31) AT=370.05n

.meas tran vdout0_32ck360 FIND v(dout0_32) AT=370.05n

.meas tran vdout0_0ck370 FIND v(dout0_0) AT=380.05n

.meas tran vdout0_1ck370 FIND v(dout0_1) AT=380.05n

.meas tran vdout0_2ck370 FIND v(dout0_2) AT=380.05n

.meas tran vdout0_3ck370 FIND v(dout0_3) AT=380.05n

.meas tran vdout0_4ck370 FIND v(dout0_4) AT=380.05n

.meas tran vdout0_5ck370 FIND v(dout0_5) AT=380.05n

.meas tran vdout0_6ck370 FIND v(dout0_6) AT=380.05n

.meas tran vdout0_7ck370 FIND v(dout0_7) AT=380.05n

.meas tran vdout0_8ck370 FIND v(dout0_8) AT=380.05n

.meas tran vdout0_9ck370 FIND v(dout0_9) AT=380.05n

.meas tran vdout0_10ck370 FIND v(dout0_10) AT=380.05n

.meas tran vdout0_11ck370 FIND v(dout0_11) AT=380.05n

.meas tran vdout0_12ck370 FIND v(dout0_12) AT=380.05n

.meas tran vdout0_13ck370 FIND v(dout0_13) AT=380.05n

.meas tran vdout0_14ck370 FIND v(dout0_14) AT=380.05n

.meas tran vdout0_15ck370 FIND v(dout0_15) AT=380.05n

.meas tran vdout0_16ck370 FIND v(dout0_16) AT=380.05n

.meas tran vdout0_17ck370 FIND v(dout0_17) AT=380.05n

.meas tran vdout0_18ck370 FIND v(dout0_18) AT=380.05n

.meas tran vdout0_19ck370 FIND v(dout0_19) AT=380.05n

.meas tran vdout0_20ck370 FIND v(dout0_20) AT=380.05n

.meas tran vdout0_21ck370 FIND v(dout0_21) AT=380.05n

.meas tran vdout0_22ck370 FIND v(dout0_22) AT=380.05n

.meas tran vdout0_23ck370 FIND v(dout0_23) AT=380.05n

.meas tran vdout0_24ck370 FIND v(dout0_24) AT=380.05n

.meas tran vdout0_25ck370 FIND v(dout0_25) AT=380.05n

.meas tran vdout0_26ck370 FIND v(dout0_26) AT=380.05n

.meas tran vdout0_27ck370 FIND v(dout0_27) AT=380.05n

.meas tran vdout0_28ck370 FIND v(dout0_28) AT=380.05n

.meas tran vdout0_29ck370 FIND v(dout0_29) AT=380.05n

.meas tran vdout0_30ck370 FIND v(dout0_30) AT=380.05n

.meas tran vdout0_31ck370 FIND v(dout0_31) AT=380.05n

.meas tran vdout0_32ck370 FIND v(dout0_32) AT=380.05n

.meas tran vdout0_0ck390 FIND v(dout0_0) AT=400.05n

.meas tran vdout0_1ck390 FIND v(dout0_1) AT=400.05n

.meas tran vdout0_2ck390 FIND v(dout0_2) AT=400.05n

.meas tran vdout0_3ck390 FIND v(dout0_3) AT=400.05n

.meas tran vdout0_4ck390 FIND v(dout0_4) AT=400.05n

.meas tran vdout0_5ck390 FIND v(dout0_5) AT=400.05n

.meas tran vdout0_6ck390 FIND v(dout0_6) AT=400.05n

.meas tran vdout0_7ck390 FIND v(dout0_7) AT=400.05n

.meas tran vdout0_8ck390 FIND v(dout0_8) AT=400.05n

.meas tran vdout0_9ck390 FIND v(dout0_9) AT=400.05n

.meas tran vdout0_10ck390 FIND v(dout0_10) AT=400.05n

.meas tran vdout0_11ck390 FIND v(dout0_11) AT=400.05n

.meas tran vdout0_12ck390 FIND v(dout0_12) AT=400.05n

.meas tran vdout0_13ck390 FIND v(dout0_13) AT=400.05n

.meas tran vdout0_14ck390 FIND v(dout0_14) AT=400.05n

.meas tran vdout0_15ck390 FIND v(dout0_15) AT=400.05n

.meas tran vdout0_16ck390 FIND v(dout0_16) AT=400.05n

.meas tran vdout0_17ck390 FIND v(dout0_17) AT=400.05n

.meas tran vdout0_18ck390 FIND v(dout0_18) AT=400.05n

.meas tran vdout0_19ck390 FIND v(dout0_19) AT=400.05n

.meas tran vdout0_20ck390 FIND v(dout0_20) AT=400.05n

.meas tran vdout0_21ck390 FIND v(dout0_21) AT=400.05n

.meas tran vdout0_22ck390 FIND v(dout0_22) AT=400.05n

.meas tran vdout0_23ck390 FIND v(dout0_23) AT=400.05n

.meas tran vdout0_24ck390 FIND v(dout0_24) AT=400.05n

.meas tran vdout0_25ck390 FIND v(dout0_25) AT=400.05n

.meas tran vdout0_26ck390 FIND v(dout0_26) AT=400.05n

.meas tran vdout0_27ck390 FIND v(dout0_27) AT=400.05n

.meas tran vdout0_28ck390 FIND v(dout0_28) AT=400.05n

.meas tran vdout0_29ck390 FIND v(dout0_29) AT=400.05n

.meas tran vdout0_30ck390 FIND v(dout0_30) AT=400.05n

.meas tran vdout0_31ck390 FIND v(dout0_31) AT=400.05n

.meas tran vdout0_32ck390 FIND v(dout0_32) AT=400.05n

.meas tran vdout0_0ck440 FIND v(dout0_0) AT=450.05n

.meas tran vdout0_1ck440 FIND v(dout0_1) AT=450.05n

.meas tran vdout0_2ck440 FIND v(dout0_2) AT=450.05n

.meas tran vdout0_3ck440 FIND v(dout0_3) AT=450.05n

.meas tran vdout0_4ck440 FIND v(dout0_4) AT=450.05n

.meas tran vdout0_5ck440 FIND v(dout0_5) AT=450.05n

.meas tran vdout0_6ck440 FIND v(dout0_6) AT=450.05n

.meas tran vdout0_7ck440 FIND v(dout0_7) AT=450.05n

.meas tran vdout0_8ck440 FIND v(dout0_8) AT=450.05n

.meas tran vdout0_9ck440 FIND v(dout0_9) AT=450.05n

.meas tran vdout0_10ck440 FIND v(dout0_10) AT=450.05n

.meas tran vdout0_11ck440 FIND v(dout0_11) AT=450.05n

.meas tran vdout0_12ck440 FIND v(dout0_12) AT=450.05n

.meas tran vdout0_13ck440 FIND v(dout0_13) AT=450.05n

.meas tran vdout0_14ck440 FIND v(dout0_14) AT=450.05n

.meas tran vdout0_15ck440 FIND v(dout0_15) AT=450.05n

.meas tran vdout0_16ck440 FIND v(dout0_16) AT=450.05n

.meas tran vdout0_17ck440 FIND v(dout0_17) AT=450.05n

.meas tran vdout0_18ck440 FIND v(dout0_18) AT=450.05n

.meas tran vdout0_19ck440 FIND v(dout0_19) AT=450.05n

.meas tran vdout0_20ck440 FIND v(dout0_20) AT=450.05n

.meas tran vdout0_21ck440 FIND v(dout0_21) AT=450.05n

.meas tran vdout0_22ck440 FIND v(dout0_22) AT=450.05n

.meas tran vdout0_23ck440 FIND v(dout0_23) AT=450.05n

.meas tran vdout0_24ck440 FIND v(dout0_24) AT=450.05n

.meas tran vdout0_25ck440 FIND v(dout0_25) AT=450.05n

.meas tran vdout0_26ck440 FIND v(dout0_26) AT=450.05n

.meas tran vdout0_27ck440 FIND v(dout0_27) AT=450.05n

.meas tran vdout0_28ck440 FIND v(dout0_28) AT=450.05n

.meas tran vdout0_29ck440 FIND v(dout0_29) AT=450.05n

.meas tran vdout0_30ck440 FIND v(dout0_30) AT=450.05n

.meas tran vdout0_31ck440 FIND v(dout0_31) AT=450.05n

.meas tran vdout0_32ck440 FIND v(dout0_32) AT=450.05n

.meas tran vdout0_0ck460 FIND v(dout0_0) AT=470.05n

.meas tran vdout0_1ck460 FIND v(dout0_1) AT=470.05n

.meas tran vdout0_2ck460 FIND v(dout0_2) AT=470.05n

.meas tran vdout0_3ck460 FIND v(dout0_3) AT=470.05n

.meas tran vdout0_4ck460 FIND v(dout0_4) AT=470.05n

.meas tran vdout0_5ck460 FIND v(dout0_5) AT=470.05n

.meas tran vdout0_6ck460 FIND v(dout0_6) AT=470.05n

.meas tran vdout0_7ck460 FIND v(dout0_7) AT=470.05n

.meas tran vdout0_8ck460 FIND v(dout0_8) AT=470.05n

.meas tran vdout0_9ck460 FIND v(dout0_9) AT=470.05n

.meas tran vdout0_10ck460 FIND v(dout0_10) AT=470.05n

.meas tran vdout0_11ck460 FIND v(dout0_11) AT=470.05n

.meas tran vdout0_12ck460 FIND v(dout0_12) AT=470.05n

.meas tran vdout0_13ck460 FIND v(dout0_13) AT=470.05n

.meas tran vdout0_14ck460 FIND v(dout0_14) AT=470.05n

.meas tran vdout0_15ck460 FIND v(dout0_15) AT=470.05n

.meas tran vdout0_16ck460 FIND v(dout0_16) AT=470.05n

.meas tran vdout0_17ck460 FIND v(dout0_17) AT=470.05n

.meas tran vdout0_18ck460 FIND v(dout0_18) AT=470.05n

.meas tran vdout0_19ck460 FIND v(dout0_19) AT=470.05n

.meas tran vdout0_20ck460 FIND v(dout0_20) AT=470.05n

.meas tran vdout0_21ck460 FIND v(dout0_21) AT=470.05n

.meas tran vdout0_22ck460 FIND v(dout0_22) AT=470.05n

.meas tran vdout0_23ck460 FIND v(dout0_23) AT=470.05n

.meas tran vdout0_24ck460 FIND v(dout0_24) AT=470.05n

.meas tran vdout0_25ck460 FIND v(dout0_25) AT=470.05n

.meas tran vdout0_26ck460 FIND v(dout0_26) AT=470.05n

.meas tran vdout0_27ck460 FIND v(dout0_27) AT=470.05n

.meas tran vdout0_28ck460 FIND v(dout0_28) AT=470.05n

.meas tran vdout0_29ck460 FIND v(dout0_29) AT=470.05n

.meas tran vdout0_30ck460 FIND v(dout0_30) AT=470.05n

.meas tran vdout0_31ck460 FIND v(dout0_31) AT=470.05n

.meas tran vdout0_32ck460 FIND v(dout0_32) AT=470.05n

.meas tran vdout0_0ck490 FIND v(dout0_0) AT=500.05n

.meas tran vdout0_1ck490 FIND v(dout0_1) AT=500.05n

.meas tran vdout0_2ck490 FIND v(dout0_2) AT=500.05n

.meas tran vdout0_3ck490 FIND v(dout0_3) AT=500.05n

.meas tran vdout0_4ck490 FIND v(dout0_4) AT=500.05n

.meas tran vdout0_5ck490 FIND v(dout0_5) AT=500.05n

.meas tran vdout0_6ck490 FIND v(dout0_6) AT=500.05n

.meas tran vdout0_7ck490 FIND v(dout0_7) AT=500.05n

.meas tran vdout0_8ck490 FIND v(dout0_8) AT=500.05n

.meas tran vdout0_9ck490 FIND v(dout0_9) AT=500.05n

.meas tran vdout0_10ck490 FIND v(dout0_10) AT=500.05n

.meas tran vdout0_11ck490 FIND v(dout0_11) AT=500.05n

.meas tran vdout0_12ck490 FIND v(dout0_12) AT=500.05n

.meas tran vdout0_13ck490 FIND v(dout0_13) AT=500.05n

.meas tran vdout0_14ck490 FIND v(dout0_14) AT=500.05n

.meas tran vdout0_15ck490 FIND v(dout0_15) AT=500.05n

.meas tran vdout0_16ck490 FIND v(dout0_16) AT=500.05n

.meas tran vdout0_17ck490 FIND v(dout0_17) AT=500.05n

.meas tran vdout0_18ck490 FIND v(dout0_18) AT=500.05n

.meas tran vdout0_19ck490 FIND v(dout0_19) AT=500.05n

.meas tran vdout0_20ck490 FIND v(dout0_20) AT=500.05n

.meas tran vdout0_21ck490 FIND v(dout0_21) AT=500.05n

.meas tran vdout0_22ck490 FIND v(dout0_22) AT=500.05n

.meas tran vdout0_23ck490 FIND v(dout0_23) AT=500.05n

.meas tran vdout0_24ck490 FIND v(dout0_24) AT=500.05n

.meas tran vdout0_25ck490 FIND v(dout0_25) AT=500.05n

.meas tran vdout0_26ck490 FIND v(dout0_26) AT=500.05n

.meas tran vdout0_27ck490 FIND v(dout0_27) AT=500.05n

.meas tran vdout0_28ck490 FIND v(dout0_28) AT=500.05n

.meas tran vdout0_29ck490 FIND v(dout0_29) AT=500.05n

.meas tran vdout0_30ck490 FIND v(dout0_30) AT=500.05n

.meas tran vdout0_31ck490 FIND v(dout0_31) AT=500.05n

.meas tran vdout0_32ck490 FIND v(dout0_32) AT=500.05n

.meas tran vdout0_0ck540 FIND v(dout0_0) AT=550.05n

.meas tran vdout0_1ck540 FIND v(dout0_1) AT=550.05n

.meas tran vdout0_2ck540 FIND v(dout0_2) AT=550.05n

.meas tran vdout0_3ck540 FIND v(dout0_3) AT=550.05n

.meas tran vdout0_4ck540 FIND v(dout0_4) AT=550.05n

.meas tran vdout0_5ck540 FIND v(dout0_5) AT=550.05n

.meas tran vdout0_6ck540 FIND v(dout0_6) AT=550.05n

.meas tran vdout0_7ck540 FIND v(dout0_7) AT=550.05n

.meas tran vdout0_8ck540 FIND v(dout0_8) AT=550.05n

.meas tran vdout0_9ck540 FIND v(dout0_9) AT=550.05n

.meas tran vdout0_10ck540 FIND v(dout0_10) AT=550.05n

.meas tran vdout0_11ck540 FIND v(dout0_11) AT=550.05n

.meas tran vdout0_12ck540 FIND v(dout0_12) AT=550.05n

.meas tran vdout0_13ck540 FIND v(dout0_13) AT=550.05n

.meas tran vdout0_14ck540 FIND v(dout0_14) AT=550.05n

.meas tran vdout0_15ck540 FIND v(dout0_15) AT=550.05n

.meas tran vdout0_16ck540 FIND v(dout0_16) AT=550.05n

.meas tran vdout0_17ck540 FIND v(dout0_17) AT=550.05n

.meas tran vdout0_18ck540 FIND v(dout0_18) AT=550.05n

.meas tran vdout0_19ck540 FIND v(dout0_19) AT=550.05n

.meas tran vdout0_20ck540 FIND v(dout0_20) AT=550.05n

.meas tran vdout0_21ck540 FIND v(dout0_21) AT=550.05n

.meas tran vdout0_22ck540 FIND v(dout0_22) AT=550.05n

.meas tran vdout0_23ck540 FIND v(dout0_23) AT=550.05n

.meas tran vdout0_24ck540 FIND v(dout0_24) AT=550.05n

.meas tran vdout0_25ck540 FIND v(dout0_25) AT=550.05n

.meas tran vdout0_26ck540 FIND v(dout0_26) AT=550.05n

.meas tran vdout0_27ck540 FIND v(dout0_27) AT=550.05n

.meas tran vdout0_28ck540 FIND v(dout0_28) AT=550.05n

.meas tran vdout0_29ck540 FIND v(dout0_29) AT=550.05n

.meas tran vdout0_30ck540 FIND v(dout0_30) AT=550.05n

.meas tran vdout0_31ck540 FIND v(dout0_31) AT=550.05n

.meas tran vdout0_32ck540 FIND v(dout0_32) AT=550.05n

.meas tran vdout0_0ck550 FIND v(dout0_0) AT=560.05n

.meas tran vdout0_1ck550 FIND v(dout0_1) AT=560.05n

.meas tran vdout0_2ck550 FIND v(dout0_2) AT=560.05n

.meas tran vdout0_3ck550 FIND v(dout0_3) AT=560.05n

.meas tran vdout0_4ck550 FIND v(dout0_4) AT=560.05n

.meas tran vdout0_5ck550 FIND v(dout0_5) AT=560.05n

.meas tran vdout0_6ck550 FIND v(dout0_6) AT=560.05n

.meas tran vdout0_7ck550 FIND v(dout0_7) AT=560.05n

.meas tran vdout0_8ck550 FIND v(dout0_8) AT=560.05n

.meas tran vdout0_9ck550 FIND v(dout0_9) AT=560.05n

.meas tran vdout0_10ck550 FIND v(dout0_10) AT=560.05n

.meas tran vdout0_11ck550 FIND v(dout0_11) AT=560.05n

.meas tran vdout0_12ck550 FIND v(dout0_12) AT=560.05n

.meas tran vdout0_13ck550 FIND v(dout0_13) AT=560.05n

.meas tran vdout0_14ck550 FIND v(dout0_14) AT=560.05n

.meas tran vdout0_15ck550 FIND v(dout0_15) AT=560.05n

.meas tran vdout0_16ck550 FIND v(dout0_16) AT=560.05n

.meas tran vdout0_17ck550 FIND v(dout0_17) AT=560.05n

.meas tran vdout0_18ck550 FIND v(dout0_18) AT=560.05n

.meas tran vdout0_19ck550 FIND v(dout0_19) AT=560.05n

.meas tran vdout0_20ck550 FIND v(dout0_20) AT=560.05n

.meas tran vdout0_21ck550 FIND v(dout0_21) AT=560.05n

.meas tran vdout0_22ck550 FIND v(dout0_22) AT=560.05n

.meas tran vdout0_23ck550 FIND v(dout0_23) AT=560.05n

.meas tran vdout0_24ck550 FIND v(dout0_24) AT=560.05n

.meas tran vdout0_25ck550 FIND v(dout0_25) AT=560.05n

.meas tran vdout0_26ck550 FIND v(dout0_26) AT=560.05n

.meas tran vdout0_27ck550 FIND v(dout0_27) AT=560.05n

.meas tran vdout0_28ck550 FIND v(dout0_28) AT=560.05n

.meas tran vdout0_29ck550 FIND v(dout0_29) AT=560.05n

.meas tran vdout0_30ck550 FIND v(dout0_30) AT=560.05n

.meas tran vdout0_31ck550 FIND v(dout0_31) AT=560.05n

.meas tran vdout0_32ck550 FIND v(dout0_32) AT=560.05n

.meas tran vdout0_0ck560 FIND v(dout0_0) AT=570.05n

.meas tran vdout0_1ck560 FIND v(dout0_1) AT=570.05n

.meas tran vdout0_2ck560 FIND v(dout0_2) AT=570.05n

.meas tran vdout0_3ck560 FIND v(dout0_3) AT=570.05n

.meas tran vdout0_4ck560 FIND v(dout0_4) AT=570.05n

.meas tran vdout0_5ck560 FIND v(dout0_5) AT=570.05n

.meas tran vdout0_6ck560 FIND v(dout0_6) AT=570.05n

.meas tran vdout0_7ck560 FIND v(dout0_7) AT=570.05n

.meas tran vdout0_8ck560 FIND v(dout0_8) AT=570.05n

.meas tran vdout0_9ck560 FIND v(dout0_9) AT=570.05n

.meas tran vdout0_10ck560 FIND v(dout0_10) AT=570.05n

.meas tran vdout0_11ck560 FIND v(dout0_11) AT=570.05n

.meas tran vdout0_12ck560 FIND v(dout0_12) AT=570.05n

.meas tran vdout0_13ck560 FIND v(dout0_13) AT=570.05n

.meas tran vdout0_14ck560 FIND v(dout0_14) AT=570.05n

.meas tran vdout0_15ck560 FIND v(dout0_15) AT=570.05n

.meas tran vdout0_16ck560 FIND v(dout0_16) AT=570.05n

.meas tran vdout0_17ck560 FIND v(dout0_17) AT=570.05n

.meas tran vdout0_18ck560 FIND v(dout0_18) AT=570.05n

.meas tran vdout0_19ck560 FIND v(dout0_19) AT=570.05n

.meas tran vdout0_20ck560 FIND v(dout0_20) AT=570.05n

.meas tran vdout0_21ck560 FIND v(dout0_21) AT=570.05n

.meas tran vdout0_22ck560 FIND v(dout0_22) AT=570.05n

.meas tran vdout0_23ck560 FIND v(dout0_23) AT=570.05n

.meas tran vdout0_24ck560 FIND v(dout0_24) AT=570.05n

.meas tran vdout0_25ck560 FIND v(dout0_25) AT=570.05n

.meas tran vdout0_26ck560 FIND v(dout0_26) AT=570.05n

.meas tran vdout0_27ck560 FIND v(dout0_27) AT=570.05n

.meas tran vdout0_28ck560 FIND v(dout0_28) AT=570.05n

.meas tran vdout0_29ck560 FIND v(dout0_29) AT=570.05n

.meas tran vdout0_30ck560 FIND v(dout0_30) AT=570.05n

.meas tran vdout0_31ck560 FIND v(dout0_31) AT=570.05n

.meas tran vdout0_32ck560 FIND v(dout0_32) AT=570.05n

.meas tran vdout0_0ck580 FIND v(dout0_0) AT=590.05n

.meas tran vdout0_1ck580 FIND v(dout0_1) AT=590.05n

.meas tran vdout0_2ck580 FIND v(dout0_2) AT=590.05n

.meas tran vdout0_3ck580 FIND v(dout0_3) AT=590.05n

.meas tran vdout0_4ck580 FIND v(dout0_4) AT=590.05n

.meas tran vdout0_5ck580 FIND v(dout0_5) AT=590.05n

.meas tran vdout0_6ck580 FIND v(dout0_6) AT=590.05n

.meas tran vdout0_7ck580 FIND v(dout0_7) AT=590.05n

.meas tran vdout0_8ck580 FIND v(dout0_8) AT=590.05n

.meas tran vdout0_9ck580 FIND v(dout0_9) AT=590.05n

.meas tran vdout0_10ck580 FIND v(dout0_10) AT=590.05n

.meas tran vdout0_11ck580 FIND v(dout0_11) AT=590.05n

.meas tran vdout0_12ck580 FIND v(dout0_12) AT=590.05n

.meas tran vdout0_13ck580 FIND v(dout0_13) AT=590.05n

.meas tran vdout0_14ck580 FIND v(dout0_14) AT=590.05n

.meas tran vdout0_15ck580 FIND v(dout0_15) AT=590.05n

.meas tran vdout0_16ck580 FIND v(dout0_16) AT=590.05n

.meas tran vdout0_17ck580 FIND v(dout0_17) AT=590.05n

.meas tran vdout0_18ck580 FIND v(dout0_18) AT=590.05n

.meas tran vdout0_19ck580 FIND v(dout0_19) AT=590.05n

.meas tran vdout0_20ck580 FIND v(dout0_20) AT=590.05n

.meas tran vdout0_21ck580 FIND v(dout0_21) AT=590.05n

.meas tran vdout0_22ck580 FIND v(dout0_22) AT=590.05n

.meas tran vdout0_23ck580 FIND v(dout0_23) AT=590.05n

.meas tran vdout0_24ck580 FIND v(dout0_24) AT=590.05n

.meas tran vdout0_25ck580 FIND v(dout0_25) AT=590.05n

.meas tran vdout0_26ck580 FIND v(dout0_26) AT=590.05n

.meas tran vdout0_27ck580 FIND v(dout0_27) AT=590.05n

.meas tran vdout0_28ck580 FIND v(dout0_28) AT=590.05n

.meas tran vdout0_29ck580 FIND v(dout0_29) AT=590.05n

.meas tran vdout0_30ck580 FIND v(dout0_30) AT=590.05n

.meas tran vdout0_31ck580 FIND v(dout0_31) AT=590.05n

.meas tran vdout0_32ck580 FIND v(dout0_32) AT=590.05n

.meas tran vdout0_0ck610 FIND v(dout0_0) AT=620.05n

.meas tran vdout0_1ck610 FIND v(dout0_1) AT=620.05n

.meas tran vdout0_2ck610 FIND v(dout0_2) AT=620.05n

.meas tran vdout0_3ck610 FIND v(dout0_3) AT=620.05n

.meas tran vdout0_4ck610 FIND v(dout0_4) AT=620.05n

.meas tran vdout0_5ck610 FIND v(dout0_5) AT=620.05n

.meas tran vdout0_6ck610 FIND v(dout0_6) AT=620.05n

.meas tran vdout0_7ck610 FIND v(dout0_7) AT=620.05n

.meas tran vdout0_8ck610 FIND v(dout0_8) AT=620.05n

.meas tran vdout0_9ck610 FIND v(dout0_9) AT=620.05n

.meas tran vdout0_10ck610 FIND v(dout0_10) AT=620.05n

.meas tran vdout0_11ck610 FIND v(dout0_11) AT=620.05n

.meas tran vdout0_12ck610 FIND v(dout0_12) AT=620.05n

.meas tran vdout0_13ck610 FIND v(dout0_13) AT=620.05n

.meas tran vdout0_14ck610 FIND v(dout0_14) AT=620.05n

.meas tran vdout0_15ck610 FIND v(dout0_15) AT=620.05n

.meas tran vdout0_16ck610 FIND v(dout0_16) AT=620.05n

.meas tran vdout0_17ck610 FIND v(dout0_17) AT=620.05n

.meas tran vdout0_18ck610 FIND v(dout0_18) AT=620.05n

.meas tran vdout0_19ck610 FIND v(dout0_19) AT=620.05n

.meas tran vdout0_20ck610 FIND v(dout0_20) AT=620.05n

.meas tran vdout0_21ck610 FIND v(dout0_21) AT=620.05n

.meas tran vdout0_22ck610 FIND v(dout0_22) AT=620.05n

.meas tran vdout0_23ck610 FIND v(dout0_23) AT=620.05n

.meas tran vdout0_24ck610 FIND v(dout0_24) AT=620.05n

.meas tran vdout0_25ck610 FIND v(dout0_25) AT=620.05n

.meas tran vdout0_26ck610 FIND v(dout0_26) AT=620.05n

.meas tran vdout0_27ck610 FIND v(dout0_27) AT=620.05n

.meas tran vdout0_28ck610 FIND v(dout0_28) AT=620.05n

.meas tran vdout0_29ck610 FIND v(dout0_29) AT=620.05n

.meas tran vdout0_30ck610 FIND v(dout0_30) AT=620.05n

.meas tran vdout0_31ck610 FIND v(dout0_31) AT=620.05n

.meas tran vdout0_32ck610 FIND v(dout0_32) AT=620.05n

.meas tran vdout0_0ck630 FIND v(dout0_0) AT=640.05n

.meas tran vdout0_1ck630 FIND v(dout0_1) AT=640.05n

.meas tran vdout0_2ck630 FIND v(dout0_2) AT=640.05n

.meas tran vdout0_3ck630 FIND v(dout0_3) AT=640.05n

.meas tran vdout0_4ck630 FIND v(dout0_4) AT=640.05n

.meas tran vdout0_5ck630 FIND v(dout0_5) AT=640.05n

.meas tran vdout0_6ck630 FIND v(dout0_6) AT=640.05n

.meas tran vdout0_7ck630 FIND v(dout0_7) AT=640.05n

.meas tran vdout0_8ck630 FIND v(dout0_8) AT=640.05n

.meas tran vdout0_9ck630 FIND v(dout0_9) AT=640.05n

.meas tran vdout0_10ck630 FIND v(dout0_10) AT=640.05n

.meas tran vdout0_11ck630 FIND v(dout0_11) AT=640.05n

.meas tran vdout0_12ck630 FIND v(dout0_12) AT=640.05n

.meas tran vdout0_13ck630 FIND v(dout0_13) AT=640.05n

.meas tran vdout0_14ck630 FIND v(dout0_14) AT=640.05n

.meas tran vdout0_15ck630 FIND v(dout0_15) AT=640.05n

.meas tran vdout0_16ck630 FIND v(dout0_16) AT=640.05n

.meas tran vdout0_17ck630 FIND v(dout0_17) AT=640.05n

.meas tran vdout0_18ck630 FIND v(dout0_18) AT=640.05n

.meas tran vdout0_19ck630 FIND v(dout0_19) AT=640.05n

.meas tran vdout0_20ck630 FIND v(dout0_20) AT=640.05n

.meas tran vdout0_21ck630 FIND v(dout0_21) AT=640.05n

.meas tran vdout0_22ck630 FIND v(dout0_22) AT=640.05n

.meas tran vdout0_23ck630 FIND v(dout0_23) AT=640.05n

.meas tran vdout0_24ck630 FIND v(dout0_24) AT=640.05n

.meas tran vdout0_25ck630 FIND v(dout0_25) AT=640.05n

.meas tran vdout0_26ck630 FIND v(dout0_26) AT=640.05n

.meas tran vdout0_27ck630 FIND v(dout0_27) AT=640.05n

.meas tran vdout0_28ck630 FIND v(dout0_28) AT=640.05n

.meas tran vdout0_29ck630 FIND v(dout0_29) AT=640.05n

.meas tran vdout0_30ck630 FIND v(dout0_30) AT=640.05n

.meas tran vdout0_31ck630 FIND v(dout0_31) AT=640.05n

.meas tran vdout0_32ck630 FIND v(dout0_32) AT=640.05n

.meas tran vdout0_0ck640 FIND v(dout0_0) AT=650.05n

.meas tran vdout0_1ck640 FIND v(dout0_1) AT=650.05n

.meas tran vdout0_2ck640 FIND v(dout0_2) AT=650.05n

.meas tran vdout0_3ck640 FIND v(dout0_3) AT=650.05n

.meas tran vdout0_4ck640 FIND v(dout0_4) AT=650.05n

.meas tran vdout0_5ck640 FIND v(dout0_5) AT=650.05n

.meas tran vdout0_6ck640 FIND v(dout0_6) AT=650.05n

.meas tran vdout0_7ck640 FIND v(dout0_7) AT=650.05n

.meas tran vdout0_8ck640 FIND v(dout0_8) AT=650.05n

.meas tran vdout0_9ck640 FIND v(dout0_9) AT=650.05n

.meas tran vdout0_10ck640 FIND v(dout0_10) AT=650.05n

.meas tran vdout0_11ck640 FIND v(dout0_11) AT=650.05n

.meas tran vdout0_12ck640 FIND v(dout0_12) AT=650.05n

.meas tran vdout0_13ck640 FIND v(dout0_13) AT=650.05n

.meas tran vdout0_14ck640 FIND v(dout0_14) AT=650.05n

.meas tran vdout0_15ck640 FIND v(dout0_15) AT=650.05n

.meas tran vdout0_16ck640 FIND v(dout0_16) AT=650.05n

.meas tran vdout0_17ck640 FIND v(dout0_17) AT=650.05n

.meas tran vdout0_18ck640 FIND v(dout0_18) AT=650.05n

.meas tran vdout0_19ck640 FIND v(dout0_19) AT=650.05n

.meas tran vdout0_20ck640 FIND v(dout0_20) AT=650.05n

.meas tran vdout0_21ck640 FIND v(dout0_21) AT=650.05n

.meas tran vdout0_22ck640 FIND v(dout0_22) AT=650.05n

.meas tran vdout0_23ck640 FIND v(dout0_23) AT=650.05n

.meas tran vdout0_24ck640 FIND v(dout0_24) AT=650.05n

.meas tran vdout0_25ck640 FIND v(dout0_25) AT=650.05n

.meas tran vdout0_26ck640 FIND v(dout0_26) AT=650.05n

.meas tran vdout0_27ck640 FIND v(dout0_27) AT=650.05n

.meas tran vdout0_28ck640 FIND v(dout0_28) AT=650.05n

.meas tran vdout0_29ck640 FIND v(dout0_29) AT=650.05n

.meas tran vdout0_30ck640 FIND v(dout0_30) AT=650.05n

.meas tran vdout0_31ck640 FIND v(dout0_31) AT=650.05n

.meas tran vdout0_32ck640 FIND v(dout0_32) AT=650.05n

.meas tran vdout0_0ck650 FIND v(dout0_0) AT=660.05n

.meas tran vdout0_1ck650 FIND v(dout0_1) AT=660.05n

.meas tran vdout0_2ck650 FIND v(dout0_2) AT=660.05n

.meas tran vdout0_3ck650 FIND v(dout0_3) AT=660.05n

.meas tran vdout0_4ck650 FIND v(dout0_4) AT=660.05n

.meas tran vdout0_5ck650 FIND v(dout0_5) AT=660.05n

.meas tran vdout0_6ck650 FIND v(dout0_6) AT=660.05n

.meas tran vdout0_7ck650 FIND v(dout0_7) AT=660.05n

.meas tran vdout0_8ck650 FIND v(dout0_8) AT=660.05n

.meas tran vdout0_9ck650 FIND v(dout0_9) AT=660.05n

.meas tran vdout0_10ck650 FIND v(dout0_10) AT=660.05n

.meas tran vdout0_11ck650 FIND v(dout0_11) AT=660.05n

.meas tran vdout0_12ck650 FIND v(dout0_12) AT=660.05n

.meas tran vdout0_13ck650 FIND v(dout0_13) AT=660.05n

.meas tran vdout0_14ck650 FIND v(dout0_14) AT=660.05n

.meas tran vdout0_15ck650 FIND v(dout0_15) AT=660.05n

.meas tran vdout0_16ck650 FIND v(dout0_16) AT=660.05n

.meas tran vdout0_17ck650 FIND v(dout0_17) AT=660.05n

.meas tran vdout0_18ck650 FIND v(dout0_18) AT=660.05n

.meas tran vdout0_19ck650 FIND v(dout0_19) AT=660.05n

.meas tran vdout0_20ck650 FIND v(dout0_20) AT=660.05n

.meas tran vdout0_21ck650 FIND v(dout0_21) AT=660.05n

.meas tran vdout0_22ck650 FIND v(dout0_22) AT=660.05n

.meas tran vdout0_23ck650 FIND v(dout0_23) AT=660.05n

.meas tran vdout0_24ck650 FIND v(dout0_24) AT=660.05n

.meas tran vdout0_25ck650 FIND v(dout0_25) AT=660.05n

.meas tran vdout0_26ck650 FIND v(dout0_26) AT=660.05n

.meas tran vdout0_27ck650 FIND v(dout0_27) AT=660.05n

.meas tran vdout0_28ck650 FIND v(dout0_28) AT=660.05n

.meas tran vdout0_29ck650 FIND v(dout0_29) AT=660.05n

.meas tran vdout0_30ck650 FIND v(dout0_30) AT=660.05n

.meas tran vdout0_31ck650 FIND v(dout0_31) AT=660.05n

.meas tran vdout0_32ck650 FIND v(dout0_32) AT=660.05n

.meas tran vdout0_0ck690 FIND v(dout0_0) AT=700.05n

.meas tran vdout0_1ck690 FIND v(dout0_1) AT=700.05n

.meas tran vdout0_2ck690 FIND v(dout0_2) AT=700.05n

.meas tran vdout0_3ck690 FIND v(dout0_3) AT=700.05n

.meas tran vdout0_4ck690 FIND v(dout0_4) AT=700.05n

.meas tran vdout0_5ck690 FIND v(dout0_5) AT=700.05n

.meas tran vdout0_6ck690 FIND v(dout0_6) AT=700.05n

.meas tran vdout0_7ck690 FIND v(dout0_7) AT=700.05n

.meas tran vdout0_8ck690 FIND v(dout0_8) AT=700.05n

.meas tran vdout0_9ck690 FIND v(dout0_9) AT=700.05n

.meas tran vdout0_10ck690 FIND v(dout0_10) AT=700.05n

.meas tran vdout0_11ck690 FIND v(dout0_11) AT=700.05n

.meas tran vdout0_12ck690 FIND v(dout0_12) AT=700.05n

.meas tran vdout0_13ck690 FIND v(dout0_13) AT=700.05n

.meas tran vdout0_14ck690 FIND v(dout0_14) AT=700.05n

.meas tran vdout0_15ck690 FIND v(dout0_15) AT=700.05n

.meas tran vdout0_16ck690 FIND v(dout0_16) AT=700.05n

.meas tran vdout0_17ck690 FIND v(dout0_17) AT=700.05n

.meas tran vdout0_18ck690 FIND v(dout0_18) AT=700.05n

.meas tran vdout0_19ck690 FIND v(dout0_19) AT=700.05n

.meas tran vdout0_20ck690 FIND v(dout0_20) AT=700.05n

.meas tran vdout0_21ck690 FIND v(dout0_21) AT=700.05n

.meas tran vdout0_22ck690 FIND v(dout0_22) AT=700.05n

.meas tran vdout0_23ck690 FIND v(dout0_23) AT=700.05n

.meas tran vdout0_24ck690 FIND v(dout0_24) AT=700.05n

.meas tran vdout0_25ck690 FIND v(dout0_25) AT=700.05n

.meas tran vdout0_26ck690 FIND v(dout0_26) AT=700.05n

.meas tran vdout0_27ck690 FIND v(dout0_27) AT=700.05n

.meas tran vdout0_28ck690 FIND v(dout0_28) AT=700.05n

.meas tran vdout0_29ck690 FIND v(dout0_29) AT=700.05n

.meas tran vdout0_30ck690 FIND v(dout0_30) AT=700.05n

.meas tran vdout0_31ck690 FIND v(dout0_31) AT=700.05n

.meas tran vdout0_32ck690 FIND v(dout0_32) AT=700.05n

.meas tran vdout0_0ck700 FIND v(dout0_0) AT=710.05n

.meas tran vdout0_1ck700 FIND v(dout0_1) AT=710.05n

.meas tran vdout0_2ck700 FIND v(dout0_2) AT=710.05n

.meas tran vdout0_3ck700 FIND v(dout0_3) AT=710.05n

.meas tran vdout0_4ck700 FIND v(dout0_4) AT=710.05n

.meas tran vdout0_5ck700 FIND v(dout0_5) AT=710.05n

.meas tran vdout0_6ck700 FIND v(dout0_6) AT=710.05n

.meas tran vdout0_7ck700 FIND v(dout0_7) AT=710.05n

.meas tran vdout0_8ck700 FIND v(dout0_8) AT=710.05n

.meas tran vdout0_9ck700 FIND v(dout0_9) AT=710.05n

.meas tran vdout0_10ck700 FIND v(dout0_10) AT=710.05n

.meas tran vdout0_11ck700 FIND v(dout0_11) AT=710.05n

.meas tran vdout0_12ck700 FIND v(dout0_12) AT=710.05n

.meas tran vdout0_13ck700 FIND v(dout0_13) AT=710.05n

.meas tran vdout0_14ck700 FIND v(dout0_14) AT=710.05n

.meas tran vdout0_15ck700 FIND v(dout0_15) AT=710.05n

.meas tran vdout0_16ck700 FIND v(dout0_16) AT=710.05n

.meas tran vdout0_17ck700 FIND v(dout0_17) AT=710.05n

.meas tran vdout0_18ck700 FIND v(dout0_18) AT=710.05n

.meas tran vdout0_19ck700 FIND v(dout0_19) AT=710.05n

.meas tran vdout0_20ck700 FIND v(dout0_20) AT=710.05n

.meas tran vdout0_21ck700 FIND v(dout0_21) AT=710.05n

.meas tran vdout0_22ck700 FIND v(dout0_22) AT=710.05n

.meas tran vdout0_23ck700 FIND v(dout0_23) AT=710.05n

.meas tran vdout0_24ck700 FIND v(dout0_24) AT=710.05n

.meas tran vdout0_25ck700 FIND v(dout0_25) AT=710.05n

.meas tran vdout0_26ck700 FIND v(dout0_26) AT=710.05n

.meas tran vdout0_27ck700 FIND v(dout0_27) AT=710.05n

.meas tran vdout0_28ck700 FIND v(dout0_28) AT=710.05n

.meas tran vdout0_29ck700 FIND v(dout0_29) AT=710.05n

.meas tran vdout0_30ck700 FIND v(dout0_30) AT=710.05n

.meas tran vdout0_31ck700 FIND v(dout0_31) AT=710.05n

.meas tran vdout0_32ck700 FIND v(dout0_32) AT=710.05n

.meas tran vdout0_0ck730 FIND v(dout0_0) AT=740.05n

.meas tran vdout0_1ck730 FIND v(dout0_1) AT=740.05n

.meas tran vdout0_2ck730 FIND v(dout0_2) AT=740.05n

.meas tran vdout0_3ck730 FIND v(dout0_3) AT=740.05n

.meas tran vdout0_4ck730 FIND v(dout0_4) AT=740.05n

.meas tran vdout0_5ck730 FIND v(dout0_5) AT=740.05n

.meas tran vdout0_6ck730 FIND v(dout0_6) AT=740.05n

.meas tran vdout0_7ck730 FIND v(dout0_7) AT=740.05n

.meas tran vdout0_8ck730 FIND v(dout0_8) AT=740.05n

.meas tran vdout0_9ck730 FIND v(dout0_9) AT=740.05n

.meas tran vdout0_10ck730 FIND v(dout0_10) AT=740.05n

.meas tran vdout0_11ck730 FIND v(dout0_11) AT=740.05n

.meas tran vdout0_12ck730 FIND v(dout0_12) AT=740.05n

.meas tran vdout0_13ck730 FIND v(dout0_13) AT=740.05n

.meas tran vdout0_14ck730 FIND v(dout0_14) AT=740.05n

.meas tran vdout0_15ck730 FIND v(dout0_15) AT=740.05n

.meas tran vdout0_16ck730 FIND v(dout0_16) AT=740.05n

.meas tran vdout0_17ck730 FIND v(dout0_17) AT=740.05n

.meas tran vdout0_18ck730 FIND v(dout0_18) AT=740.05n

.meas tran vdout0_19ck730 FIND v(dout0_19) AT=740.05n

.meas tran vdout0_20ck730 FIND v(dout0_20) AT=740.05n

.meas tran vdout0_21ck730 FIND v(dout0_21) AT=740.05n

.meas tran vdout0_22ck730 FIND v(dout0_22) AT=740.05n

.meas tran vdout0_23ck730 FIND v(dout0_23) AT=740.05n

.meas tran vdout0_24ck730 FIND v(dout0_24) AT=740.05n

.meas tran vdout0_25ck730 FIND v(dout0_25) AT=740.05n

.meas tran vdout0_26ck730 FIND v(dout0_26) AT=740.05n

.meas tran vdout0_27ck730 FIND v(dout0_27) AT=740.05n

.meas tran vdout0_28ck730 FIND v(dout0_28) AT=740.05n

.meas tran vdout0_29ck730 FIND v(dout0_29) AT=740.05n

.meas tran vdout0_30ck730 FIND v(dout0_30) AT=740.05n

.meas tran vdout0_31ck730 FIND v(dout0_31) AT=740.05n

.meas tran vdout0_32ck730 FIND v(dout0_32) AT=740.05n

.meas tran vdout0_0ck750 FIND v(dout0_0) AT=760.05n

.meas tran vdout0_1ck750 FIND v(dout0_1) AT=760.05n

.meas tran vdout0_2ck750 FIND v(dout0_2) AT=760.05n

.meas tran vdout0_3ck750 FIND v(dout0_3) AT=760.05n

.meas tran vdout0_4ck750 FIND v(dout0_4) AT=760.05n

.meas tran vdout0_5ck750 FIND v(dout0_5) AT=760.05n

.meas tran vdout0_6ck750 FIND v(dout0_6) AT=760.05n

.meas tran vdout0_7ck750 FIND v(dout0_7) AT=760.05n

.meas tran vdout0_8ck750 FIND v(dout0_8) AT=760.05n

.meas tran vdout0_9ck750 FIND v(dout0_9) AT=760.05n

.meas tran vdout0_10ck750 FIND v(dout0_10) AT=760.05n

.meas tran vdout0_11ck750 FIND v(dout0_11) AT=760.05n

.meas tran vdout0_12ck750 FIND v(dout0_12) AT=760.05n

.meas tran vdout0_13ck750 FIND v(dout0_13) AT=760.05n

.meas tran vdout0_14ck750 FIND v(dout0_14) AT=760.05n

.meas tran vdout0_15ck750 FIND v(dout0_15) AT=760.05n

.meas tran vdout0_16ck750 FIND v(dout0_16) AT=760.05n

.meas tran vdout0_17ck750 FIND v(dout0_17) AT=760.05n

.meas tran vdout0_18ck750 FIND v(dout0_18) AT=760.05n

.meas tran vdout0_19ck750 FIND v(dout0_19) AT=760.05n

.meas tran vdout0_20ck750 FIND v(dout0_20) AT=760.05n

.meas tran vdout0_21ck750 FIND v(dout0_21) AT=760.05n

.meas tran vdout0_22ck750 FIND v(dout0_22) AT=760.05n

.meas tran vdout0_23ck750 FIND v(dout0_23) AT=760.05n

.meas tran vdout0_24ck750 FIND v(dout0_24) AT=760.05n

.meas tran vdout0_25ck750 FIND v(dout0_25) AT=760.05n

.meas tran vdout0_26ck750 FIND v(dout0_26) AT=760.05n

.meas tran vdout0_27ck750 FIND v(dout0_27) AT=760.05n

.meas tran vdout0_28ck750 FIND v(dout0_28) AT=760.05n

.meas tran vdout0_29ck750 FIND v(dout0_29) AT=760.05n

.meas tran vdout0_30ck750 FIND v(dout0_30) AT=760.05n

.meas tran vdout0_31ck750 FIND v(dout0_31) AT=760.05n

.meas tran vdout0_32ck750 FIND v(dout0_32) AT=760.05n

.meas tran vdout0_0ck800 FIND v(dout0_0) AT=810.05n

.meas tran vdout0_1ck800 FIND v(dout0_1) AT=810.05n

.meas tran vdout0_2ck800 FIND v(dout0_2) AT=810.05n

.meas tran vdout0_3ck800 FIND v(dout0_3) AT=810.05n

.meas tran vdout0_4ck800 FIND v(dout0_4) AT=810.05n

.meas tran vdout0_5ck800 FIND v(dout0_5) AT=810.05n

.meas tran vdout0_6ck800 FIND v(dout0_6) AT=810.05n

.meas tran vdout0_7ck800 FIND v(dout0_7) AT=810.05n

.meas tran vdout0_8ck800 FIND v(dout0_8) AT=810.05n

.meas tran vdout0_9ck800 FIND v(dout0_9) AT=810.05n

.meas tran vdout0_10ck800 FIND v(dout0_10) AT=810.05n

.meas tran vdout0_11ck800 FIND v(dout0_11) AT=810.05n

.meas tran vdout0_12ck800 FIND v(dout0_12) AT=810.05n

.meas tran vdout0_13ck800 FIND v(dout0_13) AT=810.05n

.meas tran vdout0_14ck800 FIND v(dout0_14) AT=810.05n

.meas tran vdout0_15ck800 FIND v(dout0_15) AT=810.05n

.meas tran vdout0_16ck800 FIND v(dout0_16) AT=810.05n

.meas tran vdout0_17ck800 FIND v(dout0_17) AT=810.05n

.meas tran vdout0_18ck800 FIND v(dout0_18) AT=810.05n

.meas tran vdout0_19ck800 FIND v(dout0_19) AT=810.05n

.meas tran vdout0_20ck800 FIND v(dout0_20) AT=810.05n

.meas tran vdout0_21ck800 FIND v(dout0_21) AT=810.05n

.meas tran vdout0_22ck800 FIND v(dout0_22) AT=810.05n

.meas tran vdout0_23ck800 FIND v(dout0_23) AT=810.05n

.meas tran vdout0_24ck800 FIND v(dout0_24) AT=810.05n

.meas tran vdout0_25ck800 FIND v(dout0_25) AT=810.05n

.meas tran vdout0_26ck800 FIND v(dout0_26) AT=810.05n

.meas tran vdout0_27ck800 FIND v(dout0_27) AT=810.05n

.meas tran vdout0_28ck800 FIND v(dout0_28) AT=810.05n

.meas tran vdout0_29ck800 FIND v(dout0_29) AT=810.05n

.meas tran vdout0_30ck800 FIND v(dout0_30) AT=810.05n

.meas tran vdout0_31ck800 FIND v(dout0_31) AT=810.05n

.meas tran vdout0_32ck800 FIND v(dout0_32) AT=810.05n

.meas tran vdout0_0ck850 FIND v(dout0_0) AT=860.05n

.meas tran vdout0_1ck850 FIND v(dout0_1) AT=860.05n

.meas tran vdout0_2ck850 FIND v(dout0_2) AT=860.05n

.meas tran vdout0_3ck850 FIND v(dout0_3) AT=860.05n

.meas tran vdout0_4ck850 FIND v(dout0_4) AT=860.05n

.meas tran vdout0_5ck850 FIND v(dout0_5) AT=860.05n

.meas tran vdout0_6ck850 FIND v(dout0_6) AT=860.05n

.meas tran vdout0_7ck850 FIND v(dout0_7) AT=860.05n

.meas tran vdout0_8ck850 FIND v(dout0_8) AT=860.05n

.meas tran vdout0_9ck850 FIND v(dout0_9) AT=860.05n

.meas tran vdout0_10ck850 FIND v(dout0_10) AT=860.05n

.meas tran vdout0_11ck850 FIND v(dout0_11) AT=860.05n

.meas tran vdout0_12ck850 FIND v(dout0_12) AT=860.05n

.meas tran vdout0_13ck850 FIND v(dout0_13) AT=860.05n

.meas tran vdout0_14ck850 FIND v(dout0_14) AT=860.05n

.meas tran vdout0_15ck850 FIND v(dout0_15) AT=860.05n

.meas tran vdout0_16ck850 FIND v(dout0_16) AT=860.05n

.meas tran vdout0_17ck850 FIND v(dout0_17) AT=860.05n

.meas tran vdout0_18ck850 FIND v(dout0_18) AT=860.05n

.meas tran vdout0_19ck850 FIND v(dout0_19) AT=860.05n

.meas tran vdout0_20ck850 FIND v(dout0_20) AT=860.05n

.meas tran vdout0_21ck850 FIND v(dout0_21) AT=860.05n

.meas tran vdout0_22ck850 FIND v(dout0_22) AT=860.05n

.meas tran vdout0_23ck850 FIND v(dout0_23) AT=860.05n

.meas tran vdout0_24ck850 FIND v(dout0_24) AT=860.05n

.meas tran vdout0_25ck850 FIND v(dout0_25) AT=860.05n

.meas tran vdout0_26ck850 FIND v(dout0_26) AT=860.05n

.meas tran vdout0_27ck850 FIND v(dout0_27) AT=860.05n

.meas tran vdout0_28ck850 FIND v(dout0_28) AT=860.05n

.meas tran vdout0_29ck850 FIND v(dout0_29) AT=860.05n

.meas tran vdout0_30ck850 FIND v(dout0_30) AT=860.05n

.meas tran vdout0_31ck850 FIND v(dout0_31) AT=860.05n

.meas tran vdout0_32ck850 FIND v(dout0_32) AT=860.05n

.meas tran vdout0_0ck880 FIND v(dout0_0) AT=890.05n

.meas tran vdout0_1ck880 FIND v(dout0_1) AT=890.05n

.meas tran vdout0_2ck880 FIND v(dout0_2) AT=890.05n

.meas tran vdout0_3ck880 FIND v(dout0_3) AT=890.05n

.meas tran vdout0_4ck880 FIND v(dout0_4) AT=890.05n

.meas tran vdout0_5ck880 FIND v(dout0_5) AT=890.05n

.meas tran vdout0_6ck880 FIND v(dout0_6) AT=890.05n

.meas tran vdout0_7ck880 FIND v(dout0_7) AT=890.05n

.meas tran vdout0_8ck880 FIND v(dout0_8) AT=890.05n

.meas tran vdout0_9ck880 FIND v(dout0_9) AT=890.05n

.meas tran vdout0_10ck880 FIND v(dout0_10) AT=890.05n

.meas tran vdout0_11ck880 FIND v(dout0_11) AT=890.05n

.meas tran vdout0_12ck880 FIND v(dout0_12) AT=890.05n

.meas tran vdout0_13ck880 FIND v(dout0_13) AT=890.05n

.meas tran vdout0_14ck880 FIND v(dout0_14) AT=890.05n

.meas tran vdout0_15ck880 FIND v(dout0_15) AT=890.05n

.meas tran vdout0_16ck880 FIND v(dout0_16) AT=890.05n

.meas tran vdout0_17ck880 FIND v(dout0_17) AT=890.05n

.meas tran vdout0_18ck880 FIND v(dout0_18) AT=890.05n

.meas tran vdout0_19ck880 FIND v(dout0_19) AT=890.05n

.meas tran vdout0_20ck880 FIND v(dout0_20) AT=890.05n

.meas tran vdout0_21ck880 FIND v(dout0_21) AT=890.05n

.meas tran vdout0_22ck880 FIND v(dout0_22) AT=890.05n

.meas tran vdout0_23ck880 FIND v(dout0_23) AT=890.05n

.meas tran vdout0_24ck880 FIND v(dout0_24) AT=890.05n

.meas tran vdout0_25ck880 FIND v(dout0_25) AT=890.05n

.meas tran vdout0_26ck880 FIND v(dout0_26) AT=890.05n

.meas tran vdout0_27ck880 FIND v(dout0_27) AT=890.05n

.meas tran vdout0_28ck880 FIND v(dout0_28) AT=890.05n

.meas tran vdout0_29ck880 FIND v(dout0_29) AT=890.05n

.meas tran vdout0_30ck880 FIND v(dout0_30) AT=890.05n

.meas tran vdout0_31ck880 FIND v(dout0_31) AT=890.05n

.meas tran vdout0_32ck880 FIND v(dout0_32) AT=890.05n

.meas tran vdout0_0ck890 FIND v(dout0_0) AT=900.05n

.meas tran vdout0_1ck890 FIND v(dout0_1) AT=900.05n

.meas tran vdout0_2ck890 FIND v(dout0_2) AT=900.05n

.meas tran vdout0_3ck890 FIND v(dout0_3) AT=900.05n

.meas tran vdout0_4ck890 FIND v(dout0_4) AT=900.05n

.meas tran vdout0_5ck890 FIND v(dout0_5) AT=900.05n

.meas tran vdout0_6ck890 FIND v(dout0_6) AT=900.05n

.meas tran vdout0_7ck890 FIND v(dout0_7) AT=900.05n

.meas tran vdout0_8ck890 FIND v(dout0_8) AT=900.05n

.meas tran vdout0_9ck890 FIND v(dout0_9) AT=900.05n

.meas tran vdout0_10ck890 FIND v(dout0_10) AT=900.05n

.meas tran vdout0_11ck890 FIND v(dout0_11) AT=900.05n

.meas tran vdout0_12ck890 FIND v(dout0_12) AT=900.05n

.meas tran vdout0_13ck890 FIND v(dout0_13) AT=900.05n

.meas tran vdout0_14ck890 FIND v(dout0_14) AT=900.05n

.meas tran vdout0_15ck890 FIND v(dout0_15) AT=900.05n

.meas tran vdout0_16ck890 FIND v(dout0_16) AT=900.05n

.meas tran vdout0_17ck890 FIND v(dout0_17) AT=900.05n

.meas tran vdout0_18ck890 FIND v(dout0_18) AT=900.05n

.meas tran vdout0_19ck890 FIND v(dout0_19) AT=900.05n

.meas tran vdout0_20ck890 FIND v(dout0_20) AT=900.05n

.meas tran vdout0_21ck890 FIND v(dout0_21) AT=900.05n

.meas tran vdout0_22ck890 FIND v(dout0_22) AT=900.05n

.meas tran vdout0_23ck890 FIND v(dout0_23) AT=900.05n

.meas tran vdout0_24ck890 FIND v(dout0_24) AT=900.05n

.meas tran vdout0_25ck890 FIND v(dout0_25) AT=900.05n

.meas tran vdout0_26ck890 FIND v(dout0_26) AT=900.05n

.meas tran vdout0_27ck890 FIND v(dout0_27) AT=900.05n

.meas tran vdout0_28ck890 FIND v(dout0_28) AT=900.05n

.meas tran vdout0_29ck890 FIND v(dout0_29) AT=900.05n

.meas tran vdout0_30ck890 FIND v(dout0_30) AT=900.05n

.meas tran vdout0_31ck890 FIND v(dout0_31) AT=900.05n

.meas tran vdout0_32ck890 FIND v(dout0_32) AT=900.05n

.meas tran vdout0_0ck910 FIND v(dout0_0) AT=920.05n

.meas tran vdout0_1ck910 FIND v(dout0_1) AT=920.05n

.meas tran vdout0_2ck910 FIND v(dout0_2) AT=920.05n

.meas tran vdout0_3ck910 FIND v(dout0_3) AT=920.05n

.meas tran vdout0_4ck910 FIND v(dout0_4) AT=920.05n

.meas tran vdout0_5ck910 FIND v(dout0_5) AT=920.05n

.meas tran vdout0_6ck910 FIND v(dout0_6) AT=920.05n

.meas tran vdout0_7ck910 FIND v(dout0_7) AT=920.05n

.meas tran vdout0_8ck910 FIND v(dout0_8) AT=920.05n

.meas tran vdout0_9ck910 FIND v(dout0_9) AT=920.05n

.meas tran vdout0_10ck910 FIND v(dout0_10) AT=920.05n

.meas tran vdout0_11ck910 FIND v(dout0_11) AT=920.05n

.meas tran vdout0_12ck910 FIND v(dout0_12) AT=920.05n

.meas tran vdout0_13ck910 FIND v(dout0_13) AT=920.05n

.meas tran vdout0_14ck910 FIND v(dout0_14) AT=920.05n

.meas tran vdout0_15ck910 FIND v(dout0_15) AT=920.05n

.meas tran vdout0_16ck910 FIND v(dout0_16) AT=920.05n

.meas tran vdout0_17ck910 FIND v(dout0_17) AT=920.05n

.meas tran vdout0_18ck910 FIND v(dout0_18) AT=920.05n

.meas tran vdout0_19ck910 FIND v(dout0_19) AT=920.05n

.meas tran vdout0_20ck910 FIND v(dout0_20) AT=920.05n

.meas tran vdout0_21ck910 FIND v(dout0_21) AT=920.05n

.meas tran vdout0_22ck910 FIND v(dout0_22) AT=920.05n

.meas tran vdout0_23ck910 FIND v(dout0_23) AT=920.05n

.meas tran vdout0_24ck910 FIND v(dout0_24) AT=920.05n

.meas tran vdout0_25ck910 FIND v(dout0_25) AT=920.05n

.meas tran vdout0_26ck910 FIND v(dout0_26) AT=920.05n

.meas tran vdout0_27ck910 FIND v(dout0_27) AT=920.05n

.meas tran vdout0_28ck910 FIND v(dout0_28) AT=920.05n

.meas tran vdout0_29ck910 FIND v(dout0_29) AT=920.05n

.meas tran vdout0_30ck910 FIND v(dout0_30) AT=920.05n

.meas tran vdout0_31ck910 FIND v(dout0_31) AT=920.05n

.meas tran vdout0_32ck910 FIND v(dout0_32) AT=920.05n

.meas tran vdout0_0ck920 FIND v(dout0_0) AT=930.05n

.meas tran vdout0_1ck920 FIND v(dout0_1) AT=930.05n

.meas tran vdout0_2ck920 FIND v(dout0_2) AT=930.05n

.meas tran vdout0_3ck920 FIND v(dout0_3) AT=930.05n

.meas tran vdout0_4ck920 FIND v(dout0_4) AT=930.05n

.meas tran vdout0_5ck920 FIND v(dout0_5) AT=930.05n

.meas tran vdout0_6ck920 FIND v(dout0_6) AT=930.05n

.meas tran vdout0_7ck920 FIND v(dout0_7) AT=930.05n

.meas tran vdout0_8ck920 FIND v(dout0_8) AT=930.05n

.meas tran vdout0_9ck920 FIND v(dout0_9) AT=930.05n

.meas tran vdout0_10ck920 FIND v(dout0_10) AT=930.05n

.meas tran vdout0_11ck920 FIND v(dout0_11) AT=930.05n

.meas tran vdout0_12ck920 FIND v(dout0_12) AT=930.05n

.meas tran vdout0_13ck920 FIND v(dout0_13) AT=930.05n

.meas tran vdout0_14ck920 FIND v(dout0_14) AT=930.05n

.meas tran vdout0_15ck920 FIND v(dout0_15) AT=930.05n

.meas tran vdout0_16ck920 FIND v(dout0_16) AT=930.05n

.meas tran vdout0_17ck920 FIND v(dout0_17) AT=930.05n

.meas tran vdout0_18ck920 FIND v(dout0_18) AT=930.05n

.meas tran vdout0_19ck920 FIND v(dout0_19) AT=930.05n

.meas tran vdout0_20ck920 FIND v(dout0_20) AT=930.05n

.meas tran vdout0_21ck920 FIND v(dout0_21) AT=930.05n

.meas tran vdout0_22ck920 FIND v(dout0_22) AT=930.05n

.meas tran vdout0_23ck920 FIND v(dout0_23) AT=930.05n

.meas tran vdout0_24ck920 FIND v(dout0_24) AT=930.05n

.meas tran vdout0_25ck920 FIND v(dout0_25) AT=930.05n

.meas tran vdout0_26ck920 FIND v(dout0_26) AT=930.05n

.meas tran vdout0_27ck920 FIND v(dout0_27) AT=930.05n

.meas tran vdout0_28ck920 FIND v(dout0_28) AT=930.05n

.meas tran vdout0_29ck920 FIND v(dout0_29) AT=930.05n

.meas tran vdout0_30ck920 FIND v(dout0_30) AT=930.05n

.meas tran vdout0_31ck920 FIND v(dout0_31) AT=930.05n

.meas tran vdout0_32ck920 FIND v(dout0_32) AT=930.05n

.meas tran vdout0_0ck940 FIND v(dout0_0) AT=950.05n

.meas tran vdout0_1ck940 FIND v(dout0_1) AT=950.05n

.meas tran vdout0_2ck940 FIND v(dout0_2) AT=950.05n

.meas tran vdout0_3ck940 FIND v(dout0_3) AT=950.05n

.meas tran vdout0_4ck940 FIND v(dout0_4) AT=950.05n

.meas tran vdout0_5ck940 FIND v(dout0_5) AT=950.05n

.meas tran vdout0_6ck940 FIND v(dout0_6) AT=950.05n

.meas tran vdout0_7ck940 FIND v(dout0_7) AT=950.05n

.meas tran vdout0_8ck940 FIND v(dout0_8) AT=950.05n

.meas tran vdout0_9ck940 FIND v(dout0_9) AT=950.05n

.meas tran vdout0_10ck940 FIND v(dout0_10) AT=950.05n

.meas tran vdout0_11ck940 FIND v(dout0_11) AT=950.05n

.meas tran vdout0_12ck940 FIND v(dout0_12) AT=950.05n

.meas tran vdout0_13ck940 FIND v(dout0_13) AT=950.05n

.meas tran vdout0_14ck940 FIND v(dout0_14) AT=950.05n

.meas tran vdout0_15ck940 FIND v(dout0_15) AT=950.05n

.meas tran vdout0_16ck940 FIND v(dout0_16) AT=950.05n

.meas tran vdout0_17ck940 FIND v(dout0_17) AT=950.05n

.meas tran vdout0_18ck940 FIND v(dout0_18) AT=950.05n

.meas tran vdout0_19ck940 FIND v(dout0_19) AT=950.05n

.meas tran vdout0_20ck940 FIND v(dout0_20) AT=950.05n

.meas tran vdout0_21ck940 FIND v(dout0_21) AT=950.05n

.meas tran vdout0_22ck940 FIND v(dout0_22) AT=950.05n

.meas tran vdout0_23ck940 FIND v(dout0_23) AT=950.05n

.meas tran vdout0_24ck940 FIND v(dout0_24) AT=950.05n

.meas tran vdout0_25ck940 FIND v(dout0_25) AT=950.05n

.meas tran vdout0_26ck940 FIND v(dout0_26) AT=950.05n

.meas tran vdout0_27ck940 FIND v(dout0_27) AT=950.05n

.meas tran vdout0_28ck940 FIND v(dout0_28) AT=950.05n

.meas tran vdout0_29ck940 FIND v(dout0_29) AT=950.05n

.meas tran vdout0_30ck940 FIND v(dout0_30) AT=950.05n

.meas tran vdout0_31ck940 FIND v(dout0_31) AT=950.05n

.meas tran vdout0_32ck940 FIND v(dout0_32) AT=950.05n

.meas tran vdout0_0ck960 FIND v(dout0_0) AT=970.05n

.meas tran vdout0_1ck960 FIND v(dout0_1) AT=970.05n

.meas tran vdout0_2ck960 FIND v(dout0_2) AT=970.05n

.meas tran vdout0_3ck960 FIND v(dout0_3) AT=970.05n

.meas tran vdout0_4ck960 FIND v(dout0_4) AT=970.05n

.meas tran vdout0_5ck960 FIND v(dout0_5) AT=970.05n

.meas tran vdout0_6ck960 FIND v(dout0_6) AT=970.05n

.meas tran vdout0_7ck960 FIND v(dout0_7) AT=970.05n

.meas tran vdout0_8ck960 FIND v(dout0_8) AT=970.05n

.meas tran vdout0_9ck960 FIND v(dout0_9) AT=970.05n

.meas tran vdout0_10ck960 FIND v(dout0_10) AT=970.05n

.meas tran vdout0_11ck960 FIND v(dout0_11) AT=970.05n

.meas tran vdout0_12ck960 FIND v(dout0_12) AT=970.05n

.meas tran vdout0_13ck960 FIND v(dout0_13) AT=970.05n

.meas tran vdout0_14ck960 FIND v(dout0_14) AT=970.05n

.meas tran vdout0_15ck960 FIND v(dout0_15) AT=970.05n

.meas tran vdout0_16ck960 FIND v(dout0_16) AT=970.05n

.meas tran vdout0_17ck960 FIND v(dout0_17) AT=970.05n

.meas tran vdout0_18ck960 FIND v(dout0_18) AT=970.05n

.meas tran vdout0_19ck960 FIND v(dout0_19) AT=970.05n

.meas tran vdout0_20ck960 FIND v(dout0_20) AT=970.05n

.meas tran vdout0_21ck960 FIND v(dout0_21) AT=970.05n

.meas tran vdout0_22ck960 FIND v(dout0_22) AT=970.05n

.meas tran vdout0_23ck960 FIND v(dout0_23) AT=970.05n

.meas tran vdout0_24ck960 FIND v(dout0_24) AT=970.05n

.meas tran vdout0_25ck960 FIND v(dout0_25) AT=970.05n

.meas tran vdout0_26ck960 FIND v(dout0_26) AT=970.05n

.meas tran vdout0_27ck960 FIND v(dout0_27) AT=970.05n

.meas tran vdout0_28ck960 FIND v(dout0_28) AT=970.05n

.meas tran vdout0_29ck960 FIND v(dout0_29) AT=970.05n

.meas tran vdout0_30ck960 FIND v(dout0_30) AT=970.05n

.meas tran vdout0_31ck960 FIND v(dout0_31) AT=970.05n

.meas tran vdout0_32ck960 FIND v(dout0_32) AT=970.05n

.meas tran vdout0_0ck990 FIND v(dout0_0) AT=1000.05n

.meas tran vdout0_1ck990 FIND v(dout0_1) AT=1000.05n

.meas tran vdout0_2ck990 FIND v(dout0_2) AT=1000.05n

.meas tran vdout0_3ck990 FIND v(dout0_3) AT=1000.05n

.meas tran vdout0_4ck990 FIND v(dout0_4) AT=1000.05n

.meas tran vdout0_5ck990 FIND v(dout0_5) AT=1000.05n

.meas tran vdout0_6ck990 FIND v(dout0_6) AT=1000.05n

.meas tran vdout0_7ck990 FIND v(dout0_7) AT=1000.05n

.meas tran vdout0_8ck990 FIND v(dout0_8) AT=1000.05n

.meas tran vdout0_9ck990 FIND v(dout0_9) AT=1000.05n

.meas tran vdout0_10ck990 FIND v(dout0_10) AT=1000.05n

.meas tran vdout0_11ck990 FIND v(dout0_11) AT=1000.05n

.meas tran vdout0_12ck990 FIND v(dout0_12) AT=1000.05n

.meas tran vdout0_13ck990 FIND v(dout0_13) AT=1000.05n

.meas tran vdout0_14ck990 FIND v(dout0_14) AT=1000.05n

.meas tran vdout0_15ck990 FIND v(dout0_15) AT=1000.05n

.meas tran vdout0_16ck990 FIND v(dout0_16) AT=1000.05n

.meas tran vdout0_17ck990 FIND v(dout0_17) AT=1000.05n

.meas tran vdout0_18ck990 FIND v(dout0_18) AT=1000.05n

.meas tran vdout0_19ck990 FIND v(dout0_19) AT=1000.05n

.meas tran vdout0_20ck990 FIND v(dout0_20) AT=1000.05n

.meas tran vdout0_21ck990 FIND v(dout0_21) AT=1000.05n

.meas tran vdout0_22ck990 FIND v(dout0_22) AT=1000.05n

.meas tran vdout0_23ck990 FIND v(dout0_23) AT=1000.05n

.meas tran vdout0_24ck990 FIND v(dout0_24) AT=1000.05n

.meas tran vdout0_25ck990 FIND v(dout0_25) AT=1000.05n

.meas tran vdout0_26ck990 FIND v(dout0_26) AT=1000.05n

.meas tran vdout0_27ck990 FIND v(dout0_27) AT=1000.05n

.meas tran vdout0_28ck990 FIND v(dout0_28) AT=1000.05n

.meas tran vdout0_29ck990 FIND v(dout0_29) AT=1000.05n

.meas tran vdout0_30ck990 FIND v(dout0_30) AT=1000.05n

.meas tran vdout0_31ck990 FIND v(dout0_31) AT=1000.05n

.meas tran vdout0_32ck990 FIND v(dout0_32) AT=1000.05n

.meas tran vdout0_0ck1000 FIND v(dout0_0) AT=1010.05n

.meas tran vdout0_1ck1000 FIND v(dout0_1) AT=1010.05n

.meas tran vdout0_2ck1000 FIND v(dout0_2) AT=1010.05n

.meas tran vdout0_3ck1000 FIND v(dout0_3) AT=1010.05n

.meas tran vdout0_4ck1000 FIND v(dout0_4) AT=1010.05n

.meas tran vdout0_5ck1000 FIND v(dout0_5) AT=1010.05n

.meas tran vdout0_6ck1000 FIND v(dout0_6) AT=1010.05n

.meas tran vdout0_7ck1000 FIND v(dout0_7) AT=1010.05n

.meas tran vdout0_8ck1000 FIND v(dout0_8) AT=1010.05n

.meas tran vdout0_9ck1000 FIND v(dout0_9) AT=1010.05n

.meas tran vdout0_10ck1000 FIND v(dout0_10) AT=1010.05n

.meas tran vdout0_11ck1000 FIND v(dout0_11) AT=1010.05n

.meas tran vdout0_12ck1000 FIND v(dout0_12) AT=1010.05n

.meas tran vdout0_13ck1000 FIND v(dout0_13) AT=1010.05n

.meas tran vdout0_14ck1000 FIND v(dout0_14) AT=1010.05n

.meas tran vdout0_15ck1000 FIND v(dout0_15) AT=1010.05n

.meas tran vdout0_16ck1000 FIND v(dout0_16) AT=1010.05n

.meas tran vdout0_17ck1000 FIND v(dout0_17) AT=1010.05n

.meas tran vdout0_18ck1000 FIND v(dout0_18) AT=1010.05n

.meas tran vdout0_19ck1000 FIND v(dout0_19) AT=1010.05n

.meas tran vdout0_20ck1000 FIND v(dout0_20) AT=1010.05n

.meas tran vdout0_21ck1000 FIND v(dout0_21) AT=1010.05n

.meas tran vdout0_22ck1000 FIND v(dout0_22) AT=1010.05n

.meas tran vdout0_23ck1000 FIND v(dout0_23) AT=1010.05n

.meas tran vdout0_24ck1000 FIND v(dout0_24) AT=1010.05n

.meas tran vdout0_25ck1000 FIND v(dout0_25) AT=1010.05n

.meas tran vdout0_26ck1000 FIND v(dout0_26) AT=1010.05n

.meas tran vdout0_27ck1000 FIND v(dout0_27) AT=1010.05n

.meas tran vdout0_28ck1000 FIND v(dout0_28) AT=1010.05n

.meas tran vdout0_29ck1000 FIND v(dout0_29) AT=1010.05n

.meas tran vdout0_30ck1000 FIND v(dout0_30) AT=1010.05n

.meas tran vdout0_31ck1000 FIND v(dout0_31) AT=1010.05n

.meas tran vdout0_32ck1000 FIND v(dout0_32) AT=1010.05n

.meas tran vdout0_0ck1010 FIND v(dout0_0) AT=1020.05n

.meas tran vdout0_1ck1010 FIND v(dout0_1) AT=1020.05n

.meas tran vdout0_2ck1010 FIND v(dout0_2) AT=1020.05n

.meas tran vdout0_3ck1010 FIND v(dout0_3) AT=1020.05n

.meas tran vdout0_4ck1010 FIND v(dout0_4) AT=1020.05n

.meas tran vdout0_5ck1010 FIND v(dout0_5) AT=1020.05n

.meas tran vdout0_6ck1010 FIND v(dout0_6) AT=1020.05n

.meas tran vdout0_7ck1010 FIND v(dout0_7) AT=1020.05n

.meas tran vdout0_8ck1010 FIND v(dout0_8) AT=1020.05n

.meas tran vdout0_9ck1010 FIND v(dout0_9) AT=1020.05n

.meas tran vdout0_10ck1010 FIND v(dout0_10) AT=1020.05n

.meas tran vdout0_11ck1010 FIND v(dout0_11) AT=1020.05n

.meas tran vdout0_12ck1010 FIND v(dout0_12) AT=1020.05n

.meas tran vdout0_13ck1010 FIND v(dout0_13) AT=1020.05n

.meas tran vdout0_14ck1010 FIND v(dout0_14) AT=1020.05n

.meas tran vdout0_15ck1010 FIND v(dout0_15) AT=1020.05n

.meas tran vdout0_16ck1010 FIND v(dout0_16) AT=1020.05n

.meas tran vdout0_17ck1010 FIND v(dout0_17) AT=1020.05n

.meas tran vdout0_18ck1010 FIND v(dout0_18) AT=1020.05n

.meas tran vdout0_19ck1010 FIND v(dout0_19) AT=1020.05n

.meas tran vdout0_20ck1010 FIND v(dout0_20) AT=1020.05n

.meas tran vdout0_21ck1010 FIND v(dout0_21) AT=1020.05n

.meas tran vdout0_22ck1010 FIND v(dout0_22) AT=1020.05n

.meas tran vdout0_23ck1010 FIND v(dout0_23) AT=1020.05n

.meas tran vdout0_24ck1010 FIND v(dout0_24) AT=1020.05n

.meas tran vdout0_25ck1010 FIND v(dout0_25) AT=1020.05n

.meas tran vdout0_26ck1010 FIND v(dout0_26) AT=1020.05n

.meas tran vdout0_27ck1010 FIND v(dout0_27) AT=1020.05n

.meas tran vdout0_28ck1010 FIND v(dout0_28) AT=1020.05n

.meas tran vdout0_29ck1010 FIND v(dout0_29) AT=1020.05n

.meas tran vdout0_30ck1010 FIND v(dout0_30) AT=1020.05n

.meas tran vdout0_31ck1010 FIND v(dout0_31) AT=1020.05n

.meas tran vdout0_32ck1010 FIND v(dout0_32) AT=1020.05n

.meas tran vdout0_0ck1050 FIND v(dout0_0) AT=1060.05n

.meas tran vdout0_1ck1050 FIND v(dout0_1) AT=1060.05n

.meas tran vdout0_2ck1050 FIND v(dout0_2) AT=1060.05n

.meas tran vdout0_3ck1050 FIND v(dout0_3) AT=1060.05n

.meas tran vdout0_4ck1050 FIND v(dout0_4) AT=1060.05n

.meas tran vdout0_5ck1050 FIND v(dout0_5) AT=1060.05n

.meas tran vdout0_6ck1050 FIND v(dout0_6) AT=1060.05n

.meas tran vdout0_7ck1050 FIND v(dout0_7) AT=1060.05n

.meas tran vdout0_8ck1050 FIND v(dout0_8) AT=1060.05n

.meas tran vdout0_9ck1050 FIND v(dout0_9) AT=1060.05n

.meas tran vdout0_10ck1050 FIND v(dout0_10) AT=1060.05n

.meas tran vdout0_11ck1050 FIND v(dout0_11) AT=1060.05n

.meas tran vdout0_12ck1050 FIND v(dout0_12) AT=1060.05n

.meas tran vdout0_13ck1050 FIND v(dout0_13) AT=1060.05n

.meas tran vdout0_14ck1050 FIND v(dout0_14) AT=1060.05n

.meas tran vdout0_15ck1050 FIND v(dout0_15) AT=1060.05n

.meas tran vdout0_16ck1050 FIND v(dout0_16) AT=1060.05n

.meas tran vdout0_17ck1050 FIND v(dout0_17) AT=1060.05n

.meas tran vdout0_18ck1050 FIND v(dout0_18) AT=1060.05n

.meas tran vdout0_19ck1050 FIND v(dout0_19) AT=1060.05n

.meas tran vdout0_20ck1050 FIND v(dout0_20) AT=1060.05n

.meas tran vdout0_21ck1050 FIND v(dout0_21) AT=1060.05n

.meas tran vdout0_22ck1050 FIND v(dout0_22) AT=1060.05n

.meas tran vdout0_23ck1050 FIND v(dout0_23) AT=1060.05n

.meas tran vdout0_24ck1050 FIND v(dout0_24) AT=1060.05n

.meas tran vdout0_25ck1050 FIND v(dout0_25) AT=1060.05n

.meas tran vdout0_26ck1050 FIND v(dout0_26) AT=1060.05n

.meas tran vdout0_27ck1050 FIND v(dout0_27) AT=1060.05n

.meas tran vdout0_28ck1050 FIND v(dout0_28) AT=1060.05n

.meas tran vdout0_29ck1050 FIND v(dout0_29) AT=1060.05n

.meas tran vdout0_30ck1050 FIND v(dout0_30) AT=1060.05n

.meas tran vdout0_31ck1050 FIND v(dout0_31) AT=1060.05n

.meas tran vdout0_32ck1050 FIND v(dout0_32) AT=1060.05n

.meas tran vdout0_0ck1080 FIND v(dout0_0) AT=1090.05n

.meas tran vdout0_1ck1080 FIND v(dout0_1) AT=1090.05n

.meas tran vdout0_2ck1080 FIND v(dout0_2) AT=1090.05n

.meas tran vdout0_3ck1080 FIND v(dout0_3) AT=1090.05n

.meas tran vdout0_4ck1080 FIND v(dout0_4) AT=1090.05n

.meas tran vdout0_5ck1080 FIND v(dout0_5) AT=1090.05n

.meas tran vdout0_6ck1080 FIND v(dout0_6) AT=1090.05n

.meas tran vdout0_7ck1080 FIND v(dout0_7) AT=1090.05n

.meas tran vdout0_8ck1080 FIND v(dout0_8) AT=1090.05n

.meas tran vdout0_9ck1080 FIND v(dout0_9) AT=1090.05n

.meas tran vdout0_10ck1080 FIND v(dout0_10) AT=1090.05n

.meas tran vdout0_11ck1080 FIND v(dout0_11) AT=1090.05n

.meas tran vdout0_12ck1080 FIND v(dout0_12) AT=1090.05n

.meas tran vdout0_13ck1080 FIND v(dout0_13) AT=1090.05n

.meas tran vdout0_14ck1080 FIND v(dout0_14) AT=1090.05n

.meas tran vdout0_15ck1080 FIND v(dout0_15) AT=1090.05n

.meas tran vdout0_16ck1080 FIND v(dout0_16) AT=1090.05n

.meas tran vdout0_17ck1080 FIND v(dout0_17) AT=1090.05n

.meas tran vdout0_18ck1080 FIND v(dout0_18) AT=1090.05n

.meas tran vdout0_19ck1080 FIND v(dout0_19) AT=1090.05n

.meas tran vdout0_20ck1080 FIND v(dout0_20) AT=1090.05n

.meas tran vdout0_21ck1080 FIND v(dout0_21) AT=1090.05n

.meas tran vdout0_22ck1080 FIND v(dout0_22) AT=1090.05n

.meas tran vdout0_23ck1080 FIND v(dout0_23) AT=1090.05n

.meas tran vdout0_24ck1080 FIND v(dout0_24) AT=1090.05n

.meas tran vdout0_25ck1080 FIND v(dout0_25) AT=1090.05n

.meas tran vdout0_26ck1080 FIND v(dout0_26) AT=1090.05n

.meas tran vdout0_27ck1080 FIND v(dout0_27) AT=1090.05n

.meas tran vdout0_28ck1080 FIND v(dout0_28) AT=1090.05n

.meas tran vdout0_29ck1080 FIND v(dout0_29) AT=1090.05n

.meas tran vdout0_30ck1080 FIND v(dout0_30) AT=1090.05n

.meas tran vdout0_31ck1080 FIND v(dout0_31) AT=1090.05n

.meas tran vdout0_32ck1080 FIND v(dout0_32) AT=1090.05n

.meas tran vdout0_0ck1120 FIND v(dout0_0) AT=1130.05n

.meas tran vdout0_1ck1120 FIND v(dout0_1) AT=1130.05n

.meas tran vdout0_2ck1120 FIND v(dout0_2) AT=1130.05n

.meas tran vdout0_3ck1120 FIND v(dout0_3) AT=1130.05n

.meas tran vdout0_4ck1120 FIND v(dout0_4) AT=1130.05n

.meas tran vdout0_5ck1120 FIND v(dout0_5) AT=1130.05n

.meas tran vdout0_6ck1120 FIND v(dout0_6) AT=1130.05n

.meas tran vdout0_7ck1120 FIND v(dout0_7) AT=1130.05n

.meas tran vdout0_8ck1120 FIND v(dout0_8) AT=1130.05n

.meas tran vdout0_9ck1120 FIND v(dout0_9) AT=1130.05n

.meas tran vdout0_10ck1120 FIND v(dout0_10) AT=1130.05n

.meas tran vdout0_11ck1120 FIND v(dout0_11) AT=1130.05n

.meas tran vdout0_12ck1120 FIND v(dout0_12) AT=1130.05n

.meas tran vdout0_13ck1120 FIND v(dout0_13) AT=1130.05n

.meas tran vdout0_14ck1120 FIND v(dout0_14) AT=1130.05n

.meas tran vdout0_15ck1120 FIND v(dout0_15) AT=1130.05n

.meas tran vdout0_16ck1120 FIND v(dout0_16) AT=1130.05n

.meas tran vdout0_17ck1120 FIND v(dout0_17) AT=1130.05n

.meas tran vdout0_18ck1120 FIND v(dout0_18) AT=1130.05n

.meas tran vdout0_19ck1120 FIND v(dout0_19) AT=1130.05n

.meas tran vdout0_20ck1120 FIND v(dout0_20) AT=1130.05n

.meas tran vdout0_21ck1120 FIND v(dout0_21) AT=1130.05n

.meas tran vdout0_22ck1120 FIND v(dout0_22) AT=1130.05n

.meas tran vdout0_23ck1120 FIND v(dout0_23) AT=1130.05n

.meas tran vdout0_24ck1120 FIND v(dout0_24) AT=1130.05n

.meas tran vdout0_25ck1120 FIND v(dout0_25) AT=1130.05n

.meas tran vdout0_26ck1120 FIND v(dout0_26) AT=1130.05n

.meas tran vdout0_27ck1120 FIND v(dout0_27) AT=1130.05n

.meas tran vdout0_28ck1120 FIND v(dout0_28) AT=1130.05n

.meas tran vdout0_29ck1120 FIND v(dout0_29) AT=1130.05n

.meas tran vdout0_30ck1120 FIND v(dout0_30) AT=1130.05n

.meas tran vdout0_31ck1120 FIND v(dout0_31) AT=1130.05n

.meas tran vdout0_32ck1120 FIND v(dout0_32) AT=1130.05n

.meas tran vdout0_0ck1130 FIND v(dout0_0) AT=1140.05n

.meas tran vdout0_1ck1130 FIND v(dout0_1) AT=1140.05n

.meas tran vdout0_2ck1130 FIND v(dout0_2) AT=1140.05n

.meas tran vdout0_3ck1130 FIND v(dout0_3) AT=1140.05n

.meas tran vdout0_4ck1130 FIND v(dout0_4) AT=1140.05n

.meas tran vdout0_5ck1130 FIND v(dout0_5) AT=1140.05n

.meas tran vdout0_6ck1130 FIND v(dout0_6) AT=1140.05n

.meas tran vdout0_7ck1130 FIND v(dout0_7) AT=1140.05n

.meas tran vdout0_8ck1130 FIND v(dout0_8) AT=1140.05n

.meas tran vdout0_9ck1130 FIND v(dout0_9) AT=1140.05n

.meas tran vdout0_10ck1130 FIND v(dout0_10) AT=1140.05n

.meas tran vdout0_11ck1130 FIND v(dout0_11) AT=1140.05n

.meas tran vdout0_12ck1130 FIND v(dout0_12) AT=1140.05n

.meas tran vdout0_13ck1130 FIND v(dout0_13) AT=1140.05n

.meas tran vdout0_14ck1130 FIND v(dout0_14) AT=1140.05n

.meas tran vdout0_15ck1130 FIND v(dout0_15) AT=1140.05n

.meas tran vdout0_16ck1130 FIND v(dout0_16) AT=1140.05n

.meas tran vdout0_17ck1130 FIND v(dout0_17) AT=1140.05n

.meas tran vdout0_18ck1130 FIND v(dout0_18) AT=1140.05n

.meas tran vdout0_19ck1130 FIND v(dout0_19) AT=1140.05n

.meas tran vdout0_20ck1130 FIND v(dout0_20) AT=1140.05n

.meas tran vdout0_21ck1130 FIND v(dout0_21) AT=1140.05n

.meas tran vdout0_22ck1130 FIND v(dout0_22) AT=1140.05n

.meas tran vdout0_23ck1130 FIND v(dout0_23) AT=1140.05n

.meas tran vdout0_24ck1130 FIND v(dout0_24) AT=1140.05n

.meas tran vdout0_25ck1130 FIND v(dout0_25) AT=1140.05n

.meas tran vdout0_26ck1130 FIND v(dout0_26) AT=1140.05n

.meas tran vdout0_27ck1130 FIND v(dout0_27) AT=1140.05n

.meas tran vdout0_28ck1130 FIND v(dout0_28) AT=1140.05n

.meas tran vdout0_29ck1130 FIND v(dout0_29) AT=1140.05n

.meas tran vdout0_30ck1130 FIND v(dout0_30) AT=1140.05n

.meas tran vdout0_31ck1130 FIND v(dout0_31) AT=1140.05n

.meas tran vdout0_32ck1130 FIND v(dout0_32) AT=1140.05n

.meas tran vdout0_0ck1160 FIND v(dout0_0) AT=1170.05n

.meas tran vdout0_1ck1160 FIND v(dout0_1) AT=1170.05n

.meas tran vdout0_2ck1160 FIND v(dout0_2) AT=1170.05n

.meas tran vdout0_3ck1160 FIND v(dout0_3) AT=1170.05n

.meas tran vdout0_4ck1160 FIND v(dout0_4) AT=1170.05n

.meas tran vdout0_5ck1160 FIND v(dout0_5) AT=1170.05n

.meas tran vdout0_6ck1160 FIND v(dout0_6) AT=1170.05n

.meas tran vdout0_7ck1160 FIND v(dout0_7) AT=1170.05n

.meas tran vdout0_8ck1160 FIND v(dout0_8) AT=1170.05n

.meas tran vdout0_9ck1160 FIND v(dout0_9) AT=1170.05n

.meas tran vdout0_10ck1160 FIND v(dout0_10) AT=1170.05n

.meas tran vdout0_11ck1160 FIND v(dout0_11) AT=1170.05n

.meas tran vdout0_12ck1160 FIND v(dout0_12) AT=1170.05n

.meas tran vdout0_13ck1160 FIND v(dout0_13) AT=1170.05n

.meas tran vdout0_14ck1160 FIND v(dout0_14) AT=1170.05n

.meas tran vdout0_15ck1160 FIND v(dout0_15) AT=1170.05n

.meas tran vdout0_16ck1160 FIND v(dout0_16) AT=1170.05n

.meas tran vdout0_17ck1160 FIND v(dout0_17) AT=1170.05n

.meas tran vdout0_18ck1160 FIND v(dout0_18) AT=1170.05n

.meas tran vdout0_19ck1160 FIND v(dout0_19) AT=1170.05n

.meas tran vdout0_20ck1160 FIND v(dout0_20) AT=1170.05n

.meas tran vdout0_21ck1160 FIND v(dout0_21) AT=1170.05n

.meas tran vdout0_22ck1160 FIND v(dout0_22) AT=1170.05n

.meas tran vdout0_23ck1160 FIND v(dout0_23) AT=1170.05n

.meas tran vdout0_24ck1160 FIND v(dout0_24) AT=1170.05n

.meas tran vdout0_25ck1160 FIND v(dout0_25) AT=1170.05n

.meas tran vdout0_26ck1160 FIND v(dout0_26) AT=1170.05n

.meas tran vdout0_27ck1160 FIND v(dout0_27) AT=1170.05n

.meas tran vdout0_28ck1160 FIND v(dout0_28) AT=1170.05n

.meas tran vdout0_29ck1160 FIND v(dout0_29) AT=1170.05n

.meas tran vdout0_30ck1160 FIND v(dout0_30) AT=1170.05n

.meas tran vdout0_31ck1160 FIND v(dout0_31) AT=1170.05n

.meas tran vdout0_32ck1160 FIND v(dout0_32) AT=1170.05n

.meas tran vdout0_0ck1200 FIND v(dout0_0) AT=1210.05n

.meas tran vdout0_1ck1200 FIND v(dout0_1) AT=1210.05n

.meas tran vdout0_2ck1200 FIND v(dout0_2) AT=1210.05n

.meas tran vdout0_3ck1200 FIND v(dout0_3) AT=1210.05n

.meas tran vdout0_4ck1200 FIND v(dout0_4) AT=1210.05n

.meas tran vdout0_5ck1200 FIND v(dout0_5) AT=1210.05n

.meas tran vdout0_6ck1200 FIND v(dout0_6) AT=1210.05n

.meas tran vdout0_7ck1200 FIND v(dout0_7) AT=1210.05n

.meas tran vdout0_8ck1200 FIND v(dout0_8) AT=1210.05n

.meas tran vdout0_9ck1200 FIND v(dout0_9) AT=1210.05n

.meas tran vdout0_10ck1200 FIND v(dout0_10) AT=1210.05n

.meas tran vdout0_11ck1200 FIND v(dout0_11) AT=1210.05n

.meas tran vdout0_12ck1200 FIND v(dout0_12) AT=1210.05n

.meas tran vdout0_13ck1200 FIND v(dout0_13) AT=1210.05n

.meas tran vdout0_14ck1200 FIND v(dout0_14) AT=1210.05n

.meas tran vdout0_15ck1200 FIND v(dout0_15) AT=1210.05n

.meas tran vdout0_16ck1200 FIND v(dout0_16) AT=1210.05n

.meas tran vdout0_17ck1200 FIND v(dout0_17) AT=1210.05n

.meas tran vdout0_18ck1200 FIND v(dout0_18) AT=1210.05n

.meas tran vdout0_19ck1200 FIND v(dout0_19) AT=1210.05n

.meas tran vdout0_20ck1200 FIND v(dout0_20) AT=1210.05n

.meas tran vdout0_21ck1200 FIND v(dout0_21) AT=1210.05n

.meas tran vdout0_22ck1200 FIND v(dout0_22) AT=1210.05n

.meas tran vdout0_23ck1200 FIND v(dout0_23) AT=1210.05n

.meas tran vdout0_24ck1200 FIND v(dout0_24) AT=1210.05n

.meas tran vdout0_25ck1200 FIND v(dout0_25) AT=1210.05n

.meas tran vdout0_26ck1200 FIND v(dout0_26) AT=1210.05n

.meas tran vdout0_27ck1200 FIND v(dout0_27) AT=1210.05n

.meas tran vdout0_28ck1200 FIND v(dout0_28) AT=1210.05n

.meas tran vdout0_29ck1200 FIND v(dout0_29) AT=1210.05n

.meas tran vdout0_30ck1200 FIND v(dout0_30) AT=1210.05n

.meas tran vdout0_31ck1200 FIND v(dout0_31) AT=1210.05n

.meas tran vdout0_32ck1200 FIND v(dout0_32) AT=1210.05n

.meas tran vdout0_0ck1210 FIND v(dout0_0) AT=1220.05n

.meas tran vdout0_1ck1210 FIND v(dout0_1) AT=1220.05n

.meas tran vdout0_2ck1210 FIND v(dout0_2) AT=1220.05n

.meas tran vdout0_3ck1210 FIND v(dout0_3) AT=1220.05n

.meas tran vdout0_4ck1210 FIND v(dout0_4) AT=1220.05n

.meas tran vdout0_5ck1210 FIND v(dout0_5) AT=1220.05n

.meas tran vdout0_6ck1210 FIND v(dout0_6) AT=1220.05n

.meas tran vdout0_7ck1210 FIND v(dout0_7) AT=1220.05n

.meas tran vdout0_8ck1210 FIND v(dout0_8) AT=1220.05n

.meas tran vdout0_9ck1210 FIND v(dout0_9) AT=1220.05n

.meas tran vdout0_10ck1210 FIND v(dout0_10) AT=1220.05n

.meas tran vdout0_11ck1210 FIND v(dout0_11) AT=1220.05n

.meas tran vdout0_12ck1210 FIND v(dout0_12) AT=1220.05n

.meas tran vdout0_13ck1210 FIND v(dout0_13) AT=1220.05n

.meas tran vdout0_14ck1210 FIND v(dout0_14) AT=1220.05n

.meas tran vdout0_15ck1210 FIND v(dout0_15) AT=1220.05n

.meas tran vdout0_16ck1210 FIND v(dout0_16) AT=1220.05n

.meas tran vdout0_17ck1210 FIND v(dout0_17) AT=1220.05n

.meas tran vdout0_18ck1210 FIND v(dout0_18) AT=1220.05n

.meas tran vdout0_19ck1210 FIND v(dout0_19) AT=1220.05n

.meas tran vdout0_20ck1210 FIND v(dout0_20) AT=1220.05n

.meas tran vdout0_21ck1210 FIND v(dout0_21) AT=1220.05n

.meas tran vdout0_22ck1210 FIND v(dout0_22) AT=1220.05n

.meas tran vdout0_23ck1210 FIND v(dout0_23) AT=1220.05n

.meas tran vdout0_24ck1210 FIND v(dout0_24) AT=1220.05n

.meas tran vdout0_25ck1210 FIND v(dout0_25) AT=1220.05n

.meas tran vdout0_26ck1210 FIND v(dout0_26) AT=1220.05n

.meas tran vdout0_27ck1210 FIND v(dout0_27) AT=1220.05n

.meas tran vdout0_28ck1210 FIND v(dout0_28) AT=1220.05n

.meas tran vdout0_29ck1210 FIND v(dout0_29) AT=1220.05n

.meas tran vdout0_30ck1210 FIND v(dout0_30) AT=1220.05n

.meas tran vdout0_31ck1210 FIND v(dout0_31) AT=1220.05n

.meas tran vdout0_32ck1210 FIND v(dout0_32) AT=1220.05n

.meas tran vdout0_0ck1220 FIND v(dout0_0) AT=1230.05n

.meas tran vdout0_1ck1220 FIND v(dout0_1) AT=1230.05n

.meas tran vdout0_2ck1220 FIND v(dout0_2) AT=1230.05n

.meas tran vdout0_3ck1220 FIND v(dout0_3) AT=1230.05n

.meas tran vdout0_4ck1220 FIND v(dout0_4) AT=1230.05n

.meas tran vdout0_5ck1220 FIND v(dout0_5) AT=1230.05n

.meas tran vdout0_6ck1220 FIND v(dout0_6) AT=1230.05n

.meas tran vdout0_7ck1220 FIND v(dout0_7) AT=1230.05n

.meas tran vdout0_8ck1220 FIND v(dout0_8) AT=1230.05n

.meas tran vdout0_9ck1220 FIND v(dout0_9) AT=1230.05n

.meas tran vdout0_10ck1220 FIND v(dout0_10) AT=1230.05n

.meas tran vdout0_11ck1220 FIND v(dout0_11) AT=1230.05n

.meas tran vdout0_12ck1220 FIND v(dout0_12) AT=1230.05n

.meas tran vdout0_13ck1220 FIND v(dout0_13) AT=1230.05n

.meas tran vdout0_14ck1220 FIND v(dout0_14) AT=1230.05n

.meas tran vdout0_15ck1220 FIND v(dout0_15) AT=1230.05n

.meas tran vdout0_16ck1220 FIND v(dout0_16) AT=1230.05n

.meas tran vdout0_17ck1220 FIND v(dout0_17) AT=1230.05n

.meas tran vdout0_18ck1220 FIND v(dout0_18) AT=1230.05n

.meas tran vdout0_19ck1220 FIND v(dout0_19) AT=1230.05n

.meas tran vdout0_20ck1220 FIND v(dout0_20) AT=1230.05n

.meas tran vdout0_21ck1220 FIND v(dout0_21) AT=1230.05n

.meas tran vdout0_22ck1220 FIND v(dout0_22) AT=1230.05n

.meas tran vdout0_23ck1220 FIND v(dout0_23) AT=1230.05n

.meas tran vdout0_24ck1220 FIND v(dout0_24) AT=1230.05n

.meas tran vdout0_25ck1220 FIND v(dout0_25) AT=1230.05n

.meas tran vdout0_26ck1220 FIND v(dout0_26) AT=1230.05n

.meas tran vdout0_27ck1220 FIND v(dout0_27) AT=1230.05n

.meas tran vdout0_28ck1220 FIND v(dout0_28) AT=1230.05n

.meas tran vdout0_29ck1220 FIND v(dout0_29) AT=1230.05n

.meas tran vdout0_30ck1220 FIND v(dout0_30) AT=1230.05n

.meas tran vdout0_31ck1220 FIND v(dout0_31) AT=1230.05n

.meas tran vdout0_32ck1220 FIND v(dout0_32) AT=1230.05n

.meas tran vdout0_0ck1250 FIND v(dout0_0) AT=1260.05n

.meas tran vdout0_1ck1250 FIND v(dout0_1) AT=1260.05n

.meas tran vdout0_2ck1250 FIND v(dout0_2) AT=1260.05n

.meas tran vdout0_3ck1250 FIND v(dout0_3) AT=1260.05n

.meas tran vdout0_4ck1250 FIND v(dout0_4) AT=1260.05n

.meas tran vdout0_5ck1250 FIND v(dout0_5) AT=1260.05n

.meas tran vdout0_6ck1250 FIND v(dout0_6) AT=1260.05n

.meas tran vdout0_7ck1250 FIND v(dout0_7) AT=1260.05n

.meas tran vdout0_8ck1250 FIND v(dout0_8) AT=1260.05n

.meas tran vdout0_9ck1250 FIND v(dout0_9) AT=1260.05n

.meas tran vdout0_10ck1250 FIND v(dout0_10) AT=1260.05n

.meas tran vdout0_11ck1250 FIND v(dout0_11) AT=1260.05n

.meas tran vdout0_12ck1250 FIND v(dout0_12) AT=1260.05n

.meas tran vdout0_13ck1250 FIND v(dout0_13) AT=1260.05n

.meas tran vdout0_14ck1250 FIND v(dout0_14) AT=1260.05n

.meas tran vdout0_15ck1250 FIND v(dout0_15) AT=1260.05n

.meas tran vdout0_16ck1250 FIND v(dout0_16) AT=1260.05n

.meas tran vdout0_17ck1250 FIND v(dout0_17) AT=1260.05n

.meas tran vdout0_18ck1250 FIND v(dout0_18) AT=1260.05n

.meas tran vdout0_19ck1250 FIND v(dout0_19) AT=1260.05n

.meas tran vdout0_20ck1250 FIND v(dout0_20) AT=1260.05n

.meas tran vdout0_21ck1250 FIND v(dout0_21) AT=1260.05n

.meas tran vdout0_22ck1250 FIND v(dout0_22) AT=1260.05n

.meas tran vdout0_23ck1250 FIND v(dout0_23) AT=1260.05n

.meas tran vdout0_24ck1250 FIND v(dout0_24) AT=1260.05n

.meas tran vdout0_25ck1250 FIND v(dout0_25) AT=1260.05n

.meas tran vdout0_26ck1250 FIND v(dout0_26) AT=1260.05n

.meas tran vdout0_27ck1250 FIND v(dout0_27) AT=1260.05n

.meas tran vdout0_28ck1250 FIND v(dout0_28) AT=1260.05n

.meas tran vdout0_29ck1250 FIND v(dout0_29) AT=1260.05n

.meas tran vdout0_30ck1250 FIND v(dout0_30) AT=1260.05n

.meas tran vdout0_31ck1250 FIND v(dout0_31) AT=1260.05n

.meas tran vdout0_32ck1250 FIND v(dout0_32) AT=1260.05n

.meas tran vdout0_0ck1270 FIND v(dout0_0) AT=1280.05n

.meas tran vdout0_1ck1270 FIND v(dout0_1) AT=1280.05n

.meas tran vdout0_2ck1270 FIND v(dout0_2) AT=1280.05n

.meas tran vdout0_3ck1270 FIND v(dout0_3) AT=1280.05n

.meas tran vdout0_4ck1270 FIND v(dout0_4) AT=1280.05n

.meas tran vdout0_5ck1270 FIND v(dout0_5) AT=1280.05n

.meas tran vdout0_6ck1270 FIND v(dout0_6) AT=1280.05n

.meas tran vdout0_7ck1270 FIND v(dout0_7) AT=1280.05n

.meas tran vdout0_8ck1270 FIND v(dout0_8) AT=1280.05n

.meas tran vdout0_9ck1270 FIND v(dout0_9) AT=1280.05n

.meas tran vdout0_10ck1270 FIND v(dout0_10) AT=1280.05n

.meas tran vdout0_11ck1270 FIND v(dout0_11) AT=1280.05n

.meas tran vdout0_12ck1270 FIND v(dout0_12) AT=1280.05n

.meas tran vdout0_13ck1270 FIND v(dout0_13) AT=1280.05n

.meas tran vdout0_14ck1270 FIND v(dout0_14) AT=1280.05n

.meas tran vdout0_15ck1270 FIND v(dout0_15) AT=1280.05n

.meas tran vdout0_16ck1270 FIND v(dout0_16) AT=1280.05n

.meas tran vdout0_17ck1270 FIND v(dout0_17) AT=1280.05n

.meas tran vdout0_18ck1270 FIND v(dout0_18) AT=1280.05n

.meas tran vdout0_19ck1270 FIND v(dout0_19) AT=1280.05n

.meas tran vdout0_20ck1270 FIND v(dout0_20) AT=1280.05n

.meas tran vdout0_21ck1270 FIND v(dout0_21) AT=1280.05n

.meas tran vdout0_22ck1270 FIND v(dout0_22) AT=1280.05n

.meas tran vdout0_23ck1270 FIND v(dout0_23) AT=1280.05n

.meas tran vdout0_24ck1270 FIND v(dout0_24) AT=1280.05n

.meas tran vdout0_25ck1270 FIND v(dout0_25) AT=1280.05n

.meas tran vdout0_26ck1270 FIND v(dout0_26) AT=1280.05n

.meas tran vdout0_27ck1270 FIND v(dout0_27) AT=1280.05n

.meas tran vdout0_28ck1270 FIND v(dout0_28) AT=1280.05n

.meas tran vdout0_29ck1270 FIND v(dout0_29) AT=1280.05n

.meas tran vdout0_30ck1270 FIND v(dout0_30) AT=1280.05n

.meas tran vdout0_31ck1270 FIND v(dout0_31) AT=1280.05n

.meas tran vdout0_32ck1270 FIND v(dout0_32) AT=1280.05n

.meas tran vdout0_0ck1280 FIND v(dout0_0) AT=1290.05n

.meas tran vdout0_1ck1280 FIND v(dout0_1) AT=1290.05n

.meas tran vdout0_2ck1280 FIND v(dout0_2) AT=1290.05n

.meas tran vdout0_3ck1280 FIND v(dout0_3) AT=1290.05n

.meas tran vdout0_4ck1280 FIND v(dout0_4) AT=1290.05n

.meas tran vdout0_5ck1280 FIND v(dout0_5) AT=1290.05n

.meas tran vdout0_6ck1280 FIND v(dout0_6) AT=1290.05n

.meas tran vdout0_7ck1280 FIND v(dout0_7) AT=1290.05n

.meas tran vdout0_8ck1280 FIND v(dout0_8) AT=1290.05n

.meas tran vdout0_9ck1280 FIND v(dout0_9) AT=1290.05n

.meas tran vdout0_10ck1280 FIND v(dout0_10) AT=1290.05n

.meas tran vdout0_11ck1280 FIND v(dout0_11) AT=1290.05n

.meas tran vdout0_12ck1280 FIND v(dout0_12) AT=1290.05n

.meas tran vdout0_13ck1280 FIND v(dout0_13) AT=1290.05n

.meas tran vdout0_14ck1280 FIND v(dout0_14) AT=1290.05n

.meas tran vdout0_15ck1280 FIND v(dout0_15) AT=1290.05n

.meas tran vdout0_16ck1280 FIND v(dout0_16) AT=1290.05n

.meas tran vdout0_17ck1280 FIND v(dout0_17) AT=1290.05n

.meas tran vdout0_18ck1280 FIND v(dout0_18) AT=1290.05n

.meas tran vdout0_19ck1280 FIND v(dout0_19) AT=1290.05n

.meas tran vdout0_20ck1280 FIND v(dout0_20) AT=1290.05n

.meas tran vdout0_21ck1280 FIND v(dout0_21) AT=1290.05n

.meas tran vdout0_22ck1280 FIND v(dout0_22) AT=1290.05n

.meas tran vdout0_23ck1280 FIND v(dout0_23) AT=1290.05n

.meas tran vdout0_24ck1280 FIND v(dout0_24) AT=1290.05n

.meas tran vdout0_25ck1280 FIND v(dout0_25) AT=1290.05n

.meas tran vdout0_26ck1280 FIND v(dout0_26) AT=1290.05n

.meas tran vdout0_27ck1280 FIND v(dout0_27) AT=1290.05n

.meas tran vdout0_28ck1280 FIND v(dout0_28) AT=1290.05n

.meas tran vdout0_29ck1280 FIND v(dout0_29) AT=1290.05n

.meas tran vdout0_30ck1280 FIND v(dout0_30) AT=1290.05n

.meas tran vdout0_31ck1280 FIND v(dout0_31) AT=1290.05n

.meas tran vdout0_32ck1280 FIND v(dout0_32) AT=1290.05n

.meas tran vdout0_0ck1290 FIND v(dout0_0) AT=1300.05n

.meas tran vdout0_1ck1290 FIND v(dout0_1) AT=1300.05n

.meas tran vdout0_2ck1290 FIND v(dout0_2) AT=1300.05n

.meas tran vdout0_3ck1290 FIND v(dout0_3) AT=1300.05n

.meas tran vdout0_4ck1290 FIND v(dout0_4) AT=1300.05n

.meas tran vdout0_5ck1290 FIND v(dout0_5) AT=1300.05n

.meas tran vdout0_6ck1290 FIND v(dout0_6) AT=1300.05n

.meas tran vdout0_7ck1290 FIND v(dout0_7) AT=1300.05n

.meas tran vdout0_8ck1290 FIND v(dout0_8) AT=1300.05n

.meas tran vdout0_9ck1290 FIND v(dout0_9) AT=1300.05n

.meas tran vdout0_10ck1290 FIND v(dout0_10) AT=1300.05n

.meas tran vdout0_11ck1290 FIND v(dout0_11) AT=1300.05n

.meas tran vdout0_12ck1290 FIND v(dout0_12) AT=1300.05n

.meas tran vdout0_13ck1290 FIND v(dout0_13) AT=1300.05n

.meas tran vdout0_14ck1290 FIND v(dout0_14) AT=1300.05n

.meas tran vdout0_15ck1290 FIND v(dout0_15) AT=1300.05n

.meas tran vdout0_16ck1290 FIND v(dout0_16) AT=1300.05n

.meas tran vdout0_17ck1290 FIND v(dout0_17) AT=1300.05n

.meas tran vdout0_18ck1290 FIND v(dout0_18) AT=1300.05n

.meas tran vdout0_19ck1290 FIND v(dout0_19) AT=1300.05n

.meas tran vdout0_20ck1290 FIND v(dout0_20) AT=1300.05n

.meas tran vdout0_21ck1290 FIND v(dout0_21) AT=1300.05n

.meas tran vdout0_22ck1290 FIND v(dout0_22) AT=1300.05n

.meas tran vdout0_23ck1290 FIND v(dout0_23) AT=1300.05n

.meas tran vdout0_24ck1290 FIND v(dout0_24) AT=1300.05n

.meas tran vdout0_25ck1290 FIND v(dout0_25) AT=1300.05n

.meas tran vdout0_26ck1290 FIND v(dout0_26) AT=1300.05n

.meas tran vdout0_27ck1290 FIND v(dout0_27) AT=1300.05n

.meas tran vdout0_28ck1290 FIND v(dout0_28) AT=1300.05n

.meas tran vdout0_29ck1290 FIND v(dout0_29) AT=1300.05n

.meas tran vdout0_30ck1290 FIND v(dout0_30) AT=1300.05n

.meas tran vdout0_31ck1290 FIND v(dout0_31) AT=1300.05n

.meas tran vdout0_32ck1290 FIND v(dout0_32) AT=1300.05n

.meas tran vdout0_0ck1310 FIND v(dout0_0) AT=1320.05n

.meas tran vdout0_1ck1310 FIND v(dout0_1) AT=1320.05n

.meas tran vdout0_2ck1310 FIND v(dout0_2) AT=1320.05n

.meas tran vdout0_3ck1310 FIND v(dout0_3) AT=1320.05n

.meas tran vdout0_4ck1310 FIND v(dout0_4) AT=1320.05n

.meas tran vdout0_5ck1310 FIND v(dout0_5) AT=1320.05n

.meas tran vdout0_6ck1310 FIND v(dout0_6) AT=1320.05n

.meas tran vdout0_7ck1310 FIND v(dout0_7) AT=1320.05n

.meas tran vdout0_8ck1310 FIND v(dout0_8) AT=1320.05n

.meas tran vdout0_9ck1310 FIND v(dout0_9) AT=1320.05n

.meas tran vdout0_10ck1310 FIND v(dout0_10) AT=1320.05n

.meas tran vdout0_11ck1310 FIND v(dout0_11) AT=1320.05n

.meas tran vdout0_12ck1310 FIND v(dout0_12) AT=1320.05n

.meas tran vdout0_13ck1310 FIND v(dout0_13) AT=1320.05n

.meas tran vdout0_14ck1310 FIND v(dout0_14) AT=1320.05n

.meas tran vdout0_15ck1310 FIND v(dout0_15) AT=1320.05n

.meas tran vdout0_16ck1310 FIND v(dout0_16) AT=1320.05n

.meas tran vdout0_17ck1310 FIND v(dout0_17) AT=1320.05n

.meas tran vdout0_18ck1310 FIND v(dout0_18) AT=1320.05n

.meas tran vdout0_19ck1310 FIND v(dout0_19) AT=1320.05n

.meas tran vdout0_20ck1310 FIND v(dout0_20) AT=1320.05n

.meas tran vdout0_21ck1310 FIND v(dout0_21) AT=1320.05n

.meas tran vdout0_22ck1310 FIND v(dout0_22) AT=1320.05n

.meas tran vdout0_23ck1310 FIND v(dout0_23) AT=1320.05n

.meas tran vdout0_24ck1310 FIND v(dout0_24) AT=1320.05n

.meas tran vdout0_25ck1310 FIND v(dout0_25) AT=1320.05n

.meas tran vdout0_26ck1310 FIND v(dout0_26) AT=1320.05n

.meas tran vdout0_27ck1310 FIND v(dout0_27) AT=1320.05n

.meas tran vdout0_28ck1310 FIND v(dout0_28) AT=1320.05n

.meas tran vdout0_29ck1310 FIND v(dout0_29) AT=1320.05n

.meas tran vdout0_30ck1310 FIND v(dout0_30) AT=1320.05n

.meas tran vdout0_31ck1310 FIND v(dout0_31) AT=1320.05n

.meas tran vdout0_32ck1310 FIND v(dout0_32) AT=1320.05n

.meas tran vdout0_0ck1320 FIND v(dout0_0) AT=1330.05n

.meas tran vdout0_1ck1320 FIND v(dout0_1) AT=1330.05n

.meas tran vdout0_2ck1320 FIND v(dout0_2) AT=1330.05n

.meas tran vdout0_3ck1320 FIND v(dout0_3) AT=1330.05n

.meas tran vdout0_4ck1320 FIND v(dout0_4) AT=1330.05n

.meas tran vdout0_5ck1320 FIND v(dout0_5) AT=1330.05n

.meas tran vdout0_6ck1320 FIND v(dout0_6) AT=1330.05n

.meas tran vdout0_7ck1320 FIND v(dout0_7) AT=1330.05n

.meas tran vdout0_8ck1320 FIND v(dout0_8) AT=1330.05n

.meas tran vdout0_9ck1320 FIND v(dout0_9) AT=1330.05n

.meas tran vdout0_10ck1320 FIND v(dout0_10) AT=1330.05n

.meas tran vdout0_11ck1320 FIND v(dout0_11) AT=1330.05n

.meas tran vdout0_12ck1320 FIND v(dout0_12) AT=1330.05n

.meas tran vdout0_13ck1320 FIND v(dout0_13) AT=1330.05n

.meas tran vdout0_14ck1320 FIND v(dout0_14) AT=1330.05n

.meas tran vdout0_15ck1320 FIND v(dout0_15) AT=1330.05n

.meas tran vdout0_16ck1320 FIND v(dout0_16) AT=1330.05n

.meas tran vdout0_17ck1320 FIND v(dout0_17) AT=1330.05n

.meas tran vdout0_18ck1320 FIND v(dout0_18) AT=1330.05n

.meas tran vdout0_19ck1320 FIND v(dout0_19) AT=1330.05n

.meas tran vdout0_20ck1320 FIND v(dout0_20) AT=1330.05n

.meas tran vdout0_21ck1320 FIND v(dout0_21) AT=1330.05n

.meas tran vdout0_22ck1320 FIND v(dout0_22) AT=1330.05n

.meas tran vdout0_23ck1320 FIND v(dout0_23) AT=1330.05n

.meas tran vdout0_24ck1320 FIND v(dout0_24) AT=1330.05n

.meas tran vdout0_25ck1320 FIND v(dout0_25) AT=1330.05n

.meas tran vdout0_26ck1320 FIND v(dout0_26) AT=1330.05n

.meas tran vdout0_27ck1320 FIND v(dout0_27) AT=1330.05n

.meas tran vdout0_28ck1320 FIND v(dout0_28) AT=1330.05n

.meas tran vdout0_29ck1320 FIND v(dout0_29) AT=1330.05n

.meas tran vdout0_30ck1320 FIND v(dout0_30) AT=1330.05n

.meas tran vdout0_31ck1320 FIND v(dout0_31) AT=1330.05n

.meas tran vdout0_32ck1320 FIND v(dout0_32) AT=1330.05n

.meas tran vdout0_0ck1330 FIND v(dout0_0) AT=1340.05n

.meas tran vdout0_1ck1330 FIND v(dout0_1) AT=1340.05n

.meas tran vdout0_2ck1330 FIND v(dout0_2) AT=1340.05n

.meas tran vdout0_3ck1330 FIND v(dout0_3) AT=1340.05n

.meas tran vdout0_4ck1330 FIND v(dout0_4) AT=1340.05n

.meas tran vdout0_5ck1330 FIND v(dout0_5) AT=1340.05n

.meas tran vdout0_6ck1330 FIND v(dout0_6) AT=1340.05n

.meas tran vdout0_7ck1330 FIND v(dout0_7) AT=1340.05n

.meas tran vdout0_8ck1330 FIND v(dout0_8) AT=1340.05n

.meas tran vdout0_9ck1330 FIND v(dout0_9) AT=1340.05n

.meas tran vdout0_10ck1330 FIND v(dout0_10) AT=1340.05n

.meas tran vdout0_11ck1330 FIND v(dout0_11) AT=1340.05n

.meas tran vdout0_12ck1330 FIND v(dout0_12) AT=1340.05n

.meas tran vdout0_13ck1330 FIND v(dout0_13) AT=1340.05n

.meas tran vdout0_14ck1330 FIND v(dout0_14) AT=1340.05n

.meas tran vdout0_15ck1330 FIND v(dout0_15) AT=1340.05n

.meas tran vdout0_16ck1330 FIND v(dout0_16) AT=1340.05n

.meas tran vdout0_17ck1330 FIND v(dout0_17) AT=1340.05n

.meas tran vdout0_18ck1330 FIND v(dout0_18) AT=1340.05n

.meas tran vdout0_19ck1330 FIND v(dout0_19) AT=1340.05n

.meas tran vdout0_20ck1330 FIND v(dout0_20) AT=1340.05n

.meas tran vdout0_21ck1330 FIND v(dout0_21) AT=1340.05n

.meas tran vdout0_22ck1330 FIND v(dout0_22) AT=1340.05n

.meas tran vdout0_23ck1330 FIND v(dout0_23) AT=1340.05n

.meas tran vdout0_24ck1330 FIND v(dout0_24) AT=1340.05n

.meas tran vdout0_25ck1330 FIND v(dout0_25) AT=1340.05n

.meas tran vdout0_26ck1330 FIND v(dout0_26) AT=1340.05n

.meas tran vdout0_27ck1330 FIND v(dout0_27) AT=1340.05n

.meas tran vdout0_28ck1330 FIND v(dout0_28) AT=1340.05n

.meas tran vdout0_29ck1330 FIND v(dout0_29) AT=1340.05n

.meas tran vdout0_30ck1330 FIND v(dout0_30) AT=1340.05n

.meas tran vdout0_31ck1330 FIND v(dout0_31) AT=1340.05n

.meas tran vdout0_32ck1330 FIND v(dout0_32) AT=1340.05n

.meas tran vdout0_0ck1360 FIND v(dout0_0) AT=1370.05n

.meas tran vdout0_1ck1360 FIND v(dout0_1) AT=1370.05n

.meas tran vdout0_2ck1360 FIND v(dout0_2) AT=1370.05n

.meas tran vdout0_3ck1360 FIND v(dout0_3) AT=1370.05n

.meas tran vdout0_4ck1360 FIND v(dout0_4) AT=1370.05n

.meas tran vdout0_5ck1360 FIND v(dout0_5) AT=1370.05n

.meas tran vdout0_6ck1360 FIND v(dout0_6) AT=1370.05n

.meas tran vdout0_7ck1360 FIND v(dout0_7) AT=1370.05n

.meas tran vdout0_8ck1360 FIND v(dout0_8) AT=1370.05n

.meas tran vdout0_9ck1360 FIND v(dout0_9) AT=1370.05n

.meas tran vdout0_10ck1360 FIND v(dout0_10) AT=1370.05n

.meas tran vdout0_11ck1360 FIND v(dout0_11) AT=1370.05n

.meas tran vdout0_12ck1360 FIND v(dout0_12) AT=1370.05n

.meas tran vdout0_13ck1360 FIND v(dout0_13) AT=1370.05n

.meas tran vdout0_14ck1360 FIND v(dout0_14) AT=1370.05n

.meas tran vdout0_15ck1360 FIND v(dout0_15) AT=1370.05n

.meas tran vdout0_16ck1360 FIND v(dout0_16) AT=1370.05n

.meas tran vdout0_17ck1360 FIND v(dout0_17) AT=1370.05n

.meas tran vdout0_18ck1360 FIND v(dout0_18) AT=1370.05n

.meas tran vdout0_19ck1360 FIND v(dout0_19) AT=1370.05n

.meas tran vdout0_20ck1360 FIND v(dout0_20) AT=1370.05n

.meas tran vdout0_21ck1360 FIND v(dout0_21) AT=1370.05n

.meas tran vdout0_22ck1360 FIND v(dout0_22) AT=1370.05n

.meas tran vdout0_23ck1360 FIND v(dout0_23) AT=1370.05n

.meas tran vdout0_24ck1360 FIND v(dout0_24) AT=1370.05n

.meas tran vdout0_25ck1360 FIND v(dout0_25) AT=1370.05n

.meas tran vdout0_26ck1360 FIND v(dout0_26) AT=1370.05n

.meas tran vdout0_27ck1360 FIND v(dout0_27) AT=1370.05n

.meas tran vdout0_28ck1360 FIND v(dout0_28) AT=1370.05n

.meas tran vdout0_29ck1360 FIND v(dout0_29) AT=1370.05n

.meas tran vdout0_30ck1360 FIND v(dout0_30) AT=1370.05n

.meas tran vdout0_31ck1360 FIND v(dout0_31) AT=1370.05n

.meas tran vdout0_32ck1360 FIND v(dout0_32) AT=1370.05n

.meas tran vdout0_0ck1420 FIND v(dout0_0) AT=1430.05n

.meas tran vdout0_1ck1420 FIND v(dout0_1) AT=1430.05n

.meas tran vdout0_2ck1420 FIND v(dout0_2) AT=1430.05n

.meas tran vdout0_3ck1420 FIND v(dout0_3) AT=1430.05n

.meas tran vdout0_4ck1420 FIND v(dout0_4) AT=1430.05n

.meas tran vdout0_5ck1420 FIND v(dout0_5) AT=1430.05n

.meas tran vdout0_6ck1420 FIND v(dout0_6) AT=1430.05n

.meas tran vdout0_7ck1420 FIND v(dout0_7) AT=1430.05n

.meas tran vdout0_8ck1420 FIND v(dout0_8) AT=1430.05n

.meas tran vdout0_9ck1420 FIND v(dout0_9) AT=1430.05n

.meas tran vdout0_10ck1420 FIND v(dout0_10) AT=1430.05n

.meas tran vdout0_11ck1420 FIND v(dout0_11) AT=1430.05n

.meas tran vdout0_12ck1420 FIND v(dout0_12) AT=1430.05n

.meas tran vdout0_13ck1420 FIND v(dout0_13) AT=1430.05n

.meas tran vdout0_14ck1420 FIND v(dout0_14) AT=1430.05n

.meas tran vdout0_15ck1420 FIND v(dout0_15) AT=1430.05n

.meas tran vdout0_16ck1420 FIND v(dout0_16) AT=1430.05n

.meas tran vdout0_17ck1420 FIND v(dout0_17) AT=1430.05n

.meas tran vdout0_18ck1420 FIND v(dout0_18) AT=1430.05n

.meas tran vdout0_19ck1420 FIND v(dout0_19) AT=1430.05n

.meas tran vdout0_20ck1420 FIND v(dout0_20) AT=1430.05n

.meas tran vdout0_21ck1420 FIND v(dout0_21) AT=1430.05n

.meas tran vdout0_22ck1420 FIND v(dout0_22) AT=1430.05n

.meas tran vdout0_23ck1420 FIND v(dout0_23) AT=1430.05n

.meas tran vdout0_24ck1420 FIND v(dout0_24) AT=1430.05n

.meas tran vdout0_25ck1420 FIND v(dout0_25) AT=1430.05n

.meas tran vdout0_26ck1420 FIND v(dout0_26) AT=1430.05n

.meas tran vdout0_27ck1420 FIND v(dout0_27) AT=1430.05n

.meas tran vdout0_28ck1420 FIND v(dout0_28) AT=1430.05n

.meas tran vdout0_29ck1420 FIND v(dout0_29) AT=1430.05n

.meas tran vdout0_30ck1420 FIND v(dout0_30) AT=1430.05n

.meas tran vdout0_31ck1420 FIND v(dout0_31) AT=1430.05n

.meas tran vdout0_32ck1420 FIND v(dout0_32) AT=1430.05n

.meas tran vdout0_0ck1430 FIND v(dout0_0) AT=1440.05n

.meas tran vdout0_1ck1430 FIND v(dout0_1) AT=1440.05n

.meas tran vdout0_2ck1430 FIND v(dout0_2) AT=1440.05n

.meas tran vdout0_3ck1430 FIND v(dout0_3) AT=1440.05n

.meas tran vdout0_4ck1430 FIND v(dout0_4) AT=1440.05n

.meas tran vdout0_5ck1430 FIND v(dout0_5) AT=1440.05n

.meas tran vdout0_6ck1430 FIND v(dout0_6) AT=1440.05n

.meas tran vdout0_7ck1430 FIND v(dout0_7) AT=1440.05n

.meas tran vdout0_8ck1430 FIND v(dout0_8) AT=1440.05n

.meas tran vdout0_9ck1430 FIND v(dout0_9) AT=1440.05n

.meas tran vdout0_10ck1430 FIND v(dout0_10) AT=1440.05n

.meas tran vdout0_11ck1430 FIND v(dout0_11) AT=1440.05n

.meas tran vdout0_12ck1430 FIND v(dout0_12) AT=1440.05n

.meas tran vdout0_13ck1430 FIND v(dout0_13) AT=1440.05n

.meas tran vdout0_14ck1430 FIND v(dout0_14) AT=1440.05n

.meas tran vdout0_15ck1430 FIND v(dout0_15) AT=1440.05n

.meas tran vdout0_16ck1430 FIND v(dout0_16) AT=1440.05n

.meas tran vdout0_17ck1430 FIND v(dout0_17) AT=1440.05n

.meas tran vdout0_18ck1430 FIND v(dout0_18) AT=1440.05n

.meas tran vdout0_19ck1430 FIND v(dout0_19) AT=1440.05n

.meas tran vdout0_20ck1430 FIND v(dout0_20) AT=1440.05n

.meas tran vdout0_21ck1430 FIND v(dout0_21) AT=1440.05n

.meas tran vdout0_22ck1430 FIND v(dout0_22) AT=1440.05n

.meas tran vdout0_23ck1430 FIND v(dout0_23) AT=1440.05n

.meas tran vdout0_24ck1430 FIND v(dout0_24) AT=1440.05n

.meas tran vdout0_25ck1430 FIND v(dout0_25) AT=1440.05n

.meas tran vdout0_26ck1430 FIND v(dout0_26) AT=1440.05n

.meas tran vdout0_27ck1430 FIND v(dout0_27) AT=1440.05n

.meas tran vdout0_28ck1430 FIND v(dout0_28) AT=1440.05n

.meas tran vdout0_29ck1430 FIND v(dout0_29) AT=1440.05n

.meas tran vdout0_30ck1430 FIND v(dout0_30) AT=1440.05n

.meas tran vdout0_31ck1430 FIND v(dout0_31) AT=1440.05n

.meas tran vdout0_32ck1430 FIND v(dout0_32) AT=1440.05n

.meas tran vdout0_0ck1450 FIND v(dout0_0) AT=1460.05n

.meas tran vdout0_1ck1450 FIND v(dout0_1) AT=1460.05n

.meas tran vdout0_2ck1450 FIND v(dout0_2) AT=1460.05n

.meas tran vdout0_3ck1450 FIND v(dout0_3) AT=1460.05n

.meas tran vdout0_4ck1450 FIND v(dout0_4) AT=1460.05n

.meas tran vdout0_5ck1450 FIND v(dout0_5) AT=1460.05n

.meas tran vdout0_6ck1450 FIND v(dout0_6) AT=1460.05n

.meas tran vdout0_7ck1450 FIND v(dout0_7) AT=1460.05n

.meas tran vdout0_8ck1450 FIND v(dout0_8) AT=1460.05n

.meas tran vdout0_9ck1450 FIND v(dout0_9) AT=1460.05n

.meas tran vdout0_10ck1450 FIND v(dout0_10) AT=1460.05n

.meas tran vdout0_11ck1450 FIND v(dout0_11) AT=1460.05n

.meas tran vdout0_12ck1450 FIND v(dout0_12) AT=1460.05n

.meas tran vdout0_13ck1450 FIND v(dout0_13) AT=1460.05n

.meas tran vdout0_14ck1450 FIND v(dout0_14) AT=1460.05n

.meas tran vdout0_15ck1450 FIND v(dout0_15) AT=1460.05n

.meas tran vdout0_16ck1450 FIND v(dout0_16) AT=1460.05n

.meas tran vdout0_17ck1450 FIND v(dout0_17) AT=1460.05n

.meas tran vdout0_18ck1450 FIND v(dout0_18) AT=1460.05n

.meas tran vdout0_19ck1450 FIND v(dout0_19) AT=1460.05n

.meas tran vdout0_20ck1450 FIND v(dout0_20) AT=1460.05n

.meas tran vdout0_21ck1450 FIND v(dout0_21) AT=1460.05n

.meas tran vdout0_22ck1450 FIND v(dout0_22) AT=1460.05n

.meas tran vdout0_23ck1450 FIND v(dout0_23) AT=1460.05n

.meas tran vdout0_24ck1450 FIND v(dout0_24) AT=1460.05n

.meas tran vdout0_25ck1450 FIND v(dout0_25) AT=1460.05n

.meas tran vdout0_26ck1450 FIND v(dout0_26) AT=1460.05n

.meas tran vdout0_27ck1450 FIND v(dout0_27) AT=1460.05n

.meas tran vdout0_28ck1450 FIND v(dout0_28) AT=1460.05n

.meas tran vdout0_29ck1450 FIND v(dout0_29) AT=1460.05n

.meas tran vdout0_30ck1450 FIND v(dout0_30) AT=1460.05n

.meas tran vdout0_31ck1450 FIND v(dout0_31) AT=1460.05n

.meas tran vdout0_32ck1450 FIND v(dout0_32) AT=1460.05n

.meas tran vdout0_0ck1480 FIND v(dout0_0) AT=1490.05n

.meas tran vdout0_1ck1480 FIND v(dout0_1) AT=1490.05n

.meas tran vdout0_2ck1480 FIND v(dout0_2) AT=1490.05n

.meas tran vdout0_3ck1480 FIND v(dout0_3) AT=1490.05n

.meas tran vdout0_4ck1480 FIND v(dout0_4) AT=1490.05n

.meas tran vdout0_5ck1480 FIND v(dout0_5) AT=1490.05n

.meas tran vdout0_6ck1480 FIND v(dout0_6) AT=1490.05n

.meas tran vdout0_7ck1480 FIND v(dout0_7) AT=1490.05n

.meas tran vdout0_8ck1480 FIND v(dout0_8) AT=1490.05n

.meas tran vdout0_9ck1480 FIND v(dout0_9) AT=1490.05n

.meas tran vdout0_10ck1480 FIND v(dout0_10) AT=1490.05n

.meas tran vdout0_11ck1480 FIND v(dout0_11) AT=1490.05n

.meas tran vdout0_12ck1480 FIND v(dout0_12) AT=1490.05n

.meas tran vdout0_13ck1480 FIND v(dout0_13) AT=1490.05n

.meas tran vdout0_14ck1480 FIND v(dout0_14) AT=1490.05n

.meas tran vdout0_15ck1480 FIND v(dout0_15) AT=1490.05n

.meas tran vdout0_16ck1480 FIND v(dout0_16) AT=1490.05n

.meas tran vdout0_17ck1480 FIND v(dout0_17) AT=1490.05n

.meas tran vdout0_18ck1480 FIND v(dout0_18) AT=1490.05n

.meas tran vdout0_19ck1480 FIND v(dout0_19) AT=1490.05n

.meas tran vdout0_20ck1480 FIND v(dout0_20) AT=1490.05n

.meas tran vdout0_21ck1480 FIND v(dout0_21) AT=1490.05n

.meas tran vdout0_22ck1480 FIND v(dout0_22) AT=1490.05n

.meas tran vdout0_23ck1480 FIND v(dout0_23) AT=1490.05n

.meas tran vdout0_24ck1480 FIND v(dout0_24) AT=1490.05n

.meas tran vdout0_25ck1480 FIND v(dout0_25) AT=1490.05n

.meas tran vdout0_26ck1480 FIND v(dout0_26) AT=1490.05n

.meas tran vdout0_27ck1480 FIND v(dout0_27) AT=1490.05n

.meas tran vdout0_28ck1480 FIND v(dout0_28) AT=1490.05n

.meas tran vdout0_29ck1480 FIND v(dout0_29) AT=1490.05n

.meas tran vdout0_30ck1480 FIND v(dout0_30) AT=1490.05n

.meas tran vdout0_31ck1480 FIND v(dout0_31) AT=1490.05n

.meas tran vdout0_32ck1480 FIND v(dout0_32) AT=1490.05n

.meas tran vdout0_0ck1500 FIND v(dout0_0) AT=1510.05n

.meas tran vdout0_1ck1500 FIND v(dout0_1) AT=1510.05n

.meas tran vdout0_2ck1500 FIND v(dout0_2) AT=1510.05n

.meas tran vdout0_3ck1500 FIND v(dout0_3) AT=1510.05n

.meas tran vdout0_4ck1500 FIND v(dout0_4) AT=1510.05n

.meas tran vdout0_5ck1500 FIND v(dout0_5) AT=1510.05n

.meas tran vdout0_6ck1500 FIND v(dout0_6) AT=1510.05n

.meas tran vdout0_7ck1500 FIND v(dout0_7) AT=1510.05n

.meas tran vdout0_8ck1500 FIND v(dout0_8) AT=1510.05n

.meas tran vdout0_9ck1500 FIND v(dout0_9) AT=1510.05n

.meas tran vdout0_10ck1500 FIND v(dout0_10) AT=1510.05n

.meas tran vdout0_11ck1500 FIND v(dout0_11) AT=1510.05n

.meas tran vdout0_12ck1500 FIND v(dout0_12) AT=1510.05n

.meas tran vdout0_13ck1500 FIND v(dout0_13) AT=1510.05n

.meas tran vdout0_14ck1500 FIND v(dout0_14) AT=1510.05n

.meas tran vdout0_15ck1500 FIND v(dout0_15) AT=1510.05n

.meas tran vdout0_16ck1500 FIND v(dout0_16) AT=1510.05n

.meas tran vdout0_17ck1500 FIND v(dout0_17) AT=1510.05n

.meas tran vdout0_18ck1500 FIND v(dout0_18) AT=1510.05n

.meas tran vdout0_19ck1500 FIND v(dout0_19) AT=1510.05n

.meas tran vdout0_20ck1500 FIND v(dout0_20) AT=1510.05n

.meas tran vdout0_21ck1500 FIND v(dout0_21) AT=1510.05n

.meas tran vdout0_22ck1500 FIND v(dout0_22) AT=1510.05n

.meas tran vdout0_23ck1500 FIND v(dout0_23) AT=1510.05n

.meas tran vdout0_24ck1500 FIND v(dout0_24) AT=1510.05n

.meas tran vdout0_25ck1500 FIND v(dout0_25) AT=1510.05n

.meas tran vdout0_26ck1500 FIND v(dout0_26) AT=1510.05n

.meas tran vdout0_27ck1500 FIND v(dout0_27) AT=1510.05n

.meas tran vdout0_28ck1500 FIND v(dout0_28) AT=1510.05n

.meas tran vdout0_29ck1500 FIND v(dout0_29) AT=1510.05n

.meas tran vdout0_30ck1500 FIND v(dout0_30) AT=1510.05n

.meas tran vdout0_31ck1500 FIND v(dout0_31) AT=1510.05n

.meas tran vdout0_32ck1500 FIND v(dout0_32) AT=1510.05n

.meas tran vdout0_0ck1540 FIND v(dout0_0) AT=1550.05n

.meas tran vdout0_1ck1540 FIND v(dout0_1) AT=1550.05n

.meas tran vdout0_2ck1540 FIND v(dout0_2) AT=1550.05n

.meas tran vdout0_3ck1540 FIND v(dout0_3) AT=1550.05n

.meas tran vdout0_4ck1540 FIND v(dout0_4) AT=1550.05n

.meas tran vdout0_5ck1540 FIND v(dout0_5) AT=1550.05n

.meas tran vdout0_6ck1540 FIND v(dout0_6) AT=1550.05n

.meas tran vdout0_7ck1540 FIND v(dout0_7) AT=1550.05n

.meas tran vdout0_8ck1540 FIND v(dout0_8) AT=1550.05n

.meas tran vdout0_9ck1540 FIND v(dout0_9) AT=1550.05n

.meas tran vdout0_10ck1540 FIND v(dout0_10) AT=1550.05n

.meas tran vdout0_11ck1540 FIND v(dout0_11) AT=1550.05n

.meas tran vdout0_12ck1540 FIND v(dout0_12) AT=1550.05n

.meas tran vdout0_13ck1540 FIND v(dout0_13) AT=1550.05n

.meas tran vdout0_14ck1540 FIND v(dout0_14) AT=1550.05n

.meas tran vdout0_15ck1540 FIND v(dout0_15) AT=1550.05n

.meas tran vdout0_16ck1540 FIND v(dout0_16) AT=1550.05n

.meas tran vdout0_17ck1540 FIND v(dout0_17) AT=1550.05n

.meas tran vdout0_18ck1540 FIND v(dout0_18) AT=1550.05n

.meas tran vdout0_19ck1540 FIND v(dout0_19) AT=1550.05n

.meas tran vdout0_20ck1540 FIND v(dout0_20) AT=1550.05n

.meas tran vdout0_21ck1540 FIND v(dout0_21) AT=1550.05n

.meas tran vdout0_22ck1540 FIND v(dout0_22) AT=1550.05n

.meas tran vdout0_23ck1540 FIND v(dout0_23) AT=1550.05n

.meas tran vdout0_24ck1540 FIND v(dout0_24) AT=1550.05n

.meas tran vdout0_25ck1540 FIND v(dout0_25) AT=1550.05n

.meas tran vdout0_26ck1540 FIND v(dout0_26) AT=1550.05n

.meas tran vdout0_27ck1540 FIND v(dout0_27) AT=1550.05n

.meas tran vdout0_28ck1540 FIND v(dout0_28) AT=1550.05n

.meas tran vdout0_29ck1540 FIND v(dout0_29) AT=1550.05n

.meas tran vdout0_30ck1540 FIND v(dout0_30) AT=1550.05n

.meas tran vdout0_31ck1540 FIND v(dout0_31) AT=1550.05n

.meas tran vdout0_32ck1540 FIND v(dout0_32) AT=1550.05n

.meas tran vdout0_0ck1600 FIND v(dout0_0) AT=1610.05n

.meas tran vdout0_1ck1600 FIND v(dout0_1) AT=1610.05n

.meas tran vdout0_2ck1600 FIND v(dout0_2) AT=1610.05n

.meas tran vdout0_3ck1600 FIND v(dout0_3) AT=1610.05n

.meas tran vdout0_4ck1600 FIND v(dout0_4) AT=1610.05n

.meas tran vdout0_5ck1600 FIND v(dout0_5) AT=1610.05n

.meas tran vdout0_6ck1600 FIND v(dout0_6) AT=1610.05n

.meas tran vdout0_7ck1600 FIND v(dout0_7) AT=1610.05n

.meas tran vdout0_8ck1600 FIND v(dout0_8) AT=1610.05n

.meas tran vdout0_9ck1600 FIND v(dout0_9) AT=1610.05n

.meas tran vdout0_10ck1600 FIND v(dout0_10) AT=1610.05n

.meas tran vdout0_11ck1600 FIND v(dout0_11) AT=1610.05n

.meas tran vdout0_12ck1600 FIND v(dout0_12) AT=1610.05n

.meas tran vdout0_13ck1600 FIND v(dout0_13) AT=1610.05n

.meas tran vdout0_14ck1600 FIND v(dout0_14) AT=1610.05n

.meas tran vdout0_15ck1600 FIND v(dout0_15) AT=1610.05n

.meas tran vdout0_16ck1600 FIND v(dout0_16) AT=1610.05n

.meas tran vdout0_17ck1600 FIND v(dout0_17) AT=1610.05n

.meas tran vdout0_18ck1600 FIND v(dout0_18) AT=1610.05n

.meas tran vdout0_19ck1600 FIND v(dout0_19) AT=1610.05n

.meas tran vdout0_20ck1600 FIND v(dout0_20) AT=1610.05n

.meas tran vdout0_21ck1600 FIND v(dout0_21) AT=1610.05n

.meas tran vdout0_22ck1600 FIND v(dout0_22) AT=1610.05n

.meas tran vdout0_23ck1600 FIND v(dout0_23) AT=1610.05n

.meas tran vdout0_24ck1600 FIND v(dout0_24) AT=1610.05n

.meas tran vdout0_25ck1600 FIND v(dout0_25) AT=1610.05n

.meas tran vdout0_26ck1600 FIND v(dout0_26) AT=1610.05n

.meas tran vdout0_27ck1600 FIND v(dout0_27) AT=1610.05n

.meas tran vdout0_28ck1600 FIND v(dout0_28) AT=1610.05n

.meas tran vdout0_29ck1600 FIND v(dout0_29) AT=1610.05n

.meas tran vdout0_30ck1600 FIND v(dout0_30) AT=1610.05n

.meas tran vdout0_31ck1600 FIND v(dout0_31) AT=1610.05n

.meas tran vdout0_32ck1600 FIND v(dout0_32) AT=1610.05n

.meas tran vdout0_0ck1610 FIND v(dout0_0) AT=1620.05n

.meas tran vdout0_1ck1610 FIND v(dout0_1) AT=1620.05n

.meas tran vdout0_2ck1610 FIND v(dout0_2) AT=1620.05n

.meas tran vdout0_3ck1610 FIND v(dout0_3) AT=1620.05n

.meas tran vdout0_4ck1610 FIND v(dout0_4) AT=1620.05n

.meas tran vdout0_5ck1610 FIND v(dout0_5) AT=1620.05n

.meas tran vdout0_6ck1610 FIND v(dout0_6) AT=1620.05n

.meas tran vdout0_7ck1610 FIND v(dout0_7) AT=1620.05n

.meas tran vdout0_8ck1610 FIND v(dout0_8) AT=1620.05n

.meas tran vdout0_9ck1610 FIND v(dout0_9) AT=1620.05n

.meas tran vdout0_10ck1610 FIND v(dout0_10) AT=1620.05n

.meas tran vdout0_11ck1610 FIND v(dout0_11) AT=1620.05n

.meas tran vdout0_12ck1610 FIND v(dout0_12) AT=1620.05n

.meas tran vdout0_13ck1610 FIND v(dout0_13) AT=1620.05n

.meas tran vdout0_14ck1610 FIND v(dout0_14) AT=1620.05n

.meas tran vdout0_15ck1610 FIND v(dout0_15) AT=1620.05n

.meas tran vdout0_16ck1610 FIND v(dout0_16) AT=1620.05n

.meas tran vdout0_17ck1610 FIND v(dout0_17) AT=1620.05n

.meas tran vdout0_18ck1610 FIND v(dout0_18) AT=1620.05n

.meas tran vdout0_19ck1610 FIND v(dout0_19) AT=1620.05n

.meas tran vdout0_20ck1610 FIND v(dout0_20) AT=1620.05n

.meas tran vdout0_21ck1610 FIND v(dout0_21) AT=1620.05n

.meas tran vdout0_22ck1610 FIND v(dout0_22) AT=1620.05n

.meas tran vdout0_23ck1610 FIND v(dout0_23) AT=1620.05n

.meas tran vdout0_24ck1610 FIND v(dout0_24) AT=1620.05n

.meas tran vdout0_25ck1610 FIND v(dout0_25) AT=1620.05n

.meas tran vdout0_26ck1610 FIND v(dout0_26) AT=1620.05n

.meas tran vdout0_27ck1610 FIND v(dout0_27) AT=1620.05n

.meas tran vdout0_28ck1610 FIND v(dout0_28) AT=1620.05n

.meas tran vdout0_29ck1610 FIND v(dout0_29) AT=1620.05n

.meas tran vdout0_30ck1610 FIND v(dout0_30) AT=1620.05n

.meas tran vdout0_31ck1610 FIND v(dout0_31) AT=1620.05n

.meas tran vdout0_32ck1610 FIND v(dout0_32) AT=1620.05n

.meas tran vdout0_0ck1630 FIND v(dout0_0) AT=1640.05n

.meas tran vdout0_1ck1630 FIND v(dout0_1) AT=1640.05n

.meas tran vdout0_2ck1630 FIND v(dout0_2) AT=1640.05n

.meas tran vdout0_3ck1630 FIND v(dout0_3) AT=1640.05n

.meas tran vdout0_4ck1630 FIND v(dout0_4) AT=1640.05n

.meas tran vdout0_5ck1630 FIND v(dout0_5) AT=1640.05n

.meas tran vdout0_6ck1630 FIND v(dout0_6) AT=1640.05n

.meas tran vdout0_7ck1630 FIND v(dout0_7) AT=1640.05n

.meas tran vdout0_8ck1630 FIND v(dout0_8) AT=1640.05n

.meas tran vdout0_9ck1630 FIND v(dout0_9) AT=1640.05n

.meas tran vdout0_10ck1630 FIND v(dout0_10) AT=1640.05n

.meas tran vdout0_11ck1630 FIND v(dout0_11) AT=1640.05n

.meas tran vdout0_12ck1630 FIND v(dout0_12) AT=1640.05n

.meas tran vdout0_13ck1630 FIND v(dout0_13) AT=1640.05n

.meas tran vdout0_14ck1630 FIND v(dout0_14) AT=1640.05n

.meas tran vdout0_15ck1630 FIND v(dout0_15) AT=1640.05n

.meas tran vdout0_16ck1630 FIND v(dout0_16) AT=1640.05n

.meas tran vdout0_17ck1630 FIND v(dout0_17) AT=1640.05n

.meas tran vdout0_18ck1630 FIND v(dout0_18) AT=1640.05n

.meas tran vdout0_19ck1630 FIND v(dout0_19) AT=1640.05n

.meas tran vdout0_20ck1630 FIND v(dout0_20) AT=1640.05n

.meas tran vdout0_21ck1630 FIND v(dout0_21) AT=1640.05n

.meas tran vdout0_22ck1630 FIND v(dout0_22) AT=1640.05n

.meas tran vdout0_23ck1630 FIND v(dout0_23) AT=1640.05n

.meas tran vdout0_24ck1630 FIND v(dout0_24) AT=1640.05n

.meas tran vdout0_25ck1630 FIND v(dout0_25) AT=1640.05n

.meas tran vdout0_26ck1630 FIND v(dout0_26) AT=1640.05n

.meas tran vdout0_27ck1630 FIND v(dout0_27) AT=1640.05n

.meas tran vdout0_28ck1630 FIND v(dout0_28) AT=1640.05n

.meas tran vdout0_29ck1630 FIND v(dout0_29) AT=1640.05n

.meas tran vdout0_30ck1630 FIND v(dout0_30) AT=1640.05n

.meas tran vdout0_31ck1630 FIND v(dout0_31) AT=1640.05n

.meas tran vdout0_32ck1630 FIND v(dout0_32) AT=1640.05n

.meas tran vdout0_0ck1640 FIND v(dout0_0) AT=1650.05n

.meas tran vdout0_1ck1640 FIND v(dout0_1) AT=1650.05n

.meas tran vdout0_2ck1640 FIND v(dout0_2) AT=1650.05n

.meas tran vdout0_3ck1640 FIND v(dout0_3) AT=1650.05n

.meas tran vdout0_4ck1640 FIND v(dout0_4) AT=1650.05n

.meas tran vdout0_5ck1640 FIND v(dout0_5) AT=1650.05n

.meas tran vdout0_6ck1640 FIND v(dout0_6) AT=1650.05n

.meas tran vdout0_7ck1640 FIND v(dout0_7) AT=1650.05n

.meas tran vdout0_8ck1640 FIND v(dout0_8) AT=1650.05n

.meas tran vdout0_9ck1640 FIND v(dout0_9) AT=1650.05n

.meas tran vdout0_10ck1640 FIND v(dout0_10) AT=1650.05n

.meas tran vdout0_11ck1640 FIND v(dout0_11) AT=1650.05n

.meas tran vdout0_12ck1640 FIND v(dout0_12) AT=1650.05n

.meas tran vdout0_13ck1640 FIND v(dout0_13) AT=1650.05n

.meas tran vdout0_14ck1640 FIND v(dout0_14) AT=1650.05n

.meas tran vdout0_15ck1640 FIND v(dout0_15) AT=1650.05n

.meas tran vdout0_16ck1640 FIND v(dout0_16) AT=1650.05n

.meas tran vdout0_17ck1640 FIND v(dout0_17) AT=1650.05n

.meas tran vdout0_18ck1640 FIND v(dout0_18) AT=1650.05n

.meas tran vdout0_19ck1640 FIND v(dout0_19) AT=1650.05n

.meas tran vdout0_20ck1640 FIND v(dout0_20) AT=1650.05n

.meas tran vdout0_21ck1640 FIND v(dout0_21) AT=1650.05n

.meas tran vdout0_22ck1640 FIND v(dout0_22) AT=1650.05n

.meas tran vdout0_23ck1640 FIND v(dout0_23) AT=1650.05n

.meas tran vdout0_24ck1640 FIND v(dout0_24) AT=1650.05n

.meas tran vdout0_25ck1640 FIND v(dout0_25) AT=1650.05n

.meas tran vdout0_26ck1640 FIND v(dout0_26) AT=1650.05n

.meas tran vdout0_27ck1640 FIND v(dout0_27) AT=1650.05n

.meas tran vdout0_28ck1640 FIND v(dout0_28) AT=1650.05n

.meas tran vdout0_29ck1640 FIND v(dout0_29) AT=1650.05n

.meas tran vdout0_30ck1640 FIND v(dout0_30) AT=1650.05n

.meas tran vdout0_31ck1640 FIND v(dout0_31) AT=1650.05n

.meas tran vdout0_32ck1640 FIND v(dout0_32) AT=1650.05n

.meas tran vdout0_0ck1650 FIND v(dout0_0) AT=1660.05n

.meas tran vdout0_1ck1650 FIND v(dout0_1) AT=1660.05n

.meas tran vdout0_2ck1650 FIND v(dout0_2) AT=1660.05n

.meas tran vdout0_3ck1650 FIND v(dout0_3) AT=1660.05n

.meas tran vdout0_4ck1650 FIND v(dout0_4) AT=1660.05n

.meas tran vdout0_5ck1650 FIND v(dout0_5) AT=1660.05n

.meas tran vdout0_6ck1650 FIND v(dout0_6) AT=1660.05n

.meas tran vdout0_7ck1650 FIND v(dout0_7) AT=1660.05n

.meas tran vdout0_8ck1650 FIND v(dout0_8) AT=1660.05n

.meas tran vdout0_9ck1650 FIND v(dout0_9) AT=1660.05n

.meas tran vdout0_10ck1650 FIND v(dout0_10) AT=1660.05n

.meas tran vdout0_11ck1650 FIND v(dout0_11) AT=1660.05n

.meas tran vdout0_12ck1650 FIND v(dout0_12) AT=1660.05n

.meas tran vdout0_13ck1650 FIND v(dout0_13) AT=1660.05n

.meas tran vdout0_14ck1650 FIND v(dout0_14) AT=1660.05n

.meas tran vdout0_15ck1650 FIND v(dout0_15) AT=1660.05n

.meas tran vdout0_16ck1650 FIND v(dout0_16) AT=1660.05n

.meas tran vdout0_17ck1650 FIND v(dout0_17) AT=1660.05n

.meas tran vdout0_18ck1650 FIND v(dout0_18) AT=1660.05n

.meas tran vdout0_19ck1650 FIND v(dout0_19) AT=1660.05n

.meas tran vdout0_20ck1650 FIND v(dout0_20) AT=1660.05n

.meas tran vdout0_21ck1650 FIND v(dout0_21) AT=1660.05n

.meas tran vdout0_22ck1650 FIND v(dout0_22) AT=1660.05n

.meas tran vdout0_23ck1650 FIND v(dout0_23) AT=1660.05n

.meas tran vdout0_24ck1650 FIND v(dout0_24) AT=1660.05n

.meas tran vdout0_25ck1650 FIND v(dout0_25) AT=1660.05n

.meas tran vdout0_26ck1650 FIND v(dout0_26) AT=1660.05n

.meas tran vdout0_27ck1650 FIND v(dout0_27) AT=1660.05n

.meas tran vdout0_28ck1650 FIND v(dout0_28) AT=1660.05n

.meas tran vdout0_29ck1650 FIND v(dout0_29) AT=1660.05n

.meas tran vdout0_30ck1650 FIND v(dout0_30) AT=1660.05n

.meas tran vdout0_31ck1650 FIND v(dout0_31) AT=1660.05n

.meas tran vdout0_32ck1650 FIND v(dout0_32) AT=1660.05n

.meas tran vdout0_0ck1720 FIND v(dout0_0) AT=1730.05n

.meas tran vdout0_1ck1720 FIND v(dout0_1) AT=1730.05n

.meas tran vdout0_2ck1720 FIND v(dout0_2) AT=1730.05n

.meas tran vdout0_3ck1720 FIND v(dout0_3) AT=1730.05n

.meas tran vdout0_4ck1720 FIND v(dout0_4) AT=1730.05n

.meas tran vdout0_5ck1720 FIND v(dout0_5) AT=1730.05n

.meas tran vdout0_6ck1720 FIND v(dout0_6) AT=1730.05n

.meas tran vdout0_7ck1720 FIND v(dout0_7) AT=1730.05n

.meas tran vdout0_8ck1720 FIND v(dout0_8) AT=1730.05n

.meas tran vdout0_9ck1720 FIND v(dout0_9) AT=1730.05n

.meas tran vdout0_10ck1720 FIND v(dout0_10) AT=1730.05n

.meas tran vdout0_11ck1720 FIND v(dout0_11) AT=1730.05n

.meas tran vdout0_12ck1720 FIND v(dout0_12) AT=1730.05n

.meas tran vdout0_13ck1720 FIND v(dout0_13) AT=1730.05n

.meas tran vdout0_14ck1720 FIND v(dout0_14) AT=1730.05n

.meas tran vdout0_15ck1720 FIND v(dout0_15) AT=1730.05n

.meas tran vdout0_16ck1720 FIND v(dout0_16) AT=1730.05n

.meas tran vdout0_17ck1720 FIND v(dout0_17) AT=1730.05n

.meas tran vdout0_18ck1720 FIND v(dout0_18) AT=1730.05n

.meas tran vdout0_19ck1720 FIND v(dout0_19) AT=1730.05n

.meas tran vdout0_20ck1720 FIND v(dout0_20) AT=1730.05n

.meas tran vdout0_21ck1720 FIND v(dout0_21) AT=1730.05n

.meas tran vdout0_22ck1720 FIND v(dout0_22) AT=1730.05n

.meas tran vdout0_23ck1720 FIND v(dout0_23) AT=1730.05n

.meas tran vdout0_24ck1720 FIND v(dout0_24) AT=1730.05n

.meas tran vdout0_25ck1720 FIND v(dout0_25) AT=1730.05n

.meas tran vdout0_26ck1720 FIND v(dout0_26) AT=1730.05n

.meas tran vdout0_27ck1720 FIND v(dout0_27) AT=1730.05n

.meas tran vdout0_28ck1720 FIND v(dout0_28) AT=1730.05n

.meas tran vdout0_29ck1720 FIND v(dout0_29) AT=1730.05n

.meas tran vdout0_30ck1720 FIND v(dout0_30) AT=1730.05n

.meas tran vdout0_31ck1720 FIND v(dout0_31) AT=1730.05n

.meas tran vdout0_32ck1720 FIND v(dout0_32) AT=1730.05n

.meas tran vdout0_0ck1730 FIND v(dout0_0) AT=1740.05n

.meas tran vdout0_1ck1730 FIND v(dout0_1) AT=1740.05n

.meas tran vdout0_2ck1730 FIND v(dout0_2) AT=1740.05n

.meas tran vdout0_3ck1730 FIND v(dout0_3) AT=1740.05n

.meas tran vdout0_4ck1730 FIND v(dout0_4) AT=1740.05n

.meas tran vdout0_5ck1730 FIND v(dout0_5) AT=1740.05n

.meas tran vdout0_6ck1730 FIND v(dout0_6) AT=1740.05n

.meas tran vdout0_7ck1730 FIND v(dout0_7) AT=1740.05n

.meas tran vdout0_8ck1730 FIND v(dout0_8) AT=1740.05n

.meas tran vdout0_9ck1730 FIND v(dout0_9) AT=1740.05n

.meas tran vdout0_10ck1730 FIND v(dout0_10) AT=1740.05n

.meas tran vdout0_11ck1730 FIND v(dout0_11) AT=1740.05n

.meas tran vdout0_12ck1730 FIND v(dout0_12) AT=1740.05n

.meas tran vdout0_13ck1730 FIND v(dout0_13) AT=1740.05n

.meas tran vdout0_14ck1730 FIND v(dout0_14) AT=1740.05n

.meas tran vdout0_15ck1730 FIND v(dout0_15) AT=1740.05n

.meas tran vdout0_16ck1730 FIND v(dout0_16) AT=1740.05n

.meas tran vdout0_17ck1730 FIND v(dout0_17) AT=1740.05n

.meas tran vdout0_18ck1730 FIND v(dout0_18) AT=1740.05n

.meas tran vdout0_19ck1730 FIND v(dout0_19) AT=1740.05n

.meas tran vdout0_20ck1730 FIND v(dout0_20) AT=1740.05n

.meas tran vdout0_21ck1730 FIND v(dout0_21) AT=1740.05n

.meas tran vdout0_22ck1730 FIND v(dout0_22) AT=1740.05n

.meas tran vdout0_23ck1730 FIND v(dout0_23) AT=1740.05n

.meas tran vdout0_24ck1730 FIND v(dout0_24) AT=1740.05n

.meas tran vdout0_25ck1730 FIND v(dout0_25) AT=1740.05n

.meas tran vdout0_26ck1730 FIND v(dout0_26) AT=1740.05n

.meas tran vdout0_27ck1730 FIND v(dout0_27) AT=1740.05n

.meas tran vdout0_28ck1730 FIND v(dout0_28) AT=1740.05n

.meas tran vdout0_29ck1730 FIND v(dout0_29) AT=1740.05n

.meas tran vdout0_30ck1730 FIND v(dout0_30) AT=1740.05n

.meas tran vdout0_31ck1730 FIND v(dout0_31) AT=1740.05n

.meas tran vdout0_32ck1730 FIND v(dout0_32) AT=1740.05n

.meas tran vdout0_0ck1770 FIND v(dout0_0) AT=1780.05n

.meas tran vdout0_1ck1770 FIND v(dout0_1) AT=1780.05n

.meas tran vdout0_2ck1770 FIND v(dout0_2) AT=1780.05n

.meas tran vdout0_3ck1770 FIND v(dout0_3) AT=1780.05n

.meas tran vdout0_4ck1770 FIND v(dout0_4) AT=1780.05n

.meas tran vdout0_5ck1770 FIND v(dout0_5) AT=1780.05n

.meas tran vdout0_6ck1770 FIND v(dout0_6) AT=1780.05n

.meas tran vdout0_7ck1770 FIND v(dout0_7) AT=1780.05n

.meas tran vdout0_8ck1770 FIND v(dout0_8) AT=1780.05n

.meas tran vdout0_9ck1770 FIND v(dout0_9) AT=1780.05n

.meas tran vdout0_10ck1770 FIND v(dout0_10) AT=1780.05n

.meas tran vdout0_11ck1770 FIND v(dout0_11) AT=1780.05n

.meas tran vdout0_12ck1770 FIND v(dout0_12) AT=1780.05n

.meas tran vdout0_13ck1770 FIND v(dout0_13) AT=1780.05n

.meas tran vdout0_14ck1770 FIND v(dout0_14) AT=1780.05n

.meas tran vdout0_15ck1770 FIND v(dout0_15) AT=1780.05n

.meas tran vdout0_16ck1770 FIND v(dout0_16) AT=1780.05n

.meas tran vdout0_17ck1770 FIND v(dout0_17) AT=1780.05n

.meas tran vdout0_18ck1770 FIND v(dout0_18) AT=1780.05n

.meas tran vdout0_19ck1770 FIND v(dout0_19) AT=1780.05n

.meas tran vdout0_20ck1770 FIND v(dout0_20) AT=1780.05n

.meas tran vdout0_21ck1770 FIND v(dout0_21) AT=1780.05n

.meas tran vdout0_22ck1770 FIND v(dout0_22) AT=1780.05n

.meas tran vdout0_23ck1770 FIND v(dout0_23) AT=1780.05n

.meas tran vdout0_24ck1770 FIND v(dout0_24) AT=1780.05n

.meas tran vdout0_25ck1770 FIND v(dout0_25) AT=1780.05n

.meas tran vdout0_26ck1770 FIND v(dout0_26) AT=1780.05n

.meas tran vdout0_27ck1770 FIND v(dout0_27) AT=1780.05n

.meas tran vdout0_28ck1770 FIND v(dout0_28) AT=1780.05n

.meas tran vdout0_29ck1770 FIND v(dout0_29) AT=1780.05n

.meas tran vdout0_30ck1770 FIND v(dout0_30) AT=1780.05n

.meas tran vdout0_31ck1770 FIND v(dout0_31) AT=1780.05n

.meas tran vdout0_32ck1770 FIND v(dout0_32) AT=1780.05n

.meas tran vdout0_0ck1790 FIND v(dout0_0) AT=1800.05n

.meas tran vdout0_1ck1790 FIND v(dout0_1) AT=1800.05n

.meas tran vdout0_2ck1790 FIND v(dout0_2) AT=1800.05n

.meas tran vdout0_3ck1790 FIND v(dout0_3) AT=1800.05n

.meas tran vdout0_4ck1790 FIND v(dout0_4) AT=1800.05n

.meas tran vdout0_5ck1790 FIND v(dout0_5) AT=1800.05n

.meas tran vdout0_6ck1790 FIND v(dout0_6) AT=1800.05n

.meas tran vdout0_7ck1790 FIND v(dout0_7) AT=1800.05n

.meas tran vdout0_8ck1790 FIND v(dout0_8) AT=1800.05n

.meas tran vdout0_9ck1790 FIND v(dout0_9) AT=1800.05n

.meas tran vdout0_10ck1790 FIND v(dout0_10) AT=1800.05n

.meas tran vdout0_11ck1790 FIND v(dout0_11) AT=1800.05n

.meas tran vdout0_12ck1790 FIND v(dout0_12) AT=1800.05n

.meas tran vdout0_13ck1790 FIND v(dout0_13) AT=1800.05n

.meas tran vdout0_14ck1790 FIND v(dout0_14) AT=1800.05n

.meas tran vdout0_15ck1790 FIND v(dout0_15) AT=1800.05n

.meas tran vdout0_16ck1790 FIND v(dout0_16) AT=1800.05n

.meas tran vdout0_17ck1790 FIND v(dout0_17) AT=1800.05n

.meas tran vdout0_18ck1790 FIND v(dout0_18) AT=1800.05n

.meas tran vdout0_19ck1790 FIND v(dout0_19) AT=1800.05n

.meas tran vdout0_20ck1790 FIND v(dout0_20) AT=1800.05n

.meas tran vdout0_21ck1790 FIND v(dout0_21) AT=1800.05n

.meas tran vdout0_22ck1790 FIND v(dout0_22) AT=1800.05n

.meas tran vdout0_23ck1790 FIND v(dout0_23) AT=1800.05n

.meas tran vdout0_24ck1790 FIND v(dout0_24) AT=1800.05n

.meas tran vdout0_25ck1790 FIND v(dout0_25) AT=1800.05n

.meas tran vdout0_26ck1790 FIND v(dout0_26) AT=1800.05n

.meas tran vdout0_27ck1790 FIND v(dout0_27) AT=1800.05n

.meas tran vdout0_28ck1790 FIND v(dout0_28) AT=1800.05n

.meas tran vdout0_29ck1790 FIND v(dout0_29) AT=1800.05n

.meas tran vdout0_30ck1790 FIND v(dout0_30) AT=1800.05n

.meas tran vdout0_31ck1790 FIND v(dout0_31) AT=1800.05n

.meas tran vdout0_32ck1790 FIND v(dout0_32) AT=1800.05n

.meas tran vdout0_0ck1800 FIND v(dout0_0) AT=1810.05n

.meas tran vdout0_1ck1800 FIND v(dout0_1) AT=1810.05n

.meas tran vdout0_2ck1800 FIND v(dout0_2) AT=1810.05n

.meas tran vdout0_3ck1800 FIND v(dout0_3) AT=1810.05n

.meas tran vdout0_4ck1800 FIND v(dout0_4) AT=1810.05n

.meas tran vdout0_5ck1800 FIND v(dout0_5) AT=1810.05n

.meas tran vdout0_6ck1800 FIND v(dout0_6) AT=1810.05n

.meas tran vdout0_7ck1800 FIND v(dout0_7) AT=1810.05n

.meas tran vdout0_8ck1800 FIND v(dout0_8) AT=1810.05n

.meas tran vdout0_9ck1800 FIND v(dout0_9) AT=1810.05n

.meas tran vdout0_10ck1800 FIND v(dout0_10) AT=1810.05n

.meas tran vdout0_11ck1800 FIND v(dout0_11) AT=1810.05n

.meas tran vdout0_12ck1800 FIND v(dout0_12) AT=1810.05n

.meas tran vdout0_13ck1800 FIND v(dout0_13) AT=1810.05n

.meas tran vdout0_14ck1800 FIND v(dout0_14) AT=1810.05n

.meas tran vdout0_15ck1800 FIND v(dout0_15) AT=1810.05n

.meas tran vdout0_16ck1800 FIND v(dout0_16) AT=1810.05n

.meas tran vdout0_17ck1800 FIND v(dout0_17) AT=1810.05n

.meas tran vdout0_18ck1800 FIND v(dout0_18) AT=1810.05n

.meas tran vdout0_19ck1800 FIND v(dout0_19) AT=1810.05n

.meas tran vdout0_20ck1800 FIND v(dout0_20) AT=1810.05n

.meas tran vdout0_21ck1800 FIND v(dout0_21) AT=1810.05n

.meas tran vdout0_22ck1800 FIND v(dout0_22) AT=1810.05n

.meas tran vdout0_23ck1800 FIND v(dout0_23) AT=1810.05n

.meas tran vdout0_24ck1800 FIND v(dout0_24) AT=1810.05n

.meas tran vdout0_25ck1800 FIND v(dout0_25) AT=1810.05n

.meas tran vdout0_26ck1800 FIND v(dout0_26) AT=1810.05n

.meas tran vdout0_27ck1800 FIND v(dout0_27) AT=1810.05n

.meas tran vdout0_28ck1800 FIND v(dout0_28) AT=1810.05n

.meas tran vdout0_29ck1800 FIND v(dout0_29) AT=1810.05n

.meas tran vdout0_30ck1800 FIND v(dout0_30) AT=1810.05n

.meas tran vdout0_31ck1800 FIND v(dout0_31) AT=1810.05n

.meas tran vdout0_32ck1800 FIND v(dout0_32) AT=1810.05n

.meas tran vdout0_0ck1820 FIND v(dout0_0) AT=1830.05n

.meas tran vdout0_1ck1820 FIND v(dout0_1) AT=1830.05n

.meas tran vdout0_2ck1820 FIND v(dout0_2) AT=1830.05n

.meas tran vdout0_3ck1820 FIND v(dout0_3) AT=1830.05n

.meas tran vdout0_4ck1820 FIND v(dout0_4) AT=1830.05n

.meas tran vdout0_5ck1820 FIND v(dout0_5) AT=1830.05n

.meas tran vdout0_6ck1820 FIND v(dout0_6) AT=1830.05n

.meas tran vdout0_7ck1820 FIND v(dout0_7) AT=1830.05n

.meas tran vdout0_8ck1820 FIND v(dout0_8) AT=1830.05n

.meas tran vdout0_9ck1820 FIND v(dout0_9) AT=1830.05n

.meas tran vdout0_10ck1820 FIND v(dout0_10) AT=1830.05n

.meas tran vdout0_11ck1820 FIND v(dout0_11) AT=1830.05n

.meas tran vdout0_12ck1820 FIND v(dout0_12) AT=1830.05n

.meas tran vdout0_13ck1820 FIND v(dout0_13) AT=1830.05n

.meas tran vdout0_14ck1820 FIND v(dout0_14) AT=1830.05n

.meas tran vdout0_15ck1820 FIND v(dout0_15) AT=1830.05n

.meas tran vdout0_16ck1820 FIND v(dout0_16) AT=1830.05n

.meas tran vdout0_17ck1820 FIND v(dout0_17) AT=1830.05n

.meas tran vdout0_18ck1820 FIND v(dout0_18) AT=1830.05n

.meas tran vdout0_19ck1820 FIND v(dout0_19) AT=1830.05n

.meas tran vdout0_20ck1820 FIND v(dout0_20) AT=1830.05n

.meas tran vdout0_21ck1820 FIND v(dout0_21) AT=1830.05n

.meas tran vdout0_22ck1820 FIND v(dout0_22) AT=1830.05n

.meas tran vdout0_23ck1820 FIND v(dout0_23) AT=1830.05n

.meas tran vdout0_24ck1820 FIND v(dout0_24) AT=1830.05n

.meas tran vdout0_25ck1820 FIND v(dout0_25) AT=1830.05n

.meas tran vdout0_26ck1820 FIND v(dout0_26) AT=1830.05n

.meas tran vdout0_27ck1820 FIND v(dout0_27) AT=1830.05n

.meas tran vdout0_28ck1820 FIND v(dout0_28) AT=1830.05n

.meas tran vdout0_29ck1820 FIND v(dout0_29) AT=1830.05n

.meas tran vdout0_30ck1820 FIND v(dout0_30) AT=1830.05n

.meas tran vdout0_31ck1820 FIND v(dout0_31) AT=1830.05n

.meas tran vdout0_32ck1820 FIND v(dout0_32) AT=1830.05n

.meas tran vdout0_0ck1850 FIND v(dout0_0) AT=1860.05n

.meas tran vdout0_1ck1850 FIND v(dout0_1) AT=1860.05n

.meas tran vdout0_2ck1850 FIND v(dout0_2) AT=1860.05n

.meas tran vdout0_3ck1850 FIND v(dout0_3) AT=1860.05n

.meas tran vdout0_4ck1850 FIND v(dout0_4) AT=1860.05n

.meas tran vdout0_5ck1850 FIND v(dout0_5) AT=1860.05n

.meas tran vdout0_6ck1850 FIND v(dout0_6) AT=1860.05n

.meas tran vdout0_7ck1850 FIND v(dout0_7) AT=1860.05n

.meas tran vdout0_8ck1850 FIND v(dout0_8) AT=1860.05n

.meas tran vdout0_9ck1850 FIND v(dout0_9) AT=1860.05n

.meas tran vdout0_10ck1850 FIND v(dout0_10) AT=1860.05n

.meas tran vdout0_11ck1850 FIND v(dout0_11) AT=1860.05n

.meas tran vdout0_12ck1850 FIND v(dout0_12) AT=1860.05n

.meas tran vdout0_13ck1850 FIND v(dout0_13) AT=1860.05n

.meas tran vdout0_14ck1850 FIND v(dout0_14) AT=1860.05n

.meas tran vdout0_15ck1850 FIND v(dout0_15) AT=1860.05n

.meas tran vdout0_16ck1850 FIND v(dout0_16) AT=1860.05n

.meas tran vdout0_17ck1850 FIND v(dout0_17) AT=1860.05n

.meas tran vdout0_18ck1850 FIND v(dout0_18) AT=1860.05n

.meas tran vdout0_19ck1850 FIND v(dout0_19) AT=1860.05n

.meas tran vdout0_20ck1850 FIND v(dout0_20) AT=1860.05n

.meas tran vdout0_21ck1850 FIND v(dout0_21) AT=1860.05n

.meas tran vdout0_22ck1850 FIND v(dout0_22) AT=1860.05n

.meas tran vdout0_23ck1850 FIND v(dout0_23) AT=1860.05n

.meas tran vdout0_24ck1850 FIND v(dout0_24) AT=1860.05n

.meas tran vdout0_25ck1850 FIND v(dout0_25) AT=1860.05n

.meas tran vdout0_26ck1850 FIND v(dout0_26) AT=1860.05n

.meas tran vdout0_27ck1850 FIND v(dout0_27) AT=1860.05n

.meas tran vdout0_28ck1850 FIND v(dout0_28) AT=1860.05n

.meas tran vdout0_29ck1850 FIND v(dout0_29) AT=1860.05n

.meas tran vdout0_30ck1850 FIND v(dout0_30) AT=1860.05n

.meas tran vdout0_31ck1850 FIND v(dout0_31) AT=1860.05n

.meas tran vdout0_32ck1850 FIND v(dout0_32) AT=1860.05n

.meas tran vdout0_0ck1860 FIND v(dout0_0) AT=1870.05n

.meas tran vdout0_1ck1860 FIND v(dout0_1) AT=1870.05n

.meas tran vdout0_2ck1860 FIND v(dout0_2) AT=1870.05n

.meas tran vdout0_3ck1860 FIND v(dout0_3) AT=1870.05n

.meas tran vdout0_4ck1860 FIND v(dout0_4) AT=1870.05n

.meas tran vdout0_5ck1860 FIND v(dout0_5) AT=1870.05n

.meas tran vdout0_6ck1860 FIND v(dout0_6) AT=1870.05n

.meas tran vdout0_7ck1860 FIND v(dout0_7) AT=1870.05n

.meas tran vdout0_8ck1860 FIND v(dout0_8) AT=1870.05n

.meas tran vdout0_9ck1860 FIND v(dout0_9) AT=1870.05n

.meas tran vdout0_10ck1860 FIND v(dout0_10) AT=1870.05n

.meas tran vdout0_11ck1860 FIND v(dout0_11) AT=1870.05n

.meas tran vdout0_12ck1860 FIND v(dout0_12) AT=1870.05n

.meas tran vdout0_13ck1860 FIND v(dout0_13) AT=1870.05n

.meas tran vdout0_14ck1860 FIND v(dout0_14) AT=1870.05n

.meas tran vdout0_15ck1860 FIND v(dout0_15) AT=1870.05n

.meas tran vdout0_16ck1860 FIND v(dout0_16) AT=1870.05n

.meas tran vdout0_17ck1860 FIND v(dout0_17) AT=1870.05n

.meas tran vdout0_18ck1860 FIND v(dout0_18) AT=1870.05n

.meas tran vdout0_19ck1860 FIND v(dout0_19) AT=1870.05n

.meas tran vdout0_20ck1860 FIND v(dout0_20) AT=1870.05n

.meas tran vdout0_21ck1860 FIND v(dout0_21) AT=1870.05n

.meas tran vdout0_22ck1860 FIND v(dout0_22) AT=1870.05n

.meas tran vdout0_23ck1860 FIND v(dout0_23) AT=1870.05n

.meas tran vdout0_24ck1860 FIND v(dout0_24) AT=1870.05n

.meas tran vdout0_25ck1860 FIND v(dout0_25) AT=1870.05n

.meas tran vdout0_26ck1860 FIND v(dout0_26) AT=1870.05n

.meas tran vdout0_27ck1860 FIND v(dout0_27) AT=1870.05n

.meas tran vdout0_28ck1860 FIND v(dout0_28) AT=1870.05n

.meas tran vdout0_29ck1860 FIND v(dout0_29) AT=1870.05n

.meas tran vdout0_30ck1860 FIND v(dout0_30) AT=1870.05n

.meas tran vdout0_31ck1860 FIND v(dout0_31) AT=1870.05n

.meas tran vdout0_32ck1860 FIND v(dout0_32) AT=1870.05n

.meas tran vdout0_0ck1880 FIND v(dout0_0) AT=1890.05n

.meas tran vdout0_1ck1880 FIND v(dout0_1) AT=1890.05n

.meas tran vdout0_2ck1880 FIND v(dout0_2) AT=1890.05n

.meas tran vdout0_3ck1880 FIND v(dout0_3) AT=1890.05n

.meas tran vdout0_4ck1880 FIND v(dout0_4) AT=1890.05n

.meas tran vdout0_5ck1880 FIND v(dout0_5) AT=1890.05n

.meas tran vdout0_6ck1880 FIND v(dout0_6) AT=1890.05n

.meas tran vdout0_7ck1880 FIND v(dout0_7) AT=1890.05n

.meas tran vdout0_8ck1880 FIND v(dout0_8) AT=1890.05n

.meas tran vdout0_9ck1880 FIND v(dout0_9) AT=1890.05n

.meas tran vdout0_10ck1880 FIND v(dout0_10) AT=1890.05n

.meas tran vdout0_11ck1880 FIND v(dout0_11) AT=1890.05n

.meas tran vdout0_12ck1880 FIND v(dout0_12) AT=1890.05n

.meas tran vdout0_13ck1880 FIND v(dout0_13) AT=1890.05n

.meas tran vdout0_14ck1880 FIND v(dout0_14) AT=1890.05n

.meas tran vdout0_15ck1880 FIND v(dout0_15) AT=1890.05n

.meas tran vdout0_16ck1880 FIND v(dout0_16) AT=1890.05n

.meas tran vdout0_17ck1880 FIND v(dout0_17) AT=1890.05n

.meas tran vdout0_18ck1880 FIND v(dout0_18) AT=1890.05n

.meas tran vdout0_19ck1880 FIND v(dout0_19) AT=1890.05n

.meas tran vdout0_20ck1880 FIND v(dout0_20) AT=1890.05n

.meas tran vdout0_21ck1880 FIND v(dout0_21) AT=1890.05n

.meas tran vdout0_22ck1880 FIND v(dout0_22) AT=1890.05n

.meas tran vdout0_23ck1880 FIND v(dout0_23) AT=1890.05n

.meas tran vdout0_24ck1880 FIND v(dout0_24) AT=1890.05n

.meas tran vdout0_25ck1880 FIND v(dout0_25) AT=1890.05n

.meas tran vdout0_26ck1880 FIND v(dout0_26) AT=1890.05n

.meas tran vdout0_27ck1880 FIND v(dout0_27) AT=1890.05n

.meas tran vdout0_28ck1880 FIND v(dout0_28) AT=1890.05n

.meas tran vdout0_29ck1880 FIND v(dout0_29) AT=1890.05n

.meas tran vdout0_30ck1880 FIND v(dout0_30) AT=1890.05n

.meas tran vdout0_31ck1880 FIND v(dout0_31) AT=1890.05n

.meas tran vdout0_32ck1880 FIND v(dout0_32) AT=1890.05n

.meas tran vdout0_0ck1900 FIND v(dout0_0) AT=1910.05n

.meas tran vdout0_1ck1900 FIND v(dout0_1) AT=1910.05n

.meas tran vdout0_2ck1900 FIND v(dout0_2) AT=1910.05n

.meas tran vdout0_3ck1900 FIND v(dout0_3) AT=1910.05n

.meas tran vdout0_4ck1900 FIND v(dout0_4) AT=1910.05n

.meas tran vdout0_5ck1900 FIND v(dout0_5) AT=1910.05n

.meas tran vdout0_6ck1900 FIND v(dout0_6) AT=1910.05n

.meas tran vdout0_7ck1900 FIND v(dout0_7) AT=1910.05n

.meas tran vdout0_8ck1900 FIND v(dout0_8) AT=1910.05n

.meas tran vdout0_9ck1900 FIND v(dout0_9) AT=1910.05n

.meas tran vdout0_10ck1900 FIND v(dout0_10) AT=1910.05n

.meas tran vdout0_11ck1900 FIND v(dout0_11) AT=1910.05n

.meas tran vdout0_12ck1900 FIND v(dout0_12) AT=1910.05n

.meas tran vdout0_13ck1900 FIND v(dout0_13) AT=1910.05n

.meas tran vdout0_14ck1900 FIND v(dout0_14) AT=1910.05n

.meas tran vdout0_15ck1900 FIND v(dout0_15) AT=1910.05n

.meas tran vdout0_16ck1900 FIND v(dout0_16) AT=1910.05n

.meas tran vdout0_17ck1900 FIND v(dout0_17) AT=1910.05n

.meas tran vdout0_18ck1900 FIND v(dout0_18) AT=1910.05n

.meas tran vdout0_19ck1900 FIND v(dout0_19) AT=1910.05n

.meas tran vdout0_20ck1900 FIND v(dout0_20) AT=1910.05n

.meas tran vdout0_21ck1900 FIND v(dout0_21) AT=1910.05n

.meas tran vdout0_22ck1900 FIND v(dout0_22) AT=1910.05n

.meas tran vdout0_23ck1900 FIND v(dout0_23) AT=1910.05n

.meas tran vdout0_24ck1900 FIND v(dout0_24) AT=1910.05n

.meas tran vdout0_25ck1900 FIND v(dout0_25) AT=1910.05n

.meas tran vdout0_26ck1900 FIND v(dout0_26) AT=1910.05n

.meas tran vdout0_27ck1900 FIND v(dout0_27) AT=1910.05n

.meas tran vdout0_28ck1900 FIND v(dout0_28) AT=1910.05n

.meas tran vdout0_29ck1900 FIND v(dout0_29) AT=1910.05n

.meas tran vdout0_30ck1900 FIND v(dout0_30) AT=1910.05n

.meas tran vdout0_31ck1900 FIND v(dout0_31) AT=1910.05n

.meas tran vdout0_32ck1900 FIND v(dout0_32) AT=1910.05n

.meas tran vdout0_0ck1950 FIND v(dout0_0) AT=1960.05n

.meas tran vdout0_1ck1950 FIND v(dout0_1) AT=1960.05n

.meas tran vdout0_2ck1950 FIND v(dout0_2) AT=1960.05n

.meas tran vdout0_3ck1950 FIND v(dout0_3) AT=1960.05n

.meas tran vdout0_4ck1950 FIND v(dout0_4) AT=1960.05n

.meas tran vdout0_5ck1950 FIND v(dout0_5) AT=1960.05n

.meas tran vdout0_6ck1950 FIND v(dout0_6) AT=1960.05n

.meas tran vdout0_7ck1950 FIND v(dout0_7) AT=1960.05n

.meas tran vdout0_8ck1950 FIND v(dout0_8) AT=1960.05n

.meas tran vdout0_9ck1950 FIND v(dout0_9) AT=1960.05n

.meas tran vdout0_10ck1950 FIND v(dout0_10) AT=1960.05n

.meas tran vdout0_11ck1950 FIND v(dout0_11) AT=1960.05n

.meas tran vdout0_12ck1950 FIND v(dout0_12) AT=1960.05n

.meas tran vdout0_13ck1950 FIND v(dout0_13) AT=1960.05n

.meas tran vdout0_14ck1950 FIND v(dout0_14) AT=1960.05n

.meas tran vdout0_15ck1950 FIND v(dout0_15) AT=1960.05n

.meas tran vdout0_16ck1950 FIND v(dout0_16) AT=1960.05n

.meas tran vdout0_17ck1950 FIND v(dout0_17) AT=1960.05n

.meas tran vdout0_18ck1950 FIND v(dout0_18) AT=1960.05n

.meas tran vdout0_19ck1950 FIND v(dout0_19) AT=1960.05n

.meas tran vdout0_20ck1950 FIND v(dout0_20) AT=1960.05n

.meas tran vdout0_21ck1950 FIND v(dout0_21) AT=1960.05n

.meas tran vdout0_22ck1950 FIND v(dout0_22) AT=1960.05n

.meas tran vdout0_23ck1950 FIND v(dout0_23) AT=1960.05n

.meas tran vdout0_24ck1950 FIND v(dout0_24) AT=1960.05n

.meas tran vdout0_25ck1950 FIND v(dout0_25) AT=1960.05n

.meas tran vdout0_26ck1950 FIND v(dout0_26) AT=1960.05n

.meas tran vdout0_27ck1950 FIND v(dout0_27) AT=1960.05n

.meas tran vdout0_28ck1950 FIND v(dout0_28) AT=1960.05n

.meas tran vdout0_29ck1950 FIND v(dout0_29) AT=1960.05n

.meas tran vdout0_30ck1950 FIND v(dout0_30) AT=1960.05n

.meas tran vdout0_31ck1950 FIND v(dout0_31) AT=1960.05n

.meas tran vdout0_32ck1950 FIND v(dout0_32) AT=1960.05n

.meas tran vdout0_0ck1960 FIND v(dout0_0) AT=1970.05n

.meas tran vdout0_1ck1960 FIND v(dout0_1) AT=1970.05n

.meas tran vdout0_2ck1960 FIND v(dout0_2) AT=1970.05n

.meas tran vdout0_3ck1960 FIND v(dout0_3) AT=1970.05n

.meas tran vdout0_4ck1960 FIND v(dout0_4) AT=1970.05n

.meas tran vdout0_5ck1960 FIND v(dout0_5) AT=1970.05n

.meas tran vdout0_6ck1960 FIND v(dout0_6) AT=1970.05n

.meas tran vdout0_7ck1960 FIND v(dout0_7) AT=1970.05n

.meas tran vdout0_8ck1960 FIND v(dout0_8) AT=1970.05n

.meas tran vdout0_9ck1960 FIND v(dout0_9) AT=1970.05n

.meas tran vdout0_10ck1960 FIND v(dout0_10) AT=1970.05n

.meas tran vdout0_11ck1960 FIND v(dout0_11) AT=1970.05n

.meas tran vdout0_12ck1960 FIND v(dout0_12) AT=1970.05n

.meas tran vdout0_13ck1960 FIND v(dout0_13) AT=1970.05n

.meas tran vdout0_14ck1960 FIND v(dout0_14) AT=1970.05n

.meas tran vdout0_15ck1960 FIND v(dout0_15) AT=1970.05n

.meas tran vdout0_16ck1960 FIND v(dout0_16) AT=1970.05n

.meas tran vdout0_17ck1960 FIND v(dout0_17) AT=1970.05n

.meas tran vdout0_18ck1960 FIND v(dout0_18) AT=1970.05n

.meas tran vdout0_19ck1960 FIND v(dout0_19) AT=1970.05n

.meas tran vdout0_20ck1960 FIND v(dout0_20) AT=1970.05n

.meas tran vdout0_21ck1960 FIND v(dout0_21) AT=1970.05n

.meas tran vdout0_22ck1960 FIND v(dout0_22) AT=1970.05n

.meas tran vdout0_23ck1960 FIND v(dout0_23) AT=1970.05n

.meas tran vdout0_24ck1960 FIND v(dout0_24) AT=1970.05n

.meas tran vdout0_25ck1960 FIND v(dout0_25) AT=1970.05n

.meas tran vdout0_26ck1960 FIND v(dout0_26) AT=1970.05n

.meas tran vdout0_27ck1960 FIND v(dout0_27) AT=1970.05n

.meas tran vdout0_28ck1960 FIND v(dout0_28) AT=1970.05n

.meas tran vdout0_29ck1960 FIND v(dout0_29) AT=1970.05n

.meas tran vdout0_30ck1960 FIND v(dout0_30) AT=1970.05n

.meas tran vdout0_31ck1960 FIND v(dout0_31) AT=1970.05n

.meas tran vdout0_32ck1960 FIND v(dout0_32) AT=1970.05n

.meas tran vdout0_0ck1970 FIND v(dout0_0) AT=1980.05n

.meas tran vdout0_1ck1970 FIND v(dout0_1) AT=1980.05n

.meas tran vdout0_2ck1970 FIND v(dout0_2) AT=1980.05n

.meas tran vdout0_3ck1970 FIND v(dout0_3) AT=1980.05n

.meas tran vdout0_4ck1970 FIND v(dout0_4) AT=1980.05n

.meas tran vdout0_5ck1970 FIND v(dout0_5) AT=1980.05n

.meas tran vdout0_6ck1970 FIND v(dout0_6) AT=1980.05n

.meas tran vdout0_7ck1970 FIND v(dout0_7) AT=1980.05n

.meas tran vdout0_8ck1970 FIND v(dout0_8) AT=1980.05n

.meas tran vdout0_9ck1970 FIND v(dout0_9) AT=1980.05n

.meas tran vdout0_10ck1970 FIND v(dout0_10) AT=1980.05n

.meas tran vdout0_11ck1970 FIND v(dout0_11) AT=1980.05n

.meas tran vdout0_12ck1970 FIND v(dout0_12) AT=1980.05n

.meas tran vdout0_13ck1970 FIND v(dout0_13) AT=1980.05n

.meas tran vdout0_14ck1970 FIND v(dout0_14) AT=1980.05n

.meas tran vdout0_15ck1970 FIND v(dout0_15) AT=1980.05n

.meas tran vdout0_16ck1970 FIND v(dout0_16) AT=1980.05n

.meas tran vdout0_17ck1970 FIND v(dout0_17) AT=1980.05n

.meas tran vdout0_18ck1970 FIND v(dout0_18) AT=1980.05n

.meas tran vdout0_19ck1970 FIND v(dout0_19) AT=1980.05n

.meas tran vdout0_20ck1970 FIND v(dout0_20) AT=1980.05n

.meas tran vdout0_21ck1970 FIND v(dout0_21) AT=1980.05n

.meas tran vdout0_22ck1970 FIND v(dout0_22) AT=1980.05n

.meas tran vdout0_23ck1970 FIND v(dout0_23) AT=1980.05n

.meas tran vdout0_24ck1970 FIND v(dout0_24) AT=1980.05n

.meas tran vdout0_25ck1970 FIND v(dout0_25) AT=1980.05n

.meas tran vdout0_26ck1970 FIND v(dout0_26) AT=1980.05n

.meas tran vdout0_27ck1970 FIND v(dout0_27) AT=1980.05n

.meas tran vdout0_28ck1970 FIND v(dout0_28) AT=1980.05n

.meas tran vdout0_29ck1970 FIND v(dout0_29) AT=1980.05n

.meas tran vdout0_30ck1970 FIND v(dout0_30) AT=1980.05n

.meas tran vdout0_31ck1970 FIND v(dout0_31) AT=1980.05n

.meas tran vdout0_32ck1970 FIND v(dout0_32) AT=1980.05n

.meas tran vdout0_0ck1990 FIND v(dout0_0) AT=2000.05n

.meas tran vdout0_1ck1990 FIND v(dout0_1) AT=2000.05n

.meas tran vdout0_2ck1990 FIND v(dout0_2) AT=2000.05n

.meas tran vdout0_3ck1990 FIND v(dout0_3) AT=2000.05n

.meas tran vdout0_4ck1990 FIND v(dout0_4) AT=2000.05n

.meas tran vdout0_5ck1990 FIND v(dout0_5) AT=2000.05n

.meas tran vdout0_6ck1990 FIND v(dout0_6) AT=2000.05n

.meas tran vdout0_7ck1990 FIND v(dout0_7) AT=2000.05n

.meas tran vdout0_8ck1990 FIND v(dout0_8) AT=2000.05n

.meas tran vdout0_9ck1990 FIND v(dout0_9) AT=2000.05n

.meas tran vdout0_10ck1990 FIND v(dout0_10) AT=2000.05n

.meas tran vdout0_11ck1990 FIND v(dout0_11) AT=2000.05n

.meas tran vdout0_12ck1990 FIND v(dout0_12) AT=2000.05n

.meas tran vdout0_13ck1990 FIND v(dout0_13) AT=2000.05n

.meas tran vdout0_14ck1990 FIND v(dout0_14) AT=2000.05n

.meas tran vdout0_15ck1990 FIND v(dout0_15) AT=2000.05n

.meas tran vdout0_16ck1990 FIND v(dout0_16) AT=2000.05n

.meas tran vdout0_17ck1990 FIND v(dout0_17) AT=2000.05n

.meas tran vdout0_18ck1990 FIND v(dout0_18) AT=2000.05n

.meas tran vdout0_19ck1990 FIND v(dout0_19) AT=2000.05n

.meas tran vdout0_20ck1990 FIND v(dout0_20) AT=2000.05n

.meas tran vdout0_21ck1990 FIND v(dout0_21) AT=2000.05n

.meas tran vdout0_22ck1990 FIND v(dout0_22) AT=2000.05n

.meas tran vdout0_23ck1990 FIND v(dout0_23) AT=2000.05n

.meas tran vdout0_24ck1990 FIND v(dout0_24) AT=2000.05n

.meas tran vdout0_25ck1990 FIND v(dout0_25) AT=2000.05n

.meas tran vdout0_26ck1990 FIND v(dout0_26) AT=2000.05n

.meas tran vdout0_27ck1990 FIND v(dout0_27) AT=2000.05n

.meas tran vdout0_28ck1990 FIND v(dout0_28) AT=2000.05n

.meas tran vdout0_29ck1990 FIND v(dout0_29) AT=2000.05n

.meas tran vdout0_30ck1990 FIND v(dout0_30) AT=2000.05n

.meas tran vdout0_31ck1990 FIND v(dout0_31) AT=2000.05n

.meas tran vdout0_32ck1990 FIND v(dout0_32) AT=2000.05n

.meas tran vdout0_0ck2010 FIND v(dout0_0) AT=2020.05n

.meas tran vdout0_1ck2010 FIND v(dout0_1) AT=2020.05n

.meas tran vdout0_2ck2010 FIND v(dout0_2) AT=2020.05n

.meas tran vdout0_3ck2010 FIND v(dout0_3) AT=2020.05n

.meas tran vdout0_4ck2010 FIND v(dout0_4) AT=2020.05n

.meas tran vdout0_5ck2010 FIND v(dout0_5) AT=2020.05n

.meas tran vdout0_6ck2010 FIND v(dout0_6) AT=2020.05n

.meas tran vdout0_7ck2010 FIND v(dout0_7) AT=2020.05n

.meas tran vdout0_8ck2010 FIND v(dout0_8) AT=2020.05n

.meas tran vdout0_9ck2010 FIND v(dout0_9) AT=2020.05n

.meas tran vdout0_10ck2010 FIND v(dout0_10) AT=2020.05n

.meas tran vdout0_11ck2010 FIND v(dout0_11) AT=2020.05n

.meas tran vdout0_12ck2010 FIND v(dout0_12) AT=2020.05n

.meas tran vdout0_13ck2010 FIND v(dout0_13) AT=2020.05n

.meas tran vdout0_14ck2010 FIND v(dout0_14) AT=2020.05n

.meas tran vdout0_15ck2010 FIND v(dout0_15) AT=2020.05n

.meas tran vdout0_16ck2010 FIND v(dout0_16) AT=2020.05n

.meas tran vdout0_17ck2010 FIND v(dout0_17) AT=2020.05n

.meas tran vdout0_18ck2010 FIND v(dout0_18) AT=2020.05n

.meas tran vdout0_19ck2010 FIND v(dout0_19) AT=2020.05n

.meas tran vdout0_20ck2010 FIND v(dout0_20) AT=2020.05n

.meas tran vdout0_21ck2010 FIND v(dout0_21) AT=2020.05n

.meas tran vdout0_22ck2010 FIND v(dout0_22) AT=2020.05n

.meas tran vdout0_23ck2010 FIND v(dout0_23) AT=2020.05n

.meas tran vdout0_24ck2010 FIND v(dout0_24) AT=2020.05n

.meas tran vdout0_25ck2010 FIND v(dout0_25) AT=2020.05n

.meas tran vdout0_26ck2010 FIND v(dout0_26) AT=2020.05n

.meas tran vdout0_27ck2010 FIND v(dout0_27) AT=2020.05n

.meas tran vdout0_28ck2010 FIND v(dout0_28) AT=2020.05n

.meas tran vdout0_29ck2010 FIND v(dout0_29) AT=2020.05n

.meas tran vdout0_30ck2010 FIND v(dout0_30) AT=2020.05n

.meas tran vdout0_31ck2010 FIND v(dout0_31) AT=2020.05n

.meas tran vdout0_32ck2010 FIND v(dout0_32) AT=2020.05n

.meas tran vdout0_0ck2030 FIND v(dout0_0) AT=2040.05n

.meas tran vdout0_1ck2030 FIND v(dout0_1) AT=2040.05n

.meas tran vdout0_2ck2030 FIND v(dout0_2) AT=2040.05n

.meas tran vdout0_3ck2030 FIND v(dout0_3) AT=2040.05n

.meas tran vdout0_4ck2030 FIND v(dout0_4) AT=2040.05n

.meas tran vdout0_5ck2030 FIND v(dout0_5) AT=2040.05n

.meas tran vdout0_6ck2030 FIND v(dout0_6) AT=2040.05n

.meas tran vdout0_7ck2030 FIND v(dout0_7) AT=2040.05n

.meas tran vdout0_8ck2030 FIND v(dout0_8) AT=2040.05n

.meas tran vdout0_9ck2030 FIND v(dout0_9) AT=2040.05n

.meas tran vdout0_10ck2030 FIND v(dout0_10) AT=2040.05n

.meas tran vdout0_11ck2030 FIND v(dout0_11) AT=2040.05n

.meas tran vdout0_12ck2030 FIND v(dout0_12) AT=2040.05n

.meas tran vdout0_13ck2030 FIND v(dout0_13) AT=2040.05n

.meas tran vdout0_14ck2030 FIND v(dout0_14) AT=2040.05n

.meas tran vdout0_15ck2030 FIND v(dout0_15) AT=2040.05n

.meas tran vdout0_16ck2030 FIND v(dout0_16) AT=2040.05n

.meas tran vdout0_17ck2030 FIND v(dout0_17) AT=2040.05n

.meas tran vdout0_18ck2030 FIND v(dout0_18) AT=2040.05n

.meas tran vdout0_19ck2030 FIND v(dout0_19) AT=2040.05n

.meas tran vdout0_20ck2030 FIND v(dout0_20) AT=2040.05n

.meas tran vdout0_21ck2030 FIND v(dout0_21) AT=2040.05n

.meas tran vdout0_22ck2030 FIND v(dout0_22) AT=2040.05n

.meas tran vdout0_23ck2030 FIND v(dout0_23) AT=2040.05n

.meas tran vdout0_24ck2030 FIND v(dout0_24) AT=2040.05n

.meas tran vdout0_25ck2030 FIND v(dout0_25) AT=2040.05n

.meas tran vdout0_26ck2030 FIND v(dout0_26) AT=2040.05n

.meas tran vdout0_27ck2030 FIND v(dout0_27) AT=2040.05n

.meas tran vdout0_28ck2030 FIND v(dout0_28) AT=2040.05n

.meas tran vdout0_29ck2030 FIND v(dout0_29) AT=2040.05n

.meas tran vdout0_30ck2030 FIND v(dout0_30) AT=2040.05n

.meas tran vdout0_31ck2030 FIND v(dout0_31) AT=2040.05n

.meas tran vdout0_32ck2030 FIND v(dout0_32) AT=2040.05n

.meas tran vdout0_0ck2040 FIND v(dout0_0) AT=2050.05n

.meas tran vdout0_1ck2040 FIND v(dout0_1) AT=2050.05n

.meas tran vdout0_2ck2040 FIND v(dout0_2) AT=2050.05n

.meas tran vdout0_3ck2040 FIND v(dout0_3) AT=2050.05n

.meas tran vdout0_4ck2040 FIND v(dout0_4) AT=2050.05n

.meas tran vdout0_5ck2040 FIND v(dout0_5) AT=2050.05n

.meas tran vdout0_6ck2040 FIND v(dout0_6) AT=2050.05n

.meas tran vdout0_7ck2040 FIND v(dout0_7) AT=2050.05n

.meas tran vdout0_8ck2040 FIND v(dout0_8) AT=2050.05n

.meas tran vdout0_9ck2040 FIND v(dout0_9) AT=2050.05n

.meas tran vdout0_10ck2040 FIND v(dout0_10) AT=2050.05n

.meas tran vdout0_11ck2040 FIND v(dout0_11) AT=2050.05n

.meas tran vdout0_12ck2040 FIND v(dout0_12) AT=2050.05n

.meas tran vdout0_13ck2040 FIND v(dout0_13) AT=2050.05n

.meas tran vdout0_14ck2040 FIND v(dout0_14) AT=2050.05n

.meas tran vdout0_15ck2040 FIND v(dout0_15) AT=2050.05n

.meas tran vdout0_16ck2040 FIND v(dout0_16) AT=2050.05n

.meas tran vdout0_17ck2040 FIND v(dout0_17) AT=2050.05n

.meas tran vdout0_18ck2040 FIND v(dout0_18) AT=2050.05n

.meas tran vdout0_19ck2040 FIND v(dout0_19) AT=2050.05n

.meas tran vdout0_20ck2040 FIND v(dout0_20) AT=2050.05n

.meas tran vdout0_21ck2040 FIND v(dout0_21) AT=2050.05n

.meas tran vdout0_22ck2040 FIND v(dout0_22) AT=2050.05n

.meas tran vdout0_23ck2040 FIND v(dout0_23) AT=2050.05n

.meas tran vdout0_24ck2040 FIND v(dout0_24) AT=2050.05n

.meas tran vdout0_25ck2040 FIND v(dout0_25) AT=2050.05n

.meas tran vdout0_26ck2040 FIND v(dout0_26) AT=2050.05n

.meas tran vdout0_27ck2040 FIND v(dout0_27) AT=2050.05n

.meas tran vdout0_28ck2040 FIND v(dout0_28) AT=2050.05n

.meas tran vdout0_29ck2040 FIND v(dout0_29) AT=2050.05n

.meas tran vdout0_30ck2040 FIND v(dout0_30) AT=2050.05n

.meas tran vdout0_31ck2040 FIND v(dout0_31) AT=2050.05n

.meas tran vdout0_32ck2040 FIND v(dout0_32) AT=2050.05n
