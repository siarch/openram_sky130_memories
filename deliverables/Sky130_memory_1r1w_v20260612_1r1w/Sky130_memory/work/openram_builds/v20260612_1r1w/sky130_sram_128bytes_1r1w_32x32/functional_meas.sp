.meas tran vdout1_0ck40 FIND v(dout1_0) AT=50.05n

.meas tran vdout1_1ck40 FIND v(dout1_1) AT=50.05n

.meas tran vdout1_2ck40 FIND v(dout1_2) AT=50.05n

.meas tran vdout1_3ck40 FIND v(dout1_3) AT=50.05n

.meas tran vdout1_4ck40 FIND v(dout1_4) AT=50.05n

.meas tran vdout1_5ck40 FIND v(dout1_5) AT=50.05n

.meas tran vdout1_6ck40 FIND v(dout1_6) AT=50.05n

.meas tran vdout1_7ck40 FIND v(dout1_7) AT=50.05n

.meas tran vdout1_8ck40 FIND v(dout1_8) AT=50.05n

.meas tran vdout1_9ck40 FIND v(dout1_9) AT=50.05n

.meas tran vdout1_10ck40 FIND v(dout1_10) AT=50.05n

.meas tran vdout1_11ck40 FIND v(dout1_11) AT=50.05n

.meas tran vdout1_12ck40 FIND v(dout1_12) AT=50.05n

.meas tran vdout1_13ck40 FIND v(dout1_13) AT=50.05n

.meas tran vdout1_14ck40 FIND v(dout1_14) AT=50.05n

.meas tran vdout1_15ck40 FIND v(dout1_15) AT=50.05n

.meas tran vdout1_16ck40 FIND v(dout1_16) AT=50.05n

.meas tran vdout1_17ck40 FIND v(dout1_17) AT=50.05n

.meas tran vdout1_18ck40 FIND v(dout1_18) AT=50.05n

.meas tran vdout1_19ck40 FIND v(dout1_19) AT=50.05n

.meas tran vdout1_20ck40 FIND v(dout1_20) AT=50.05n

.meas tran vdout1_21ck40 FIND v(dout1_21) AT=50.05n

.meas tran vdout1_22ck40 FIND v(dout1_22) AT=50.05n

.meas tran vdout1_23ck40 FIND v(dout1_23) AT=50.05n

.meas tran vdout1_24ck40 FIND v(dout1_24) AT=50.05n

.meas tran vdout1_25ck40 FIND v(dout1_25) AT=50.05n

.meas tran vdout1_26ck40 FIND v(dout1_26) AT=50.05n

.meas tran vdout1_27ck40 FIND v(dout1_27) AT=50.05n

.meas tran vdout1_28ck40 FIND v(dout1_28) AT=50.05n

.meas tran vdout1_29ck40 FIND v(dout1_29) AT=50.05n

.meas tran vdout1_30ck40 FIND v(dout1_30) AT=50.05n

.meas tran vdout1_31ck40 FIND v(dout1_31) AT=50.05n

.meas tran vdout1_32ck40 FIND v(dout1_32) AT=50.05n

.meas tran vdout1_0ck60 FIND v(dout1_0) AT=70.05n

.meas tran vdout1_1ck60 FIND v(dout1_1) AT=70.05n

.meas tran vdout1_2ck60 FIND v(dout1_2) AT=70.05n

.meas tran vdout1_3ck60 FIND v(dout1_3) AT=70.05n

.meas tran vdout1_4ck60 FIND v(dout1_4) AT=70.05n

.meas tran vdout1_5ck60 FIND v(dout1_5) AT=70.05n

.meas tran vdout1_6ck60 FIND v(dout1_6) AT=70.05n

.meas tran vdout1_7ck60 FIND v(dout1_7) AT=70.05n

.meas tran vdout1_8ck60 FIND v(dout1_8) AT=70.05n

.meas tran vdout1_9ck60 FIND v(dout1_9) AT=70.05n

.meas tran vdout1_10ck60 FIND v(dout1_10) AT=70.05n

.meas tran vdout1_11ck60 FIND v(dout1_11) AT=70.05n

.meas tran vdout1_12ck60 FIND v(dout1_12) AT=70.05n

.meas tran vdout1_13ck60 FIND v(dout1_13) AT=70.05n

.meas tran vdout1_14ck60 FIND v(dout1_14) AT=70.05n

.meas tran vdout1_15ck60 FIND v(dout1_15) AT=70.05n

.meas tran vdout1_16ck60 FIND v(dout1_16) AT=70.05n

.meas tran vdout1_17ck60 FIND v(dout1_17) AT=70.05n

.meas tran vdout1_18ck60 FIND v(dout1_18) AT=70.05n

.meas tran vdout1_19ck60 FIND v(dout1_19) AT=70.05n

.meas tran vdout1_20ck60 FIND v(dout1_20) AT=70.05n

.meas tran vdout1_21ck60 FIND v(dout1_21) AT=70.05n

.meas tran vdout1_22ck60 FIND v(dout1_22) AT=70.05n

.meas tran vdout1_23ck60 FIND v(dout1_23) AT=70.05n

.meas tran vdout1_24ck60 FIND v(dout1_24) AT=70.05n

.meas tran vdout1_25ck60 FIND v(dout1_25) AT=70.05n

.meas tran vdout1_26ck60 FIND v(dout1_26) AT=70.05n

.meas tran vdout1_27ck60 FIND v(dout1_27) AT=70.05n

.meas tran vdout1_28ck60 FIND v(dout1_28) AT=70.05n

.meas tran vdout1_29ck60 FIND v(dout1_29) AT=70.05n

.meas tran vdout1_30ck60 FIND v(dout1_30) AT=70.05n

.meas tran vdout1_31ck60 FIND v(dout1_31) AT=70.05n

.meas tran vdout1_32ck60 FIND v(dout1_32) AT=70.05n

.meas tran vdout1_0ck70 FIND v(dout1_0) AT=80.05n

.meas tran vdout1_1ck70 FIND v(dout1_1) AT=80.05n

.meas tran vdout1_2ck70 FIND v(dout1_2) AT=80.05n

.meas tran vdout1_3ck70 FIND v(dout1_3) AT=80.05n

.meas tran vdout1_4ck70 FIND v(dout1_4) AT=80.05n

.meas tran vdout1_5ck70 FIND v(dout1_5) AT=80.05n

.meas tran vdout1_6ck70 FIND v(dout1_6) AT=80.05n

.meas tran vdout1_7ck70 FIND v(dout1_7) AT=80.05n

.meas tran vdout1_8ck70 FIND v(dout1_8) AT=80.05n

.meas tran vdout1_9ck70 FIND v(dout1_9) AT=80.05n

.meas tran vdout1_10ck70 FIND v(dout1_10) AT=80.05n

.meas tran vdout1_11ck70 FIND v(dout1_11) AT=80.05n

.meas tran vdout1_12ck70 FIND v(dout1_12) AT=80.05n

.meas tran vdout1_13ck70 FIND v(dout1_13) AT=80.05n

.meas tran vdout1_14ck70 FIND v(dout1_14) AT=80.05n

.meas tran vdout1_15ck70 FIND v(dout1_15) AT=80.05n

.meas tran vdout1_16ck70 FIND v(dout1_16) AT=80.05n

.meas tran vdout1_17ck70 FIND v(dout1_17) AT=80.05n

.meas tran vdout1_18ck70 FIND v(dout1_18) AT=80.05n

.meas tran vdout1_19ck70 FIND v(dout1_19) AT=80.05n

.meas tran vdout1_20ck70 FIND v(dout1_20) AT=80.05n

.meas tran vdout1_21ck70 FIND v(dout1_21) AT=80.05n

.meas tran vdout1_22ck70 FIND v(dout1_22) AT=80.05n

.meas tran vdout1_23ck70 FIND v(dout1_23) AT=80.05n

.meas tran vdout1_24ck70 FIND v(dout1_24) AT=80.05n

.meas tran vdout1_25ck70 FIND v(dout1_25) AT=80.05n

.meas tran vdout1_26ck70 FIND v(dout1_26) AT=80.05n

.meas tran vdout1_27ck70 FIND v(dout1_27) AT=80.05n

.meas tran vdout1_28ck70 FIND v(dout1_28) AT=80.05n

.meas tran vdout1_29ck70 FIND v(dout1_29) AT=80.05n

.meas tran vdout1_30ck70 FIND v(dout1_30) AT=80.05n

.meas tran vdout1_31ck70 FIND v(dout1_31) AT=80.05n

.meas tran vdout1_32ck70 FIND v(dout1_32) AT=80.05n

.meas tran vdout1_0ck90 FIND v(dout1_0) AT=100.05n

.meas tran vdout1_1ck90 FIND v(dout1_1) AT=100.05n

.meas tran vdout1_2ck90 FIND v(dout1_2) AT=100.05n

.meas tran vdout1_3ck90 FIND v(dout1_3) AT=100.05n

.meas tran vdout1_4ck90 FIND v(dout1_4) AT=100.05n

.meas tran vdout1_5ck90 FIND v(dout1_5) AT=100.05n

.meas tran vdout1_6ck90 FIND v(dout1_6) AT=100.05n

.meas tran vdout1_7ck90 FIND v(dout1_7) AT=100.05n

.meas tran vdout1_8ck90 FIND v(dout1_8) AT=100.05n

.meas tran vdout1_9ck90 FIND v(dout1_9) AT=100.05n

.meas tran vdout1_10ck90 FIND v(dout1_10) AT=100.05n

.meas tran vdout1_11ck90 FIND v(dout1_11) AT=100.05n

.meas tran vdout1_12ck90 FIND v(dout1_12) AT=100.05n

.meas tran vdout1_13ck90 FIND v(dout1_13) AT=100.05n

.meas tran vdout1_14ck90 FIND v(dout1_14) AT=100.05n

.meas tran vdout1_15ck90 FIND v(dout1_15) AT=100.05n

.meas tran vdout1_16ck90 FIND v(dout1_16) AT=100.05n

.meas tran vdout1_17ck90 FIND v(dout1_17) AT=100.05n

.meas tran vdout1_18ck90 FIND v(dout1_18) AT=100.05n

.meas tran vdout1_19ck90 FIND v(dout1_19) AT=100.05n

.meas tran vdout1_20ck90 FIND v(dout1_20) AT=100.05n

.meas tran vdout1_21ck90 FIND v(dout1_21) AT=100.05n

.meas tran vdout1_22ck90 FIND v(dout1_22) AT=100.05n

.meas tran vdout1_23ck90 FIND v(dout1_23) AT=100.05n

.meas tran vdout1_24ck90 FIND v(dout1_24) AT=100.05n

.meas tran vdout1_25ck90 FIND v(dout1_25) AT=100.05n

.meas tran vdout1_26ck90 FIND v(dout1_26) AT=100.05n

.meas tran vdout1_27ck90 FIND v(dout1_27) AT=100.05n

.meas tran vdout1_28ck90 FIND v(dout1_28) AT=100.05n

.meas tran vdout1_29ck90 FIND v(dout1_29) AT=100.05n

.meas tran vdout1_30ck90 FIND v(dout1_30) AT=100.05n

.meas tran vdout1_31ck90 FIND v(dout1_31) AT=100.05n

.meas tran vdout1_32ck90 FIND v(dout1_32) AT=100.05n

.meas tran vdout1_0ck100 FIND v(dout1_0) AT=110.05n

.meas tran vdout1_1ck100 FIND v(dout1_1) AT=110.05n

.meas tran vdout1_2ck100 FIND v(dout1_2) AT=110.05n

.meas tran vdout1_3ck100 FIND v(dout1_3) AT=110.05n

.meas tran vdout1_4ck100 FIND v(dout1_4) AT=110.05n

.meas tran vdout1_5ck100 FIND v(dout1_5) AT=110.05n

.meas tran vdout1_6ck100 FIND v(dout1_6) AT=110.05n

.meas tran vdout1_7ck100 FIND v(dout1_7) AT=110.05n

.meas tran vdout1_8ck100 FIND v(dout1_8) AT=110.05n

.meas tran vdout1_9ck100 FIND v(dout1_9) AT=110.05n

.meas tran vdout1_10ck100 FIND v(dout1_10) AT=110.05n

.meas tran vdout1_11ck100 FIND v(dout1_11) AT=110.05n

.meas tran vdout1_12ck100 FIND v(dout1_12) AT=110.05n

.meas tran vdout1_13ck100 FIND v(dout1_13) AT=110.05n

.meas tran vdout1_14ck100 FIND v(dout1_14) AT=110.05n

.meas tran vdout1_15ck100 FIND v(dout1_15) AT=110.05n

.meas tran vdout1_16ck100 FIND v(dout1_16) AT=110.05n

.meas tran vdout1_17ck100 FIND v(dout1_17) AT=110.05n

.meas tran vdout1_18ck100 FIND v(dout1_18) AT=110.05n

.meas tran vdout1_19ck100 FIND v(dout1_19) AT=110.05n

.meas tran vdout1_20ck100 FIND v(dout1_20) AT=110.05n

.meas tran vdout1_21ck100 FIND v(dout1_21) AT=110.05n

.meas tran vdout1_22ck100 FIND v(dout1_22) AT=110.05n

.meas tran vdout1_23ck100 FIND v(dout1_23) AT=110.05n

.meas tran vdout1_24ck100 FIND v(dout1_24) AT=110.05n

.meas tran vdout1_25ck100 FIND v(dout1_25) AT=110.05n

.meas tran vdout1_26ck100 FIND v(dout1_26) AT=110.05n

.meas tran vdout1_27ck100 FIND v(dout1_27) AT=110.05n

.meas tran vdout1_28ck100 FIND v(dout1_28) AT=110.05n

.meas tran vdout1_29ck100 FIND v(dout1_29) AT=110.05n

.meas tran vdout1_30ck100 FIND v(dout1_30) AT=110.05n

.meas tran vdout1_31ck100 FIND v(dout1_31) AT=110.05n

.meas tran vdout1_32ck100 FIND v(dout1_32) AT=110.05n

.meas tran vdout1_0ck110 FIND v(dout1_0) AT=120.05n

.meas tran vdout1_1ck110 FIND v(dout1_1) AT=120.05n

.meas tran vdout1_2ck110 FIND v(dout1_2) AT=120.05n

.meas tran vdout1_3ck110 FIND v(dout1_3) AT=120.05n

.meas tran vdout1_4ck110 FIND v(dout1_4) AT=120.05n

.meas tran vdout1_5ck110 FIND v(dout1_5) AT=120.05n

.meas tran vdout1_6ck110 FIND v(dout1_6) AT=120.05n

.meas tran vdout1_7ck110 FIND v(dout1_7) AT=120.05n

.meas tran vdout1_8ck110 FIND v(dout1_8) AT=120.05n

.meas tran vdout1_9ck110 FIND v(dout1_9) AT=120.05n

.meas tran vdout1_10ck110 FIND v(dout1_10) AT=120.05n

.meas tran vdout1_11ck110 FIND v(dout1_11) AT=120.05n

.meas tran vdout1_12ck110 FIND v(dout1_12) AT=120.05n

.meas tran vdout1_13ck110 FIND v(dout1_13) AT=120.05n

.meas tran vdout1_14ck110 FIND v(dout1_14) AT=120.05n

.meas tran vdout1_15ck110 FIND v(dout1_15) AT=120.05n

.meas tran vdout1_16ck110 FIND v(dout1_16) AT=120.05n

.meas tran vdout1_17ck110 FIND v(dout1_17) AT=120.05n

.meas tran vdout1_18ck110 FIND v(dout1_18) AT=120.05n

.meas tran vdout1_19ck110 FIND v(dout1_19) AT=120.05n

.meas tran vdout1_20ck110 FIND v(dout1_20) AT=120.05n

.meas tran vdout1_21ck110 FIND v(dout1_21) AT=120.05n

.meas tran vdout1_22ck110 FIND v(dout1_22) AT=120.05n

.meas tran vdout1_23ck110 FIND v(dout1_23) AT=120.05n

.meas tran vdout1_24ck110 FIND v(dout1_24) AT=120.05n

.meas tran vdout1_25ck110 FIND v(dout1_25) AT=120.05n

.meas tran vdout1_26ck110 FIND v(dout1_26) AT=120.05n

.meas tran vdout1_27ck110 FIND v(dout1_27) AT=120.05n

.meas tran vdout1_28ck110 FIND v(dout1_28) AT=120.05n

.meas tran vdout1_29ck110 FIND v(dout1_29) AT=120.05n

.meas tran vdout1_30ck110 FIND v(dout1_30) AT=120.05n

.meas tran vdout1_31ck110 FIND v(dout1_31) AT=120.05n

.meas tran vdout1_32ck110 FIND v(dout1_32) AT=120.05n

.meas tran vdout1_0ck130 FIND v(dout1_0) AT=140.05n

.meas tran vdout1_1ck130 FIND v(dout1_1) AT=140.05n

.meas tran vdout1_2ck130 FIND v(dout1_2) AT=140.05n

.meas tran vdout1_3ck130 FIND v(dout1_3) AT=140.05n

.meas tran vdout1_4ck130 FIND v(dout1_4) AT=140.05n

.meas tran vdout1_5ck130 FIND v(dout1_5) AT=140.05n

.meas tran vdout1_6ck130 FIND v(dout1_6) AT=140.05n

.meas tran vdout1_7ck130 FIND v(dout1_7) AT=140.05n

.meas tran vdout1_8ck130 FIND v(dout1_8) AT=140.05n

.meas tran vdout1_9ck130 FIND v(dout1_9) AT=140.05n

.meas tran vdout1_10ck130 FIND v(dout1_10) AT=140.05n

.meas tran vdout1_11ck130 FIND v(dout1_11) AT=140.05n

.meas tran vdout1_12ck130 FIND v(dout1_12) AT=140.05n

.meas tran vdout1_13ck130 FIND v(dout1_13) AT=140.05n

.meas tran vdout1_14ck130 FIND v(dout1_14) AT=140.05n

.meas tran vdout1_15ck130 FIND v(dout1_15) AT=140.05n

.meas tran vdout1_16ck130 FIND v(dout1_16) AT=140.05n

.meas tran vdout1_17ck130 FIND v(dout1_17) AT=140.05n

.meas tran vdout1_18ck130 FIND v(dout1_18) AT=140.05n

.meas tran vdout1_19ck130 FIND v(dout1_19) AT=140.05n

.meas tran vdout1_20ck130 FIND v(dout1_20) AT=140.05n

.meas tran vdout1_21ck130 FIND v(dout1_21) AT=140.05n

.meas tran vdout1_22ck130 FIND v(dout1_22) AT=140.05n

.meas tran vdout1_23ck130 FIND v(dout1_23) AT=140.05n

.meas tran vdout1_24ck130 FIND v(dout1_24) AT=140.05n

.meas tran vdout1_25ck130 FIND v(dout1_25) AT=140.05n

.meas tran vdout1_26ck130 FIND v(dout1_26) AT=140.05n

.meas tran vdout1_27ck130 FIND v(dout1_27) AT=140.05n

.meas tran vdout1_28ck130 FIND v(dout1_28) AT=140.05n

.meas tran vdout1_29ck130 FIND v(dout1_29) AT=140.05n

.meas tran vdout1_30ck130 FIND v(dout1_30) AT=140.05n

.meas tran vdout1_31ck130 FIND v(dout1_31) AT=140.05n

.meas tran vdout1_32ck130 FIND v(dout1_32) AT=140.05n

.meas tran vdout1_0ck150 FIND v(dout1_0) AT=160.05n

.meas tran vdout1_1ck150 FIND v(dout1_1) AT=160.05n

.meas tran vdout1_2ck150 FIND v(dout1_2) AT=160.05n

.meas tran vdout1_3ck150 FIND v(dout1_3) AT=160.05n

.meas tran vdout1_4ck150 FIND v(dout1_4) AT=160.05n

.meas tran vdout1_5ck150 FIND v(dout1_5) AT=160.05n

.meas tran vdout1_6ck150 FIND v(dout1_6) AT=160.05n

.meas tran vdout1_7ck150 FIND v(dout1_7) AT=160.05n

.meas tran vdout1_8ck150 FIND v(dout1_8) AT=160.05n

.meas tran vdout1_9ck150 FIND v(dout1_9) AT=160.05n

.meas tran vdout1_10ck150 FIND v(dout1_10) AT=160.05n

.meas tran vdout1_11ck150 FIND v(dout1_11) AT=160.05n

.meas tran vdout1_12ck150 FIND v(dout1_12) AT=160.05n

.meas tran vdout1_13ck150 FIND v(dout1_13) AT=160.05n

.meas tran vdout1_14ck150 FIND v(dout1_14) AT=160.05n

.meas tran vdout1_15ck150 FIND v(dout1_15) AT=160.05n

.meas tran vdout1_16ck150 FIND v(dout1_16) AT=160.05n

.meas tran vdout1_17ck150 FIND v(dout1_17) AT=160.05n

.meas tran vdout1_18ck150 FIND v(dout1_18) AT=160.05n

.meas tran vdout1_19ck150 FIND v(dout1_19) AT=160.05n

.meas tran vdout1_20ck150 FIND v(dout1_20) AT=160.05n

.meas tran vdout1_21ck150 FIND v(dout1_21) AT=160.05n

.meas tran vdout1_22ck150 FIND v(dout1_22) AT=160.05n

.meas tran vdout1_23ck150 FIND v(dout1_23) AT=160.05n

.meas tran vdout1_24ck150 FIND v(dout1_24) AT=160.05n

.meas tran vdout1_25ck150 FIND v(dout1_25) AT=160.05n

.meas tran vdout1_26ck150 FIND v(dout1_26) AT=160.05n

.meas tran vdout1_27ck150 FIND v(dout1_27) AT=160.05n

.meas tran vdout1_28ck150 FIND v(dout1_28) AT=160.05n

.meas tran vdout1_29ck150 FIND v(dout1_29) AT=160.05n

.meas tran vdout1_30ck150 FIND v(dout1_30) AT=160.05n

.meas tran vdout1_31ck150 FIND v(dout1_31) AT=160.05n

.meas tran vdout1_32ck150 FIND v(dout1_32) AT=160.05n

.meas tran vdout1_0ck170 FIND v(dout1_0) AT=180.05n

.meas tran vdout1_1ck170 FIND v(dout1_1) AT=180.05n

.meas tran vdout1_2ck170 FIND v(dout1_2) AT=180.05n

.meas tran vdout1_3ck170 FIND v(dout1_3) AT=180.05n

.meas tran vdout1_4ck170 FIND v(dout1_4) AT=180.05n

.meas tran vdout1_5ck170 FIND v(dout1_5) AT=180.05n

.meas tran vdout1_6ck170 FIND v(dout1_6) AT=180.05n

.meas tran vdout1_7ck170 FIND v(dout1_7) AT=180.05n

.meas tran vdout1_8ck170 FIND v(dout1_8) AT=180.05n

.meas tran vdout1_9ck170 FIND v(dout1_9) AT=180.05n

.meas tran vdout1_10ck170 FIND v(dout1_10) AT=180.05n

.meas tran vdout1_11ck170 FIND v(dout1_11) AT=180.05n

.meas tran vdout1_12ck170 FIND v(dout1_12) AT=180.05n

.meas tran vdout1_13ck170 FIND v(dout1_13) AT=180.05n

.meas tran vdout1_14ck170 FIND v(dout1_14) AT=180.05n

.meas tran vdout1_15ck170 FIND v(dout1_15) AT=180.05n

.meas tran vdout1_16ck170 FIND v(dout1_16) AT=180.05n

.meas tran vdout1_17ck170 FIND v(dout1_17) AT=180.05n

.meas tran vdout1_18ck170 FIND v(dout1_18) AT=180.05n

.meas tran vdout1_19ck170 FIND v(dout1_19) AT=180.05n

.meas tran vdout1_20ck170 FIND v(dout1_20) AT=180.05n

.meas tran vdout1_21ck170 FIND v(dout1_21) AT=180.05n

.meas tran vdout1_22ck170 FIND v(dout1_22) AT=180.05n

.meas tran vdout1_23ck170 FIND v(dout1_23) AT=180.05n

.meas tran vdout1_24ck170 FIND v(dout1_24) AT=180.05n

.meas tran vdout1_25ck170 FIND v(dout1_25) AT=180.05n

.meas tran vdout1_26ck170 FIND v(dout1_26) AT=180.05n

.meas tran vdout1_27ck170 FIND v(dout1_27) AT=180.05n

.meas tran vdout1_28ck170 FIND v(dout1_28) AT=180.05n

.meas tran vdout1_29ck170 FIND v(dout1_29) AT=180.05n

.meas tran vdout1_30ck170 FIND v(dout1_30) AT=180.05n

.meas tran vdout1_31ck170 FIND v(dout1_31) AT=180.05n

.meas tran vdout1_32ck170 FIND v(dout1_32) AT=180.05n

.meas tran vdout1_0ck200 FIND v(dout1_0) AT=210.05n

.meas tran vdout1_1ck200 FIND v(dout1_1) AT=210.05n

.meas tran vdout1_2ck200 FIND v(dout1_2) AT=210.05n

.meas tran vdout1_3ck200 FIND v(dout1_3) AT=210.05n

.meas tran vdout1_4ck200 FIND v(dout1_4) AT=210.05n

.meas tran vdout1_5ck200 FIND v(dout1_5) AT=210.05n

.meas tran vdout1_6ck200 FIND v(dout1_6) AT=210.05n

.meas tran vdout1_7ck200 FIND v(dout1_7) AT=210.05n

.meas tran vdout1_8ck200 FIND v(dout1_8) AT=210.05n

.meas tran vdout1_9ck200 FIND v(dout1_9) AT=210.05n

.meas tran vdout1_10ck200 FIND v(dout1_10) AT=210.05n

.meas tran vdout1_11ck200 FIND v(dout1_11) AT=210.05n

.meas tran vdout1_12ck200 FIND v(dout1_12) AT=210.05n

.meas tran vdout1_13ck200 FIND v(dout1_13) AT=210.05n

.meas tran vdout1_14ck200 FIND v(dout1_14) AT=210.05n

.meas tran vdout1_15ck200 FIND v(dout1_15) AT=210.05n

.meas tran vdout1_16ck200 FIND v(dout1_16) AT=210.05n

.meas tran vdout1_17ck200 FIND v(dout1_17) AT=210.05n

.meas tran vdout1_18ck200 FIND v(dout1_18) AT=210.05n

.meas tran vdout1_19ck200 FIND v(dout1_19) AT=210.05n

.meas tran vdout1_20ck200 FIND v(dout1_20) AT=210.05n

.meas tran vdout1_21ck200 FIND v(dout1_21) AT=210.05n

.meas tran vdout1_22ck200 FIND v(dout1_22) AT=210.05n

.meas tran vdout1_23ck200 FIND v(dout1_23) AT=210.05n

.meas tran vdout1_24ck200 FIND v(dout1_24) AT=210.05n

.meas tran vdout1_25ck200 FIND v(dout1_25) AT=210.05n

.meas tran vdout1_26ck200 FIND v(dout1_26) AT=210.05n

.meas tran vdout1_27ck200 FIND v(dout1_27) AT=210.05n

.meas tran vdout1_28ck200 FIND v(dout1_28) AT=210.05n

.meas tran vdout1_29ck200 FIND v(dout1_29) AT=210.05n

.meas tran vdout1_30ck200 FIND v(dout1_30) AT=210.05n

.meas tran vdout1_31ck200 FIND v(dout1_31) AT=210.05n

.meas tran vdout1_32ck200 FIND v(dout1_32) AT=210.05n

.meas tran vdout1_0ck240 FIND v(dout1_0) AT=250.05n

.meas tran vdout1_1ck240 FIND v(dout1_1) AT=250.05n

.meas tran vdout1_2ck240 FIND v(dout1_2) AT=250.05n

.meas tran vdout1_3ck240 FIND v(dout1_3) AT=250.05n

.meas tran vdout1_4ck240 FIND v(dout1_4) AT=250.05n

.meas tran vdout1_5ck240 FIND v(dout1_5) AT=250.05n

.meas tran vdout1_6ck240 FIND v(dout1_6) AT=250.05n

.meas tran vdout1_7ck240 FIND v(dout1_7) AT=250.05n

.meas tran vdout1_8ck240 FIND v(dout1_8) AT=250.05n

.meas tran vdout1_9ck240 FIND v(dout1_9) AT=250.05n

.meas tran vdout1_10ck240 FIND v(dout1_10) AT=250.05n

.meas tran vdout1_11ck240 FIND v(dout1_11) AT=250.05n

.meas tran vdout1_12ck240 FIND v(dout1_12) AT=250.05n

.meas tran vdout1_13ck240 FIND v(dout1_13) AT=250.05n

.meas tran vdout1_14ck240 FIND v(dout1_14) AT=250.05n

.meas tran vdout1_15ck240 FIND v(dout1_15) AT=250.05n

.meas tran vdout1_16ck240 FIND v(dout1_16) AT=250.05n

.meas tran vdout1_17ck240 FIND v(dout1_17) AT=250.05n

.meas tran vdout1_18ck240 FIND v(dout1_18) AT=250.05n

.meas tran vdout1_19ck240 FIND v(dout1_19) AT=250.05n

.meas tran vdout1_20ck240 FIND v(dout1_20) AT=250.05n

.meas tran vdout1_21ck240 FIND v(dout1_21) AT=250.05n

.meas tran vdout1_22ck240 FIND v(dout1_22) AT=250.05n

.meas tran vdout1_23ck240 FIND v(dout1_23) AT=250.05n

.meas tran vdout1_24ck240 FIND v(dout1_24) AT=250.05n

.meas tran vdout1_25ck240 FIND v(dout1_25) AT=250.05n

.meas tran vdout1_26ck240 FIND v(dout1_26) AT=250.05n

.meas tran vdout1_27ck240 FIND v(dout1_27) AT=250.05n

.meas tran vdout1_28ck240 FIND v(dout1_28) AT=250.05n

.meas tran vdout1_29ck240 FIND v(dout1_29) AT=250.05n

.meas tran vdout1_30ck240 FIND v(dout1_30) AT=250.05n

.meas tran vdout1_31ck240 FIND v(dout1_31) AT=250.05n

.meas tran vdout1_32ck240 FIND v(dout1_32) AT=250.05n

.meas tran vdout1_0ck260 FIND v(dout1_0) AT=270.05n

.meas tran vdout1_1ck260 FIND v(dout1_1) AT=270.05n

.meas tran vdout1_2ck260 FIND v(dout1_2) AT=270.05n

.meas tran vdout1_3ck260 FIND v(dout1_3) AT=270.05n

.meas tran vdout1_4ck260 FIND v(dout1_4) AT=270.05n

.meas tran vdout1_5ck260 FIND v(dout1_5) AT=270.05n

.meas tran vdout1_6ck260 FIND v(dout1_6) AT=270.05n

.meas tran vdout1_7ck260 FIND v(dout1_7) AT=270.05n

.meas tran vdout1_8ck260 FIND v(dout1_8) AT=270.05n

.meas tran vdout1_9ck260 FIND v(dout1_9) AT=270.05n

.meas tran vdout1_10ck260 FIND v(dout1_10) AT=270.05n

.meas tran vdout1_11ck260 FIND v(dout1_11) AT=270.05n

.meas tran vdout1_12ck260 FIND v(dout1_12) AT=270.05n

.meas tran vdout1_13ck260 FIND v(dout1_13) AT=270.05n

.meas tran vdout1_14ck260 FIND v(dout1_14) AT=270.05n

.meas tran vdout1_15ck260 FIND v(dout1_15) AT=270.05n

.meas tran vdout1_16ck260 FIND v(dout1_16) AT=270.05n

.meas tran vdout1_17ck260 FIND v(dout1_17) AT=270.05n

.meas tran vdout1_18ck260 FIND v(dout1_18) AT=270.05n

.meas tran vdout1_19ck260 FIND v(dout1_19) AT=270.05n

.meas tran vdout1_20ck260 FIND v(dout1_20) AT=270.05n

.meas tran vdout1_21ck260 FIND v(dout1_21) AT=270.05n

.meas tran vdout1_22ck260 FIND v(dout1_22) AT=270.05n

.meas tran vdout1_23ck260 FIND v(dout1_23) AT=270.05n

.meas tran vdout1_24ck260 FIND v(dout1_24) AT=270.05n

.meas tran vdout1_25ck260 FIND v(dout1_25) AT=270.05n

.meas tran vdout1_26ck260 FIND v(dout1_26) AT=270.05n

.meas tran vdout1_27ck260 FIND v(dout1_27) AT=270.05n

.meas tran vdout1_28ck260 FIND v(dout1_28) AT=270.05n

.meas tran vdout1_29ck260 FIND v(dout1_29) AT=270.05n

.meas tran vdout1_30ck260 FIND v(dout1_30) AT=270.05n

.meas tran vdout1_31ck260 FIND v(dout1_31) AT=270.05n

.meas tran vdout1_32ck260 FIND v(dout1_32) AT=270.05n

.meas tran vdout1_0ck280 FIND v(dout1_0) AT=290.05n

.meas tran vdout1_1ck280 FIND v(dout1_1) AT=290.05n

.meas tran vdout1_2ck280 FIND v(dout1_2) AT=290.05n

.meas tran vdout1_3ck280 FIND v(dout1_3) AT=290.05n

.meas tran vdout1_4ck280 FIND v(dout1_4) AT=290.05n

.meas tran vdout1_5ck280 FIND v(dout1_5) AT=290.05n

.meas tran vdout1_6ck280 FIND v(dout1_6) AT=290.05n

.meas tran vdout1_7ck280 FIND v(dout1_7) AT=290.05n

.meas tran vdout1_8ck280 FIND v(dout1_8) AT=290.05n

.meas tran vdout1_9ck280 FIND v(dout1_9) AT=290.05n

.meas tran vdout1_10ck280 FIND v(dout1_10) AT=290.05n

.meas tran vdout1_11ck280 FIND v(dout1_11) AT=290.05n

.meas tran vdout1_12ck280 FIND v(dout1_12) AT=290.05n

.meas tran vdout1_13ck280 FIND v(dout1_13) AT=290.05n

.meas tran vdout1_14ck280 FIND v(dout1_14) AT=290.05n

.meas tran vdout1_15ck280 FIND v(dout1_15) AT=290.05n

.meas tran vdout1_16ck280 FIND v(dout1_16) AT=290.05n

.meas tran vdout1_17ck280 FIND v(dout1_17) AT=290.05n

.meas tran vdout1_18ck280 FIND v(dout1_18) AT=290.05n

.meas tran vdout1_19ck280 FIND v(dout1_19) AT=290.05n

.meas tran vdout1_20ck280 FIND v(dout1_20) AT=290.05n

.meas tran vdout1_21ck280 FIND v(dout1_21) AT=290.05n

.meas tran vdout1_22ck280 FIND v(dout1_22) AT=290.05n

.meas tran vdout1_23ck280 FIND v(dout1_23) AT=290.05n

.meas tran vdout1_24ck280 FIND v(dout1_24) AT=290.05n

.meas tran vdout1_25ck280 FIND v(dout1_25) AT=290.05n

.meas tran vdout1_26ck280 FIND v(dout1_26) AT=290.05n

.meas tran vdout1_27ck280 FIND v(dout1_27) AT=290.05n

.meas tran vdout1_28ck280 FIND v(dout1_28) AT=290.05n

.meas tran vdout1_29ck280 FIND v(dout1_29) AT=290.05n

.meas tran vdout1_30ck280 FIND v(dout1_30) AT=290.05n

.meas tran vdout1_31ck280 FIND v(dout1_31) AT=290.05n

.meas tran vdout1_32ck280 FIND v(dout1_32) AT=290.05n

.meas tran vdout1_0ck320 FIND v(dout1_0) AT=330.05n

.meas tran vdout1_1ck320 FIND v(dout1_1) AT=330.05n

.meas tran vdout1_2ck320 FIND v(dout1_2) AT=330.05n

.meas tran vdout1_3ck320 FIND v(dout1_3) AT=330.05n

.meas tran vdout1_4ck320 FIND v(dout1_4) AT=330.05n

.meas tran vdout1_5ck320 FIND v(dout1_5) AT=330.05n

.meas tran vdout1_6ck320 FIND v(dout1_6) AT=330.05n

.meas tran vdout1_7ck320 FIND v(dout1_7) AT=330.05n

.meas tran vdout1_8ck320 FIND v(dout1_8) AT=330.05n

.meas tran vdout1_9ck320 FIND v(dout1_9) AT=330.05n

.meas tran vdout1_10ck320 FIND v(dout1_10) AT=330.05n

.meas tran vdout1_11ck320 FIND v(dout1_11) AT=330.05n

.meas tran vdout1_12ck320 FIND v(dout1_12) AT=330.05n

.meas tran vdout1_13ck320 FIND v(dout1_13) AT=330.05n

.meas tran vdout1_14ck320 FIND v(dout1_14) AT=330.05n

.meas tran vdout1_15ck320 FIND v(dout1_15) AT=330.05n

.meas tran vdout1_16ck320 FIND v(dout1_16) AT=330.05n

.meas tran vdout1_17ck320 FIND v(dout1_17) AT=330.05n

.meas tran vdout1_18ck320 FIND v(dout1_18) AT=330.05n

.meas tran vdout1_19ck320 FIND v(dout1_19) AT=330.05n

.meas tran vdout1_20ck320 FIND v(dout1_20) AT=330.05n

.meas tran vdout1_21ck320 FIND v(dout1_21) AT=330.05n

.meas tran vdout1_22ck320 FIND v(dout1_22) AT=330.05n

.meas tran vdout1_23ck320 FIND v(dout1_23) AT=330.05n

.meas tran vdout1_24ck320 FIND v(dout1_24) AT=330.05n

.meas tran vdout1_25ck320 FIND v(dout1_25) AT=330.05n

.meas tran vdout1_26ck320 FIND v(dout1_26) AT=330.05n

.meas tran vdout1_27ck320 FIND v(dout1_27) AT=330.05n

.meas tran vdout1_28ck320 FIND v(dout1_28) AT=330.05n

.meas tran vdout1_29ck320 FIND v(dout1_29) AT=330.05n

.meas tran vdout1_30ck320 FIND v(dout1_30) AT=330.05n

.meas tran vdout1_31ck320 FIND v(dout1_31) AT=330.05n

.meas tran vdout1_32ck320 FIND v(dout1_32) AT=330.05n

.meas tran vdout1_0ck340 FIND v(dout1_0) AT=350.05n

.meas tran vdout1_1ck340 FIND v(dout1_1) AT=350.05n

.meas tran vdout1_2ck340 FIND v(dout1_2) AT=350.05n

.meas tran vdout1_3ck340 FIND v(dout1_3) AT=350.05n

.meas tran vdout1_4ck340 FIND v(dout1_4) AT=350.05n

.meas tran vdout1_5ck340 FIND v(dout1_5) AT=350.05n

.meas tran vdout1_6ck340 FIND v(dout1_6) AT=350.05n

.meas tran vdout1_7ck340 FIND v(dout1_7) AT=350.05n

.meas tran vdout1_8ck340 FIND v(dout1_8) AT=350.05n

.meas tran vdout1_9ck340 FIND v(dout1_9) AT=350.05n

.meas tran vdout1_10ck340 FIND v(dout1_10) AT=350.05n

.meas tran vdout1_11ck340 FIND v(dout1_11) AT=350.05n

.meas tran vdout1_12ck340 FIND v(dout1_12) AT=350.05n

.meas tran vdout1_13ck340 FIND v(dout1_13) AT=350.05n

.meas tran vdout1_14ck340 FIND v(dout1_14) AT=350.05n

.meas tran vdout1_15ck340 FIND v(dout1_15) AT=350.05n

.meas tran vdout1_16ck340 FIND v(dout1_16) AT=350.05n

.meas tran vdout1_17ck340 FIND v(dout1_17) AT=350.05n

.meas tran vdout1_18ck340 FIND v(dout1_18) AT=350.05n

.meas tran vdout1_19ck340 FIND v(dout1_19) AT=350.05n

.meas tran vdout1_20ck340 FIND v(dout1_20) AT=350.05n

.meas tran vdout1_21ck340 FIND v(dout1_21) AT=350.05n

.meas tran vdout1_22ck340 FIND v(dout1_22) AT=350.05n

.meas tran vdout1_23ck340 FIND v(dout1_23) AT=350.05n

.meas tran vdout1_24ck340 FIND v(dout1_24) AT=350.05n

.meas tran vdout1_25ck340 FIND v(dout1_25) AT=350.05n

.meas tran vdout1_26ck340 FIND v(dout1_26) AT=350.05n

.meas tran vdout1_27ck340 FIND v(dout1_27) AT=350.05n

.meas tran vdout1_28ck340 FIND v(dout1_28) AT=350.05n

.meas tran vdout1_29ck340 FIND v(dout1_29) AT=350.05n

.meas tran vdout1_30ck340 FIND v(dout1_30) AT=350.05n

.meas tran vdout1_31ck340 FIND v(dout1_31) AT=350.05n

.meas tran vdout1_32ck340 FIND v(dout1_32) AT=350.05n

.meas tran vdout1_0ck370 FIND v(dout1_0) AT=380.05n

.meas tran vdout1_1ck370 FIND v(dout1_1) AT=380.05n

.meas tran vdout1_2ck370 FIND v(dout1_2) AT=380.05n

.meas tran vdout1_3ck370 FIND v(dout1_3) AT=380.05n

.meas tran vdout1_4ck370 FIND v(dout1_4) AT=380.05n

.meas tran vdout1_5ck370 FIND v(dout1_5) AT=380.05n

.meas tran vdout1_6ck370 FIND v(dout1_6) AT=380.05n

.meas tran vdout1_7ck370 FIND v(dout1_7) AT=380.05n

.meas tran vdout1_8ck370 FIND v(dout1_8) AT=380.05n

.meas tran vdout1_9ck370 FIND v(dout1_9) AT=380.05n

.meas tran vdout1_10ck370 FIND v(dout1_10) AT=380.05n

.meas tran vdout1_11ck370 FIND v(dout1_11) AT=380.05n

.meas tran vdout1_12ck370 FIND v(dout1_12) AT=380.05n

.meas tran vdout1_13ck370 FIND v(dout1_13) AT=380.05n

.meas tran vdout1_14ck370 FIND v(dout1_14) AT=380.05n

.meas tran vdout1_15ck370 FIND v(dout1_15) AT=380.05n

.meas tran vdout1_16ck370 FIND v(dout1_16) AT=380.05n

.meas tran vdout1_17ck370 FIND v(dout1_17) AT=380.05n

.meas tran vdout1_18ck370 FIND v(dout1_18) AT=380.05n

.meas tran vdout1_19ck370 FIND v(dout1_19) AT=380.05n

.meas tran vdout1_20ck370 FIND v(dout1_20) AT=380.05n

.meas tran vdout1_21ck370 FIND v(dout1_21) AT=380.05n

.meas tran vdout1_22ck370 FIND v(dout1_22) AT=380.05n

.meas tran vdout1_23ck370 FIND v(dout1_23) AT=380.05n

.meas tran vdout1_24ck370 FIND v(dout1_24) AT=380.05n

.meas tran vdout1_25ck370 FIND v(dout1_25) AT=380.05n

.meas tran vdout1_26ck370 FIND v(dout1_26) AT=380.05n

.meas tran vdout1_27ck370 FIND v(dout1_27) AT=380.05n

.meas tran vdout1_28ck370 FIND v(dout1_28) AT=380.05n

.meas tran vdout1_29ck370 FIND v(dout1_29) AT=380.05n

.meas tran vdout1_30ck370 FIND v(dout1_30) AT=380.05n

.meas tran vdout1_31ck370 FIND v(dout1_31) AT=380.05n

.meas tran vdout1_32ck370 FIND v(dout1_32) AT=380.05n

.meas tran vdout1_0ck380 FIND v(dout1_0) AT=390.05n

.meas tran vdout1_1ck380 FIND v(dout1_1) AT=390.05n

.meas tran vdout1_2ck380 FIND v(dout1_2) AT=390.05n

.meas tran vdout1_3ck380 FIND v(dout1_3) AT=390.05n

.meas tran vdout1_4ck380 FIND v(dout1_4) AT=390.05n

.meas tran vdout1_5ck380 FIND v(dout1_5) AT=390.05n

.meas tran vdout1_6ck380 FIND v(dout1_6) AT=390.05n

.meas tran vdout1_7ck380 FIND v(dout1_7) AT=390.05n

.meas tran vdout1_8ck380 FIND v(dout1_8) AT=390.05n

.meas tran vdout1_9ck380 FIND v(dout1_9) AT=390.05n

.meas tran vdout1_10ck380 FIND v(dout1_10) AT=390.05n

.meas tran vdout1_11ck380 FIND v(dout1_11) AT=390.05n

.meas tran vdout1_12ck380 FIND v(dout1_12) AT=390.05n

.meas tran vdout1_13ck380 FIND v(dout1_13) AT=390.05n

.meas tran vdout1_14ck380 FIND v(dout1_14) AT=390.05n

.meas tran vdout1_15ck380 FIND v(dout1_15) AT=390.05n

.meas tran vdout1_16ck380 FIND v(dout1_16) AT=390.05n

.meas tran vdout1_17ck380 FIND v(dout1_17) AT=390.05n

.meas tran vdout1_18ck380 FIND v(dout1_18) AT=390.05n

.meas tran vdout1_19ck380 FIND v(dout1_19) AT=390.05n

.meas tran vdout1_20ck380 FIND v(dout1_20) AT=390.05n

.meas tran vdout1_21ck380 FIND v(dout1_21) AT=390.05n

.meas tran vdout1_22ck380 FIND v(dout1_22) AT=390.05n

.meas tran vdout1_23ck380 FIND v(dout1_23) AT=390.05n

.meas tran vdout1_24ck380 FIND v(dout1_24) AT=390.05n

.meas tran vdout1_25ck380 FIND v(dout1_25) AT=390.05n

.meas tran vdout1_26ck380 FIND v(dout1_26) AT=390.05n

.meas tran vdout1_27ck380 FIND v(dout1_27) AT=390.05n

.meas tran vdout1_28ck380 FIND v(dout1_28) AT=390.05n

.meas tran vdout1_29ck380 FIND v(dout1_29) AT=390.05n

.meas tran vdout1_30ck380 FIND v(dout1_30) AT=390.05n

.meas tran vdout1_31ck380 FIND v(dout1_31) AT=390.05n

.meas tran vdout1_32ck380 FIND v(dout1_32) AT=390.05n

.meas tran vdout1_0ck400 FIND v(dout1_0) AT=410.05n

.meas tran vdout1_1ck400 FIND v(dout1_1) AT=410.05n

.meas tran vdout1_2ck400 FIND v(dout1_2) AT=410.05n

.meas tran vdout1_3ck400 FIND v(dout1_3) AT=410.05n

.meas tran vdout1_4ck400 FIND v(dout1_4) AT=410.05n

.meas tran vdout1_5ck400 FIND v(dout1_5) AT=410.05n

.meas tran vdout1_6ck400 FIND v(dout1_6) AT=410.05n

.meas tran vdout1_7ck400 FIND v(dout1_7) AT=410.05n

.meas tran vdout1_8ck400 FIND v(dout1_8) AT=410.05n

.meas tran vdout1_9ck400 FIND v(dout1_9) AT=410.05n

.meas tran vdout1_10ck400 FIND v(dout1_10) AT=410.05n

.meas tran vdout1_11ck400 FIND v(dout1_11) AT=410.05n

.meas tran vdout1_12ck400 FIND v(dout1_12) AT=410.05n

.meas tran vdout1_13ck400 FIND v(dout1_13) AT=410.05n

.meas tran vdout1_14ck400 FIND v(dout1_14) AT=410.05n

.meas tran vdout1_15ck400 FIND v(dout1_15) AT=410.05n

.meas tran vdout1_16ck400 FIND v(dout1_16) AT=410.05n

.meas tran vdout1_17ck400 FIND v(dout1_17) AT=410.05n

.meas tran vdout1_18ck400 FIND v(dout1_18) AT=410.05n

.meas tran vdout1_19ck400 FIND v(dout1_19) AT=410.05n

.meas tran vdout1_20ck400 FIND v(dout1_20) AT=410.05n

.meas tran vdout1_21ck400 FIND v(dout1_21) AT=410.05n

.meas tran vdout1_22ck400 FIND v(dout1_22) AT=410.05n

.meas tran vdout1_23ck400 FIND v(dout1_23) AT=410.05n

.meas tran vdout1_24ck400 FIND v(dout1_24) AT=410.05n

.meas tran vdout1_25ck400 FIND v(dout1_25) AT=410.05n

.meas tran vdout1_26ck400 FIND v(dout1_26) AT=410.05n

.meas tran vdout1_27ck400 FIND v(dout1_27) AT=410.05n

.meas tran vdout1_28ck400 FIND v(dout1_28) AT=410.05n

.meas tran vdout1_29ck400 FIND v(dout1_29) AT=410.05n

.meas tran vdout1_30ck400 FIND v(dout1_30) AT=410.05n

.meas tran vdout1_31ck400 FIND v(dout1_31) AT=410.05n

.meas tran vdout1_32ck400 FIND v(dout1_32) AT=410.05n

.meas tran vdout1_0ck420 FIND v(dout1_0) AT=430.05n

.meas tran vdout1_1ck420 FIND v(dout1_1) AT=430.05n

.meas tran vdout1_2ck420 FIND v(dout1_2) AT=430.05n

.meas tran vdout1_3ck420 FIND v(dout1_3) AT=430.05n

.meas tran vdout1_4ck420 FIND v(dout1_4) AT=430.05n

.meas tran vdout1_5ck420 FIND v(dout1_5) AT=430.05n

.meas tran vdout1_6ck420 FIND v(dout1_6) AT=430.05n

.meas tran vdout1_7ck420 FIND v(dout1_7) AT=430.05n

.meas tran vdout1_8ck420 FIND v(dout1_8) AT=430.05n

.meas tran vdout1_9ck420 FIND v(dout1_9) AT=430.05n

.meas tran vdout1_10ck420 FIND v(dout1_10) AT=430.05n

.meas tran vdout1_11ck420 FIND v(dout1_11) AT=430.05n

.meas tran vdout1_12ck420 FIND v(dout1_12) AT=430.05n

.meas tran vdout1_13ck420 FIND v(dout1_13) AT=430.05n

.meas tran vdout1_14ck420 FIND v(dout1_14) AT=430.05n

.meas tran vdout1_15ck420 FIND v(dout1_15) AT=430.05n

.meas tran vdout1_16ck420 FIND v(dout1_16) AT=430.05n

.meas tran vdout1_17ck420 FIND v(dout1_17) AT=430.05n

.meas tran vdout1_18ck420 FIND v(dout1_18) AT=430.05n

.meas tran vdout1_19ck420 FIND v(dout1_19) AT=430.05n

.meas tran vdout1_20ck420 FIND v(dout1_20) AT=430.05n

.meas tran vdout1_21ck420 FIND v(dout1_21) AT=430.05n

.meas tran vdout1_22ck420 FIND v(dout1_22) AT=430.05n

.meas tran vdout1_23ck420 FIND v(dout1_23) AT=430.05n

.meas tran vdout1_24ck420 FIND v(dout1_24) AT=430.05n

.meas tran vdout1_25ck420 FIND v(dout1_25) AT=430.05n

.meas tran vdout1_26ck420 FIND v(dout1_26) AT=430.05n

.meas tran vdout1_27ck420 FIND v(dout1_27) AT=430.05n

.meas tran vdout1_28ck420 FIND v(dout1_28) AT=430.05n

.meas tran vdout1_29ck420 FIND v(dout1_29) AT=430.05n

.meas tran vdout1_30ck420 FIND v(dout1_30) AT=430.05n

.meas tran vdout1_31ck420 FIND v(dout1_31) AT=430.05n

.meas tran vdout1_32ck420 FIND v(dout1_32) AT=430.05n

.meas tran vdout1_0ck440 FIND v(dout1_0) AT=450.05n

.meas tran vdout1_1ck440 FIND v(dout1_1) AT=450.05n

.meas tran vdout1_2ck440 FIND v(dout1_2) AT=450.05n

.meas tran vdout1_3ck440 FIND v(dout1_3) AT=450.05n

.meas tran vdout1_4ck440 FIND v(dout1_4) AT=450.05n

.meas tran vdout1_5ck440 FIND v(dout1_5) AT=450.05n

.meas tran vdout1_6ck440 FIND v(dout1_6) AT=450.05n

.meas tran vdout1_7ck440 FIND v(dout1_7) AT=450.05n

.meas tran vdout1_8ck440 FIND v(dout1_8) AT=450.05n

.meas tran vdout1_9ck440 FIND v(dout1_9) AT=450.05n

.meas tran vdout1_10ck440 FIND v(dout1_10) AT=450.05n

.meas tran vdout1_11ck440 FIND v(dout1_11) AT=450.05n

.meas tran vdout1_12ck440 FIND v(dout1_12) AT=450.05n

.meas tran vdout1_13ck440 FIND v(dout1_13) AT=450.05n

.meas tran vdout1_14ck440 FIND v(dout1_14) AT=450.05n

.meas tran vdout1_15ck440 FIND v(dout1_15) AT=450.05n

.meas tran vdout1_16ck440 FIND v(dout1_16) AT=450.05n

.meas tran vdout1_17ck440 FIND v(dout1_17) AT=450.05n

.meas tran vdout1_18ck440 FIND v(dout1_18) AT=450.05n

.meas tran vdout1_19ck440 FIND v(dout1_19) AT=450.05n

.meas tran vdout1_20ck440 FIND v(dout1_20) AT=450.05n

.meas tran vdout1_21ck440 FIND v(dout1_21) AT=450.05n

.meas tran vdout1_22ck440 FIND v(dout1_22) AT=450.05n

.meas tran vdout1_23ck440 FIND v(dout1_23) AT=450.05n

.meas tran vdout1_24ck440 FIND v(dout1_24) AT=450.05n

.meas tran vdout1_25ck440 FIND v(dout1_25) AT=450.05n

.meas tran vdout1_26ck440 FIND v(dout1_26) AT=450.05n

.meas tran vdout1_27ck440 FIND v(dout1_27) AT=450.05n

.meas tran vdout1_28ck440 FIND v(dout1_28) AT=450.05n

.meas tran vdout1_29ck440 FIND v(dout1_29) AT=450.05n

.meas tran vdout1_30ck440 FIND v(dout1_30) AT=450.05n

.meas tran vdout1_31ck440 FIND v(dout1_31) AT=450.05n

.meas tran vdout1_32ck440 FIND v(dout1_32) AT=450.05n

.meas tran vdout1_0ck470 FIND v(dout1_0) AT=480.05n

.meas tran vdout1_1ck470 FIND v(dout1_1) AT=480.05n

.meas tran vdout1_2ck470 FIND v(dout1_2) AT=480.05n

.meas tran vdout1_3ck470 FIND v(dout1_3) AT=480.05n

.meas tran vdout1_4ck470 FIND v(dout1_4) AT=480.05n

.meas tran vdout1_5ck470 FIND v(dout1_5) AT=480.05n

.meas tran vdout1_6ck470 FIND v(dout1_6) AT=480.05n

.meas tran vdout1_7ck470 FIND v(dout1_7) AT=480.05n

.meas tran vdout1_8ck470 FIND v(dout1_8) AT=480.05n

.meas tran vdout1_9ck470 FIND v(dout1_9) AT=480.05n

.meas tran vdout1_10ck470 FIND v(dout1_10) AT=480.05n

.meas tran vdout1_11ck470 FIND v(dout1_11) AT=480.05n

.meas tran vdout1_12ck470 FIND v(dout1_12) AT=480.05n

.meas tran vdout1_13ck470 FIND v(dout1_13) AT=480.05n

.meas tran vdout1_14ck470 FIND v(dout1_14) AT=480.05n

.meas tran vdout1_15ck470 FIND v(dout1_15) AT=480.05n

.meas tran vdout1_16ck470 FIND v(dout1_16) AT=480.05n

.meas tran vdout1_17ck470 FIND v(dout1_17) AT=480.05n

.meas tran vdout1_18ck470 FIND v(dout1_18) AT=480.05n

.meas tran vdout1_19ck470 FIND v(dout1_19) AT=480.05n

.meas tran vdout1_20ck470 FIND v(dout1_20) AT=480.05n

.meas tran vdout1_21ck470 FIND v(dout1_21) AT=480.05n

.meas tran vdout1_22ck470 FIND v(dout1_22) AT=480.05n

.meas tran vdout1_23ck470 FIND v(dout1_23) AT=480.05n

.meas tran vdout1_24ck470 FIND v(dout1_24) AT=480.05n

.meas tran vdout1_25ck470 FIND v(dout1_25) AT=480.05n

.meas tran vdout1_26ck470 FIND v(dout1_26) AT=480.05n

.meas tran vdout1_27ck470 FIND v(dout1_27) AT=480.05n

.meas tran vdout1_28ck470 FIND v(dout1_28) AT=480.05n

.meas tran vdout1_29ck470 FIND v(dout1_29) AT=480.05n

.meas tran vdout1_30ck470 FIND v(dout1_30) AT=480.05n

.meas tran vdout1_31ck470 FIND v(dout1_31) AT=480.05n

.meas tran vdout1_32ck470 FIND v(dout1_32) AT=480.05n

.meas tran vdout1_0ck490 FIND v(dout1_0) AT=500.05n

.meas tran vdout1_1ck490 FIND v(dout1_1) AT=500.05n

.meas tran vdout1_2ck490 FIND v(dout1_2) AT=500.05n

.meas tran vdout1_3ck490 FIND v(dout1_3) AT=500.05n

.meas tran vdout1_4ck490 FIND v(dout1_4) AT=500.05n

.meas tran vdout1_5ck490 FIND v(dout1_5) AT=500.05n

.meas tran vdout1_6ck490 FIND v(dout1_6) AT=500.05n

.meas tran vdout1_7ck490 FIND v(dout1_7) AT=500.05n

.meas tran vdout1_8ck490 FIND v(dout1_8) AT=500.05n

.meas tran vdout1_9ck490 FIND v(dout1_9) AT=500.05n

.meas tran vdout1_10ck490 FIND v(dout1_10) AT=500.05n

.meas tran vdout1_11ck490 FIND v(dout1_11) AT=500.05n

.meas tran vdout1_12ck490 FIND v(dout1_12) AT=500.05n

.meas tran vdout1_13ck490 FIND v(dout1_13) AT=500.05n

.meas tran vdout1_14ck490 FIND v(dout1_14) AT=500.05n

.meas tran vdout1_15ck490 FIND v(dout1_15) AT=500.05n

.meas tran vdout1_16ck490 FIND v(dout1_16) AT=500.05n

.meas tran vdout1_17ck490 FIND v(dout1_17) AT=500.05n

.meas tran vdout1_18ck490 FIND v(dout1_18) AT=500.05n

.meas tran vdout1_19ck490 FIND v(dout1_19) AT=500.05n

.meas tran vdout1_20ck490 FIND v(dout1_20) AT=500.05n

.meas tran vdout1_21ck490 FIND v(dout1_21) AT=500.05n

.meas tran vdout1_22ck490 FIND v(dout1_22) AT=500.05n

.meas tran vdout1_23ck490 FIND v(dout1_23) AT=500.05n

.meas tran vdout1_24ck490 FIND v(dout1_24) AT=500.05n

.meas tran vdout1_25ck490 FIND v(dout1_25) AT=500.05n

.meas tran vdout1_26ck490 FIND v(dout1_26) AT=500.05n

.meas tran vdout1_27ck490 FIND v(dout1_27) AT=500.05n

.meas tran vdout1_28ck490 FIND v(dout1_28) AT=500.05n

.meas tran vdout1_29ck490 FIND v(dout1_29) AT=500.05n

.meas tran vdout1_30ck490 FIND v(dout1_30) AT=500.05n

.meas tran vdout1_31ck490 FIND v(dout1_31) AT=500.05n

.meas tran vdout1_32ck490 FIND v(dout1_32) AT=500.05n

.meas tran vdout1_0ck510 FIND v(dout1_0) AT=520.05n

.meas tran vdout1_1ck510 FIND v(dout1_1) AT=520.05n

.meas tran vdout1_2ck510 FIND v(dout1_2) AT=520.05n

.meas tran vdout1_3ck510 FIND v(dout1_3) AT=520.05n

.meas tran vdout1_4ck510 FIND v(dout1_4) AT=520.05n

.meas tran vdout1_5ck510 FIND v(dout1_5) AT=520.05n

.meas tran vdout1_6ck510 FIND v(dout1_6) AT=520.05n

.meas tran vdout1_7ck510 FIND v(dout1_7) AT=520.05n

.meas tran vdout1_8ck510 FIND v(dout1_8) AT=520.05n

.meas tran vdout1_9ck510 FIND v(dout1_9) AT=520.05n

.meas tran vdout1_10ck510 FIND v(dout1_10) AT=520.05n

.meas tran vdout1_11ck510 FIND v(dout1_11) AT=520.05n

.meas tran vdout1_12ck510 FIND v(dout1_12) AT=520.05n

.meas tran vdout1_13ck510 FIND v(dout1_13) AT=520.05n

.meas tran vdout1_14ck510 FIND v(dout1_14) AT=520.05n

.meas tran vdout1_15ck510 FIND v(dout1_15) AT=520.05n

.meas tran vdout1_16ck510 FIND v(dout1_16) AT=520.05n

.meas tran vdout1_17ck510 FIND v(dout1_17) AT=520.05n

.meas tran vdout1_18ck510 FIND v(dout1_18) AT=520.05n

.meas tran vdout1_19ck510 FIND v(dout1_19) AT=520.05n

.meas tran vdout1_20ck510 FIND v(dout1_20) AT=520.05n

.meas tran vdout1_21ck510 FIND v(dout1_21) AT=520.05n

.meas tran vdout1_22ck510 FIND v(dout1_22) AT=520.05n

.meas tran vdout1_23ck510 FIND v(dout1_23) AT=520.05n

.meas tran vdout1_24ck510 FIND v(dout1_24) AT=520.05n

.meas tran vdout1_25ck510 FIND v(dout1_25) AT=520.05n

.meas tran vdout1_26ck510 FIND v(dout1_26) AT=520.05n

.meas tran vdout1_27ck510 FIND v(dout1_27) AT=520.05n

.meas tran vdout1_28ck510 FIND v(dout1_28) AT=520.05n

.meas tran vdout1_29ck510 FIND v(dout1_29) AT=520.05n

.meas tran vdout1_30ck510 FIND v(dout1_30) AT=520.05n

.meas tran vdout1_31ck510 FIND v(dout1_31) AT=520.05n

.meas tran vdout1_32ck510 FIND v(dout1_32) AT=520.05n

.meas tran vdout1_0ck530 FIND v(dout1_0) AT=540.05n

.meas tran vdout1_1ck530 FIND v(dout1_1) AT=540.05n

.meas tran vdout1_2ck530 FIND v(dout1_2) AT=540.05n

.meas tran vdout1_3ck530 FIND v(dout1_3) AT=540.05n

.meas tran vdout1_4ck530 FIND v(dout1_4) AT=540.05n

.meas tran vdout1_5ck530 FIND v(dout1_5) AT=540.05n

.meas tran vdout1_6ck530 FIND v(dout1_6) AT=540.05n

.meas tran vdout1_7ck530 FIND v(dout1_7) AT=540.05n

.meas tran vdout1_8ck530 FIND v(dout1_8) AT=540.05n

.meas tran vdout1_9ck530 FIND v(dout1_9) AT=540.05n

.meas tran vdout1_10ck530 FIND v(dout1_10) AT=540.05n

.meas tran vdout1_11ck530 FIND v(dout1_11) AT=540.05n

.meas tran vdout1_12ck530 FIND v(dout1_12) AT=540.05n

.meas tran vdout1_13ck530 FIND v(dout1_13) AT=540.05n

.meas tran vdout1_14ck530 FIND v(dout1_14) AT=540.05n

.meas tran vdout1_15ck530 FIND v(dout1_15) AT=540.05n

.meas tran vdout1_16ck530 FIND v(dout1_16) AT=540.05n

.meas tran vdout1_17ck530 FIND v(dout1_17) AT=540.05n

.meas tran vdout1_18ck530 FIND v(dout1_18) AT=540.05n

.meas tran vdout1_19ck530 FIND v(dout1_19) AT=540.05n

.meas tran vdout1_20ck530 FIND v(dout1_20) AT=540.05n

.meas tran vdout1_21ck530 FIND v(dout1_21) AT=540.05n

.meas tran vdout1_22ck530 FIND v(dout1_22) AT=540.05n

.meas tran vdout1_23ck530 FIND v(dout1_23) AT=540.05n

.meas tran vdout1_24ck530 FIND v(dout1_24) AT=540.05n

.meas tran vdout1_25ck530 FIND v(dout1_25) AT=540.05n

.meas tran vdout1_26ck530 FIND v(dout1_26) AT=540.05n

.meas tran vdout1_27ck530 FIND v(dout1_27) AT=540.05n

.meas tran vdout1_28ck530 FIND v(dout1_28) AT=540.05n

.meas tran vdout1_29ck530 FIND v(dout1_29) AT=540.05n

.meas tran vdout1_30ck530 FIND v(dout1_30) AT=540.05n

.meas tran vdout1_31ck530 FIND v(dout1_31) AT=540.05n

.meas tran vdout1_32ck530 FIND v(dout1_32) AT=540.05n

.meas tran vdout1_0ck650 FIND v(dout1_0) AT=660.05n

.meas tran vdout1_1ck650 FIND v(dout1_1) AT=660.05n

.meas tran vdout1_2ck650 FIND v(dout1_2) AT=660.05n

.meas tran vdout1_3ck650 FIND v(dout1_3) AT=660.05n

.meas tran vdout1_4ck650 FIND v(dout1_4) AT=660.05n

.meas tran vdout1_5ck650 FIND v(dout1_5) AT=660.05n

.meas tran vdout1_6ck650 FIND v(dout1_6) AT=660.05n

.meas tran vdout1_7ck650 FIND v(dout1_7) AT=660.05n

.meas tran vdout1_8ck650 FIND v(dout1_8) AT=660.05n

.meas tran vdout1_9ck650 FIND v(dout1_9) AT=660.05n

.meas tran vdout1_10ck650 FIND v(dout1_10) AT=660.05n

.meas tran vdout1_11ck650 FIND v(dout1_11) AT=660.05n

.meas tran vdout1_12ck650 FIND v(dout1_12) AT=660.05n

.meas tran vdout1_13ck650 FIND v(dout1_13) AT=660.05n

.meas tran vdout1_14ck650 FIND v(dout1_14) AT=660.05n

.meas tran vdout1_15ck650 FIND v(dout1_15) AT=660.05n

.meas tran vdout1_16ck650 FIND v(dout1_16) AT=660.05n

.meas tran vdout1_17ck650 FIND v(dout1_17) AT=660.05n

.meas tran vdout1_18ck650 FIND v(dout1_18) AT=660.05n

.meas tran vdout1_19ck650 FIND v(dout1_19) AT=660.05n

.meas tran vdout1_20ck650 FIND v(dout1_20) AT=660.05n

.meas tran vdout1_21ck650 FIND v(dout1_21) AT=660.05n

.meas tran vdout1_22ck650 FIND v(dout1_22) AT=660.05n

.meas tran vdout1_23ck650 FIND v(dout1_23) AT=660.05n

.meas tran vdout1_24ck650 FIND v(dout1_24) AT=660.05n

.meas tran vdout1_25ck650 FIND v(dout1_25) AT=660.05n

.meas tran vdout1_26ck650 FIND v(dout1_26) AT=660.05n

.meas tran vdout1_27ck650 FIND v(dout1_27) AT=660.05n

.meas tran vdout1_28ck650 FIND v(dout1_28) AT=660.05n

.meas tran vdout1_29ck650 FIND v(dout1_29) AT=660.05n

.meas tran vdout1_30ck650 FIND v(dout1_30) AT=660.05n

.meas tran vdout1_31ck650 FIND v(dout1_31) AT=660.05n

.meas tran vdout1_32ck650 FIND v(dout1_32) AT=660.05n

.meas tran vdout1_0ck680 FIND v(dout1_0) AT=690.05n

.meas tran vdout1_1ck680 FIND v(dout1_1) AT=690.05n

.meas tran vdout1_2ck680 FIND v(dout1_2) AT=690.05n

.meas tran vdout1_3ck680 FIND v(dout1_3) AT=690.05n

.meas tran vdout1_4ck680 FIND v(dout1_4) AT=690.05n

.meas tran vdout1_5ck680 FIND v(dout1_5) AT=690.05n

.meas tran vdout1_6ck680 FIND v(dout1_6) AT=690.05n

.meas tran vdout1_7ck680 FIND v(dout1_7) AT=690.05n

.meas tran vdout1_8ck680 FIND v(dout1_8) AT=690.05n

.meas tran vdout1_9ck680 FIND v(dout1_9) AT=690.05n

.meas tran vdout1_10ck680 FIND v(dout1_10) AT=690.05n

.meas tran vdout1_11ck680 FIND v(dout1_11) AT=690.05n

.meas tran vdout1_12ck680 FIND v(dout1_12) AT=690.05n

.meas tran vdout1_13ck680 FIND v(dout1_13) AT=690.05n

.meas tran vdout1_14ck680 FIND v(dout1_14) AT=690.05n

.meas tran vdout1_15ck680 FIND v(dout1_15) AT=690.05n

.meas tran vdout1_16ck680 FIND v(dout1_16) AT=690.05n

.meas tran vdout1_17ck680 FIND v(dout1_17) AT=690.05n

.meas tran vdout1_18ck680 FIND v(dout1_18) AT=690.05n

.meas tran vdout1_19ck680 FIND v(dout1_19) AT=690.05n

.meas tran vdout1_20ck680 FIND v(dout1_20) AT=690.05n

.meas tran vdout1_21ck680 FIND v(dout1_21) AT=690.05n

.meas tran vdout1_22ck680 FIND v(dout1_22) AT=690.05n

.meas tran vdout1_23ck680 FIND v(dout1_23) AT=690.05n

.meas tran vdout1_24ck680 FIND v(dout1_24) AT=690.05n

.meas tran vdout1_25ck680 FIND v(dout1_25) AT=690.05n

.meas tran vdout1_26ck680 FIND v(dout1_26) AT=690.05n

.meas tran vdout1_27ck680 FIND v(dout1_27) AT=690.05n

.meas tran vdout1_28ck680 FIND v(dout1_28) AT=690.05n

.meas tran vdout1_29ck680 FIND v(dout1_29) AT=690.05n

.meas tran vdout1_30ck680 FIND v(dout1_30) AT=690.05n

.meas tran vdout1_31ck680 FIND v(dout1_31) AT=690.05n

.meas tran vdout1_32ck680 FIND v(dout1_32) AT=690.05n

.meas tran vdout1_0ck690 FIND v(dout1_0) AT=700.05n

.meas tran vdout1_1ck690 FIND v(dout1_1) AT=700.05n

.meas tran vdout1_2ck690 FIND v(dout1_2) AT=700.05n

.meas tran vdout1_3ck690 FIND v(dout1_3) AT=700.05n

.meas tran vdout1_4ck690 FIND v(dout1_4) AT=700.05n

.meas tran vdout1_5ck690 FIND v(dout1_5) AT=700.05n

.meas tran vdout1_6ck690 FIND v(dout1_6) AT=700.05n

.meas tran vdout1_7ck690 FIND v(dout1_7) AT=700.05n

.meas tran vdout1_8ck690 FIND v(dout1_8) AT=700.05n

.meas tran vdout1_9ck690 FIND v(dout1_9) AT=700.05n

.meas tran vdout1_10ck690 FIND v(dout1_10) AT=700.05n

.meas tran vdout1_11ck690 FIND v(dout1_11) AT=700.05n

.meas tran vdout1_12ck690 FIND v(dout1_12) AT=700.05n

.meas tran vdout1_13ck690 FIND v(dout1_13) AT=700.05n

.meas tran vdout1_14ck690 FIND v(dout1_14) AT=700.05n

.meas tran vdout1_15ck690 FIND v(dout1_15) AT=700.05n

.meas tran vdout1_16ck690 FIND v(dout1_16) AT=700.05n

.meas tran vdout1_17ck690 FIND v(dout1_17) AT=700.05n

.meas tran vdout1_18ck690 FIND v(dout1_18) AT=700.05n

.meas tran vdout1_19ck690 FIND v(dout1_19) AT=700.05n

.meas tran vdout1_20ck690 FIND v(dout1_20) AT=700.05n

.meas tran vdout1_21ck690 FIND v(dout1_21) AT=700.05n

.meas tran vdout1_22ck690 FIND v(dout1_22) AT=700.05n

.meas tran vdout1_23ck690 FIND v(dout1_23) AT=700.05n

.meas tran vdout1_24ck690 FIND v(dout1_24) AT=700.05n

.meas tran vdout1_25ck690 FIND v(dout1_25) AT=700.05n

.meas tran vdout1_26ck690 FIND v(dout1_26) AT=700.05n

.meas tran vdout1_27ck690 FIND v(dout1_27) AT=700.05n

.meas tran vdout1_28ck690 FIND v(dout1_28) AT=700.05n

.meas tran vdout1_29ck690 FIND v(dout1_29) AT=700.05n

.meas tran vdout1_30ck690 FIND v(dout1_30) AT=700.05n

.meas tran vdout1_31ck690 FIND v(dout1_31) AT=700.05n

.meas tran vdout1_32ck690 FIND v(dout1_32) AT=700.05n

.meas tran vdout1_0ck700 FIND v(dout1_0) AT=710.05n

.meas tran vdout1_1ck700 FIND v(dout1_1) AT=710.05n

.meas tran vdout1_2ck700 FIND v(dout1_2) AT=710.05n

.meas tran vdout1_3ck700 FIND v(dout1_3) AT=710.05n

.meas tran vdout1_4ck700 FIND v(dout1_4) AT=710.05n

.meas tran vdout1_5ck700 FIND v(dout1_5) AT=710.05n

.meas tran vdout1_6ck700 FIND v(dout1_6) AT=710.05n

.meas tran vdout1_7ck700 FIND v(dout1_7) AT=710.05n

.meas tran vdout1_8ck700 FIND v(dout1_8) AT=710.05n

.meas tran vdout1_9ck700 FIND v(dout1_9) AT=710.05n

.meas tran vdout1_10ck700 FIND v(dout1_10) AT=710.05n

.meas tran vdout1_11ck700 FIND v(dout1_11) AT=710.05n

.meas tran vdout1_12ck700 FIND v(dout1_12) AT=710.05n

.meas tran vdout1_13ck700 FIND v(dout1_13) AT=710.05n

.meas tran vdout1_14ck700 FIND v(dout1_14) AT=710.05n

.meas tran vdout1_15ck700 FIND v(dout1_15) AT=710.05n

.meas tran vdout1_16ck700 FIND v(dout1_16) AT=710.05n

.meas tran vdout1_17ck700 FIND v(dout1_17) AT=710.05n

.meas tran vdout1_18ck700 FIND v(dout1_18) AT=710.05n

.meas tran vdout1_19ck700 FIND v(dout1_19) AT=710.05n

.meas tran vdout1_20ck700 FIND v(dout1_20) AT=710.05n

.meas tran vdout1_21ck700 FIND v(dout1_21) AT=710.05n

.meas tran vdout1_22ck700 FIND v(dout1_22) AT=710.05n

.meas tran vdout1_23ck700 FIND v(dout1_23) AT=710.05n

.meas tran vdout1_24ck700 FIND v(dout1_24) AT=710.05n

.meas tran vdout1_25ck700 FIND v(dout1_25) AT=710.05n

.meas tran vdout1_26ck700 FIND v(dout1_26) AT=710.05n

.meas tran vdout1_27ck700 FIND v(dout1_27) AT=710.05n

.meas tran vdout1_28ck700 FIND v(dout1_28) AT=710.05n

.meas tran vdout1_29ck700 FIND v(dout1_29) AT=710.05n

.meas tran vdout1_30ck700 FIND v(dout1_30) AT=710.05n

.meas tran vdout1_31ck700 FIND v(dout1_31) AT=710.05n

.meas tran vdout1_32ck700 FIND v(dout1_32) AT=710.05n

.meas tran vdout1_0ck720 FIND v(dout1_0) AT=730.05n

.meas tran vdout1_1ck720 FIND v(dout1_1) AT=730.05n

.meas tran vdout1_2ck720 FIND v(dout1_2) AT=730.05n

.meas tran vdout1_3ck720 FIND v(dout1_3) AT=730.05n

.meas tran vdout1_4ck720 FIND v(dout1_4) AT=730.05n

.meas tran vdout1_5ck720 FIND v(dout1_5) AT=730.05n

.meas tran vdout1_6ck720 FIND v(dout1_6) AT=730.05n

.meas tran vdout1_7ck720 FIND v(dout1_7) AT=730.05n

.meas tran vdout1_8ck720 FIND v(dout1_8) AT=730.05n

.meas tran vdout1_9ck720 FIND v(dout1_9) AT=730.05n

.meas tran vdout1_10ck720 FIND v(dout1_10) AT=730.05n

.meas tran vdout1_11ck720 FIND v(dout1_11) AT=730.05n

.meas tran vdout1_12ck720 FIND v(dout1_12) AT=730.05n

.meas tran vdout1_13ck720 FIND v(dout1_13) AT=730.05n

.meas tran vdout1_14ck720 FIND v(dout1_14) AT=730.05n

.meas tran vdout1_15ck720 FIND v(dout1_15) AT=730.05n

.meas tran vdout1_16ck720 FIND v(dout1_16) AT=730.05n

.meas tran vdout1_17ck720 FIND v(dout1_17) AT=730.05n

.meas tran vdout1_18ck720 FIND v(dout1_18) AT=730.05n

.meas tran vdout1_19ck720 FIND v(dout1_19) AT=730.05n

.meas tran vdout1_20ck720 FIND v(dout1_20) AT=730.05n

.meas tran vdout1_21ck720 FIND v(dout1_21) AT=730.05n

.meas tran vdout1_22ck720 FIND v(dout1_22) AT=730.05n

.meas tran vdout1_23ck720 FIND v(dout1_23) AT=730.05n

.meas tran vdout1_24ck720 FIND v(dout1_24) AT=730.05n

.meas tran vdout1_25ck720 FIND v(dout1_25) AT=730.05n

.meas tran vdout1_26ck720 FIND v(dout1_26) AT=730.05n

.meas tran vdout1_27ck720 FIND v(dout1_27) AT=730.05n

.meas tran vdout1_28ck720 FIND v(dout1_28) AT=730.05n

.meas tran vdout1_29ck720 FIND v(dout1_29) AT=730.05n

.meas tran vdout1_30ck720 FIND v(dout1_30) AT=730.05n

.meas tran vdout1_31ck720 FIND v(dout1_31) AT=730.05n

.meas tran vdout1_32ck720 FIND v(dout1_32) AT=730.05n

.meas tran vdout1_0ck770 FIND v(dout1_0) AT=780.05n

.meas tran vdout1_1ck770 FIND v(dout1_1) AT=780.05n

.meas tran vdout1_2ck770 FIND v(dout1_2) AT=780.05n

.meas tran vdout1_3ck770 FIND v(dout1_3) AT=780.05n

.meas tran vdout1_4ck770 FIND v(dout1_4) AT=780.05n

.meas tran vdout1_5ck770 FIND v(dout1_5) AT=780.05n

.meas tran vdout1_6ck770 FIND v(dout1_6) AT=780.05n

.meas tran vdout1_7ck770 FIND v(dout1_7) AT=780.05n

.meas tran vdout1_8ck770 FIND v(dout1_8) AT=780.05n

.meas tran vdout1_9ck770 FIND v(dout1_9) AT=780.05n

.meas tran vdout1_10ck770 FIND v(dout1_10) AT=780.05n

.meas tran vdout1_11ck770 FIND v(dout1_11) AT=780.05n

.meas tran vdout1_12ck770 FIND v(dout1_12) AT=780.05n

.meas tran vdout1_13ck770 FIND v(dout1_13) AT=780.05n

.meas tran vdout1_14ck770 FIND v(dout1_14) AT=780.05n

.meas tran vdout1_15ck770 FIND v(dout1_15) AT=780.05n

.meas tran vdout1_16ck770 FIND v(dout1_16) AT=780.05n

.meas tran vdout1_17ck770 FIND v(dout1_17) AT=780.05n

.meas tran vdout1_18ck770 FIND v(dout1_18) AT=780.05n

.meas tran vdout1_19ck770 FIND v(dout1_19) AT=780.05n

.meas tran vdout1_20ck770 FIND v(dout1_20) AT=780.05n

.meas tran vdout1_21ck770 FIND v(dout1_21) AT=780.05n

.meas tran vdout1_22ck770 FIND v(dout1_22) AT=780.05n

.meas tran vdout1_23ck770 FIND v(dout1_23) AT=780.05n

.meas tran vdout1_24ck770 FIND v(dout1_24) AT=780.05n

.meas tran vdout1_25ck770 FIND v(dout1_25) AT=780.05n

.meas tran vdout1_26ck770 FIND v(dout1_26) AT=780.05n

.meas tran vdout1_27ck770 FIND v(dout1_27) AT=780.05n

.meas tran vdout1_28ck770 FIND v(dout1_28) AT=780.05n

.meas tran vdout1_29ck770 FIND v(dout1_29) AT=780.05n

.meas tran vdout1_30ck770 FIND v(dout1_30) AT=780.05n

.meas tran vdout1_31ck770 FIND v(dout1_31) AT=780.05n

.meas tran vdout1_32ck770 FIND v(dout1_32) AT=780.05n

.meas tran vdout1_0ck780 FIND v(dout1_0) AT=790.05n

.meas tran vdout1_1ck780 FIND v(dout1_1) AT=790.05n

.meas tran vdout1_2ck780 FIND v(dout1_2) AT=790.05n

.meas tran vdout1_3ck780 FIND v(dout1_3) AT=790.05n

.meas tran vdout1_4ck780 FIND v(dout1_4) AT=790.05n

.meas tran vdout1_5ck780 FIND v(dout1_5) AT=790.05n

.meas tran vdout1_6ck780 FIND v(dout1_6) AT=790.05n

.meas tran vdout1_7ck780 FIND v(dout1_7) AT=790.05n

.meas tran vdout1_8ck780 FIND v(dout1_8) AT=790.05n

.meas tran vdout1_9ck780 FIND v(dout1_9) AT=790.05n

.meas tran vdout1_10ck780 FIND v(dout1_10) AT=790.05n

.meas tran vdout1_11ck780 FIND v(dout1_11) AT=790.05n

.meas tran vdout1_12ck780 FIND v(dout1_12) AT=790.05n

.meas tran vdout1_13ck780 FIND v(dout1_13) AT=790.05n

.meas tran vdout1_14ck780 FIND v(dout1_14) AT=790.05n

.meas tran vdout1_15ck780 FIND v(dout1_15) AT=790.05n

.meas tran vdout1_16ck780 FIND v(dout1_16) AT=790.05n

.meas tran vdout1_17ck780 FIND v(dout1_17) AT=790.05n

.meas tran vdout1_18ck780 FIND v(dout1_18) AT=790.05n

.meas tran vdout1_19ck780 FIND v(dout1_19) AT=790.05n

.meas tran vdout1_20ck780 FIND v(dout1_20) AT=790.05n

.meas tran vdout1_21ck780 FIND v(dout1_21) AT=790.05n

.meas tran vdout1_22ck780 FIND v(dout1_22) AT=790.05n

.meas tran vdout1_23ck780 FIND v(dout1_23) AT=790.05n

.meas tran vdout1_24ck780 FIND v(dout1_24) AT=790.05n

.meas tran vdout1_25ck780 FIND v(dout1_25) AT=790.05n

.meas tran vdout1_26ck780 FIND v(dout1_26) AT=790.05n

.meas tran vdout1_27ck780 FIND v(dout1_27) AT=790.05n

.meas tran vdout1_28ck780 FIND v(dout1_28) AT=790.05n

.meas tran vdout1_29ck780 FIND v(dout1_29) AT=790.05n

.meas tran vdout1_30ck780 FIND v(dout1_30) AT=790.05n

.meas tran vdout1_31ck780 FIND v(dout1_31) AT=790.05n

.meas tran vdout1_32ck780 FIND v(dout1_32) AT=790.05n

.meas tran vdout1_0ck800 FIND v(dout1_0) AT=810.05n

.meas tran vdout1_1ck800 FIND v(dout1_1) AT=810.05n

.meas tran vdout1_2ck800 FIND v(dout1_2) AT=810.05n

.meas tran vdout1_3ck800 FIND v(dout1_3) AT=810.05n

.meas tran vdout1_4ck800 FIND v(dout1_4) AT=810.05n

.meas tran vdout1_5ck800 FIND v(dout1_5) AT=810.05n

.meas tran vdout1_6ck800 FIND v(dout1_6) AT=810.05n

.meas tran vdout1_7ck800 FIND v(dout1_7) AT=810.05n

.meas tran vdout1_8ck800 FIND v(dout1_8) AT=810.05n

.meas tran vdout1_9ck800 FIND v(dout1_9) AT=810.05n

.meas tran vdout1_10ck800 FIND v(dout1_10) AT=810.05n

.meas tran vdout1_11ck800 FIND v(dout1_11) AT=810.05n

.meas tran vdout1_12ck800 FIND v(dout1_12) AT=810.05n

.meas tran vdout1_13ck800 FIND v(dout1_13) AT=810.05n

.meas tran vdout1_14ck800 FIND v(dout1_14) AT=810.05n

.meas tran vdout1_15ck800 FIND v(dout1_15) AT=810.05n

.meas tran vdout1_16ck800 FIND v(dout1_16) AT=810.05n

.meas tran vdout1_17ck800 FIND v(dout1_17) AT=810.05n

.meas tran vdout1_18ck800 FIND v(dout1_18) AT=810.05n

.meas tran vdout1_19ck800 FIND v(dout1_19) AT=810.05n

.meas tran vdout1_20ck800 FIND v(dout1_20) AT=810.05n

.meas tran vdout1_21ck800 FIND v(dout1_21) AT=810.05n

.meas tran vdout1_22ck800 FIND v(dout1_22) AT=810.05n

.meas tran vdout1_23ck800 FIND v(dout1_23) AT=810.05n

.meas tran vdout1_24ck800 FIND v(dout1_24) AT=810.05n

.meas tran vdout1_25ck800 FIND v(dout1_25) AT=810.05n

.meas tran vdout1_26ck800 FIND v(dout1_26) AT=810.05n

.meas tran vdout1_27ck800 FIND v(dout1_27) AT=810.05n

.meas tran vdout1_28ck800 FIND v(dout1_28) AT=810.05n

.meas tran vdout1_29ck800 FIND v(dout1_29) AT=810.05n

.meas tran vdout1_30ck800 FIND v(dout1_30) AT=810.05n

.meas tran vdout1_31ck800 FIND v(dout1_31) AT=810.05n

.meas tran vdout1_32ck800 FIND v(dout1_32) AT=810.05n

.meas tran vdout1_0ck820 FIND v(dout1_0) AT=830.05n

.meas tran vdout1_1ck820 FIND v(dout1_1) AT=830.05n

.meas tran vdout1_2ck820 FIND v(dout1_2) AT=830.05n

.meas tran vdout1_3ck820 FIND v(dout1_3) AT=830.05n

.meas tran vdout1_4ck820 FIND v(dout1_4) AT=830.05n

.meas tran vdout1_5ck820 FIND v(dout1_5) AT=830.05n

.meas tran vdout1_6ck820 FIND v(dout1_6) AT=830.05n

.meas tran vdout1_7ck820 FIND v(dout1_7) AT=830.05n

.meas tran vdout1_8ck820 FIND v(dout1_8) AT=830.05n

.meas tran vdout1_9ck820 FIND v(dout1_9) AT=830.05n

.meas tran vdout1_10ck820 FIND v(dout1_10) AT=830.05n

.meas tran vdout1_11ck820 FIND v(dout1_11) AT=830.05n

.meas tran vdout1_12ck820 FIND v(dout1_12) AT=830.05n

.meas tran vdout1_13ck820 FIND v(dout1_13) AT=830.05n

.meas tran vdout1_14ck820 FIND v(dout1_14) AT=830.05n

.meas tran vdout1_15ck820 FIND v(dout1_15) AT=830.05n

.meas tran vdout1_16ck820 FIND v(dout1_16) AT=830.05n

.meas tran vdout1_17ck820 FIND v(dout1_17) AT=830.05n

.meas tran vdout1_18ck820 FIND v(dout1_18) AT=830.05n

.meas tran vdout1_19ck820 FIND v(dout1_19) AT=830.05n

.meas tran vdout1_20ck820 FIND v(dout1_20) AT=830.05n

.meas tran vdout1_21ck820 FIND v(dout1_21) AT=830.05n

.meas tran vdout1_22ck820 FIND v(dout1_22) AT=830.05n

.meas tran vdout1_23ck820 FIND v(dout1_23) AT=830.05n

.meas tran vdout1_24ck820 FIND v(dout1_24) AT=830.05n

.meas tran vdout1_25ck820 FIND v(dout1_25) AT=830.05n

.meas tran vdout1_26ck820 FIND v(dout1_26) AT=830.05n

.meas tran vdout1_27ck820 FIND v(dout1_27) AT=830.05n

.meas tran vdout1_28ck820 FIND v(dout1_28) AT=830.05n

.meas tran vdout1_29ck820 FIND v(dout1_29) AT=830.05n

.meas tran vdout1_30ck820 FIND v(dout1_30) AT=830.05n

.meas tran vdout1_31ck820 FIND v(dout1_31) AT=830.05n

.meas tran vdout1_32ck820 FIND v(dout1_32) AT=830.05n

.meas tran vdout1_0ck840 FIND v(dout1_0) AT=850.05n

.meas tran vdout1_1ck840 FIND v(dout1_1) AT=850.05n

.meas tran vdout1_2ck840 FIND v(dout1_2) AT=850.05n

.meas tran vdout1_3ck840 FIND v(dout1_3) AT=850.05n

.meas tran vdout1_4ck840 FIND v(dout1_4) AT=850.05n

.meas tran vdout1_5ck840 FIND v(dout1_5) AT=850.05n

.meas tran vdout1_6ck840 FIND v(dout1_6) AT=850.05n

.meas tran vdout1_7ck840 FIND v(dout1_7) AT=850.05n

.meas tran vdout1_8ck840 FIND v(dout1_8) AT=850.05n

.meas tran vdout1_9ck840 FIND v(dout1_9) AT=850.05n

.meas tran vdout1_10ck840 FIND v(dout1_10) AT=850.05n

.meas tran vdout1_11ck840 FIND v(dout1_11) AT=850.05n

.meas tran vdout1_12ck840 FIND v(dout1_12) AT=850.05n

.meas tran vdout1_13ck840 FIND v(dout1_13) AT=850.05n

.meas tran vdout1_14ck840 FIND v(dout1_14) AT=850.05n

.meas tran vdout1_15ck840 FIND v(dout1_15) AT=850.05n

.meas tran vdout1_16ck840 FIND v(dout1_16) AT=850.05n

.meas tran vdout1_17ck840 FIND v(dout1_17) AT=850.05n

.meas tran vdout1_18ck840 FIND v(dout1_18) AT=850.05n

.meas tran vdout1_19ck840 FIND v(dout1_19) AT=850.05n

.meas tran vdout1_20ck840 FIND v(dout1_20) AT=850.05n

.meas tran vdout1_21ck840 FIND v(dout1_21) AT=850.05n

.meas tran vdout1_22ck840 FIND v(dout1_22) AT=850.05n

.meas tran vdout1_23ck840 FIND v(dout1_23) AT=850.05n

.meas tran vdout1_24ck840 FIND v(dout1_24) AT=850.05n

.meas tran vdout1_25ck840 FIND v(dout1_25) AT=850.05n

.meas tran vdout1_26ck840 FIND v(dout1_26) AT=850.05n

.meas tran vdout1_27ck840 FIND v(dout1_27) AT=850.05n

.meas tran vdout1_28ck840 FIND v(dout1_28) AT=850.05n

.meas tran vdout1_29ck840 FIND v(dout1_29) AT=850.05n

.meas tran vdout1_30ck840 FIND v(dout1_30) AT=850.05n

.meas tran vdout1_31ck840 FIND v(dout1_31) AT=850.05n

.meas tran vdout1_32ck840 FIND v(dout1_32) AT=850.05n

.meas tran vdout1_0ck850 FIND v(dout1_0) AT=860.05n

.meas tran vdout1_1ck850 FIND v(dout1_1) AT=860.05n

.meas tran vdout1_2ck850 FIND v(dout1_2) AT=860.05n

.meas tran vdout1_3ck850 FIND v(dout1_3) AT=860.05n

.meas tran vdout1_4ck850 FIND v(dout1_4) AT=860.05n

.meas tran vdout1_5ck850 FIND v(dout1_5) AT=860.05n

.meas tran vdout1_6ck850 FIND v(dout1_6) AT=860.05n

.meas tran vdout1_7ck850 FIND v(dout1_7) AT=860.05n

.meas tran vdout1_8ck850 FIND v(dout1_8) AT=860.05n

.meas tran vdout1_9ck850 FIND v(dout1_9) AT=860.05n

.meas tran vdout1_10ck850 FIND v(dout1_10) AT=860.05n

.meas tran vdout1_11ck850 FIND v(dout1_11) AT=860.05n

.meas tran vdout1_12ck850 FIND v(dout1_12) AT=860.05n

.meas tran vdout1_13ck850 FIND v(dout1_13) AT=860.05n

.meas tran vdout1_14ck850 FIND v(dout1_14) AT=860.05n

.meas tran vdout1_15ck850 FIND v(dout1_15) AT=860.05n

.meas tran vdout1_16ck850 FIND v(dout1_16) AT=860.05n

.meas tran vdout1_17ck850 FIND v(dout1_17) AT=860.05n

.meas tran vdout1_18ck850 FIND v(dout1_18) AT=860.05n

.meas tran vdout1_19ck850 FIND v(dout1_19) AT=860.05n

.meas tran vdout1_20ck850 FIND v(dout1_20) AT=860.05n

.meas tran vdout1_21ck850 FIND v(dout1_21) AT=860.05n

.meas tran vdout1_22ck850 FIND v(dout1_22) AT=860.05n

.meas tran vdout1_23ck850 FIND v(dout1_23) AT=860.05n

.meas tran vdout1_24ck850 FIND v(dout1_24) AT=860.05n

.meas tran vdout1_25ck850 FIND v(dout1_25) AT=860.05n

.meas tran vdout1_26ck850 FIND v(dout1_26) AT=860.05n

.meas tran vdout1_27ck850 FIND v(dout1_27) AT=860.05n

.meas tran vdout1_28ck850 FIND v(dout1_28) AT=860.05n

.meas tran vdout1_29ck850 FIND v(dout1_29) AT=860.05n

.meas tran vdout1_30ck850 FIND v(dout1_30) AT=860.05n

.meas tran vdout1_31ck850 FIND v(dout1_31) AT=860.05n

.meas tran vdout1_32ck850 FIND v(dout1_32) AT=860.05n

.meas tran vdout1_0ck910 FIND v(dout1_0) AT=920.05n

.meas tran vdout1_1ck910 FIND v(dout1_1) AT=920.05n

.meas tran vdout1_2ck910 FIND v(dout1_2) AT=920.05n

.meas tran vdout1_3ck910 FIND v(dout1_3) AT=920.05n

.meas tran vdout1_4ck910 FIND v(dout1_4) AT=920.05n

.meas tran vdout1_5ck910 FIND v(dout1_5) AT=920.05n

.meas tran vdout1_6ck910 FIND v(dout1_6) AT=920.05n

.meas tran vdout1_7ck910 FIND v(dout1_7) AT=920.05n

.meas tran vdout1_8ck910 FIND v(dout1_8) AT=920.05n

.meas tran vdout1_9ck910 FIND v(dout1_9) AT=920.05n

.meas tran vdout1_10ck910 FIND v(dout1_10) AT=920.05n

.meas tran vdout1_11ck910 FIND v(dout1_11) AT=920.05n

.meas tran vdout1_12ck910 FIND v(dout1_12) AT=920.05n

.meas tran vdout1_13ck910 FIND v(dout1_13) AT=920.05n

.meas tran vdout1_14ck910 FIND v(dout1_14) AT=920.05n

.meas tran vdout1_15ck910 FIND v(dout1_15) AT=920.05n

.meas tran vdout1_16ck910 FIND v(dout1_16) AT=920.05n

.meas tran vdout1_17ck910 FIND v(dout1_17) AT=920.05n

.meas tran vdout1_18ck910 FIND v(dout1_18) AT=920.05n

.meas tran vdout1_19ck910 FIND v(dout1_19) AT=920.05n

.meas tran vdout1_20ck910 FIND v(dout1_20) AT=920.05n

.meas tran vdout1_21ck910 FIND v(dout1_21) AT=920.05n

.meas tran vdout1_22ck910 FIND v(dout1_22) AT=920.05n

.meas tran vdout1_23ck910 FIND v(dout1_23) AT=920.05n

.meas tran vdout1_24ck910 FIND v(dout1_24) AT=920.05n

.meas tran vdout1_25ck910 FIND v(dout1_25) AT=920.05n

.meas tran vdout1_26ck910 FIND v(dout1_26) AT=920.05n

.meas tran vdout1_27ck910 FIND v(dout1_27) AT=920.05n

.meas tran vdout1_28ck910 FIND v(dout1_28) AT=920.05n

.meas tran vdout1_29ck910 FIND v(dout1_29) AT=920.05n

.meas tran vdout1_30ck910 FIND v(dout1_30) AT=920.05n

.meas tran vdout1_31ck910 FIND v(dout1_31) AT=920.05n

.meas tran vdout1_32ck910 FIND v(dout1_32) AT=920.05n

.meas tran vdout1_0ck930 FIND v(dout1_0) AT=940.05n

.meas tran vdout1_1ck930 FIND v(dout1_1) AT=940.05n

.meas tran vdout1_2ck930 FIND v(dout1_2) AT=940.05n

.meas tran vdout1_3ck930 FIND v(dout1_3) AT=940.05n

.meas tran vdout1_4ck930 FIND v(dout1_4) AT=940.05n

.meas tran vdout1_5ck930 FIND v(dout1_5) AT=940.05n

.meas tran vdout1_6ck930 FIND v(dout1_6) AT=940.05n

.meas tran vdout1_7ck930 FIND v(dout1_7) AT=940.05n

.meas tran vdout1_8ck930 FIND v(dout1_8) AT=940.05n

.meas tran vdout1_9ck930 FIND v(dout1_9) AT=940.05n

.meas tran vdout1_10ck930 FIND v(dout1_10) AT=940.05n

.meas tran vdout1_11ck930 FIND v(dout1_11) AT=940.05n

.meas tran vdout1_12ck930 FIND v(dout1_12) AT=940.05n

.meas tran vdout1_13ck930 FIND v(dout1_13) AT=940.05n

.meas tran vdout1_14ck930 FIND v(dout1_14) AT=940.05n

.meas tran vdout1_15ck930 FIND v(dout1_15) AT=940.05n

.meas tran vdout1_16ck930 FIND v(dout1_16) AT=940.05n

.meas tran vdout1_17ck930 FIND v(dout1_17) AT=940.05n

.meas tran vdout1_18ck930 FIND v(dout1_18) AT=940.05n

.meas tran vdout1_19ck930 FIND v(dout1_19) AT=940.05n

.meas tran vdout1_20ck930 FIND v(dout1_20) AT=940.05n

.meas tran vdout1_21ck930 FIND v(dout1_21) AT=940.05n

.meas tran vdout1_22ck930 FIND v(dout1_22) AT=940.05n

.meas tran vdout1_23ck930 FIND v(dout1_23) AT=940.05n

.meas tran vdout1_24ck930 FIND v(dout1_24) AT=940.05n

.meas tran vdout1_25ck930 FIND v(dout1_25) AT=940.05n

.meas tran vdout1_26ck930 FIND v(dout1_26) AT=940.05n

.meas tran vdout1_27ck930 FIND v(dout1_27) AT=940.05n

.meas tran vdout1_28ck930 FIND v(dout1_28) AT=940.05n

.meas tran vdout1_29ck930 FIND v(dout1_29) AT=940.05n

.meas tran vdout1_30ck930 FIND v(dout1_30) AT=940.05n

.meas tran vdout1_31ck930 FIND v(dout1_31) AT=940.05n

.meas tran vdout1_32ck930 FIND v(dout1_32) AT=940.05n

.meas tran vdout1_0ck940 FIND v(dout1_0) AT=950.05n

.meas tran vdout1_1ck940 FIND v(dout1_1) AT=950.05n

.meas tran vdout1_2ck940 FIND v(dout1_2) AT=950.05n

.meas tran vdout1_3ck940 FIND v(dout1_3) AT=950.05n

.meas tran vdout1_4ck940 FIND v(dout1_4) AT=950.05n

.meas tran vdout1_5ck940 FIND v(dout1_5) AT=950.05n

.meas tran vdout1_6ck940 FIND v(dout1_6) AT=950.05n

.meas tran vdout1_7ck940 FIND v(dout1_7) AT=950.05n

.meas tran vdout1_8ck940 FIND v(dout1_8) AT=950.05n

.meas tran vdout1_9ck940 FIND v(dout1_9) AT=950.05n

.meas tran vdout1_10ck940 FIND v(dout1_10) AT=950.05n

.meas tran vdout1_11ck940 FIND v(dout1_11) AT=950.05n

.meas tran vdout1_12ck940 FIND v(dout1_12) AT=950.05n

.meas tran vdout1_13ck940 FIND v(dout1_13) AT=950.05n

.meas tran vdout1_14ck940 FIND v(dout1_14) AT=950.05n

.meas tran vdout1_15ck940 FIND v(dout1_15) AT=950.05n

.meas tran vdout1_16ck940 FIND v(dout1_16) AT=950.05n

.meas tran vdout1_17ck940 FIND v(dout1_17) AT=950.05n

.meas tran vdout1_18ck940 FIND v(dout1_18) AT=950.05n

.meas tran vdout1_19ck940 FIND v(dout1_19) AT=950.05n

.meas tran vdout1_20ck940 FIND v(dout1_20) AT=950.05n

.meas tran vdout1_21ck940 FIND v(dout1_21) AT=950.05n

.meas tran vdout1_22ck940 FIND v(dout1_22) AT=950.05n

.meas tran vdout1_23ck940 FIND v(dout1_23) AT=950.05n

.meas tran vdout1_24ck940 FIND v(dout1_24) AT=950.05n

.meas tran vdout1_25ck940 FIND v(dout1_25) AT=950.05n

.meas tran vdout1_26ck940 FIND v(dout1_26) AT=950.05n

.meas tran vdout1_27ck940 FIND v(dout1_27) AT=950.05n

.meas tran vdout1_28ck940 FIND v(dout1_28) AT=950.05n

.meas tran vdout1_29ck940 FIND v(dout1_29) AT=950.05n

.meas tran vdout1_30ck940 FIND v(dout1_30) AT=950.05n

.meas tran vdout1_31ck940 FIND v(dout1_31) AT=950.05n

.meas tran vdout1_32ck940 FIND v(dout1_32) AT=950.05n

.meas tran vdout1_0ck950 FIND v(dout1_0) AT=960.05n

.meas tran vdout1_1ck950 FIND v(dout1_1) AT=960.05n

.meas tran vdout1_2ck950 FIND v(dout1_2) AT=960.05n

.meas tran vdout1_3ck950 FIND v(dout1_3) AT=960.05n

.meas tran vdout1_4ck950 FIND v(dout1_4) AT=960.05n

.meas tran vdout1_5ck950 FIND v(dout1_5) AT=960.05n

.meas tran vdout1_6ck950 FIND v(dout1_6) AT=960.05n

.meas tran vdout1_7ck950 FIND v(dout1_7) AT=960.05n

.meas tran vdout1_8ck950 FIND v(dout1_8) AT=960.05n

.meas tran vdout1_9ck950 FIND v(dout1_9) AT=960.05n

.meas tran vdout1_10ck950 FIND v(dout1_10) AT=960.05n

.meas tran vdout1_11ck950 FIND v(dout1_11) AT=960.05n

.meas tran vdout1_12ck950 FIND v(dout1_12) AT=960.05n

.meas tran vdout1_13ck950 FIND v(dout1_13) AT=960.05n

.meas tran vdout1_14ck950 FIND v(dout1_14) AT=960.05n

.meas tran vdout1_15ck950 FIND v(dout1_15) AT=960.05n

.meas tran vdout1_16ck950 FIND v(dout1_16) AT=960.05n

.meas tran vdout1_17ck950 FIND v(dout1_17) AT=960.05n

.meas tran vdout1_18ck950 FIND v(dout1_18) AT=960.05n

.meas tran vdout1_19ck950 FIND v(dout1_19) AT=960.05n

.meas tran vdout1_20ck950 FIND v(dout1_20) AT=960.05n

.meas tran vdout1_21ck950 FIND v(dout1_21) AT=960.05n

.meas tran vdout1_22ck950 FIND v(dout1_22) AT=960.05n

.meas tran vdout1_23ck950 FIND v(dout1_23) AT=960.05n

.meas tran vdout1_24ck950 FIND v(dout1_24) AT=960.05n

.meas tran vdout1_25ck950 FIND v(dout1_25) AT=960.05n

.meas tran vdout1_26ck950 FIND v(dout1_26) AT=960.05n

.meas tran vdout1_27ck950 FIND v(dout1_27) AT=960.05n

.meas tran vdout1_28ck950 FIND v(dout1_28) AT=960.05n

.meas tran vdout1_29ck950 FIND v(dout1_29) AT=960.05n

.meas tran vdout1_30ck950 FIND v(dout1_30) AT=960.05n

.meas tran vdout1_31ck950 FIND v(dout1_31) AT=960.05n

.meas tran vdout1_32ck950 FIND v(dout1_32) AT=960.05n

.meas tran vdout1_0ck980 FIND v(dout1_0) AT=990.05n

.meas tran vdout1_1ck980 FIND v(dout1_1) AT=990.05n

.meas tran vdout1_2ck980 FIND v(dout1_2) AT=990.05n

.meas tran vdout1_3ck980 FIND v(dout1_3) AT=990.05n

.meas tran vdout1_4ck980 FIND v(dout1_4) AT=990.05n

.meas tran vdout1_5ck980 FIND v(dout1_5) AT=990.05n

.meas tran vdout1_6ck980 FIND v(dout1_6) AT=990.05n

.meas tran vdout1_7ck980 FIND v(dout1_7) AT=990.05n

.meas tran vdout1_8ck980 FIND v(dout1_8) AT=990.05n

.meas tran vdout1_9ck980 FIND v(dout1_9) AT=990.05n

.meas tran vdout1_10ck980 FIND v(dout1_10) AT=990.05n

.meas tran vdout1_11ck980 FIND v(dout1_11) AT=990.05n

.meas tran vdout1_12ck980 FIND v(dout1_12) AT=990.05n

.meas tran vdout1_13ck980 FIND v(dout1_13) AT=990.05n

.meas tran vdout1_14ck980 FIND v(dout1_14) AT=990.05n

.meas tran vdout1_15ck980 FIND v(dout1_15) AT=990.05n

.meas tran vdout1_16ck980 FIND v(dout1_16) AT=990.05n

.meas tran vdout1_17ck980 FIND v(dout1_17) AT=990.05n

.meas tran vdout1_18ck980 FIND v(dout1_18) AT=990.05n

.meas tran vdout1_19ck980 FIND v(dout1_19) AT=990.05n

.meas tran vdout1_20ck980 FIND v(dout1_20) AT=990.05n

.meas tran vdout1_21ck980 FIND v(dout1_21) AT=990.05n

.meas tran vdout1_22ck980 FIND v(dout1_22) AT=990.05n

.meas tran vdout1_23ck980 FIND v(dout1_23) AT=990.05n

.meas tran vdout1_24ck980 FIND v(dout1_24) AT=990.05n

.meas tran vdout1_25ck980 FIND v(dout1_25) AT=990.05n

.meas tran vdout1_26ck980 FIND v(dout1_26) AT=990.05n

.meas tran vdout1_27ck980 FIND v(dout1_27) AT=990.05n

.meas tran vdout1_28ck980 FIND v(dout1_28) AT=990.05n

.meas tran vdout1_29ck980 FIND v(dout1_29) AT=990.05n

.meas tran vdout1_30ck980 FIND v(dout1_30) AT=990.05n

.meas tran vdout1_31ck980 FIND v(dout1_31) AT=990.05n

.meas tran vdout1_32ck980 FIND v(dout1_32) AT=990.05n

.meas tran vdout1_0ck990 FIND v(dout1_0) AT=1000.05n

.meas tran vdout1_1ck990 FIND v(dout1_1) AT=1000.05n

.meas tran vdout1_2ck990 FIND v(dout1_2) AT=1000.05n

.meas tran vdout1_3ck990 FIND v(dout1_3) AT=1000.05n

.meas tran vdout1_4ck990 FIND v(dout1_4) AT=1000.05n

.meas tran vdout1_5ck990 FIND v(dout1_5) AT=1000.05n

.meas tran vdout1_6ck990 FIND v(dout1_6) AT=1000.05n

.meas tran vdout1_7ck990 FIND v(dout1_7) AT=1000.05n

.meas tran vdout1_8ck990 FIND v(dout1_8) AT=1000.05n

.meas tran vdout1_9ck990 FIND v(dout1_9) AT=1000.05n

.meas tran vdout1_10ck990 FIND v(dout1_10) AT=1000.05n

.meas tran vdout1_11ck990 FIND v(dout1_11) AT=1000.05n

.meas tran vdout1_12ck990 FIND v(dout1_12) AT=1000.05n

.meas tran vdout1_13ck990 FIND v(dout1_13) AT=1000.05n

.meas tran vdout1_14ck990 FIND v(dout1_14) AT=1000.05n

.meas tran vdout1_15ck990 FIND v(dout1_15) AT=1000.05n

.meas tran vdout1_16ck990 FIND v(dout1_16) AT=1000.05n

.meas tran vdout1_17ck990 FIND v(dout1_17) AT=1000.05n

.meas tran vdout1_18ck990 FIND v(dout1_18) AT=1000.05n

.meas tran vdout1_19ck990 FIND v(dout1_19) AT=1000.05n

.meas tran vdout1_20ck990 FIND v(dout1_20) AT=1000.05n

.meas tran vdout1_21ck990 FIND v(dout1_21) AT=1000.05n

.meas tran vdout1_22ck990 FIND v(dout1_22) AT=1000.05n

.meas tran vdout1_23ck990 FIND v(dout1_23) AT=1000.05n

.meas tran vdout1_24ck990 FIND v(dout1_24) AT=1000.05n

.meas tran vdout1_25ck990 FIND v(dout1_25) AT=1000.05n

.meas tran vdout1_26ck990 FIND v(dout1_26) AT=1000.05n

.meas tran vdout1_27ck990 FIND v(dout1_27) AT=1000.05n

.meas tran vdout1_28ck990 FIND v(dout1_28) AT=1000.05n

.meas tran vdout1_29ck990 FIND v(dout1_29) AT=1000.05n

.meas tran vdout1_30ck990 FIND v(dout1_30) AT=1000.05n

.meas tran vdout1_31ck990 FIND v(dout1_31) AT=1000.05n

.meas tran vdout1_32ck990 FIND v(dout1_32) AT=1000.05n

.meas tran vdout1_0ck1020 FIND v(dout1_0) AT=1030.05n

.meas tran vdout1_1ck1020 FIND v(dout1_1) AT=1030.05n

.meas tran vdout1_2ck1020 FIND v(dout1_2) AT=1030.05n

.meas tran vdout1_3ck1020 FIND v(dout1_3) AT=1030.05n

.meas tran vdout1_4ck1020 FIND v(dout1_4) AT=1030.05n

.meas tran vdout1_5ck1020 FIND v(dout1_5) AT=1030.05n

.meas tran vdout1_6ck1020 FIND v(dout1_6) AT=1030.05n

.meas tran vdout1_7ck1020 FIND v(dout1_7) AT=1030.05n

.meas tran vdout1_8ck1020 FIND v(dout1_8) AT=1030.05n

.meas tran vdout1_9ck1020 FIND v(dout1_9) AT=1030.05n

.meas tran vdout1_10ck1020 FIND v(dout1_10) AT=1030.05n

.meas tran vdout1_11ck1020 FIND v(dout1_11) AT=1030.05n

.meas tran vdout1_12ck1020 FIND v(dout1_12) AT=1030.05n

.meas tran vdout1_13ck1020 FIND v(dout1_13) AT=1030.05n

.meas tran vdout1_14ck1020 FIND v(dout1_14) AT=1030.05n

.meas tran vdout1_15ck1020 FIND v(dout1_15) AT=1030.05n

.meas tran vdout1_16ck1020 FIND v(dout1_16) AT=1030.05n

.meas tran vdout1_17ck1020 FIND v(dout1_17) AT=1030.05n

.meas tran vdout1_18ck1020 FIND v(dout1_18) AT=1030.05n

.meas tran vdout1_19ck1020 FIND v(dout1_19) AT=1030.05n

.meas tran vdout1_20ck1020 FIND v(dout1_20) AT=1030.05n

.meas tran vdout1_21ck1020 FIND v(dout1_21) AT=1030.05n

.meas tran vdout1_22ck1020 FIND v(dout1_22) AT=1030.05n

.meas tran vdout1_23ck1020 FIND v(dout1_23) AT=1030.05n

.meas tran vdout1_24ck1020 FIND v(dout1_24) AT=1030.05n

.meas tran vdout1_25ck1020 FIND v(dout1_25) AT=1030.05n

.meas tran vdout1_26ck1020 FIND v(dout1_26) AT=1030.05n

.meas tran vdout1_27ck1020 FIND v(dout1_27) AT=1030.05n

.meas tran vdout1_28ck1020 FIND v(dout1_28) AT=1030.05n

.meas tran vdout1_29ck1020 FIND v(dout1_29) AT=1030.05n

.meas tran vdout1_30ck1020 FIND v(dout1_30) AT=1030.05n

.meas tran vdout1_31ck1020 FIND v(dout1_31) AT=1030.05n

.meas tran vdout1_32ck1020 FIND v(dout1_32) AT=1030.05n

.meas tran vdout1_0ck1030 FIND v(dout1_0) AT=1040.05n

.meas tran vdout1_1ck1030 FIND v(dout1_1) AT=1040.05n

.meas tran vdout1_2ck1030 FIND v(dout1_2) AT=1040.05n

.meas tran vdout1_3ck1030 FIND v(dout1_3) AT=1040.05n

.meas tran vdout1_4ck1030 FIND v(dout1_4) AT=1040.05n

.meas tran vdout1_5ck1030 FIND v(dout1_5) AT=1040.05n

.meas tran vdout1_6ck1030 FIND v(dout1_6) AT=1040.05n

.meas tran vdout1_7ck1030 FIND v(dout1_7) AT=1040.05n

.meas tran vdout1_8ck1030 FIND v(dout1_8) AT=1040.05n

.meas tran vdout1_9ck1030 FIND v(dout1_9) AT=1040.05n

.meas tran vdout1_10ck1030 FIND v(dout1_10) AT=1040.05n

.meas tran vdout1_11ck1030 FIND v(dout1_11) AT=1040.05n

.meas tran vdout1_12ck1030 FIND v(dout1_12) AT=1040.05n

.meas tran vdout1_13ck1030 FIND v(dout1_13) AT=1040.05n

.meas tran vdout1_14ck1030 FIND v(dout1_14) AT=1040.05n

.meas tran vdout1_15ck1030 FIND v(dout1_15) AT=1040.05n

.meas tran vdout1_16ck1030 FIND v(dout1_16) AT=1040.05n

.meas tran vdout1_17ck1030 FIND v(dout1_17) AT=1040.05n

.meas tran vdout1_18ck1030 FIND v(dout1_18) AT=1040.05n

.meas tran vdout1_19ck1030 FIND v(dout1_19) AT=1040.05n

.meas tran vdout1_20ck1030 FIND v(dout1_20) AT=1040.05n

.meas tran vdout1_21ck1030 FIND v(dout1_21) AT=1040.05n

.meas tran vdout1_22ck1030 FIND v(dout1_22) AT=1040.05n

.meas tran vdout1_23ck1030 FIND v(dout1_23) AT=1040.05n

.meas tran vdout1_24ck1030 FIND v(dout1_24) AT=1040.05n

.meas tran vdout1_25ck1030 FIND v(dout1_25) AT=1040.05n

.meas tran vdout1_26ck1030 FIND v(dout1_26) AT=1040.05n

.meas tran vdout1_27ck1030 FIND v(dout1_27) AT=1040.05n

.meas tran vdout1_28ck1030 FIND v(dout1_28) AT=1040.05n

.meas tran vdout1_29ck1030 FIND v(dout1_29) AT=1040.05n

.meas tran vdout1_30ck1030 FIND v(dout1_30) AT=1040.05n

.meas tran vdout1_31ck1030 FIND v(dout1_31) AT=1040.05n

.meas tran vdout1_32ck1030 FIND v(dout1_32) AT=1040.05n

.meas tran vdout1_0ck1060 FIND v(dout1_0) AT=1070.05n

.meas tran vdout1_1ck1060 FIND v(dout1_1) AT=1070.05n

.meas tran vdout1_2ck1060 FIND v(dout1_2) AT=1070.05n

.meas tran vdout1_3ck1060 FIND v(dout1_3) AT=1070.05n

.meas tran vdout1_4ck1060 FIND v(dout1_4) AT=1070.05n

.meas tran vdout1_5ck1060 FIND v(dout1_5) AT=1070.05n

.meas tran vdout1_6ck1060 FIND v(dout1_6) AT=1070.05n

.meas tran vdout1_7ck1060 FIND v(dout1_7) AT=1070.05n

.meas tran vdout1_8ck1060 FIND v(dout1_8) AT=1070.05n

.meas tran vdout1_9ck1060 FIND v(dout1_9) AT=1070.05n

.meas tran vdout1_10ck1060 FIND v(dout1_10) AT=1070.05n

.meas tran vdout1_11ck1060 FIND v(dout1_11) AT=1070.05n

.meas tran vdout1_12ck1060 FIND v(dout1_12) AT=1070.05n

.meas tran vdout1_13ck1060 FIND v(dout1_13) AT=1070.05n

.meas tran vdout1_14ck1060 FIND v(dout1_14) AT=1070.05n

.meas tran vdout1_15ck1060 FIND v(dout1_15) AT=1070.05n

.meas tran vdout1_16ck1060 FIND v(dout1_16) AT=1070.05n

.meas tran vdout1_17ck1060 FIND v(dout1_17) AT=1070.05n

.meas tran vdout1_18ck1060 FIND v(dout1_18) AT=1070.05n

.meas tran vdout1_19ck1060 FIND v(dout1_19) AT=1070.05n

.meas tran vdout1_20ck1060 FIND v(dout1_20) AT=1070.05n

.meas tran vdout1_21ck1060 FIND v(dout1_21) AT=1070.05n

.meas tran vdout1_22ck1060 FIND v(dout1_22) AT=1070.05n

.meas tran vdout1_23ck1060 FIND v(dout1_23) AT=1070.05n

.meas tran vdout1_24ck1060 FIND v(dout1_24) AT=1070.05n

.meas tran vdout1_25ck1060 FIND v(dout1_25) AT=1070.05n

.meas tran vdout1_26ck1060 FIND v(dout1_26) AT=1070.05n

.meas tran vdout1_27ck1060 FIND v(dout1_27) AT=1070.05n

.meas tran vdout1_28ck1060 FIND v(dout1_28) AT=1070.05n

.meas tran vdout1_29ck1060 FIND v(dout1_29) AT=1070.05n

.meas tran vdout1_30ck1060 FIND v(dout1_30) AT=1070.05n

.meas tran vdout1_31ck1060 FIND v(dout1_31) AT=1070.05n

.meas tran vdout1_32ck1060 FIND v(dout1_32) AT=1070.05n

.meas tran vdout1_0ck1080 FIND v(dout1_0) AT=1090.05n

.meas tran vdout1_1ck1080 FIND v(dout1_1) AT=1090.05n

.meas tran vdout1_2ck1080 FIND v(dout1_2) AT=1090.05n

.meas tran vdout1_3ck1080 FIND v(dout1_3) AT=1090.05n

.meas tran vdout1_4ck1080 FIND v(dout1_4) AT=1090.05n

.meas tran vdout1_5ck1080 FIND v(dout1_5) AT=1090.05n

.meas tran vdout1_6ck1080 FIND v(dout1_6) AT=1090.05n

.meas tran vdout1_7ck1080 FIND v(dout1_7) AT=1090.05n

.meas tran vdout1_8ck1080 FIND v(dout1_8) AT=1090.05n

.meas tran vdout1_9ck1080 FIND v(dout1_9) AT=1090.05n

.meas tran vdout1_10ck1080 FIND v(dout1_10) AT=1090.05n

.meas tran vdout1_11ck1080 FIND v(dout1_11) AT=1090.05n

.meas tran vdout1_12ck1080 FIND v(dout1_12) AT=1090.05n

.meas tran vdout1_13ck1080 FIND v(dout1_13) AT=1090.05n

.meas tran vdout1_14ck1080 FIND v(dout1_14) AT=1090.05n

.meas tran vdout1_15ck1080 FIND v(dout1_15) AT=1090.05n

.meas tran vdout1_16ck1080 FIND v(dout1_16) AT=1090.05n

.meas tran vdout1_17ck1080 FIND v(dout1_17) AT=1090.05n

.meas tran vdout1_18ck1080 FIND v(dout1_18) AT=1090.05n

.meas tran vdout1_19ck1080 FIND v(dout1_19) AT=1090.05n

.meas tran vdout1_20ck1080 FIND v(dout1_20) AT=1090.05n

.meas tran vdout1_21ck1080 FIND v(dout1_21) AT=1090.05n

.meas tran vdout1_22ck1080 FIND v(dout1_22) AT=1090.05n

.meas tran vdout1_23ck1080 FIND v(dout1_23) AT=1090.05n

.meas tran vdout1_24ck1080 FIND v(dout1_24) AT=1090.05n

.meas tran vdout1_25ck1080 FIND v(dout1_25) AT=1090.05n

.meas tran vdout1_26ck1080 FIND v(dout1_26) AT=1090.05n

.meas tran vdout1_27ck1080 FIND v(dout1_27) AT=1090.05n

.meas tran vdout1_28ck1080 FIND v(dout1_28) AT=1090.05n

.meas tran vdout1_29ck1080 FIND v(dout1_29) AT=1090.05n

.meas tran vdout1_30ck1080 FIND v(dout1_30) AT=1090.05n

.meas tran vdout1_31ck1080 FIND v(dout1_31) AT=1090.05n

.meas tran vdout1_32ck1080 FIND v(dout1_32) AT=1090.05n

.meas tran vdout1_0ck1140 FIND v(dout1_0) AT=1150.05n

.meas tran vdout1_1ck1140 FIND v(dout1_1) AT=1150.05n

.meas tran vdout1_2ck1140 FIND v(dout1_2) AT=1150.05n

.meas tran vdout1_3ck1140 FIND v(dout1_3) AT=1150.05n

.meas tran vdout1_4ck1140 FIND v(dout1_4) AT=1150.05n

.meas tran vdout1_5ck1140 FIND v(dout1_5) AT=1150.05n

.meas tran vdout1_6ck1140 FIND v(dout1_6) AT=1150.05n

.meas tran vdout1_7ck1140 FIND v(dout1_7) AT=1150.05n

.meas tran vdout1_8ck1140 FIND v(dout1_8) AT=1150.05n

.meas tran vdout1_9ck1140 FIND v(dout1_9) AT=1150.05n

.meas tran vdout1_10ck1140 FIND v(dout1_10) AT=1150.05n

.meas tran vdout1_11ck1140 FIND v(dout1_11) AT=1150.05n

.meas tran vdout1_12ck1140 FIND v(dout1_12) AT=1150.05n

.meas tran vdout1_13ck1140 FIND v(dout1_13) AT=1150.05n

.meas tran vdout1_14ck1140 FIND v(dout1_14) AT=1150.05n

.meas tran vdout1_15ck1140 FIND v(dout1_15) AT=1150.05n

.meas tran vdout1_16ck1140 FIND v(dout1_16) AT=1150.05n

.meas tran vdout1_17ck1140 FIND v(dout1_17) AT=1150.05n

.meas tran vdout1_18ck1140 FIND v(dout1_18) AT=1150.05n

.meas tran vdout1_19ck1140 FIND v(dout1_19) AT=1150.05n

.meas tran vdout1_20ck1140 FIND v(dout1_20) AT=1150.05n

.meas tran vdout1_21ck1140 FIND v(dout1_21) AT=1150.05n

.meas tran vdout1_22ck1140 FIND v(dout1_22) AT=1150.05n

.meas tran vdout1_23ck1140 FIND v(dout1_23) AT=1150.05n

.meas tran vdout1_24ck1140 FIND v(dout1_24) AT=1150.05n

.meas tran vdout1_25ck1140 FIND v(dout1_25) AT=1150.05n

.meas tran vdout1_26ck1140 FIND v(dout1_26) AT=1150.05n

.meas tran vdout1_27ck1140 FIND v(dout1_27) AT=1150.05n

.meas tran vdout1_28ck1140 FIND v(dout1_28) AT=1150.05n

.meas tran vdout1_29ck1140 FIND v(dout1_29) AT=1150.05n

.meas tran vdout1_30ck1140 FIND v(dout1_30) AT=1150.05n

.meas tran vdout1_31ck1140 FIND v(dout1_31) AT=1150.05n

.meas tran vdout1_32ck1140 FIND v(dout1_32) AT=1150.05n

.meas tran vdout1_0ck1200 FIND v(dout1_0) AT=1210.05n

.meas tran vdout1_1ck1200 FIND v(dout1_1) AT=1210.05n

.meas tran vdout1_2ck1200 FIND v(dout1_2) AT=1210.05n

.meas tran vdout1_3ck1200 FIND v(dout1_3) AT=1210.05n

.meas tran vdout1_4ck1200 FIND v(dout1_4) AT=1210.05n

.meas tran vdout1_5ck1200 FIND v(dout1_5) AT=1210.05n

.meas tran vdout1_6ck1200 FIND v(dout1_6) AT=1210.05n

.meas tran vdout1_7ck1200 FIND v(dout1_7) AT=1210.05n

.meas tran vdout1_8ck1200 FIND v(dout1_8) AT=1210.05n

.meas tran vdout1_9ck1200 FIND v(dout1_9) AT=1210.05n

.meas tran vdout1_10ck1200 FIND v(dout1_10) AT=1210.05n

.meas tran vdout1_11ck1200 FIND v(dout1_11) AT=1210.05n

.meas tran vdout1_12ck1200 FIND v(dout1_12) AT=1210.05n

.meas tran vdout1_13ck1200 FIND v(dout1_13) AT=1210.05n

.meas tran vdout1_14ck1200 FIND v(dout1_14) AT=1210.05n

.meas tran vdout1_15ck1200 FIND v(dout1_15) AT=1210.05n

.meas tran vdout1_16ck1200 FIND v(dout1_16) AT=1210.05n

.meas tran vdout1_17ck1200 FIND v(dout1_17) AT=1210.05n

.meas tran vdout1_18ck1200 FIND v(dout1_18) AT=1210.05n

.meas tran vdout1_19ck1200 FIND v(dout1_19) AT=1210.05n

.meas tran vdout1_20ck1200 FIND v(dout1_20) AT=1210.05n

.meas tran vdout1_21ck1200 FIND v(dout1_21) AT=1210.05n

.meas tran vdout1_22ck1200 FIND v(dout1_22) AT=1210.05n

.meas tran vdout1_23ck1200 FIND v(dout1_23) AT=1210.05n

.meas tran vdout1_24ck1200 FIND v(dout1_24) AT=1210.05n

.meas tran vdout1_25ck1200 FIND v(dout1_25) AT=1210.05n

.meas tran vdout1_26ck1200 FIND v(dout1_26) AT=1210.05n

.meas tran vdout1_27ck1200 FIND v(dout1_27) AT=1210.05n

.meas tran vdout1_28ck1200 FIND v(dout1_28) AT=1210.05n

.meas tran vdout1_29ck1200 FIND v(dout1_29) AT=1210.05n

.meas tran vdout1_30ck1200 FIND v(dout1_30) AT=1210.05n

.meas tran vdout1_31ck1200 FIND v(dout1_31) AT=1210.05n

.meas tran vdout1_32ck1200 FIND v(dout1_32) AT=1210.05n

.meas tran vdout1_0ck1280 FIND v(dout1_0) AT=1290.05n

.meas tran vdout1_1ck1280 FIND v(dout1_1) AT=1290.05n

.meas tran vdout1_2ck1280 FIND v(dout1_2) AT=1290.05n

.meas tran vdout1_3ck1280 FIND v(dout1_3) AT=1290.05n

.meas tran vdout1_4ck1280 FIND v(dout1_4) AT=1290.05n

.meas tran vdout1_5ck1280 FIND v(dout1_5) AT=1290.05n

.meas tran vdout1_6ck1280 FIND v(dout1_6) AT=1290.05n

.meas tran vdout1_7ck1280 FIND v(dout1_7) AT=1290.05n

.meas tran vdout1_8ck1280 FIND v(dout1_8) AT=1290.05n

.meas tran vdout1_9ck1280 FIND v(dout1_9) AT=1290.05n

.meas tran vdout1_10ck1280 FIND v(dout1_10) AT=1290.05n

.meas tran vdout1_11ck1280 FIND v(dout1_11) AT=1290.05n

.meas tran vdout1_12ck1280 FIND v(dout1_12) AT=1290.05n

.meas tran vdout1_13ck1280 FIND v(dout1_13) AT=1290.05n

.meas tran vdout1_14ck1280 FIND v(dout1_14) AT=1290.05n

.meas tran vdout1_15ck1280 FIND v(dout1_15) AT=1290.05n

.meas tran vdout1_16ck1280 FIND v(dout1_16) AT=1290.05n

.meas tran vdout1_17ck1280 FIND v(dout1_17) AT=1290.05n

.meas tran vdout1_18ck1280 FIND v(dout1_18) AT=1290.05n

.meas tran vdout1_19ck1280 FIND v(dout1_19) AT=1290.05n

.meas tran vdout1_20ck1280 FIND v(dout1_20) AT=1290.05n

.meas tran vdout1_21ck1280 FIND v(dout1_21) AT=1290.05n

.meas tran vdout1_22ck1280 FIND v(dout1_22) AT=1290.05n

.meas tran vdout1_23ck1280 FIND v(dout1_23) AT=1290.05n

.meas tran vdout1_24ck1280 FIND v(dout1_24) AT=1290.05n

.meas tran vdout1_25ck1280 FIND v(dout1_25) AT=1290.05n

.meas tran vdout1_26ck1280 FIND v(dout1_26) AT=1290.05n

.meas tran vdout1_27ck1280 FIND v(dout1_27) AT=1290.05n

.meas tran vdout1_28ck1280 FIND v(dout1_28) AT=1290.05n

.meas tran vdout1_29ck1280 FIND v(dout1_29) AT=1290.05n

.meas tran vdout1_30ck1280 FIND v(dout1_30) AT=1290.05n

.meas tran vdout1_31ck1280 FIND v(dout1_31) AT=1290.05n

.meas tran vdout1_32ck1280 FIND v(dout1_32) AT=1290.05n

.meas tran vdout1_0ck1300 FIND v(dout1_0) AT=1310.05n

.meas tran vdout1_1ck1300 FIND v(dout1_1) AT=1310.05n

.meas tran vdout1_2ck1300 FIND v(dout1_2) AT=1310.05n

.meas tran vdout1_3ck1300 FIND v(dout1_3) AT=1310.05n

.meas tran vdout1_4ck1300 FIND v(dout1_4) AT=1310.05n

.meas tran vdout1_5ck1300 FIND v(dout1_5) AT=1310.05n

.meas tran vdout1_6ck1300 FIND v(dout1_6) AT=1310.05n

.meas tran vdout1_7ck1300 FIND v(dout1_7) AT=1310.05n

.meas tran vdout1_8ck1300 FIND v(dout1_8) AT=1310.05n

.meas tran vdout1_9ck1300 FIND v(dout1_9) AT=1310.05n

.meas tran vdout1_10ck1300 FIND v(dout1_10) AT=1310.05n

.meas tran vdout1_11ck1300 FIND v(dout1_11) AT=1310.05n

.meas tran vdout1_12ck1300 FIND v(dout1_12) AT=1310.05n

.meas tran vdout1_13ck1300 FIND v(dout1_13) AT=1310.05n

.meas tran vdout1_14ck1300 FIND v(dout1_14) AT=1310.05n

.meas tran vdout1_15ck1300 FIND v(dout1_15) AT=1310.05n

.meas tran vdout1_16ck1300 FIND v(dout1_16) AT=1310.05n

.meas tran vdout1_17ck1300 FIND v(dout1_17) AT=1310.05n

.meas tran vdout1_18ck1300 FIND v(dout1_18) AT=1310.05n

.meas tran vdout1_19ck1300 FIND v(dout1_19) AT=1310.05n

.meas tran vdout1_20ck1300 FIND v(dout1_20) AT=1310.05n

.meas tran vdout1_21ck1300 FIND v(dout1_21) AT=1310.05n

.meas tran vdout1_22ck1300 FIND v(dout1_22) AT=1310.05n

.meas tran vdout1_23ck1300 FIND v(dout1_23) AT=1310.05n

.meas tran vdout1_24ck1300 FIND v(dout1_24) AT=1310.05n

.meas tran vdout1_25ck1300 FIND v(dout1_25) AT=1310.05n

.meas tran vdout1_26ck1300 FIND v(dout1_26) AT=1310.05n

.meas tran vdout1_27ck1300 FIND v(dout1_27) AT=1310.05n

.meas tran vdout1_28ck1300 FIND v(dout1_28) AT=1310.05n

.meas tran vdout1_29ck1300 FIND v(dout1_29) AT=1310.05n

.meas tran vdout1_30ck1300 FIND v(dout1_30) AT=1310.05n

.meas tran vdout1_31ck1300 FIND v(dout1_31) AT=1310.05n

.meas tran vdout1_32ck1300 FIND v(dout1_32) AT=1310.05n

.meas tran vdout1_0ck1380 FIND v(dout1_0) AT=1390.05n

.meas tran vdout1_1ck1380 FIND v(dout1_1) AT=1390.05n

.meas tran vdout1_2ck1380 FIND v(dout1_2) AT=1390.05n

.meas tran vdout1_3ck1380 FIND v(dout1_3) AT=1390.05n

.meas tran vdout1_4ck1380 FIND v(dout1_4) AT=1390.05n

.meas tran vdout1_5ck1380 FIND v(dout1_5) AT=1390.05n

.meas tran vdout1_6ck1380 FIND v(dout1_6) AT=1390.05n

.meas tran vdout1_7ck1380 FIND v(dout1_7) AT=1390.05n

.meas tran vdout1_8ck1380 FIND v(dout1_8) AT=1390.05n

.meas tran vdout1_9ck1380 FIND v(dout1_9) AT=1390.05n

.meas tran vdout1_10ck1380 FIND v(dout1_10) AT=1390.05n

.meas tran vdout1_11ck1380 FIND v(dout1_11) AT=1390.05n

.meas tran vdout1_12ck1380 FIND v(dout1_12) AT=1390.05n

.meas tran vdout1_13ck1380 FIND v(dout1_13) AT=1390.05n

.meas tran vdout1_14ck1380 FIND v(dout1_14) AT=1390.05n

.meas tran vdout1_15ck1380 FIND v(dout1_15) AT=1390.05n

.meas tran vdout1_16ck1380 FIND v(dout1_16) AT=1390.05n

.meas tran vdout1_17ck1380 FIND v(dout1_17) AT=1390.05n

.meas tran vdout1_18ck1380 FIND v(dout1_18) AT=1390.05n

.meas tran vdout1_19ck1380 FIND v(dout1_19) AT=1390.05n

.meas tran vdout1_20ck1380 FIND v(dout1_20) AT=1390.05n

.meas tran vdout1_21ck1380 FIND v(dout1_21) AT=1390.05n

.meas tran vdout1_22ck1380 FIND v(dout1_22) AT=1390.05n

.meas tran vdout1_23ck1380 FIND v(dout1_23) AT=1390.05n

.meas tran vdout1_24ck1380 FIND v(dout1_24) AT=1390.05n

.meas tran vdout1_25ck1380 FIND v(dout1_25) AT=1390.05n

.meas tran vdout1_26ck1380 FIND v(dout1_26) AT=1390.05n

.meas tran vdout1_27ck1380 FIND v(dout1_27) AT=1390.05n

.meas tran vdout1_28ck1380 FIND v(dout1_28) AT=1390.05n

.meas tran vdout1_29ck1380 FIND v(dout1_29) AT=1390.05n

.meas tran vdout1_30ck1380 FIND v(dout1_30) AT=1390.05n

.meas tran vdout1_31ck1380 FIND v(dout1_31) AT=1390.05n

.meas tran vdout1_32ck1380 FIND v(dout1_32) AT=1390.05n

.meas tran vdout1_0ck1440 FIND v(dout1_0) AT=1450.05n

.meas tran vdout1_1ck1440 FIND v(dout1_1) AT=1450.05n

.meas tran vdout1_2ck1440 FIND v(dout1_2) AT=1450.05n

.meas tran vdout1_3ck1440 FIND v(dout1_3) AT=1450.05n

.meas tran vdout1_4ck1440 FIND v(dout1_4) AT=1450.05n

.meas tran vdout1_5ck1440 FIND v(dout1_5) AT=1450.05n

.meas tran vdout1_6ck1440 FIND v(dout1_6) AT=1450.05n

.meas tran vdout1_7ck1440 FIND v(dout1_7) AT=1450.05n

.meas tran vdout1_8ck1440 FIND v(dout1_8) AT=1450.05n

.meas tran vdout1_9ck1440 FIND v(dout1_9) AT=1450.05n

.meas tran vdout1_10ck1440 FIND v(dout1_10) AT=1450.05n

.meas tran vdout1_11ck1440 FIND v(dout1_11) AT=1450.05n

.meas tran vdout1_12ck1440 FIND v(dout1_12) AT=1450.05n

.meas tran vdout1_13ck1440 FIND v(dout1_13) AT=1450.05n

.meas tran vdout1_14ck1440 FIND v(dout1_14) AT=1450.05n

.meas tran vdout1_15ck1440 FIND v(dout1_15) AT=1450.05n

.meas tran vdout1_16ck1440 FIND v(dout1_16) AT=1450.05n

.meas tran vdout1_17ck1440 FIND v(dout1_17) AT=1450.05n

.meas tran vdout1_18ck1440 FIND v(dout1_18) AT=1450.05n

.meas tran vdout1_19ck1440 FIND v(dout1_19) AT=1450.05n

.meas tran vdout1_20ck1440 FIND v(dout1_20) AT=1450.05n

.meas tran vdout1_21ck1440 FIND v(dout1_21) AT=1450.05n

.meas tran vdout1_22ck1440 FIND v(dout1_22) AT=1450.05n

.meas tran vdout1_23ck1440 FIND v(dout1_23) AT=1450.05n

.meas tran vdout1_24ck1440 FIND v(dout1_24) AT=1450.05n

.meas tran vdout1_25ck1440 FIND v(dout1_25) AT=1450.05n

.meas tran vdout1_26ck1440 FIND v(dout1_26) AT=1450.05n

.meas tran vdout1_27ck1440 FIND v(dout1_27) AT=1450.05n

.meas tran vdout1_28ck1440 FIND v(dout1_28) AT=1450.05n

.meas tran vdout1_29ck1440 FIND v(dout1_29) AT=1450.05n

.meas tran vdout1_30ck1440 FIND v(dout1_30) AT=1450.05n

.meas tran vdout1_31ck1440 FIND v(dout1_31) AT=1450.05n

.meas tran vdout1_32ck1440 FIND v(dout1_32) AT=1450.05n

.meas tran vdout1_0ck1450 FIND v(dout1_0) AT=1460.05n

.meas tran vdout1_1ck1450 FIND v(dout1_1) AT=1460.05n

.meas tran vdout1_2ck1450 FIND v(dout1_2) AT=1460.05n

.meas tran vdout1_3ck1450 FIND v(dout1_3) AT=1460.05n

.meas tran vdout1_4ck1450 FIND v(dout1_4) AT=1460.05n

.meas tran vdout1_5ck1450 FIND v(dout1_5) AT=1460.05n

.meas tran vdout1_6ck1450 FIND v(dout1_6) AT=1460.05n

.meas tran vdout1_7ck1450 FIND v(dout1_7) AT=1460.05n

.meas tran vdout1_8ck1450 FIND v(dout1_8) AT=1460.05n

.meas tran vdout1_9ck1450 FIND v(dout1_9) AT=1460.05n

.meas tran vdout1_10ck1450 FIND v(dout1_10) AT=1460.05n

.meas tran vdout1_11ck1450 FIND v(dout1_11) AT=1460.05n

.meas tran vdout1_12ck1450 FIND v(dout1_12) AT=1460.05n

.meas tran vdout1_13ck1450 FIND v(dout1_13) AT=1460.05n

.meas tran vdout1_14ck1450 FIND v(dout1_14) AT=1460.05n

.meas tran vdout1_15ck1450 FIND v(dout1_15) AT=1460.05n

.meas tran vdout1_16ck1450 FIND v(dout1_16) AT=1460.05n

.meas tran vdout1_17ck1450 FIND v(dout1_17) AT=1460.05n

.meas tran vdout1_18ck1450 FIND v(dout1_18) AT=1460.05n

.meas tran vdout1_19ck1450 FIND v(dout1_19) AT=1460.05n

.meas tran vdout1_20ck1450 FIND v(dout1_20) AT=1460.05n

.meas tran vdout1_21ck1450 FIND v(dout1_21) AT=1460.05n

.meas tran vdout1_22ck1450 FIND v(dout1_22) AT=1460.05n

.meas tran vdout1_23ck1450 FIND v(dout1_23) AT=1460.05n

.meas tran vdout1_24ck1450 FIND v(dout1_24) AT=1460.05n

.meas tran vdout1_25ck1450 FIND v(dout1_25) AT=1460.05n

.meas tran vdout1_26ck1450 FIND v(dout1_26) AT=1460.05n

.meas tran vdout1_27ck1450 FIND v(dout1_27) AT=1460.05n

.meas tran vdout1_28ck1450 FIND v(dout1_28) AT=1460.05n

.meas tran vdout1_29ck1450 FIND v(dout1_29) AT=1460.05n

.meas tran vdout1_30ck1450 FIND v(dout1_30) AT=1460.05n

.meas tran vdout1_31ck1450 FIND v(dout1_31) AT=1460.05n

.meas tran vdout1_32ck1450 FIND v(dout1_32) AT=1460.05n

.meas tran vdout1_0ck1460 FIND v(dout1_0) AT=1470.05n

.meas tran vdout1_1ck1460 FIND v(dout1_1) AT=1470.05n

.meas tran vdout1_2ck1460 FIND v(dout1_2) AT=1470.05n

.meas tran vdout1_3ck1460 FIND v(dout1_3) AT=1470.05n

.meas tran vdout1_4ck1460 FIND v(dout1_4) AT=1470.05n

.meas tran vdout1_5ck1460 FIND v(dout1_5) AT=1470.05n

.meas tran vdout1_6ck1460 FIND v(dout1_6) AT=1470.05n

.meas tran vdout1_7ck1460 FIND v(dout1_7) AT=1470.05n

.meas tran vdout1_8ck1460 FIND v(dout1_8) AT=1470.05n

.meas tran vdout1_9ck1460 FIND v(dout1_9) AT=1470.05n

.meas tran vdout1_10ck1460 FIND v(dout1_10) AT=1470.05n

.meas tran vdout1_11ck1460 FIND v(dout1_11) AT=1470.05n

.meas tran vdout1_12ck1460 FIND v(dout1_12) AT=1470.05n

.meas tran vdout1_13ck1460 FIND v(dout1_13) AT=1470.05n

.meas tran vdout1_14ck1460 FIND v(dout1_14) AT=1470.05n

.meas tran vdout1_15ck1460 FIND v(dout1_15) AT=1470.05n

.meas tran vdout1_16ck1460 FIND v(dout1_16) AT=1470.05n

.meas tran vdout1_17ck1460 FIND v(dout1_17) AT=1470.05n

.meas tran vdout1_18ck1460 FIND v(dout1_18) AT=1470.05n

.meas tran vdout1_19ck1460 FIND v(dout1_19) AT=1470.05n

.meas tran vdout1_20ck1460 FIND v(dout1_20) AT=1470.05n

.meas tran vdout1_21ck1460 FIND v(dout1_21) AT=1470.05n

.meas tran vdout1_22ck1460 FIND v(dout1_22) AT=1470.05n

.meas tran vdout1_23ck1460 FIND v(dout1_23) AT=1470.05n

.meas tran vdout1_24ck1460 FIND v(dout1_24) AT=1470.05n

.meas tran vdout1_25ck1460 FIND v(dout1_25) AT=1470.05n

.meas tran vdout1_26ck1460 FIND v(dout1_26) AT=1470.05n

.meas tran vdout1_27ck1460 FIND v(dout1_27) AT=1470.05n

.meas tran vdout1_28ck1460 FIND v(dout1_28) AT=1470.05n

.meas tran vdout1_29ck1460 FIND v(dout1_29) AT=1470.05n

.meas tran vdout1_30ck1460 FIND v(dout1_30) AT=1470.05n

.meas tran vdout1_31ck1460 FIND v(dout1_31) AT=1470.05n

.meas tran vdout1_32ck1460 FIND v(dout1_32) AT=1470.05n

.meas tran vdout1_0ck1560 FIND v(dout1_0) AT=1570.05n

.meas tran vdout1_1ck1560 FIND v(dout1_1) AT=1570.05n

.meas tran vdout1_2ck1560 FIND v(dout1_2) AT=1570.05n

.meas tran vdout1_3ck1560 FIND v(dout1_3) AT=1570.05n

.meas tran vdout1_4ck1560 FIND v(dout1_4) AT=1570.05n

.meas tran vdout1_5ck1560 FIND v(dout1_5) AT=1570.05n

.meas tran vdout1_6ck1560 FIND v(dout1_6) AT=1570.05n

.meas tran vdout1_7ck1560 FIND v(dout1_7) AT=1570.05n

.meas tran vdout1_8ck1560 FIND v(dout1_8) AT=1570.05n

.meas tran vdout1_9ck1560 FIND v(dout1_9) AT=1570.05n

.meas tran vdout1_10ck1560 FIND v(dout1_10) AT=1570.05n

.meas tran vdout1_11ck1560 FIND v(dout1_11) AT=1570.05n

.meas tran vdout1_12ck1560 FIND v(dout1_12) AT=1570.05n

.meas tran vdout1_13ck1560 FIND v(dout1_13) AT=1570.05n

.meas tran vdout1_14ck1560 FIND v(dout1_14) AT=1570.05n

.meas tran vdout1_15ck1560 FIND v(dout1_15) AT=1570.05n

.meas tran vdout1_16ck1560 FIND v(dout1_16) AT=1570.05n

.meas tran vdout1_17ck1560 FIND v(dout1_17) AT=1570.05n

.meas tran vdout1_18ck1560 FIND v(dout1_18) AT=1570.05n

.meas tran vdout1_19ck1560 FIND v(dout1_19) AT=1570.05n

.meas tran vdout1_20ck1560 FIND v(dout1_20) AT=1570.05n

.meas tran vdout1_21ck1560 FIND v(dout1_21) AT=1570.05n

.meas tran vdout1_22ck1560 FIND v(dout1_22) AT=1570.05n

.meas tran vdout1_23ck1560 FIND v(dout1_23) AT=1570.05n

.meas tran vdout1_24ck1560 FIND v(dout1_24) AT=1570.05n

.meas tran vdout1_25ck1560 FIND v(dout1_25) AT=1570.05n

.meas tran vdout1_26ck1560 FIND v(dout1_26) AT=1570.05n

.meas tran vdout1_27ck1560 FIND v(dout1_27) AT=1570.05n

.meas tran vdout1_28ck1560 FIND v(dout1_28) AT=1570.05n

.meas tran vdout1_29ck1560 FIND v(dout1_29) AT=1570.05n

.meas tran vdout1_30ck1560 FIND v(dout1_30) AT=1570.05n

.meas tran vdout1_31ck1560 FIND v(dout1_31) AT=1570.05n

.meas tran vdout1_32ck1560 FIND v(dout1_32) AT=1570.05n

.meas tran vdout1_0ck1580 FIND v(dout1_0) AT=1590.05n

.meas tran vdout1_1ck1580 FIND v(dout1_1) AT=1590.05n

.meas tran vdout1_2ck1580 FIND v(dout1_2) AT=1590.05n

.meas tran vdout1_3ck1580 FIND v(dout1_3) AT=1590.05n

.meas tran vdout1_4ck1580 FIND v(dout1_4) AT=1590.05n

.meas tran vdout1_5ck1580 FIND v(dout1_5) AT=1590.05n

.meas tran vdout1_6ck1580 FIND v(dout1_6) AT=1590.05n

.meas tran vdout1_7ck1580 FIND v(dout1_7) AT=1590.05n

.meas tran vdout1_8ck1580 FIND v(dout1_8) AT=1590.05n

.meas tran vdout1_9ck1580 FIND v(dout1_9) AT=1590.05n

.meas tran vdout1_10ck1580 FIND v(dout1_10) AT=1590.05n

.meas tran vdout1_11ck1580 FIND v(dout1_11) AT=1590.05n

.meas tran vdout1_12ck1580 FIND v(dout1_12) AT=1590.05n

.meas tran vdout1_13ck1580 FIND v(dout1_13) AT=1590.05n

.meas tran vdout1_14ck1580 FIND v(dout1_14) AT=1590.05n

.meas tran vdout1_15ck1580 FIND v(dout1_15) AT=1590.05n

.meas tran vdout1_16ck1580 FIND v(dout1_16) AT=1590.05n

.meas tran vdout1_17ck1580 FIND v(dout1_17) AT=1590.05n

.meas tran vdout1_18ck1580 FIND v(dout1_18) AT=1590.05n

.meas tran vdout1_19ck1580 FIND v(dout1_19) AT=1590.05n

.meas tran vdout1_20ck1580 FIND v(dout1_20) AT=1590.05n

.meas tran vdout1_21ck1580 FIND v(dout1_21) AT=1590.05n

.meas tran vdout1_22ck1580 FIND v(dout1_22) AT=1590.05n

.meas tran vdout1_23ck1580 FIND v(dout1_23) AT=1590.05n

.meas tran vdout1_24ck1580 FIND v(dout1_24) AT=1590.05n

.meas tran vdout1_25ck1580 FIND v(dout1_25) AT=1590.05n

.meas tran vdout1_26ck1580 FIND v(dout1_26) AT=1590.05n

.meas tran vdout1_27ck1580 FIND v(dout1_27) AT=1590.05n

.meas tran vdout1_28ck1580 FIND v(dout1_28) AT=1590.05n

.meas tran vdout1_29ck1580 FIND v(dout1_29) AT=1590.05n

.meas tran vdout1_30ck1580 FIND v(dout1_30) AT=1590.05n

.meas tran vdout1_31ck1580 FIND v(dout1_31) AT=1590.05n

.meas tran vdout1_32ck1580 FIND v(dout1_32) AT=1590.05n

.meas tran vdout1_0ck1610 FIND v(dout1_0) AT=1620.05n

.meas tran vdout1_1ck1610 FIND v(dout1_1) AT=1620.05n

.meas tran vdout1_2ck1610 FIND v(dout1_2) AT=1620.05n

.meas tran vdout1_3ck1610 FIND v(dout1_3) AT=1620.05n

.meas tran vdout1_4ck1610 FIND v(dout1_4) AT=1620.05n

.meas tran vdout1_5ck1610 FIND v(dout1_5) AT=1620.05n

.meas tran vdout1_6ck1610 FIND v(dout1_6) AT=1620.05n

.meas tran vdout1_7ck1610 FIND v(dout1_7) AT=1620.05n

.meas tran vdout1_8ck1610 FIND v(dout1_8) AT=1620.05n

.meas tran vdout1_9ck1610 FIND v(dout1_9) AT=1620.05n

.meas tran vdout1_10ck1610 FIND v(dout1_10) AT=1620.05n

.meas tran vdout1_11ck1610 FIND v(dout1_11) AT=1620.05n

.meas tran vdout1_12ck1610 FIND v(dout1_12) AT=1620.05n

.meas tran vdout1_13ck1610 FIND v(dout1_13) AT=1620.05n

.meas tran vdout1_14ck1610 FIND v(dout1_14) AT=1620.05n

.meas tran vdout1_15ck1610 FIND v(dout1_15) AT=1620.05n

.meas tran vdout1_16ck1610 FIND v(dout1_16) AT=1620.05n

.meas tran vdout1_17ck1610 FIND v(dout1_17) AT=1620.05n

.meas tran vdout1_18ck1610 FIND v(dout1_18) AT=1620.05n

.meas tran vdout1_19ck1610 FIND v(dout1_19) AT=1620.05n

.meas tran vdout1_20ck1610 FIND v(dout1_20) AT=1620.05n

.meas tran vdout1_21ck1610 FIND v(dout1_21) AT=1620.05n

.meas tran vdout1_22ck1610 FIND v(dout1_22) AT=1620.05n

.meas tran vdout1_23ck1610 FIND v(dout1_23) AT=1620.05n

.meas tran vdout1_24ck1610 FIND v(dout1_24) AT=1620.05n

.meas tran vdout1_25ck1610 FIND v(dout1_25) AT=1620.05n

.meas tran vdout1_26ck1610 FIND v(dout1_26) AT=1620.05n

.meas tran vdout1_27ck1610 FIND v(dout1_27) AT=1620.05n

.meas tran vdout1_28ck1610 FIND v(dout1_28) AT=1620.05n

.meas tran vdout1_29ck1610 FIND v(dout1_29) AT=1620.05n

.meas tran vdout1_30ck1610 FIND v(dout1_30) AT=1620.05n

.meas tran vdout1_31ck1610 FIND v(dout1_31) AT=1620.05n

.meas tran vdout1_32ck1610 FIND v(dout1_32) AT=1620.05n

.meas tran vdout1_0ck1620 FIND v(dout1_0) AT=1630.05n

.meas tran vdout1_1ck1620 FIND v(dout1_1) AT=1630.05n

.meas tran vdout1_2ck1620 FIND v(dout1_2) AT=1630.05n

.meas tran vdout1_3ck1620 FIND v(dout1_3) AT=1630.05n

.meas tran vdout1_4ck1620 FIND v(dout1_4) AT=1630.05n

.meas tran vdout1_5ck1620 FIND v(dout1_5) AT=1630.05n

.meas tran vdout1_6ck1620 FIND v(dout1_6) AT=1630.05n

.meas tran vdout1_7ck1620 FIND v(dout1_7) AT=1630.05n

.meas tran vdout1_8ck1620 FIND v(dout1_8) AT=1630.05n

.meas tran vdout1_9ck1620 FIND v(dout1_9) AT=1630.05n

.meas tran vdout1_10ck1620 FIND v(dout1_10) AT=1630.05n

.meas tran vdout1_11ck1620 FIND v(dout1_11) AT=1630.05n

.meas tran vdout1_12ck1620 FIND v(dout1_12) AT=1630.05n

.meas tran vdout1_13ck1620 FIND v(dout1_13) AT=1630.05n

.meas tran vdout1_14ck1620 FIND v(dout1_14) AT=1630.05n

.meas tran vdout1_15ck1620 FIND v(dout1_15) AT=1630.05n

.meas tran vdout1_16ck1620 FIND v(dout1_16) AT=1630.05n

.meas tran vdout1_17ck1620 FIND v(dout1_17) AT=1630.05n

.meas tran vdout1_18ck1620 FIND v(dout1_18) AT=1630.05n

.meas tran vdout1_19ck1620 FIND v(dout1_19) AT=1630.05n

.meas tran vdout1_20ck1620 FIND v(dout1_20) AT=1630.05n

.meas tran vdout1_21ck1620 FIND v(dout1_21) AT=1630.05n

.meas tran vdout1_22ck1620 FIND v(dout1_22) AT=1630.05n

.meas tran vdout1_23ck1620 FIND v(dout1_23) AT=1630.05n

.meas tran vdout1_24ck1620 FIND v(dout1_24) AT=1630.05n

.meas tran vdout1_25ck1620 FIND v(dout1_25) AT=1630.05n

.meas tran vdout1_26ck1620 FIND v(dout1_26) AT=1630.05n

.meas tran vdout1_27ck1620 FIND v(dout1_27) AT=1630.05n

.meas tran vdout1_28ck1620 FIND v(dout1_28) AT=1630.05n

.meas tran vdout1_29ck1620 FIND v(dout1_29) AT=1630.05n

.meas tran vdout1_30ck1620 FIND v(dout1_30) AT=1630.05n

.meas tran vdout1_31ck1620 FIND v(dout1_31) AT=1630.05n

.meas tran vdout1_32ck1620 FIND v(dout1_32) AT=1630.05n

.meas tran vdout1_0ck1640 FIND v(dout1_0) AT=1650.05n

.meas tran vdout1_1ck1640 FIND v(dout1_1) AT=1650.05n

.meas tran vdout1_2ck1640 FIND v(dout1_2) AT=1650.05n

.meas tran vdout1_3ck1640 FIND v(dout1_3) AT=1650.05n

.meas tran vdout1_4ck1640 FIND v(dout1_4) AT=1650.05n

.meas tran vdout1_5ck1640 FIND v(dout1_5) AT=1650.05n

.meas tran vdout1_6ck1640 FIND v(dout1_6) AT=1650.05n

.meas tran vdout1_7ck1640 FIND v(dout1_7) AT=1650.05n

.meas tran vdout1_8ck1640 FIND v(dout1_8) AT=1650.05n

.meas tran vdout1_9ck1640 FIND v(dout1_9) AT=1650.05n

.meas tran vdout1_10ck1640 FIND v(dout1_10) AT=1650.05n

.meas tran vdout1_11ck1640 FIND v(dout1_11) AT=1650.05n

.meas tran vdout1_12ck1640 FIND v(dout1_12) AT=1650.05n

.meas tran vdout1_13ck1640 FIND v(dout1_13) AT=1650.05n

.meas tran vdout1_14ck1640 FIND v(dout1_14) AT=1650.05n

.meas tran vdout1_15ck1640 FIND v(dout1_15) AT=1650.05n

.meas tran vdout1_16ck1640 FIND v(dout1_16) AT=1650.05n

.meas tran vdout1_17ck1640 FIND v(dout1_17) AT=1650.05n

.meas tran vdout1_18ck1640 FIND v(dout1_18) AT=1650.05n

.meas tran vdout1_19ck1640 FIND v(dout1_19) AT=1650.05n

.meas tran vdout1_20ck1640 FIND v(dout1_20) AT=1650.05n

.meas tran vdout1_21ck1640 FIND v(dout1_21) AT=1650.05n

.meas tran vdout1_22ck1640 FIND v(dout1_22) AT=1650.05n

.meas tran vdout1_23ck1640 FIND v(dout1_23) AT=1650.05n

.meas tran vdout1_24ck1640 FIND v(dout1_24) AT=1650.05n

.meas tran vdout1_25ck1640 FIND v(dout1_25) AT=1650.05n

.meas tran vdout1_26ck1640 FIND v(dout1_26) AT=1650.05n

.meas tran vdout1_27ck1640 FIND v(dout1_27) AT=1650.05n

.meas tran vdout1_28ck1640 FIND v(dout1_28) AT=1650.05n

.meas tran vdout1_29ck1640 FIND v(dout1_29) AT=1650.05n

.meas tran vdout1_30ck1640 FIND v(dout1_30) AT=1650.05n

.meas tran vdout1_31ck1640 FIND v(dout1_31) AT=1650.05n

.meas tran vdout1_32ck1640 FIND v(dout1_32) AT=1650.05n

.meas tran vdout1_0ck1660 FIND v(dout1_0) AT=1670.05n

.meas tran vdout1_1ck1660 FIND v(dout1_1) AT=1670.05n

.meas tran vdout1_2ck1660 FIND v(dout1_2) AT=1670.05n

.meas tran vdout1_3ck1660 FIND v(dout1_3) AT=1670.05n

.meas tran vdout1_4ck1660 FIND v(dout1_4) AT=1670.05n

.meas tran vdout1_5ck1660 FIND v(dout1_5) AT=1670.05n

.meas tran vdout1_6ck1660 FIND v(dout1_6) AT=1670.05n

.meas tran vdout1_7ck1660 FIND v(dout1_7) AT=1670.05n

.meas tran vdout1_8ck1660 FIND v(dout1_8) AT=1670.05n

.meas tran vdout1_9ck1660 FIND v(dout1_9) AT=1670.05n

.meas tran vdout1_10ck1660 FIND v(dout1_10) AT=1670.05n

.meas tran vdout1_11ck1660 FIND v(dout1_11) AT=1670.05n

.meas tran vdout1_12ck1660 FIND v(dout1_12) AT=1670.05n

.meas tran vdout1_13ck1660 FIND v(dout1_13) AT=1670.05n

.meas tran vdout1_14ck1660 FIND v(dout1_14) AT=1670.05n

.meas tran vdout1_15ck1660 FIND v(dout1_15) AT=1670.05n

.meas tran vdout1_16ck1660 FIND v(dout1_16) AT=1670.05n

.meas tran vdout1_17ck1660 FIND v(dout1_17) AT=1670.05n

.meas tran vdout1_18ck1660 FIND v(dout1_18) AT=1670.05n

.meas tran vdout1_19ck1660 FIND v(dout1_19) AT=1670.05n

.meas tran vdout1_20ck1660 FIND v(dout1_20) AT=1670.05n

.meas tran vdout1_21ck1660 FIND v(dout1_21) AT=1670.05n

.meas tran vdout1_22ck1660 FIND v(dout1_22) AT=1670.05n

.meas tran vdout1_23ck1660 FIND v(dout1_23) AT=1670.05n

.meas tran vdout1_24ck1660 FIND v(dout1_24) AT=1670.05n

.meas tran vdout1_25ck1660 FIND v(dout1_25) AT=1670.05n

.meas tran vdout1_26ck1660 FIND v(dout1_26) AT=1670.05n

.meas tran vdout1_27ck1660 FIND v(dout1_27) AT=1670.05n

.meas tran vdout1_28ck1660 FIND v(dout1_28) AT=1670.05n

.meas tran vdout1_29ck1660 FIND v(dout1_29) AT=1670.05n

.meas tran vdout1_30ck1660 FIND v(dout1_30) AT=1670.05n

.meas tran vdout1_31ck1660 FIND v(dout1_31) AT=1670.05n

.meas tran vdout1_32ck1660 FIND v(dout1_32) AT=1670.05n

.meas tran vdout1_0ck1790 FIND v(dout1_0) AT=1800.05n

.meas tran vdout1_1ck1790 FIND v(dout1_1) AT=1800.05n

.meas tran vdout1_2ck1790 FIND v(dout1_2) AT=1800.05n

.meas tran vdout1_3ck1790 FIND v(dout1_3) AT=1800.05n

.meas tran vdout1_4ck1790 FIND v(dout1_4) AT=1800.05n

.meas tran vdout1_5ck1790 FIND v(dout1_5) AT=1800.05n

.meas tran vdout1_6ck1790 FIND v(dout1_6) AT=1800.05n

.meas tran vdout1_7ck1790 FIND v(dout1_7) AT=1800.05n

.meas tran vdout1_8ck1790 FIND v(dout1_8) AT=1800.05n

.meas tran vdout1_9ck1790 FIND v(dout1_9) AT=1800.05n

.meas tran vdout1_10ck1790 FIND v(dout1_10) AT=1800.05n

.meas tran vdout1_11ck1790 FIND v(dout1_11) AT=1800.05n

.meas tran vdout1_12ck1790 FIND v(dout1_12) AT=1800.05n

.meas tran vdout1_13ck1790 FIND v(dout1_13) AT=1800.05n

.meas tran vdout1_14ck1790 FIND v(dout1_14) AT=1800.05n

.meas tran vdout1_15ck1790 FIND v(dout1_15) AT=1800.05n

.meas tran vdout1_16ck1790 FIND v(dout1_16) AT=1800.05n

.meas tran vdout1_17ck1790 FIND v(dout1_17) AT=1800.05n

.meas tran vdout1_18ck1790 FIND v(dout1_18) AT=1800.05n

.meas tran vdout1_19ck1790 FIND v(dout1_19) AT=1800.05n

.meas tran vdout1_20ck1790 FIND v(dout1_20) AT=1800.05n

.meas tran vdout1_21ck1790 FIND v(dout1_21) AT=1800.05n

.meas tran vdout1_22ck1790 FIND v(dout1_22) AT=1800.05n

.meas tran vdout1_23ck1790 FIND v(dout1_23) AT=1800.05n

.meas tran vdout1_24ck1790 FIND v(dout1_24) AT=1800.05n

.meas tran vdout1_25ck1790 FIND v(dout1_25) AT=1800.05n

.meas tran vdout1_26ck1790 FIND v(dout1_26) AT=1800.05n

.meas tran vdout1_27ck1790 FIND v(dout1_27) AT=1800.05n

.meas tran vdout1_28ck1790 FIND v(dout1_28) AT=1800.05n

.meas tran vdout1_29ck1790 FIND v(dout1_29) AT=1800.05n

.meas tran vdout1_30ck1790 FIND v(dout1_30) AT=1800.05n

.meas tran vdout1_31ck1790 FIND v(dout1_31) AT=1800.05n

.meas tran vdout1_32ck1790 FIND v(dout1_32) AT=1800.05n

.meas tran vdout1_0ck1820 FIND v(dout1_0) AT=1830.05n

.meas tran vdout1_1ck1820 FIND v(dout1_1) AT=1830.05n

.meas tran vdout1_2ck1820 FIND v(dout1_2) AT=1830.05n

.meas tran vdout1_3ck1820 FIND v(dout1_3) AT=1830.05n

.meas tran vdout1_4ck1820 FIND v(dout1_4) AT=1830.05n

.meas tran vdout1_5ck1820 FIND v(dout1_5) AT=1830.05n

.meas tran vdout1_6ck1820 FIND v(dout1_6) AT=1830.05n

.meas tran vdout1_7ck1820 FIND v(dout1_7) AT=1830.05n

.meas tran vdout1_8ck1820 FIND v(dout1_8) AT=1830.05n

.meas tran vdout1_9ck1820 FIND v(dout1_9) AT=1830.05n

.meas tran vdout1_10ck1820 FIND v(dout1_10) AT=1830.05n

.meas tran vdout1_11ck1820 FIND v(dout1_11) AT=1830.05n

.meas tran vdout1_12ck1820 FIND v(dout1_12) AT=1830.05n

.meas tran vdout1_13ck1820 FIND v(dout1_13) AT=1830.05n

.meas tran vdout1_14ck1820 FIND v(dout1_14) AT=1830.05n

.meas tran vdout1_15ck1820 FIND v(dout1_15) AT=1830.05n

.meas tran vdout1_16ck1820 FIND v(dout1_16) AT=1830.05n

.meas tran vdout1_17ck1820 FIND v(dout1_17) AT=1830.05n

.meas tran vdout1_18ck1820 FIND v(dout1_18) AT=1830.05n

.meas tran vdout1_19ck1820 FIND v(dout1_19) AT=1830.05n

.meas tran vdout1_20ck1820 FIND v(dout1_20) AT=1830.05n

.meas tran vdout1_21ck1820 FIND v(dout1_21) AT=1830.05n

.meas tran vdout1_22ck1820 FIND v(dout1_22) AT=1830.05n

.meas tran vdout1_23ck1820 FIND v(dout1_23) AT=1830.05n

.meas tran vdout1_24ck1820 FIND v(dout1_24) AT=1830.05n

.meas tran vdout1_25ck1820 FIND v(dout1_25) AT=1830.05n

.meas tran vdout1_26ck1820 FIND v(dout1_26) AT=1830.05n

.meas tran vdout1_27ck1820 FIND v(dout1_27) AT=1830.05n

.meas tran vdout1_28ck1820 FIND v(dout1_28) AT=1830.05n

.meas tran vdout1_29ck1820 FIND v(dout1_29) AT=1830.05n

.meas tran vdout1_30ck1820 FIND v(dout1_30) AT=1830.05n

.meas tran vdout1_31ck1820 FIND v(dout1_31) AT=1830.05n

.meas tran vdout1_32ck1820 FIND v(dout1_32) AT=1830.05n

.meas tran vdout1_0ck1840 FIND v(dout1_0) AT=1850.05n

.meas tran vdout1_1ck1840 FIND v(dout1_1) AT=1850.05n

.meas tran vdout1_2ck1840 FIND v(dout1_2) AT=1850.05n

.meas tran vdout1_3ck1840 FIND v(dout1_3) AT=1850.05n

.meas tran vdout1_4ck1840 FIND v(dout1_4) AT=1850.05n

.meas tran vdout1_5ck1840 FIND v(dout1_5) AT=1850.05n

.meas tran vdout1_6ck1840 FIND v(dout1_6) AT=1850.05n

.meas tran vdout1_7ck1840 FIND v(dout1_7) AT=1850.05n

.meas tran vdout1_8ck1840 FIND v(dout1_8) AT=1850.05n

.meas tran vdout1_9ck1840 FIND v(dout1_9) AT=1850.05n

.meas tran vdout1_10ck1840 FIND v(dout1_10) AT=1850.05n

.meas tran vdout1_11ck1840 FIND v(dout1_11) AT=1850.05n

.meas tran vdout1_12ck1840 FIND v(dout1_12) AT=1850.05n

.meas tran vdout1_13ck1840 FIND v(dout1_13) AT=1850.05n

.meas tran vdout1_14ck1840 FIND v(dout1_14) AT=1850.05n

.meas tran vdout1_15ck1840 FIND v(dout1_15) AT=1850.05n

.meas tran vdout1_16ck1840 FIND v(dout1_16) AT=1850.05n

.meas tran vdout1_17ck1840 FIND v(dout1_17) AT=1850.05n

.meas tran vdout1_18ck1840 FIND v(dout1_18) AT=1850.05n

.meas tran vdout1_19ck1840 FIND v(dout1_19) AT=1850.05n

.meas tran vdout1_20ck1840 FIND v(dout1_20) AT=1850.05n

.meas tran vdout1_21ck1840 FIND v(dout1_21) AT=1850.05n

.meas tran vdout1_22ck1840 FIND v(dout1_22) AT=1850.05n

.meas tran vdout1_23ck1840 FIND v(dout1_23) AT=1850.05n

.meas tran vdout1_24ck1840 FIND v(dout1_24) AT=1850.05n

.meas tran vdout1_25ck1840 FIND v(dout1_25) AT=1850.05n

.meas tran vdout1_26ck1840 FIND v(dout1_26) AT=1850.05n

.meas tran vdout1_27ck1840 FIND v(dout1_27) AT=1850.05n

.meas tran vdout1_28ck1840 FIND v(dout1_28) AT=1850.05n

.meas tran vdout1_29ck1840 FIND v(dout1_29) AT=1850.05n

.meas tran vdout1_30ck1840 FIND v(dout1_30) AT=1850.05n

.meas tran vdout1_31ck1840 FIND v(dout1_31) AT=1850.05n

.meas tran vdout1_32ck1840 FIND v(dout1_32) AT=1850.05n

.meas tran vdout1_0ck1860 FIND v(dout1_0) AT=1870.05n

.meas tran vdout1_1ck1860 FIND v(dout1_1) AT=1870.05n

.meas tran vdout1_2ck1860 FIND v(dout1_2) AT=1870.05n

.meas tran vdout1_3ck1860 FIND v(dout1_3) AT=1870.05n

.meas tran vdout1_4ck1860 FIND v(dout1_4) AT=1870.05n

.meas tran vdout1_5ck1860 FIND v(dout1_5) AT=1870.05n

.meas tran vdout1_6ck1860 FIND v(dout1_6) AT=1870.05n

.meas tran vdout1_7ck1860 FIND v(dout1_7) AT=1870.05n

.meas tran vdout1_8ck1860 FIND v(dout1_8) AT=1870.05n

.meas tran vdout1_9ck1860 FIND v(dout1_9) AT=1870.05n

.meas tran vdout1_10ck1860 FIND v(dout1_10) AT=1870.05n

.meas tran vdout1_11ck1860 FIND v(dout1_11) AT=1870.05n

.meas tran vdout1_12ck1860 FIND v(dout1_12) AT=1870.05n

.meas tran vdout1_13ck1860 FIND v(dout1_13) AT=1870.05n

.meas tran vdout1_14ck1860 FIND v(dout1_14) AT=1870.05n

.meas tran vdout1_15ck1860 FIND v(dout1_15) AT=1870.05n

.meas tran vdout1_16ck1860 FIND v(dout1_16) AT=1870.05n

.meas tran vdout1_17ck1860 FIND v(dout1_17) AT=1870.05n

.meas tran vdout1_18ck1860 FIND v(dout1_18) AT=1870.05n

.meas tran vdout1_19ck1860 FIND v(dout1_19) AT=1870.05n

.meas tran vdout1_20ck1860 FIND v(dout1_20) AT=1870.05n

.meas tran vdout1_21ck1860 FIND v(dout1_21) AT=1870.05n

.meas tran vdout1_22ck1860 FIND v(dout1_22) AT=1870.05n

.meas tran vdout1_23ck1860 FIND v(dout1_23) AT=1870.05n

.meas tran vdout1_24ck1860 FIND v(dout1_24) AT=1870.05n

.meas tran vdout1_25ck1860 FIND v(dout1_25) AT=1870.05n

.meas tran vdout1_26ck1860 FIND v(dout1_26) AT=1870.05n

.meas tran vdout1_27ck1860 FIND v(dout1_27) AT=1870.05n

.meas tran vdout1_28ck1860 FIND v(dout1_28) AT=1870.05n

.meas tran vdout1_29ck1860 FIND v(dout1_29) AT=1870.05n

.meas tran vdout1_30ck1860 FIND v(dout1_30) AT=1870.05n

.meas tran vdout1_31ck1860 FIND v(dout1_31) AT=1870.05n

.meas tran vdout1_32ck1860 FIND v(dout1_32) AT=1870.05n

.meas tran vdout1_0ck1900 FIND v(dout1_0) AT=1910.05n

.meas tran vdout1_1ck1900 FIND v(dout1_1) AT=1910.05n

.meas tran vdout1_2ck1900 FIND v(dout1_2) AT=1910.05n

.meas tran vdout1_3ck1900 FIND v(dout1_3) AT=1910.05n

.meas tran vdout1_4ck1900 FIND v(dout1_4) AT=1910.05n

.meas tran vdout1_5ck1900 FIND v(dout1_5) AT=1910.05n

.meas tran vdout1_6ck1900 FIND v(dout1_6) AT=1910.05n

.meas tran vdout1_7ck1900 FIND v(dout1_7) AT=1910.05n

.meas tran vdout1_8ck1900 FIND v(dout1_8) AT=1910.05n

.meas tran vdout1_9ck1900 FIND v(dout1_9) AT=1910.05n

.meas tran vdout1_10ck1900 FIND v(dout1_10) AT=1910.05n

.meas tran vdout1_11ck1900 FIND v(dout1_11) AT=1910.05n

.meas tran vdout1_12ck1900 FIND v(dout1_12) AT=1910.05n

.meas tran vdout1_13ck1900 FIND v(dout1_13) AT=1910.05n

.meas tran vdout1_14ck1900 FIND v(dout1_14) AT=1910.05n

.meas tran vdout1_15ck1900 FIND v(dout1_15) AT=1910.05n

.meas tran vdout1_16ck1900 FIND v(dout1_16) AT=1910.05n

.meas tran vdout1_17ck1900 FIND v(dout1_17) AT=1910.05n

.meas tran vdout1_18ck1900 FIND v(dout1_18) AT=1910.05n

.meas tran vdout1_19ck1900 FIND v(dout1_19) AT=1910.05n

.meas tran vdout1_20ck1900 FIND v(dout1_20) AT=1910.05n

.meas tran vdout1_21ck1900 FIND v(dout1_21) AT=1910.05n

.meas tran vdout1_22ck1900 FIND v(dout1_22) AT=1910.05n

.meas tran vdout1_23ck1900 FIND v(dout1_23) AT=1910.05n

.meas tran vdout1_24ck1900 FIND v(dout1_24) AT=1910.05n

.meas tran vdout1_25ck1900 FIND v(dout1_25) AT=1910.05n

.meas tran vdout1_26ck1900 FIND v(dout1_26) AT=1910.05n

.meas tran vdout1_27ck1900 FIND v(dout1_27) AT=1910.05n

.meas tran vdout1_28ck1900 FIND v(dout1_28) AT=1910.05n

.meas tran vdout1_29ck1900 FIND v(dout1_29) AT=1910.05n

.meas tran vdout1_30ck1900 FIND v(dout1_30) AT=1910.05n

.meas tran vdout1_31ck1900 FIND v(dout1_31) AT=1910.05n

.meas tran vdout1_32ck1900 FIND v(dout1_32) AT=1910.05n

.meas tran vdout1_0ck1920 FIND v(dout1_0) AT=1930.05n

.meas tran vdout1_1ck1920 FIND v(dout1_1) AT=1930.05n

.meas tran vdout1_2ck1920 FIND v(dout1_2) AT=1930.05n

.meas tran vdout1_3ck1920 FIND v(dout1_3) AT=1930.05n

.meas tran vdout1_4ck1920 FIND v(dout1_4) AT=1930.05n

.meas tran vdout1_5ck1920 FIND v(dout1_5) AT=1930.05n

.meas tran vdout1_6ck1920 FIND v(dout1_6) AT=1930.05n

.meas tran vdout1_7ck1920 FIND v(dout1_7) AT=1930.05n

.meas tran vdout1_8ck1920 FIND v(dout1_8) AT=1930.05n

.meas tran vdout1_9ck1920 FIND v(dout1_9) AT=1930.05n

.meas tran vdout1_10ck1920 FIND v(dout1_10) AT=1930.05n

.meas tran vdout1_11ck1920 FIND v(dout1_11) AT=1930.05n

.meas tran vdout1_12ck1920 FIND v(dout1_12) AT=1930.05n

.meas tran vdout1_13ck1920 FIND v(dout1_13) AT=1930.05n

.meas tran vdout1_14ck1920 FIND v(dout1_14) AT=1930.05n

.meas tran vdout1_15ck1920 FIND v(dout1_15) AT=1930.05n

.meas tran vdout1_16ck1920 FIND v(dout1_16) AT=1930.05n

.meas tran vdout1_17ck1920 FIND v(dout1_17) AT=1930.05n

.meas tran vdout1_18ck1920 FIND v(dout1_18) AT=1930.05n

.meas tran vdout1_19ck1920 FIND v(dout1_19) AT=1930.05n

.meas tran vdout1_20ck1920 FIND v(dout1_20) AT=1930.05n

.meas tran vdout1_21ck1920 FIND v(dout1_21) AT=1930.05n

.meas tran vdout1_22ck1920 FIND v(dout1_22) AT=1930.05n

.meas tran vdout1_23ck1920 FIND v(dout1_23) AT=1930.05n

.meas tran vdout1_24ck1920 FIND v(dout1_24) AT=1930.05n

.meas tran vdout1_25ck1920 FIND v(dout1_25) AT=1930.05n

.meas tran vdout1_26ck1920 FIND v(dout1_26) AT=1930.05n

.meas tran vdout1_27ck1920 FIND v(dout1_27) AT=1930.05n

.meas tran vdout1_28ck1920 FIND v(dout1_28) AT=1930.05n

.meas tran vdout1_29ck1920 FIND v(dout1_29) AT=1930.05n

.meas tran vdout1_30ck1920 FIND v(dout1_30) AT=1930.05n

.meas tran vdout1_31ck1920 FIND v(dout1_31) AT=1930.05n

.meas tran vdout1_32ck1920 FIND v(dout1_32) AT=1930.05n

.meas tran vdout1_0ck1930 FIND v(dout1_0) AT=1940.05n

.meas tran vdout1_1ck1930 FIND v(dout1_1) AT=1940.05n

.meas tran vdout1_2ck1930 FIND v(dout1_2) AT=1940.05n

.meas tran vdout1_3ck1930 FIND v(dout1_3) AT=1940.05n

.meas tran vdout1_4ck1930 FIND v(dout1_4) AT=1940.05n

.meas tran vdout1_5ck1930 FIND v(dout1_5) AT=1940.05n

.meas tran vdout1_6ck1930 FIND v(dout1_6) AT=1940.05n

.meas tran vdout1_7ck1930 FIND v(dout1_7) AT=1940.05n

.meas tran vdout1_8ck1930 FIND v(dout1_8) AT=1940.05n

.meas tran vdout1_9ck1930 FIND v(dout1_9) AT=1940.05n

.meas tran vdout1_10ck1930 FIND v(dout1_10) AT=1940.05n

.meas tran vdout1_11ck1930 FIND v(dout1_11) AT=1940.05n

.meas tran vdout1_12ck1930 FIND v(dout1_12) AT=1940.05n

.meas tran vdout1_13ck1930 FIND v(dout1_13) AT=1940.05n

.meas tran vdout1_14ck1930 FIND v(dout1_14) AT=1940.05n

.meas tran vdout1_15ck1930 FIND v(dout1_15) AT=1940.05n

.meas tran vdout1_16ck1930 FIND v(dout1_16) AT=1940.05n

.meas tran vdout1_17ck1930 FIND v(dout1_17) AT=1940.05n

.meas tran vdout1_18ck1930 FIND v(dout1_18) AT=1940.05n

.meas tran vdout1_19ck1930 FIND v(dout1_19) AT=1940.05n

.meas tran vdout1_20ck1930 FIND v(dout1_20) AT=1940.05n

.meas tran vdout1_21ck1930 FIND v(dout1_21) AT=1940.05n

.meas tran vdout1_22ck1930 FIND v(dout1_22) AT=1940.05n

.meas tran vdout1_23ck1930 FIND v(dout1_23) AT=1940.05n

.meas tran vdout1_24ck1930 FIND v(dout1_24) AT=1940.05n

.meas tran vdout1_25ck1930 FIND v(dout1_25) AT=1940.05n

.meas tran vdout1_26ck1930 FIND v(dout1_26) AT=1940.05n

.meas tran vdout1_27ck1930 FIND v(dout1_27) AT=1940.05n

.meas tran vdout1_28ck1930 FIND v(dout1_28) AT=1940.05n

.meas tran vdout1_29ck1930 FIND v(dout1_29) AT=1940.05n

.meas tran vdout1_30ck1930 FIND v(dout1_30) AT=1940.05n

.meas tran vdout1_31ck1930 FIND v(dout1_31) AT=1940.05n

.meas tran vdout1_32ck1930 FIND v(dout1_32) AT=1940.05n

.meas tran vdout1_0ck1960 FIND v(dout1_0) AT=1970.05n

.meas tran vdout1_1ck1960 FIND v(dout1_1) AT=1970.05n

.meas tran vdout1_2ck1960 FIND v(dout1_2) AT=1970.05n

.meas tran vdout1_3ck1960 FIND v(dout1_3) AT=1970.05n

.meas tran vdout1_4ck1960 FIND v(dout1_4) AT=1970.05n

.meas tran vdout1_5ck1960 FIND v(dout1_5) AT=1970.05n

.meas tran vdout1_6ck1960 FIND v(dout1_6) AT=1970.05n

.meas tran vdout1_7ck1960 FIND v(dout1_7) AT=1970.05n

.meas tran vdout1_8ck1960 FIND v(dout1_8) AT=1970.05n

.meas tran vdout1_9ck1960 FIND v(dout1_9) AT=1970.05n

.meas tran vdout1_10ck1960 FIND v(dout1_10) AT=1970.05n

.meas tran vdout1_11ck1960 FIND v(dout1_11) AT=1970.05n

.meas tran vdout1_12ck1960 FIND v(dout1_12) AT=1970.05n

.meas tran vdout1_13ck1960 FIND v(dout1_13) AT=1970.05n

.meas tran vdout1_14ck1960 FIND v(dout1_14) AT=1970.05n

.meas tran vdout1_15ck1960 FIND v(dout1_15) AT=1970.05n

.meas tran vdout1_16ck1960 FIND v(dout1_16) AT=1970.05n

.meas tran vdout1_17ck1960 FIND v(dout1_17) AT=1970.05n

.meas tran vdout1_18ck1960 FIND v(dout1_18) AT=1970.05n

.meas tran vdout1_19ck1960 FIND v(dout1_19) AT=1970.05n

.meas tran vdout1_20ck1960 FIND v(dout1_20) AT=1970.05n

.meas tran vdout1_21ck1960 FIND v(dout1_21) AT=1970.05n

.meas tran vdout1_22ck1960 FIND v(dout1_22) AT=1970.05n

.meas tran vdout1_23ck1960 FIND v(dout1_23) AT=1970.05n

.meas tran vdout1_24ck1960 FIND v(dout1_24) AT=1970.05n

.meas tran vdout1_25ck1960 FIND v(dout1_25) AT=1970.05n

.meas tran vdout1_26ck1960 FIND v(dout1_26) AT=1970.05n

.meas tran vdout1_27ck1960 FIND v(dout1_27) AT=1970.05n

.meas tran vdout1_28ck1960 FIND v(dout1_28) AT=1970.05n

.meas tran vdout1_29ck1960 FIND v(dout1_29) AT=1970.05n

.meas tran vdout1_30ck1960 FIND v(dout1_30) AT=1970.05n

.meas tran vdout1_31ck1960 FIND v(dout1_31) AT=1970.05n

.meas tran vdout1_32ck1960 FIND v(dout1_32) AT=1970.05n

.meas tran vdout1_0ck1970 FIND v(dout1_0) AT=1980.05n

.meas tran vdout1_1ck1970 FIND v(dout1_1) AT=1980.05n

.meas tran vdout1_2ck1970 FIND v(dout1_2) AT=1980.05n

.meas tran vdout1_3ck1970 FIND v(dout1_3) AT=1980.05n

.meas tran vdout1_4ck1970 FIND v(dout1_4) AT=1980.05n

.meas tran vdout1_5ck1970 FIND v(dout1_5) AT=1980.05n

.meas tran vdout1_6ck1970 FIND v(dout1_6) AT=1980.05n

.meas tran vdout1_7ck1970 FIND v(dout1_7) AT=1980.05n

.meas tran vdout1_8ck1970 FIND v(dout1_8) AT=1980.05n

.meas tran vdout1_9ck1970 FIND v(dout1_9) AT=1980.05n

.meas tran vdout1_10ck1970 FIND v(dout1_10) AT=1980.05n

.meas tran vdout1_11ck1970 FIND v(dout1_11) AT=1980.05n

.meas tran vdout1_12ck1970 FIND v(dout1_12) AT=1980.05n

.meas tran vdout1_13ck1970 FIND v(dout1_13) AT=1980.05n

.meas tran vdout1_14ck1970 FIND v(dout1_14) AT=1980.05n

.meas tran vdout1_15ck1970 FIND v(dout1_15) AT=1980.05n

.meas tran vdout1_16ck1970 FIND v(dout1_16) AT=1980.05n

.meas tran vdout1_17ck1970 FIND v(dout1_17) AT=1980.05n

.meas tran vdout1_18ck1970 FIND v(dout1_18) AT=1980.05n

.meas tran vdout1_19ck1970 FIND v(dout1_19) AT=1980.05n

.meas tran vdout1_20ck1970 FIND v(dout1_20) AT=1980.05n

.meas tran vdout1_21ck1970 FIND v(dout1_21) AT=1980.05n

.meas tran vdout1_22ck1970 FIND v(dout1_22) AT=1980.05n

.meas tran vdout1_23ck1970 FIND v(dout1_23) AT=1980.05n

.meas tran vdout1_24ck1970 FIND v(dout1_24) AT=1980.05n

.meas tran vdout1_25ck1970 FIND v(dout1_25) AT=1980.05n

.meas tran vdout1_26ck1970 FIND v(dout1_26) AT=1980.05n

.meas tran vdout1_27ck1970 FIND v(dout1_27) AT=1980.05n

.meas tran vdout1_28ck1970 FIND v(dout1_28) AT=1980.05n

.meas tran vdout1_29ck1970 FIND v(dout1_29) AT=1980.05n

.meas tran vdout1_30ck1970 FIND v(dout1_30) AT=1980.05n

.meas tran vdout1_31ck1970 FIND v(dout1_31) AT=1980.05n

.meas tran vdout1_32ck1970 FIND v(dout1_32) AT=1980.05n

.meas tran vdout1_0ck1990 FIND v(dout1_0) AT=2000.05n

.meas tran vdout1_1ck1990 FIND v(dout1_1) AT=2000.05n

.meas tran vdout1_2ck1990 FIND v(dout1_2) AT=2000.05n

.meas tran vdout1_3ck1990 FIND v(dout1_3) AT=2000.05n

.meas tran vdout1_4ck1990 FIND v(dout1_4) AT=2000.05n

.meas tran vdout1_5ck1990 FIND v(dout1_5) AT=2000.05n

.meas tran vdout1_6ck1990 FIND v(dout1_6) AT=2000.05n

.meas tran vdout1_7ck1990 FIND v(dout1_7) AT=2000.05n

.meas tran vdout1_8ck1990 FIND v(dout1_8) AT=2000.05n

.meas tran vdout1_9ck1990 FIND v(dout1_9) AT=2000.05n

.meas tran vdout1_10ck1990 FIND v(dout1_10) AT=2000.05n

.meas tran vdout1_11ck1990 FIND v(dout1_11) AT=2000.05n

.meas tran vdout1_12ck1990 FIND v(dout1_12) AT=2000.05n

.meas tran vdout1_13ck1990 FIND v(dout1_13) AT=2000.05n

.meas tran vdout1_14ck1990 FIND v(dout1_14) AT=2000.05n

.meas tran vdout1_15ck1990 FIND v(dout1_15) AT=2000.05n

.meas tran vdout1_16ck1990 FIND v(dout1_16) AT=2000.05n

.meas tran vdout1_17ck1990 FIND v(dout1_17) AT=2000.05n

.meas tran vdout1_18ck1990 FIND v(dout1_18) AT=2000.05n

.meas tran vdout1_19ck1990 FIND v(dout1_19) AT=2000.05n

.meas tran vdout1_20ck1990 FIND v(dout1_20) AT=2000.05n

.meas tran vdout1_21ck1990 FIND v(dout1_21) AT=2000.05n

.meas tran vdout1_22ck1990 FIND v(dout1_22) AT=2000.05n

.meas tran vdout1_23ck1990 FIND v(dout1_23) AT=2000.05n

.meas tran vdout1_24ck1990 FIND v(dout1_24) AT=2000.05n

.meas tran vdout1_25ck1990 FIND v(dout1_25) AT=2000.05n

.meas tran vdout1_26ck1990 FIND v(dout1_26) AT=2000.05n

.meas tran vdout1_27ck1990 FIND v(dout1_27) AT=2000.05n

.meas tran vdout1_28ck1990 FIND v(dout1_28) AT=2000.05n

.meas tran vdout1_29ck1990 FIND v(dout1_29) AT=2000.05n

.meas tran vdout1_30ck1990 FIND v(dout1_30) AT=2000.05n

.meas tran vdout1_31ck1990 FIND v(dout1_31) AT=2000.05n

.meas tran vdout1_32ck1990 FIND v(dout1_32) AT=2000.05n

.meas tran vdout1_0ck2000 FIND v(dout1_0) AT=2010.05n

.meas tran vdout1_1ck2000 FIND v(dout1_1) AT=2010.05n

.meas tran vdout1_2ck2000 FIND v(dout1_2) AT=2010.05n

.meas tran vdout1_3ck2000 FIND v(dout1_3) AT=2010.05n

.meas tran vdout1_4ck2000 FIND v(dout1_4) AT=2010.05n

.meas tran vdout1_5ck2000 FIND v(dout1_5) AT=2010.05n

.meas tran vdout1_6ck2000 FIND v(dout1_6) AT=2010.05n

.meas tran vdout1_7ck2000 FIND v(dout1_7) AT=2010.05n

.meas tran vdout1_8ck2000 FIND v(dout1_8) AT=2010.05n

.meas tran vdout1_9ck2000 FIND v(dout1_9) AT=2010.05n

.meas tran vdout1_10ck2000 FIND v(dout1_10) AT=2010.05n

.meas tran vdout1_11ck2000 FIND v(dout1_11) AT=2010.05n

.meas tran vdout1_12ck2000 FIND v(dout1_12) AT=2010.05n

.meas tran vdout1_13ck2000 FIND v(dout1_13) AT=2010.05n

.meas tran vdout1_14ck2000 FIND v(dout1_14) AT=2010.05n

.meas tran vdout1_15ck2000 FIND v(dout1_15) AT=2010.05n

.meas tran vdout1_16ck2000 FIND v(dout1_16) AT=2010.05n

.meas tran vdout1_17ck2000 FIND v(dout1_17) AT=2010.05n

.meas tran vdout1_18ck2000 FIND v(dout1_18) AT=2010.05n

.meas tran vdout1_19ck2000 FIND v(dout1_19) AT=2010.05n

.meas tran vdout1_20ck2000 FIND v(dout1_20) AT=2010.05n

.meas tran vdout1_21ck2000 FIND v(dout1_21) AT=2010.05n

.meas tran vdout1_22ck2000 FIND v(dout1_22) AT=2010.05n

.meas tran vdout1_23ck2000 FIND v(dout1_23) AT=2010.05n

.meas tran vdout1_24ck2000 FIND v(dout1_24) AT=2010.05n

.meas tran vdout1_25ck2000 FIND v(dout1_25) AT=2010.05n

.meas tran vdout1_26ck2000 FIND v(dout1_26) AT=2010.05n

.meas tran vdout1_27ck2000 FIND v(dout1_27) AT=2010.05n

.meas tran vdout1_28ck2000 FIND v(dout1_28) AT=2010.05n

.meas tran vdout1_29ck2000 FIND v(dout1_29) AT=2010.05n

.meas tran vdout1_30ck2000 FIND v(dout1_30) AT=2010.05n

.meas tran vdout1_31ck2000 FIND v(dout1_31) AT=2010.05n

.meas tran vdout1_32ck2000 FIND v(dout1_32) AT=2010.05n

.meas tran vdout1_0ck2020 FIND v(dout1_0) AT=2030.05n

.meas tran vdout1_1ck2020 FIND v(dout1_1) AT=2030.05n

.meas tran vdout1_2ck2020 FIND v(dout1_2) AT=2030.05n

.meas tran vdout1_3ck2020 FIND v(dout1_3) AT=2030.05n

.meas tran vdout1_4ck2020 FIND v(dout1_4) AT=2030.05n

.meas tran vdout1_5ck2020 FIND v(dout1_5) AT=2030.05n

.meas tran vdout1_6ck2020 FIND v(dout1_6) AT=2030.05n

.meas tran vdout1_7ck2020 FIND v(dout1_7) AT=2030.05n

.meas tran vdout1_8ck2020 FIND v(dout1_8) AT=2030.05n

.meas tran vdout1_9ck2020 FIND v(dout1_9) AT=2030.05n

.meas tran vdout1_10ck2020 FIND v(dout1_10) AT=2030.05n

.meas tran vdout1_11ck2020 FIND v(dout1_11) AT=2030.05n

.meas tran vdout1_12ck2020 FIND v(dout1_12) AT=2030.05n

.meas tran vdout1_13ck2020 FIND v(dout1_13) AT=2030.05n

.meas tran vdout1_14ck2020 FIND v(dout1_14) AT=2030.05n

.meas tran vdout1_15ck2020 FIND v(dout1_15) AT=2030.05n

.meas tran vdout1_16ck2020 FIND v(dout1_16) AT=2030.05n

.meas tran vdout1_17ck2020 FIND v(dout1_17) AT=2030.05n

.meas tran vdout1_18ck2020 FIND v(dout1_18) AT=2030.05n

.meas tran vdout1_19ck2020 FIND v(dout1_19) AT=2030.05n

.meas tran vdout1_20ck2020 FIND v(dout1_20) AT=2030.05n

.meas tran vdout1_21ck2020 FIND v(dout1_21) AT=2030.05n

.meas tran vdout1_22ck2020 FIND v(dout1_22) AT=2030.05n

.meas tran vdout1_23ck2020 FIND v(dout1_23) AT=2030.05n

.meas tran vdout1_24ck2020 FIND v(dout1_24) AT=2030.05n

.meas tran vdout1_25ck2020 FIND v(dout1_25) AT=2030.05n

.meas tran vdout1_26ck2020 FIND v(dout1_26) AT=2030.05n

.meas tran vdout1_27ck2020 FIND v(dout1_27) AT=2030.05n

.meas tran vdout1_28ck2020 FIND v(dout1_28) AT=2030.05n

.meas tran vdout1_29ck2020 FIND v(dout1_29) AT=2030.05n

.meas tran vdout1_30ck2020 FIND v(dout1_30) AT=2030.05n

.meas tran vdout1_31ck2020 FIND v(dout1_31) AT=2030.05n

.meas tran vdout1_32ck2020 FIND v(dout1_32) AT=2030.05n
