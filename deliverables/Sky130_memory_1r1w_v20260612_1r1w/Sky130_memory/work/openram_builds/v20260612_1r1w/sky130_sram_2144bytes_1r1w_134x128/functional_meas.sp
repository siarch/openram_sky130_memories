.meas tran vdout1_0ck40 FIND v(dout1_0) AT=50.05n

.meas tran vdout1_1ck40 FIND v(dout1_1) AT=50.05n

.meas tran vdout1_2ck40 FIND v(dout1_2) AT=50.05n

.meas tran vdout1_3ck40 FIND v(dout1_3) AT=50.05n

.meas tran vdout1_4ck40 FIND v(dout1_4) AT=50.05n

.meas tran vdout1_5ck40 FIND v(dout1_5) AT=50.05n

.meas tran vdout1_6ck40 FIND v(dout1_6) AT=50.05n

.meas tran vdout1_7ck40 FIND v(dout1_7) AT=50.05n

.meas tran vdout1_8ck40 FIND v(dout1_8) AT=50.05n

.meas tran vdout1_9ck40 FIND v(dout1_9) AT=50.05n

.meas tran vdout1_10ck40 FIND v(dout1_10) AT=50.05n

.meas tran vdout1_11ck40 FIND v(dout1_11) AT=50.05n

.meas tran vdout1_12ck40 FIND v(dout1_12) AT=50.05n

.meas tran vdout1_13ck40 FIND v(dout1_13) AT=50.05n

.meas tran vdout1_14ck40 FIND v(dout1_14) AT=50.05n

.meas tran vdout1_15ck40 FIND v(dout1_15) AT=50.05n

.meas tran vdout1_16ck40 FIND v(dout1_16) AT=50.05n

.meas tran vdout1_17ck40 FIND v(dout1_17) AT=50.05n

.meas tran vdout1_18ck40 FIND v(dout1_18) AT=50.05n

.meas tran vdout1_19ck40 FIND v(dout1_19) AT=50.05n

.meas tran vdout1_20ck40 FIND v(dout1_20) AT=50.05n

.meas tran vdout1_21ck40 FIND v(dout1_21) AT=50.05n

.meas tran vdout1_22ck40 FIND v(dout1_22) AT=50.05n

.meas tran vdout1_23ck40 FIND v(dout1_23) AT=50.05n

.meas tran vdout1_24ck40 FIND v(dout1_24) AT=50.05n

.meas tran vdout1_25ck40 FIND v(dout1_25) AT=50.05n

.meas tran vdout1_26ck40 FIND v(dout1_26) AT=50.05n

.meas tran vdout1_27ck40 FIND v(dout1_27) AT=50.05n

.meas tran vdout1_28ck40 FIND v(dout1_28) AT=50.05n

.meas tran vdout1_29ck40 FIND v(dout1_29) AT=50.05n

.meas tran vdout1_30ck40 FIND v(dout1_30) AT=50.05n

.meas tran vdout1_31ck40 FIND v(dout1_31) AT=50.05n

.meas tran vdout1_32ck40 FIND v(dout1_32) AT=50.05n

.meas tran vdout1_33ck40 FIND v(dout1_33) AT=50.05n

.meas tran vdout1_34ck40 FIND v(dout1_34) AT=50.05n

.meas tran vdout1_35ck40 FIND v(dout1_35) AT=50.05n

.meas tran vdout1_36ck40 FIND v(dout1_36) AT=50.05n

.meas tran vdout1_37ck40 FIND v(dout1_37) AT=50.05n

.meas tran vdout1_38ck40 FIND v(dout1_38) AT=50.05n

.meas tran vdout1_39ck40 FIND v(dout1_39) AT=50.05n

.meas tran vdout1_40ck40 FIND v(dout1_40) AT=50.05n

.meas tran vdout1_41ck40 FIND v(dout1_41) AT=50.05n

.meas tran vdout1_42ck40 FIND v(dout1_42) AT=50.05n

.meas tran vdout1_43ck40 FIND v(dout1_43) AT=50.05n

.meas tran vdout1_44ck40 FIND v(dout1_44) AT=50.05n

.meas tran vdout1_45ck40 FIND v(dout1_45) AT=50.05n

.meas tran vdout1_46ck40 FIND v(dout1_46) AT=50.05n

.meas tran vdout1_47ck40 FIND v(dout1_47) AT=50.05n

.meas tran vdout1_48ck40 FIND v(dout1_48) AT=50.05n

.meas tran vdout1_49ck40 FIND v(dout1_49) AT=50.05n

.meas tran vdout1_50ck40 FIND v(dout1_50) AT=50.05n

.meas tran vdout1_51ck40 FIND v(dout1_51) AT=50.05n

.meas tran vdout1_52ck40 FIND v(dout1_52) AT=50.05n

.meas tran vdout1_53ck40 FIND v(dout1_53) AT=50.05n

.meas tran vdout1_54ck40 FIND v(dout1_54) AT=50.05n

.meas tran vdout1_55ck40 FIND v(dout1_55) AT=50.05n

.meas tran vdout1_56ck40 FIND v(dout1_56) AT=50.05n

.meas tran vdout1_57ck40 FIND v(dout1_57) AT=50.05n

.meas tran vdout1_58ck40 FIND v(dout1_58) AT=50.05n

.meas tran vdout1_59ck40 FIND v(dout1_59) AT=50.05n

.meas tran vdout1_60ck40 FIND v(dout1_60) AT=50.05n

.meas tran vdout1_61ck40 FIND v(dout1_61) AT=50.05n

.meas tran vdout1_62ck40 FIND v(dout1_62) AT=50.05n

.meas tran vdout1_63ck40 FIND v(dout1_63) AT=50.05n

.meas tran vdout1_64ck40 FIND v(dout1_64) AT=50.05n

.meas tran vdout1_65ck40 FIND v(dout1_65) AT=50.05n

.meas tran vdout1_66ck40 FIND v(dout1_66) AT=50.05n

.meas tran vdout1_67ck40 FIND v(dout1_67) AT=50.05n

.meas tran vdout1_68ck40 FIND v(dout1_68) AT=50.05n

.meas tran vdout1_69ck40 FIND v(dout1_69) AT=50.05n

.meas tran vdout1_70ck40 FIND v(dout1_70) AT=50.05n

.meas tran vdout1_71ck40 FIND v(dout1_71) AT=50.05n

.meas tran vdout1_72ck40 FIND v(dout1_72) AT=50.05n

.meas tran vdout1_73ck40 FIND v(dout1_73) AT=50.05n

.meas tran vdout1_74ck40 FIND v(dout1_74) AT=50.05n

.meas tran vdout1_75ck40 FIND v(dout1_75) AT=50.05n

.meas tran vdout1_76ck40 FIND v(dout1_76) AT=50.05n

.meas tran vdout1_77ck40 FIND v(dout1_77) AT=50.05n

.meas tran vdout1_78ck40 FIND v(dout1_78) AT=50.05n

.meas tran vdout1_79ck40 FIND v(dout1_79) AT=50.05n

.meas tran vdout1_80ck40 FIND v(dout1_80) AT=50.05n

.meas tran vdout1_81ck40 FIND v(dout1_81) AT=50.05n

.meas tran vdout1_82ck40 FIND v(dout1_82) AT=50.05n

.meas tran vdout1_83ck40 FIND v(dout1_83) AT=50.05n

.meas tran vdout1_84ck40 FIND v(dout1_84) AT=50.05n

.meas tran vdout1_85ck40 FIND v(dout1_85) AT=50.05n

.meas tran vdout1_86ck40 FIND v(dout1_86) AT=50.05n

.meas tran vdout1_87ck40 FIND v(dout1_87) AT=50.05n

.meas tran vdout1_88ck40 FIND v(dout1_88) AT=50.05n

.meas tran vdout1_89ck40 FIND v(dout1_89) AT=50.05n

.meas tran vdout1_90ck40 FIND v(dout1_90) AT=50.05n

.meas tran vdout1_91ck40 FIND v(dout1_91) AT=50.05n

.meas tran vdout1_92ck40 FIND v(dout1_92) AT=50.05n

.meas tran vdout1_93ck40 FIND v(dout1_93) AT=50.05n

.meas tran vdout1_94ck40 FIND v(dout1_94) AT=50.05n

.meas tran vdout1_95ck40 FIND v(dout1_95) AT=50.05n

.meas tran vdout1_96ck40 FIND v(dout1_96) AT=50.05n

.meas tran vdout1_97ck40 FIND v(dout1_97) AT=50.05n

.meas tran vdout1_98ck40 FIND v(dout1_98) AT=50.05n

.meas tran vdout1_99ck40 FIND v(dout1_99) AT=50.05n

.meas tran vdout1_100ck40 FIND v(dout1_100) AT=50.05n

.meas tran vdout1_101ck40 FIND v(dout1_101) AT=50.05n

.meas tran vdout1_102ck40 FIND v(dout1_102) AT=50.05n

.meas tran vdout1_103ck40 FIND v(dout1_103) AT=50.05n

.meas tran vdout1_104ck40 FIND v(dout1_104) AT=50.05n

.meas tran vdout1_105ck40 FIND v(dout1_105) AT=50.05n

.meas tran vdout1_106ck40 FIND v(dout1_106) AT=50.05n

.meas tran vdout1_107ck40 FIND v(dout1_107) AT=50.05n

.meas tran vdout1_108ck40 FIND v(dout1_108) AT=50.05n

.meas tran vdout1_109ck40 FIND v(dout1_109) AT=50.05n

.meas tran vdout1_110ck40 FIND v(dout1_110) AT=50.05n

.meas tran vdout1_111ck40 FIND v(dout1_111) AT=50.05n

.meas tran vdout1_112ck40 FIND v(dout1_112) AT=50.05n

.meas tran vdout1_113ck40 FIND v(dout1_113) AT=50.05n

.meas tran vdout1_114ck40 FIND v(dout1_114) AT=50.05n

.meas tran vdout1_115ck40 FIND v(dout1_115) AT=50.05n

.meas tran vdout1_116ck40 FIND v(dout1_116) AT=50.05n

.meas tran vdout1_117ck40 FIND v(dout1_117) AT=50.05n

.meas tran vdout1_118ck40 FIND v(dout1_118) AT=50.05n

.meas tran vdout1_119ck40 FIND v(dout1_119) AT=50.05n

.meas tran vdout1_120ck40 FIND v(dout1_120) AT=50.05n

.meas tran vdout1_121ck40 FIND v(dout1_121) AT=50.05n

.meas tran vdout1_122ck40 FIND v(dout1_122) AT=50.05n

.meas tran vdout1_123ck40 FIND v(dout1_123) AT=50.05n

.meas tran vdout1_124ck40 FIND v(dout1_124) AT=50.05n

.meas tran vdout1_125ck40 FIND v(dout1_125) AT=50.05n

.meas tran vdout1_126ck40 FIND v(dout1_126) AT=50.05n

.meas tran vdout1_127ck40 FIND v(dout1_127) AT=50.05n

.meas tran vdout1_128ck40 FIND v(dout1_128) AT=50.05n

.meas tran vdout1_129ck40 FIND v(dout1_129) AT=50.05n

.meas tran vdout1_130ck40 FIND v(dout1_130) AT=50.05n

.meas tran vdout1_131ck40 FIND v(dout1_131) AT=50.05n

.meas tran vdout1_132ck40 FIND v(dout1_132) AT=50.05n

.meas tran vdout1_133ck40 FIND v(dout1_133) AT=50.05n

.meas tran vdout1_134ck40 FIND v(dout1_134) AT=50.05n

.meas tran vdout1_0ck50 FIND v(dout1_0) AT=60.05n

.meas tran vdout1_1ck50 FIND v(dout1_1) AT=60.05n

.meas tran vdout1_2ck50 FIND v(dout1_2) AT=60.05n

.meas tran vdout1_3ck50 FIND v(dout1_3) AT=60.05n

.meas tran vdout1_4ck50 FIND v(dout1_4) AT=60.05n

.meas tran vdout1_5ck50 FIND v(dout1_5) AT=60.05n

.meas tran vdout1_6ck50 FIND v(dout1_6) AT=60.05n

.meas tran vdout1_7ck50 FIND v(dout1_7) AT=60.05n

.meas tran vdout1_8ck50 FIND v(dout1_8) AT=60.05n

.meas tran vdout1_9ck50 FIND v(dout1_9) AT=60.05n

.meas tran vdout1_10ck50 FIND v(dout1_10) AT=60.05n

.meas tran vdout1_11ck50 FIND v(dout1_11) AT=60.05n

.meas tran vdout1_12ck50 FIND v(dout1_12) AT=60.05n

.meas tran vdout1_13ck50 FIND v(dout1_13) AT=60.05n

.meas tran vdout1_14ck50 FIND v(dout1_14) AT=60.05n

.meas tran vdout1_15ck50 FIND v(dout1_15) AT=60.05n

.meas tran vdout1_16ck50 FIND v(dout1_16) AT=60.05n

.meas tran vdout1_17ck50 FIND v(dout1_17) AT=60.05n

.meas tran vdout1_18ck50 FIND v(dout1_18) AT=60.05n

.meas tran vdout1_19ck50 FIND v(dout1_19) AT=60.05n

.meas tran vdout1_20ck50 FIND v(dout1_20) AT=60.05n

.meas tran vdout1_21ck50 FIND v(dout1_21) AT=60.05n

.meas tran vdout1_22ck50 FIND v(dout1_22) AT=60.05n

.meas tran vdout1_23ck50 FIND v(dout1_23) AT=60.05n

.meas tran vdout1_24ck50 FIND v(dout1_24) AT=60.05n

.meas tran vdout1_25ck50 FIND v(dout1_25) AT=60.05n

.meas tran vdout1_26ck50 FIND v(dout1_26) AT=60.05n

.meas tran vdout1_27ck50 FIND v(dout1_27) AT=60.05n

.meas tran vdout1_28ck50 FIND v(dout1_28) AT=60.05n

.meas tran vdout1_29ck50 FIND v(dout1_29) AT=60.05n

.meas tran vdout1_30ck50 FIND v(dout1_30) AT=60.05n

.meas tran vdout1_31ck50 FIND v(dout1_31) AT=60.05n

.meas tran vdout1_32ck50 FIND v(dout1_32) AT=60.05n

.meas tran vdout1_33ck50 FIND v(dout1_33) AT=60.05n

.meas tran vdout1_34ck50 FIND v(dout1_34) AT=60.05n

.meas tran vdout1_35ck50 FIND v(dout1_35) AT=60.05n

.meas tran vdout1_36ck50 FIND v(dout1_36) AT=60.05n

.meas tran vdout1_37ck50 FIND v(dout1_37) AT=60.05n

.meas tran vdout1_38ck50 FIND v(dout1_38) AT=60.05n

.meas tran vdout1_39ck50 FIND v(dout1_39) AT=60.05n

.meas tran vdout1_40ck50 FIND v(dout1_40) AT=60.05n

.meas tran vdout1_41ck50 FIND v(dout1_41) AT=60.05n

.meas tran vdout1_42ck50 FIND v(dout1_42) AT=60.05n

.meas tran vdout1_43ck50 FIND v(dout1_43) AT=60.05n

.meas tran vdout1_44ck50 FIND v(dout1_44) AT=60.05n

.meas tran vdout1_45ck50 FIND v(dout1_45) AT=60.05n

.meas tran vdout1_46ck50 FIND v(dout1_46) AT=60.05n

.meas tran vdout1_47ck50 FIND v(dout1_47) AT=60.05n

.meas tran vdout1_48ck50 FIND v(dout1_48) AT=60.05n

.meas tran vdout1_49ck50 FIND v(dout1_49) AT=60.05n

.meas tran vdout1_50ck50 FIND v(dout1_50) AT=60.05n

.meas tran vdout1_51ck50 FIND v(dout1_51) AT=60.05n

.meas tran vdout1_52ck50 FIND v(dout1_52) AT=60.05n

.meas tran vdout1_53ck50 FIND v(dout1_53) AT=60.05n

.meas tran vdout1_54ck50 FIND v(dout1_54) AT=60.05n

.meas tran vdout1_55ck50 FIND v(dout1_55) AT=60.05n

.meas tran vdout1_56ck50 FIND v(dout1_56) AT=60.05n

.meas tran vdout1_57ck50 FIND v(dout1_57) AT=60.05n

.meas tran vdout1_58ck50 FIND v(dout1_58) AT=60.05n

.meas tran vdout1_59ck50 FIND v(dout1_59) AT=60.05n

.meas tran vdout1_60ck50 FIND v(dout1_60) AT=60.05n

.meas tran vdout1_61ck50 FIND v(dout1_61) AT=60.05n

.meas tran vdout1_62ck50 FIND v(dout1_62) AT=60.05n

.meas tran vdout1_63ck50 FIND v(dout1_63) AT=60.05n

.meas tran vdout1_64ck50 FIND v(dout1_64) AT=60.05n

.meas tran vdout1_65ck50 FIND v(dout1_65) AT=60.05n

.meas tran vdout1_66ck50 FIND v(dout1_66) AT=60.05n

.meas tran vdout1_67ck50 FIND v(dout1_67) AT=60.05n

.meas tran vdout1_68ck50 FIND v(dout1_68) AT=60.05n

.meas tran vdout1_69ck50 FIND v(dout1_69) AT=60.05n

.meas tran vdout1_70ck50 FIND v(dout1_70) AT=60.05n

.meas tran vdout1_71ck50 FIND v(dout1_71) AT=60.05n

.meas tran vdout1_72ck50 FIND v(dout1_72) AT=60.05n

.meas tran vdout1_73ck50 FIND v(dout1_73) AT=60.05n

.meas tran vdout1_74ck50 FIND v(dout1_74) AT=60.05n

.meas tran vdout1_75ck50 FIND v(dout1_75) AT=60.05n

.meas tran vdout1_76ck50 FIND v(dout1_76) AT=60.05n

.meas tran vdout1_77ck50 FIND v(dout1_77) AT=60.05n

.meas tran vdout1_78ck50 FIND v(dout1_78) AT=60.05n

.meas tran vdout1_79ck50 FIND v(dout1_79) AT=60.05n

.meas tran vdout1_80ck50 FIND v(dout1_80) AT=60.05n

.meas tran vdout1_81ck50 FIND v(dout1_81) AT=60.05n

.meas tran vdout1_82ck50 FIND v(dout1_82) AT=60.05n

.meas tran vdout1_83ck50 FIND v(dout1_83) AT=60.05n

.meas tran vdout1_84ck50 FIND v(dout1_84) AT=60.05n

.meas tran vdout1_85ck50 FIND v(dout1_85) AT=60.05n

.meas tran vdout1_86ck50 FIND v(dout1_86) AT=60.05n

.meas tran vdout1_87ck50 FIND v(dout1_87) AT=60.05n

.meas tran vdout1_88ck50 FIND v(dout1_88) AT=60.05n

.meas tran vdout1_89ck50 FIND v(dout1_89) AT=60.05n

.meas tran vdout1_90ck50 FIND v(dout1_90) AT=60.05n

.meas tran vdout1_91ck50 FIND v(dout1_91) AT=60.05n

.meas tran vdout1_92ck50 FIND v(dout1_92) AT=60.05n

.meas tran vdout1_93ck50 FIND v(dout1_93) AT=60.05n

.meas tran vdout1_94ck50 FIND v(dout1_94) AT=60.05n

.meas tran vdout1_95ck50 FIND v(dout1_95) AT=60.05n

.meas tran vdout1_96ck50 FIND v(dout1_96) AT=60.05n

.meas tran vdout1_97ck50 FIND v(dout1_97) AT=60.05n

.meas tran vdout1_98ck50 FIND v(dout1_98) AT=60.05n

.meas tran vdout1_99ck50 FIND v(dout1_99) AT=60.05n

.meas tran vdout1_100ck50 FIND v(dout1_100) AT=60.05n

.meas tran vdout1_101ck50 FIND v(dout1_101) AT=60.05n

.meas tran vdout1_102ck50 FIND v(dout1_102) AT=60.05n

.meas tran vdout1_103ck50 FIND v(dout1_103) AT=60.05n

.meas tran vdout1_104ck50 FIND v(dout1_104) AT=60.05n

.meas tran vdout1_105ck50 FIND v(dout1_105) AT=60.05n

.meas tran vdout1_106ck50 FIND v(dout1_106) AT=60.05n

.meas tran vdout1_107ck50 FIND v(dout1_107) AT=60.05n

.meas tran vdout1_108ck50 FIND v(dout1_108) AT=60.05n

.meas tran vdout1_109ck50 FIND v(dout1_109) AT=60.05n

.meas tran vdout1_110ck50 FIND v(dout1_110) AT=60.05n

.meas tran vdout1_111ck50 FIND v(dout1_111) AT=60.05n

.meas tran vdout1_112ck50 FIND v(dout1_112) AT=60.05n

.meas tran vdout1_113ck50 FIND v(dout1_113) AT=60.05n

.meas tran vdout1_114ck50 FIND v(dout1_114) AT=60.05n

.meas tran vdout1_115ck50 FIND v(dout1_115) AT=60.05n

.meas tran vdout1_116ck50 FIND v(dout1_116) AT=60.05n

.meas tran vdout1_117ck50 FIND v(dout1_117) AT=60.05n

.meas tran vdout1_118ck50 FIND v(dout1_118) AT=60.05n

.meas tran vdout1_119ck50 FIND v(dout1_119) AT=60.05n

.meas tran vdout1_120ck50 FIND v(dout1_120) AT=60.05n

.meas tran vdout1_121ck50 FIND v(dout1_121) AT=60.05n

.meas tran vdout1_122ck50 FIND v(dout1_122) AT=60.05n

.meas tran vdout1_123ck50 FIND v(dout1_123) AT=60.05n

.meas tran vdout1_124ck50 FIND v(dout1_124) AT=60.05n

.meas tran vdout1_125ck50 FIND v(dout1_125) AT=60.05n

.meas tran vdout1_126ck50 FIND v(dout1_126) AT=60.05n

.meas tran vdout1_127ck50 FIND v(dout1_127) AT=60.05n

.meas tran vdout1_128ck50 FIND v(dout1_128) AT=60.05n

.meas tran vdout1_129ck50 FIND v(dout1_129) AT=60.05n

.meas tran vdout1_130ck50 FIND v(dout1_130) AT=60.05n

.meas tran vdout1_131ck50 FIND v(dout1_131) AT=60.05n

.meas tran vdout1_132ck50 FIND v(dout1_132) AT=60.05n

.meas tran vdout1_133ck50 FIND v(dout1_133) AT=60.05n

.meas tran vdout1_134ck50 FIND v(dout1_134) AT=60.05n

.meas tran vdout1_0ck60 FIND v(dout1_0) AT=70.05n

.meas tran vdout1_1ck60 FIND v(dout1_1) AT=70.05n

.meas tran vdout1_2ck60 FIND v(dout1_2) AT=70.05n

.meas tran vdout1_3ck60 FIND v(dout1_3) AT=70.05n

.meas tran vdout1_4ck60 FIND v(dout1_4) AT=70.05n

.meas tran vdout1_5ck60 FIND v(dout1_5) AT=70.05n

.meas tran vdout1_6ck60 FIND v(dout1_6) AT=70.05n

.meas tran vdout1_7ck60 FIND v(dout1_7) AT=70.05n

.meas tran vdout1_8ck60 FIND v(dout1_8) AT=70.05n

.meas tran vdout1_9ck60 FIND v(dout1_9) AT=70.05n

.meas tran vdout1_10ck60 FIND v(dout1_10) AT=70.05n

.meas tran vdout1_11ck60 FIND v(dout1_11) AT=70.05n

.meas tran vdout1_12ck60 FIND v(dout1_12) AT=70.05n

.meas tran vdout1_13ck60 FIND v(dout1_13) AT=70.05n

.meas tran vdout1_14ck60 FIND v(dout1_14) AT=70.05n

.meas tran vdout1_15ck60 FIND v(dout1_15) AT=70.05n

.meas tran vdout1_16ck60 FIND v(dout1_16) AT=70.05n

.meas tran vdout1_17ck60 FIND v(dout1_17) AT=70.05n

.meas tran vdout1_18ck60 FIND v(dout1_18) AT=70.05n

.meas tran vdout1_19ck60 FIND v(dout1_19) AT=70.05n

.meas tran vdout1_20ck60 FIND v(dout1_20) AT=70.05n

.meas tran vdout1_21ck60 FIND v(dout1_21) AT=70.05n

.meas tran vdout1_22ck60 FIND v(dout1_22) AT=70.05n

.meas tran vdout1_23ck60 FIND v(dout1_23) AT=70.05n

.meas tran vdout1_24ck60 FIND v(dout1_24) AT=70.05n

.meas tran vdout1_25ck60 FIND v(dout1_25) AT=70.05n

.meas tran vdout1_26ck60 FIND v(dout1_26) AT=70.05n

.meas tran vdout1_27ck60 FIND v(dout1_27) AT=70.05n

.meas tran vdout1_28ck60 FIND v(dout1_28) AT=70.05n

.meas tran vdout1_29ck60 FIND v(dout1_29) AT=70.05n

.meas tran vdout1_30ck60 FIND v(dout1_30) AT=70.05n

.meas tran vdout1_31ck60 FIND v(dout1_31) AT=70.05n

.meas tran vdout1_32ck60 FIND v(dout1_32) AT=70.05n

.meas tran vdout1_33ck60 FIND v(dout1_33) AT=70.05n

.meas tran vdout1_34ck60 FIND v(dout1_34) AT=70.05n

.meas tran vdout1_35ck60 FIND v(dout1_35) AT=70.05n

.meas tran vdout1_36ck60 FIND v(dout1_36) AT=70.05n

.meas tran vdout1_37ck60 FIND v(dout1_37) AT=70.05n

.meas tran vdout1_38ck60 FIND v(dout1_38) AT=70.05n

.meas tran vdout1_39ck60 FIND v(dout1_39) AT=70.05n

.meas tran vdout1_40ck60 FIND v(dout1_40) AT=70.05n

.meas tran vdout1_41ck60 FIND v(dout1_41) AT=70.05n

.meas tran vdout1_42ck60 FIND v(dout1_42) AT=70.05n

.meas tran vdout1_43ck60 FIND v(dout1_43) AT=70.05n

.meas tran vdout1_44ck60 FIND v(dout1_44) AT=70.05n

.meas tran vdout1_45ck60 FIND v(dout1_45) AT=70.05n

.meas tran vdout1_46ck60 FIND v(dout1_46) AT=70.05n

.meas tran vdout1_47ck60 FIND v(dout1_47) AT=70.05n

.meas tran vdout1_48ck60 FIND v(dout1_48) AT=70.05n

.meas tran vdout1_49ck60 FIND v(dout1_49) AT=70.05n

.meas tran vdout1_50ck60 FIND v(dout1_50) AT=70.05n

.meas tran vdout1_51ck60 FIND v(dout1_51) AT=70.05n

.meas tran vdout1_52ck60 FIND v(dout1_52) AT=70.05n

.meas tran vdout1_53ck60 FIND v(dout1_53) AT=70.05n

.meas tran vdout1_54ck60 FIND v(dout1_54) AT=70.05n

.meas tran vdout1_55ck60 FIND v(dout1_55) AT=70.05n

.meas tran vdout1_56ck60 FIND v(dout1_56) AT=70.05n

.meas tran vdout1_57ck60 FIND v(dout1_57) AT=70.05n

.meas tran vdout1_58ck60 FIND v(dout1_58) AT=70.05n

.meas tran vdout1_59ck60 FIND v(dout1_59) AT=70.05n

.meas tran vdout1_60ck60 FIND v(dout1_60) AT=70.05n

.meas tran vdout1_61ck60 FIND v(dout1_61) AT=70.05n

.meas tran vdout1_62ck60 FIND v(dout1_62) AT=70.05n

.meas tran vdout1_63ck60 FIND v(dout1_63) AT=70.05n

.meas tran vdout1_64ck60 FIND v(dout1_64) AT=70.05n

.meas tran vdout1_65ck60 FIND v(dout1_65) AT=70.05n

.meas tran vdout1_66ck60 FIND v(dout1_66) AT=70.05n

.meas tran vdout1_67ck60 FIND v(dout1_67) AT=70.05n

.meas tran vdout1_68ck60 FIND v(dout1_68) AT=70.05n

.meas tran vdout1_69ck60 FIND v(dout1_69) AT=70.05n

.meas tran vdout1_70ck60 FIND v(dout1_70) AT=70.05n

.meas tran vdout1_71ck60 FIND v(dout1_71) AT=70.05n

.meas tran vdout1_72ck60 FIND v(dout1_72) AT=70.05n

.meas tran vdout1_73ck60 FIND v(dout1_73) AT=70.05n

.meas tran vdout1_74ck60 FIND v(dout1_74) AT=70.05n

.meas tran vdout1_75ck60 FIND v(dout1_75) AT=70.05n

.meas tran vdout1_76ck60 FIND v(dout1_76) AT=70.05n

.meas tran vdout1_77ck60 FIND v(dout1_77) AT=70.05n

.meas tran vdout1_78ck60 FIND v(dout1_78) AT=70.05n

.meas tran vdout1_79ck60 FIND v(dout1_79) AT=70.05n

.meas tran vdout1_80ck60 FIND v(dout1_80) AT=70.05n

.meas tran vdout1_81ck60 FIND v(dout1_81) AT=70.05n

.meas tran vdout1_82ck60 FIND v(dout1_82) AT=70.05n

.meas tran vdout1_83ck60 FIND v(dout1_83) AT=70.05n

.meas tran vdout1_84ck60 FIND v(dout1_84) AT=70.05n

.meas tran vdout1_85ck60 FIND v(dout1_85) AT=70.05n

.meas tran vdout1_86ck60 FIND v(dout1_86) AT=70.05n

.meas tran vdout1_87ck60 FIND v(dout1_87) AT=70.05n

.meas tran vdout1_88ck60 FIND v(dout1_88) AT=70.05n

.meas tran vdout1_89ck60 FIND v(dout1_89) AT=70.05n

.meas tran vdout1_90ck60 FIND v(dout1_90) AT=70.05n

.meas tran vdout1_91ck60 FIND v(dout1_91) AT=70.05n

.meas tran vdout1_92ck60 FIND v(dout1_92) AT=70.05n

.meas tran vdout1_93ck60 FIND v(dout1_93) AT=70.05n

.meas tran vdout1_94ck60 FIND v(dout1_94) AT=70.05n

.meas tran vdout1_95ck60 FIND v(dout1_95) AT=70.05n

.meas tran vdout1_96ck60 FIND v(dout1_96) AT=70.05n

.meas tran vdout1_97ck60 FIND v(dout1_97) AT=70.05n

.meas tran vdout1_98ck60 FIND v(dout1_98) AT=70.05n

.meas tran vdout1_99ck60 FIND v(dout1_99) AT=70.05n

.meas tran vdout1_100ck60 FIND v(dout1_100) AT=70.05n

.meas tran vdout1_101ck60 FIND v(dout1_101) AT=70.05n

.meas tran vdout1_102ck60 FIND v(dout1_102) AT=70.05n

.meas tran vdout1_103ck60 FIND v(dout1_103) AT=70.05n

.meas tran vdout1_104ck60 FIND v(dout1_104) AT=70.05n

.meas tran vdout1_105ck60 FIND v(dout1_105) AT=70.05n

.meas tran vdout1_106ck60 FIND v(dout1_106) AT=70.05n

.meas tran vdout1_107ck60 FIND v(dout1_107) AT=70.05n

.meas tran vdout1_108ck60 FIND v(dout1_108) AT=70.05n

.meas tran vdout1_109ck60 FIND v(dout1_109) AT=70.05n

.meas tran vdout1_110ck60 FIND v(dout1_110) AT=70.05n

.meas tran vdout1_111ck60 FIND v(dout1_111) AT=70.05n

.meas tran vdout1_112ck60 FIND v(dout1_112) AT=70.05n

.meas tran vdout1_113ck60 FIND v(dout1_113) AT=70.05n

.meas tran vdout1_114ck60 FIND v(dout1_114) AT=70.05n

.meas tran vdout1_115ck60 FIND v(dout1_115) AT=70.05n

.meas tran vdout1_116ck60 FIND v(dout1_116) AT=70.05n

.meas tran vdout1_117ck60 FIND v(dout1_117) AT=70.05n

.meas tran vdout1_118ck60 FIND v(dout1_118) AT=70.05n

.meas tran vdout1_119ck60 FIND v(dout1_119) AT=70.05n

.meas tran vdout1_120ck60 FIND v(dout1_120) AT=70.05n

.meas tran vdout1_121ck60 FIND v(dout1_121) AT=70.05n

.meas tran vdout1_122ck60 FIND v(dout1_122) AT=70.05n

.meas tran vdout1_123ck60 FIND v(dout1_123) AT=70.05n

.meas tran vdout1_124ck60 FIND v(dout1_124) AT=70.05n

.meas tran vdout1_125ck60 FIND v(dout1_125) AT=70.05n

.meas tran vdout1_126ck60 FIND v(dout1_126) AT=70.05n

.meas tran vdout1_127ck60 FIND v(dout1_127) AT=70.05n

.meas tran vdout1_128ck60 FIND v(dout1_128) AT=70.05n

.meas tran vdout1_129ck60 FIND v(dout1_129) AT=70.05n

.meas tran vdout1_130ck60 FIND v(dout1_130) AT=70.05n

.meas tran vdout1_131ck60 FIND v(dout1_131) AT=70.05n

.meas tran vdout1_132ck60 FIND v(dout1_132) AT=70.05n

.meas tran vdout1_133ck60 FIND v(dout1_133) AT=70.05n

.meas tran vdout1_134ck60 FIND v(dout1_134) AT=70.05n

.meas tran vdout1_0ck80 FIND v(dout1_0) AT=90.05n

.meas tran vdout1_1ck80 FIND v(dout1_1) AT=90.05n

.meas tran vdout1_2ck80 FIND v(dout1_2) AT=90.05n

.meas tran vdout1_3ck80 FIND v(dout1_3) AT=90.05n

.meas tran vdout1_4ck80 FIND v(dout1_4) AT=90.05n

.meas tran vdout1_5ck80 FIND v(dout1_5) AT=90.05n

.meas tran vdout1_6ck80 FIND v(dout1_6) AT=90.05n

.meas tran vdout1_7ck80 FIND v(dout1_7) AT=90.05n

.meas tran vdout1_8ck80 FIND v(dout1_8) AT=90.05n

.meas tran vdout1_9ck80 FIND v(dout1_9) AT=90.05n

.meas tran vdout1_10ck80 FIND v(dout1_10) AT=90.05n

.meas tran vdout1_11ck80 FIND v(dout1_11) AT=90.05n

.meas tran vdout1_12ck80 FIND v(dout1_12) AT=90.05n

.meas tran vdout1_13ck80 FIND v(dout1_13) AT=90.05n

.meas tran vdout1_14ck80 FIND v(dout1_14) AT=90.05n

.meas tran vdout1_15ck80 FIND v(dout1_15) AT=90.05n

.meas tran vdout1_16ck80 FIND v(dout1_16) AT=90.05n

.meas tran vdout1_17ck80 FIND v(dout1_17) AT=90.05n

.meas tran vdout1_18ck80 FIND v(dout1_18) AT=90.05n

.meas tran vdout1_19ck80 FIND v(dout1_19) AT=90.05n

.meas tran vdout1_20ck80 FIND v(dout1_20) AT=90.05n

.meas tran vdout1_21ck80 FIND v(dout1_21) AT=90.05n

.meas tran vdout1_22ck80 FIND v(dout1_22) AT=90.05n

.meas tran vdout1_23ck80 FIND v(dout1_23) AT=90.05n

.meas tran vdout1_24ck80 FIND v(dout1_24) AT=90.05n

.meas tran vdout1_25ck80 FIND v(dout1_25) AT=90.05n

.meas tran vdout1_26ck80 FIND v(dout1_26) AT=90.05n

.meas tran vdout1_27ck80 FIND v(dout1_27) AT=90.05n

.meas tran vdout1_28ck80 FIND v(dout1_28) AT=90.05n

.meas tran vdout1_29ck80 FIND v(dout1_29) AT=90.05n

.meas tran vdout1_30ck80 FIND v(dout1_30) AT=90.05n

.meas tran vdout1_31ck80 FIND v(dout1_31) AT=90.05n

.meas tran vdout1_32ck80 FIND v(dout1_32) AT=90.05n

.meas tran vdout1_33ck80 FIND v(dout1_33) AT=90.05n

.meas tran vdout1_34ck80 FIND v(dout1_34) AT=90.05n

.meas tran vdout1_35ck80 FIND v(dout1_35) AT=90.05n

.meas tran vdout1_36ck80 FIND v(dout1_36) AT=90.05n

.meas tran vdout1_37ck80 FIND v(dout1_37) AT=90.05n

.meas tran vdout1_38ck80 FIND v(dout1_38) AT=90.05n

.meas tran vdout1_39ck80 FIND v(dout1_39) AT=90.05n

.meas tran vdout1_40ck80 FIND v(dout1_40) AT=90.05n

.meas tran vdout1_41ck80 FIND v(dout1_41) AT=90.05n

.meas tran vdout1_42ck80 FIND v(dout1_42) AT=90.05n

.meas tran vdout1_43ck80 FIND v(dout1_43) AT=90.05n

.meas tran vdout1_44ck80 FIND v(dout1_44) AT=90.05n

.meas tran vdout1_45ck80 FIND v(dout1_45) AT=90.05n

.meas tran vdout1_46ck80 FIND v(dout1_46) AT=90.05n

.meas tran vdout1_47ck80 FIND v(dout1_47) AT=90.05n

.meas tran vdout1_48ck80 FIND v(dout1_48) AT=90.05n

.meas tran vdout1_49ck80 FIND v(dout1_49) AT=90.05n

.meas tran vdout1_50ck80 FIND v(dout1_50) AT=90.05n

.meas tran vdout1_51ck80 FIND v(dout1_51) AT=90.05n

.meas tran vdout1_52ck80 FIND v(dout1_52) AT=90.05n

.meas tran vdout1_53ck80 FIND v(dout1_53) AT=90.05n

.meas tran vdout1_54ck80 FIND v(dout1_54) AT=90.05n

.meas tran vdout1_55ck80 FIND v(dout1_55) AT=90.05n

.meas tran vdout1_56ck80 FIND v(dout1_56) AT=90.05n

.meas tran vdout1_57ck80 FIND v(dout1_57) AT=90.05n

.meas tran vdout1_58ck80 FIND v(dout1_58) AT=90.05n

.meas tran vdout1_59ck80 FIND v(dout1_59) AT=90.05n

.meas tran vdout1_60ck80 FIND v(dout1_60) AT=90.05n

.meas tran vdout1_61ck80 FIND v(dout1_61) AT=90.05n

.meas tran vdout1_62ck80 FIND v(dout1_62) AT=90.05n

.meas tran vdout1_63ck80 FIND v(dout1_63) AT=90.05n

.meas tran vdout1_64ck80 FIND v(dout1_64) AT=90.05n

.meas tran vdout1_65ck80 FIND v(dout1_65) AT=90.05n

.meas tran vdout1_66ck80 FIND v(dout1_66) AT=90.05n

.meas tran vdout1_67ck80 FIND v(dout1_67) AT=90.05n

.meas tran vdout1_68ck80 FIND v(dout1_68) AT=90.05n

.meas tran vdout1_69ck80 FIND v(dout1_69) AT=90.05n

.meas tran vdout1_70ck80 FIND v(dout1_70) AT=90.05n

.meas tran vdout1_71ck80 FIND v(dout1_71) AT=90.05n

.meas tran vdout1_72ck80 FIND v(dout1_72) AT=90.05n

.meas tran vdout1_73ck80 FIND v(dout1_73) AT=90.05n

.meas tran vdout1_74ck80 FIND v(dout1_74) AT=90.05n

.meas tran vdout1_75ck80 FIND v(dout1_75) AT=90.05n

.meas tran vdout1_76ck80 FIND v(dout1_76) AT=90.05n

.meas tran vdout1_77ck80 FIND v(dout1_77) AT=90.05n

.meas tran vdout1_78ck80 FIND v(dout1_78) AT=90.05n

.meas tran vdout1_79ck80 FIND v(dout1_79) AT=90.05n

.meas tran vdout1_80ck80 FIND v(dout1_80) AT=90.05n

.meas tran vdout1_81ck80 FIND v(dout1_81) AT=90.05n

.meas tran vdout1_82ck80 FIND v(dout1_82) AT=90.05n

.meas tran vdout1_83ck80 FIND v(dout1_83) AT=90.05n

.meas tran vdout1_84ck80 FIND v(dout1_84) AT=90.05n

.meas tran vdout1_85ck80 FIND v(dout1_85) AT=90.05n

.meas tran vdout1_86ck80 FIND v(dout1_86) AT=90.05n

.meas tran vdout1_87ck80 FIND v(dout1_87) AT=90.05n

.meas tran vdout1_88ck80 FIND v(dout1_88) AT=90.05n

.meas tran vdout1_89ck80 FIND v(dout1_89) AT=90.05n

.meas tran vdout1_90ck80 FIND v(dout1_90) AT=90.05n

.meas tran vdout1_91ck80 FIND v(dout1_91) AT=90.05n

.meas tran vdout1_92ck80 FIND v(dout1_92) AT=90.05n

.meas tran vdout1_93ck80 FIND v(dout1_93) AT=90.05n

.meas tran vdout1_94ck80 FIND v(dout1_94) AT=90.05n

.meas tran vdout1_95ck80 FIND v(dout1_95) AT=90.05n

.meas tran vdout1_96ck80 FIND v(dout1_96) AT=90.05n

.meas tran vdout1_97ck80 FIND v(dout1_97) AT=90.05n

.meas tran vdout1_98ck80 FIND v(dout1_98) AT=90.05n

.meas tran vdout1_99ck80 FIND v(dout1_99) AT=90.05n

.meas tran vdout1_100ck80 FIND v(dout1_100) AT=90.05n

.meas tran vdout1_101ck80 FIND v(dout1_101) AT=90.05n

.meas tran vdout1_102ck80 FIND v(dout1_102) AT=90.05n

.meas tran vdout1_103ck80 FIND v(dout1_103) AT=90.05n

.meas tran vdout1_104ck80 FIND v(dout1_104) AT=90.05n

.meas tran vdout1_105ck80 FIND v(dout1_105) AT=90.05n

.meas tran vdout1_106ck80 FIND v(dout1_106) AT=90.05n

.meas tran vdout1_107ck80 FIND v(dout1_107) AT=90.05n

.meas tran vdout1_108ck80 FIND v(dout1_108) AT=90.05n

.meas tran vdout1_109ck80 FIND v(dout1_109) AT=90.05n

.meas tran vdout1_110ck80 FIND v(dout1_110) AT=90.05n

.meas tran vdout1_111ck80 FIND v(dout1_111) AT=90.05n

.meas tran vdout1_112ck80 FIND v(dout1_112) AT=90.05n

.meas tran vdout1_113ck80 FIND v(dout1_113) AT=90.05n

.meas tran vdout1_114ck80 FIND v(dout1_114) AT=90.05n

.meas tran vdout1_115ck80 FIND v(dout1_115) AT=90.05n

.meas tran vdout1_116ck80 FIND v(dout1_116) AT=90.05n

.meas tran vdout1_117ck80 FIND v(dout1_117) AT=90.05n

.meas tran vdout1_118ck80 FIND v(dout1_118) AT=90.05n

.meas tran vdout1_119ck80 FIND v(dout1_119) AT=90.05n

.meas tran vdout1_120ck80 FIND v(dout1_120) AT=90.05n

.meas tran vdout1_121ck80 FIND v(dout1_121) AT=90.05n

.meas tran vdout1_122ck80 FIND v(dout1_122) AT=90.05n

.meas tran vdout1_123ck80 FIND v(dout1_123) AT=90.05n

.meas tran vdout1_124ck80 FIND v(dout1_124) AT=90.05n

.meas tran vdout1_125ck80 FIND v(dout1_125) AT=90.05n

.meas tran vdout1_126ck80 FIND v(dout1_126) AT=90.05n

.meas tran vdout1_127ck80 FIND v(dout1_127) AT=90.05n

.meas tran vdout1_128ck80 FIND v(dout1_128) AT=90.05n

.meas tran vdout1_129ck80 FIND v(dout1_129) AT=90.05n

.meas tran vdout1_130ck80 FIND v(dout1_130) AT=90.05n

.meas tran vdout1_131ck80 FIND v(dout1_131) AT=90.05n

.meas tran vdout1_132ck80 FIND v(dout1_132) AT=90.05n

.meas tran vdout1_133ck80 FIND v(dout1_133) AT=90.05n

.meas tran vdout1_134ck80 FIND v(dout1_134) AT=90.05n

.meas tran vdout1_0ck90 FIND v(dout1_0) AT=100.05n

.meas tran vdout1_1ck90 FIND v(dout1_1) AT=100.05n

.meas tran vdout1_2ck90 FIND v(dout1_2) AT=100.05n

.meas tran vdout1_3ck90 FIND v(dout1_3) AT=100.05n

.meas tran vdout1_4ck90 FIND v(dout1_4) AT=100.05n

.meas tran vdout1_5ck90 FIND v(dout1_5) AT=100.05n

.meas tran vdout1_6ck90 FIND v(dout1_6) AT=100.05n

.meas tran vdout1_7ck90 FIND v(dout1_7) AT=100.05n

.meas tran vdout1_8ck90 FIND v(dout1_8) AT=100.05n

.meas tran vdout1_9ck90 FIND v(dout1_9) AT=100.05n

.meas tran vdout1_10ck90 FIND v(dout1_10) AT=100.05n

.meas tran vdout1_11ck90 FIND v(dout1_11) AT=100.05n

.meas tran vdout1_12ck90 FIND v(dout1_12) AT=100.05n

.meas tran vdout1_13ck90 FIND v(dout1_13) AT=100.05n

.meas tran vdout1_14ck90 FIND v(dout1_14) AT=100.05n

.meas tran vdout1_15ck90 FIND v(dout1_15) AT=100.05n

.meas tran vdout1_16ck90 FIND v(dout1_16) AT=100.05n

.meas tran vdout1_17ck90 FIND v(dout1_17) AT=100.05n

.meas tran vdout1_18ck90 FIND v(dout1_18) AT=100.05n

.meas tran vdout1_19ck90 FIND v(dout1_19) AT=100.05n

.meas tran vdout1_20ck90 FIND v(dout1_20) AT=100.05n

.meas tran vdout1_21ck90 FIND v(dout1_21) AT=100.05n

.meas tran vdout1_22ck90 FIND v(dout1_22) AT=100.05n

.meas tran vdout1_23ck90 FIND v(dout1_23) AT=100.05n

.meas tran vdout1_24ck90 FIND v(dout1_24) AT=100.05n

.meas tran vdout1_25ck90 FIND v(dout1_25) AT=100.05n

.meas tran vdout1_26ck90 FIND v(dout1_26) AT=100.05n

.meas tran vdout1_27ck90 FIND v(dout1_27) AT=100.05n

.meas tran vdout1_28ck90 FIND v(dout1_28) AT=100.05n

.meas tran vdout1_29ck90 FIND v(dout1_29) AT=100.05n

.meas tran vdout1_30ck90 FIND v(dout1_30) AT=100.05n

.meas tran vdout1_31ck90 FIND v(dout1_31) AT=100.05n

.meas tran vdout1_32ck90 FIND v(dout1_32) AT=100.05n

.meas tran vdout1_33ck90 FIND v(dout1_33) AT=100.05n

.meas tran vdout1_34ck90 FIND v(dout1_34) AT=100.05n

.meas tran vdout1_35ck90 FIND v(dout1_35) AT=100.05n

.meas tran vdout1_36ck90 FIND v(dout1_36) AT=100.05n

.meas tran vdout1_37ck90 FIND v(dout1_37) AT=100.05n

.meas tran vdout1_38ck90 FIND v(dout1_38) AT=100.05n

.meas tran vdout1_39ck90 FIND v(dout1_39) AT=100.05n

.meas tran vdout1_40ck90 FIND v(dout1_40) AT=100.05n

.meas tran vdout1_41ck90 FIND v(dout1_41) AT=100.05n

.meas tran vdout1_42ck90 FIND v(dout1_42) AT=100.05n

.meas tran vdout1_43ck90 FIND v(dout1_43) AT=100.05n

.meas tran vdout1_44ck90 FIND v(dout1_44) AT=100.05n

.meas tran vdout1_45ck90 FIND v(dout1_45) AT=100.05n

.meas tran vdout1_46ck90 FIND v(dout1_46) AT=100.05n

.meas tran vdout1_47ck90 FIND v(dout1_47) AT=100.05n

.meas tran vdout1_48ck90 FIND v(dout1_48) AT=100.05n

.meas tran vdout1_49ck90 FIND v(dout1_49) AT=100.05n

.meas tran vdout1_50ck90 FIND v(dout1_50) AT=100.05n

.meas tran vdout1_51ck90 FIND v(dout1_51) AT=100.05n

.meas tran vdout1_52ck90 FIND v(dout1_52) AT=100.05n

.meas tran vdout1_53ck90 FIND v(dout1_53) AT=100.05n

.meas tran vdout1_54ck90 FIND v(dout1_54) AT=100.05n

.meas tran vdout1_55ck90 FIND v(dout1_55) AT=100.05n

.meas tran vdout1_56ck90 FIND v(dout1_56) AT=100.05n

.meas tran vdout1_57ck90 FIND v(dout1_57) AT=100.05n

.meas tran vdout1_58ck90 FIND v(dout1_58) AT=100.05n

.meas tran vdout1_59ck90 FIND v(dout1_59) AT=100.05n

.meas tran vdout1_60ck90 FIND v(dout1_60) AT=100.05n

.meas tran vdout1_61ck90 FIND v(dout1_61) AT=100.05n

.meas tran vdout1_62ck90 FIND v(dout1_62) AT=100.05n

.meas tran vdout1_63ck90 FIND v(dout1_63) AT=100.05n

.meas tran vdout1_64ck90 FIND v(dout1_64) AT=100.05n

.meas tran vdout1_65ck90 FIND v(dout1_65) AT=100.05n

.meas tran vdout1_66ck90 FIND v(dout1_66) AT=100.05n

.meas tran vdout1_67ck90 FIND v(dout1_67) AT=100.05n

.meas tran vdout1_68ck90 FIND v(dout1_68) AT=100.05n

.meas tran vdout1_69ck90 FIND v(dout1_69) AT=100.05n

.meas tran vdout1_70ck90 FIND v(dout1_70) AT=100.05n

.meas tran vdout1_71ck90 FIND v(dout1_71) AT=100.05n

.meas tran vdout1_72ck90 FIND v(dout1_72) AT=100.05n

.meas tran vdout1_73ck90 FIND v(dout1_73) AT=100.05n

.meas tran vdout1_74ck90 FIND v(dout1_74) AT=100.05n

.meas tran vdout1_75ck90 FIND v(dout1_75) AT=100.05n

.meas tran vdout1_76ck90 FIND v(dout1_76) AT=100.05n

.meas tran vdout1_77ck90 FIND v(dout1_77) AT=100.05n

.meas tran vdout1_78ck90 FIND v(dout1_78) AT=100.05n

.meas tran vdout1_79ck90 FIND v(dout1_79) AT=100.05n

.meas tran vdout1_80ck90 FIND v(dout1_80) AT=100.05n

.meas tran vdout1_81ck90 FIND v(dout1_81) AT=100.05n

.meas tran vdout1_82ck90 FIND v(dout1_82) AT=100.05n

.meas tran vdout1_83ck90 FIND v(dout1_83) AT=100.05n

.meas tran vdout1_84ck90 FIND v(dout1_84) AT=100.05n

.meas tran vdout1_85ck90 FIND v(dout1_85) AT=100.05n

.meas tran vdout1_86ck90 FIND v(dout1_86) AT=100.05n

.meas tran vdout1_87ck90 FIND v(dout1_87) AT=100.05n

.meas tran vdout1_88ck90 FIND v(dout1_88) AT=100.05n

.meas tran vdout1_89ck90 FIND v(dout1_89) AT=100.05n

.meas tran vdout1_90ck90 FIND v(dout1_90) AT=100.05n

.meas tran vdout1_91ck90 FIND v(dout1_91) AT=100.05n

.meas tran vdout1_92ck90 FIND v(dout1_92) AT=100.05n

.meas tran vdout1_93ck90 FIND v(dout1_93) AT=100.05n

.meas tran vdout1_94ck90 FIND v(dout1_94) AT=100.05n

.meas tran vdout1_95ck90 FIND v(dout1_95) AT=100.05n

.meas tran vdout1_96ck90 FIND v(dout1_96) AT=100.05n

.meas tran vdout1_97ck90 FIND v(dout1_97) AT=100.05n

.meas tran vdout1_98ck90 FIND v(dout1_98) AT=100.05n

.meas tran vdout1_99ck90 FIND v(dout1_99) AT=100.05n

.meas tran vdout1_100ck90 FIND v(dout1_100) AT=100.05n

.meas tran vdout1_101ck90 FIND v(dout1_101) AT=100.05n

.meas tran vdout1_102ck90 FIND v(dout1_102) AT=100.05n

.meas tran vdout1_103ck90 FIND v(dout1_103) AT=100.05n

.meas tran vdout1_104ck90 FIND v(dout1_104) AT=100.05n

.meas tran vdout1_105ck90 FIND v(dout1_105) AT=100.05n

.meas tran vdout1_106ck90 FIND v(dout1_106) AT=100.05n

.meas tran vdout1_107ck90 FIND v(dout1_107) AT=100.05n

.meas tran vdout1_108ck90 FIND v(dout1_108) AT=100.05n

.meas tran vdout1_109ck90 FIND v(dout1_109) AT=100.05n

.meas tran vdout1_110ck90 FIND v(dout1_110) AT=100.05n

.meas tran vdout1_111ck90 FIND v(dout1_111) AT=100.05n

.meas tran vdout1_112ck90 FIND v(dout1_112) AT=100.05n

.meas tran vdout1_113ck90 FIND v(dout1_113) AT=100.05n

.meas tran vdout1_114ck90 FIND v(dout1_114) AT=100.05n

.meas tran vdout1_115ck90 FIND v(dout1_115) AT=100.05n

.meas tran vdout1_116ck90 FIND v(dout1_116) AT=100.05n

.meas tran vdout1_117ck90 FIND v(dout1_117) AT=100.05n

.meas tran vdout1_118ck90 FIND v(dout1_118) AT=100.05n

.meas tran vdout1_119ck90 FIND v(dout1_119) AT=100.05n

.meas tran vdout1_120ck90 FIND v(dout1_120) AT=100.05n

.meas tran vdout1_121ck90 FIND v(dout1_121) AT=100.05n

.meas tran vdout1_122ck90 FIND v(dout1_122) AT=100.05n

.meas tran vdout1_123ck90 FIND v(dout1_123) AT=100.05n

.meas tran vdout1_124ck90 FIND v(dout1_124) AT=100.05n

.meas tran vdout1_125ck90 FIND v(dout1_125) AT=100.05n

.meas tran vdout1_126ck90 FIND v(dout1_126) AT=100.05n

.meas tran vdout1_127ck90 FIND v(dout1_127) AT=100.05n

.meas tran vdout1_128ck90 FIND v(dout1_128) AT=100.05n

.meas tran vdout1_129ck90 FIND v(dout1_129) AT=100.05n

.meas tran vdout1_130ck90 FIND v(dout1_130) AT=100.05n

.meas tran vdout1_131ck90 FIND v(dout1_131) AT=100.05n

.meas tran vdout1_132ck90 FIND v(dout1_132) AT=100.05n

.meas tran vdout1_133ck90 FIND v(dout1_133) AT=100.05n

.meas tran vdout1_134ck90 FIND v(dout1_134) AT=100.05n

.meas tran vdout1_0ck100 FIND v(dout1_0) AT=110.05n

.meas tran vdout1_1ck100 FIND v(dout1_1) AT=110.05n

.meas tran vdout1_2ck100 FIND v(dout1_2) AT=110.05n

.meas tran vdout1_3ck100 FIND v(dout1_3) AT=110.05n

.meas tran vdout1_4ck100 FIND v(dout1_4) AT=110.05n

.meas tran vdout1_5ck100 FIND v(dout1_5) AT=110.05n

.meas tran vdout1_6ck100 FIND v(dout1_6) AT=110.05n

.meas tran vdout1_7ck100 FIND v(dout1_7) AT=110.05n

.meas tran vdout1_8ck100 FIND v(dout1_8) AT=110.05n

.meas tran vdout1_9ck100 FIND v(dout1_9) AT=110.05n

.meas tran vdout1_10ck100 FIND v(dout1_10) AT=110.05n

.meas tran vdout1_11ck100 FIND v(dout1_11) AT=110.05n

.meas tran vdout1_12ck100 FIND v(dout1_12) AT=110.05n

.meas tran vdout1_13ck100 FIND v(dout1_13) AT=110.05n

.meas tran vdout1_14ck100 FIND v(dout1_14) AT=110.05n

.meas tran vdout1_15ck100 FIND v(dout1_15) AT=110.05n

.meas tran vdout1_16ck100 FIND v(dout1_16) AT=110.05n

.meas tran vdout1_17ck100 FIND v(dout1_17) AT=110.05n

.meas tran vdout1_18ck100 FIND v(dout1_18) AT=110.05n

.meas tran vdout1_19ck100 FIND v(dout1_19) AT=110.05n

.meas tran vdout1_20ck100 FIND v(dout1_20) AT=110.05n

.meas tran vdout1_21ck100 FIND v(dout1_21) AT=110.05n

.meas tran vdout1_22ck100 FIND v(dout1_22) AT=110.05n

.meas tran vdout1_23ck100 FIND v(dout1_23) AT=110.05n

.meas tran vdout1_24ck100 FIND v(dout1_24) AT=110.05n

.meas tran vdout1_25ck100 FIND v(dout1_25) AT=110.05n

.meas tran vdout1_26ck100 FIND v(dout1_26) AT=110.05n

.meas tran vdout1_27ck100 FIND v(dout1_27) AT=110.05n

.meas tran vdout1_28ck100 FIND v(dout1_28) AT=110.05n

.meas tran vdout1_29ck100 FIND v(dout1_29) AT=110.05n

.meas tran vdout1_30ck100 FIND v(dout1_30) AT=110.05n

.meas tran vdout1_31ck100 FIND v(dout1_31) AT=110.05n

.meas tran vdout1_32ck100 FIND v(dout1_32) AT=110.05n

.meas tran vdout1_33ck100 FIND v(dout1_33) AT=110.05n

.meas tran vdout1_34ck100 FIND v(dout1_34) AT=110.05n

.meas tran vdout1_35ck100 FIND v(dout1_35) AT=110.05n

.meas tran vdout1_36ck100 FIND v(dout1_36) AT=110.05n

.meas tran vdout1_37ck100 FIND v(dout1_37) AT=110.05n

.meas tran vdout1_38ck100 FIND v(dout1_38) AT=110.05n

.meas tran vdout1_39ck100 FIND v(dout1_39) AT=110.05n

.meas tran vdout1_40ck100 FIND v(dout1_40) AT=110.05n

.meas tran vdout1_41ck100 FIND v(dout1_41) AT=110.05n

.meas tran vdout1_42ck100 FIND v(dout1_42) AT=110.05n

.meas tran vdout1_43ck100 FIND v(dout1_43) AT=110.05n

.meas tran vdout1_44ck100 FIND v(dout1_44) AT=110.05n

.meas tran vdout1_45ck100 FIND v(dout1_45) AT=110.05n

.meas tran vdout1_46ck100 FIND v(dout1_46) AT=110.05n

.meas tran vdout1_47ck100 FIND v(dout1_47) AT=110.05n

.meas tran vdout1_48ck100 FIND v(dout1_48) AT=110.05n

.meas tran vdout1_49ck100 FIND v(dout1_49) AT=110.05n

.meas tran vdout1_50ck100 FIND v(dout1_50) AT=110.05n

.meas tran vdout1_51ck100 FIND v(dout1_51) AT=110.05n

.meas tran vdout1_52ck100 FIND v(dout1_52) AT=110.05n

.meas tran vdout1_53ck100 FIND v(dout1_53) AT=110.05n

.meas tran vdout1_54ck100 FIND v(dout1_54) AT=110.05n

.meas tran vdout1_55ck100 FIND v(dout1_55) AT=110.05n

.meas tran vdout1_56ck100 FIND v(dout1_56) AT=110.05n

.meas tran vdout1_57ck100 FIND v(dout1_57) AT=110.05n

.meas tran vdout1_58ck100 FIND v(dout1_58) AT=110.05n

.meas tran vdout1_59ck100 FIND v(dout1_59) AT=110.05n

.meas tran vdout1_60ck100 FIND v(dout1_60) AT=110.05n

.meas tran vdout1_61ck100 FIND v(dout1_61) AT=110.05n

.meas tran vdout1_62ck100 FIND v(dout1_62) AT=110.05n

.meas tran vdout1_63ck100 FIND v(dout1_63) AT=110.05n

.meas tran vdout1_64ck100 FIND v(dout1_64) AT=110.05n

.meas tran vdout1_65ck100 FIND v(dout1_65) AT=110.05n

.meas tran vdout1_66ck100 FIND v(dout1_66) AT=110.05n

.meas tran vdout1_67ck100 FIND v(dout1_67) AT=110.05n

.meas tran vdout1_68ck100 FIND v(dout1_68) AT=110.05n

.meas tran vdout1_69ck100 FIND v(dout1_69) AT=110.05n

.meas tran vdout1_70ck100 FIND v(dout1_70) AT=110.05n

.meas tran vdout1_71ck100 FIND v(dout1_71) AT=110.05n

.meas tran vdout1_72ck100 FIND v(dout1_72) AT=110.05n

.meas tran vdout1_73ck100 FIND v(dout1_73) AT=110.05n

.meas tran vdout1_74ck100 FIND v(dout1_74) AT=110.05n

.meas tran vdout1_75ck100 FIND v(dout1_75) AT=110.05n

.meas tran vdout1_76ck100 FIND v(dout1_76) AT=110.05n

.meas tran vdout1_77ck100 FIND v(dout1_77) AT=110.05n

.meas tran vdout1_78ck100 FIND v(dout1_78) AT=110.05n

.meas tran vdout1_79ck100 FIND v(dout1_79) AT=110.05n

.meas tran vdout1_80ck100 FIND v(dout1_80) AT=110.05n

.meas tran vdout1_81ck100 FIND v(dout1_81) AT=110.05n

.meas tran vdout1_82ck100 FIND v(dout1_82) AT=110.05n

.meas tran vdout1_83ck100 FIND v(dout1_83) AT=110.05n

.meas tran vdout1_84ck100 FIND v(dout1_84) AT=110.05n

.meas tran vdout1_85ck100 FIND v(dout1_85) AT=110.05n

.meas tran vdout1_86ck100 FIND v(dout1_86) AT=110.05n

.meas tran vdout1_87ck100 FIND v(dout1_87) AT=110.05n

.meas tran vdout1_88ck100 FIND v(dout1_88) AT=110.05n

.meas tran vdout1_89ck100 FIND v(dout1_89) AT=110.05n

.meas tran vdout1_90ck100 FIND v(dout1_90) AT=110.05n

.meas tran vdout1_91ck100 FIND v(dout1_91) AT=110.05n

.meas tran vdout1_92ck100 FIND v(dout1_92) AT=110.05n

.meas tran vdout1_93ck100 FIND v(dout1_93) AT=110.05n

.meas tran vdout1_94ck100 FIND v(dout1_94) AT=110.05n

.meas tran vdout1_95ck100 FIND v(dout1_95) AT=110.05n

.meas tran vdout1_96ck100 FIND v(dout1_96) AT=110.05n

.meas tran vdout1_97ck100 FIND v(dout1_97) AT=110.05n

.meas tran vdout1_98ck100 FIND v(dout1_98) AT=110.05n

.meas tran vdout1_99ck100 FIND v(dout1_99) AT=110.05n

.meas tran vdout1_100ck100 FIND v(dout1_100) AT=110.05n

.meas tran vdout1_101ck100 FIND v(dout1_101) AT=110.05n

.meas tran vdout1_102ck100 FIND v(dout1_102) AT=110.05n

.meas tran vdout1_103ck100 FIND v(dout1_103) AT=110.05n

.meas tran vdout1_104ck100 FIND v(dout1_104) AT=110.05n

.meas tran vdout1_105ck100 FIND v(dout1_105) AT=110.05n

.meas tran vdout1_106ck100 FIND v(dout1_106) AT=110.05n

.meas tran vdout1_107ck100 FIND v(dout1_107) AT=110.05n

.meas tran vdout1_108ck100 FIND v(dout1_108) AT=110.05n

.meas tran vdout1_109ck100 FIND v(dout1_109) AT=110.05n

.meas tran vdout1_110ck100 FIND v(dout1_110) AT=110.05n

.meas tran vdout1_111ck100 FIND v(dout1_111) AT=110.05n

.meas tran vdout1_112ck100 FIND v(dout1_112) AT=110.05n

.meas tran vdout1_113ck100 FIND v(dout1_113) AT=110.05n

.meas tran vdout1_114ck100 FIND v(dout1_114) AT=110.05n

.meas tran vdout1_115ck100 FIND v(dout1_115) AT=110.05n

.meas tran vdout1_116ck100 FIND v(dout1_116) AT=110.05n

.meas tran vdout1_117ck100 FIND v(dout1_117) AT=110.05n

.meas tran vdout1_118ck100 FIND v(dout1_118) AT=110.05n

.meas tran vdout1_119ck100 FIND v(dout1_119) AT=110.05n

.meas tran vdout1_120ck100 FIND v(dout1_120) AT=110.05n

.meas tran vdout1_121ck100 FIND v(dout1_121) AT=110.05n

.meas tran vdout1_122ck100 FIND v(dout1_122) AT=110.05n

.meas tran vdout1_123ck100 FIND v(dout1_123) AT=110.05n

.meas tran vdout1_124ck100 FIND v(dout1_124) AT=110.05n

.meas tran vdout1_125ck100 FIND v(dout1_125) AT=110.05n

.meas tran vdout1_126ck100 FIND v(dout1_126) AT=110.05n

.meas tran vdout1_127ck100 FIND v(dout1_127) AT=110.05n

.meas tran vdout1_128ck100 FIND v(dout1_128) AT=110.05n

.meas tran vdout1_129ck100 FIND v(dout1_129) AT=110.05n

.meas tran vdout1_130ck100 FIND v(dout1_130) AT=110.05n

.meas tran vdout1_131ck100 FIND v(dout1_131) AT=110.05n

.meas tran vdout1_132ck100 FIND v(dout1_132) AT=110.05n

.meas tran vdout1_133ck100 FIND v(dout1_133) AT=110.05n

.meas tran vdout1_134ck100 FIND v(dout1_134) AT=110.05n

.meas tran vdout1_0ck120 FIND v(dout1_0) AT=130.05n

.meas tran vdout1_1ck120 FIND v(dout1_1) AT=130.05n

.meas tran vdout1_2ck120 FIND v(dout1_2) AT=130.05n

.meas tran vdout1_3ck120 FIND v(dout1_3) AT=130.05n

.meas tran vdout1_4ck120 FIND v(dout1_4) AT=130.05n

.meas tran vdout1_5ck120 FIND v(dout1_5) AT=130.05n

.meas tran vdout1_6ck120 FIND v(dout1_6) AT=130.05n

.meas tran vdout1_7ck120 FIND v(dout1_7) AT=130.05n

.meas tran vdout1_8ck120 FIND v(dout1_8) AT=130.05n

.meas tran vdout1_9ck120 FIND v(dout1_9) AT=130.05n

.meas tran vdout1_10ck120 FIND v(dout1_10) AT=130.05n

.meas tran vdout1_11ck120 FIND v(dout1_11) AT=130.05n

.meas tran vdout1_12ck120 FIND v(dout1_12) AT=130.05n

.meas tran vdout1_13ck120 FIND v(dout1_13) AT=130.05n

.meas tran vdout1_14ck120 FIND v(dout1_14) AT=130.05n

.meas tran vdout1_15ck120 FIND v(dout1_15) AT=130.05n

.meas tran vdout1_16ck120 FIND v(dout1_16) AT=130.05n

.meas tran vdout1_17ck120 FIND v(dout1_17) AT=130.05n

.meas tran vdout1_18ck120 FIND v(dout1_18) AT=130.05n

.meas tran vdout1_19ck120 FIND v(dout1_19) AT=130.05n

.meas tran vdout1_20ck120 FIND v(dout1_20) AT=130.05n

.meas tran vdout1_21ck120 FIND v(dout1_21) AT=130.05n

.meas tran vdout1_22ck120 FIND v(dout1_22) AT=130.05n

.meas tran vdout1_23ck120 FIND v(dout1_23) AT=130.05n

.meas tran vdout1_24ck120 FIND v(dout1_24) AT=130.05n

.meas tran vdout1_25ck120 FIND v(dout1_25) AT=130.05n

.meas tran vdout1_26ck120 FIND v(dout1_26) AT=130.05n

.meas tran vdout1_27ck120 FIND v(dout1_27) AT=130.05n

.meas tran vdout1_28ck120 FIND v(dout1_28) AT=130.05n

.meas tran vdout1_29ck120 FIND v(dout1_29) AT=130.05n

.meas tran vdout1_30ck120 FIND v(dout1_30) AT=130.05n

.meas tran vdout1_31ck120 FIND v(dout1_31) AT=130.05n

.meas tran vdout1_32ck120 FIND v(dout1_32) AT=130.05n

.meas tran vdout1_33ck120 FIND v(dout1_33) AT=130.05n

.meas tran vdout1_34ck120 FIND v(dout1_34) AT=130.05n

.meas tran vdout1_35ck120 FIND v(dout1_35) AT=130.05n

.meas tran vdout1_36ck120 FIND v(dout1_36) AT=130.05n

.meas tran vdout1_37ck120 FIND v(dout1_37) AT=130.05n

.meas tran vdout1_38ck120 FIND v(dout1_38) AT=130.05n

.meas tran vdout1_39ck120 FIND v(dout1_39) AT=130.05n

.meas tran vdout1_40ck120 FIND v(dout1_40) AT=130.05n

.meas tran vdout1_41ck120 FIND v(dout1_41) AT=130.05n

.meas tran vdout1_42ck120 FIND v(dout1_42) AT=130.05n

.meas tran vdout1_43ck120 FIND v(dout1_43) AT=130.05n

.meas tran vdout1_44ck120 FIND v(dout1_44) AT=130.05n

.meas tran vdout1_45ck120 FIND v(dout1_45) AT=130.05n

.meas tran vdout1_46ck120 FIND v(dout1_46) AT=130.05n

.meas tran vdout1_47ck120 FIND v(dout1_47) AT=130.05n

.meas tran vdout1_48ck120 FIND v(dout1_48) AT=130.05n

.meas tran vdout1_49ck120 FIND v(dout1_49) AT=130.05n

.meas tran vdout1_50ck120 FIND v(dout1_50) AT=130.05n

.meas tran vdout1_51ck120 FIND v(dout1_51) AT=130.05n

.meas tran vdout1_52ck120 FIND v(dout1_52) AT=130.05n

.meas tran vdout1_53ck120 FIND v(dout1_53) AT=130.05n

.meas tran vdout1_54ck120 FIND v(dout1_54) AT=130.05n

.meas tran vdout1_55ck120 FIND v(dout1_55) AT=130.05n

.meas tran vdout1_56ck120 FIND v(dout1_56) AT=130.05n

.meas tran vdout1_57ck120 FIND v(dout1_57) AT=130.05n

.meas tran vdout1_58ck120 FIND v(dout1_58) AT=130.05n

.meas tran vdout1_59ck120 FIND v(dout1_59) AT=130.05n

.meas tran vdout1_60ck120 FIND v(dout1_60) AT=130.05n

.meas tran vdout1_61ck120 FIND v(dout1_61) AT=130.05n

.meas tran vdout1_62ck120 FIND v(dout1_62) AT=130.05n

.meas tran vdout1_63ck120 FIND v(dout1_63) AT=130.05n

.meas tran vdout1_64ck120 FIND v(dout1_64) AT=130.05n

.meas tran vdout1_65ck120 FIND v(dout1_65) AT=130.05n

.meas tran vdout1_66ck120 FIND v(dout1_66) AT=130.05n

.meas tran vdout1_67ck120 FIND v(dout1_67) AT=130.05n

.meas tran vdout1_68ck120 FIND v(dout1_68) AT=130.05n

.meas tran vdout1_69ck120 FIND v(dout1_69) AT=130.05n

.meas tran vdout1_70ck120 FIND v(dout1_70) AT=130.05n

.meas tran vdout1_71ck120 FIND v(dout1_71) AT=130.05n

.meas tran vdout1_72ck120 FIND v(dout1_72) AT=130.05n

.meas tran vdout1_73ck120 FIND v(dout1_73) AT=130.05n

.meas tran vdout1_74ck120 FIND v(dout1_74) AT=130.05n

.meas tran vdout1_75ck120 FIND v(dout1_75) AT=130.05n

.meas tran vdout1_76ck120 FIND v(dout1_76) AT=130.05n

.meas tran vdout1_77ck120 FIND v(dout1_77) AT=130.05n

.meas tran vdout1_78ck120 FIND v(dout1_78) AT=130.05n

.meas tran vdout1_79ck120 FIND v(dout1_79) AT=130.05n

.meas tran vdout1_80ck120 FIND v(dout1_80) AT=130.05n

.meas tran vdout1_81ck120 FIND v(dout1_81) AT=130.05n

.meas tran vdout1_82ck120 FIND v(dout1_82) AT=130.05n

.meas tran vdout1_83ck120 FIND v(dout1_83) AT=130.05n

.meas tran vdout1_84ck120 FIND v(dout1_84) AT=130.05n

.meas tran vdout1_85ck120 FIND v(dout1_85) AT=130.05n

.meas tran vdout1_86ck120 FIND v(dout1_86) AT=130.05n

.meas tran vdout1_87ck120 FIND v(dout1_87) AT=130.05n

.meas tran vdout1_88ck120 FIND v(dout1_88) AT=130.05n

.meas tran vdout1_89ck120 FIND v(dout1_89) AT=130.05n

.meas tran vdout1_90ck120 FIND v(dout1_90) AT=130.05n

.meas tran vdout1_91ck120 FIND v(dout1_91) AT=130.05n

.meas tran vdout1_92ck120 FIND v(dout1_92) AT=130.05n

.meas tran vdout1_93ck120 FIND v(dout1_93) AT=130.05n

.meas tran vdout1_94ck120 FIND v(dout1_94) AT=130.05n

.meas tran vdout1_95ck120 FIND v(dout1_95) AT=130.05n

.meas tran vdout1_96ck120 FIND v(dout1_96) AT=130.05n

.meas tran vdout1_97ck120 FIND v(dout1_97) AT=130.05n

.meas tran vdout1_98ck120 FIND v(dout1_98) AT=130.05n

.meas tran vdout1_99ck120 FIND v(dout1_99) AT=130.05n

.meas tran vdout1_100ck120 FIND v(dout1_100) AT=130.05n

.meas tran vdout1_101ck120 FIND v(dout1_101) AT=130.05n

.meas tran vdout1_102ck120 FIND v(dout1_102) AT=130.05n

.meas tran vdout1_103ck120 FIND v(dout1_103) AT=130.05n

.meas tran vdout1_104ck120 FIND v(dout1_104) AT=130.05n

.meas tran vdout1_105ck120 FIND v(dout1_105) AT=130.05n

.meas tran vdout1_106ck120 FIND v(dout1_106) AT=130.05n

.meas tran vdout1_107ck120 FIND v(dout1_107) AT=130.05n

.meas tran vdout1_108ck120 FIND v(dout1_108) AT=130.05n

.meas tran vdout1_109ck120 FIND v(dout1_109) AT=130.05n

.meas tran vdout1_110ck120 FIND v(dout1_110) AT=130.05n

.meas tran vdout1_111ck120 FIND v(dout1_111) AT=130.05n

.meas tran vdout1_112ck120 FIND v(dout1_112) AT=130.05n

.meas tran vdout1_113ck120 FIND v(dout1_113) AT=130.05n

.meas tran vdout1_114ck120 FIND v(dout1_114) AT=130.05n

.meas tran vdout1_115ck120 FIND v(dout1_115) AT=130.05n

.meas tran vdout1_116ck120 FIND v(dout1_116) AT=130.05n

.meas tran vdout1_117ck120 FIND v(dout1_117) AT=130.05n

.meas tran vdout1_118ck120 FIND v(dout1_118) AT=130.05n

.meas tran vdout1_119ck120 FIND v(dout1_119) AT=130.05n

.meas tran vdout1_120ck120 FIND v(dout1_120) AT=130.05n

.meas tran vdout1_121ck120 FIND v(dout1_121) AT=130.05n

.meas tran vdout1_122ck120 FIND v(dout1_122) AT=130.05n

.meas tran vdout1_123ck120 FIND v(dout1_123) AT=130.05n

.meas tran vdout1_124ck120 FIND v(dout1_124) AT=130.05n

.meas tran vdout1_125ck120 FIND v(dout1_125) AT=130.05n

.meas tran vdout1_126ck120 FIND v(dout1_126) AT=130.05n

.meas tran vdout1_127ck120 FIND v(dout1_127) AT=130.05n

.meas tran vdout1_128ck120 FIND v(dout1_128) AT=130.05n

.meas tran vdout1_129ck120 FIND v(dout1_129) AT=130.05n

.meas tran vdout1_130ck120 FIND v(dout1_130) AT=130.05n

.meas tran vdout1_131ck120 FIND v(dout1_131) AT=130.05n

.meas tran vdout1_132ck120 FIND v(dout1_132) AT=130.05n

.meas tran vdout1_133ck120 FIND v(dout1_133) AT=130.05n

.meas tran vdout1_134ck120 FIND v(dout1_134) AT=130.05n

.meas tran vdout1_0ck140 FIND v(dout1_0) AT=150.05n

.meas tran vdout1_1ck140 FIND v(dout1_1) AT=150.05n

.meas tran vdout1_2ck140 FIND v(dout1_2) AT=150.05n

.meas tran vdout1_3ck140 FIND v(dout1_3) AT=150.05n

.meas tran vdout1_4ck140 FIND v(dout1_4) AT=150.05n

.meas tran vdout1_5ck140 FIND v(dout1_5) AT=150.05n

.meas tran vdout1_6ck140 FIND v(dout1_6) AT=150.05n

.meas tran vdout1_7ck140 FIND v(dout1_7) AT=150.05n

.meas tran vdout1_8ck140 FIND v(dout1_8) AT=150.05n

.meas tran vdout1_9ck140 FIND v(dout1_9) AT=150.05n

.meas tran vdout1_10ck140 FIND v(dout1_10) AT=150.05n

.meas tran vdout1_11ck140 FIND v(dout1_11) AT=150.05n

.meas tran vdout1_12ck140 FIND v(dout1_12) AT=150.05n

.meas tran vdout1_13ck140 FIND v(dout1_13) AT=150.05n

.meas tran vdout1_14ck140 FIND v(dout1_14) AT=150.05n

.meas tran vdout1_15ck140 FIND v(dout1_15) AT=150.05n

.meas tran vdout1_16ck140 FIND v(dout1_16) AT=150.05n

.meas tran vdout1_17ck140 FIND v(dout1_17) AT=150.05n

.meas tran vdout1_18ck140 FIND v(dout1_18) AT=150.05n

.meas tran vdout1_19ck140 FIND v(dout1_19) AT=150.05n

.meas tran vdout1_20ck140 FIND v(dout1_20) AT=150.05n

.meas tran vdout1_21ck140 FIND v(dout1_21) AT=150.05n

.meas tran vdout1_22ck140 FIND v(dout1_22) AT=150.05n

.meas tran vdout1_23ck140 FIND v(dout1_23) AT=150.05n

.meas tran vdout1_24ck140 FIND v(dout1_24) AT=150.05n

.meas tran vdout1_25ck140 FIND v(dout1_25) AT=150.05n

.meas tran vdout1_26ck140 FIND v(dout1_26) AT=150.05n

.meas tran vdout1_27ck140 FIND v(dout1_27) AT=150.05n

.meas tran vdout1_28ck140 FIND v(dout1_28) AT=150.05n

.meas tran vdout1_29ck140 FIND v(dout1_29) AT=150.05n

.meas tran vdout1_30ck140 FIND v(dout1_30) AT=150.05n

.meas tran vdout1_31ck140 FIND v(dout1_31) AT=150.05n

.meas tran vdout1_32ck140 FIND v(dout1_32) AT=150.05n

.meas tran vdout1_33ck140 FIND v(dout1_33) AT=150.05n

.meas tran vdout1_34ck140 FIND v(dout1_34) AT=150.05n

.meas tran vdout1_35ck140 FIND v(dout1_35) AT=150.05n

.meas tran vdout1_36ck140 FIND v(dout1_36) AT=150.05n

.meas tran vdout1_37ck140 FIND v(dout1_37) AT=150.05n

.meas tran vdout1_38ck140 FIND v(dout1_38) AT=150.05n

.meas tran vdout1_39ck140 FIND v(dout1_39) AT=150.05n

.meas tran vdout1_40ck140 FIND v(dout1_40) AT=150.05n

.meas tran vdout1_41ck140 FIND v(dout1_41) AT=150.05n

.meas tran vdout1_42ck140 FIND v(dout1_42) AT=150.05n

.meas tran vdout1_43ck140 FIND v(dout1_43) AT=150.05n

.meas tran vdout1_44ck140 FIND v(dout1_44) AT=150.05n

.meas tran vdout1_45ck140 FIND v(dout1_45) AT=150.05n

.meas tran vdout1_46ck140 FIND v(dout1_46) AT=150.05n

.meas tran vdout1_47ck140 FIND v(dout1_47) AT=150.05n

.meas tran vdout1_48ck140 FIND v(dout1_48) AT=150.05n

.meas tran vdout1_49ck140 FIND v(dout1_49) AT=150.05n

.meas tran vdout1_50ck140 FIND v(dout1_50) AT=150.05n

.meas tran vdout1_51ck140 FIND v(dout1_51) AT=150.05n

.meas tran vdout1_52ck140 FIND v(dout1_52) AT=150.05n

.meas tran vdout1_53ck140 FIND v(dout1_53) AT=150.05n

.meas tran vdout1_54ck140 FIND v(dout1_54) AT=150.05n

.meas tran vdout1_55ck140 FIND v(dout1_55) AT=150.05n

.meas tran vdout1_56ck140 FIND v(dout1_56) AT=150.05n

.meas tran vdout1_57ck140 FIND v(dout1_57) AT=150.05n

.meas tran vdout1_58ck140 FIND v(dout1_58) AT=150.05n

.meas tran vdout1_59ck140 FIND v(dout1_59) AT=150.05n

.meas tran vdout1_60ck140 FIND v(dout1_60) AT=150.05n

.meas tran vdout1_61ck140 FIND v(dout1_61) AT=150.05n

.meas tran vdout1_62ck140 FIND v(dout1_62) AT=150.05n

.meas tran vdout1_63ck140 FIND v(dout1_63) AT=150.05n

.meas tran vdout1_64ck140 FIND v(dout1_64) AT=150.05n

.meas tran vdout1_65ck140 FIND v(dout1_65) AT=150.05n

.meas tran vdout1_66ck140 FIND v(dout1_66) AT=150.05n

.meas tran vdout1_67ck140 FIND v(dout1_67) AT=150.05n

.meas tran vdout1_68ck140 FIND v(dout1_68) AT=150.05n

.meas tran vdout1_69ck140 FIND v(dout1_69) AT=150.05n

.meas tran vdout1_70ck140 FIND v(dout1_70) AT=150.05n

.meas tran vdout1_71ck140 FIND v(dout1_71) AT=150.05n

.meas tran vdout1_72ck140 FIND v(dout1_72) AT=150.05n

.meas tran vdout1_73ck140 FIND v(dout1_73) AT=150.05n

.meas tran vdout1_74ck140 FIND v(dout1_74) AT=150.05n

.meas tran vdout1_75ck140 FIND v(dout1_75) AT=150.05n

.meas tran vdout1_76ck140 FIND v(dout1_76) AT=150.05n

.meas tran vdout1_77ck140 FIND v(dout1_77) AT=150.05n

.meas tran vdout1_78ck140 FIND v(dout1_78) AT=150.05n

.meas tran vdout1_79ck140 FIND v(dout1_79) AT=150.05n

.meas tran vdout1_80ck140 FIND v(dout1_80) AT=150.05n

.meas tran vdout1_81ck140 FIND v(dout1_81) AT=150.05n

.meas tran vdout1_82ck140 FIND v(dout1_82) AT=150.05n

.meas tran vdout1_83ck140 FIND v(dout1_83) AT=150.05n

.meas tran vdout1_84ck140 FIND v(dout1_84) AT=150.05n

.meas tran vdout1_85ck140 FIND v(dout1_85) AT=150.05n

.meas tran vdout1_86ck140 FIND v(dout1_86) AT=150.05n

.meas tran vdout1_87ck140 FIND v(dout1_87) AT=150.05n

.meas tran vdout1_88ck140 FIND v(dout1_88) AT=150.05n

.meas tran vdout1_89ck140 FIND v(dout1_89) AT=150.05n

.meas tran vdout1_90ck140 FIND v(dout1_90) AT=150.05n

.meas tran vdout1_91ck140 FIND v(dout1_91) AT=150.05n

.meas tran vdout1_92ck140 FIND v(dout1_92) AT=150.05n

.meas tran vdout1_93ck140 FIND v(dout1_93) AT=150.05n

.meas tran vdout1_94ck140 FIND v(dout1_94) AT=150.05n

.meas tran vdout1_95ck140 FIND v(dout1_95) AT=150.05n

.meas tran vdout1_96ck140 FIND v(dout1_96) AT=150.05n

.meas tran vdout1_97ck140 FIND v(dout1_97) AT=150.05n

.meas tran vdout1_98ck140 FIND v(dout1_98) AT=150.05n

.meas tran vdout1_99ck140 FIND v(dout1_99) AT=150.05n

.meas tran vdout1_100ck140 FIND v(dout1_100) AT=150.05n

.meas tran vdout1_101ck140 FIND v(dout1_101) AT=150.05n

.meas tran vdout1_102ck140 FIND v(dout1_102) AT=150.05n

.meas tran vdout1_103ck140 FIND v(dout1_103) AT=150.05n

.meas tran vdout1_104ck140 FIND v(dout1_104) AT=150.05n

.meas tran vdout1_105ck140 FIND v(dout1_105) AT=150.05n

.meas tran vdout1_106ck140 FIND v(dout1_106) AT=150.05n

.meas tran vdout1_107ck140 FIND v(dout1_107) AT=150.05n

.meas tran vdout1_108ck140 FIND v(dout1_108) AT=150.05n

.meas tran vdout1_109ck140 FIND v(dout1_109) AT=150.05n

.meas tran vdout1_110ck140 FIND v(dout1_110) AT=150.05n

.meas tran vdout1_111ck140 FIND v(dout1_111) AT=150.05n

.meas tran vdout1_112ck140 FIND v(dout1_112) AT=150.05n

.meas tran vdout1_113ck140 FIND v(dout1_113) AT=150.05n

.meas tran vdout1_114ck140 FIND v(dout1_114) AT=150.05n

.meas tran vdout1_115ck140 FIND v(dout1_115) AT=150.05n

.meas tran vdout1_116ck140 FIND v(dout1_116) AT=150.05n

.meas tran vdout1_117ck140 FIND v(dout1_117) AT=150.05n

.meas tran vdout1_118ck140 FIND v(dout1_118) AT=150.05n

.meas tran vdout1_119ck140 FIND v(dout1_119) AT=150.05n

.meas tran vdout1_120ck140 FIND v(dout1_120) AT=150.05n

.meas tran vdout1_121ck140 FIND v(dout1_121) AT=150.05n

.meas tran vdout1_122ck140 FIND v(dout1_122) AT=150.05n

.meas tran vdout1_123ck140 FIND v(dout1_123) AT=150.05n

.meas tran vdout1_124ck140 FIND v(dout1_124) AT=150.05n

.meas tran vdout1_125ck140 FIND v(dout1_125) AT=150.05n

.meas tran vdout1_126ck140 FIND v(dout1_126) AT=150.05n

.meas tran vdout1_127ck140 FIND v(dout1_127) AT=150.05n

.meas tran vdout1_128ck140 FIND v(dout1_128) AT=150.05n

.meas tran vdout1_129ck140 FIND v(dout1_129) AT=150.05n

.meas tran vdout1_130ck140 FIND v(dout1_130) AT=150.05n

.meas tran vdout1_131ck140 FIND v(dout1_131) AT=150.05n

.meas tran vdout1_132ck140 FIND v(dout1_132) AT=150.05n

.meas tran vdout1_133ck140 FIND v(dout1_133) AT=150.05n

.meas tran vdout1_134ck140 FIND v(dout1_134) AT=150.05n

.meas tran vdout1_0ck150 FIND v(dout1_0) AT=160.05n

.meas tran vdout1_1ck150 FIND v(dout1_1) AT=160.05n

.meas tran vdout1_2ck150 FIND v(dout1_2) AT=160.05n

.meas tran vdout1_3ck150 FIND v(dout1_3) AT=160.05n

.meas tran vdout1_4ck150 FIND v(dout1_4) AT=160.05n

.meas tran vdout1_5ck150 FIND v(dout1_5) AT=160.05n

.meas tran vdout1_6ck150 FIND v(dout1_6) AT=160.05n

.meas tran vdout1_7ck150 FIND v(dout1_7) AT=160.05n

.meas tran vdout1_8ck150 FIND v(dout1_8) AT=160.05n

.meas tran vdout1_9ck150 FIND v(dout1_9) AT=160.05n

.meas tran vdout1_10ck150 FIND v(dout1_10) AT=160.05n

.meas tran vdout1_11ck150 FIND v(dout1_11) AT=160.05n

.meas tran vdout1_12ck150 FIND v(dout1_12) AT=160.05n

.meas tran vdout1_13ck150 FIND v(dout1_13) AT=160.05n

.meas tran vdout1_14ck150 FIND v(dout1_14) AT=160.05n

.meas tran vdout1_15ck150 FIND v(dout1_15) AT=160.05n

.meas tran vdout1_16ck150 FIND v(dout1_16) AT=160.05n

.meas tran vdout1_17ck150 FIND v(dout1_17) AT=160.05n

.meas tran vdout1_18ck150 FIND v(dout1_18) AT=160.05n

.meas tran vdout1_19ck150 FIND v(dout1_19) AT=160.05n

.meas tran vdout1_20ck150 FIND v(dout1_20) AT=160.05n

.meas tran vdout1_21ck150 FIND v(dout1_21) AT=160.05n

.meas tran vdout1_22ck150 FIND v(dout1_22) AT=160.05n

.meas tran vdout1_23ck150 FIND v(dout1_23) AT=160.05n

.meas tran vdout1_24ck150 FIND v(dout1_24) AT=160.05n

.meas tran vdout1_25ck150 FIND v(dout1_25) AT=160.05n

.meas tran vdout1_26ck150 FIND v(dout1_26) AT=160.05n

.meas tran vdout1_27ck150 FIND v(dout1_27) AT=160.05n

.meas tran vdout1_28ck150 FIND v(dout1_28) AT=160.05n

.meas tran vdout1_29ck150 FIND v(dout1_29) AT=160.05n

.meas tran vdout1_30ck150 FIND v(dout1_30) AT=160.05n

.meas tran vdout1_31ck150 FIND v(dout1_31) AT=160.05n

.meas tran vdout1_32ck150 FIND v(dout1_32) AT=160.05n

.meas tran vdout1_33ck150 FIND v(dout1_33) AT=160.05n

.meas tran vdout1_34ck150 FIND v(dout1_34) AT=160.05n

.meas tran vdout1_35ck150 FIND v(dout1_35) AT=160.05n

.meas tran vdout1_36ck150 FIND v(dout1_36) AT=160.05n

.meas tran vdout1_37ck150 FIND v(dout1_37) AT=160.05n

.meas tran vdout1_38ck150 FIND v(dout1_38) AT=160.05n

.meas tran vdout1_39ck150 FIND v(dout1_39) AT=160.05n

.meas tran vdout1_40ck150 FIND v(dout1_40) AT=160.05n

.meas tran vdout1_41ck150 FIND v(dout1_41) AT=160.05n

.meas tran vdout1_42ck150 FIND v(dout1_42) AT=160.05n

.meas tran vdout1_43ck150 FIND v(dout1_43) AT=160.05n

.meas tran vdout1_44ck150 FIND v(dout1_44) AT=160.05n

.meas tran vdout1_45ck150 FIND v(dout1_45) AT=160.05n

.meas tran vdout1_46ck150 FIND v(dout1_46) AT=160.05n

.meas tran vdout1_47ck150 FIND v(dout1_47) AT=160.05n

.meas tran vdout1_48ck150 FIND v(dout1_48) AT=160.05n

.meas tran vdout1_49ck150 FIND v(dout1_49) AT=160.05n

.meas tran vdout1_50ck150 FIND v(dout1_50) AT=160.05n

.meas tran vdout1_51ck150 FIND v(dout1_51) AT=160.05n

.meas tran vdout1_52ck150 FIND v(dout1_52) AT=160.05n

.meas tran vdout1_53ck150 FIND v(dout1_53) AT=160.05n

.meas tran vdout1_54ck150 FIND v(dout1_54) AT=160.05n

.meas tran vdout1_55ck150 FIND v(dout1_55) AT=160.05n

.meas tran vdout1_56ck150 FIND v(dout1_56) AT=160.05n

.meas tran vdout1_57ck150 FIND v(dout1_57) AT=160.05n

.meas tran vdout1_58ck150 FIND v(dout1_58) AT=160.05n

.meas tran vdout1_59ck150 FIND v(dout1_59) AT=160.05n

.meas tran vdout1_60ck150 FIND v(dout1_60) AT=160.05n

.meas tran vdout1_61ck150 FIND v(dout1_61) AT=160.05n

.meas tran vdout1_62ck150 FIND v(dout1_62) AT=160.05n

.meas tran vdout1_63ck150 FIND v(dout1_63) AT=160.05n

.meas tran vdout1_64ck150 FIND v(dout1_64) AT=160.05n

.meas tran vdout1_65ck150 FIND v(dout1_65) AT=160.05n

.meas tran vdout1_66ck150 FIND v(dout1_66) AT=160.05n

.meas tran vdout1_67ck150 FIND v(dout1_67) AT=160.05n

.meas tran vdout1_68ck150 FIND v(dout1_68) AT=160.05n

.meas tran vdout1_69ck150 FIND v(dout1_69) AT=160.05n

.meas tran vdout1_70ck150 FIND v(dout1_70) AT=160.05n

.meas tran vdout1_71ck150 FIND v(dout1_71) AT=160.05n

.meas tran vdout1_72ck150 FIND v(dout1_72) AT=160.05n

.meas tran vdout1_73ck150 FIND v(dout1_73) AT=160.05n

.meas tran vdout1_74ck150 FIND v(dout1_74) AT=160.05n

.meas tran vdout1_75ck150 FIND v(dout1_75) AT=160.05n

.meas tran vdout1_76ck150 FIND v(dout1_76) AT=160.05n

.meas tran vdout1_77ck150 FIND v(dout1_77) AT=160.05n

.meas tran vdout1_78ck150 FIND v(dout1_78) AT=160.05n

.meas tran vdout1_79ck150 FIND v(dout1_79) AT=160.05n

.meas tran vdout1_80ck150 FIND v(dout1_80) AT=160.05n

.meas tran vdout1_81ck150 FIND v(dout1_81) AT=160.05n

.meas tran vdout1_82ck150 FIND v(dout1_82) AT=160.05n

.meas tran vdout1_83ck150 FIND v(dout1_83) AT=160.05n

.meas tran vdout1_84ck150 FIND v(dout1_84) AT=160.05n

.meas tran vdout1_85ck150 FIND v(dout1_85) AT=160.05n

.meas tran vdout1_86ck150 FIND v(dout1_86) AT=160.05n

.meas tran vdout1_87ck150 FIND v(dout1_87) AT=160.05n

.meas tran vdout1_88ck150 FIND v(dout1_88) AT=160.05n

.meas tran vdout1_89ck150 FIND v(dout1_89) AT=160.05n

.meas tran vdout1_90ck150 FIND v(dout1_90) AT=160.05n

.meas tran vdout1_91ck150 FIND v(dout1_91) AT=160.05n

.meas tran vdout1_92ck150 FIND v(dout1_92) AT=160.05n

.meas tran vdout1_93ck150 FIND v(dout1_93) AT=160.05n

.meas tran vdout1_94ck150 FIND v(dout1_94) AT=160.05n

.meas tran vdout1_95ck150 FIND v(dout1_95) AT=160.05n

.meas tran vdout1_96ck150 FIND v(dout1_96) AT=160.05n

.meas tran vdout1_97ck150 FIND v(dout1_97) AT=160.05n

.meas tran vdout1_98ck150 FIND v(dout1_98) AT=160.05n

.meas tran vdout1_99ck150 FIND v(dout1_99) AT=160.05n

.meas tran vdout1_100ck150 FIND v(dout1_100) AT=160.05n

.meas tran vdout1_101ck150 FIND v(dout1_101) AT=160.05n

.meas tran vdout1_102ck150 FIND v(dout1_102) AT=160.05n

.meas tran vdout1_103ck150 FIND v(dout1_103) AT=160.05n

.meas tran vdout1_104ck150 FIND v(dout1_104) AT=160.05n

.meas tran vdout1_105ck150 FIND v(dout1_105) AT=160.05n

.meas tran vdout1_106ck150 FIND v(dout1_106) AT=160.05n

.meas tran vdout1_107ck150 FIND v(dout1_107) AT=160.05n

.meas tran vdout1_108ck150 FIND v(dout1_108) AT=160.05n

.meas tran vdout1_109ck150 FIND v(dout1_109) AT=160.05n

.meas tran vdout1_110ck150 FIND v(dout1_110) AT=160.05n

.meas tran vdout1_111ck150 FIND v(dout1_111) AT=160.05n

.meas tran vdout1_112ck150 FIND v(dout1_112) AT=160.05n

.meas tran vdout1_113ck150 FIND v(dout1_113) AT=160.05n

.meas tran vdout1_114ck150 FIND v(dout1_114) AT=160.05n

.meas tran vdout1_115ck150 FIND v(dout1_115) AT=160.05n

.meas tran vdout1_116ck150 FIND v(dout1_116) AT=160.05n

.meas tran vdout1_117ck150 FIND v(dout1_117) AT=160.05n

.meas tran vdout1_118ck150 FIND v(dout1_118) AT=160.05n

.meas tran vdout1_119ck150 FIND v(dout1_119) AT=160.05n

.meas tran vdout1_120ck150 FIND v(dout1_120) AT=160.05n

.meas tran vdout1_121ck150 FIND v(dout1_121) AT=160.05n

.meas tran vdout1_122ck150 FIND v(dout1_122) AT=160.05n

.meas tran vdout1_123ck150 FIND v(dout1_123) AT=160.05n

.meas tran vdout1_124ck150 FIND v(dout1_124) AT=160.05n

.meas tran vdout1_125ck150 FIND v(dout1_125) AT=160.05n

.meas tran vdout1_126ck150 FIND v(dout1_126) AT=160.05n

.meas tran vdout1_127ck150 FIND v(dout1_127) AT=160.05n

.meas tran vdout1_128ck150 FIND v(dout1_128) AT=160.05n

.meas tran vdout1_129ck150 FIND v(dout1_129) AT=160.05n

.meas tran vdout1_130ck150 FIND v(dout1_130) AT=160.05n

.meas tran vdout1_131ck150 FIND v(dout1_131) AT=160.05n

.meas tran vdout1_132ck150 FIND v(dout1_132) AT=160.05n

.meas tran vdout1_133ck150 FIND v(dout1_133) AT=160.05n

.meas tran vdout1_134ck150 FIND v(dout1_134) AT=160.05n

.meas tran vdout1_0ck190 FIND v(dout1_0) AT=200.05n

.meas tran vdout1_1ck190 FIND v(dout1_1) AT=200.05n

.meas tran vdout1_2ck190 FIND v(dout1_2) AT=200.05n

.meas tran vdout1_3ck190 FIND v(dout1_3) AT=200.05n

.meas tran vdout1_4ck190 FIND v(dout1_4) AT=200.05n

.meas tran vdout1_5ck190 FIND v(dout1_5) AT=200.05n

.meas tran vdout1_6ck190 FIND v(dout1_6) AT=200.05n

.meas tran vdout1_7ck190 FIND v(dout1_7) AT=200.05n

.meas tran vdout1_8ck190 FIND v(dout1_8) AT=200.05n

.meas tran vdout1_9ck190 FIND v(dout1_9) AT=200.05n

.meas tran vdout1_10ck190 FIND v(dout1_10) AT=200.05n

.meas tran vdout1_11ck190 FIND v(dout1_11) AT=200.05n

.meas tran vdout1_12ck190 FIND v(dout1_12) AT=200.05n

.meas tran vdout1_13ck190 FIND v(dout1_13) AT=200.05n

.meas tran vdout1_14ck190 FIND v(dout1_14) AT=200.05n

.meas tran vdout1_15ck190 FIND v(dout1_15) AT=200.05n

.meas tran vdout1_16ck190 FIND v(dout1_16) AT=200.05n

.meas tran vdout1_17ck190 FIND v(dout1_17) AT=200.05n

.meas tran vdout1_18ck190 FIND v(dout1_18) AT=200.05n

.meas tran vdout1_19ck190 FIND v(dout1_19) AT=200.05n

.meas tran vdout1_20ck190 FIND v(dout1_20) AT=200.05n

.meas tran vdout1_21ck190 FIND v(dout1_21) AT=200.05n

.meas tran vdout1_22ck190 FIND v(dout1_22) AT=200.05n

.meas tran vdout1_23ck190 FIND v(dout1_23) AT=200.05n

.meas tran vdout1_24ck190 FIND v(dout1_24) AT=200.05n

.meas tran vdout1_25ck190 FIND v(dout1_25) AT=200.05n

.meas tran vdout1_26ck190 FIND v(dout1_26) AT=200.05n

.meas tran vdout1_27ck190 FIND v(dout1_27) AT=200.05n

.meas tran vdout1_28ck190 FIND v(dout1_28) AT=200.05n

.meas tran vdout1_29ck190 FIND v(dout1_29) AT=200.05n

.meas tran vdout1_30ck190 FIND v(dout1_30) AT=200.05n

.meas tran vdout1_31ck190 FIND v(dout1_31) AT=200.05n

.meas tran vdout1_32ck190 FIND v(dout1_32) AT=200.05n

.meas tran vdout1_33ck190 FIND v(dout1_33) AT=200.05n

.meas tran vdout1_34ck190 FIND v(dout1_34) AT=200.05n

.meas tran vdout1_35ck190 FIND v(dout1_35) AT=200.05n

.meas tran vdout1_36ck190 FIND v(dout1_36) AT=200.05n

.meas tran vdout1_37ck190 FIND v(dout1_37) AT=200.05n

.meas tran vdout1_38ck190 FIND v(dout1_38) AT=200.05n

.meas tran vdout1_39ck190 FIND v(dout1_39) AT=200.05n

.meas tran vdout1_40ck190 FIND v(dout1_40) AT=200.05n

.meas tran vdout1_41ck190 FIND v(dout1_41) AT=200.05n

.meas tran vdout1_42ck190 FIND v(dout1_42) AT=200.05n

.meas tran vdout1_43ck190 FIND v(dout1_43) AT=200.05n

.meas tran vdout1_44ck190 FIND v(dout1_44) AT=200.05n

.meas tran vdout1_45ck190 FIND v(dout1_45) AT=200.05n

.meas tran vdout1_46ck190 FIND v(dout1_46) AT=200.05n

.meas tran vdout1_47ck190 FIND v(dout1_47) AT=200.05n

.meas tran vdout1_48ck190 FIND v(dout1_48) AT=200.05n

.meas tran vdout1_49ck190 FIND v(dout1_49) AT=200.05n

.meas tran vdout1_50ck190 FIND v(dout1_50) AT=200.05n

.meas tran vdout1_51ck190 FIND v(dout1_51) AT=200.05n

.meas tran vdout1_52ck190 FIND v(dout1_52) AT=200.05n

.meas tran vdout1_53ck190 FIND v(dout1_53) AT=200.05n

.meas tran vdout1_54ck190 FIND v(dout1_54) AT=200.05n

.meas tran vdout1_55ck190 FIND v(dout1_55) AT=200.05n

.meas tran vdout1_56ck190 FIND v(dout1_56) AT=200.05n

.meas tran vdout1_57ck190 FIND v(dout1_57) AT=200.05n

.meas tran vdout1_58ck190 FIND v(dout1_58) AT=200.05n

.meas tran vdout1_59ck190 FIND v(dout1_59) AT=200.05n

.meas tran vdout1_60ck190 FIND v(dout1_60) AT=200.05n

.meas tran vdout1_61ck190 FIND v(dout1_61) AT=200.05n

.meas tran vdout1_62ck190 FIND v(dout1_62) AT=200.05n

.meas tran vdout1_63ck190 FIND v(dout1_63) AT=200.05n

.meas tran vdout1_64ck190 FIND v(dout1_64) AT=200.05n

.meas tran vdout1_65ck190 FIND v(dout1_65) AT=200.05n

.meas tran vdout1_66ck190 FIND v(dout1_66) AT=200.05n

.meas tran vdout1_67ck190 FIND v(dout1_67) AT=200.05n

.meas tran vdout1_68ck190 FIND v(dout1_68) AT=200.05n

.meas tran vdout1_69ck190 FIND v(dout1_69) AT=200.05n

.meas tran vdout1_70ck190 FIND v(dout1_70) AT=200.05n

.meas tran vdout1_71ck190 FIND v(dout1_71) AT=200.05n

.meas tran vdout1_72ck190 FIND v(dout1_72) AT=200.05n

.meas tran vdout1_73ck190 FIND v(dout1_73) AT=200.05n

.meas tran vdout1_74ck190 FIND v(dout1_74) AT=200.05n

.meas tran vdout1_75ck190 FIND v(dout1_75) AT=200.05n

.meas tran vdout1_76ck190 FIND v(dout1_76) AT=200.05n

.meas tran vdout1_77ck190 FIND v(dout1_77) AT=200.05n

.meas tran vdout1_78ck190 FIND v(dout1_78) AT=200.05n

.meas tran vdout1_79ck190 FIND v(dout1_79) AT=200.05n

.meas tran vdout1_80ck190 FIND v(dout1_80) AT=200.05n

.meas tran vdout1_81ck190 FIND v(dout1_81) AT=200.05n

.meas tran vdout1_82ck190 FIND v(dout1_82) AT=200.05n

.meas tran vdout1_83ck190 FIND v(dout1_83) AT=200.05n

.meas tran vdout1_84ck190 FIND v(dout1_84) AT=200.05n

.meas tran vdout1_85ck190 FIND v(dout1_85) AT=200.05n

.meas tran vdout1_86ck190 FIND v(dout1_86) AT=200.05n

.meas tran vdout1_87ck190 FIND v(dout1_87) AT=200.05n

.meas tran vdout1_88ck190 FIND v(dout1_88) AT=200.05n

.meas tran vdout1_89ck190 FIND v(dout1_89) AT=200.05n

.meas tran vdout1_90ck190 FIND v(dout1_90) AT=200.05n

.meas tran vdout1_91ck190 FIND v(dout1_91) AT=200.05n

.meas tran vdout1_92ck190 FIND v(dout1_92) AT=200.05n

.meas tran vdout1_93ck190 FIND v(dout1_93) AT=200.05n

.meas tran vdout1_94ck190 FIND v(dout1_94) AT=200.05n

.meas tran vdout1_95ck190 FIND v(dout1_95) AT=200.05n

.meas tran vdout1_96ck190 FIND v(dout1_96) AT=200.05n

.meas tran vdout1_97ck190 FIND v(dout1_97) AT=200.05n

.meas tran vdout1_98ck190 FIND v(dout1_98) AT=200.05n

.meas tran vdout1_99ck190 FIND v(dout1_99) AT=200.05n

.meas tran vdout1_100ck190 FIND v(dout1_100) AT=200.05n

.meas tran vdout1_101ck190 FIND v(dout1_101) AT=200.05n

.meas tran vdout1_102ck190 FIND v(dout1_102) AT=200.05n

.meas tran vdout1_103ck190 FIND v(dout1_103) AT=200.05n

.meas tran vdout1_104ck190 FIND v(dout1_104) AT=200.05n

.meas tran vdout1_105ck190 FIND v(dout1_105) AT=200.05n

.meas tran vdout1_106ck190 FIND v(dout1_106) AT=200.05n

.meas tran vdout1_107ck190 FIND v(dout1_107) AT=200.05n

.meas tran vdout1_108ck190 FIND v(dout1_108) AT=200.05n

.meas tran vdout1_109ck190 FIND v(dout1_109) AT=200.05n

.meas tran vdout1_110ck190 FIND v(dout1_110) AT=200.05n

.meas tran vdout1_111ck190 FIND v(dout1_111) AT=200.05n

.meas tran vdout1_112ck190 FIND v(dout1_112) AT=200.05n

.meas tran vdout1_113ck190 FIND v(dout1_113) AT=200.05n

.meas tran vdout1_114ck190 FIND v(dout1_114) AT=200.05n

.meas tran vdout1_115ck190 FIND v(dout1_115) AT=200.05n

.meas tran vdout1_116ck190 FIND v(dout1_116) AT=200.05n

.meas tran vdout1_117ck190 FIND v(dout1_117) AT=200.05n

.meas tran vdout1_118ck190 FIND v(dout1_118) AT=200.05n

.meas tran vdout1_119ck190 FIND v(dout1_119) AT=200.05n

.meas tran vdout1_120ck190 FIND v(dout1_120) AT=200.05n

.meas tran vdout1_121ck190 FIND v(dout1_121) AT=200.05n

.meas tran vdout1_122ck190 FIND v(dout1_122) AT=200.05n

.meas tran vdout1_123ck190 FIND v(dout1_123) AT=200.05n

.meas tran vdout1_124ck190 FIND v(dout1_124) AT=200.05n

.meas tran vdout1_125ck190 FIND v(dout1_125) AT=200.05n

.meas tran vdout1_126ck190 FIND v(dout1_126) AT=200.05n

.meas tran vdout1_127ck190 FIND v(dout1_127) AT=200.05n

.meas tran vdout1_128ck190 FIND v(dout1_128) AT=200.05n

.meas tran vdout1_129ck190 FIND v(dout1_129) AT=200.05n

.meas tran vdout1_130ck190 FIND v(dout1_130) AT=200.05n

.meas tran vdout1_131ck190 FIND v(dout1_131) AT=200.05n

.meas tran vdout1_132ck190 FIND v(dout1_132) AT=200.05n

.meas tran vdout1_133ck190 FIND v(dout1_133) AT=200.05n

.meas tran vdout1_134ck190 FIND v(dout1_134) AT=200.05n

.meas tran vdout1_0ck210 FIND v(dout1_0) AT=220.05n

.meas tran vdout1_1ck210 FIND v(dout1_1) AT=220.05n

.meas tran vdout1_2ck210 FIND v(dout1_2) AT=220.05n

.meas tran vdout1_3ck210 FIND v(dout1_3) AT=220.05n

.meas tran vdout1_4ck210 FIND v(dout1_4) AT=220.05n

.meas tran vdout1_5ck210 FIND v(dout1_5) AT=220.05n

.meas tran vdout1_6ck210 FIND v(dout1_6) AT=220.05n

.meas tran vdout1_7ck210 FIND v(dout1_7) AT=220.05n

.meas tran vdout1_8ck210 FIND v(dout1_8) AT=220.05n

.meas tran vdout1_9ck210 FIND v(dout1_9) AT=220.05n

.meas tran vdout1_10ck210 FIND v(dout1_10) AT=220.05n

.meas tran vdout1_11ck210 FIND v(dout1_11) AT=220.05n

.meas tran vdout1_12ck210 FIND v(dout1_12) AT=220.05n

.meas tran vdout1_13ck210 FIND v(dout1_13) AT=220.05n

.meas tran vdout1_14ck210 FIND v(dout1_14) AT=220.05n

.meas tran vdout1_15ck210 FIND v(dout1_15) AT=220.05n

.meas tran vdout1_16ck210 FIND v(dout1_16) AT=220.05n

.meas tran vdout1_17ck210 FIND v(dout1_17) AT=220.05n

.meas tran vdout1_18ck210 FIND v(dout1_18) AT=220.05n

.meas tran vdout1_19ck210 FIND v(dout1_19) AT=220.05n

.meas tran vdout1_20ck210 FIND v(dout1_20) AT=220.05n

.meas tran vdout1_21ck210 FIND v(dout1_21) AT=220.05n

.meas tran vdout1_22ck210 FIND v(dout1_22) AT=220.05n

.meas tran vdout1_23ck210 FIND v(dout1_23) AT=220.05n

.meas tran vdout1_24ck210 FIND v(dout1_24) AT=220.05n

.meas tran vdout1_25ck210 FIND v(dout1_25) AT=220.05n

.meas tran vdout1_26ck210 FIND v(dout1_26) AT=220.05n

.meas tran vdout1_27ck210 FIND v(dout1_27) AT=220.05n

.meas tran vdout1_28ck210 FIND v(dout1_28) AT=220.05n

.meas tran vdout1_29ck210 FIND v(dout1_29) AT=220.05n

.meas tran vdout1_30ck210 FIND v(dout1_30) AT=220.05n

.meas tran vdout1_31ck210 FIND v(dout1_31) AT=220.05n

.meas tran vdout1_32ck210 FIND v(dout1_32) AT=220.05n

.meas tran vdout1_33ck210 FIND v(dout1_33) AT=220.05n

.meas tran vdout1_34ck210 FIND v(dout1_34) AT=220.05n

.meas tran vdout1_35ck210 FIND v(dout1_35) AT=220.05n

.meas tran vdout1_36ck210 FIND v(dout1_36) AT=220.05n

.meas tran vdout1_37ck210 FIND v(dout1_37) AT=220.05n

.meas tran vdout1_38ck210 FIND v(dout1_38) AT=220.05n

.meas tran vdout1_39ck210 FIND v(dout1_39) AT=220.05n

.meas tran vdout1_40ck210 FIND v(dout1_40) AT=220.05n

.meas tran vdout1_41ck210 FIND v(dout1_41) AT=220.05n

.meas tran vdout1_42ck210 FIND v(dout1_42) AT=220.05n

.meas tran vdout1_43ck210 FIND v(dout1_43) AT=220.05n

.meas tran vdout1_44ck210 FIND v(dout1_44) AT=220.05n

.meas tran vdout1_45ck210 FIND v(dout1_45) AT=220.05n

.meas tran vdout1_46ck210 FIND v(dout1_46) AT=220.05n

.meas tran vdout1_47ck210 FIND v(dout1_47) AT=220.05n

.meas tran vdout1_48ck210 FIND v(dout1_48) AT=220.05n

.meas tran vdout1_49ck210 FIND v(dout1_49) AT=220.05n

.meas tran vdout1_50ck210 FIND v(dout1_50) AT=220.05n

.meas tran vdout1_51ck210 FIND v(dout1_51) AT=220.05n

.meas tran vdout1_52ck210 FIND v(dout1_52) AT=220.05n

.meas tran vdout1_53ck210 FIND v(dout1_53) AT=220.05n

.meas tran vdout1_54ck210 FIND v(dout1_54) AT=220.05n

.meas tran vdout1_55ck210 FIND v(dout1_55) AT=220.05n

.meas tran vdout1_56ck210 FIND v(dout1_56) AT=220.05n

.meas tran vdout1_57ck210 FIND v(dout1_57) AT=220.05n

.meas tran vdout1_58ck210 FIND v(dout1_58) AT=220.05n

.meas tran vdout1_59ck210 FIND v(dout1_59) AT=220.05n

.meas tran vdout1_60ck210 FIND v(dout1_60) AT=220.05n

.meas tran vdout1_61ck210 FIND v(dout1_61) AT=220.05n

.meas tran vdout1_62ck210 FIND v(dout1_62) AT=220.05n

.meas tran vdout1_63ck210 FIND v(dout1_63) AT=220.05n

.meas tran vdout1_64ck210 FIND v(dout1_64) AT=220.05n

.meas tran vdout1_65ck210 FIND v(dout1_65) AT=220.05n

.meas tran vdout1_66ck210 FIND v(dout1_66) AT=220.05n

.meas tran vdout1_67ck210 FIND v(dout1_67) AT=220.05n

.meas tran vdout1_68ck210 FIND v(dout1_68) AT=220.05n

.meas tran vdout1_69ck210 FIND v(dout1_69) AT=220.05n

.meas tran vdout1_70ck210 FIND v(dout1_70) AT=220.05n

.meas tran vdout1_71ck210 FIND v(dout1_71) AT=220.05n

.meas tran vdout1_72ck210 FIND v(dout1_72) AT=220.05n

.meas tran vdout1_73ck210 FIND v(dout1_73) AT=220.05n

.meas tran vdout1_74ck210 FIND v(dout1_74) AT=220.05n

.meas tran vdout1_75ck210 FIND v(dout1_75) AT=220.05n

.meas tran vdout1_76ck210 FIND v(dout1_76) AT=220.05n

.meas tran vdout1_77ck210 FIND v(dout1_77) AT=220.05n

.meas tran vdout1_78ck210 FIND v(dout1_78) AT=220.05n

.meas tran vdout1_79ck210 FIND v(dout1_79) AT=220.05n

.meas tran vdout1_80ck210 FIND v(dout1_80) AT=220.05n

.meas tran vdout1_81ck210 FIND v(dout1_81) AT=220.05n

.meas tran vdout1_82ck210 FIND v(dout1_82) AT=220.05n

.meas tran vdout1_83ck210 FIND v(dout1_83) AT=220.05n

.meas tran vdout1_84ck210 FIND v(dout1_84) AT=220.05n

.meas tran vdout1_85ck210 FIND v(dout1_85) AT=220.05n

.meas tran vdout1_86ck210 FIND v(dout1_86) AT=220.05n

.meas tran vdout1_87ck210 FIND v(dout1_87) AT=220.05n

.meas tran vdout1_88ck210 FIND v(dout1_88) AT=220.05n

.meas tran vdout1_89ck210 FIND v(dout1_89) AT=220.05n

.meas tran vdout1_90ck210 FIND v(dout1_90) AT=220.05n

.meas tran vdout1_91ck210 FIND v(dout1_91) AT=220.05n

.meas tran vdout1_92ck210 FIND v(dout1_92) AT=220.05n

.meas tran vdout1_93ck210 FIND v(dout1_93) AT=220.05n

.meas tran vdout1_94ck210 FIND v(dout1_94) AT=220.05n

.meas tran vdout1_95ck210 FIND v(dout1_95) AT=220.05n

.meas tran vdout1_96ck210 FIND v(dout1_96) AT=220.05n

.meas tran vdout1_97ck210 FIND v(dout1_97) AT=220.05n

.meas tran vdout1_98ck210 FIND v(dout1_98) AT=220.05n

.meas tran vdout1_99ck210 FIND v(dout1_99) AT=220.05n

.meas tran vdout1_100ck210 FIND v(dout1_100) AT=220.05n

.meas tran vdout1_101ck210 FIND v(dout1_101) AT=220.05n

.meas tran vdout1_102ck210 FIND v(dout1_102) AT=220.05n

.meas tran vdout1_103ck210 FIND v(dout1_103) AT=220.05n

.meas tran vdout1_104ck210 FIND v(dout1_104) AT=220.05n

.meas tran vdout1_105ck210 FIND v(dout1_105) AT=220.05n

.meas tran vdout1_106ck210 FIND v(dout1_106) AT=220.05n

.meas tran vdout1_107ck210 FIND v(dout1_107) AT=220.05n

.meas tran vdout1_108ck210 FIND v(dout1_108) AT=220.05n

.meas tran vdout1_109ck210 FIND v(dout1_109) AT=220.05n

.meas tran vdout1_110ck210 FIND v(dout1_110) AT=220.05n

.meas tran vdout1_111ck210 FIND v(dout1_111) AT=220.05n

.meas tran vdout1_112ck210 FIND v(dout1_112) AT=220.05n

.meas tran vdout1_113ck210 FIND v(dout1_113) AT=220.05n

.meas tran vdout1_114ck210 FIND v(dout1_114) AT=220.05n

.meas tran vdout1_115ck210 FIND v(dout1_115) AT=220.05n

.meas tran vdout1_116ck210 FIND v(dout1_116) AT=220.05n

.meas tran vdout1_117ck210 FIND v(dout1_117) AT=220.05n

.meas tran vdout1_118ck210 FIND v(dout1_118) AT=220.05n

.meas tran vdout1_119ck210 FIND v(dout1_119) AT=220.05n

.meas tran vdout1_120ck210 FIND v(dout1_120) AT=220.05n

.meas tran vdout1_121ck210 FIND v(dout1_121) AT=220.05n

.meas tran vdout1_122ck210 FIND v(dout1_122) AT=220.05n

.meas tran vdout1_123ck210 FIND v(dout1_123) AT=220.05n

.meas tran vdout1_124ck210 FIND v(dout1_124) AT=220.05n

.meas tran vdout1_125ck210 FIND v(dout1_125) AT=220.05n

.meas tran vdout1_126ck210 FIND v(dout1_126) AT=220.05n

.meas tran vdout1_127ck210 FIND v(dout1_127) AT=220.05n

.meas tran vdout1_128ck210 FIND v(dout1_128) AT=220.05n

.meas tran vdout1_129ck210 FIND v(dout1_129) AT=220.05n

.meas tran vdout1_130ck210 FIND v(dout1_130) AT=220.05n

.meas tran vdout1_131ck210 FIND v(dout1_131) AT=220.05n

.meas tran vdout1_132ck210 FIND v(dout1_132) AT=220.05n

.meas tran vdout1_133ck210 FIND v(dout1_133) AT=220.05n

.meas tran vdout1_134ck210 FIND v(dout1_134) AT=220.05n

.meas tran vdout1_0ck230 FIND v(dout1_0) AT=240.05n

.meas tran vdout1_1ck230 FIND v(dout1_1) AT=240.05n

.meas tran vdout1_2ck230 FIND v(dout1_2) AT=240.05n

.meas tran vdout1_3ck230 FIND v(dout1_3) AT=240.05n

.meas tran vdout1_4ck230 FIND v(dout1_4) AT=240.05n

.meas tran vdout1_5ck230 FIND v(dout1_5) AT=240.05n

.meas tran vdout1_6ck230 FIND v(dout1_6) AT=240.05n

.meas tran vdout1_7ck230 FIND v(dout1_7) AT=240.05n

.meas tran vdout1_8ck230 FIND v(dout1_8) AT=240.05n

.meas tran vdout1_9ck230 FIND v(dout1_9) AT=240.05n

.meas tran vdout1_10ck230 FIND v(dout1_10) AT=240.05n

.meas tran vdout1_11ck230 FIND v(dout1_11) AT=240.05n

.meas tran vdout1_12ck230 FIND v(dout1_12) AT=240.05n

.meas tran vdout1_13ck230 FIND v(dout1_13) AT=240.05n

.meas tran vdout1_14ck230 FIND v(dout1_14) AT=240.05n

.meas tran vdout1_15ck230 FIND v(dout1_15) AT=240.05n

.meas tran vdout1_16ck230 FIND v(dout1_16) AT=240.05n

.meas tran vdout1_17ck230 FIND v(dout1_17) AT=240.05n

.meas tran vdout1_18ck230 FIND v(dout1_18) AT=240.05n

.meas tran vdout1_19ck230 FIND v(dout1_19) AT=240.05n

.meas tran vdout1_20ck230 FIND v(dout1_20) AT=240.05n

.meas tran vdout1_21ck230 FIND v(dout1_21) AT=240.05n

.meas tran vdout1_22ck230 FIND v(dout1_22) AT=240.05n

.meas tran vdout1_23ck230 FIND v(dout1_23) AT=240.05n

.meas tran vdout1_24ck230 FIND v(dout1_24) AT=240.05n

.meas tran vdout1_25ck230 FIND v(dout1_25) AT=240.05n

.meas tran vdout1_26ck230 FIND v(dout1_26) AT=240.05n

.meas tran vdout1_27ck230 FIND v(dout1_27) AT=240.05n

.meas tran vdout1_28ck230 FIND v(dout1_28) AT=240.05n

.meas tran vdout1_29ck230 FIND v(dout1_29) AT=240.05n

.meas tran vdout1_30ck230 FIND v(dout1_30) AT=240.05n

.meas tran vdout1_31ck230 FIND v(dout1_31) AT=240.05n

.meas tran vdout1_32ck230 FIND v(dout1_32) AT=240.05n

.meas tran vdout1_33ck230 FIND v(dout1_33) AT=240.05n

.meas tran vdout1_34ck230 FIND v(dout1_34) AT=240.05n

.meas tran vdout1_35ck230 FIND v(dout1_35) AT=240.05n

.meas tran vdout1_36ck230 FIND v(dout1_36) AT=240.05n

.meas tran vdout1_37ck230 FIND v(dout1_37) AT=240.05n

.meas tran vdout1_38ck230 FIND v(dout1_38) AT=240.05n

.meas tran vdout1_39ck230 FIND v(dout1_39) AT=240.05n

.meas tran vdout1_40ck230 FIND v(dout1_40) AT=240.05n

.meas tran vdout1_41ck230 FIND v(dout1_41) AT=240.05n

.meas tran vdout1_42ck230 FIND v(dout1_42) AT=240.05n

.meas tran vdout1_43ck230 FIND v(dout1_43) AT=240.05n

.meas tran vdout1_44ck230 FIND v(dout1_44) AT=240.05n

.meas tran vdout1_45ck230 FIND v(dout1_45) AT=240.05n

.meas tran vdout1_46ck230 FIND v(dout1_46) AT=240.05n

.meas tran vdout1_47ck230 FIND v(dout1_47) AT=240.05n

.meas tran vdout1_48ck230 FIND v(dout1_48) AT=240.05n

.meas tran vdout1_49ck230 FIND v(dout1_49) AT=240.05n

.meas tran vdout1_50ck230 FIND v(dout1_50) AT=240.05n

.meas tran vdout1_51ck230 FIND v(dout1_51) AT=240.05n

.meas tran vdout1_52ck230 FIND v(dout1_52) AT=240.05n

.meas tran vdout1_53ck230 FIND v(dout1_53) AT=240.05n

.meas tran vdout1_54ck230 FIND v(dout1_54) AT=240.05n

.meas tran vdout1_55ck230 FIND v(dout1_55) AT=240.05n

.meas tran vdout1_56ck230 FIND v(dout1_56) AT=240.05n

.meas tran vdout1_57ck230 FIND v(dout1_57) AT=240.05n

.meas tran vdout1_58ck230 FIND v(dout1_58) AT=240.05n

.meas tran vdout1_59ck230 FIND v(dout1_59) AT=240.05n

.meas tran vdout1_60ck230 FIND v(dout1_60) AT=240.05n

.meas tran vdout1_61ck230 FIND v(dout1_61) AT=240.05n

.meas tran vdout1_62ck230 FIND v(dout1_62) AT=240.05n

.meas tran vdout1_63ck230 FIND v(dout1_63) AT=240.05n

.meas tran vdout1_64ck230 FIND v(dout1_64) AT=240.05n

.meas tran vdout1_65ck230 FIND v(dout1_65) AT=240.05n

.meas tran vdout1_66ck230 FIND v(dout1_66) AT=240.05n

.meas tran vdout1_67ck230 FIND v(dout1_67) AT=240.05n

.meas tran vdout1_68ck230 FIND v(dout1_68) AT=240.05n

.meas tran vdout1_69ck230 FIND v(dout1_69) AT=240.05n

.meas tran vdout1_70ck230 FIND v(dout1_70) AT=240.05n

.meas tran vdout1_71ck230 FIND v(dout1_71) AT=240.05n

.meas tran vdout1_72ck230 FIND v(dout1_72) AT=240.05n

.meas tran vdout1_73ck230 FIND v(dout1_73) AT=240.05n

.meas tran vdout1_74ck230 FIND v(dout1_74) AT=240.05n

.meas tran vdout1_75ck230 FIND v(dout1_75) AT=240.05n

.meas tran vdout1_76ck230 FIND v(dout1_76) AT=240.05n

.meas tran vdout1_77ck230 FIND v(dout1_77) AT=240.05n

.meas tran vdout1_78ck230 FIND v(dout1_78) AT=240.05n

.meas tran vdout1_79ck230 FIND v(dout1_79) AT=240.05n

.meas tran vdout1_80ck230 FIND v(dout1_80) AT=240.05n

.meas tran vdout1_81ck230 FIND v(dout1_81) AT=240.05n

.meas tran vdout1_82ck230 FIND v(dout1_82) AT=240.05n

.meas tran vdout1_83ck230 FIND v(dout1_83) AT=240.05n

.meas tran vdout1_84ck230 FIND v(dout1_84) AT=240.05n

.meas tran vdout1_85ck230 FIND v(dout1_85) AT=240.05n

.meas tran vdout1_86ck230 FIND v(dout1_86) AT=240.05n

.meas tran vdout1_87ck230 FIND v(dout1_87) AT=240.05n

.meas tran vdout1_88ck230 FIND v(dout1_88) AT=240.05n

.meas tran vdout1_89ck230 FIND v(dout1_89) AT=240.05n

.meas tran vdout1_90ck230 FIND v(dout1_90) AT=240.05n

.meas tran vdout1_91ck230 FIND v(dout1_91) AT=240.05n

.meas tran vdout1_92ck230 FIND v(dout1_92) AT=240.05n

.meas tran vdout1_93ck230 FIND v(dout1_93) AT=240.05n

.meas tran vdout1_94ck230 FIND v(dout1_94) AT=240.05n

.meas tran vdout1_95ck230 FIND v(dout1_95) AT=240.05n

.meas tran vdout1_96ck230 FIND v(dout1_96) AT=240.05n

.meas tran vdout1_97ck230 FIND v(dout1_97) AT=240.05n

.meas tran vdout1_98ck230 FIND v(dout1_98) AT=240.05n

.meas tran vdout1_99ck230 FIND v(dout1_99) AT=240.05n

.meas tran vdout1_100ck230 FIND v(dout1_100) AT=240.05n

.meas tran vdout1_101ck230 FIND v(dout1_101) AT=240.05n

.meas tran vdout1_102ck230 FIND v(dout1_102) AT=240.05n

.meas tran vdout1_103ck230 FIND v(dout1_103) AT=240.05n

.meas tran vdout1_104ck230 FIND v(dout1_104) AT=240.05n

.meas tran vdout1_105ck230 FIND v(dout1_105) AT=240.05n

.meas tran vdout1_106ck230 FIND v(dout1_106) AT=240.05n

.meas tran vdout1_107ck230 FIND v(dout1_107) AT=240.05n

.meas tran vdout1_108ck230 FIND v(dout1_108) AT=240.05n

.meas tran vdout1_109ck230 FIND v(dout1_109) AT=240.05n

.meas tran vdout1_110ck230 FIND v(dout1_110) AT=240.05n

.meas tran vdout1_111ck230 FIND v(dout1_111) AT=240.05n

.meas tran vdout1_112ck230 FIND v(dout1_112) AT=240.05n

.meas tran vdout1_113ck230 FIND v(dout1_113) AT=240.05n

.meas tran vdout1_114ck230 FIND v(dout1_114) AT=240.05n

.meas tran vdout1_115ck230 FIND v(dout1_115) AT=240.05n

.meas tran vdout1_116ck230 FIND v(dout1_116) AT=240.05n

.meas tran vdout1_117ck230 FIND v(dout1_117) AT=240.05n

.meas tran vdout1_118ck230 FIND v(dout1_118) AT=240.05n

.meas tran vdout1_119ck230 FIND v(dout1_119) AT=240.05n

.meas tran vdout1_120ck230 FIND v(dout1_120) AT=240.05n

.meas tran vdout1_121ck230 FIND v(dout1_121) AT=240.05n

.meas tran vdout1_122ck230 FIND v(dout1_122) AT=240.05n

.meas tran vdout1_123ck230 FIND v(dout1_123) AT=240.05n

.meas tran vdout1_124ck230 FIND v(dout1_124) AT=240.05n

.meas tran vdout1_125ck230 FIND v(dout1_125) AT=240.05n

.meas tran vdout1_126ck230 FIND v(dout1_126) AT=240.05n

.meas tran vdout1_127ck230 FIND v(dout1_127) AT=240.05n

.meas tran vdout1_128ck230 FIND v(dout1_128) AT=240.05n

.meas tran vdout1_129ck230 FIND v(dout1_129) AT=240.05n

.meas tran vdout1_130ck230 FIND v(dout1_130) AT=240.05n

.meas tran vdout1_131ck230 FIND v(dout1_131) AT=240.05n

.meas tran vdout1_132ck230 FIND v(dout1_132) AT=240.05n

.meas tran vdout1_133ck230 FIND v(dout1_133) AT=240.05n

.meas tran vdout1_134ck230 FIND v(dout1_134) AT=240.05n

.meas tran vdout1_0ck330 FIND v(dout1_0) AT=340.05n

.meas tran vdout1_1ck330 FIND v(dout1_1) AT=340.05n

.meas tran vdout1_2ck330 FIND v(dout1_2) AT=340.05n

.meas tran vdout1_3ck330 FIND v(dout1_3) AT=340.05n

.meas tran vdout1_4ck330 FIND v(dout1_4) AT=340.05n

.meas tran vdout1_5ck330 FIND v(dout1_5) AT=340.05n

.meas tran vdout1_6ck330 FIND v(dout1_6) AT=340.05n

.meas tran vdout1_7ck330 FIND v(dout1_7) AT=340.05n

.meas tran vdout1_8ck330 FIND v(dout1_8) AT=340.05n

.meas tran vdout1_9ck330 FIND v(dout1_9) AT=340.05n

.meas tran vdout1_10ck330 FIND v(dout1_10) AT=340.05n

.meas tran vdout1_11ck330 FIND v(dout1_11) AT=340.05n

.meas tran vdout1_12ck330 FIND v(dout1_12) AT=340.05n

.meas tran vdout1_13ck330 FIND v(dout1_13) AT=340.05n

.meas tran vdout1_14ck330 FIND v(dout1_14) AT=340.05n

.meas tran vdout1_15ck330 FIND v(dout1_15) AT=340.05n

.meas tran vdout1_16ck330 FIND v(dout1_16) AT=340.05n

.meas tran vdout1_17ck330 FIND v(dout1_17) AT=340.05n

.meas tran vdout1_18ck330 FIND v(dout1_18) AT=340.05n

.meas tran vdout1_19ck330 FIND v(dout1_19) AT=340.05n

.meas tran vdout1_20ck330 FIND v(dout1_20) AT=340.05n

.meas tran vdout1_21ck330 FIND v(dout1_21) AT=340.05n

.meas tran vdout1_22ck330 FIND v(dout1_22) AT=340.05n

.meas tran vdout1_23ck330 FIND v(dout1_23) AT=340.05n

.meas tran vdout1_24ck330 FIND v(dout1_24) AT=340.05n

.meas tran vdout1_25ck330 FIND v(dout1_25) AT=340.05n

.meas tran vdout1_26ck330 FIND v(dout1_26) AT=340.05n

.meas tran vdout1_27ck330 FIND v(dout1_27) AT=340.05n

.meas tran vdout1_28ck330 FIND v(dout1_28) AT=340.05n

.meas tran vdout1_29ck330 FIND v(dout1_29) AT=340.05n

.meas tran vdout1_30ck330 FIND v(dout1_30) AT=340.05n

.meas tran vdout1_31ck330 FIND v(dout1_31) AT=340.05n

.meas tran vdout1_32ck330 FIND v(dout1_32) AT=340.05n

.meas tran vdout1_33ck330 FIND v(dout1_33) AT=340.05n

.meas tran vdout1_34ck330 FIND v(dout1_34) AT=340.05n

.meas tran vdout1_35ck330 FIND v(dout1_35) AT=340.05n

.meas tran vdout1_36ck330 FIND v(dout1_36) AT=340.05n

.meas tran vdout1_37ck330 FIND v(dout1_37) AT=340.05n

.meas tran vdout1_38ck330 FIND v(dout1_38) AT=340.05n

.meas tran vdout1_39ck330 FIND v(dout1_39) AT=340.05n

.meas tran vdout1_40ck330 FIND v(dout1_40) AT=340.05n

.meas tran vdout1_41ck330 FIND v(dout1_41) AT=340.05n

.meas tran vdout1_42ck330 FIND v(dout1_42) AT=340.05n

.meas tran vdout1_43ck330 FIND v(dout1_43) AT=340.05n

.meas tran vdout1_44ck330 FIND v(dout1_44) AT=340.05n

.meas tran vdout1_45ck330 FIND v(dout1_45) AT=340.05n

.meas tran vdout1_46ck330 FIND v(dout1_46) AT=340.05n

.meas tran vdout1_47ck330 FIND v(dout1_47) AT=340.05n

.meas tran vdout1_48ck330 FIND v(dout1_48) AT=340.05n

.meas tran vdout1_49ck330 FIND v(dout1_49) AT=340.05n

.meas tran vdout1_50ck330 FIND v(dout1_50) AT=340.05n

.meas tran vdout1_51ck330 FIND v(dout1_51) AT=340.05n

.meas tran vdout1_52ck330 FIND v(dout1_52) AT=340.05n

.meas tran vdout1_53ck330 FIND v(dout1_53) AT=340.05n

.meas tran vdout1_54ck330 FIND v(dout1_54) AT=340.05n

.meas tran vdout1_55ck330 FIND v(dout1_55) AT=340.05n

.meas tran vdout1_56ck330 FIND v(dout1_56) AT=340.05n

.meas tran vdout1_57ck330 FIND v(dout1_57) AT=340.05n

.meas tran vdout1_58ck330 FIND v(dout1_58) AT=340.05n

.meas tran vdout1_59ck330 FIND v(dout1_59) AT=340.05n

.meas tran vdout1_60ck330 FIND v(dout1_60) AT=340.05n

.meas tran vdout1_61ck330 FIND v(dout1_61) AT=340.05n

.meas tran vdout1_62ck330 FIND v(dout1_62) AT=340.05n

.meas tran vdout1_63ck330 FIND v(dout1_63) AT=340.05n

.meas tran vdout1_64ck330 FIND v(dout1_64) AT=340.05n

.meas tran vdout1_65ck330 FIND v(dout1_65) AT=340.05n

.meas tran vdout1_66ck330 FIND v(dout1_66) AT=340.05n

.meas tran vdout1_67ck330 FIND v(dout1_67) AT=340.05n

.meas tran vdout1_68ck330 FIND v(dout1_68) AT=340.05n

.meas tran vdout1_69ck330 FIND v(dout1_69) AT=340.05n

.meas tran vdout1_70ck330 FIND v(dout1_70) AT=340.05n

.meas tran vdout1_71ck330 FIND v(dout1_71) AT=340.05n

.meas tran vdout1_72ck330 FIND v(dout1_72) AT=340.05n

.meas tran vdout1_73ck330 FIND v(dout1_73) AT=340.05n

.meas tran vdout1_74ck330 FIND v(dout1_74) AT=340.05n

.meas tran vdout1_75ck330 FIND v(dout1_75) AT=340.05n

.meas tran vdout1_76ck330 FIND v(dout1_76) AT=340.05n

.meas tran vdout1_77ck330 FIND v(dout1_77) AT=340.05n

.meas tran vdout1_78ck330 FIND v(dout1_78) AT=340.05n

.meas tran vdout1_79ck330 FIND v(dout1_79) AT=340.05n

.meas tran vdout1_80ck330 FIND v(dout1_80) AT=340.05n

.meas tran vdout1_81ck330 FIND v(dout1_81) AT=340.05n

.meas tran vdout1_82ck330 FIND v(dout1_82) AT=340.05n

.meas tran vdout1_83ck330 FIND v(dout1_83) AT=340.05n

.meas tran vdout1_84ck330 FIND v(dout1_84) AT=340.05n

.meas tran vdout1_85ck330 FIND v(dout1_85) AT=340.05n

.meas tran vdout1_86ck330 FIND v(dout1_86) AT=340.05n

.meas tran vdout1_87ck330 FIND v(dout1_87) AT=340.05n

.meas tran vdout1_88ck330 FIND v(dout1_88) AT=340.05n

.meas tran vdout1_89ck330 FIND v(dout1_89) AT=340.05n

.meas tran vdout1_90ck330 FIND v(dout1_90) AT=340.05n

.meas tran vdout1_91ck330 FIND v(dout1_91) AT=340.05n

.meas tran vdout1_92ck330 FIND v(dout1_92) AT=340.05n

.meas tran vdout1_93ck330 FIND v(dout1_93) AT=340.05n

.meas tran vdout1_94ck330 FIND v(dout1_94) AT=340.05n

.meas tran vdout1_95ck330 FIND v(dout1_95) AT=340.05n

.meas tran vdout1_96ck330 FIND v(dout1_96) AT=340.05n

.meas tran vdout1_97ck330 FIND v(dout1_97) AT=340.05n

.meas tran vdout1_98ck330 FIND v(dout1_98) AT=340.05n

.meas tran vdout1_99ck330 FIND v(dout1_99) AT=340.05n

.meas tran vdout1_100ck330 FIND v(dout1_100) AT=340.05n

.meas tran vdout1_101ck330 FIND v(dout1_101) AT=340.05n

.meas tran vdout1_102ck330 FIND v(dout1_102) AT=340.05n

.meas tran vdout1_103ck330 FIND v(dout1_103) AT=340.05n

.meas tran vdout1_104ck330 FIND v(dout1_104) AT=340.05n

.meas tran vdout1_105ck330 FIND v(dout1_105) AT=340.05n

.meas tran vdout1_106ck330 FIND v(dout1_106) AT=340.05n

.meas tran vdout1_107ck330 FIND v(dout1_107) AT=340.05n

.meas tran vdout1_108ck330 FIND v(dout1_108) AT=340.05n

.meas tran vdout1_109ck330 FIND v(dout1_109) AT=340.05n

.meas tran vdout1_110ck330 FIND v(dout1_110) AT=340.05n

.meas tran vdout1_111ck330 FIND v(dout1_111) AT=340.05n

.meas tran vdout1_112ck330 FIND v(dout1_112) AT=340.05n

.meas tran vdout1_113ck330 FIND v(dout1_113) AT=340.05n

.meas tran vdout1_114ck330 FIND v(dout1_114) AT=340.05n

.meas tran vdout1_115ck330 FIND v(dout1_115) AT=340.05n

.meas tran vdout1_116ck330 FIND v(dout1_116) AT=340.05n

.meas tran vdout1_117ck330 FIND v(dout1_117) AT=340.05n

.meas tran vdout1_118ck330 FIND v(dout1_118) AT=340.05n

.meas tran vdout1_119ck330 FIND v(dout1_119) AT=340.05n

.meas tran vdout1_120ck330 FIND v(dout1_120) AT=340.05n

.meas tran vdout1_121ck330 FIND v(dout1_121) AT=340.05n

.meas tran vdout1_122ck330 FIND v(dout1_122) AT=340.05n

.meas tran vdout1_123ck330 FIND v(dout1_123) AT=340.05n

.meas tran vdout1_124ck330 FIND v(dout1_124) AT=340.05n

.meas tran vdout1_125ck330 FIND v(dout1_125) AT=340.05n

.meas tran vdout1_126ck330 FIND v(dout1_126) AT=340.05n

.meas tran vdout1_127ck330 FIND v(dout1_127) AT=340.05n

.meas tran vdout1_128ck330 FIND v(dout1_128) AT=340.05n

.meas tran vdout1_129ck330 FIND v(dout1_129) AT=340.05n

.meas tran vdout1_130ck330 FIND v(dout1_130) AT=340.05n

.meas tran vdout1_131ck330 FIND v(dout1_131) AT=340.05n

.meas tran vdout1_132ck330 FIND v(dout1_132) AT=340.05n

.meas tran vdout1_133ck330 FIND v(dout1_133) AT=340.05n

.meas tran vdout1_134ck330 FIND v(dout1_134) AT=340.05n

.meas tran vdout1_0ck340 FIND v(dout1_0) AT=350.05n

.meas tran vdout1_1ck340 FIND v(dout1_1) AT=350.05n

.meas tran vdout1_2ck340 FIND v(dout1_2) AT=350.05n

.meas tran vdout1_3ck340 FIND v(dout1_3) AT=350.05n

.meas tran vdout1_4ck340 FIND v(dout1_4) AT=350.05n

.meas tran vdout1_5ck340 FIND v(dout1_5) AT=350.05n

.meas tran vdout1_6ck340 FIND v(dout1_6) AT=350.05n

.meas tran vdout1_7ck340 FIND v(dout1_7) AT=350.05n

.meas tran vdout1_8ck340 FIND v(dout1_8) AT=350.05n

.meas tran vdout1_9ck340 FIND v(dout1_9) AT=350.05n

.meas tran vdout1_10ck340 FIND v(dout1_10) AT=350.05n

.meas tran vdout1_11ck340 FIND v(dout1_11) AT=350.05n

.meas tran vdout1_12ck340 FIND v(dout1_12) AT=350.05n

.meas tran vdout1_13ck340 FIND v(dout1_13) AT=350.05n

.meas tran vdout1_14ck340 FIND v(dout1_14) AT=350.05n

.meas tran vdout1_15ck340 FIND v(dout1_15) AT=350.05n

.meas tran vdout1_16ck340 FIND v(dout1_16) AT=350.05n

.meas tran vdout1_17ck340 FIND v(dout1_17) AT=350.05n

.meas tran vdout1_18ck340 FIND v(dout1_18) AT=350.05n

.meas tran vdout1_19ck340 FIND v(dout1_19) AT=350.05n

.meas tran vdout1_20ck340 FIND v(dout1_20) AT=350.05n

.meas tran vdout1_21ck340 FIND v(dout1_21) AT=350.05n

.meas tran vdout1_22ck340 FIND v(dout1_22) AT=350.05n

.meas tran vdout1_23ck340 FIND v(dout1_23) AT=350.05n

.meas tran vdout1_24ck340 FIND v(dout1_24) AT=350.05n

.meas tran vdout1_25ck340 FIND v(dout1_25) AT=350.05n

.meas tran vdout1_26ck340 FIND v(dout1_26) AT=350.05n

.meas tran vdout1_27ck340 FIND v(dout1_27) AT=350.05n

.meas tran vdout1_28ck340 FIND v(dout1_28) AT=350.05n

.meas tran vdout1_29ck340 FIND v(dout1_29) AT=350.05n

.meas tran vdout1_30ck340 FIND v(dout1_30) AT=350.05n

.meas tran vdout1_31ck340 FIND v(dout1_31) AT=350.05n

.meas tran vdout1_32ck340 FIND v(dout1_32) AT=350.05n

.meas tran vdout1_33ck340 FIND v(dout1_33) AT=350.05n

.meas tran vdout1_34ck340 FIND v(dout1_34) AT=350.05n

.meas tran vdout1_35ck340 FIND v(dout1_35) AT=350.05n

.meas tran vdout1_36ck340 FIND v(dout1_36) AT=350.05n

.meas tran vdout1_37ck340 FIND v(dout1_37) AT=350.05n

.meas tran vdout1_38ck340 FIND v(dout1_38) AT=350.05n

.meas tran vdout1_39ck340 FIND v(dout1_39) AT=350.05n

.meas tran vdout1_40ck340 FIND v(dout1_40) AT=350.05n

.meas tran vdout1_41ck340 FIND v(dout1_41) AT=350.05n

.meas tran vdout1_42ck340 FIND v(dout1_42) AT=350.05n

.meas tran vdout1_43ck340 FIND v(dout1_43) AT=350.05n

.meas tran vdout1_44ck340 FIND v(dout1_44) AT=350.05n

.meas tran vdout1_45ck340 FIND v(dout1_45) AT=350.05n

.meas tran vdout1_46ck340 FIND v(dout1_46) AT=350.05n

.meas tran vdout1_47ck340 FIND v(dout1_47) AT=350.05n

.meas tran vdout1_48ck340 FIND v(dout1_48) AT=350.05n

.meas tran vdout1_49ck340 FIND v(dout1_49) AT=350.05n

.meas tran vdout1_50ck340 FIND v(dout1_50) AT=350.05n

.meas tran vdout1_51ck340 FIND v(dout1_51) AT=350.05n

.meas tran vdout1_52ck340 FIND v(dout1_52) AT=350.05n

.meas tran vdout1_53ck340 FIND v(dout1_53) AT=350.05n

.meas tran vdout1_54ck340 FIND v(dout1_54) AT=350.05n

.meas tran vdout1_55ck340 FIND v(dout1_55) AT=350.05n

.meas tran vdout1_56ck340 FIND v(dout1_56) AT=350.05n

.meas tran vdout1_57ck340 FIND v(dout1_57) AT=350.05n

.meas tran vdout1_58ck340 FIND v(dout1_58) AT=350.05n

.meas tran vdout1_59ck340 FIND v(dout1_59) AT=350.05n

.meas tran vdout1_60ck340 FIND v(dout1_60) AT=350.05n

.meas tran vdout1_61ck340 FIND v(dout1_61) AT=350.05n

.meas tran vdout1_62ck340 FIND v(dout1_62) AT=350.05n

.meas tran vdout1_63ck340 FIND v(dout1_63) AT=350.05n

.meas tran vdout1_64ck340 FIND v(dout1_64) AT=350.05n

.meas tran vdout1_65ck340 FIND v(dout1_65) AT=350.05n

.meas tran vdout1_66ck340 FIND v(dout1_66) AT=350.05n

.meas tran vdout1_67ck340 FIND v(dout1_67) AT=350.05n

.meas tran vdout1_68ck340 FIND v(dout1_68) AT=350.05n

.meas tran vdout1_69ck340 FIND v(dout1_69) AT=350.05n

.meas tran vdout1_70ck340 FIND v(dout1_70) AT=350.05n

.meas tran vdout1_71ck340 FIND v(dout1_71) AT=350.05n

.meas tran vdout1_72ck340 FIND v(dout1_72) AT=350.05n

.meas tran vdout1_73ck340 FIND v(dout1_73) AT=350.05n

.meas tran vdout1_74ck340 FIND v(dout1_74) AT=350.05n

.meas tran vdout1_75ck340 FIND v(dout1_75) AT=350.05n

.meas tran vdout1_76ck340 FIND v(dout1_76) AT=350.05n

.meas tran vdout1_77ck340 FIND v(dout1_77) AT=350.05n

.meas tran vdout1_78ck340 FIND v(dout1_78) AT=350.05n

.meas tran vdout1_79ck340 FIND v(dout1_79) AT=350.05n

.meas tran vdout1_80ck340 FIND v(dout1_80) AT=350.05n

.meas tran vdout1_81ck340 FIND v(dout1_81) AT=350.05n

.meas tran vdout1_82ck340 FIND v(dout1_82) AT=350.05n

.meas tran vdout1_83ck340 FIND v(dout1_83) AT=350.05n

.meas tran vdout1_84ck340 FIND v(dout1_84) AT=350.05n

.meas tran vdout1_85ck340 FIND v(dout1_85) AT=350.05n

.meas tran vdout1_86ck340 FIND v(dout1_86) AT=350.05n

.meas tran vdout1_87ck340 FIND v(dout1_87) AT=350.05n

.meas tran vdout1_88ck340 FIND v(dout1_88) AT=350.05n

.meas tran vdout1_89ck340 FIND v(dout1_89) AT=350.05n

.meas tran vdout1_90ck340 FIND v(dout1_90) AT=350.05n

.meas tran vdout1_91ck340 FIND v(dout1_91) AT=350.05n

.meas tran vdout1_92ck340 FIND v(dout1_92) AT=350.05n

.meas tran vdout1_93ck340 FIND v(dout1_93) AT=350.05n

.meas tran vdout1_94ck340 FIND v(dout1_94) AT=350.05n

.meas tran vdout1_95ck340 FIND v(dout1_95) AT=350.05n

.meas tran vdout1_96ck340 FIND v(dout1_96) AT=350.05n

.meas tran vdout1_97ck340 FIND v(dout1_97) AT=350.05n

.meas tran vdout1_98ck340 FIND v(dout1_98) AT=350.05n

.meas tran vdout1_99ck340 FIND v(dout1_99) AT=350.05n

.meas tran vdout1_100ck340 FIND v(dout1_100) AT=350.05n

.meas tran vdout1_101ck340 FIND v(dout1_101) AT=350.05n

.meas tran vdout1_102ck340 FIND v(dout1_102) AT=350.05n

.meas tran vdout1_103ck340 FIND v(dout1_103) AT=350.05n

.meas tran vdout1_104ck340 FIND v(dout1_104) AT=350.05n

.meas tran vdout1_105ck340 FIND v(dout1_105) AT=350.05n

.meas tran vdout1_106ck340 FIND v(dout1_106) AT=350.05n

.meas tran vdout1_107ck340 FIND v(dout1_107) AT=350.05n

.meas tran vdout1_108ck340 FIND v(dout1_108) AT=350.05n

.meas tran vdout1_109ck340 FIND v(dout1_109) AT=350.05n

.meas tran vdout1_110ck340 FIND v(dout1_110) AT=350.05n

.meas tran vdout1_111ck340 FIND v(dout1_111) AT=350.05n

.meas tran vdout1_112ck340 FIND v(dout1_112) AT=350.05n

.meas tran vdout1_113ck340 FIND v(dout1_113) AT=350.05n

.meas tran vdout1_114ck340 FIND v(dout1_114) AT=350.05n

.meas tran vdout1_115ck340 FIND v(dout1_115) AT=350.05n

.meas tran vdout1_116ck340 FIND v(dout1_116) AT=350.05n

.meas tran vdout1_117ck340 FIND v(dout1_117) AT=350.05n

.meas tran vdout1_118ck340 FIND v(dout1_118) AT=350.05n

.meas tran vdout1_119ck340 FIND v(dout1_119) AT=350.05n

.meas tran vdout1_120ck340 FIND v(dout1_120) AT=350.05n

.meas tran vdout1_121ck340 FIND v(dout1_121) AT=350.05n

.meas tran vdout1_122ck340 FIND v(dout1_122) AT=350.05n

.meas tran vdout1_123ck340 FIND v(dout1_123) AT=350.05n

.meas tran vdout1_124ck340 FIND v(dout1_124) AT=350.05n

.meas tran vdout1_125ck340 FIND v(dout1_125) AT=350.05n

.meas tran vdout1_126ck340 FIND v(dout1_126) AT=350.05n

.meas tran vdout1_127ck340 FIND v(dout1_127) AT=350.05n

.meas tran vdout1_128ck340 FIND v(dout1_128) AT=350.05n

.meas tran vdout1_129ck340 FIND v(dout1_129) AT=350.05n

.meas tran vdout1_130ck340 FIND v(dout1_130) AT=350.05n

.meas tran vdout1_131ck340 FIND v(dout1_131) AT=350.05n

.meas tran vdout1_132ck340 FIND v(dout1_132) AT=350.05n

.meas tran vdout1_133ck340 FIND v(dout1_133) AT=350.05n

.meas tran vdout1_134ck340 FIND v(dout1_134) AT=350.05n

.meas tran vdout1_0ck350 FIND v(dout1_0) AT=360.05n

.meas tran vdout1_1ck350 FIND v(dout1_1) AT=360.05n

.meas tran vdout1_2ck350 FIND v(dout1_2) AT=360.05n

.meas tran vdout1_3ck350 FIND v(dout1_3) AT=360.05n

.meas tran vdout1_4ck350 FIND v(dout1_4) AT=360.05n

.meas tran vdout1_5ck350 FIND v(dout1_5) AT=360.05n

.meas tran vdout1_6ck350 FIND v(dout1_6) AT=360.05n

.meas tran vdout1_7ck350 FIND v(dout1_7) AT=360.05n

.meas tran vdout1_8ck350 FIND v(dout1_8) AT=360.05n

.meas tran vdout1_9ck350 FIND v(dout1_9) AT=360.05n

.meas tran vdout1_10ck350 FIND v(dout1_10) AT=360.05n

.meas tran vdout1_11ck350 FIND v(dout1_11) AT=360.05n

.meas tran vdout1_12ck350 FIND v(dout1_12) AT=360.05n

.meas tran vdout1_13ck350 FIND v(dout1_13) AT=360.05n

.meas tran vdout1_14ck350 FIND v(dout1_14) AT=360.05n

.meas tran vdout1_15ck350 FIND v(dout1_15) AT=360.05n

.meas tran vdout1_16ck350 FIND v(dout1_16) AT=360.05n

.meas tran vdout1_17ck350 FIND v(dout1_17) AT=360.05n

.meas tran vdout1_18ck350 FIND v(dout1_18) AT=360.05n

.meas tran vdout1_19ck350 FIND v(dout1_19) AT=360.05n

.meas tran vdout1_20ck350 FIND v(dout1_20) AT=360.05n

.meas tran vdout1_21ck350 FIND v(dout1_21) AT=360.05n

.meas tran vdout1_22ck350 FIND v(dout1_22) AT=360.05n

.meas tran vdout1_23ck350 FIND v(dout1_23) AT=360.05n

.meas tran vdout1_24ck350 FIND v(dout1_24) AT=360.05n

.meas tran vdout1_25ck350 FIND v(dout1_25) AT=360.05n

.meas tran vdout1_26ck350 FIND v(dout1_26) AT=360.05n

.meas tran vdout1_27ck350 FIND v(dout1_27) AT=360.05n

.meas tran vdout1_28ck350 FIND v(dout1_28) AT=360.05n

.meas tran vdout1_29ck350 FIND v(dout1_29) AT=360.05n

.meas tran vdout1_30ck350 FIND v(dout1_30) AT=360.05n

.meas tran vdout1_31ck350 FIND v(dout1_31) AT=360.05n

.meas tran vdout1_32ck350 FIND v(dout1_32) AT=360.05n

.meas tran vdout1_33ck350 FIND v(dout1_33) AT=360.05n

.meas tran vdout1_34ck350 FIND v(dout1_34) AT=360.05n

.meas tran vdout1_35ck350 FIND v(dout1_35) AT=360.05n

.meas tran vdout1_36ck350 FIND v(dout1_36) AT=360.05n

.meas tran vdout1_37ck350 FIND v(dout1_37) AT=360.05n

.meas tran vdout1_38ck350 FIND v(dout1_38) AT=360.05n

.meas tran vdout1_39ck350 FIND v(dout1_39) AT=360.05n

.meas tran vdout1_40ck350 FIND v(dout1_40) AT=360.05n

.meas tran vdout1_41ck350 FIND v(dout1_41) AT=360.05n

.meas tran vdout1_42ck350 FIND v(dout1_42) AT=360.05n

.meas tran vdout1_43ck350 FIND v(dout1_43) AT=360.05n

.meas tran vdout1_44ck350 FIND v(dout1_44) AT=360.05n

.meas tran vdout1_45ck350 FIND v(dout1_45) AT=360.05n

.meas tran vdout1_46ck350 FIND v(dout1_46) AT=360.05n

.meas tran vdout1_47ck350 FIND v(dout1_47) AT=360.05n

.meas tran vdout1_48ck350 FIND v(dout1_48) AT=360.05n

.meas tran vdout1_49ck350 FIND v(dout1_49) AT=360.05n

.meas tran vdout1_50ck350 FIND v(dout1_50) AT=360.05n

.meas tran vdout1_51ck350 FIND v(dout1_51) AT=360.05n

.meas tran vdout1_52ck350 FIND v(dout1_52) AT=360.05n

.meas tran vdout1_53ck350 FIND v(dout1_53) AT=360.05n

.meas tran vdout1_54ck350 FIND v(dout1_54) AT=360.05n

.meas tran vdout1_55ck350 FIND v(dout1_55) AT=360.05n

.meas tran vdout1_56ck350 FIND v(dout1_56) AT=360.05n

.meas tran vdout1_57ck350 FIND v(dout1_57) AT=360.05n

.meas tran vdout1_58ck350 FIND v(dout1_58) AT=360.05n

.meas tran vdout1_59ck350 FIND v(dout1_59) AT=360.05n

.meas tran vdout1_60ck350 FIND v(dout1_60) AT=360.05n

.meas tran vdout1_61ck350 FIND v(dout1_61) AT=360.05n

.meas tran vdout1_62ck350 FIND v(dout1_62) AT=360.05n

.meas tran vdout1_63ck350 FIND v(dout1_63) AT=360.05n

.meas tran vdout1_64ck350 FIND v(dout1_64) AT=360.05n

.meas tran vdout1_65ck350 FIND v(dout1_65) AT=360.05n

.meas tran vdout1_66ck350 FIND v(dout1_66) AT=360.05n

.meas tran vdout1_67ck350 FIND v(dout1_67) AT=360.05n

.meas tran vdout1_68ck350 FIND v(dout1_68) AT=360.05n

.meas tran vdout1_69ck350 FIND v(dout1_69) AT=360.05n

.meas tran vdout1_70ck350 FIND v(dout1_70) AT=360.05n

.meas tran vdout1_71ck350 FIND v(dout1_71) AT=360.05n

.meas tran vdout1_72ck350 FIND v(dout1_72) AT=360.05n

.meas tran vdout1_73ck350 FIND v(dout1_73) AT=360.05n

.meas tran vdout1_74ck350 FIND v(dout1_74) AT=360.05n

.meas tran vdout1_75ck350 FIND v(dout1_75) AT=360.05n

.meas tran vdout1_76ck350 FIND v(dout1_76) AT=360.05n

.meas tran vdout1_77ck350 FIND v(dout1_77) AT=360.05n

.meas tran vdout1_78ck350 FIND v(dout1_78) AT=360.05n

.meas tran vdout1_79ck350 FIND v(dout1_79) AT=360.05n

.meas tran vdout1_80ck350 FIND v(dout1_80) AT=360.05n

.meas tran vdout1_81ck350 FIND v(dout1_81) AT=360.05n

.meas tran vdout1_82ck350 FIND v(dout1_82) AT=360.05n

.meas tran vdout1_83ck350 FIND v(dout1_83) AT=360.05n

.meas tran vdout1_84ck350 FIND v(dout1_84) AT=360.05n

.meas tran vdout1_85ck350 FIND v(dout1_85) AT=360.05n

.meas tran vdout1_86ck350 FIND v(dout1_86) AT=360.05n

.meas tran vdout1_87ck350 FIND v(dout1_87) AT=360.05n

.meas tran vdout1_88ck350 FIND v(dout1_88) AT=360.05n

.meas tran vdout1_89ck350 FIND v(dout1_89) AT=360.05n

.meas tran vdout1_90ck350 FIND v(dout1_90) AT=360.05n

.meas tran vdout1_91ck350 FIND v(dout1_91) AT=360.05n

.meas tran vdout1_92ck350 FIND v(dout1_92) AT=360.05n

.meas tran vdout1_93ck350 FIND v(dout1_93) AT=360.05n

.meas tran vdout1_94ck350 FIND v(dout1_94) AT=360.05n

.meas tran vdout1_95ck350 FIND v(dout1_95) AT=360.05n

.meas tran vdout1_96ck350 FIND v(dout1_96) AT=360.05n

.meas tran vdout1_97ck350 FIND v(dout1_97) AT=360.05n

.meas tran vdout1_98ck350 FIND v(dout1_98) AT=360.05n

.meas tran vdout1_99ck350 FIND v(dout1_99) AT=360.05n

.meas tran vdout1_100ck350 FIND v(dout1_100) AT=360.05n

.meas tran vdout1_101ck350 FIND v(dout1_101) AT=360.05n

.meas tran vdout1_102ck350 FIND v(dout1_102) AT=360.05n

.meas tran vdout1_103ck350 FIND v(dout1_103) AT=360.05n

.meas tran vdout1_104ck350 FIND v(dout1_104) AT=360.05n

.meas tran vdout1_105ck350 FIND v(dout1_105) AT=360.05n

.meas tran vdout1_106ck350 FIND v(dout1_106) AT=360.05n

.meas tran vdout1_107ck350 FIND v(dout1_107) AT=360.05n

.meas tran vdout1_108ck350 FIND v(dout1_108) AT=360.05n

.meas tran vdout1_109ck350 FIND v(dout1_109) AT=360.05n

.meas tran vdout1_110ck350 FIND v(dout1_110) AT=360.05n

.meas tran vdout1_111ck350 FIND v(dout1_111) AT=360.05n

.meas tran vdout1_112ck350 FIND v(dout1_112) AT=360.05n

.meas tran vdout1_113ck350 FIND v(dout1_113) AT=360.05n

.meas tran vdout1_114ck350 FIND v(dout1_114) AT=360.05n

.meas tran vdout1_115ck350 FIND v(dout1_115) AT=360.05n

.meas tran vdout1_116ck350 FIND v(dout1_116) AT=360.05n

.meas tran vdout1_117ck350 FIND v(dout1_117) AT=360.05n

.meas tran vdout1_118ck350 FIND v(dout1_118) AT=360.05n

.meas tran vdout1_119ck350 FIND v(dout1_119) AT=360.05n

.meas tran vdout1_120ck350 FIND v(dout1_120) AT=360.05n

.meas tran vdout1_121ck350 FIND v(dout1_121) AT=360.05n

.meas tran vdout1_122ck350 FIND v(dout1_122) AT=360.05n

.meas tran vdout1_123ck350 FIND v(dout1_123) AT=360.05n

.meas tran vdout1_124ck350 FIND v(dout1_124) AT=360.05n

.meas tran vdout1_125ck350 FIND v(dout1_125) AT=360.05n

.meas tran vdout1_126ck350 FIND v(dout1_126) AT=360.05n

.meas tran vdout1_127ck350 FIND v(dout1_127) AT=360.05n

.meas tran vdout1_128ck350 FIND v(dout1_128) AT=360.05n

.meas tran vdout1_129ck350 FIND v(dout1_129) AT=360.05n

.meas tran vdout1_130ck350 FIND v(dout1_130) AT=360.05n

.meas tran vdout1_131ck350 FIND v(dout1_131) AT=360.05n

.meas tran vdout1_132ck350 FIND v(dout1_132) AT=360.05n

.meas tran vdout1_133ck350 FIND v(dout1_133) AT=360.05n

.meas tran vdout1_134ck350 FIND v(dout1_134) AT=360.05n

.meas tran vdout1_0ck360 FIND v(dout1_0) AT=370.05n

.meas tran vdout1_1ck360 FIND v(dout1_1) AT=370.05n

.meas tran vdout1_2ck360 FIND v(dout1_2) AT=370.05n

.meas tran vdout1_3ck360 FIND v(dout1_3) AT=370.05n

.meas tran vdout1_4ck360 FIND v(dout1_4) AT=370.05n

.meas tran vdout1_5ck360 FIND v(dout1_5) AT=370.05n

.meas tran vdout1_6ck360 FIND v(dout1_6) AT=370.05n

.meas tran vdout1_7ck360 FIND v(dout1_7) AT=370.05n

.meas tran vdout1_8ck360 FIND v(dout1_8) AT=370.05n

.meas tran vdout1_9ck360 FIND v(dout1_9) AT=370.05n

.meas tran vdout1_10ck360 FIND v(dout1_10) AT=370.05n

.meas tran vdout1_11ck360 FIND v(dout1_11) AT=370.05n

.meas tran vdout1_12ck360 FIND v(dout1_12) AT=370.05n

.meas tran vdout1_13ck360 FIND v(dout1_13) AT=370.05n

.meas tran vdout1_14ck360 FIND v(dout1_14) AT=370.05n

.meas tran vdout1_15ck360 FIND v(dout1_15) AT=370.05n

.meas tran vdout1_16ck360 FIND v(dout1_16) AT=370.05n

.meas tran vdout1_17ck360 FIND v(dout1_17) AT=370.05n

.meas tran vdout1_18ck360 FIND v(dout1_18) AT=370.05n

.meas tran vdout1_19ck360 FIND v(dout1_19) AT=370.05n

.meas tran vdout1_20ck360 FIND v(dout1_20) AT=370.05n

.meas tran vdout1_21ck360 FIND v(dout1_21) AT=370.05n

.meas tran vdout1_22ck360 FIND v(dout1_22) AT=370.05n

.meas tran vdout1_23ck360 FIND v(dout1_23) AT=370.05n

.meas tran vdout1_24ck360 FIND v(dout1_24) AT=370.05n

.meas tran vdout1_25ck360 FIND v(dout1_25) AT=370.05n

.meas tran vdout1_26ck360 FIND v(dout1_26) AT=370.05n

.meas tran vdout1_27ck360 FIND v(dout1_27) AT=370.05n

.meas tran vdout1_28ck360 FIND v(dout1_28) AT=370.05n

.meas tran vdout1_29ck360 FIND v(dout1_29) AT=370.05n

.meas tran vdout1_30ck360 FIND v(dout1_30) AT=370.05n

.meas tran vdout1_31ck360 FIND v(dout1_31) AT=370.05n

.meas tran vdout1_32ck360 FIND v(dout1_32) AT=370.05n

.meas tran vdout1_33ck360 FIND v(dout1_33) AT=370.05n

.meas tran vdout1_34ck360 FIND v(dout1_34) AT=370.05n

.meas tran vdout1_35ck360 FIND v(dout1_35) AT=370.05n

.meas tran vdout1_36ck360 FIND v(dout1_36) AT=370.05n

.meas tran vdout1_37ck360 FIND v(dout1_37) AT=370.05n

.meas tran vdout1_38ck360 FIND v(dout1_38) AT=370.05n

.meas tran vdout1_39ck360 FIND v(dout1_39) AT=370.05n

.meas tran vdout1_40ck360 FIND v(dout1_40) AT=370.05n

.meas tran vdout1_41ck360 FIND v(dout1_41) AT=370.05n

.meas tran vdout1_42ck360 FIND v(dout1_42) AT=370.05n

.meas tran vdout1_43ck360 FIND v(dout1_43) AT=370.05n

.meas tran vdout1_44ck360 FIND v(dout1_44) AT=370.05n

.meas tran vdout1_45ck360 FIND v(dout1_45) AT=370.05n

.meas tran vdout1_46ck360 FIND v(dout1_46) AT=370.05n

.meas tran vdout1_47ck360 FIND v(dout1_47) AT=370.05n

.meas tran vdout1_48ck360 FIND v(dout1_48) AT=370.05n

.meas tran vdout1_49ck360 FIND v(dout1_49) AT=370.05n

.meas tran vdout1_50ck360 FIND v(dout1_50) AT=370.05n

.meas tran vdout1_51ck360 FIND v(dout1_51) AT=370.05n

.meas tran vdout1_52ck360 FIND v(dout1_52) AT=370.05n

.meas tran vdout1_53ck360 FIND v(dout1_53) AT=370.05n

.meas tran vdout1_54ck360 FIND v(dout1_54) AT=370.05n

.meas tran vdout1_55ck360 FIND v(dout1_55) AT=370.05n

.meas tran vdout1_56ck360 FIND v(dout1_56) AT=370.05n

.meas tran vdout1_57ck360 FIND v(dout1_57) AT=370.05n

.meas tran vdout1_58ck360 FIND v(dout1_58) AT=370.05n

.meas tran vdout1_59ck360 FIND v(dout1_59) AT=370.05n

.meas tran vdout1_60ck360 FIND v(dout1_60) AT=370.05n

.meas tran vdout1_61ck360 FIND v(dout1_61) AT=370.05n

.meas tran vdout1_62ck360 FIND v(dout1_62) AT=370.05n

.meas tran vdout1_63ck360 FIND v(dout1_63) AT=370.05n

.meas tran vdout1_64ck360 FIND v(dout1_64) AT=370.05n

.meas tran vdout1_65ck360 FIND v(dout1_65) AT=370.05n

.meas tran vdout1_66ck360 FIND v(dout1_66) AT=370.05n

.meas tran vdout1_67ck360 FIND v(dout1_67) AT=370.05n

.meas tran vdout1_68ck360 FIND v(dout1_68) AT=370.05n

.meas tran vdout1_69ck360 FIND v(dout1_69) AT=370.05n

.meas tran vdout1_70ck360 FIND v(dout1_70) AT=370.05n

.meas tran vdout1_71ck360 FIND v(dout1_71) AT=370.05n

.meas tran vdout1_72ck360 FIND v(dout1_72) AT=370.05n

.meas tran vdout1_73ck360 FIND v(dout1_73) AT=370.05n

.meas tran vdout1_74ck360 FIND v(dout1_74) AT=370.05n

.meas tran vdout1_75ck360 FIND v(dout1_75) AT=370.05n

.meas tran vdout1_76ck360 FIND v(dout1_76) AT=370.05n

.meas tran vdout1_77ck360 FIND v(dout1_77) AT=370.05n

.meas tran vdout1_78ck360 FIND v(dout1_78) AT=370.05n

.meas tran vdout1_79ck360 FIND v(dout1_79) AT=370.05n

.meas tran vdout1_80ck360 FIND v(dout1_80) AT=370.05n

.meas tran vdout1_81ck360 FIND v(dout1_81) AT=370.05n

.meas tran vdout1_82ck360 FIND v(dout1_82) AT=370.05n

.meas tran vdout1_83ck360 FIND v(dout1_83) AT=370.05n

.meas tran vdout1_84ck360 FIND v(dout1_84) AT=370.05n

.meas tran vdout1_85ck360 FIND v(dout1_85) AT=370.05n

.meas tran vdout1_86ck360 FIND v(dout1_86) AT=370.05n

.meas tran vdout1_87ck360 FIND v(dout1_87) AT=370.05n

.meas tran vdout1_88ck360 FIND v(dout1_88) AT=370.05n

.meas tran vdout1_89ck360 FIND v(dout1_89) AT=370.05n

.meas tran vdout1_90ck360 FIND v(dout1_90) AT=370.05n

.meas tran vdout1_91ck360 FIND v(dout1_91) AT=370.05n

.meas tran vdout1_92ck360 FIND v(dout1_92) AT=370.05n

.meas tran vdout1_93ck360 FIND v(dout1_93) AT=370.05n

.meas tran vdout1_94ck360 FIND v(dout1_94) AT=370.05n

.meas tran vdout1_95ck360 FIND v(dout1_95) AT=370.05n

.meas tran vdout1_96ck360 FIND v(dout1_96) AT=370.05n

.meas tran vdout1_97ck360 FIND v(dout1_97) AT=370.05n

.meas tran vdout1_98ck360 FIND v(dout1_98) AT=370.05n

.meas tran vdout1_99ck360 FIND v(dout1_99) AT=370.05n

.meas tran vdout1_100ck360 FIND v(dout1_100) AT=370.05n

.meas tran vdout1_101ck360 FIND v(dout1_101) AT=370.05n

.meas tran vdout1_102ck360 FIND v(dout1_102) AT=370.05n

.meas tran vdout1_103ck360 FIND v(dout1_103) AT=370.05n

.meas tran vdout1_104ck360 FIND v(dout1_104) AT=370.05n

.meas tran vdout1_105ck360 FIND v(dout1_105) AT=370.05n

.meas tran vdout1_106ck360 FIND v(dout1_106) AT=370.05n

.meas tran vdout1_107ck360 FIND v(dout1_107) AT=370.05n

.meas tran vdout1_108ck360 FIND v(dout1_108) AT=370.05n

.meas tran vdout1_109ck360 FIND v(dout1_109) AT=370.05n

.meas tran vdout1_110ck360 FIND v(dout1_110) AT=370.05n

.meas tran vdout1_111ck360 FIND v(dout1_111) AT=370.05n

.meas tran vdout1_112ck360 FIND v(dout1_112) AT=370.05n

.meas tran vdout1_113ck360 FIND v(dout1_113) AT=370.05n

.meas tran vdout1_114ck360 FIND v(dout1_114) AT=370.05n

.meas tran vdout1_115ck360 FIND v(dout1_115) AT=370.05n

.meas tran vdout1_116ck360 FIND v(dout1_116) AT=370.05n

.meas tran vdout1_117ck360 FIND v(dout1_117) AT=370.05n

.meas tran vdout1_118ck360 FIND v(dout1_118) AT=370.05n

.meas tran vdout1_119ck360 FIND v(dout1_119) AT=370.05n

.meas tran vdout1_120ck360 FIND v(dout1_120) AT=370.05n

.meas tran vdout1_121ck360 FIND v(dout1_121) AT=370.05n

.meas tran vdout1_122ck360 FIND v(dout1_122) AT=370.05n

.meas tran vdout1_123ck360 FIND v(dout1_123) AT=370.05n

.meas tran vdout1_124ck360 FIND v(dout1_124) AT=370.05n

.meas tran vdout1_125ck360 FIND v(dout1_125) AT=370.05n

.meas tran vdout1_126ck360 FIND v(dout1_126) AT=370.05n

.meas tran vdout1_127ck360 FIND v(dout1_127) AT=370.05n

.meas tran vdout1_128ck360 FIND v(dout1_128) AT=370.05n

.meas tran vdout1_129ck360 FIND v(dout1_129) AT=370.05n

.meas tran vdout1_130ck360 FIND v(dout1_130) AT=370.05n

.meas tran vdout1_131ck360 FIND v(dout1_131) AT=370.05n

.meas tran vdout1_132ck360 FIND v(dout1_132) AT=370.05n

.meas tran vdout1_133ck360 FIND v(dout1_133) AT=370.05n

.meas tran vdout1_134ck360 FIND v(dout1_134) AT=370.05n

.meas tran vdout1_0ck380 FIND v(dout1_0) AT=390.05n

.meas tran vdout1_1ck380 FIND v(dout1_1) AT=390.05n

.meas tran vdout1_2ck380 FIND v(dout1_2) AT=390.05n

.meas tran vdout1_3ck380 FIND v(dout1_3) AT=390.05n

.meas tran vdout1_4ck380 FIND v(dout1_4) AT=390.05n

.meas tran vdout1_5ck380 FIND v(dout1_5) AT=390.05n

.meas tran vdout1_6ck380 FIND v(dout1_6) AT=390.05n

.meas tran vdout1_7ck380 FIND v(dout1_7) AT=390.05n

.meas tran vdout1_8ck380 FIND v(dout1_8) AT=390.05n

.meas tran vdout1_9ck380 FIND v(dout1_9) AT=390.05n

.meas tran vdout1_10ck380 FIND v(dout1_10) AT=390.05n

.meas tran vdout1_11ck380 FIND v(dout1_11) AT=390.05n

.meas tran vdout1_12ck380 FIND v(dout1_12) AT=390.05n

.meas tran vdout1_13ck380 FIND v(dout1_13) AT=390.05n

.meas tran vdout1_14ck380 FIND v(dout1_14) AT=390.05n

.meas tran vdout1_15ck380 FIND v(dout1_15) AT=390.05n

.meas tran vdout1_16ck380 FIND v(dout1_16) AT=390.05n

.meas tran vdout1_17ck380 FIND v(dout1_17) AT=390.05n

.meas tran vdout1_18ck380 FIND v(dout1_18) AT=390.05n

.meas tran vdout1_19ck380 FIND v(dout1_19) AT=390.05n

.meas tran vdout1_20ck380 FIND v(dout1_20) AT=390.05n

.meas tran vdout1_21ck380 FIND v(dout1_21) AT=390.05n

.meas tran vdout1_22ck380 FIND v(dout1_22) AT=390.05n

.meas tran vdout1_23ck380 FIND v(dout1_23) AT=390.05n

.meas tran vdout1_24ck380 FIND v(dout1_24) AT=390.05n

.meas tran vdout1_25ck380 FIND v(dout1_25) AT=390.05n

.meas tran vdout1_26ck380 FIND v(dout1_26) AT=390.05n

.meas tran vdout1_27ck380 FIND v(dout1_27) AT=390.05n

.meas tran vdout1_28ck380 FIND v(dout1_28) AT=390.05n

.meas tran vdout1_29ck380 FIND v(dout1_29) AT=390.05n

.meas tran vdout1_30ck380 FIND v(dout1_30) AT=390.05n

.meas tran vdout1_31ck380 FIND v(dout1_31) AT=390.05n

.meas tran vdout1_32ck380 FIND v(dout1_32) AT=390.05n

.meas tran vdout1_33ck380 FIND v(dout1_33) AT=390.05n

.meas tran vdout1_34ck380 FIND v(dout1_34) AT=390.05n

.meas tran vdout1_35ck380 FIND v(dout1_35) AT=390.05n

.meas tran vdout1_36ck380 FIND v(dout1_36) AT=390.05n

.meas tran vdout1_37ck380 FIND v(dout1_37) AT=390.05n

.meas tran vdout1_38ck380 FIND v(dout1_38) AT=390.05n

.meas tran vdout1_39ck380 FIND v(dout1_39) AT=390.05n

.meas tran vdout1_40ck380 FIND v(dout1_40) AT=390.05n

.meas tran vdout1_41ck380 FIND v(dout1_41) AT=390.05n

.meas tran vdout1_42ck380 FIND v(dout1_42) AT=390.05n

.meas tran vdout1_43ck380 FIND v(dout1_43) AT=390.05n

.meas tran vdout1_44ck380 FIND v(dout1_44) AT=390.05n

.meas tran vdout1_45ck380 FIND v(dout1_45) AT=390.05n

.meas tran vdout1_46ck380 FIND v(dout1_46) AT=390.05n

.meas tran vdout1_47ck380 FIND v(dout1_47) AT=390.05n

.meas tran vdout1_48ck380 FIND v(dout1_48) AT=390.05n

.meas tran vdout1_49ck380 FIND v(dout1_49) AT=390.05n

.meas tran vdout1_50ck380 FIND v(dout1_50) AT=390.05n

.meas tran vdout1_51ck380 FIND v(dout1_51) AT=390.05n

.meas tran vdout1_52ck380 FIND v(dout1_52) AT=390.05n

.meas tran vdout1_53ck380 FIND v(dout1_53) AT=390.05n

.meas tran vdout1_54ck380 FIND v(dout1_54) AT=390.05n

.meas tran vdout1_55ck380 FIND v(dout1_55) AT=390.05n

.meas tran vdout1_56ck380 FIND v(dout1_56) AT=390.05n

.meas tran vdout1_57ck380 FIND v(dout1_57) AT=390.05n

.meas tran vdout1_58ck380 FIND v(dout1_58) AT=390.05n

.meas tran vdout1_59ck380 FIND v(dout1_59) AT=390.05n

.meas tran vdout1_60ck380 FIND v(dout1_60) AT=390.05n

.meas tran vdout1_61ck380 FIND v(dout1_61) AT=390.05n

.meas tran vdout1_62ck380 FIND v(dout1_62) AT=390.05n

.meas tran vdout1_63ck380 FIND v(dout1_63) AT=390.05n

.meas tran vdout1_64ck380 FIND v(dout1_64) AT=390.05n

.meas tran vdout1_65ck380 FIND v(dout1_65) AT=390.05n

.meas tran vdout1_66ck380 FIND v(dout1_66) AT=390.05n

.meas tran vdout1_67ck380 FIND v(dout1_67) AT=390.05n

.meas tran vdout1_68ck380 FIND v(dout1_68) AT=390.05n

.meas tran vdout1_69ck380 FIND v(dout1_69) AT=390.05n

.meas tran vdout1_70ck380 FIND v(dout1_70) AT=390.05n

.meas tran vdout1_71ck380 FIND v(dout1_71) AT=390.05n

.meas tran vdout1_72ck380 FIND v(dout1_72) AT=390.05n

.meas tran vdout1_73ck380 FIND v(dout1_73) AT=390.05n

.meas tran vdout1_74ck380 FIND v(dout1_74) AT=390.05n

.meas tran vdout1_75ck380 FIND v(dout1_75) AT=390.05n

.meas tran vdout1_76ck380 FIND v(dout1_76) AT=390.05n

.meas tran vdout1_77ck380 FIND v(dout1_77) AT=390.05n

.meas tran vdout1_78ck380 FIND v(dout1_78) AT=390.05n

.meas tran vdout1_79ck380 FIND v(dout1_79) AT=390.05n

.meas tran vdout1_80ck380 FIND v(dout1_80) AT=390.05n

.meas tran vdout1_81ck380 FIND v(dout1_81) AT=390.05n

.meas tran vdout1_82ck380 FIND v(dout1_82) AT=390.05n

.meas tran vdout1_83ck380 FIND v(dout1_83) AT=390.05n

.meas tran vdout1_84ck380 FIND v(dout1_84) AT=390.05n

.meas tran vdout1_85ck380 FIND v(dout1_85) AT=390.05n

.meas tran vdout1_86ck380 FIND v(dout1_86) AT=390.05n

.meas tran vdout1_87ck380 FIND v(dout1_87) AT=390.05n

.meas tran vdout1_88ck380 FIND v(dout1_88) AT=390.05n

.meas tran vdout1_89ck380 FIND v(dout1_89) AT=390.05n

.meas tran vdout1_90ck380 FIND v(dout1_90) AT=390.05n

.meas tran vdout1_91ck380 FIND v(dout1_91) AT=390.05n

.meas tran vdout1_92ck380 FIND v(dout1_92) AT=390.05n

.meas tran vdout1_93ck380 FIND v(dout1_93) AT=390.05n

.meas tran vdout1_94ck380 FIND v(dout1_94) AT=390.05n

.meas tran vdout1_95ck380 FIND v(dout1_95) AT=390.05n

.meas tran vdout1_96ck380 FIND v(dout1_96) AT=390.05n

.meas tran vdout1_97ck380 FIND v(dout1_97) AT=390.05n

.meas tran vdout1_98ck380 FIND v(dout1_98) AT=390.05n

.meas tran vdout1_99ck380 FIND v(dout1_99) AT=390.05n

.meas tran vdout1_100ck380 FIND v(dout1_100) AT=390.05n

.meas tran vdout1_101ck380 FIND v(dout1_101) AT=390.05n

.meas tran vdout1_102ck380 FIND v(dout1_102) AT=390.05n

.meas tran vdout1_103ck380 FIND v(dout1_103) AT=390.05n

.meas tran vdout1_104ck380 FIND v(dout1_104) AT=390.05n

.meas tran vdout1_105ck380 FIND v(dout1_105) AT=390.05n

.meas tran vdout1_106ck380 FIND v(dout1_106) AT=390.05n

.meas tran vdout1_107ck380 FIND v(dout1_107) AT=390.05n

.meas tran vdout1_108ck380 FIND v(dout1_108) AT=390.05n

.meas tran vdout1_109ck380 FIND v(dout1_109) AT=390.05n

.meas tran vdout1_110ck380 FIND v(dout1_110) AT=390.05n

.meas tran vdout1_111ck380 FIND v(dout1_111) AT=390.05n

.meas tran vdout1_112ck380 FIND v(dout1_112) AT=390.05n

.meas tran vdout1_113ck380 FIND v(dout1_113) AT=390.05n

.meas tran vdout1_114ck380 FIND v(dout1_114) AT=390.05n

.meas tran vdout1_115ck380 FIND v(dout1_115) AT=390.05n

.meas tran vdout1_116ck380 FIND v(dout1_116) AT=390.05n

.meas tran vdout1_117ck380 FIND v(dout1_117) AT=390.05n

.meas tran vdout1_118ck380 FIND v(dout1_118) AT=390.05n

.meas tran vdout1_119ck380 FIND v(dout1_119) AT=390.05n

.meas tran vdout1_120ck380 FIND v(dout1_120) AT=390.05n

.meas tran vdout1_121ck380 FIND v(dout1_121) AT=390.05n

.meas tran vdout1_122ck380 FIND v(dout1_122) AT=390.05n

.meas tran vdout1_123ck380 FIND v(dout1_123) AT=390.05n

.meas tran vdout1_124ck380 FIND v(dout1_124) AT=390.05n

.meas tran vdout1_125ck380 FIND v(dout1_125) AT=390.05n

.meas tran vdout1_126ck380 FIND v(dout1_126) AT=390.05n

.meas tran vdout1_127ck380 FIND v(dout1_127) AT=390.05n

.meas tran vdout1_128ck380 FIND v(dout1_128) AT=390.05n

.meas tran vdout1_129ck380 FIND v(dout1_129) AT=390.05n

.meas tran vdout1_130ck380 FIND v(dout1_130) AT=390.05n

.meas tran vdout1_131ck380 FIND v(dout1_131) AT=390.05n

.meas tran vdout1_132ck380 FIND v(dout1_132) AT=390.05n

.meas tran vdout1_133ck380 FIND v(dout1_133) AT=390.05n

.meas tran vdout1_134ck380 FIND v(dout1_134) AT=390.05n

.meas tran vdout1_0ck430 FIND v(dout1_0) AT=440.05n

.meas tran vdout1_1ck430 FIND v(dout1_1) AT=440.05n

.meas tran vdout1_2ck430 FIND v(dout1_2) AT=440.05n

.meas tran vdout1_3ck430 FIND v(dout1_3) AT=440.05n

.meas tran vdout1_4ck430 FIND v(dout1_4) AT=440.05n

.meas tran vdout1_5ck430 FIND v(dout1_5) AT=440.05n

.meas tran vdout1_6ck430 FIND v(dout1_6) AT=440.05n

.meas tran vdout1_7ck430 FIND v(dout1_7) AT=440.05n

.meas tran vdout1_8ck430 FIND v(dout1_8) AT=440.05n

.meas tran vdout1_9ck430 FIND v(dout1_9) AT=440.05n

.meas tran vdout1_10ck430 FIND v(dout1_10) AT=440.05n

.meas tran vdout1_11ck430 FIND v(dout1_11) AT=440.05n

.meas tran vdout1_12ck430 FIND v(dout1_12) AT=440.05n

.meas tran vdout1_13ck430 FIND v(dout1_13) AT=440.05n

.meas tran vdout1_14ck430 FIND v(dout1_14) AT=440.05n

.meas tran vdout1_15ck430 FIND v(dout1_15) AT=440.05n

.meas tran vdout1_16ck430 FIND v(dout1_16) AT=440.05n

.meas tran vdout1_17ck430 FIND v(dout1_17) AT=440.05n

.meas tran vdout1_18ck430 FIND v(dout1_18) AT=440.05n

.meas tran vdout1_19ck430 FIND v(dout1_19) AT=440.05n

.meas tran vdout1_20ck430 FIND v(dout1_20) AT=440.05n

.meas tran vdout1_21ck430 FIND v(dout1_21) AT=440.05n

.meas tran vdout1_22ck430 FIND v(dout1_22) AT=440.05n

.meas tran vdout1_23ck430 FIND v(dout1_23) AT=440.05n

.meas tran vdout1_24ck430 FIND v(dout1_24) AT=440.05n

.meas tran vdout1_25ck430 FIND v(dout1_25) AT=440.05n

.meas tran vdout1_26ck430 FIND v(dout1_26) AT=440.05n

.meas tran vdout1_27ck430 FIND v(dout1_27) AT=440.05n

.meas tran vdout1_28ck430 FIND v(dout1_28) AT=440.05n

.meas tran vdout1_29ck430 FIND v(dout1_29) AT=440.05n

.meas tran vdout1_30ck430 FIND v(dout1_30) AT=440.05n

.meas tran vdout1_31ck430 FIND v(dout1_31) AT=440.05n

.meas tran vdout1_32ck430 FIND v(dout1_32) AT=440.05n

.meas tran vdout1_33ck430 FIND v(dout1_33) AT=440.05n

.meas tran vdout1_34ck430 FIND v(dout1_34) AT=440.05n

.meas tran vdout1_35ck430 FIND v(dout1_35) AT=440.05n

.meas tran vdout1_36ck430 FIND v(dout1_36) AT=440.05n

.meas tran vdout1_37ck430 FIND v(dout1_37) AT=440.05n

.meas tran vdout1_38ck430 FIND v(dout1_38) AT=440.05n

.meas tran vdout1_39ck430 FIND v(dout1_39) AT=440.05n

.meas tran vdout1_40ck430 FIND v(dout1_40) AT=440.05n

.meas tran vdout1_41ck430 FIND v(dout1_41) AT=440.05n

.meas tran vdout1_42ck430 FIND v(dout1_42) AT=440.05n

.meas tran vdout1_43ck430 FIND v(dout1_43) AT=440.05n

.meas tran vdout1_44ck430 FIND v(dout1_44) AT=440.05n

.meas tran vdout1_45ck430 FIND v(dout1_45) AT=440.05n

.meas tran vdout1_46ck430 FIND v(dout1_46) AT=440.05n

.meas tran vdout1_47ck430 FIND v(dout1_47) AT=440.05n

.meas tran vdout1_48ck430 FIND v(dout1_48) AT=440.05n

.meas tran vdout1_49ck430 FIND v(dout1_49) AT=440.05n

.meas tran vdout1_50ck430 FIND v(dout1_50) AT=440.05n

.meas tran vdout1_51ck430 FIND v(dout1_51) AT=440.05n

.meas tran vdout1_52ck430 FIND v(dout1_52) AT=440.05n

.meas tran vdout1_53ck430 FIND v(dout1_53) AT=440.05n

.meas tran vdout1_54ck430 FIND v(dout1_54) AT=440.05n

.meas tran vdout1_55ck430 FIND v(dout1_55) AT=440.05n

.meas tran vdout1_56ck430 FIND v(dout1_56) AT=440.05n

.meas tran vdout1_57ck430 FIND v(dout1_57) AT=440.05n

.meas tran vdout1_58ck430 FIND v(dout1_58) AT=440.05n

.meas tran vdout1_59ck430 FIND v(dout1_59) AT=440.05n

.meas tran vdout1_60ck430 FIND v(dout1_60) AT=440.05n

.meas tran vdout1_61ck430 FIND v(dout1_61) AT=440.05n

.meas tran vdout1_62ck430 FIND v(dout1_62) AT=440.05n

.meas tran vdout1_63ck430 FIND v(dout1_63) AT=440.05n

.meas tran vdout1_64ck430 FIND v(dout1_64) AT=440.05n

.meas tran vdout1_65ck430 FIND v(dout1_65) AT=440.05n

.meas tran vdout1_66ck430 FIND v(dout1_66) AT=440.05n

.meas tran vdout1_67ck430 FIND v(dout1_67) AT=440.05n

.meas tran vdout1_68ck430 FIND v(dout1_68) AT=440.05n

.meas tran vdout1_69ck430 FIND v(dout1_69) AT=440.05n

.meas tran vdout1_70ck430 FIND v(dout1_70) AT=440.05n

.meas tran vdout1_71ck430 FIND v(dout1_71) AT=440.05n

.meas tran vdout1_72ck430 FIND v(dout1_72) AT=440.05n

.meas tran vdout1_73ck430 FIND v(dout1_73) AT=440.05n

.meas tran vdout1_74ck430 FIND v(dout1_74) AT=440.05n

.meas tran vdout1_75ck430 FIND v(dout1_75) AT=440.05n

.meas tran vdout1_76ck430 FIND v(dout1_76) AT=440.05n

.meas tran vdout1_77ck430 FIND v(dout1_77) AT=440.05n

.meas tran vdout1_78ck430 FIND v(dout1_78) AT=440.05n

.meas tran vdout1_79ck430 FIND v(dout1_79) AT=440.05n

.meas tran vdout1_80ck430 FIND v(dout1_80) AT=440.05n

.meas tran vdout1_81ck430 FIND v(dout1_81) AT=440.05n

.meas tran vdout1_82ck430 FIND v(dout1_82) AT=440.05n

.meas tran vdout1_83ck430 FIND v(dout1_83) AT=440.05n

.meas tran vdout1_84ck430 FIND v(dout1_84) AT=440.05n

.meas tran vdout1_85ck430 FIND v(dout1_85) AT=440.05n

.meas tran vdout1_86ck430 FIND v(dout1_86) AT=440.05n

.meas tran vdout1_87ck430 FIND v(dout1_87) AT=440.05n

.meas tran vdout1_88ck430 FIND v(dout1_88) AT=440.05n

.meas tran vdout1_89ck430 FIND v(dout1_89) AT=440.05n

.meas tran vdout1_90ck430 FIND v(dout1_90) AT=440.05n

.meas tran vdout1_91ck430 FIND v(dout1_91) AT=440.05n

.meas tran vdout1_92ck430 FIND v(dout1_92) AT=440.05n

.meas tran vdout1_93ck430 FIND v(dout1_93) AT=440.05n

.meas tran vdout1_94ck430 FIND v(dout1_94) AT=440.05n

.meas tran vdout1_95ck430 FIND v(dout1_95) AT=440.05n

.meas tran vdout1_96ck430 FIND v(dout1_96) AT=440.05n

.meas tran vdout1_97ck430 FIND v(dout1_97) AT=440.05n

.meas tran vdout1_98ck430 FIND v(dout1_98) AT=440.05n

.meas tran vdout1_99ck430 FIND v(dout1_99) AT=440.05n

.meas tran vdout1_100ck430 FIND v(dout1_100) AT=440.05n

.meas tran vdout1_101ck430 FIND v(dout1_101) AT=440.05n

.meas tran vdout1_102ck430 FIND v(dout1_102) AT=440.05n

.meas tran vdout1_103ck430 FIND v(dout1_103) AT=440.05n

.meas tran vdout1_104ck430 FIND v(dout1_104) AT=440.05n

.meas tran vdout1_105ck430 FIND v(dout1_105) AT=440.05n

.meas tran vdout1_106ck430 FIND v(dout1_106) AT=440.05n

.meas tran vdout1_107ck430 FIND v(dout1_107) AT=440.05n

.meas tran vdout1_108ck430 FIND v(dout1_108) AT=440.05n

.meas tran vdout1_109ck430 FIND v(dout1_109) AT=440.05n

.meas tran vdout1_110ck430 FIND v(dout1_110) AT=440.05n

.meas tran vdout1_111ck430 FIND v(dout1_111) AT=440.05n

.meas tran vdout1_112ck430 FIND v(dout1_112) AT=440.05n

.meas tran vdout1_113ck430 FIND v(dout1_113) AT=440.05n

.meas tran vdout1_114ck430 FIND v(dout1_114) AT=440.05n

.meas tran vdout1_115ck430 FIND v(dout1_115) AT=440.05n

.meas tran vdout1_116ck430 FIND v(dout1_116) AT=440.05n

.meas tran vdout1_117ck430 FIND v(dout1_117) AT=440.05n

.meas tran vdout1_118ck430 FIND v(dout1_118) AT=440.05n

.meas tran vdout1_119ck430 FIND v(dout1_119) AT=440.05n

.meas tran vdout1_120ck430 FIND v(dout1_120) AT=440.05n

.meas tran vdout1_121ck430 FIND v(dout1_121) AT=440.05n

.meas tran vdout1_122ck430 FIND v(dout1_122) AT=440.05n

.meas tran vdout1_123ck430 FIND v(dout1_123) AT=440.05n

.meas tran vdout1_124ck430 FIND v(dout1_124) AT=440.05n

.meas tran vdout1_125ck430 FIND v(dout1_125) AT=440.05n

.meas tran vdout1_126ck430 FIND v(dout1_126) AT=440.05n

.meas tran vdout1_127ck430 FIND v(dout1_127) AT=440.05n

.meas tran vdout1_128ck430 FIND v(dout1_128) AT=440.05n

.meas tran vdout1_129ck430 FIND v(dout1_129) AT=440.05n

.meas tran vdout1_130ck430 FIND v(dout1_130) AT=440.05n

.meas tran vdout1_131ck430 FIND v(dout1_131) AT=440.05n

.meas tran vdout1_132ck430 FIND v(dout1_132) AT=440.05n

.meas tran vdout1_133ck430 FIND v(dout1_133) AT=440.05n

.meas tran vdout1_134ck430 FIND v(dout1_134) AT=440.05n

.meas tran vdout1_0ck450 FIND v(dout1_0) AT=460.05n

.meas tran vdout1_1ck450 FIND v(dout1_1) AT=460.05n

.meas tran vdout1_2ck450 FIND v(dout1_2) AT=460.05n

.meas tran vdout1_3ck450 FIND v(dout1_3) AT=460.05n

.meas tran vdout1_4ck450 FIND v(dout1_4) AT=460.05n

.meas tran vdout1_5ck450 FIND v(dout1_5) AT=460.05n

.meas tran vdout1_6ck450 FIND v(dout1_6) AT=460.05n

.meas tran vdout1_7ck450 FIND v(dout1_7) AT=460.05n

.meas tran vdout1_8ck450 FIND v(dout1_8) AT=460.05n

.meas tran vdout1_9ck450 FIND v(dout1_9) AT=460.05n

.meas tran vdout1_10ck450 FIND v(dout1_10) AT=460.05n

.meas tran vdout1_11ck450 FIND v(dout1_11) AT=460.05n

.meas tran vdout1_12ck450 FIND v(dout1_12) AT=460.05n

.meas tran vdout1_13ck450 FIND v(dout1_13) AT=460.05n

.meas tran vdout1_14ck450 FIND v(dout1_14) AT=460.05n

.meas tran vdout1_15ck450 FIND v(dout1_15) AT=460.05n

.meas tran vdout1_16ck450 FIND v(dout1_16) AT=460.05n

.meas tran vdout1_17ck450 FIND v(dout1_17) AT=460.05n

.meas tran vdout1_18ck450 FIND v(dout1_18) AT=460.05n

.meas tran vdout1_19ck450 FIND v(dout1_19) AT=460.05n

.meas tran vdout1_20ck450 FIND v(dout1_20) AT=460.05n

.meas tran vdout1_21ck450 FIND v(dout1_21) AT=460.05n

.meas tran vdout1_22ck450 FIND v(dout1_22) AT=460.05n

.meas tran vdout1_23ck450 FIND v(dout1_23) AT=460.05n

.meas tran vdout1_24ck450 FIND v(dout1_24) AT=460.05n

.meas tran vdout1_25ck450 FIND v(dout1_25) AT=460.05n

.meas tran vdout1_26ck450 FIND v(dout1_26) AT=460.05n

.meas tran vdout1_27ck450 FIND v(dout1_27) AT=460.05n

.meas tran vdout1_28ck450 FIND v(dout1_28) AT=460.05n

.meas tran vdout1_29ck450 FIND v(dout1_29) AT=460.05n

.meas tran vdout1_30ck450 FIND v(dout1_30) AT=460.05n

.meas tran vdout1_31ck450 FIND v(dout1_31) AT=460.05n

.meas tran vdout1_32ck450 FIND v(dout1_32) AT=460.05n

.meas tran vdout1_33ck450 FIND v(dout1_33) AT=460.05n

.meas tran vdout1_34ck450 FIND v(dout1_34) AT=460.05n

.meas tran vdout1_35ck450 FIND v(dout1_35) AT=460.05n

.meas tran vdout1_36ck450 FIND v(dout1_36) AT=460.05n

.meas tran vdout1_37ck450 FIND v(dout1_37) AT=460.05n

.meas tran vdout1_38ck450 FIND v(dout1_38) AT=460.05n

.meas tran vdout1_39ck450 FIND v(dout1_39) AT=460.05n

.meas tran vdout1_40ck450 FIND v(dout1_40) AT=460.05n

.meas tran vdout1_41ck450 FIND v(dout1_41) AT=460.05n

.meas tran vdout1_42ck450 FIND v(dout1_42) AT=460.05n

.meas tran vdout1_43ck450 FIND v(dout1_43) AT=460.05n

.meas tran vdout1_44ck450 FIND v(dout1_44) AT=460.05n

.meas tran vdout1_45ck450 FIND v(dout1_45) AT=460.05n

.meas tran vdout1_46ck450 FIND v(dout1_46) AT=460.05n

.meas tran vdout1_47ck450 FIND v(dout1_47) AT=460.05n

.meas tran vdout1_48ck450 FIND v(dout1_48) AT=460.05n

.meas tran vdout1_49ck450 FIND v(dout1_49) AT=460.05n

.meas tran vdout1_50ck450 FIND v(dout1_50) AT=460.05n

.meas tran vdout1_51ck450 FIND v(dout1_51) AT=460.05n

.meas tran vdout1_52ck450 FIND v(dout1_52) AT=460.05n

.meas tran vdout1_53ck450 FIND v(dout1_53) AT=460.05n

.meas tran vdout1_54ck450 FIND v(dout1_54) AT=460.05n

.meas tran vdout1_55ck450 FIND v(dout1_55) AT=460.05n

.meas tran vdout1_56ck450 FIND v(dout1_56) AT=460.05n

.meas tran vdout1_57ck450 FIND v(dout1_57) AT=460.05n

.meas tran vdout1_58ck450 FIND v(dout1_58) AT=460.05n

.meas tran vdout1_59ck450 FIND v(dout1_59) AT=460.05n

.meas tran vdout1_60ck450 FIND v(dout1_60) AT=460.05n

.meas tran vdout1_61ck450 FIND v(dout1_61) AT=460.05n

.meas tran vdout1_62ck450 FIND v(dout1_62) AT=460.05n

.meas tran vdout1_63ck450 FIND v(dout1_63) AT=460.05n

.meas tran vdout1_64ck450 FIND v(dout1_64) AT=460.05n

.meas tran vdout1_65ck450 FIND v(dout1_65) AT=460.05n

.meas tran vdout1_66ck450 FIND v(dout1_66) AT=460.05n

.meas tran vdout1_67ck450 FIND v(dout1_67) AT=460.05n

.meas tran vdout1_68ck450 FIND v(dout1_68) AT=460.05n

.meas tran vdout1_69ck450 FIND v(dout1_69) AT=460.05n

.meas tran vdout1_70ck450 FIND v(dout1_70) AT=460.05n

.meas tran vdout1_71ck450 FIND v(dout1_71) AT=460.05n

.meas tran vdout1_72ck450 FIND v(dout1_72) AT=460.05n

.meas tran vdout1_73ck450 FIND v(dout1_73) AT=460.05n

.meas tran vdout1_74ck450 FIND v(dout1_74) AT=460.05n

.meas tran vdout1_75ck450 FIND v(dout1_75) AT=460.05n

.meas tran vdout1_76ck450 FIND v(dout1_76) AT=460.05n

.meas tran vdout1_77ck450 FIND v(dout1_77) AT=460.05n

.meas tran vdout1_78ck450 FIND v(dout1_78) AT=460.05n

.meas tran vdout1_79ck450 FIND v(dout1_79) AT=460.05n

.meas tran vdout1_80ck450 FIND v(dout1_80) AT=460.05n

.meas tran vdout1_81ck450 FIND v(dout1_81) AT=460.05n

.meas tran vdout1_82ck450 FIND v(dout1_82) AT=460.05n

.meas tran vdout1_83ck450 FIND v(dout1_83) AT=460.05n

.meas tran vdout1_84ck450 FIND v(dout1_84) AT=460.05n

.meas tran vdout1_85ck450 FIND v(dout1_85) AT=460.05n

.meas tran vdout1_86ck450 FIND v(dout1_86) AT=460.05n

.meas tran vdout1_87ck450 FIND v(dout1_87) AT=460.05n

.meas tran vdout1_88ck450 FIND v(dout1_88) AT=460.05n

.meas tran vdout1_89ck450 FIND v(dout1_89) AT=460.05n

.meas tran vdout1_90ck450 FIND v(dout1_90) AT=460.05n

.meas tran vdout1_91ck450 FIND v(dout1_91) AT=460.05n

.meas tran vdout1_92ck450 FIND v(dout1_92) AT=460.05n

.meas tran vdout1_93ck450 FIND v(dout1_93) AT=460.05n

.meas tran vdout1_94ck450 FIND v(dout1_94) AT=460.05n

.meas tran vdout1_95ck450 FIND v(dout1_95) AT=460.05n

.meas tran vdout1_96ck450 FIND v(dout1_96) AT=460.05n

.meas tran vdout1_97ck450 FIND v(dout1_97) AT=460.05n

.meas tran vdout1_98ck450 FIND v(dout1_98) AT=460.05n

.meas tran vdout1_99ck450 FIND v(dout1_99) AT=460.05n

.meas tran vdout1_100ck450 FIND v(dout1_100) AT=460.05n

.meas tran vdout1_101ck450 FIND v(dout1_101) AT=460.05n

.meas tran vdout1_102ck450 FIND v(dout1_102) AT=460.05n

.meas tran vdout1_103ck450 FIND v(dout1_103) AT=460.05n

.meas tran vdout1_104ck450 FIND v(dout1_104) AT=460.05n

.meas tran vdout1_105ck450 FIND v(dout1_105) AT=460.05n

.meas tran vdout1_106ck450 FIND v(dout1_106) AT=460.05n

.meas tran vdout1_107ck450 FIND v(dout1_107) AT=460.05n

.meas tran vdout1_108ck450 FIND v(dout1_108) AT=460.05n

.meas tran vdout1_109ck450 FIND v(dout1_109) AT=460.05n

.meas tran vdout1_110ck450 FIND v(dout1_110) AT=460.05n

.meas tran vdout1_111ck450 FIND v(dout1_111) AT=460.05n

.meas tran vdout1_112ck450 FIND v(dout1_112) AT=460.05n

.meas tran vdout1_113ck450 FIND v(dout1_113) AT=460.05n

.meas tran vdout1_114ck450 FIND v(dout1_114) AT=460.05n

.meas tran vdout1_115ck450 FIND v(dout1_115) AT=460.05n

.meas tran vdout1_116ck450 FIND v(dout1_116) AT=460.05n

.meas tran vdout1_117ck450 FIND v(dout1_117) AT=460.05n

.meas tran vdout1_118ck450 FIND v(dout1_118) AT=460.05n

.meas tran vdout1_119ck450 FIND v(dout1_119) AT=460.05n

.meas tran vdout1_120ck450 FIND v(dout1_120) AT=460.05n

.meas tran vdout1_121ck450 FIND v(dout1_121) AT=460.05n

.meas tran vdout1_122ck450 FIND v(dout1_122) AT=460.05n

.meas tran vdout1_123ck450 FIND v(dout1_123) AT=460.05n

.meas tran vdout1_124ck450 FIND v(dout1_124) AT=460.05n

.meas tran vdout1_125ck450 FIND v(dout1_125) AT=460.05n

.meas tran vdout1_126ck450 FIND v(dout1_126) AT=460.05n

.meas tran vdout1_127ck450 FIND v(dout1_127) AT=460.05n

.meas tran vdout1_128ck450 FIND v(dout1_128) AT=460.05n

.meas tran vdout1_129ck450 FIND v(dout1_129) AT=460.05n

.meas tran vdout1_130ck450 FIND v(dout1_130) AT=460.05n

.meas tran vdout1_131ck450 FIND v(dout1_131) AT=460.05n

.meas tran vdout1_132ck450 FIND v(dout1_132) AT=460.05n

.meas tran vdout1_133ck450 FIND v(dout1_133) AT=460.05n

.meas tran vdout1_134ck450 FIND v(dout1_134) AT=460.05n

.meas tran vdout1_0ck460 FIND v(dout1_0) AT=470.05n

.meas tran vdout1_1ck460 FIND v(dout1_1) AT=470.05n

.meas tran vdout1_2ck460 FIND v(dout1_2) AT=470.05n

.meas tran vdout1_3ck460 FIND v(dout1_3) AT=470.05n

.meas tran vdout1_4ck460 FIND v(dout1_4) AT=470.05n

.meas tran vdout1_5ck460 FIND v(dout1_5) AT=470.05n

.meas tran vdout1_6ck460 FIND v(dout1_6) AT=470.05n

.meas tran vdout1_7ck460 FIND v(dout1_7) AT=470.05n

.meas tran vdout1_8ck460 FIND v(dout1_8) AT=470.05n

.meas tran vdout1_9ck460 FIND v(dout1_9) AT=470.05n

.meas tran vdout1_10ck460 FIND v(dout1_10) AT=470.05n

.meas tran vdout1_11ck460 FIND v(dout1_11) AT=470.05n

.meas tran vdout1_12ck460 FIND v(dout1_12) AT=470.05n

.meas tran vdout1_13ck460 FIND v(dout1_13) AT=470.05n

.meas tran vdout1_14ck460 FIND v(dout1_14) AT=470.05n

.meas tran vdout1_15ck460 FIND v(dout1_15) AT=470.05n

.meas tran vdout1_16ck460 FIND v(dout1_16) AT=470.05n

.meas tran vdout1_17ck460 FIND v(dout1_17) AT=470.05n

.meas tran vdout1_18ck460 FIND v(dout1_18) AT=470.05n

.meas tran vdout1_19ck460 FIND v(dout1_19) AT=470.05n

.meas tran vdout1_20ck460 FIND v(dout1_20) AT=470.05n

.meas tran vdout1_21ck460 FIND v(dout1_21) AT=470.05n

.meas tran vdout1_22ck460 FIND v(dout1_22) AT=470.05n

.meas tran vdout1_23ck460 FIND v(dout1_23) AT=470.05n

.meas tran vdout1_24ck460 FIND v(dout1_24) AT=470.05n

.meas tran vdout1_25ck460 FIND v(dout1_25) AT=470.05n

.meas tran vdout1_26ck460 FIND v(dout1_26) AT=470.05n

.meas tran vdout1_27ck460 FIND v(dout1_27) AT=470.05n

.meas tran vdout1_28ck460 FIND v(dout1_28) AT=470.05n

.meas tran vdout1_29ck460 FIND v(dout1_29) AT=470.05n

.meas tran vdout1_30ck460 FIND v(dout1_30) AT=470.05n

.meas tran vdout1_31ck460 FIND v(dout1_31) AT=470.05n

.meas tran vdout1_32ck460 FIND v(dout1_32) AT=470.05n

.meas tran vdout1_33ck460 FIND v(dout1_33) AT=470.05n

.meas tran vdout1_34ck460 FIND v(dout1_34) AT=470.05n

.meas tran vdout1_35ck460 FIND v(dout1_35) AT=470.05n

.meas tran vdout1_36ck460 FIND v(dout1_36) AT=470.05n

.meas tran vdout1_37ck460 FIND v(dout1_37) AT=470.05n

.meas tran vdout1_38ck460 FIND v(dout1_38) AT=470.05n

.meas tran vdout1_39ck460 FIND v(dout1_39) AT=470.05n

.meas tran vdout1_40ck460 FIND v(dout1_40) AT=470.05n

.meas tran vdout1_41ck460 FIND v(dout1_41) AT=470.05n

.meas tran vdout1_42ck460 FIND v(dout1_42) AT=470.05n

.meas tran vdout1_43ck460 FIND v(dout1_43) AT=470.05n

.meas tran vdout1_44ck460 FIND v(dout1_44) AT=470.05n

.meas tran vdout1_45ck460 FIND v(dout1_45) AT=470.05n

.meas tran vdout1_46ck460 FIND v(dout1_46) AT=470.05n

.meas tran vdout1_47ck460 FIND v(dout1_47) AT=470.05n

.meas tran vdout1_48ck460 FIND v(dout1_48) AT=470.05n

.meas tran vdout1_49ck460 FIND v(dout1_49) AT=470.05n

.meas tran vdout1_50ck460 FIND v(dout1_50) AT=470.05n

.meas tran vdout1_51ck460 FIND v(dout1_51) AT=470.05n

.meas tran vdout1_52ck460 FIND v(dout1_52) AT=470.05n

.meas tran vdout1_53ck460 FIND v(dout1_53) AT=470.05n

.meas tran vdout1_54ck460 FIND v(dout1_54) AT=470.05n

.meas tran vdout1_55ck460 FIND v(dout1_55) AT=470.05n

.meas tran vdout1_56ck460 FIND v(dout1_56) AT=470.05n

.meas tran vdout1_57ck460 FIND v(dout1_57) AT=470.05n

.meas tran vdout1_58ck460 FIND v(dout1_58) AT=470.05n

.meas tran vdout1_59ck460 FIND v(dout1_59) AT=470.05n

.meas tran vdout1_60ck460 FIND v(dout1_60) AT=470.05n

.meas tran vdout1_61ck460 FIND v(dout1_61) AT=470.05n

.meas tran vdout1_62ck460 FIND v(dout1_62) AT=470.05n

.meas tran vdout1_63ck460 FIND v(dout1_63) AT=470.05n

.meas tran vdout1_64ck460 FIND v(dout1_64) AT=470.05n

.meas tran vdout1_65ck460 FIND v(dout1_65) AT=470.05n

.meas tran vdout1_66ck460 FIND v(dout1_66) AT=470.05n

.meas tran vdout1_67ck460 FIND v(dout1_67) AT=470.05n

.meas tran vdout1_68ck460 FIND v(dout1_68) AT=470.05n

.meas tran vdout1_69ck460 FIND v(dout1_69) AT=470.05n

.meas tran vdout1_70ck460 FIND v(dout1_70) AT=470.05n

.meas tran vdout1_71ck460 FIND v(dout1_71) AT=470.05n

.meas tran vdout1_72ck460 FIND v(dout1_72) AT=470.05n

.meas tran vdout1_73ck460 FIND v(dout1_73) AT=470.05n

.meas tran vdout1_74ck460 FIND v(dout1_74) AT=470.05n

.meas tran vdout1_75ck460 FIND v(dout1_75) AT=470.05n

.meas tran vdout1_76ck460 FIND v(dout1_76) AT=470.05n

.meas tran vdout1_77ck460 FIND v(dout1_77) AT=470.05n

.meas tran vdout1_78ck460 FIND v(dout1_78) AT=470.05n

.meas tran vdout1_79ck460 FIND v(dout1_79) AT=470.05n

.meas tran vdout1_80ck460 FIND v(dout1_80) AT=470.05n

.meas tran vdout1_81ck460 FIND v(dout1_81) AT=470.05n

.meas tran vdout1_82ck460 FIND v(dout1_82) AT=470.05n

.meas tran vdout1_83ck460 FIND v(dout1_83) AT=470.05n

.meas tran vdout1_84ck460 FIND v(dout1_84) AT=470.05n

.meas tran vdout1_85ck460 FIND v(dout1_85) AT=470.05n

.meas tran vdout1_86ck460 FIND v(dout1_86) AT=470.05n

.meas tran vdout1_87ck460 FIND v(dout1_87) AT=470.05n

.meas tran vdout1_88ck460 FIND v(dout1_88) AT=470.05n

.meas tran vdout1_89ck460 FIND v(dout1_89) AT=470.05n

.meas tran vdout1_90ck460 FIND v(dout1_90) AT=470.05n

.meas tran vdout1_91ck460 FIND v(dout1_91) AT=470.05n

.meas tran vdout1_92ck460 FIND v(dout1_92) AT=470.05n

.meas tran vdout1_93ck460 FIND v(dout1_93) AT=470.05n

.meas tran vdout1_94ck460 FIND v(dout1_94) AT=470.05n

.meas tran vdout1_95ck460 FIND v(dout1_95) AT=470.05n

.meas tran vdout1_96ck460 FIND v(dout1_96) AT=470.05n

.meas tran vdout1_97ck460 FIND v(dout1_97) AT=470.05n

.meas tran vdout1_98ck460 FIND v(dout1_98) AT=470.05n

.meas tran vdout1_99ck460 FIND v(dout1_99) AT=470.05n

.meas tran vdout1_100ck460 FIND v(dout1_100) AT=470.05n

.meas tran vdout1_101ck460 FIND v(dout1_101) AT=470.05n

.meas tran vdout1_102ck460 FIND v(dout1_102) AT=470.05n

.meas tran vdout1_103ck460 FIND v(dout1_103) AT=470.05n

.meas tran vdout1_104ck460 FIND v(dout1_104) AT=470.05n

.meas tran vdout1_105ck460 FIND v(dout1_105) AT=470.05n

.meas tran vdout1_106ck460 FIND v(dout1_106) AT=470.05n

.meas tran vdout1_107ck460 FIND v(dout1_107) AT=470.05n

.meas tran vdout1_108ck460 FIND v(dout1_108) AT=470.05n

.meas tran vdout1_109ck460 FIND v(dout1_109) AT=470.05n

.meas tran vdout1_110ck460 FIND v(dout1_110) AT=470.05n

.meas tran vdout1_111ck460 FIND v(dout1_111) AT=470.05n

.meas tran vdout1_112ck460 FIND v(dout1_112) AT=470.05n

.meas tran vdout1_113ck460 FIND v(dout1_113) AT=470.05n

.meas tran vdout1_114ck460 FIND v(dout1_114) AT=470.05n

.meas tran vdout1_115ck460 FIND v(dout1_115) AT=470.05n

.meas tran vdout1_116ck460 FIND v(dout1_116) AT=470.05n

.meas tran vdout1_117ck460 FIND v(dout1_117) AT=470.05n

.meas tran vdout1_118ck460 FIND v(dout1_118) AT=470.05n

.meas tran vdout1_119ck460 FIND v(dout1_119) AT=470.05n

.meas tran vdout1_120ck460 FIND v(dout1_120) AT=470.05n

.meas tran vdout1_121ck460 FIND v(dout1_121) AT=470.05n

.meas tran vdout1_122ck460 FIND v(dout1_122) AT=470.05n

.meas tran vdout1_123ck460 FIND v(dout1_123) AT=470.05n

.meas tran vdout1_124ck460 FIND v(dout1_124) AT=470.05n

.meas tran vdout1_125ck460 FIND v(dout1_125) AT=470.05n

.meas tran vdout1_126ck460 FIND v(dout1_126) AT=470.05n

.meas tran vdout1_127ck460 FIND v(dout1_127) AT=470.05n

.meas tran vdout1_128ck460 FIND v(dout1_128) AT=470.05n

.meas tran vdout1_129ck460 FIND v(dout1_129) AT=470.05n

.meas tran vdout1_130ck460 FIND v(dout1_130) AT=470.05n

.meas tran vdout1_131ck460 FIND v(dout1_131) AT=470.05n

.meas tran vdout1_132ck460 FIND v(dout1_132) AT=470.05n

.meas tran vdout1_133ck460 FIND v(dout1_133) AT=470.05n

.meas tran vdout1_134ck460 FIND v(dout1_134) AT=470.05n

.meas tran vdout1_0ck480 FIND v(dout1_0) AT=490.05n

.meas tran vdout1_1ck480 FIND v(dout1_1) AT=490.05n

.meas tran vdout1_2ck480 FIND v(dout1_2) AT=490.05n

.meas tran vdout1_3ck480 FIND v(dout1_3) AT=490.05n

.meas tran vdout1_4ck480 FIND v(dout1_4) AT=490.05n

.meas tran vdout1_5ck480 FIND v(dout1_5) AT=490.05n

.meas tran vdout1_6ck480 FIND v(dout1_6) AT=490.05n

.meas tran vdout1_7ck480 FIND v(dout1_7) AT=490.05n

.meas tran vdout1_8ck480 FIND v(dout1_8) AT=490.05n

.meas tran vdout1_9ck480 FIND v(dout1_9) AT=490.05n

.meas tran vdout1_10ck480 FIND v(dout1_10) AT=490.05n

.meas tran vdout1_11ck480 FIND v(dout1_11) AT=490.05n

.meas tran vdout1_12ck480 FIND v(dout1_12) AT=490.05n

.meas tran vdout1_13ck480 FIND v(dout1_13) AT=490.05n

.meas tran vdout1_14ck480 FIND v(dout1_14) AT=490.05n

.meas tran vdout1_15ck480 FIND v(dout1_15) AT=490.05n

.meas tran vdout1_16ck480 FIND v(dout1_16) AT=490.05n

.meas tran vdout1_17ck480 FIND v(dout1_17) AT=490.05n

.meas tran vdout1_18ck480 FIND v(dout1_18) AT=490.05n

.meas tran vdout1_19ck480 FIND v(dout1_19) AT=490.05n

.meas tran vdout1_20ck480 FIND v(dout1_20) AT=490.05n

.meas tran vdout1_21ck480 FIND v(dout1_21) AT=490.05n

.meas tran vdout1_22ck480 FIND v(dout1_22) AT=490.05n

.meas tran vdout1_23ck480 FIND v(dout1_23) AT=490.05n

.meas tran vdout1_24ck480 FIND v(dout1_24) AT=490.05n

.meas tran vdout1_25ck480 FIND v(dout1_25) AT=490.05n

.meas tran vdout1_26ck480 FIND v(dout1_26) AT=490.05n

.meas tran vdout1_27ck480 FIND v(dout1_27) AT=490.05n

.meas tran vdout1_28ck480 FIND v(dout1_28) AT=490.05n

.meas tran vdout1_29ck480 FIND v(dout1_29) AT=490.05n

.meas tran vdout1_30ck480 FIND v(dout1_30) AT=490.05n

.meas tran vdout1_31ck480 FIND v(dout1_31) AT=490.05n

.meas tran vdout1_32ck480 FIND v(dout1_32) AT=490.05n

.meas tran vdout1_33ck480 FIND v(dout1_33) AT=490.05n

.meas tran vdout1_34ck480 FIND v(dout1_34) AT=490.05n

.meas tran vdout1_35ck480 FIND v(dout1_35) AT=490.05n

.meas tran vdout1_36ck480 FIND v(dout1_36) AT=490.05n

.meas tran vdout1_37ck480 FIND v(dout1_37) AT=490.05n

.meas tran vdout1_38ck480 FIND v(dout1_38) AT=490.05n

.meas tran vdout1_39ck480 FIND v(dout1_39) AT=490.05n

.meas tran vdout1_40ck480 FIND v(dout1_40) AT=490.05n

.meas tran vdout1_41ck480 FIND v(dout1_41) AT=490.05n

.meas tran vdout1_42ck480 FIND v(dout1_42) AT=490.05n

.meas tran vdout1_43ck480 FIND v(dout1_43) AT=490.05n

.meas tran vdout1_44ck480 FIND v(dout1_44) AT=490.05n

.meas tran vdout1_45ck480 FIND v(dout1_45) AT=490.05n

.meas tran vdout1_46ck480 FIND v(dout1_46) AT=490.05n

.meas tran vdout1_47ck480 FIND v(dout1_47) AT=490.05n

.meas tran vdout1_48ck480 FIND v(dout1_48) AT=490.05n

.meas tran vdout1_49ck480 FIND v(dout1_49) AT=490.05n

.meas tran vdout1_50ck480 FIND v(dout1_50) AT=490.05n

.meas tran vdout1_51ck480 FIND v(dout1_51) AT=490.05n

.meas tran vdout1_52ck480 FIND v(dout1_52) AT=490.05n

.meas tran vdout1_53ck480 FIND v(dout1_53) AT=490.05n

.meas tran vdout1_54ck480 FIND v(dout1_54) AT=490.05n

.meas tran vdout1_55ck480 FIND v(dout1_55) AT=490.05n

.meas tran vdout1_56ck480 FIND v(dout1_56) AT=490.05n

.meas tran vdout1_57ck480 FIND v(dout1_57) AT=490.05n

.meas tran vdout1_58ck480 FIND v(dout1_58) AT=490.05n

.meas tran vdout1_59ck480 FIND v(dout1_59) AT=490.05n

.meas tran vdout1_60ck480 FIND v(dout1_60) AT=490.05n

.meas tran vdout1_61ck480 FIND v(dout1_61) AT=490.05n

.meas tran vdout1_62ck480 FIND v(dout1_62) AT=490.05n

.meas tran vdout1_63ck480 FIND v(dout1_63) AT=490.05n

.meas tran vdout1_64ck480 FIND v(dout1_64) AT=490.05n

.meas tran vdout1_65ck480 FIND v(dout1_65) AT=490.05n

.meas tran vdout1_66ck480 FIND v(dout1_66) AT=490.05n

.meas tran vdout1_67ck480 FIND v(dout1_67) AT=490.05n

.meas tran vdout1_68ck480 FIND v(dout1_68) AT=490.05n

.meas tran vdout1_69ck480 FIND v(dout1_69) AT=490.05n

.meas tran vdout1_70ck480 FIND v(dout1_70) AT=490.05n

.meas tran vdout1_71ck480 FIND v(dout1_71) AT=490.05n

.meas tran vdout1_72ck480 FIND v(dout1_72) AT=490.05n

.meas tran vdout1_73ck480 FIND v(dout1_73) AT=490.05n

.meas tran vdout1_74ck480 FIND v(dout1_74) AT=490.05n

.meas tran vdout1_75ck480 FIND v(dout1_75) AT=490.05n

.meas tran vdout1_76ck480 FIND v(dout1_76) AT=490.05n

.meas tran vdout1_77ck480 FIND v(dout1_77) AT=490.05n

.meas tran vdout1_78ck480 FIND v(dout1_78) AT=490.05n

.meas tran vdout1_79ck480 FIND v(dout1_79) AT=490.05n

.meas tran vdout1_80ck480 FIND v(dout1_80) AT=490.05n

.meas tran vdout1_81ck480 FIND v(dout1_81) AT=490.05n

.meas tran vdout1_82ck480 FIND v(dout1_82) AT=490.05n

.meas tran vdout1_83ck480 FIND v(dout1_83) AT=490.05n

.meas tran vdout1_84ck480 FIND v(dout1_84) AT=490.05n

.meas tran vdout1_85ck480 FIND v(dout1_85) AT=490.05n

.meas tran vdout1_86ck480 FIND v(dout1_86) AT=490.05n

.meas tran vdout1_87ck480 FIND v(dout1_87) AT=490.05n

.meas tran vdout1_88ck480 FIND v(dout1_88) AT=490.05n

.meas tran vdout1_89ck480 FIND v(dout1_89) AT=490.05n

.meas tran vdout1_90ck480 FIND v(dout1_90) AT=490.05n

.meas tran vdout1_91ck480 FIND v(dout1_91) AT=490.05n

.meas tran vdout1_92ck480 FIND v(dout1_92) AT=490.05n

.meas tran vdout1_93ck480 FIND v(dout1_93) AT=490.05n

.meas tran vdout1_94ck480 FIND v(dout1_94) AT=490.05n

.meas tran vdout1_95ck480 FIND v(dout1_95) AT=490.05n

.meas tran vdout1_96ck480 FIND v(dout1_96) AT=490.05n

.meas tran vdout1_97ck480 FIND v(dout1_97) AT=490.05n

.meas tran vdout1_98ck480 FIND v(dout1_98) AT=490.05n

.meas tran vdout1_99ck480 FIND v(dout1_99) AT=490.05n

.meas tran vdout1_100ck480 FIND v(dout1_100) AT=490.05n

.meas tran vdout1_101ck480 FIND v(dout1_101) AT=490.05n

.meas tran vdout1_102ck480 FIND v(dout1_102) AT=490.05n

.meas tran vdout1_103ck480 FIND v(dout1_103) AT=490.05n

.meas tran vdout1_104ck480 FIND v(dout1_104) AT=490.05n

.meas tran vdout1_105ck480 FIND v(dout1_105) AT=490.05n

.meas tran vdout1_106ck480 FIND v(dout1_106) AT=490.05n

.meas tran vdout1_107ck480 FIND v(dout1_107) AT=490.05n

.meas tran vdout1_108ck480 FIND v(dout1_108) AT=490.05n

.meas tran vdout1_109ck480 FIND v(dout1_109) AT=490.05n

.meas tran vdout1_110ck480 FIND v(dout1_110) AT=490.05n

.meas tran vdout1_111ck480 FIND v(dout1_111) AT=490.05n

.meas tran vdout1_112ck480 FIND v(dout1_112) AT=490.05n

.meas tran vdout1_113ck480 FIND v(dout1_113) AT=490.05n

.meas tran vdout1_114ck480 FIND v(dout1_114) AT=490.05n

.meas tran vdout1_115ck480 FIND v(dout1_115) AT=490.05n

.meas tran vdout1_116ck480 FIND v(dout1_116) AT=490.05n

.meas tran vdout1_117ck480 FIND v(dout1_117) AT=490.05n

.meas tran vdout1_118ck480 FIND v(dout1_118) AT=490.05n

.meas tran vdout1_119ck480 FIND v(dout1_119) AT=490.05n

.meas tran vdout1_120ck480 FIND v(dout1_120) AT=490.05n

.meas tran vdout1_121ck480 FIND v(dout1_121) AT=490.05n

.meas tran vdout1_122ck480 FIND v(dout1_122) AT=490.05n

.meas tran vdout1_123ck480 FIND v(dout1_123) AT=490.05n

.meas tran vdout1_124ck480 FIND v(dout1_124) AT=490.05n

.meas tran vdout1_125ck480 FIND v(dout1_125) AT=490.05n

.meas tran vdout1_126ck480 FIND v(dout1_126) AT=490.05n

.meas tran vdout1_127ck480 FIND v(dout1_127) AT=490.05n

.meas tran vdout1_128ck480 FIND v(dout1_128) AT=490.05n

.meas tran vdout1_129ck480 FIND v(dout1_129) AT=490.05n

.meas tran vdout1_130ck480 FIND v(dout1_130) AT=490.05n

.meas tran vdout1_131ck480 FIND v(dout1_131) AT=490.05n

.meas tran vdout1_132ck480 FIND v(dout1_132) AT=490.05n

.meas tran vdout1_133ck480 FIND v(dout1_133) AT=490.05n

.meas tran vdout1_134ck480 FIND v(dout1_134) AT=490.05n

.meas tran vdout1_0ck490 FIND v(dout1_0) AT=500.05n

.meas tran vdout1_1ck490 FIND v(dout1_1) AT=500.05n

.meas tran vdout1_2ck490 FIND v(dout1_2) AT=500.05n

.meas tran vdout1_3ck490 FIND v(dout1_3) AT=500.05n

.meas tran vdout1_4ck490 FIND v(dout1_4) AT=500.05n

.meas tran vdout1_5ck490 FIND v(dout1_5) AT=500.05n

.meas tran vdout1_6ck490 FIND v(dout1_6) AT=500.05n

.meas tran vdout1_7ck490 FIND v(dout1_7) AT=500.05n

.meas tran vdout1_8ck490 FIND v(dout1_8) AT=500.05n

.meas tran vdout1_9ck490 FIND v(dout1_9) AT=500.05n

.meas tran vdout1_10ck490 FIND v(dout1_10) AT=500.05n

.meas tran vdout1_11ck490 FIND v(dout1_11) AT=500.05n

.meas tran vdout1_12ck490 FIND v(dout1_12) AT=500.05n

.meas tran vdout1_13ck490 FIND v(dout1_13) AT=500.05n

.meas tran vdout1_14ck490 FIND v(dout1_14) AT=500.05n

.meas tran vdout1_15ck490 FIND v(dout1_15) AT=500.05n

.meas tran vdout1_16ck490 FIND v(dout1_16) AT=500.05n

.meas tran vdout1_17ck490 FIND v(dout1_17) AT=500.05n

.meas tran vdout1_18ck490 FIND v(dout1_18) AT=500.05n

.meas tran vdout1_19ck490 FIND v(dout1_19) AT=500.05n

.meas tran vdout1_20ck490 FIND v(dout1_20) AT=500.05n

.meas tran vdout1_21ck490 FIND v(dout1_21) AT=500.05n

.meas tran vdout1_22ck490 FIND v(dout1_22) AT=500.05n

.meas tran vdout1_23ck490 FIND v(dout1_23) AT=500.05n

.meas tran vdout1_24ck490 FIND v(dout1_24) AT=500.05n

.meas tran vdout1_25ck490 FIND v(dout1_25) AT=500.05n

.meas tran vdout1_26ck490 FIND v(dout1_26) AT=500.05n

.meas tran vdout1_27ck490 FIND v(dout1_27) AT=500.05n

.meas tran vdout1_28ck490 FIND v(dout1_28) AT=500.05n

.meas tran vdout1_29ck490 FIND v(dout1_29) AT=500.05n

.meas tran vdout1_30ck490 FIND v(dout1_30) AT=500.05n

.meas tran vdout1_31ck490 FIND v(dout1_31) AT=500.05n

.meas tran vdout1_32ck490 FIND v(dout1_32) AT=500.05n

.meas tran vdout1_33ck490 FIND v(dout1_33) AT=500.05n

.meas tran vdout1_34ck490 FIND v(dout1_34) AT=500.05n

.meas tran vdout1_35ck490 FIND v(dout1_35) AT=500.05n

.meas tran vdout1_36ck490 FIND v(dout1_36) AT=500.05n

.meas tran vdout1_37ck490 FIND v(dout1_37) AT=500.05n

.meas tran vdout1_38ck490 FIND v(dout1_38) AT=500.05n

.meas tran vdout1_39ck490 FIND v(dout1_39) AT=500.05n

.meas tran vdout1_40ck490 FIND v(dout1_40) AT=500.05n

.meas tran vdout1_41ck490 FIND v(dout1_41) AT=500.05n

.meas tran vdout1_42ck490 FIND v(dout1_42) AT=500.05n

.meas tran vdout1_43ck490 FIND v(dout1_43) AT=500.05n

.meas tran vdout1_44ck490 FIND v(dout1_44) AT=500.05n

.meas tran vdout1_45ck490 FIND v(dout1_45) AT=500.05n

.meas tran vdout1_46ck490 FIND v(dout1_46) AT=500.05n

.meas tran vdout1_47ck490 FIND v(dout1_47) AT=500.05n

.meas tran vdout1_48ck490 FIND v(dout1_48) AT=500.05n

.meas tran vdout1_49ck490 FIND v(dout1_49) AT=500.05n

.meas tran vdout1_50ck490 FIND v(dout1_50) AT=500.05n

.meas tran vdout1_51ck490 FIND v(dout1_51) AT=500.05n

.meas tran vdout1_52ck490 FIND v(dout1_52) AT=500.05n

.meas tran vdout1_53ck490 FIND v(dout1_53) AT=500.05n

.meas tran vdout1_54ck490 FIND v(dout1_54) AT=500.05n

.meas tran vdout1_55ck490 FIND v(dout1_55) AT=500.05n

.meas tran vdout1_56ck490 FIND v(dout1_56) AT=500.05n

.meas tran vdout1_57ck490 FIND v(dout1_57) AT=500.05n

.meas tran vdout1_58ck490 FIND v(dout1_58) AT=500.05n

.meas tran vdout1_59ck490 FIND v(dout1_59) AT=500.05n

.meas tran vdout1_60ck490 FIND v(dout1_60) AT=500.05n

.meas tran vdout1_61ck490 FIND v(dout1_61) AT=500.05n

.meas tran vdout1_62ck490 FIND v(dout1_62) AT=500.05n

.meas tran vdout1_63ck490 FIND v(dout1_63) AT=500.05n

.meas tran vdout1_64ck490 FIND v(dout1_64) AT=500.05n

.meas tran vdout1_65ck490 FIND v(dout1_65) AT=500.05n

.meas tran vdout1_66ck490 FIND v(dout1_66) AT=500.05n

.meas tran vdout1_67ck490 FIND v(dout1_67) AT=500.05n

.meas tran vdout1_68ck490 FIND v(dout1_68) AT=500.05n

.meas tran vdout1_69ck490 FIND v(dout1_69) AT=500.05n

.meas tran vdout1_70ck490 FIND v(dout1_70) AT=500.05n

.meas tran vdout1_71ck490 FIND v(dout1_71) AT=500.05n

.meas tran vdout1_72ck490 FIND v(dout1_72) AT=500.05n

.meas tran vdout1_73ck490 FIND v(dout1_73) AT=500.05n

.meas tran vdout1_74ck490 FIND v(dout1_74) AT=500.05n

.meas tran vdout1_75ck490 FIND v(dout1_75) AT=500.05n

.meas tran vdout1_76ck490 FIND v(dout1_76) AT=500.05n

.meas tran vdout1_77ck490 FIND v(dout1_77) AT=500.05n

.meas tran vdout1_78ck490 FIND v(dout1_78) AT=500.05n

.meas tran vdout1_79ck490 FIND v(dout1_79) AT=500.05n

.meas tran vdout1_80ck490 FIND v(dout1_80) AT=500.05n

.meas tran vdout1_81ck490 FIND v(dout1_81) AT=500.05n

.meas tran vdout1_82ck490 FIND v(dout1_82) AT=500.05n

.meas tran vdout1_83ck490 FIND v(dout1_83) AT=500.05n

.meas tran vdout1_84ck490 FIND v(dout1_84) AT=500.05n

.meas tran vdout1_85ck490 FIND v(dout1_85) AT=500.05n

.meas tran vdout1_86ck490 FIND v(dout1_86) AT=500.05n

.meas tran vdout1_87ck490 FIND v(dout1_87) AT=500.05n

.meas tran vdout1_88ck490 FIND v(dout1_88) AT=500.05n

.meas tran vdout1_89ck490 FIND v(dout1_89) AT=500.05n

.meas tran vdout1_90ck490 FIND v(dout1_90) AT=500.05n

.meas tran vdout1_91ck490 FIND v(dout1_91) AT=500.05n

.meas tran vdout1_92ck490 FIND v(dout1_92) AT=500.05n

.meas tran vdout1_93ck490 FIND v(dout1_93) AT=500.05n

.meas tran vdout1_94ck490 FIND v(dout1_94) AT=500.05n

.meas tran vdout1_95ck490 FIND v(dout1_95) AT=500.05n

.meas tran vdout1_96ck490 FIND v(dout1_96) AT=500.05n

.meas tran vdout1_97ck490 FIND v(dout1_97) AT=500.05n

.meas tran vdout1_98ck490 FIND v(dout1_98) AT=500.05n

.meas tran vdout1_99ck490 FIND v(dout1_99) AT=500.05n

.meas tran vdout1_100ck490 FIND v(dout1_100) AT=500.05n

.meas tran vdout1_101ck490 FIND v(dout1_101) AT=500.05n

.meas tran vdout1_102ck490 FIND v(dout1_102) AT=500.05n

.meas tran vdout1_103ck490 FIND v(dout1_103) AT=500.05n

.meas tran vdout1_104ck490 FIND v(dout1_104) AT=500.05n

.meas tran vdout1_105ck490 FIND v(dout1_105) AT=500.05n

.meas tran vdout1_106ck490 FIND v(dout1_106) AT=500.05n

.meas tran vdout1_107ck490 FIND v(dout1_107) AT=500.05n

.meas tran vdout1_108ck490 FIND v(dout1_108) AT=500.05n

.meas tran vdout1_109ck490 FIND v(dout1_109) AT=500.05n

.meas tran vdout1_110ck490 FIND v(dout1_110) AT=500.05n

.meas tran vdout1_111ck490 FIND v(dout1_111) AT=500.05n

.meas tran vdout1_112ck490 FIND v(dout1_112) AT=500.05n

.meas tran vdout1_113ck490 FIND v(dout1_113) AT=500.05n

.meas tran vdout1_114ck490 FIND v(dout1_114) AT=500.05n

.meas tran vdout1_115ck490 FIND v(dout1_115) AT=500.05n

.meas tran vdout1_116ck490 FIND v(dout1_116) AT=500.05n

.meas tran vdout1_117ck490 FIND v(dout1_117) AT=500.05n

.meas tran vdout1_118ck490 FIND v(dout1_118) AT=500.05n

.meas tran vdout1_119ck490 FIND v(dout1_119) AT=500.05n

.meas tran vdout1_120ck490 FIND v(dout1_120) AT=500.05n

.meas tran vdout1_121ck490 FIND v(dout1_121) AT=500.05n

.meas tran vdout1_122ck490 FIND v(dout1_122) AT=500.05n

.meas tran vdout1_123ck490 FIND v(dout1_123) AT=500.05n

.meas tran vdout1_124ck490 FIND v(dout1_124) AT=500.05n

.meas tran vdout1_125ck490 FIND v(dout1_125) AT=500.05n

.meas tran vdout1_126ck490 FIND v(dout1_126) AT=500.05n

.meas tran vdout1_127ck490 FIND v(dout1_127) AT=500.05n

.meas tran vdout1_128ck490 FIND v(dout1_128) AT=500.05n

.meas tran vdout1_129ck490 FIND v(dout1_129) AT=500.05n

.meas tran vdout1_130ck490 FIND v(dout1_130) AT=500.05n

.meas tran vdout1_131ck490 FIND v(dout1_131) AT=500.05n

.meas tran vdout1_132ck490 FIND v(dout1_132) AT=500.05n

.meas tran vdout1_133ck490 FIND v(dout1_133) AT=500.05n

.meas tran vdout1_134ck490 FIND v(dout1_134) AT=500.05n

.meas tran vdout1_0ck500 FIND v(dout1_0) AT=510.05n

.meas tran vdout1_1ck500 FIND v(dout1_1) AT=510.05n

.meas tran vdout1_2ck500 FIND v(dout1_2) AT=510.05n

.meas tran vdout1_3ck500 FIND v(dout1_3) AT=510.05n

.meas tran vdout1_4ck500 FIND v(dout1_4) AT=510.05n

.meas tran vdout1_5ck500 FIND v(dout1_5) AT=510.05n

.meas tran vdout1_6ck500 FIND v(dout1_6) AT=510.05n

.meas tran vdout1_7ck500 FIND v(dout1_7) AT=510.05n

.meas tran vdout1_8ck500 FIND v(dout1_8) AT=510.05n

.meas tran vdout1_9ck500 FIND v(dout1_9) AT=510.05n

.meas tran vdout1_10ck500 FIND v(dout1_10) AT=510.05n

.meas tran vdout1_11ck500 FIND v(dout1_11) AT=510.05n

.meas tran vdout1_12ck500 FIND v(dout1_12) AT=510.05n

.meas tran vdout1_13ck500 FIND v(dout1_13) AT=510.05n

.meas tran vdout1_14ck500 FIND v(dout1_14) AT=510.05n

.meas tran vdout1_15ck500 FIND v(dout1_15) AT=510.05n

.meas tran vdout1_16ck500 FIND v(dout1_16) AT=510.05n

.meas tran vdout1_17ck500 FIND v(dout1_17) AT=510.05n

.meas tran vdout1_18ck500 FIND v(dout1_18) AT=510.05n

.meas tran vdout1_19ck500 FIND v(dout1_19) AT=510.05n

.meas tran vdout1_20ck500 FIND v(dout1_20) AT=510.05n

.meas tran vdout1_21ck500 FIND v(dout1_21) AT=510.05n

.meas tran vdout1_22ck500 FIND v(dout1_22) AT=510.05n

.meas tran vdout1_23ck500 FIND v(dout1_23) AT=510.05n

.meas tran vdout1_24ck500 FIND v(dout1_24) AT=510.05n

.meas tran vdout1_25ck500 FIND v(dout1_25) AT=510.05n

.meas tran vdout1_26ck500 FIND v(dout1_26) AT=510.05n

.meas tran vdout1_27ck500 FIND v(dout1_27) AT=510.05n

.meas tran vdout1_28ck500 FIND v(dout1_28) AT=510.05n

.meas tran vdout1_29ck500 FIND v(dout1_29) AT=510.05n

.meas tran vdout1_30ck500 FIND v(dout1_30) AT=510.05n

.meas tran vdout1_31ck500 FIND v(dout1_31) AT=510.05n

.meas tran vdout1_32ck500 FIND v(dout1_32) AT=510.05n

.meas tran vdout1_33ck500 FIND v(dout1_33) AT=510.05n

.meas tran vdout1_34ck500 FIND v(dout1_34) AT=510.05n

.meas tran vdout1_35ck500 FIND v(dout1_35) AT=510.05n

.meas tran vdout1_36ck500 FIND v(dout1_36) AT=510.05n

.meas tran vdout1_37ck500 FIND v(dout1_37) AT=510.05n

.meas tran vdout1_38ck500 FIND v(dout1_38) AT=510.05n

.meas tran vdout1_39ck500 FIND v(dout1_39) AT=510.05n

.meas tran vdout1_40ck500 FIND v(dout1_40) AT=510.05n

.meas tran vdout1_41ck500 FIND v(dout1_41) AT=510.05n

.meas tran vdout1_42ck500 FIND v(dout1_42) AT=510.05n

.meas tran vdout1_43ck500 FIND v(dout1_43) AT=510.05n

.meas tran vdout1_44ck500 FIND v(dout1_44) AT=510.05n

.meas tran vdout1_45ck500 FIND v(dout1_45) AT=510.05n

.meas tran vdout1_46ck500 FIND v(dout1_46) AT=510.05n

.meas tran vdout1_47ck500 FIND v(dout1_47) AT=510.05n

.meas tran vdout1_48ck500 FIND v(dout1_48) AT=510.05n

.meas tran vdout1_49ck500 FIND v(dout1_49) AT=510.05n

.meas tran vdout1_50ck500 FIND v(dout1_50) AT=510.05n

.meas tran vdout1_51ck500 FIND v(dout1_51) AT=510.05n

.meas tran vdout1_52ck500 FIND v(dout1_52) AT=510.05n

.meas tran vdout1_53ck500 FIND v(dout1_53) AT=510.05n

.meas tran vdout1_54ck500 FIND v(dout1_54) AT=510.05n

.meas tran vdout1_55ck500 FIND v(dout1_55) AT=510.05n

.meas tran vdout1_56ck500 FIND v(dout1_56) AT=510.05n

.meas tran vdout1_57ck500 FIND v(dout1_57) AT=510.05n

.meas tran vdout1_58ck500 FIND v(dout1_58) AT=510.05n

.meas tran vdout1_59ck500 FIND v(dout1_59) AT=510.05n

.meas tran vdout1_60ck500 FIND v(dout1_60) AT=510.05n

.meas tran vdout1_61ck500 FIND v(dout1_61) AT=510.05n

.meas tran vdout1_62ck500 FIND v(dout1_62) AT=510.05n

.meas tran vdout1_63ck500 FIND v(dout1_63) AT=510.05n

.meas tran vdout1_64ck500 FIND v(dout1_64) AT=510.05n

.meas tran vdout1_65ck500 FIND v(dout1_65) AT=510.05n

.meas tran vdout1_66ck500 FIND v(dout1_66) AT=510.05n

.meas tran vdout1_67ck500 FIND v(dout1_67) AT=510.05n

.meas tran vdout1_68ck500 FIND v(dout1_68) AT=510.05n

.meas tran vdout1_69ck500 FIND v(dout1_69) AT=510.05n

.meas tran vdout1_70ck500 FIND v(dout1_70) AT=510.05n

.meas tran vdout1_71ck500 FIND v(dout1_71) AT=510.05n

.meas tran vdout1_72ck500 FIND v(dout1_72) AT=510.05n

.meas tran vdout1_73ck500 FIND v(dout1_73) AT=510.05n

.meas tran vdout1_74ck500 FIND v(dout1_74) AT=510.05n

.meas tran vdout1_75ck500 FIND v(dout1_75) AT=510.05n

.meas tran vdout1_76ck500 FIND v(dout1_76) AT=510.05n

.meas tran vdout1_77ck500 FIND v(dout1_77) AT=510.05n

.meas tran vdout1_78ck500 FIND v(dout1_78) AT=510.05n

.meas tran vdout1_79ck500 FIND v(dout1_79) AT=510.05n

.meas tran vdout1_80ck500 FIND v(dout1_80) AT=510.05n

.meas tran vdout1_81ck500 FIND v(dout1_81) AT=510.05n

.meas tran vdout1_82ck500 FIND v(dout1_82) AT=510.05n

.meas tran vdout1_83ck500 FIND v(dout1_83) AT=510.05n

.meas tran vdout1_84ck500 FIND v(dout1_84) AT=510.05n

.meas tran vdout1_85ck500 FIND v(dout1_85) AT=510.05n

.meas tran vdout1_86ck500 FIND v(dout1_86) AT=510.05n

.meas tran vdout1_87ck500 FIND v(dout1_87) AT=510.05n

.meas tran vdout1_88ck500 FIND v(dout1_88) AT=510.05n

.meas tran vdout1_89ck500 FIND v(dout1_89) AT=510.05n

.meas tran vdout1_90ck500 FIND v(dout1_90) AT=510.05n

.meas tran vdout1_91ck500 FIND v(dout1_91) AT=510.05n

.meas tran vdout1_92ck500 FIND v(dout1_92) AT=510.05n

.meas tran vdout1_93ck500 FIND v(dout1_93) AT=510.05n

.meas tran vdout1_94ck500 FIND v(dout1_94) AT=510.05n

.meas tran vdout1_95ck500 FIND v(dout1_95) AT=510.05n

.meas tran vdout1_96ck500 FIND v(dout1_96) AT=510.05n

.meas tran vdout1_97ck500 FIND v(dout1_97) AT=510.05n

.meas tran vdout1_98ck500 FIND v(dout1_98) AT=510.05n

.meas tran vdout1_99ck500 FIND v(dout1_99) AT=510.05n

.meas tran vdout1_100ck500 FIND v(dout1_100) AT=510.05n

.meas tran vdout1_101ck500 FIND v(dout1_101) AT=510.05n

.meas tran vdout1_102ck500 FIND v(dout1_102) AT=510.05n

.meas tran vdout1_103ck500 FIND v(dout1_103) AT=510.05n

.meas tran vdout1_104ck500 FIND v(dout1_104) AT=510.05n

.meas tran vdout1_105ck500 FIND v(dout1_105) AT=510.05n

.meas tran vdout1_106ck500 FIND v(dout1_106) AT=510.05n

.meas tran vdout1_107ck500 FIND v(dout1_107) AT=510.05n

.meas tran vdout1_108ck500 FIND v(dout1_108) AT=510.05n

.meas tran vdout1_109ck500 FIND v(dout1_109) AT=510.05n

.meas tran vdout1_110ck500 FIND v(dout1_110) AT=510.05n

.meas tran vdout1_111ck500 FIND v(dout1_111) AT=510.05n

.meas tran vdout1_112ck500 FIND v(dout1_112) AT=510.05n

.meas tran vdout1_113ck500 FIND v(dout1_113) AT=510.05n

.meas tran vdout1_114ck500 FIND v(dout1_114) AT=510.05n

.meas tran vdout1_115ck500 FIND v(dout1_115) AT=510.05n

.meas tran vdout1_116ck500 FIND v(dout1_116) AT=510.05n

.meas tran vdout1_117ck500 FIND v(dout1_117) AT=510.05n

.meas tran vdout1_118ck500 FIND v(dout1_118) AT=510.05n

.meas tran vdout1_119ck500 FIND v(dout1_119) AT=510.05n

.meas tran vdout1_120ck500 FIND v(dout1_120) AT=510.05n

.meas tran vdout1_121ck500 FIND v(dout1_121) AT=510.05n

.meas tran vdout1_122ck500 FIND v(dout1_122) AT=510.05n

.meas tran vdout1_123ck500 FIND v(dout1_123) AT=510.05n

.meas tran vdout1_124ck500 FIND v(dout1_124) AT=510.05n

.meas tran vdout1_125ck500 FIND v(dout1_125) AT=510.05n

.meas tran vdout1_126ck500 FIND v(dout1_126) AT=510.05n

.meas tran vdout1_127ck500 FIND v(dout1_127) AT=510.05n

.meas tran vdout1_128ck500 FIND v(dout1_128) AT=510.05n

.meas tran vdout1_129ck500 FIND v(dout1_129) AT=510.05n

.meas tran vdout1_130ck500 FIND v(dout1_130) AT=510.05n

.meas tran vdout1_131ck500 FIND v(dout1_131) AT=510.05n

.meas tran vdout1_132ck500 FIND v(dout1_132) AT=510.05n

.meas tran vdout1_133ck500 FIND v(dout1_133) AT=510.05n

.meas tran vdout1_134ck500 FIND v(dout1_134) AT=510.05n

.meas tran vdout1_0ck540 FIND v(dout1_0) AT=550.05n

.meas tran vdout1_1ck540 FIND v(dout1_1) AT=550.05n

.meas tran vdout1_2ck540 FIND v(dout1_2) AT=550.05n

.meas tran vdout1_3ck540 FIND v(dout1_3) AT=550.05n

.meas tran vdout1_4ck540 FIND v(dout1_4) AT=550.05n

.meas tran vdout1_5ck540 FIND v(dout1_5) AT=550.05n

.meas tran vdout1_6ck540 FIND v(dout1_6) AT=550.05n

.meas tran vdout1_7ck540 FIND v(dout1_7) AT=550.05n

.meas tran vdout1_8ck540 FIND v(dout1_8) AT=550.05n

.meas tran vdout1_9ck540 FIND v(dout1_9) AT=550.05n

.meas tran vdout1_10ck540 FIND v(dout1_10) AT=550.05n

.meas tran vdout1_11ck540 FIND v(dout1_11) AT=550.05n

.meas tran vdout1_12ck540 FIND v(dout1_12) AT=550.05n

.meas tran vdout1_13ck540 FIND v(dout1_13) AT=550.05n

.meas tran vdout1_14ck540 FIND v(dout1_14) AT=550.05n

.meas tran vdout1_15ck540 FIND v(dout1_15) AT=550.05n

.meas tran vdout1_16ck540 FIND v(dout1_16) AT=550.05n

.meas tran vdout1_17ck540 FIND v(dout1_17) AT=550.05n

.meas tran vdout1_18ck540 FIND v(dout1_18) AT=550.05n

.meas tran vdout1_19ck540 FIND v(dout1_19) AT=550.05n

.meas tran vdout1_20ck540 FIND v(dout1_20) AT=550.05n

.meas tran vdout1_21ck540 FIND v(dout1_21) AT=550.05n

.meas tran vdout1_22ck540 FIND v(dout1_22) AT=550.05n

.meas tran vdout1_23ck540 FIND v(dout1_23) AT=550.05n

.meas tran vdout1_24ck540 FIND v(dout1_24) AT=550.05n

.meas tran vdout1_25ck540 FIND v(dout1_25) AT=550.05n

.meas tran vdout1_26ck540 FIND v(dout1_26) AT=550.05n

.meas tran vdout1_27ck540 FIND v(dout1_27) AT=550.05n

.meas tran vdout1_28ck540 FIND v(dout1_28) AT=550.05n

.meas tran vdout1_29ck540 FIND v(dout1_29) AT=550.05n

.meas tran vdout1_30ck540 FIND v(dout1_30) AT=550.05n

.meas tran vdout1_31ck540 FIND v(dout1_31) AT=550.05n

.meas tran vdout1_32ck540 FIND v(dout1_32) AT=550.05n

.meas tran vdout1_33ck540 FIND v(dout1_33) AT=550.05n

.meas tran vdout1_34ck540 FIND v(dout1_34) AT=550.05n

.meas tran vdout1_35ck540 FIND v(dout1_35) AT=550.05n

.meas tran vdout1_36ck540 FIND v(dout1_36) AT=550.05n

.meas tran vdout1_37ck540 FIND v(dout1_37) AT=550.05n

.meas tran vdout1_38ck540 FIND v(dout1_38) AT=550.05n

.meas tran vdout1_39ck540 FIND v(dout1_39) AT=550.05n

.meas tran vdout1_40ck540 FIND v(dout1_40) AT=550.05n

.meas tran vdout1_41ck540 FIND v(dout1_41) AT=550.05n

.meas tran vdout1_42ck540 FIND v(dout1_42) AT=550.05n

.meas tran vdout1_43ck540 FIND v(dout1_43) AT=550.05n

.meas tran vdout1_44ck540 FIND v(dout1_44) AT=550.05n

.meas tran vdout1_45ck540 FIND v(dout1_45) AT=550.05n

.meas tran vdout1_46ck540 FIND v(dout1_46) AT=550.05n

.meas tran vdout1_47ck540 FIND v(dout1_47) AT=550.05n

.meas tran vdout1_48ck540 FIND v(dout1_48) AT=550.05n

.meas tran vdout1_49ck540 FIND v(dout1_49) AT=550.05n

.meas tran vdout1_50ck540 FIND v(dout1_50) AT=550.05n

.meas tran vdout1_51ck540 FIND v(dout1_51) AT=550.05n

.meas tran vdout1_52ck540 FIND v(dout1_52) AT=550.05n

.meas tran vdout1_53ck540 FIND v(dout1_53) AT=550.05n

.meas tran vdout1_54ck540 FIND v(dout1_54) AT=550.05n

.meas tran vdout1_55ck540 FIND v(dout1_55) AT=550.05n

.meas tran vdout1_56ck540 FIND v(dout1_56) AT=550.05n

.meas tran vdout1_57ck540 FIND v(dout1_57) AT=550.05n

.meas tran vdout1_58ck540 FIND v(dout1_58) AT=550.05n

.meas tran vdout1_59ck540 FIND v(dout1_59) AT=550.05n

.meas tran vdout1_60ck540 FIND v(dout1_60) AT=550.05n

.meas tran vdout1_61ck540 FIND v(dout1_61) AT=550.05n

.meas tran vdout1_62ck540 FIND v(dout1_62) AT=550.05n

.meas tran vdout1_63ck540 FIND v(dout1_63) AT=550.05n

.meas tran vdout1_64ck540 FIND v(dout1_64) AT=550.05n

.meas tran vdout1_65ck540 FIND v(dout1_65) AT=550.05n

.meas tran vdout1_66ck540 FIND v(dout1_66) AT=550.05n

.meas tran vdout1_67ck540 FIND v(dout1_67) AT=550.05n

.meas tran vdout1_68ck540 FIND v(dout1_68) AT=550.05n

.meas tran vdout1_69ck540 FIND v(dout1_69) AT=550.05n

.meas tran vdout1_70ck540 FIND v(dout1_70) AT=550.05n

.meas tran vdout1_71ck540 FIND v(dout1_71) AT=550.05n

.meas tran vdout1_72ck540 FIND v(dout1_72) AT=550.05n

.meas tran vdout1_73ck540 FIND v(dout1_73) AT=550.05n

.meas tran vdout1_74ck540 FIND v(dout1_74) AT=550.05n

.meas tran vdout1_75ck540 FIND v(dout1_75) AT=550.05n

.meas tran vdout1_76ck540 FIND v(dout1_76) AT=550.05n

.meas tran vdout1_77ck540 FIND v(dout1_77) AT=550.05n

.meas tran vdout1_78ck540 FIND v(dout1_78) AT=550.05n

.meas tran vdout1_79ck540 FIND v(dout1_79) AT=550.05n

.meas tran vdout1_80ck540 FIND v(dout1_80) AT=550.05n

.meas tran vdout1_81ck540 FIND v(dout1_81) AT=550.05n

.meas tran vdout1_82ck540 FIND v(dout1_82) AT=550.05n

.meas tran vdout1_83ck540 FIND v(dout1_83) AT=550.05n

.meas tran vdout1_84ck540 FIND v(dout1_84) AT=550.05n

.meas tran vdout1_85ck540 FIND v(dout1_85) AT=550.05n

.meas tran vdout1_86ck540 FIND v(dout1_86) AT=550.05n

.meas tran vdout1_87ck540 FIND v(dout1_87) AT=550.05n

.meas tran vdout1_88ck540 FIND v(dout1_88) AT=550.05n

.meas tran vdout1_89ck540 FIND v(dout1_89) AT=550.05n

.meas tran vdout1_90ck540 FIND v(dout1_90) AT=550.05n

.meas tran vdout1_91ck540 FIND v(dout1_91) AT=550.05n

.meas tran vdout1_92ck540 FIND v(dout1_92) AT=550.05n

.meas tran vdout1_93ck540 FIND v(dout1_93) AT=550.05n

.meas tran vdout1_94ck540 FIND v(dout1_94) AT=550.05n

.meas tran vdout1_95ck540 FIND v(dout1_95) AT=550.05n

.meas tran vdout1_96ck540 FIND v(dout1_96) AT=550.05n

.meas tran vdout1_97ck540 FIND v(dout1_97) AT=550.05n

.meas tran vdout1_98ck540 FIND v(dout1_98) AT=550.05n

.meas tran vdout1_99ck540 FIND v(dout1_99) AT=550.05n

.meas tran vdout1_100ck540 FIND v(dout1_100) AT=550.05n

.meas tran vdout1_101ck540 FIND v(dout1_101) AT=550.05n

.meas tran vdout1_102ck540 FIND v(dout1_102) AT=550.05n

.meas tran vdout1_103ck540 FIND v(dout1_103) AT=550.05n

.meas tran vdout1_104ck540 FIND v(dout1_104) AT=550.05n

.meas tran vdout1_105ck540 FIND v(dout1_105) AT=550.05n

.meas tran vdout1_106ck540 FIND v(dout1_106) AT=550.05n

.meas tran vdout1_107ck540 FIND v(dout1_107) AT=550.05n

.meas tran vdout1_108ck540 FIND v(dout1_108) AT=550.05n

.meas tran vdout1_109ck540 FIND v(dout1_109) AT=550.05n

.meas tran vdout1_110ck540 FIND v(dout1_110) AT=550.05n

.meas tran vdout1_111ck540 FIND v(dout1_111) AT=550.05n

.meas tran vdout1_112ck540 FIND v(dout1_112) AT=550.05n

.meas tran vdout1_113ck540 FIND v(dout1_113) AT=550.05n

.meas tran vdout1_114ck540 FIND v(dout1_114) AT=550.05n

.meas tran vdout1_115ck540 FIND v(dout1_115) AT=550.05n

.meas tran vdout1_116ck540 FIND v(dout1_116) AT=550.05n

.meas tran vdout1_117ck540 FIND v(dout1_117) AT=550.05n

.meas tran vdout1_118ck540 FIND v(dout1_118) AT=550.05n

.meas tran vdout1_119ck540 FIND v(dout1_119) AT=550.05n

.meas tran vdout1_120ck540 FIND v(dout1_120) AT=550.05n

.meas tran vdout1_121ck540 FIND v(dout1_121) AT=550.05n

.meas tran vdout1_122ck540 FIND v(dout1_122) AT=550.05n

.meas tran vdout1_123ck540 FIND v(dout1_123) AT=550.05n

.meas tran vdout1_124ck540 FIND v(dout1_124) AT=550.05n

.meas tran vdout1_125ck540 FIND v(dout1_125) AT=550.05n

.meas tran vdout1_126ck540 FIND v(dout1_126) AT=550.05n

.meas tran vdout1_127ck540 FIND v(dout1_127) AT=550.05n

.meas tran vdout1_128ck540 FIND v(dout1_128) AT=550.05n

.meas tran vdout1_129ck540 FIND v(dout1_129) AT=550.05n

.meas tran vdout1_130ck540 FIND v(dout1_130) AT=550.05n

.meas tran vdout1_131ck540 FIND v(dout1_131) AT=550.05n

.meas tran vdout1_132ck540 FIND v(dout1_132) AT=550.05n

.meas tran vdout1_133ck540 FIND v(dout1_133) AT=550.05n

.meas tran vdout1_134ck540 FIND v(dout1_134) AT=550.05n

.meas tran vdout1_0ck570 FIND v(dout1_0) AT=580.05n

.meas tran vdout1_1ck570 FIND v(dout1_1) AT=580.05n

.meas tran vdout1_2ck570 FIND v(dout1_2) AT=580.05n

.meas tran vdout1_3ck570 FIND v(dout1_3) AT=580.05n

.meas tran vdout1_4ck570 FIND v(dout1_4) AT=580.05n

.meas tran vdout1_5ck570 FIND v(dout1_5) AT=580.05n

.meas tran vdout1_6ck570 FIND v(dout1_6) AT=580.05n

.meas tran vdout1_7ck570 FIND v(dout1_7) AT=580.05n

.meas tran vdout1_8ck570 FIND v(dout1_8) AT=580.05n

.meas tran vdout1_9ck570 FIND v(dout1_9) AT=580.05n

.meas tran vdout1_10ck570 FIND v(dout1_10) AT=580.05n

.meas tran vdout1_11ck570 FIND v(dout1_11) AT=580.05n

.meas tran vdout1_12ck570 FIND v(dout1_12) AT=580.05n

.meas tran vdout1_13ck570 FIND v(dout1_13) AT=580.05n

.meas tran vdout1_14ck570 FIND v(dout1_14) AT=580.05n

.meas tran vdout1_15ck570 FIND v(dout1_15) AT=580.05n

.meas tran vdout1_16ck570 FIND v(dout1_16) AT=580.05n

.meas tran vdout1_17ck570 FIND v(dout1_17) AT=580.05n

.meas tran vdout1_18ck570 FIND v(dout1_18) AT=580.05n

.meas tran vdout1_19ck570 FIND v(dout1_19) AT=580.05n

.meas tran vdout1_20ck570 FIND v(dout1_20) AT=580.05n

.meas tran vdout1_21ck570 FIND v(dout1_21) AT=580.05n

.meas tran vdout1_22ck570 FIND v(dout1_22) AT=580.05n

.meas tran vdout1_23ck570 FIND v(dout1_23) AT=580.05n

.meas tran vdout1_24ck570 FIND v(dout1_24) AT=580.05n

.meas tran vdout1_25ck570 FIND v(dout1_25) AT=580.05n

.meas tran vdout1_26ck570 FIND v(dout1_26) AT=580.05n

.meas tran vdout1_27ck570 FIND v(dout1_27) AT=580.05n

.meas tran vdout1_28ck570 FIND v(dout1_28) AT=580.05n

.meas tran vdout1_29ck570 FIND v(dout1_29) AT=580.05n

.meas tran vdout1_30ck570 FIND v(dout1_30) AT=580.05n

.meas tran vdout1_31ck570 FIND v(dout1_31) AT=580.05n

.meas tran vdout1_32ck570 FIND v(dout1_32) AT=580.05n

.meas tran vdout1_33ck570 FIND v(dout1_33) AT=580.05n

.meas tran vdout1_34ck570 FIND v(dout1_34) AT=580.05n

.meas tran vdout1_35ck570 FIND v(dout1_35) AT=580.05n

.meas tran vdout1_36ck570 FIND v(dout1_36) AT=580.05n

.meas tran vdout1_37ck570 FIND v(dout1_37) AT=580.05n

.meas tran vdout1_38ck570 FIND v(dout1_38) AT=580.05n

.meas tran vdout1_39ck570 FIND v(dout1_39) AT=580.05n

.meas tran vdout1_40ck570 FIND v(dout1_40) AT=580.05n

.meas tran vdout1_41ck570 FIND v(dout1_41) AT=580.05n

.meas tran vdout1_42ck570 FIND v(dout1_42) AT=580.05n

.meas tran vdout1_43ck570 FIND v(dout1_43) AT=580.05n

.meas tran vdout1_44ck570 FIND v(dout1_44) AT=580.05n

.meas tran vdout1_45ck570 FIND v(dout1_45) AT=580.05n

.meas tran vdout1_46ck570 FIND v(dout1_46) AT=580.05n

.meas tran vdout1_47ck570 FIND v(dout1_47) AT=580.05n

.meas tran vdout1_48ck570 FIND v(dout1_48) AT=580.05n

.meas tran vdout1_49ck570 FIND v(dout1_49) AT=580.05n

.meas tran vdout1_50ck570 FIND v(dout1_50) AT=580.05n

.meas tran vdout1_51ck570 FIND v(dout1_51) AT=580.05n

.meas tran vdout1_52ck570 FIND v(dout1_52) AT=580.05n

.meas tran vdout1_53ck570 FIND v(dout1_53) AT=580.05n

.meas tran vdout1_54ck570 FIND v(dout1_54) AT=580.05n

.meas tran vdout1_55ck570 FIND v(dout1_55) AT=580.05n

.meas tran vdout1_56ck570 FIND v(dout1_56) AT=580.05n

.meas tran vdout1_57ck570 FIND v(dout1_57) AT=580.05n

.meas tran vdout1_58ck570 FIND v(dout1_58) AT=580.05n

.meas tran vdout1_59ck570 FIND v(dout1_59) AT=580.05n

.meas tran vdout1_60ck570 FIND v(dout1_60) AT=580.05n

.meas tran vdout1_61ck570 FIND v(dout1_61) AT=580.05n

.meas tran vdout1_62ck570 FIND v(dout1_62) AT=580.05n

.meas tran vdout1_63ck570 FIND v(dout1_63) AT=580.05n

.meas tran vdout1_64ck570 FIND v(dout1_64) AT=580.05n

.meas tran vdout1_65ck570 FIND v(dout1_65) AT=580.05n

.meas tran vdout1_66ck570 FIND v(dout1_66) AT=580.05n

.meas tran vdout1_67ck570 FIND v(dout1_67) AT=580.05n

.meas tran vdout1_68ck570 FIND v(dout1_68) AT=580.05n

.meas tran vdout1_69ck570 FIND v(dout1_69) AT=580.05n

.meas tran vdout1_70ck570 FIND v(dout1_70) AT=580.05n

.meas tran vdout1_71ck570 FIND v(dout1_71) AT=580.05n

.meas tran vdout1_72ck570 FIND v(dout1_72) AT=580.05n

.meas tran vdout1_73ck570 FIND v(dout1_73) AT=580.05n

.meas tran vdout1_74ck570 FIND v(dout1_74) AT=580.05n

.meas tran vdout1_75ck570 FIND v(dout1_75) AT=580.05n

.meas tran vdout1_76ck570 FIND v(dout1_76) AT=580.05n

.meas tran vdout1_77ck570 FIND v(dout1_77) AT=580.05n

.meas tran vdout1_78ck570 FIND v(dout1_78) AT=580.05n

.meas tran vdout1_79ck570 FIND v(dout1_79) AT=580.05n

.meas tran vdout1_80ck570 FIND v(dout1_80) AT=580.05n

.meas tran vdout1_81ck570 FIND v(dout1_81) AT=580.05n

.meas tran vdout1_82ck570 FIND v(dout1_82) AT=580.05n

.meas tran vdout1_83ck570 FIND v(dout1_83) AT=580.05n

.meas tran vdout1_84ck570 FIND v(dout1_84) AT=580.05n

.meas tran vdout1_85ck570 FIND v(dout1_85) AT=580.05n

.meas tran vdout1_86ck570 FIND v(dout1_86) AT=580.05n

.meas tran vdout1_87ck570 FIND v(dout1_87) AT=580.05n

.meas tran vdout1_88ck570 FIND v(dout1_88) AT=580.05n

.meas tran vdout1_89ck570 FIND v(dout1_89) AT=580.05n

.meas tran vdout1_90ck570 FIND v(dout1_90) AT=580.05n

.meas tran vdout1_91ck570 FIND v(dout1_91) AT=580.05n

.meas tran vdout1_92ck570 FIND v(dout1_92) AT=580.05n

.meas tran vdout1_93ck570 FIND v(dout1_93) AT=580.05n

.meas tran vdout1_94ck570 FIND v(dout1_94) AT=580.05n

.meas tran vdout1_95ck570 FIND v(dout1_95) AT=580.05n

.meas tran vdout1_96ck570 FIND v(dout1_96) AT=580.05n

.meas tran vdout1_97ck570 FIND v(dout1_97) AT=580.05n

.meas tran vdout1_98ck570 FIND v(dout1_98) AT=580.05n

.meas tran vdout1_99ck570 FIND v(dout1_99) AT=580.05n

.meas tran vdout1_100ck570 FIND v(dout1_100) AT=580.05n

.meas tran vdout1_101ck570 FIND v(dout1_101) AT=580.05n

.meas tran vdout1_102ck570 FIND v(dout1_102) AT=580.05n

.meas tran vdout1_103ck570 FIND v(dout1_103) AT=580.05n

.meas tran vdout1_104ck570 FIND v(dout1_104) AT=580.05n

.meas tran vdout1_105ck570 FIND v(dout1_105) AT=580.05n

.meas tran vdout1_106ck570 FIND v(dout1_106) AT=580.05n

.meas tran vdout1_107ck570 FIND v(dout1_107) AT=580.05n

.meas tran vdout1_108ck570 FIND v(dout1_108) AT=580.05n

.meas tran vdout1_109ck570 FIND v(dout1_109) AT=580.05n

.meas tran vdout1_110ck570 FIND v(dout1_110) AT=580.05n

.meas tran vdout1_111ck570 FIND v(dout1_111) AT=580.05n

.meas tran vdout1_112ck570 FIND v(dout1_112) AT=580.05n

.meas tran vdout1_113ck570 FIND v(dout1_113) AT=580.05n

.meas tran vdout1_114ck570 FIND v(dout1_114) AT=580.05n

.meas tran vdout1_115ck570 FIND v(dout1_115) AT=580.05n

.meas tran vdout1_116ck570 FIND v(dout1_116) AT=580.05n

.meas tran vdout1_117ck570 FIND v(dout1_117) AT=580.05n

.meas tran vdout1_118ck570 FIND v(dout1_118) AT=580.05n

.meas tran vdout1_119ck570 FIND v(dout1_119) AT=580.05n

.meas tran vdout1_120ck570 FIND v(dout1_120) AT=580.05n

.meas tran vdout1_121ck570 FIND v(dout1_121) AT=580.05n

.meas tran vdout1_122ck570 FIND v(dout1_122) AT=580.05n

.meas tran vdout1_123ck570 FIND v(dout1_123) AT=580.05n

.meas tran vdout1_124ck570 FIND v(dout1_124) AT=580.05n

.meas tran vdout1_125ck570 FIND v(dout1_125) AT=580.05n

.meas tran vdout1_126ck570 FIND v(dout1_126) AT=580.05n

.meas tran vdout1_127ck570 FIND v(dout1_127) AT=580.05n

.meas tran vdout1_128ck570 FIND v(dout1_128) AT=580.05n

.meas tran vdout1_129ck570 FIND v(dout1_129) AT=580.05n

.meas tran vdout1_130ck570 FIND v(dout1_130) AT=580.05n

.meas tran vdout1_131ck570 FIND v(dout1_131) AT=580.05n

.meas tran vdout1_132ck570 FIND v(dout1_132) AT=580.05n

.meas tran vdout1_133ck570 FIND v(dout1_133) AT=580.05n

.meas tran vdout1_134ck570 FIND v(dout1_134) AT=580.05n

.meas tran vdout1_0ck590 FIND v(dout1_0) AT=600.05n

.meas tran vdout1_1ck590 FIND v(dout1_1) AT=600.05n

.meas tran vdout1_2ck590 FIND v(dout1_2) AT=600.05n

.meas tran vdout1_3ck590 FIND v(dout1_3) AT=600.05n

.meas tran vdout1_4ck590 FIND v(dout1_4) AT=600.05n

.meas tran vdout1_5ck590 FIND v(dout1_5) AT=600.05n

.meas tran vdout1_6ck590 FIND v(dout1_6) AT=600.05n

.meas tran vdout1_7ck590 FIND v(dout1_7) AT=600.05n

.meas tran vdout1_8ck590 FIND v(dout1_8) AT=600.05n

.meas tran vdout1_9ck590 FIND v(dout1_9) AT=600.05n

.meas tran vdout1_10ck590 FIND v(dout1_10) AT=600.05n

.meas tran vdout1_11ck590 FIND v(dout1_11) AT=600.05n

.meas tran vdout1_12ck590 FIND v(dout1_12) AT=600.05n

.meas tran vdout1_13ck590 FIND v(dout1_13) AT=600.05n

.meas tran vdout1_14ck590 FIND v(dout1_14) AT=600.05n

.meas tran vdout1_15ck590 FIND v(dout1_15) AT=600.05n

.meas tran vdout1_16ck590 FIND v(dout1_16) AT=600.05n

.meas tran vdout1_17ck590 FIND v(dout1_17) AT=600.05n

.meas tran vdout1_18ck590 FIND v(dout1_18) AT=600.05n

.meas tran vdout1_19ck590 FIND v(dout1_19) AT=600.05n

.meas tran vdout1_20ck590 FIND v(dout1_20) AT=600.05n

.meas tran vdout1_21ck590 FIND v(dout1_21) AT=600.05n

.meas tran vdout1_22ck590 FIND v(dout1_22) AT=600.05n

.meas tran vdout1_23ck590 FIND v(dout1_23) AT=600.05n

.meas tran vdout1_24ck590 FIND v(dout1_24) AT=600.05n

.meas tran vdout1_25ck590 FIND v(dout1_25) AT=600.05n

.meas tran vdout1_26ck590 FIND v(dout1_26) AT=600.05n

.meas tran vdout1_27ck590 FIND v(dout1_27) AT=600.05n

.meas tran vdout1_28ck590 FIND v(dout1_28) AT=600.05n

.meas tran vdout1_29ck590 FIND v(dout1_29) AT=600.05n

.meas tran vdout1_30ck590 FIND v(dout1_30) AT=600.05n

.meas tran vdout1_31ck590 FIND v(dout1_31) AT=600.05n

.meas tran vdout1_32ck590 FIND v(dout1_32) AT=600.05n

.meas tran vdout1_33ck590 FIND v(dout1_33) AT=600.05n

.meas tran vdout1_34ck590 FIND v(dout1_34) AT=600.05n

.meas tran vdout1_35ck590 FIND v(dout1_35) AT=600.05n

.meas tran vdout1_36ck590 FIND v(dout1_36) AT=600.05n

.meas tran vdout1_37ck590 FIND v(dout1_37) AT=600.05n

.meas tran vdout1_38ck590 FIND v(dout1_38) AT=600.05n

.meas tran vdout1_39ck590 FIND v(dout1_39) AT=600.05n

.meas tran vdout1_40ck590 FIND v(dout1_40) AT=600.05n

.meas tran vdout1_41ck590 FIND v(dout1_41) AT=600.05n

.meas tran vdout1_42ck590 FIND v(dout1_42) AT=600.05n

.meas tran vdout1_43ck590 FIND v(dout1_43) AT=600.05n

.meas tran vdout1_44ck590 FIND v(dout1_44) AT=600.05n

.meas tran vdout1_45ck590 FIND v(dout1_45) AT=600.05n

.meas tran vdout1_46ck590 FIND v(dout1_46) AT=600.05n

.meas tran vdout1_47ck590 FIND v(dout1_47) AT=600.05n

.meas tran vdout1_48ck590 FIND v(dout1_48) AT=600.05n

.meas tran vdout1_49ck590 FIND v(dout1_49) AT=600.05n

.meas tran vdout1_50ck590 FIND v(dout1_50) AT=600.05n

.meas tran vdout1_51ck590 FIND v(dout1_51) AT=600.05n

.meas tran vdout1_52ck590 FIND v(dout1_52) AT=600.05n

.meas tran vdout1_53ck590 FIND v(dout1_53) AT=600.05n

.meas tran vdout1_54ck590 FIND v(dout1_54) AT=600.05n

.meas tran vdout1_55ck590 FIND v(dout1_55) AT=600.05n

.meas tran vdout1_56ck590 FIND v(dout1_56) AT=600.05n

.meas tran vdout1_57ck590 FIND v(dout1_57) AT=600.05n

.meas tran vdout1_58ck590 FIND v(dout1_58) AT=600.05n

.meas tran vdout1_59ck590 FIND v(dout1_59) AT=600.05n

.meas tran vdout1_60ck590 FIND v(dout1_60) AT=600.05n

.meas tran vdout1_61ck590 FIND v(dout1_61) AT=600.05n

.meas tran vdout1_62ck590 FIND v(dout1_62) AT=600.05n

.meas tran vdout1_63ck590 FIND v(dout1_63) AT=600.05n

.meas tran vdout1_64ck590 FIND v(dout1_64) AT=600.05n

.meas tran vdout1_65ck590 FIND v(dout1_65) AT=600.05n

.meas tran vdout1_66ck590 FIND v(dout1_66) AT=600.05n

.meas tran vdout1_67ck590 FIND v(dout1_67) AT=600.05n

.meas tran vdout1_68ck590 FIND v(dout1_68) AT=600.05n

.meas tran vdout1_69ck590 FIND v(dout1_69) AT=600.05n

.meas tran vdout1_70ck590 FIND v(dout1_70) AT=600.05n

.meas tran vdout1_71ck590 FIND v(dout1_71) AT=600.05n

.meas tran vdout1_72ck590 FIND v(dout1_72) AT=600.05n

.meas tran vdout1_73ck590 FIND v(dout1_73) AT=600.05n

.meas tran vdout1_74ck590 FIND v(dout1_74) AT=600.05n

.meas tran vdout1_75ck590 FIND v(dout1_75) AT=600.05n

.meas tran vdout1_76ck590 FIND v(dout1_76) AT=600.05n

.meas tran vdout1_77ck590 FIND v(dout1_77) AT=600.05n

.meas tran vdout1_78ck590 FIND v(dout1_78) AT=600.05n

.meas tran vdout1_79ck590 FIND v(dout1_79) AT=600.05n

.meas tran vdout1_80ck590 FIND v(dout1_80) AT=600.05n

.meas tran vdout1_81ck590 FIND v(dout1_81) AT=600.05n

.meas tran vdout1_82ck590 FIND v(dout1_82) AT=600.05n

.meas tran vdout1_83ck590 FIND v(dout1_83) AT=600.05n

.meas tran vdout1_84ck590 FIND v(dout1_84) AT=600.05n

.meas tran vdout1_85ck590 FIND v(dout1_85) AT=600.05n

.meas tran vdout1_86ck590 FIND v(dout1_86) AT=600.05n

.meas tran vdout1_87ck590 FIND v(dout1_87) AT=600.05n

.meas tran vdout1_88ck590 FIND v(dout1_88) AT=600.05n

.meas tran vdout1_89ck590 FIND v(dout1_89) AT=600.05n

.meas tran vdout1_90ck590 FIND v(dout1_90) AT=600.05n

.meas tran vdout1_91ck590 FIND v(dout1_91) AT=600.05n

.meas tran vdout1_92ck590 FIND v(dout1_92) AT=600.05n

.meas tran vdout1_93ck590 FIND v(dout1_93) AT=600.05n

.meas tran vdout1_94ck590 FIND v(dout1_94) AT=600.05n

.meas tran vdout1_95ck590 FIND v(dout1_95) AT=600.05n

.meas tran vdout1_96ck590 FIND v(dout1_96) AT=600.05n

.meas tran vdout1_97ck590 FIND v(dout1_97) AT=600.05n

.meas tran vdout1_98ck590 FIND v(dout1_98) AT=600.05n

.meas tran vdout1_99ck590 FIND v(dout1_99) AT=600.05n

.meas tran vdout1_100ck590 FIND v(dout1_100) AT=600.05n

.meas tran vdout1_101ck590 FIND v(dout1_101) AT=600.05n

.meas tran vdout1_102ck590 FIND v(dout1_102) AT=600.05n

.meas tran vdout1_103ck590 FIND v(dout1_103) AT=600.05n

.meas tran vdout1_104ck590 FIND v(dout1_104) AT=600.05n

.meas tran vdout1_105ck590 FIND v(dout1_105) AT=600.05n

.meas tran vdout1_106ck590 FIND v(dout1_106) AT=600.05n

.meas tran vdout1_107ck590 FIND v(dout1_107) AT=600.05n

.meas tran vdout1_108ck590 FIND v(dout1_108) AT=600.05n

.meas tran vdout1_109ck590 FIND v(dout1_109) AT=600.05n

.meas tran vdout1_110ck590 FIND v(dout1_110) AT=600.05n

.meas tran vdout1_111ck590 FIND v(dout1_111) AT=600.05n

.meas tran vdout1_112ck590 FIND v(dout1_112) AT=600.05n

.meas tran vdout1_113ck590 FIND v(dout1_113) AT=600.05n

.meas tran vdout1_114ck590 FIND v(dout1_114) AT=600.05n

.meas tran vdout1_115ck590 FIND v(dout1_115) AT=600.05n

.meas tran vdout1_116ck590 FIND v(dout1_116) AT=600.05n

.meas tran vdout1_117ck590 FIND v(dout1_117) AT=600.05n

.meas tran vdout1_118ck590 FIND v(dout1_118) AT=600.05n

.meas tran vdout1_119ck590 FIND v(dout1_119) AT=600.05n

.meas tran vdout1_120ck590 FIND v(dout1_120) AT=600.05n

.meas tran vdout1_121ck590 FIND v(dout1_121) AT=600.05n

.meas tran vdout1_122ck590 FIND v(dout1_122) AT=600.05n

.meas tran vdout1_123ck590 FIND v(dout1_123) AT=600.05n

.meas tran vdout1_124ck590 FIND v(dout1_124) AT=600.05n

.meas tran vdout1_125ck590 FIND v(dout1_125) AT=600.05n

.meas tran vdout1_126ck590 FIND v(dout1_126) AT=600.05n

.meas tran vdout1_127ck590 FIND v(dout1_127) AT=600.05n

.meas tran vdout1_128ck590 FIND v(dout1_128) AT=600.05n

.meas tran vdout1_129ck590 FIND v(dout1_129) AT=600.05n

.meas tran vdout1_130ck590 FIND v(dout1_130) AT=600.05n

.meas tran vdout1_131ck590 FIND v(dout1_131) AT=600.05n

.meas tran vdout1_132ck590 FIND v(dout1_132) AT=600.05n

.meas tran vdout1_133ck590 FIND v(dout1_133) AT=600.05n

.meas tran vdout1_134ck590 FIND v(dout1_134) AT=600.05n

.meas tran vdout1_0ck600 FIND v(dout1_0) AT=610.05n

.meas tran vdout1_1ck600 FIND v(dout1_1) AT=610.05n

.meas tran vdout1_2ck600 FIND v(dout1_2) AT=610.05n

.meas tran vdout1_3ck600 FIND v(dout1_3) AT=610.05n

.meas tran vdout1_4ck600 FIND v(dout1_4) AT=610.05n

.meas tran vdout1_5ck600 FIND v(dout1_5) AT=610.05n

.meas tran vdout1_6ck600 FIND v(dout1_6) AT=610.05n

.meas tran vdout1_7ck600 FIND v(dout1_7) AT=610.05n

.meas tran vdout1_8ck600 FIND v(dout1_8) AT=610.05n

.meas tran vdout1_9ck600 FIND v(dout1_9) AT=610.05n

.meas tran vdout1_10ck600 FIND v(dout1_10) AT=610.05n

.meas tran vdout1_11ck600 FIND v(dout1_11) AT=610.05n

.meas tran vdout1_12ck600 FIND v(dout1_12) AT=610.05n

.meas tran vdout1_13ck600 FIND v(dout1_13) AT=610.05n

.meas tran vdout1_14ck600 FIND v(dout1_14) AT=610.05n

.meas tran vdout1_15ck600 FIND v(dout1_15) AT=610.05n

.meas tran vdout1_16ck600 FIND v(dout1_16) AT=610.05n

.meas tran vdout1_17ck600 FIND v(dout1_17) AT=610.05n

.meas tran vdout1_18ck600 FIND v(dout1_18) AT=610.05n

.meas tran vdout1_19ck600 FIND v(dout1_19) AT=610.05n

.meas tran vdout1_20ck600 FIND v(dout1_20) AT=610.05n

.meas tran vdout1_21ck600 FIND v(dout1_21) AT=610.05n

.meas tran vdout1_22ck600 FIND v(dout1_22) AT=610.05n

.meas tran vdout1_23ck600 FIND v(dout1_23) AT=610.05n

.meas tran vdout1_24ck600 FIND v(dout1_24) AT=610.05n

.meas tran vdout1_25ck600 FIND v(dout1_25) AT=610.05n

.meas tran vdout1_26ck600 FIND v(dout1_26) AT=610.05n

.meas tran vdout1_27ck600 FIND v(dout1_27) AT=610.05n

.meas tran vdout1_28ck600 FIND v(dout1_28) AT=610.05n

.meas tran vdout1_29ck600 FIND v(dout1_29) AT=610.05n

.meas tran vdout1_30ck600 FIND v(dout1_30) AT=610.05n

.meas tran vdout1_31ck600 FIND v(dout1_31) AT=610.05n

.meas tran vdout1_32ck600 FIND v(dout1_32) AT=610.05n

.meas tran vdout1_33ck600 FIND v(dout1_33) AT=610.05n

.meas tran vdout1_34ck600 FIND v(dout1_34) AT=610.05n

.meas tran vdout1_35ck600 FIND v(dout1_35) AT=610.05n

.meas tran vdout1_36ck600 FIND v(dout1_36) AT=610.05n

.meas tran vdout1_37ck600 FIND v(dout1_37) AT=610.05n

.meas tran vdout1_38ck600 FIND v(dout1_38) AT=610.05n

.meas tran vdout1_39ck600 FIND v(dout1_39) AT=610.05n

.meas tran vdout1_40ck600 FIND v(dout1_40) AT=610.05n

.meas tran vdout1_41ck600 FIND v(dout1_41) AT=610.05n

.meas tran vdout1_42ck600 FIND v(dout1_42) AT=610.05n

.meas tran vdout1_43ck600 FIND v(dout1_43) AT=610.05n

.meas tran vdout1_44ck600 FIND v(dout1_44) AT=610.05n

.meas tran vdout1_45ck600 FIND v(dout1_45) AT=610.05n

.meas tran vdout1_46ck600 FIND v(dout1_46) AT=610.05n

.meas tran vdout1_47ck600 FIND v(dout1_47) AT=610.05n

.meas tran vdout1_48ck600 FIND v(dout1_48) AT=610.05n

.meas tran vdout1_49ck600 FIND v(dout1_49) AT=610.05n

.meas tran vdout1_50ck600 FIND v(dout1_50) AT=610.05n

.meas tran vdout1_51ck600 FIND v(dout1_51) AT=610.05n

.meas tran vdout1_52ck600 FIND v(dout1_52) AT=610.05n

.meas tran vdout1_53ck600 FIND v(dout1_53) AT=610.05n

.meas tran vdout1_54ck600 FIND v(dout1_54) AT=610.05n

.meas tran vdout1_55ck600 FIND v(dout1_55) AT=610.05n

.meas tran vdout1_56ck600 FIND v(dout1_56) AT=610.05n

.meas tran vdout1_57ck600 FIND v(dout1_57) AT=610.05n

.meas tran vdout1_58ck600 FIND v(dout1_58) AT=610.05n

.meas tran vdout1_59ck600 FIND v(dout1_59) AT=610.05n

.meas tran vdout1_60ck600 FIND v(dout1_60) AT=610.05n

.meas tran vdout1_61ck600 FIND v(dout1_61) AT=610.05n

.meas tran vdout1_62ck600 FIND v(dout1_62) AT=610.05n

.meas tran vdout1_63ck600 FIND v(dout1_63) AT=610.05n

.meas tran vdout1_64ck600 FIND v(dout1_64) AT=610.05n

.meas tran vdout1_65ck600 FIND v(dout1_65) AT=610.05n

.meas tran vdout1_66ck600 FIND v(dout1_66) AT=610.05n

.meas tran vdout1_67ck600 FIND v(dout1_67) AT=610.05n

.meas tran vdout1_68ck600 FIND v(dout1_68) AT=610.05n

.meas tran vdout1_69ck600 FIND v(dout1_69) AT=610.05n

.meas tran vdout1_70ck600 FIND v(dout1_70) AT=610.05n

.meas tran vdout1_71ck600 FIND v(dout1_71) AT=610.05n

.meas tran vdout1_72ck600 FIND v(dout1_72) AT=610.05n

.meas tran vdout1_73ck600 FIND v(dout1_73) AT=610.05n

.meas tran vdout1_74ck600 FIND v(dout1_74) AT=610.05n

.meas tran vdout1_75ck600 FIND v(dout1_75) AT=610.05n

.meas tran vdout1_76ck600 FIND v(dout1_76) AT=610.05n

.meas tran vdout1_77ck600 FIND v(dout1_77) AT=610.05n

.meas tran vdout1_78ck600 FIND v(dout1_78) AT=610.05n

.meas tran vdout1_79ck600 FIND v(dout1_79) AT=610.05n

.meas tran vdout1_80ck600 FIND v(dout1_80) AT=610.05n

.meas tran vdout1_81ck600 FIND v(dout1_81) AT=610.05n

.meas tran vdout1_82ck600 FIND v(dout1_82) AT=610.05n

.meas tran vdout1_83ck600 FIND v(dout1_83) AT=610.05n

.meas tran vdout1_84ck600 FIND v(dout1_84) AT=610.05n

.meas tran vdout1_85ck600 FIND v(dout1_85) AT=610.05n

.meas tran vdout1_86ck600 FIND v(dout1_86) AT=610.05n

.meas tran vdout1_87ck600 FIND v(dout1_87) AT=610.05n

.meas tran vdout1_88ck600 FIND v(dout1_88) AT=610.05n

.meas tran vdout1_89ck600 FIND v(dout1_89) AT=610.05n

.meas tran vdout1_90ck600 FIND v(dout1_90) AT=610.05n

.meas tran vdout1_91ck600 FIND v(dout1_91) AT=610.05n

.meas tran vdout1_92ck600 FIND v(dout1_92) AT=610.05n

.meas tran vdout1_93ck600 FIND v(dout1_93) AT=610.05n

.meas tran vdout1_94ck600 FIND v(dout1_94) AT=610.05n

.meas tran vdout1_95ck600 FIND v(dout1_95) AT=610.05n

.meas tran vdout1_96ck600 FIND v(dout1_96) AT=610.05n

.meas tran vdout1_97ck600 FIND v(dout1_97) AT=610.05n

.meas tran vdout1_98ck600 FIND v(dout1_98) AT=610.05n

.meas tran vdout1_99ck600 FIND v(dout1_99) AT=610.05n

.meas tran vdout1_100ck600 FIND v(dout1_100) AT=610.05n

.meas tran vdout1_101ck600 FIND v(dout1_101) AT=610.05n

.meas tran vdout1_102ck600 FIND v(dout1_102) AT=610.05n

.meas tran vdout1_103ck600 FIND v(dout1_103) AT=610.05n

.meas tran vdout1_104ck600 FIND v(dout1_104) AT=610.05n

.meas tran vdout1_105ck600 FIND v(dout1_105) AT=610.05n

.meas tran vdout1_106ck600 FIND v(dout1_106) AT=610.05n

.meas tran vdout1_107ck600 FIND v(dout1_107) AT=610.05n

.meas tran vdout1_108ck600 FIND v(dout1_108) AT=610.05n

.meas tran vdout1_109ck600 FIND v(dout1_109) AT=610.05n

.meas tran vdout1_110ck600 FIND v(dout1_110) AT=610.05n

.meas tran vdout1_111ck600 FIND v(dout1_111) AT=610.05n

.meas tran vdout1_112ck600 FIND v(dout1_112) AT=610.05n

.meas tran vdout1_113ck600 FIND v(dout1_113) AT=610.05n

.meas tran vdout1_114ck600 FIND v(dout1_114) AT=610.05n

.meas tran vdout1_115ck600 FIND v(dout1_115) AT=610.05n

.meas tran vdout1_116ck600 FIND v(dout1_116) AT=610.05n

.meas tran vdout1_117ck600 FIND v(dout1_117) AT=610.05n

.meas tran vdout1_118ck600 FIND v(dout1_118) AT=610.05n

.meas tran vdout1_119ck600 FIND v(dout1_119) AT=610.05n

.meas tran vdout1_120ck600 FIND v(dout1_120) AT=610.05n

.meas tran vdout1_121ck600 FIND v(dout1_121) AT=610.05n

.meas tran vdout1_122ck600 FIND v(dout1_122) AT=610.05n

.meas tran vdout1_123ck600 FIND v(dout1_123) AT=610.05n

.meas tran vdout1_124ck600 FIND v(dout1_124) AT=610.05n

.meas tran vdout1_125ck600 FIND v(dout1_125) AT=610.05n

.meas tran vdout1_126ck600 FIND v(dout1_126) AT=610.05n

.meas tran vdout1_127ck600 FIND v(dout1_127) AT=610.05n

.meas tran vdout1_128ck600 FIND v(dout1_128) AT=610.05n

.meas tran vdout1_129ck600 FIND v(dout1_129) AT=610.05n

.meas tran vdout1_130ck600 FIND v(dout1_130) AT=610.05n

.meas tran vdout1_131ck600 FIND v(dout1_131) AT=610.05n

.meas tran vdout1_132ck600 FIND v(dout1_132) AT=610.05n

.meas tran vdout1_133ck600 FIND v(dout1_133) AT=610.05n

.meas tran vdout1_134ck600 FIND v(dout1_134) AT=610.05n

.meas tran vdout1_0ck630 FIND v(dout1_0) AT=640.05n

.meas tran vdout1_1ck630 FIND v(dout1_1) AT=640.05n

.meas tran vdout1_2ck630 FIND v(dout1_2) AT=640.05n

.meas tran vdout1_3ck630 FIND v(dout1_3) AT=640.05n

.meas tran vdout1_4ck630 FIND v(dout1_4) AT=640.05n

.meas tran vdout1_5ck630 FIND v(dout1_5) AT=640.05n

.meas tran vdout1_6ck630 FIND v(dout1_6) AT=640.05n

.meas tran vdout1_7ck630 FIND v(dout1_7) AT=640.05n

.meas tran vdout1_8ck630 FIND v(dout1_8) AT=640.05n

.meas tran vdout1_9ck630 FIND v(dout1_9) AT=640.05n

.meas tran vdout1_10ck630 FIND v(dout1_10) AT=640.05n

.meas tran vdout1_11ck630 FIND v(dout1_11) AT=640.05n

.meas tran vdout1_12ck630 FIND v(dout1_12) AT=640.05n

.meas tran vdout1_13ck630 FIND v(dout1_13) AT=640.05n

.meas tran vdout1_14ck630 FIND v(dout1_14) AT=640.05n

.meas tran vdout1_15ck630 FIND v(dout1_15) AT=640.05n

.meas tran vdout1_16ck630 FIND v(dout1_16) AT=640.05n

.meas tran vdout1_17ck630 FIND v(dout1_17) AT=640.05n

.meas tran vdout1_18ck630 FIND v(dout1_18) AT=640.05n

.meas tran vdout1_19ck630 FIND v(dout1_19) AT=640.05n

.meas tran vdout1_20ck630 FIND v(dout1_20) AT=640.05n

.meas tran vdout1_21ck630 FIND v(dout1_21) AT=640.05n

.meas tran vdout1_22ck630 FIND v(dout1_22) AT=640.05n

.meas tran vdout1_23ck630 FIND v(dout1_23) AT=640.05n

.meas tran vdout1_24ck630 FIND v(dout1_24) AT=640.05n

.meas tran vdout1_25ck630 FIND v(dout1_25) AT=640.05n

.meas tran vdout1_26ck630 FIND v(dout1_26) AT=640.05n

.meas tran vdout1_27ck630 FIND v(dout1_27) AT=640.05n

.meas tran vdout1_28ck630 FIND v(dout1_28) AT=640.05n

.meas tran vdout1_29ck630 FIND v(dout1_29) AT=640.05n

.meas tran vdout1_30ck630 FIND v(dout1_30) AT=640.05n

.meas tran vdout1_31ck630 FIND v(dout1_31) AT=640.05n

.meas tran vdout1_32ck630 FIND v(dout1_32) AT=640.05n

.meas tran vdout1_33ck630 FIND v(dout1_33) AT=640.05n

.meas tran vdout1_34ck630 FIND v(dout1_34) AT=640.05n

.meas tran vdout1_35ck630 FIND v(dout1_35) AT=640.05n

.meas tran vdout1_36ck630 FIND v(dout1_36) AT=640.05n

.meas tran vdout1_37ck630 FIND v(dout1_37) AT=640.05n

.meas tran vdout1_38ck630 FIND v(dout1_38) AT=640.05n

.meas tran vdout1_39ck630 FIND v(dout1_39) AT=640.05n

.meas tran vdout1_40ck630 FIND v(dout1_40) AT=640.05n

.meas tran vdout1_41ck630 FIND v(dout1_41) AT=640.05n

.meas tran vdout1_42ck630 FIND v(dout1_42) AT=640.05n

.meas tran vdout1_43ck630 FIND v(dout1_43) AT=640.05n

.meas tran vdout1_44ck630 FIND v(dout1_44) AT=640.05n

.meas tran vdout1_45ck630 FIND v(dout1_45) AT=640.05n

.meas tran vdout1_46ck630 FIND v(dout1_46) AT=640.05n

.meas tran vdout1_47ck630 FIND v(dout1_47) AT=640.05n

.meas tran vdout1_48ck630 FIND v(dout1_48) AT=640.05n

.meas tran vdout1_49ck630 FIND v(dout1_49) AT=640.05n

.meas tran vdout1_50ck630 FIND v(dout1_50) AT=640.05n

.meas tran vdout1_51ck630 FIND v(dout1_51) AT=640.05n

.meas tran vdout1_52ck630 FIND v(dout1_52) AT=640.05n

.meas tran vdout1_53ck630 FIND v(dout1_53) AT=640.05n

.meas tran vdout1_54ck630 FIND v(dout1_54) AT=640.05n

.meas tran vdout1_55ck630 FIND v(dout1_55) AT=640.05n

.meas tran vdout1_56ck630 FIND v(dout1_56) AT=640.05n

.meas tran vdout1_57ck630 FIND v(dout1_57) AT=640.05n

.meas tran vdout1_58ck630 FIND v(dout1_58) AT=640.05n

.meas tran vdout1_59ck630 FIND v(dout1_59) AT=640.05n

.meas tran vdout1_60ck630 FIND v(dout1_60) AT=640.05n

.meas tran vdout1_61ck630 FIND v(dout1_61) AT=640.05n

.meas tran vdout1_62ck630 FIND v(dout1_62) AT=640.05n

.meas tran vdout1_63ck630 FIND v(dout1_63) AT=640.05n

.meas tran vdout1_64ck630 FIND v(dout1_64) AT=640.05n

.meas tran vdout1_65ck630 FIND v(dout1_65) AT=640.05n

.meas tran vdout1_66ck630 FIND v(dout1_66) AT=640.05n

.meas tran vdout1_67ck630 FIND v(dout1_67) AT=640.05n

.meas tran vdout1_68ck630 FIND v(dout1_68) AT=640.05n

.meas tran vdout1_69ck630 FIND v(dout1_69) AT=640.05n

.meas tran vdout1_70ck630 FIND v(dout1_70) AT=640.05n

.meas tran vdout1_71ck630 FIND v(dout1_71) AT=640.05n

.meas tran vdout1_72ck630 FIND v(dout1_72) AT=640.05n

.meas tran vdout1_73ck630 FIND v(dout1_73) AT=640.05n

.meas tran vdout1_74ck630 FIND v(dout1_74) AT=640.05n

.meas tran vdout1_75ck630 FIND v(dout1_75) AT=640.05n

.meas tran vdout1_76ck630 FIND v(dout1_76) AT=640.05n

.meas tran vdout1_77ck630 FIND v(dout1_77) AT=640.05n

.meas tran vdout1_78ck630 FIND v(dout1_78) AT=640.05n

.meas tran vdout1_79ck630 FIND v(dout1_79) AT=640.05n

.meas tran vdout1_80ck630 FIND v(dout1_80) AT=640.05n

.meas tran vdout1_81ck630 FIND v(dout1_81) AT=640.05n

.meas tran vdout1_82ck630 FIND v(dout1_82) AT=640.05n

.meas tran vdout1_83ck630 FIND v(dout1_83) AT=640.05n

.meas tran vdout1_84ck630 FIND v(dout1_84) AT=640.05n

.meas tran vdout1_85ck630 FIND v(dout1_85) AT=640.05n

.meas tran vdout1_86ck630 FIND v(dout1_86) AT=640.05n

.meas tran vdout1_87ck630 FIND v(dout1_87) AT=640.05n

.meas tran vdout1_88ck630 FIND v(dout1_88) AT=640.05n

.meas tran vdout1_89ck630 FIND v(dout1_89) AT=640.05n

.meas tran vdout1_90ck630 FIND v(dout1_90) AT=640.05n

.meas tran vdout1_91ck630 FIND v(dout1_91) AT=640.05n

.meas tran vdout1_92ck630 FIND v(dout1_92) AT=640.05n

.meas tran vdout1_93ck630 FIND v(dout1_93) AT=640.05n

.meas tran vdout1_94ck630 FIND v(dout1_94) AT=640.05n

.meas tran vdout1_95ck630 FIND v(dout1_95) AT=640.05n

.meas tran vdout1_96ck630 FIND v(dout1_96) AT=640.05n

.meas tran vdout1_97ck630 FIND v(dout1_97) AT=640.05n

.meas tran vdout1_98ck630 FIND v(dout1_98) AT=640.05n

.meas tran vdout1_99ck630 FIND v(dout1_99) AT=640.05n

.meas tran vdout1_100ck630 FIND v(dout1_100) AT=640.05n

.meas tran vdout1_101ck630 FIND v(dout1_101) AT=640.05n

.meas tran vdout1_102ck630 FIND v(dout1_102) AT=640.05n

.meas tran vdout1_103ck630 FIND v(dout1_103) AT=640.05n

.meas tran vdout1_104ck630 FIND v(dout1_104) AT=640.05n

.meas tran vdout1_105ck630 FIND v(dout1_105) AT=640.05n

.meas tran vdout1_106ck630 FIND v(dout1_106) AT=640.05n

.meas tran vdout1_107ck630 FIND v(dout1_107) AT=640.05n

.meas tran vdout1_108ck630 FIND v(dout1_108) AT=640.05n

.meas tran vdout1_109ck630 FIND v(dout1_109) AT=640.05n

.meas tran vdout1_110ck630 FIND v(dout1_110) AT=640.05n

.meas tran vdout1_111ck630 FIND v(dout1_111) AT=640.05n

.meas tran vdout1_112ck630 FIND v(dout1_112) AT=640.05n

.meas tran vdout1_113ck630 FIND v(dout1_113) AT=640.05n

.meas tran vdout1_114ck630 FIND v(dout1_114) AT=640.05n

.meas tran vdout1_115ck630 FIND v(dout1_115) AT=640.05n

.meas tran vdout1_116ck630 FIND v(dout1_116) AT=640.05n

.meas tran vdout1_117ck630 FIND v(dout1_117) AT=640.05n

.meas tran vdout1_118ck630 FIND v(dout1_118) AT=640.05n

.meas tran vdout1_119ck630 FIND v(dout1_119) AT=640.05n

.meas tran vdout1_120ck630 FIND v(dout1_120) AT=640.05n

.meas tran vdout1_121ck630 FIND v(dout1_121) AT=640.05n

.meas tran vdout1_122ck630 FIND v(dout1_122) AT=640.05n

.meas tran vdout1_123ck630 FIND v(dout1_123) AT=640.05n

.meas tran vdout1_124ck630 FIND v(dout1_124) AT=640.05n

.meas tran vdout1_125ck630 FIND v(dout1_125) AT=640.05n

.meas tran vdout1_126ck630 FIND v(dout1_126) AT=640.05n

.meas tran vdout1_127ck630 FIND v(dout1_127) AT=640.05n

.meas tran vdout1_128ck630 FIND v(dout1_128) AT=640.05n

.meas tran vdout1_129ck630 FIND v(dout1_129) AT=640.05n

.meas tran vdout1_130ck630 FIND v(dout1_130) AT=640.05n

.meas tran vdout1_131ck630 FIND v(dout1_131) AT=640.05n

.meas tran vdout1_132ck630 FIND v(dout1_132) AT=640.05n

.meas tran vdout1_133ck630 FIND v(dout1_133) AT=640.05n

.meas tran vdout1_134ck630 FIND v(dout1_134) AT=640.05n

.meas tran vdout1_0ck640 FIND v(dout1_0) AT=650.05n

.meas tran vdout1_1ck640 FIND v(dout1_1) AT=650.05n

.meas tran vdout1_2ck640 FIND v(dout1_2) AT=650.05n

.meas tran vdout1_3ck640 FIND v(dout1_3) AT=650.05n

.meas tran vdout1_4ck640 FIND v(dout1_4) AT=650.05n

.meas tran vdout1_5ck640 FIND v(dout1_5) AT=650.05n

.meas tran vdout1_6ck640 FIND v(dout1_6) AT=650.05n

.meas tran vdout1_7ck640 FIND v(dout1_7) AT=650.05n

.meas tran vdout1_8ck640 FIND v(dout1_8) AT=650.05n

.meas tran vdout1_9ck640 FIND v(dout1_9) AT=650.05n

.meas tran vdout1_10ck640 FIND v(dout1_10) AT=650.05n

.meas tran vdout1_11ck640 FIND v(dout1_11) AT=650.05n

.meas tran vdout1_12ck640 FIND v(dout1_12) AT=650.05n

.meas tran vdout1_13ck640 FIND v(dout1_13) AT=650.05n

.meas tran vdout1_14ck640 FIND v(dout1_14) AT=650.05n

.meas tran vdout1_15ck640 FIND v(dout1_15) AT=650.05n

.meas tran vdout1_16ck640 FIND v(dout1_16) AT=650.05n

.meas tran vdout1_17ck640 FIND v(dout1_17) AT=650.05n

.meas tran vdout1_18ck640 FIND v(dout1_18) AT=650.05n

.meas tran vdout1_19ck640 FIND v(dout1_19) AT=650.05n

.meas tran vdout1_20ck640 FIND v(dout1_20) AT=650.05n

.meas tran vdout1_21ck640 FIND v(dout1_21) AT=650.05n

.meas tran vdout1_22ck640 FIND v(dout1_22) AT=650.05n

.meas tran vdout1_23ck640 FIND v(dout1_23) AT=650.05n

.meas tran vdout1_24ck640 FIND v(dout1_24) AT=650.05n

.meas tran vdout1_25ck640 FIND v(dout1_25) AT=650.05n

.meas tran vdout1_26ck640 FIND v(dout1_26) AT=650.05n

.meas tran vdout1_27ck640 FIND v(dout1_27) AT=650.05n

.meas tran vdout1_28ck640 FIND v(dout1_28) AT=650.05n

.meas tran vdout1_29ck640 FIND v(dout1_29) AT=650.05n

.meas tran vdout1_30ck640 FIND v(dout1_30) AT=650.05n

.meas tran vdout1_31ck640 FIND v(dout1_31) AT=650.05n

.meas tran vdout1_32ck640 FIND v(dout1_32) AT=650.05n

.meas tran vdout1_33ck640 FIND v(dout1_33) AT=650.05n

.meas tran vdout1_34ck640 FIND v(dout1_34) AT=650.05n

.meas tran vdout1_35ck640 FIND v(dout1_35) AT=650.05n

.meas tran vdout1_36ck640 FIND v(dout1_36) AT=650.05n

.meas tran vdout1_37ck640 FIND v(dout1_37) AT=650.05n

.meas tran vdout1_38ck640 FIND v(dout1_38) AT=650.05n

.meas tran vdout1_39ck640 FIND v(dout1_39) AT=650.05n

.meas tran vdout1_40ck640 FIND v(dout1_40) AT=650.05n

.meas tran vdout1_41ck640 FIND v(dout1_41) AT=650.05n

.meas tran vdout1_42ck640 FIND v(dout1_42) AT=650.05n

.meas tran vdout1_43ck640 FIND v(dout1_43) AT=650.05n

.meas tran vdout1_44ck640 FIND v(dout1_44) AT=650.05n

.meas tran vdout1_45ck640 FIND v(dout1_45) AT=650.05n

.meas tran vdout1_46ck640 FIND v(dout1_46) AT=650.05n

.meas tran vdout1_47ck640 FIND v(dout1_47) AT=650.05n

.meas tran vdout1_48ck640 FIND v(dout1_48) AT=650.05n

.meas tran vdout1_49ck640 FIND v(dout1_49) AT=650.05n

.meas tran vdout1_50ck640 FIND v(dout1_50) AT=650.05n

.meas tran vdout1_51ck640 FIND v(dout1_51) AT=650.05n

.meas tran vdout1_52ck640 FIND v(dout1_52) AT=650.05n

.meas tran vdout1_53ck640 FIND v(dout1_53) AT=650.05n

.meas tran vdout1_54ck640 FIND v(dout1_54) AT=650.05n

.meas tran vdout1_55ck640 FIND v(dout1_55) AT=650.05n

.meas tran vdout1_56ck640 FIND v(dout1_56) AT=650.05n

.meas tran vdout1_57ck640 FIND v(dout1_57) AT=650.05n

.meas tran vdout1_58ck640 FIND v(dout1_58) AT=650.05n

.meas tran vdout1_59ck640 FIND v(dout1_59) AT=650.05n

.meas tran vdout1_60ck640 FIND v(dout1_60) AT=650.05n

.meas tran vdout1_61ck640 FIND v(dout1_61) AT=650.05n

.meas tran vdout1_62ck640 FIND v(dout1_62) AT=650.05n

.meas tran vdout1_63ck640 FIND v(dout1_63) AT=650.05n

.meas tran vdout1_64ck640 FIND v(dout1_64) AT=650.05n

.meas tran vdout1_65ck640 FIND v(dout1_65) AT=650.05n

.meas tran vdout1_66ck640 FIND v(dout1_66) AT=650.05n

.meas tran vdout1_67ck640 FIND v(dout1_67) AT=650.05n

.meas tran vdout1_68ck640 FIND v(dout1_68) AT=650.05n

.meas tran vdout1_69ck640 FIND v(dout1_69) AT=650.05n

.meas tran vdout1_70ck640 FIND v(dout1_70) AT=650.05n

.meas tran vdout1_71ck640 FIND v(dout1_71) AT=650.05n

.meas tran vdout1_72ck640 FIND v(dout1_72) AT=650.05n

.meas tran vdout1_73ck640 FIND v(dout1_73) AT=650.05n

.meas tran vdout1_74ck640 FIND v(dout1_74) AT=650.05n

.meas tran vdout1_75ck640 FIND v(dout1_75) AT=650.05n

.meas tran vdout1_76ck640 FIND v(dout1_76) AT=650.05n

.meas tran vdout1_77ck640 FIND v(dout1_77) AT=650.05n

.meas tran vdout1_78ck640 FIND v(dout1_78) AT=650.05n

.meas tran vdout1_79ck640 FIND v(dout1_79) AT=650.05n

.meas tran vdout1_80ck640 FIND v(dout1_80) AT=650.05n

.meas tran vdout1_81ck640 FIND v(dout1_81) AT=650.05n

.meas tran vdout1_82ck640 FIND v(dout1_82) AT=650.05n

.meas tran vdout1_83ck640 FIND v(dout1_83) AT=650.05n

.meas tran vdout1_84ck640 FIND v(dout1_84) AT=650.05n

.meas tran vdout1_85ck640 FIND v(dout1_85) AT=650.05n

.meas tran vdout1_86ck640 FIND v(dout1_86) AT=650.05n

.meas tran vdout1_87ck640 FIND v(dout1_87) AT=650.05n

.meas tran vdout1_88ck640 FIND v(dout1_88) AT=650.05n

.meas tran vdout1_89ck640 FIND v(dout1_89) AT=650.05n

.meas tran vdout1_90ck640 FIND v(dout1_90) AT=650.05n

.meas tran vdout1_91ck640 FIND v(dout1_91) AT=650.05n

.meas tran vdout1_92ck640 FIND v(dout1_92) AT=650.05n

.meas tran vdout1_93ck640 FIND v(dout1_93) AT=650.05n

.meas tran vdout1_94ck640 FIND v(dout1_94) AT=650.05n

.meas tran vdout1_95ck640 FIND v(dout1_95) AT=650.05n

.meas tran vdout1_96ck640 FIND v(dout1_96) AT=650.05n

.meas tran vdout1_97ck640 FIND v(dout1_97) AT=650.05n

.meas tran vdout1_98ck640 FIND v(dout1_98) AT=650.05n

.meas tran vdout1_99ck640 FIND v(dout1_99) AT=650.05n

.meas tran vdout1_100ck640 FIND v(dout1_100) AT=650.05n

.meas tran vdout1_101ck640 FIND v(dout1_101) AT=650.05n

.meas tran vdout1_102ck640 FIND v(dout1_102) AT=650.05n

.meas tran vdout1_103ck640 FIND v(dout1_103) AT=650.05n

.meas tran vdout1_104ck640 FIND v(dout1_104) AT=650.05n

.meas tran vdout1_105ck640 FIND v(dout1_105) AT=650.05n

.meas tran vdout1_106ck640 FIND v(dout1_106) AT=650.05n

.meas tran vdout1_107ck640 FIND v(dout1_107) AT=650.05n

.meas tran vdout1_108ck640 FIND v(dout1_108) AT=650.05n

.meas tran vdout1_109ck640 FIND v(dout1_109) AT=650.05n

.meas tran vdout1_110ck640 FIND v(dout1_110) AT=650.05n

.meas tran vdout1_111ck640 FIND v(dout1_111) AT=650.05n

.meas tran vdout1_112ck640 FIND v(dout1_112) AT=650.05n

.meas tran vdout1_113ck640 FIND v(dout1_113) AT=650.05n

.meas tran vdout1_114ck640 FIND v(dout1_114) AT=650.05n

.meas tran vdout1_115ck640 FIND v(dout1_115) AT=650.05n

.meas tran vdout1_116ck640 FIND v(dout1_116) AT=650.05n

.meas tran vdout1_117ck640 FIND v(dout1_117) AT=650.05n

.meas tran vdout1_118ck640 FIND v(dout1_118) AT=650.05n

.meas tran vdout1_119ck640 FIND v(dout1_119) AT=650.05n

.meas tran vdout1_120ck640 FIND v(dout1_120) AT=650.05n

.meas tran vdout1_121ck640 FIND v(dout1_121) AT=650.05n

.meas tran vdout1_122ck640 FIND v(dout1_122) AT=650.05n

.meas tran vdout1_123ck640 FIND v(dout1_123) AT=650.05n

.meas tran vdout1_124ck640 FIND v(dout1_124) AT=650.05n

.meas tran vdout1_125ck640 FIND v(dout1_125) AT=650.05n

.meas tran vdout1_126ck640 FIND v(dout1_126) AT=650.05n

.meas tran vdout1_127ck640 FIND v(dout1_127) AT=650.05n

.meas tran vdout1_128ck640 FIND v(dout1_128) AT=650.05n

.meas tran vdout1_129ck640 FIND v(dout1_129) AT=650.05n

.meas tran vdout1_130ck640 FIND v(dout1_130) AT=650.05n

.meas tran vdout1_131ck640 FIND v(dout1_131) AT=650.05n

.meas tran vdout1_132ck640 FIND v(dout1_132) AT=650.05n

.meas tran vdout1_133ck640 FIND v(dout1_133) AT=650.05n

.meas tran vdout1_134ck640 FIND v(dout1_134) AT=650.05n

.meas tran vdout1_0ck660 FIND v(dout1_0) AT=670.05n

.meas tran vdout1_1ck660 FIND v(dout1_1) AT=670.05n

.meas tran vdout1_2ck660 FIND v(dout1_2) AT=670.05n

.meas tran vdout1_3ck660 FIND v(dout1_3) AT=670.05n

.meas tran vdout1_4ck660 FIND v(dout1_4) AT=670.05n

.meas tran vdout1_5ck660 FIND v(dout1_5) AT=670.05n

.meas tran vdout1_6ck660 FIND v(dout1_6) AT=670.05n

.meas tran vdout1_7ck660 FIND v(dout1_7) AT=670.05n

.meas tran vdout1_8ck660 FIND v(dout1_8) AT=670.05n

.meas tran vdout1_9ck660 FIND v(dout1_9) AT=670.05n

.meas tran vdout1_10ck660 FIND v(dout1_10) AT=670.05n

.meas tran vdout1_11ck660 FIND v(dout1_11) AT=670.05n

.meas tran vdout1_12ck660 FIND v(dout1_12) AT=670.05n

.meas tran vdout1_13ck660 FIND v(dout1_13) AT=670.05n

.meas tran vdout1_14ck660 FIND v(dout1_14) AT=670.05n

.meas tran vdout1_15ck660 FIND v(dout1_15) AT=670.05n

.meas tran vdout1_16ck660 FIND v(dout1_16) AT=670.05n

.meas tran vdout1_17ck660 FIND v(dout1_17) AT=670.05n

.meas tran vdout1_18ck660 FIND v(dout1_18) AT=670.05n

.meas tran vdout1_19ck660 FIND v(dout1_19) AT=670.05n

.meas tran vdout1_20ck660 FIND v(dout1_20) AT=670.05n

.meas tran vdout1_21ck660 FIND v(dout1_21) AT=670.05n

.meas tran vdout1_22ck660 FIND v(dout1_22) AT=670.05n

.meas tran vdout1_23ck660 FIND v(dout1_23) AT=670.05n

.meas tran vdout1_24ck660 FIND v(dout1_24) AT=670.05n

.meas tran vdout1_25ck660 FIND v(dout1_25) AT=670.05n

.meas tran vdout1_26ck660 FIND v(dout1_26) AT=670.05n

.meas tran vdout1_27ck660 FIND v(dout1_27) AT=670.05n

.meas tran vdout1_28ck660 FIND v(dout1_28) AT=670.05n

.meas tran vdout1_29ck660 FIND v(dout1_29) AT=670.05n

.meas tran vdout1_30ck660 FIND v(dout1_30) AT=670.05n

.meas tran vdout1_31ck660 FIND v(dout1_31) AT=670.05n

.meas tran vdout1_32ck660 FIND v(dout1_32) AT=670.05n

.meas tran vdout1_33ck660 FIND v(dout1_33) AT=670.05n

.meas tran vdout1_34ck660 FIND v(dout1_34) AT=670.05n

.meas tran vdout1_35ck660 FIND v(dout1_35) AT=670.05n

.meas tran vdout1_36ck660 FIND v(dout1_36) AT=670.05n

.meas tran vdout1_37ck660 FIND v(dout1_37) AT=670.05n

.meas tran vdout1_38ck660 FIND v(dout1_38) AT=670.05n

.meas tran vdout1_39ck660 FIND v(dout1_39) AT=670.05n

.meas tran vdout1_40ck660 FIND v(dout1_40) AT=670.05n

.meas tran vdout1_41ck660 FIND v(dout1_41) AT=670.05n

.meas tran vdout1_42ck660 FIND v(dout1_42) AT=670.05n

.meas tran vdout1_43ck660 FIND v(dout1_43) AT=670.05n

.meas tran vdout1_44ck660 FIND v(dout1_44) AT=670.05n

.meas tran vdout1_45ck660 FIND v(dout1_45) AT=670.05n

.meas tran vdout1_46ck660 FIND v(dout1_46) AT=670.05n

.meas tran vdout1_47ck660 FIND v(dout1_47) AT=670.05n

.meas tran vdout1_48ck660 FIND v(dout1_48) AT=670.05n

.meas tran vdout1_49ck660 FIND v(dout1_49) AT=670.05n

.meas tran vdout1_50ck660 FIND v(dout1_50) AT=670.05n

.meas tran vdout1_51ck660 FIND v(dout1_51) AT=670.05n

.meas tran vdout1_52ck660 FIND v(dout1_52) AT=670.05n

.meas tran vdout1_53ck660 FIND v(dout1_53) AT=670.05n

.meas tran vdout1_54ck660 FIND v(dout1_54) AT=670.05n

.meas tran vdout1_55ck660 FIND v(dout1_55) AT=670.05n

.meas tran vdout1_56ck660 FIND v(dout1_56) AT=670.05n

.meas tran vdout1_57ck660 FIND v(dout1_57) AT=670.05n

.meas tran vdout1_58ck660 FIND v(dout1_58) AT=670.05n

.meas tran vdout1_59ck660 FIND v(dout1_59) AT=670.05n

.meas tran vdout1_60ck660 FIND v(dout1_60) AT=670.05n

.meas tran vdout1_61ck660 FIND v(dout1_61) AT=670.05n

.meas tran vdout1_62ck660 FIND v(dout1_62) AT=670.05n

.meas tran vdout1_63ck660 FIND v(dout1_63) AT=670.05n

.meas tran vdout1_64ck660 FIND v(dout1_64) AT=670.05n

.meas tran vdout1_65ck660 FIND v(dout1_65) AT=670.05n

.meas tran vdout1_66ck660 FIND v(dout1_66) AT=670.05n

.meas tran vdout1_67ck660 FIND v(dout1_67) AT=670.05n

.meas tran vdout1_68ck660 FIND v(dout1_68) AT=670.05n

.meas tran vdout1_69ck660 FIND v(dout1_69) AT=670.05n

.meas tran vdout1_70ck660 FIND v(dout1_70) AT=670.05n

.meas tran vdout1_71ck660 FIND v(dout1_71) AT=670.05n

.meas tran vdout1_72ck660 FIND v(dout1_72) AT=670.05n

.meas tran vdout1_73ck660 FIND v(dout1_73) AT=670.05n

.meas tran vdout1_74ck660 FIND v(dout1_74) AT=670.05n

.meas tran vdout1_75ck660 FIND v(dout1_75) AT=670.05n

.meas tran vdout1_76ck660 FIND v(dout1_76) AT=670.05n

.meas tran vdout1_77ck660 FIND v(dout1_77) AT=670.05n

.meas tran vdout1_78ck660 FIND v(dout1_78) AT=670.05n

.meas tran vdout1_79ck660 FIND v(dout1_79) AT=670.05n

.meas tran vdout1_80ck660 FIND v(dout1_80) AT=670.05n

.meas tran vdout1_81ck660 FIND v(dout1_81) AT=670.05n

.meas tran vdout1_82ck660 FIND v(dout1_82) AT=670.05n

.meas tran vdout1_83ck660 FIND v(dout1_83) AT=670.05n

.meas tran vdout1_84ck660 FIND v(dout1_84) AT=670.05n

.meas tran vdout1_85ck660 FIND v(dout1_85) AT=670.05n

.meas tran vdout1_86ck660 FIND v(dout1_86) AT=670.05n

.meas tran vdout1_87ck660 FIND v(dout1_87) AT=670.05n

.meas tran vdout1_88ck660 FIND v(dout1_88) AT=670.05n

.meas tran vdout1_89ck660 FIND v(dout1_89) AT=670.05n

.meas tran vdout1_90ck660 FIND v(dout1_90) AT=670.05n

.meas tran vdout1_91ck660 FIND v(dout1_91) AT=670.05n

.meas tran vdout1_92ck660 FIND v(dout1_92) AT=670.05n

.meas tran vdout1_93ck660 FIND v(dout1_93) AT=670.05n

.meas tran vdout1_94ck660 FIND v(dout1_94) AT=670.05n

.meas tran vdout1_95ck660 FIND v(dout1_95) AT=670.05n

.meas tran vdout1_96ck660 FIND v(dout1_96) AT=670.05n

.meas tran vdout1_97ck660 FIND v(dout1_97) AT=670.05n

.meas tran vdout1_98ck660 FIND v(dout1_98) AT=670.05n

.meas tran vdout1_99ck660 FIND v(dout1_99) AT=670.05n

.meas tran vdout1_100ck660 FIND v(dout1_100) AT=670.05n

.meas tran vdout1_101ck660 FIND v(dout1_101) AT=670.05n

.meas tran vdout1_102ck660 FIND v(dout1_102) AT=670.05n

.meas tran vdout1_103ck660 FIND v(dout1_103) AT=670.05n

.meas tran vdout1_104ck660 FIND v(dout1_104) AT=670.05n

.meas tran vdout1_105ck660 FIND v(dout1_105) AT=670.05n

.meas tran vdout1_106ck660 FIND v(dout1_106) AT=670.05n

.meas tran vdout1_107ck660 FIND v(dout1_107) AT=670.05n

.meas tran vdout1_108ck660 FIND v(dout1_108) AT=670.05n

.meas tran vdout1_109ck660 FIND v(dout1_109) AT=670.05n

.meas tran vdout1_110ck660 FIND v(dout1_110) AT=670.05n

.meas tran vdout1_111ck660 FIND v(dout1_111) AT=670.05n

.meas tran vdout1_112ck660 FIND v(dout1_112) AT=670.05n

.meas tran vdout1_113ck660 FIND v(dout1_113) AT=670.05n

.meas tran vdout1_114ck660 FIND v(dout1_114) AT=670.05n

.meas tran vdout1_115ck660 FIND v(dout1_115) AT=670.05n

.meas tran vdout1_116ck660 FIND v(dout1_116) AT=670.05n

.meas tran vdout1_117ck660 FIND v(dout1_117) AT=670.05n

.meas tran vdout1_118ck660 FIND v(dout1_118) AT=670.05n

.meas tran vdout1_119ck660 FIND v(dout1_119) AT=670.05n

.meas tran vdout1_120ck660 FIND v(dout1_120) AT=670.05n

.meas tran vdout1_121ck660 FIND v(dout1_121) AT=670.05n

.meas tran vdout1_122ck660 FIND v(dout1_122) AT=670.05n

.meas tran vdout1_123ck660 FIND v(dout1_123) AT=670.05n

.meas tran vdout1_124ck660 FIND v(dout1_124) AT=670.05n

.meas tran vdout1_125ck660 FIND v(dout1_125) AT=670.05n

.meas tran vdout1_126ck660 FIND v(dout1_126) AT=670.05n

.meas tran vdout1_127ck660 FIND v(dout1_127) AT=670.05n

.meas tran vdout1_128ck660 FIND v(dout1_128) AT=670.05n

.meas tran vdout1_129ck660 FIND v(dout1_129) AT=670.05n

.meas tran vdout1_130ck660 FIND v(dout1_130) AT=670.05n

.meas tran vdout1_131ck660 FIND v(dout1_131) AT=670.05n

.meas tran vdout1_132ck660 FIND v(dout1_132) AT=670.05n

.meas tran vdout1_133ck660 FIND v(dout1_133) AT=670.05n

.meas tran vdout1_134ck660 FIND v(dout1_134) AT=670.05n

.meas tran vdout1_0ck670 FIND v(dout1_0) AT=680.05n

.meas tran vdout1_1ck670 FIND v(dout1_1) AT=680.05n

.meas tran vdout1_2ck670 FIND v(dout1_2) AT=680.05n

.meas tran vdout1_3ck670 FIND v(dout1_3) AT=680.05n

.meas tran vdout1_4ck670 FIND v(dout1_4) AT=680.05n

.meas tran vdout1_5ck670 FIND v(dout1_5) AT=680.05n

.meas tran vdout1_6ck670 FIND v(dout1_6) AT=680.05n

.meas tran vdout1_7ck670 FIND v(dout1_7) AT=680.05n

.meas tran vdout1_8ck670 FIND v(dout1_8) AT=680.05n

.meas tran vdout1_9ck670 FIND v(dout1_9) AT=680.05n

.meas tran vdout1_10ck670 FIND v(dout1_10) AT=680.05n

.meas tran vdout1_11ck670 FIND v(dout1_11) AT=680.05n

.meas tran vdout1_12ck670 FIND v(dout1_12) AT=680.05n

.meas tran vdout1_13ck670 FIND v(dout1_13) AT=680.05n

.meas tran vdout1_14ck670 FIND v(dout1_14) AT=680.05n

.meas tran vdout1_15ck670 FIND v(dout1_15) AT=680.05n

.meas tran vdout1_16ck670 FIND v(dout1_16) AT=680.05n

.meas tran vdout1_17ck670 FIND v(dout1_17) AT=680.05n

.meas tran vdout1_18ck670 FIND v(dout1_18) AT=680.05n

.meas tran vdout1_19ck670 FIND v(dout1_19) AT=680.05n

.meas tran vdout1_20ck670 FIND v(dout1_20) AT=680.05n

.meas tran vdout1_21ck670 FIND v(dout1_21) AT=680.05n

.meas tran vdout1_22ck670 FIND v(dout1_22) AT=680.05n

.meas tran vdout1_23ck670 FIND v(dout1_23) AT=680.05n

.meas tran vdout1_24ck670 FIND v(dout1_24) AT=680.05n

.meas tran vdout1_25ck670 FIND v(dout1_25) AT=680.05n

.meas tran vdout1_26ck670 FIND v(dout1_26) AT=680.05n

.meas tran vdout1_27ck670 FIND v(dout1_27) AT=680.05n

.meas tran vdout1_28ck670 FIND v(dout1_28) AT=680.05n

.meas tran vdout1_29ck670 FIND v(dout1_29) AT=680.05n

.meas tran vdout1_30ck670 FIND v(dout1_30) AT=680.05n

.meas tran vdout1_31ck670 FIND v(dout1_31) AT=680.05n

.meas tran vdout1_32ck670 FIND v(dout1_32) AT=680.05n

.meas tran vdout1_33ck670 FIND v(dout1_33) AT=680.05n

.meas tran vdout1_34ck670 FIND v(dout1_34) AT=680.05n

.meas tran vdout1_35ck670 FIND v(dout1_35) AT=680.05n

.meas tran vdout1_36ck670 FIND v(dout1_36) AT=680.05n

.meas tran vdout1_37ck670 FIND v(dout1_37) AT=680.05n

.meas tran vdout1_38ck670 FIND v(dout1_38) AT=680.05n

.meas tran vdout1_39ck670 FIND v(dout1_39) AT=680.05n

.meas tran vdout1_40ck670 FIND v(dout1_40) AT=680.05n

.meas tran vdout1_41ck670 FIND v(dout1_41) AT=680.05n

.meas tran vdout1_42ck670 FIND v(dout1_42) AT=680.05n

.meas tran vdout1_43ck670 FIND v(dout1_43) AT=680.05n

.meas tran vdout1_44ck670 FIND v(dout1_44) AT=680.05n

.meas tran vdout1_45ck670 FIND v(dout1_45) AT=680.05n

.meas tran vdout1_46ck670 FIND v(dout1_46) AT=680.05n

.meas tran vdout1_47ck670 FIND v(dout1_47) AT=680.05n

.meas tran vdout1_48ck670 FIND v(dout1_48) AT=680.05n

.meas tran vdout1_49ck670 FIND v(dout1_49) AT=680.05n

.meas tran vdout1_50ck670 FIND v(dout1_50) AT=680.05n

.meas tran vdout1_51ck670 FIND v(dout1_51) AT=680.05n

.meas tran vdout1_52ck670 FIND v(dout1_52) AT=680.05n

.meas tran vdout1_53ck670 FIND v(dout1_53) AT=680.05n

.meas tran vdout1_54ck670 FIND v(dout1_54) AT=680.05n

.meas tran vdout1_55ck670 FIND v(dout1_55) AT=680.05n

.meas tran vdout1_56ck670 FIND v(dout1_56) AT=680.05n

.meas tran vdout1_57ck670 FIND v(dout1_57) AT=680.05n

.meas tran vdout1_58ck670 FIND v(dout1_58) AT=680.05n

.meas tran vdout1_59ck670 FIND v(dout1_59) AT=680.05n

.meas tran vdout1_60ck670 FIND v(dout1_60) AT=680.05n

.meas tran vdout1_61ck670 FIND v(dout1_61) AT=680.05n

.meas tran vdout1_62ck670 FIND v(dout1_62) AT=680.05n

.meas tran vdout1_63ck670 FIND v(dout1_63) AT=680.05n

.meas tran vdout1_64ck670 FIND v(dout1_64) AT=680.05n

.meas tran vdout1_65ck670 FIND v(dout1_65) AT=680.05n

.meas tran vdout1_66ck670 FIND v(dout1_66) AT=680.05n

.meas tran vdout1_67ck670 FIND v(dout1_67) AT=680.05n

.meas tran vdout1_68ck670 FIND v(dout1_68) AT=680.05n

.meas tran vdout1_69ck670 FIND v(dout1_69) AT=680.05n

.meas tran vdout1_70ck670 FIND v(dout1_70) AT=680.05n

.meas tran vdout1_71ck670 FIND v(dout1_71) AT=680.05n

.meas tran vdout1_72ck670 FIND v(dout1_72) AT=680.05n

.meas tran vdout1_73ck670 FIND v(dout1_73) AT=680.05n

.meas tran vdout1_74ck670 FIND v(dout1_74) AT=680.05n

.meas tran vdout1_75ck670 FIND v(dout1_75) AT=680.05n

.meas tran vdout1_76ck670 FIND v(dout1_76) AT=680.05n

.meas tran vdout1_77ck670 FIND v(dout1_77) AT=680.05n

.meas tran vdout1_78ck670 FIND v(dout1_78) AT=680.05n

.meas tran vdout1_79ck670 FIND v(dout1_79) AT=680.05n

.meas tran vdout1_80ck670 FIND v(dout1_80) AT=680.05n

.meas tran vdout1_81ck670 FIND v(dout1_81) AT=680.05n

.meas tran vdout1_82ck670 FIND v(dout1_82) AT=680.05n

.meas tran vdout1_83ck670 FIND v(dout1_83) AT=680.05n

.meas tran vdout1_84ck670 FIND v(dout1_84) AT=680.05n

.meas tran vdout1_85ck670 FIND v(dout1_85) AT=680.05n

.meas tran vdout1_86ck670 FIND v(dout1_86) AT=680.05n

.meas tran vdout1_87ck670 FIND v(dout1_87) AT=680.05n

.meas tran vdout1_88ck670 FIND v(dout1_88) AT=680.05n

.meas tran vdout1_89ck670 FIND v(dout1_89) AT=680.05n

.meas tran vdout1_90ck670 FIND v(dout1_90) AT=680.05n

.meas tran vdout1_91ck670 FIND v(dout1_91) AT=680.05n

.meas tran vdout1_92ck670 FIND v(dout1_92) AT=680.05n

.meas tran vdout1_93ck670 FIND v(dout1_93) AT=680.05n

.meas tran vdout1_94ck670 FIND v(dout1_94) AT=680.05n

.meas tran vdout1_95ck670 FIND v(dout1_95) AT=680.05n

.meas tran vdout1_96ck670 FIND v(dout1_96) AT=680.05n

.meas tran vdout1_97ck670 FIND v(dout1_97) AT=680.05n

.meas tran vdout1_98ck670 FIND v(dout1_98) AT=680.05n

.meas tran vdout1_99ck670 FIND v(dout1_99) AT=680.05n

.meas tran vdout1_100ck670 FIND v(dout1_100) AT=680.05n

.meas tran vdout1_101ck670 FIND v(dout1_101) AT=680.05n

.meas tran vdout1_102ck670 FIND v(dout1_102) AT=680.05n

.meas tran vdout1_103ck670 FIND v(dout1_103) AT=680.05n

.meas tran vdout1_104ck670 FIND v(dout1_104) AT=680.05n

.meas tran vdout1_105ck670 FIND v(dout1_105) AT=680.05n

.meas tran vdout1_106ck670 FIND v(dout1_106) AT=680.05n

.meas tran vdout1_107ck670 FIND v(dout1_107) AT=680.05n

.meas tran vdout1_108ck670 FIND v(dout1_108) AT=680.05n

.meas tran vdout1_109ck670 FIND v(dout1_109) AT=680.05n

.meas tran vdout1_110ck670 FIND v(dout1_110) AT=680.05n

.meas tran vdout1_111ck670 FIND v(dout1_111) AT=680.05n

.meas tran vdout1_112ck670 FIND v(dout1_112) AT=680.05n

.meas tran vdout1_113ck670 FIND v(dout1_113) AT=680.05n

.meas tran vdout1_114ck670 FIND v(dout1_114) AT=680.05n

.meas tran vdout1_115ck670 FIND v(dout1_115) AT=680.05n

.meas tran vdout1_116ck670 FIND v(dout1_116) AT=680.05n

.meas tran vdout1_117ck670 FIND v(dout1_117) AT=680.05n

.meas tran vdout1_118ck670 FIND v(dout1_118) AT=680.05n

.meas tran vdout1_119ck670 FIND v(dout1_119) AT=680.05n

.meas tran vdout1_120ck670 FIND v(dout1_120) AT=680.05n

.meas tran vdout1_121ck670 FIND v(dout1_121) AT=680.05n

.meas tran vdout1_122ck670 FIND v(dout1_122) AT=680.05n

.meas tran vdout1_123ck670 FIND v(dout1_123) AT=680.05n

.meas tran vdout1_124ck670 FIND v(dout1_124) AT=680.05n

.meas tran vdout1_125ck670 FIND v(dout1_125) AT=680.05n

.meas tran vdout1_126ck670 FIND v(dout1_126) AT=680.05n

.meas tran vdout1_127ck670 FIND v(dout1_127) AT=680.05n

.meas tran vdout1_128ck670 FIND v(dout1_128) AT=680.05n

.meas tran vdout1_129ck670 FIND v(dout1_129) AT=680.05n

.meas tran vdout1_130ck670 FIND v(dout1_130) AT=680.05n

.meas tran vdout1_131ck670 FIND v(dout1_131) AT=680.05n

.meas tran vdout1_132ck670 FIND v(dout1_132) AT=680.05n

.meas tran vdout1_133ck670 FIND v(dout1_133) AT=680.05n

.meas tran vdout1_134ck670 FIND v(dout1_134) AT=680.05n

.meas tran vdout1_0ck710 FIND v(dout1_0) AT=720.05n

.meas tran vdout1_1ck710 FIND v(dout1_1) AT=720.05n

.meas tran vdout1_2ck710 FIND v(dout1_2) AT=720.05n

.meas tran vdout1_3ck710 FIND v(dout1_3) AT=720.05n

.meas tran vdout1_4ck710 FIND v(dout1_4) AT=720.05n

.meas tran vdout1_5ck710 FIND v(dout1_5) AT=720.05n

.meas tran vdout1_6ck710 FIND v(dout1_6) AT=720.05n

.meas tran vdout1_7ck710 FIND v(dout1_7) AT=720.05n

.meas tran vdout1_8ck710 FIND v(dout1_8) AT=720.05n

.meas tran vdout1_9ck710 FIND v(dout1_9) AT=720.05n

.meas tran vdout1_10ck710 FIND v(dout1_10) AT=720.05n

.meas tran vdout1_11ck710 FIND v(dout1_11) AT=720.05n

.meas tran vdout1_12ck710 FIND v(dout1_12) AT=720.05n

.meas tran vdout1_13ck710 FIND v(dout1_13) AT=720.05n

.meas tran vdout1_14ck710 FIND v(dout1_14) AT=720.05n

.meas tran vdout1_15ck710 FIND v(dout1_15) AT=720.05n

.meas tran vdout1_16ck710 FIND v(dout1_16) AT=720.05n

.meas tran vdout1_17ck710 FIND v(dout1_17) AT=720.05n

.meas tran vdout1_18ck710 FIND v(dout1_18) AT=720.05n

.meas tran vdout1_19ck710 FIND v(dout1_19) AT=720.05n

.meas tran vdout1_20ck710 FIND v(dout1_20) AT=720.05n

.meas tran vdout1_21ck710 FIND v(dout1_21) AT=720.05n

.meas tran vdout1_22ck710 FIND v(dout1_22) AT=720.05n

.meas tran vdout1_23ck710 FIND v(dout1_23) AT=720.05n

.meas tran vdout1_24ck710 FIND v(dout1_24) AT=720.05n

.meas tran vdout1_25ck710 FIND v(dout1_25) AT=720.05n

.meas tran vdout1_26ck710 FIND v(dout1_26) AT=720.05n

.meas tran vdout1_27ck710 FIND v(dout1_27) AT=720.05n

.meas tran vdout1_28ck710 FIND v(dout1_28) AT=720.05n

.meas tran vdout1_29ck710 FIND v(dout1_29) AT=720.05n

.meas tran vdout1_30ck710 FIND v(dout1_30) AT=720.05n

.meas tran vdout1_31ck710 FIND v(dout1_31) AT=720.05n

.meas tran vdout1_32ck710 FIND v(dout1_32) AT=720.05n

.meas tran vdout1_33ck710 FIND v(dout1_33) AT=720.05n

.meas tran vdout1_34ck710 FIND v(dout1_34) AT=720.05n

.meas tran vdout1_35ck710 FIND v(dout1_35) AT=720.05n

.meas tran vdout1_36ck710 FIND v(dout1_36) AT=720.05n

.meas tran vdout1_37ck710 FIND v(dout1_37) AT=720.05n

.meas tran vdout1_38ck710 FIND v(dout1_38) AT=720.05n

.meas tran vdout1_39ck710 FIND v(dout1_39) AT=720.05n

.meas tran vdout1_40ck710 FIND v(dout1_40) AT=720.05n

.meas tran vdout1_41ck710 FIND v(dout1_41) AT=720.05n

.meas tran vdout1_42ck710 FIND v(dout1_42) AT=720.05n

.meas tran vdout1_43ck710 FIND v(dout1_43) AT=720.05n

.meas tran vdout1_44ck710 FIND v(dout1_44) AT=720.05n

.meas tran vdout1_45ck710 FIND v(dout1_45) AT=720.05n

.meas tran vdout1_46ck710 FIND v(dout1_46) AT=720.05n

.meas tran vdout1_47ck710 FIND v(dout1_47) AT=720.05n

.meas tran vdout1_48ck710 FIND v(dout1_48) AT=720.05n

.meas tran vdout1_49ck710 FIND v(dout1_49) AT=720.05n

.meas tran vdout1_50ck710 FIND v(dout1_50) AT=720.05n

.meas tran vdout1_51ck710 FIND v(dout1_51) AT=720.05n

.meas tran vdout1_52ck710 FIND v(dout1_52) AT=720.05n

.meas tran vdout1_53ck710 FIND v(dout1_53) AT=720.05n

.meas tran vdout1_54ck710 FIND v(dout1_54) AT=720.05n

.meas tran vdout1_55ck710 FIND v(dout1_55) AT=720.05n

.meas tran vdout1_56ck710 FIND v(dout1_56) AT=720.05n

.meas tran vdout1_57ck710 FIND v(dout1_57) AT=720.05n

.meas tran vdout1_58ck710 FIND v(dout1_58) AT=720.05n

.meas tran vdout1_59ck710 FIND v(dout1_59) AT=720.05n

.meas tran vdout1_60ck710 FIND v(dout1_60) AT=720.05n

.meas tran vdout1_61ck710 FIND v(dout1_61) AT=720.05n

.meas tran vdout1_62ck710 FIND v(dout1_62) AT=720.05n

.meas tran vdout1_63ck710 FIND v(dout1_63) AT=720.05n

.meas tran vdout1_64ck710 FIND v(dout1_64) AT=720.05n

.meas tran vdout1_65ck710 FIND v(dout1_65) AT=720.05n

.meas tran vdout1_66ck710 FIND v(dout1_66) AT=720.05n

.meas tran vdout1_67ck710 FIND v(dout1_67) AT=720.05n

.meas tran vdout1_68ck710 FIND v(dout1_68) AT=720.05n

.meas tran vdout1_69ck710 FIND v(dout1_69) AT=720.05n

.meas tran vdout1_70ck710 FIND v(dout1_70) AT=720.05n

.meas tran vdout1_71ck710 FIND v(dout1_71) AT=720.05n

.meas tran vdout1_72ck710 FIND v(dout1_72) AT=720.05n

.meas tran vdout1_73ck710 FIND v(dout1_73) AT=720.05n

.meas tran vdout1_74ck710 FIND v(dout1_74) AT=720.05n

.meas tran vdout1_75ck710 FIND v(dout1_75) AT=720.05n

.meas tran vdout1_76ck710 FIND v(dout1_76) AT=720.05n

.meas tran vdout1_77ck710 FIND v(dout1_77) AT=720.05n

.meas tran vdout1_78ck710 FIND v(dout1_78) AT=720.05n

.meas tran vdout1_79ck710 FIND v(dout1_79) AT=720.05n

.meas tran vdout1_80ck710 FIND v(dout1_80) AT=720.05n

.meas tran vdout1_81ck710 FIND v(dout1_81) AT=720.05n

.meas tran vdout1_82ck710 FIND v(dout1_82) AT=720.05n

.meas tran vdout1_83ck710 FIND v(dout1_83) AT=720.05n

.meas tran vdout1_84ck710 FIND v(dout1_84) AT=720.05n

.meas tran vdout1_85ck710 FIND v(dout1_85) AT=720.05n

.meas tran vdout1_86ck710 FIND v(dout1_86) AT=720.05n

.meas tran vdout1_87ck710 FIND v(dout1_87) AT=720.05n

.meas tran vdout1_88ck710 FIND v(dout1_88) AT=720.05n

.meas tran vdout1_89ck710 FIND v(dout1_89) AT=720.05n

.meas tran vdout1_90ck710 FIND v(dout1_90) AT=720.05n

.meas tran vdout1_91ck710 FIND v(dout1_91) AT=720.05n

.meas tran vdout1_92ck710 FIND v(dout1_92) AT=720.05n

.meas tran vdout1_93ck710 FIND v(dout1_93) AT=720.05n

.meas tran vdout1_94ck710 FIND v(dout1_94) AT=720.05n

.meas tran vdout1_95ck710 FIND v(dout1_95) AT=720.05n

.meas tran vdout1_96ck710 FIND v(dout1_96) AT=720.05n

.meas tran vdout1_97ck710 FIND v(dout1_97) AT=720.05n

.meas tran vdout1_98ck710 FIND v(dout1_98) AT=720.05n

.meas tran vdout1_99ck710 FIND v(dout1_99) AT=720.05n

.meas tran vdout1_100ck710 FIND v(dout1_100) AT=720.05n

.meas tran vdout1_101ck710 FIND v(dout1_101) AT=720.05n

.meas tran vdout1_102ck710 FIND v(dout1_102) AT=720.05n

.meas tran vdout1_103ck710 FIND v(dout1_103) AT=720.05n

.meas tran vdout1_104ck710 FIND v(dout1_104) AT=720.05n

.meas tran vdout1_105ck710 FIND v(dout1_105) AT=720.05n

.meas tran vdout1_106ck710 FIND v(dout1_106) AT=720.05n

.meas tran vdout1_107ck710 FIND v(dout1_107) AT=720.05n

.meas tran vdout1_108ck710 FIND v(dout1_108) AT=720.05n

.meas tran vdout1_109ck710 FIND v(dout1_109) AT=720.05n

.meas tran vdout1_110ck710 FIND v(dout1_110) AT=720.05n

.meas tran vdout1_111ck710 FIND v(dout1_111) AT=720.05n

.meas tran vdout1_112ck710 FIND v(dout1_112) AT=720.05n

.meas tran vdout1_113ck710 FIND v(dout1_113) AT=720.05n

.meas tran vdout1_114ck710 FIND v(dout1_114) AT=720.05n

.meas tran vdout1_115ck710 FIND v(dout1_115) AT=720.05n

.meas tran vdout1_116ck710 FIND v(dout1_116) AT=720.05n

.meas tran vdout1_117ck710 FIND v(dout1_117) AT=720.05n

.meas tran vdout1_118ck710 FIND v(dout1_118) AT=720.05n

.meas tran vdout1_119ck710 FIND v(dout1_119) AT=720.05n

.meas tran vdout1_120ck710 FIND v(dout1_120) AT=720.05n

.meas tran vdout1_121ck710 FIND v(dout1_121) AT=720.05n

.meas tran vdout1_122ck710 FIND v(dout1_122) AT=720.05n

.meas tran vdout1_123ck710 FIND v(dout1_123) AT=720.05n

.meas tran vdout1_124ck710 FIND v(dout1_124) AT=720.05n

.meas tran vdout1_125ck710 FIND v(dout1_125) AT=720.05n

.meas tran vdout1_126ck710 FIND v(dout1_126) AT=720.05n

.meas tran vdout1_127ck710 FIND v(dout1_127) AT=720.05n

.meas tran vdout1_128ck710 FIND v(dout1_128) AT=720.05n

.meas tran vdout1_129ck710 FIND v(dout1_129) AT=720.05n

.meas tran vdout1_130ck710 FIND v(dout1_130) AT=720.05n

.meas tran vdout1_131ck710 FIND v(dout1_131) AT=720.05n

.meas tran vdout1_132ck710 FIND v(dout1_132) AT=720.05n

.meas tran vdout1_133ck710 FIND v(dout1_133) AT=720.05n

.meas tran vdout1_134ck710 FIND v(dout1_134) AT=720.05n

.meas tran vdout1_0ck720 FIND v(dout1_0) AT=730.05n

.meas tran vdout1_1ck720 FIND v(dout1_1) AT=730.05n

.meas tran vdout1_2ck720 FIND v(dout1_2) AT=730.05n

.meas tran vdout1_3ck720 FIND v(dout1_3) AT=730.05n

.meas tran vdout1_4ck720 FIND v(dout1_4) AT=730.05n

.meas tran vdout1_5ck720 FIND v(dout1_5) AT=730.05n

.meas tran vdout1_6ck720 FIND v(dout1_6) AT=730.05n

.meas tran vdout1_7ck720 FIND v(dout1_7) AT=730.05n

.meas tran vdout1_8ck720 FIND v(dout1_8) AT=730.05n

.meas tran vdout1_9ck720 FIND v(dout1_9) AT=730.05n

.meas tran vdout1_10ck720 FIND v(dout1_10) AT=730.05n

.meas tran vdout1_11ck720 FIND v(dout1_11) AT=730.05n

.meas tran vdout1_12ck720 FIND v(dout1_12) AT=730.05n

.meas tran vdout1_13ck720 FIND v(dout1_13) AT=730.05n

.meas tran vdout1_14ck720 FIND v(dout1_14) AT=730.05n

.meas tran vdout1_15ck720 FIND v(dout1_15) AT=730.05n

.meas tran vdout1_16ck720 FIND v(dout1_16) AT=730.05n

.meas tran vdout1_17ck720 FIND v(dout1_17) AT=730.05n

.meas tran vdout1_18ck720 FIND v(dout1_18) AT=730.05n

.meas tran vdout1_19ck720 FIND v(dout1_19) AT=730.05n

.meas tran vdout1_20ck720 FIND v(dout1_20) AT=730.05n

.meas tran vdout1_21ck720 FIND v(dout1_21) AT=730.05n

.meas tran vdout1_22ck720 FIND v(dout1_22) AT=730.05n

.meas tran vdout1_23ck720 FIND v(dout1_23) AT=730.05n

.meas tran vdout1_24ck720 FIND v(dout1_24) AT=730.05n

.meas tran vdout1_25ck720 FIND v(dout1_25) AT=730.05n

.meas tran vdout1_26ck720 FIND v(dout1_26) AT=730.05n

.meas tran vdout1_27ck720 FIND v(dout1_27) AT=730.05n

.meas tran vdout1_28ck720 FIND v(dout1_28) AT=730.05n

.meas tran vdout1_29ck720 FIND v(dout1_29) AT=730.05n

.meas tran vdout1_30ck720 FIND v(dout1_30) AT=730.05n

.meas tran vdout1_31ck720 FIND v(dout1_31) AT=730.05n

.meas tran vdout1_32ck720 FIND v(dout1_32) AT=730.05n

.meas tran vdout1_33ck720 FIND v(dout1_33) AT=730.05n

.meas tran vdout1_34ck720 FIND v(dout1_34) AT=730.05n

.meas tran vdout1_35ck720 FIND v(dout1_35) AT=730.05n

.meas tran vdout1_36ck720 FIND v(dout1_36) AT=730.05n

.meas tran vdout1_37ck720 FIND v(dout1_37) AT=730.05n

.meas tran vdout1_38ck720 FIND v(dout1_38) AT=730.05n

.meas tran vdout1_39ck720 FIND v(dout1_39) AT=730.05n

.meas tran vdout1_40ck720 FIND v(dout1_40) AT=730.05n

.meas tran vdout1_41ck720 FIND v(dout1_41) AT=730.05n

.meas tran vdout1_42ck720 FIND v(dout1_42) AT=730.05n

.meas tran vdout1_43ck720 FIND v(dout1_43) AT=730.05n

.meas tran vdout1_44ck720 FIND v(dout1_44) AT=730.05n

.meas tran vdout1_45ck720 FIND v(dout1_45) AT=730.05n

.meas tran vdout1_46ck720 FIND v(dout1_46) AT=730.05n

.meas tran vdout1_47ck720 FIND v(dout1_47) AT=730.05n

.meas tran vdout1_48ck720 FIND v(dout1_48) AT=730.05n

.meas tran vdout1_49ck720 FIND v(dout1_49) AT=730.05n

.meas tran vdout1_50ck720 FIND v(dout1_50) AT=730.05n

.meas tran vdout1_51ck720 FIND v(dout1_51) AT=730.05n

.meas tran vdout1_52ck720 FIND v(dout1_52) AT=730.05n

.meas tran vdout1_53ck720 FIND v(dout1_53) AT=730.05n

.meas tran vdout1_54ck720 FIND v(dout1_54) AT=730.05n

.meas tran vdout1_55ck720 FIND v(dout1_55) AT=730.05n

.meas tran vdout1_56ck720 FIND v(dout1_56) AT=730.05n

.meas tran vdout1_57ck720 FIND v(dout1_57) AT=730.05n

.meas tran vdout1_58ck720 FIND v(dout1_58) AT=730.05n

.meas tran vdout1_59ck720 FIND v(dout1_59) AT=730.05n

.meas tran vdout1_60ck720 FIND v(dout1_60) AT=730.05n

.meas tran vdout1_61ck720 FIND v(dout1_61) AT=730.05n

.meas tran vdout1_62ck720 FIND v(dout1_62) AT=730.05n

.meas tran vdout1_63ck720 FIND v(dout1_63) AT=730.05n

.meas tran vdout1_64ck720 FIND v(dout1_64) AT=730.05n

.meas tran vdout1_65ck720 FIND v(dout1_65) AT=730.05n

.meas tran vdout1_66ck720 FIND v(dout1_66) AT=730.05n

.meas tran vdout1_67ck720 FIND v(dout1_67) AT=730.05n

.meas tran vdout1_68ck720 FIND v(dout1_68) AT=730.05n

.meas tran vdout1_69ck720 FIND v(dout1_69) AT=730.05n

.meas tran vdout1_70ck720 FIND v(dout1_70) AT=730.05n

.meas tran vdout1_71ck720 FIND v(dout1_71) AT=730.05n

.meas tran vdout1_72ck720 FIND v(dout1_72) AT=730.05n

.meas tran vdout1_73ck720 FIND v(dout1_73) AT=730.05n

.meas tran vdout1_74ck720 FIND v(dout1_74) AT=730.05n

.meas tran vdout1_75ck720 FIND v(dout1_75) AT=730.05n

.meas tran vdout1_76ck720 FIND v(dout1_76) AT=730.05n

.meas tran vdout1_77ck720 FIND v(dout1_77) AT=730.05n

.meas tran vdout1_78ck720 FIND v(dout1_78) AT=730.05n

.meas tran vdout1_79ck720 FIND v(dout1_79) AT=730.05n

.meas tran vdout1_80ck720 FIND v(dout1_80) AT=730.05n

.meas tran vdout1_81ck720 FIND v(dout1_81) AT=730.05n

.meas tran vdout1_82ck720 FIND v(dout1_82) AT=730.05n

.meas tran vdout1_83ck720 FIND v(dout1_83) AT=730.05n

.meas tran vdout1_84ck720 FIND v(dout1_84) AT=730.05n

.meas tran vdout1_85ck720 FIND v(dout1_85) AT=730.05n

.meas tran vdout1_86ck720 FIND v(dout1_86) AT=730.05n

.meas tran vdout1_87ck720 FIND v(dout1_87) AT=730.05n

.meas tran vdout1_88ck720 FIND v(dout1_88) AT=730.05n

.meas tran vdout1_89ck720 FIND v(dout1_89) AT=730.05n

.meas tran vdout1_90ck720 FIND v(dout1_90) AT=730.05n

.meas tran vdout1_91ck720 FIND v(dout1_91) AT=730.05n

.meas tran vdout1_92ck720 FIND v(dout1_92) AT=730.05n

.meas tran vdout1_93ck720 FIND v(dout1_93) AT=730.05n

.meas tran vdout1_94ck720 FIND v(dout1_94) AT=730.05n

.meas tran vdout1_95ck720 FIND v(dout1_95) AT=730.05n

.meas tran vdout1_96ck720 FIND v(dout1_96) AT=730.05n

.meas tran vdout1_97ck720 FIND v(dout1_97) AT=730.05n

.meas tran vdout1_98ck720 FIND v(dout1_98) AT=730.05n

.meas tran vdout1_99ck720 FIND v(dout1_99) AT=730.05n

.meas tran vdout1_100ck720 FIND v(dout1_100) AT=730.05n

.meas tran vdout1_101ck720 FIND v(dout1_101) AT=730.05n

.meas tran vdout1_102ck720 FIND v(dout1_102) AT=730.05n

.meas tran vdout1_103ck720 FIND v(dout1_103) AT=730.05n

.meas tran vdout1_104ck720 FIND v(dout1_104) AT=730.05n

.meas tran vdout1_105ck720 FIND v(dout1_105) AT=730.05n

.meas tran vdout1_106ck720 FIND v(dout1_106) AT=730.05n

.meas tran vdout1_107ck720 FIND v(dout1_107) AT=730.05n

.meas tran vdout1_108ck720 FIND v(dout1_108) AT=730.05n

.meas tran vdout1_109ck720 FIND v(dout1_109) AT=730.05n

.meas tran vdout1_110ck720 FIND v(dout1_110) AT=730.05n

.meas tran vdout1_111ck720 FIND v(dout1_111) AT=730.05n

.meas tran vdout1_112ck720 FIND v(dout1_112) AT=730.05n

.meas tran vdout1_113ck720 FIND v(dout1_113) AT=730.05n

.meas tran vdout1_114ck720 FIND v(dout1_114) AT=730.05n

.meas tran vdout1_115ck720 FIND v(dout1_115) AT=730.05n

.meas tran vdout1_116ck720 FIND v(dout1_116) AT=730.05n

.meas tran vdout1_117ck720 FIND v(dout1_117) AT=730.05n

.meas tran vdout1_118ck720 FIND v(dout1_118) AT=730.05n

.meas tran vdout1_119ck720 FIND v(dout1_119) AT=730.05n

.meas tran vdout1_120ck720 FIND v(dout1_120) AT=730.05n

.meas tran vdout1_121ck720 FIND v(dout1_121) AT=730.05n

.meas tran vdout1_122ck720 FIND v(dout1_122) AT=730.05n

.meas tran vdout1_123ck720 FIND v(dout1_123) AT=730.05n

.meas tran vdout1_124ck720 FIND v(dout1_124) AT=730.05n

.meas tran vdout1_125ck720 FIND v(dout1_125) AT=730.05n

.meas tran vdout1_126ck720 FIND v(dout1_126) AT=730.05n

.meas tran vdout1_127ck720 FIND v(dout1_127) AT=730.05n

.meas tran vdout1_128ck720 FIND v(dout1_128) AT=730.05n

.meas tran vdout1_129ck720 FIND v(dout1_129) AT=730.05n

.meas tran vdout1_130ck720 FIND v(dout1_130) AT=730.05n

.meas tran vdout1_131ck720 FIND v(dout1_131) AT=730.05n

.meas tran vdout1_132ck720 FIND v(dout1_132) AT=730.05n

.meas tran vdout1_133ck720 FIND v(dout1_133) AT=730.05n

.meas tran vdout1_134ck720 FIND v(dout1_134) AT=730.05n

.meas tran vdout1_0ck730 FIND v(dout1_0) AT=740.05n

.meas tran vdout1_1ck730 FIND v(dout1_1) AT=740.05n

.meas tran vdout1_2ck730 FIND v(dout1_2) AT=740.05n

.meas tran vdout1_3ck730 FIND v(dout1_3) AT=740.05n

.meas tran vdout1_4ck730 FIND v(dout1_4) AT=740.05n

.meas tran vdout1_5ck730 FIND v(dout1_5) AT=740.05n

.meas tran vdout1_6ck730 FIND v(dout1_6) AT=740.05n

.meas tran vdout1_7ck730 FIND v(dout1_7) AT=740.05n

.meas tran vdout1_8ck730 FIND v(dout1_8) AT=740.05n

.meas tran vdout1_9ck730 FIND v(dout1_9) AT=740.05n

.meas tran vdout1_10ck730 FIND v(dout1_10) AT=740.05n

.meas tran vdout1_11ck730 FIND v(dout1_11) AT=740.05n

.meas tran vdout1_12ck730 FIND v(dout1_12) AT=740.05n

.meas tran vdout1_13ck730 FIND v(dout1_13) AT=740.05n

.meas tran vdout1_14ck730 FIND v(dout1_14) AT=740.05n

.meas tran vdout1_15ck730 FIND v(dout1_15) AT=740.05n

.meas tran vdout1_16ck730 FIND v(dout1_16) AT=740.05n

.meas tran vdout1_17ck730 FIND v(dout1_17) AT=740.05n

.meas tran vdout1_18ck730 FIND v(dout1_18) AT=740.05n

.meas tran vdout1_19ck730 FIND v(dout1_19) AT=740.05n

.meas tran vdout1_20ck730 FIND v(dout1_20) AT=740.05n

.meas tran vdout1_21ck730 FIND v(dout1_21) AT=740.05n

.meas tran vdout1_22ck730 FIND v(dout1_22) AT=740.05n

.meas tran vdout1_23ck730 FIND v(dout1_23) AT=740.05n

.meas tran vdout1_24ck730 FIND v(dout1_24) AT=740.05n

.meas tran vdout1_25ck730 FIND v(dout1_25) AT=740.05n

.meas tran vdout1_26ck730 FIND v(dout1_26) AT=740.05n

.meas tran vdout1_27ck730 FIND v(dout1_27) AT=740.05n

.meas tran vdout1_28ck730 FIND v(dout1_28) AT=740.05n

.meas tran vdout1_29ck730 FIND v(dout1_29) AT=740.05n

.meas tran vdout1_30ck730 FIND v(dout1_30) AT=740.05n

.meas tran vdout1_31ck730 FIND v(dout1_31) AT=740.05n

.meas tran vdout1_32ck730 FIND v(dout1_32) AT=740.05n

.meas tran vdout1_33ck730 FIND v(dout1_33) AT=740.05n

.meas tran vdout1_34ck730 FIND v(dout1_34) AT=740.05n

.meas tran vdout1_35ck730 FIND v(dout1_35) AT=740.05n

.meas tran vdout1_36ck730 FIND v(dout1_36) AT=740.05n

.meas tran vdout1_37ck730 FIND v(dout1_37) AT=740.05n

.meas tran vdout1_38ck730 FIND v(dout1_38) AT=740.05n

.meas tran vdout1_39ck730 FIND v(dout1_39) AT=740.05n

.meas tran vdout1_40ck730 FIND v(dout1_40) AT=740.05n

.meas tran vdout1_41ck730 FIND v(dout1_41) AT=740.05n

.meas tran vdout1_42ck730 FIND v(dout1_42) AT=740.05n

.meas tran vdout1_43ck730 FIND v(dout1_43) AT=740.05n

.meas tran vdout1_44ck730 FIND v(dout1_44) AT=740.05n

.meas tran vdout1_45ck730 FIND v(dout1_45) AT=740.05n

.meas tran vdout1_46ck730 FIND v(dout1_46) AT=740.05n

.meas tran vdout1_47ck730 FIND v(dout1_47) AT=740.05n

.meas tran vdout1_48ck730 FIND v(dout1_48) AT=740.05n

.meas tran vdout1_49ck730 FIND v(dout1_49) AT=740.05n

.meas tran vdout1_50ck730 FIND v(dout1_50) AT=740.05n

.meas tran vdout1_51ck730 FIND v(dout1_51) AT=740.05n

.meas tran vdout1_52ck730 FIND v(dout1_52) AT=740.05n

.meas tran vdout1_53ck730 FIND v(dout1_53) AT=740.05n

.meas tran vdout1_54ck730 FIND v(dout1_54) AT=740.05n

.meas tran vdout1_55ck730 FIND v(dout1_55) AT=740.05n

.meas tran vdout1_56ck730 FIND v(dout1_56) AT=740.05n

.meas tran vdout1_57ck730 FIND v(dout1_57) AT=740.05n

.meas tran vdout1_58ck730 FIND v(dout1_58) AT=740.05n

.meas tran vdout1_59ck730 FIND v(dout1_59) AT=740.05n

.meas tran vdout1_60ck730 FIND v(dout1_60) AT=740.05n

.meas tran vdout1_61ck730 FIND v(dout1_61) AT=740.05n

.meas tran vdout1_62ck730 FIND v(dout1_62) AT=740.05n

.meas tran vdout1_63ck730 FIND v(dout1_63) AT=740.05n

.meas tran vdout1_64ck730 FIND v(dout1_64) AT=740.05n

.meas tran vdout1_65ck730 FIND v(dout1_65) AT=740.05n

.meas tran vdout1_66ck730 FIND v(dout1_66) AT=740.05n

.meas tran vdout1_67ck730 FIND v(dout1_67) AT=740.05n

.meas tran vdout1_68ck730 FIND v(dout1_68) AT=740.05n

.meas tran vdout1_69ck730 FIND v(dout1_69) AT=740.05n

.meas tran vdout1_70ck730 FIND v(dout1_70) AT=740.05n

.meas tran vdout1_71ck730 FIND v(dout1_71) AT=740.05n

.meas tran vdout1_72ck730 FIND v(dout1_72) AT=740.05n

.meas tran vdout1_73ck730 FIND v(dout1_73) AT=740.05n

.meas tran vdout1_74ck730 FIND v(dout1_74) AT=740.05n

.meas tran vdout1_75ck730 FIND v(dout1_75) AT=740.05n

.meas tran vdout1_76ck730 FIND v(dout1_76) AT=740.05n

.meas tran vdout1_77ck730 FIND v(dout1_77) AT=740.05n

.meas tran vdout1_78ck730 FIND v(dout1_78) AT=740.05n

.meas tran vdout1_79ck730 FIND v(dout1_79) AT=740.05n

.meas tran vdout1_80ck730 FIND v(dout1_80) AT=740.05n

.meas tran vdout1_81ck730 FIND v(dout1_81) AT=740.05n

.meas tran vdout1_82ck730 FIND v(dout1_82) AT=740.05n

.meas tran vdout1_83ck730 FIND v(dout1_83) AT=740.05n

.meas tran vdout1_84ck730 FIND v(dout1_84) AT=740.05n

.meas tran vdout1_85ck730 FIND v(dout1_85) AT=740.05n

.meas tran vdout1_86ck730 FIND v(dout1_86) AT=740.05n

.meas tran vdout1_87ck730 FIND v(dout1_87) AT=740.05n

.meas tran vdout1_88ck730 FIND v(dout1_88) AT=740.05n

.meas tran vdout1_89ck730 FIND v(dout1_89) AT=740.05n

.meas tran vdout1_90ck730 FIND v(dout1_90) AT=740.05n

.meas tran vdout1_91ck730 FIND v(dout1_91) AT=740.05n

.meas tran vdout1_92ck730 FIND v(dout1_92) AT=740.05n

.meas tran vdout1_93ck730 FIND v(dout1_93) AT=740.05n

.meas tran vdout1_94ck730 FIND v(dout1_94) AT=740.05n

.meas tran vdout1_95ck730 FIND v(dout1_95) AT=740.05n

.meas tran vdout1_96ck730 FIND v(dout1_96) AT=740.05n

.meas tran vdout1_97ck730 FIND v(dout1_97) AT=740.05n

.meas tran vdout1_98ck730 FIND v(dout1_98) AT=740.05n

.meas tran vdout1_99ck730 FIND v(dout1_99) AT=740.05n

.meas tran vdout1_100ck730 FIND v(dout1_100) AT=740.05n

.meas tran vdout1_101ck730 FIND v(dout1_101) AT=740.05n

.meas tran vdout1_102ck730 FIND v(dout1_102) AT=740.05n

.meas tran vdout1_103ck730 FIND v(dout1_103) AT=740.05n

.meas tran vdout1_104ck730 FIND v(dout1_104) AT=740.05n

.meas tran vdout1_105ck730 FIND v(dout1_105) AT=740.05n

.meas tran vdout1_106ck730 FIND v(dout1_106) AT=740.05n

.meas tran vdout1_107ck730 FIND v(dout1_107) AT=740.05n

.meas tran vdout1_108ck730 FIND v(dout1_108) AT=740.05n

.meas tran vdout1_109ck730 FIND v(dout1_109) AT=740.05n

.meas tran vdout1_110ck730 FIND v(dout1_110) AT=740.05n

.meas tran vdout1_111ck730 FIND v(dout1_111) AT=740.05n

.meas tran vdout1_112ck730 FIND v(dout1_112) AT=740.05n

.meas tran vdout1_113ck730 FIND v(dout1_113) AT=740.05n

.meas tran vdout1_114ck730 FIND v(dout1_114) AT=740.05n

.meas tran vdout1_115ck730 FIND v(dout1_115) AT=740.05n

.meas tran vdout1_116ck730 FIND v(dout1_116) AT=740.05n

.meas tran vdout1_117ck730 FIND v(dout1_117) AT=740.05n

.meas tran vdout1_118ck730 FIND v(dout1_118) AT=740.05n

.meas tran vdout1_119ck730 FIND v(dout1_119) AT=740.05n

.meas tran vdout1_120ck730 FIND v(dout1_120) AT=740.05n

.meas tran vdout1_121ck730 FIND v(dout1_121) AT=740.05n

.meas tran vdout1_122ck730 FIND v(dout1_122) AT=740.05n

.meas tran vdout1_123ck730 FIND v(dout1_123) AT=740.05n

.meas tran vdout1_124ck730 FIND v(dout1_124) AT=740.05n

.meas tran vdout1_125ck730 FIND v(dout1_125) AT=740.05n

.meas tran vdout1_126ck730 FIND v(dout1_126) AT=740.05n

.meas tran vdout1_127ck730 FIND v(dout1_127) AT=740.05n

.meas tran vdout1_128ck730 FIND v(dout1_128) AT=740.05n

.meas tran vdout1_129ck730 FIND v(dout1_129) AT=740.05n

.meas tran vdout1_130ck730 FIND v(dout1_130) AT=740.05n

.meas tran vdout1_131ck730 FIND v(dout1_131) AT=740.05n

.meas tran vdout1_132ck730 FIND v(dout1_132) AT=740.05n

.meas tran vdout1_133ck730 FIND v(dout1_133) AT=740.05n

.meas tran vdout1_134ck730 FIND v(dout1_134) AT=740.05n

.meas tran vdout1_0ck770 FIND v(dout1_0) AT=780.05n

.meas tran vdout1_1ck770 FIND v(dout1_1) AT=780.05n

.meas tran vdout1_2ck770 FIND v(dout1_2) AT=780.05n

.meas tran vdout1_3ck770 FIND v(dout1_3) AT=780.05n

.meas tran vdout1_4ck770 FIND v(dout1_4) AT=780.05n

.meas tran vdout1_5ck770 FIND v(dout1_5) AT=780.05n

.meas tran vdout1_6ck770 FIND v(dout1_6) AT=780.05n

.meas tran vdout1_7ck770 FIND v(dout1_7) AT=780.05n

.meas tran vdout1_8ck770 FIND v(dout1_8) AT=780.05n

.meas tran vdout1_9ck770 FIND v(dout1_9) AT=780.05n

.meas tran vdout1_10ck770 FIND v(dout1_10) AT=780.05n

.meas tran vdout1_11ck770 FIND v(dout1_11) AT=780.05n

.meas tran vdout1_12ck770 FIND v(dout1_12) AT=780.05n

.meas tran vdout1_13ck770 FIND v(dout1_13) AT=780.05n

.meas tran vdout1_14ck770 FIND v(dout1_14) AT=780.05n

.meas tran vdout1_15ck770 FIND v(dout1_15) AT=780.05n

.meas tran vdout1_16ck770 FIND v(dout1_16) AT=780.05n

.meas tran vdout1_17ck770 FIND v(dout1_17) AT=780.05n

.meas tran vdout1_18ck770 FIND v(dout1_18) AT=780.05n

.meas tran vdout1_19ck770 FIND v(dout1_19) AT=780.05n

.meas tran vdout1_20ck770 FIND v(dout1_20) AT=780.05n

.meas tran vdout1_21ck770 FIND v(dout1_21) AT=780.05n

.meas tran vdout1_22ck770 FIND v(dout1_22) AT=780.05n

.meas tran vdout1_23ck770 FIND v(dout1_23) AT=780.05n

.meas tran vdout1_24ck770 FIND v(dout1_24) AT=780.05n

.meas tran vdout1_25ck770 FIND v(dout1_25) AT=780.05n

.meas tran vdout1_26ck770 FIND v(dout1_26) AT=780.05n

.meas tran vdout1_27ck770 FIND v(dout1_27) AT=780.05n

.meas tran vdout1_28ck770 FIND v(dout1_28) AT=780.05n

.meas tran vdout1_29ck770 FIND v(dout1_29) AT=780.05n

.meas tran vdout1_30ck770 FIND v(dout1_30) AT=780.05n

.meas tran vdout1_31ck770 FIND v(dout1_31) AT=780.05n

.meas tran vdout1_32ck770 FIND v(dout1_32) AT=780.05n

.meas tran vdout1_33ck770 FIND v(dout1_33) AT=780.05n

.meas tran vdout1_34ck770 FIND v(dout1_34) AT=780.05n

.meas tran vdout1_35ck770 FIND v(dout1_35) AT=780.05n

.meas tran vdout1_36ck770 FIND v(dout1_36) AT=780.05n

.meas tran vdout1_37ck770 FIND v(dout1_37) AT=780.05n

.meas tran vdout1_38ck770 FIND v(dout1_38) AT=780.05n

.meas tran vdout1_39ck770 FIND v(dout1_39) AT=780.05n

.meas tran vdout1_40ck770 FIND v(dout1_40) AT=780.05n

.meas tran vdout1_41ck770 FIND v(dout1_41) AT=780.05n

.meas tran vdout1_42ck770 FIND v(dout1_42) AT=780.05n

.meas tran vdout1_43ck770 FIND v(dout1_43) AT=780.05n

.meas tran vdout1_44ck770 FIND v(dout1_44) AT=780.05n

.meas tran vdout1_45ck770 FIND v(dout1_45) AT=780.05n

.meas tran vdout1_46ck770 FIND v(dout1_46) AT=780.05n

.meas tran vdout1_47ck770 FIND v(dout1_47) AT=780.05n

.meas tran vdout1_48ck770 FIND v(dout1_48) AT=780.05n

.meas tran vdout1_49ck770 FIND v(dout1_49) AT=780.05n

.meas tran vdout1_50ck770 FIND v(dout1_50) AT=780.05n

.meas tran vdout1_51ck770 FIND v(dout1_51) AT=780.05n

.meas tran vdout1_52ck770 FIND v(dout1_52) AT=780.05n

.meas tran vdout1_53ck770 FIND v(dout1_53) AT=780.05n

.meas tran vdout1_54ck770 FIND v(dout1_54) AT=780.05n

.meas tran vdout1_55ck770 FIND v(dout1_55) AT=780.05n

.meas tran vdout1_56ck770 FIND v(dout1_56) AT=780.05n

.meas tran vdout1_57ck770 FIND v(dout1_57) AT=780.05n

.meas tran vdout1_58ck770 FIND v(dout1_58) AT=780.05n

.meas tran vdout1_59ck770 FIND v(dout1_59) AT=780.05n

.meas tran vdout1_60ck770 FIND v(dout1_60) AT=780.05n

.meas tran vdout1_61ck770 FIND v(dout1_61) AT=780.05n

.meas tran vdout1_62ck770 FIND v(dout1_62) AT=780.05n

.meas tran vdout1_63ck770 FIND v(dout1_63) AT=780.05n

.meas tran vdout1_64ck770 FIND v(dout1_64) AT=780.05n

.meas tran vdout1_65ck770 FIND v(dout1_65) AT=780.05n

.meas tran vdout1_66ck770 FIND v(dout1_66) AT=780.05n

.meas tran vdout1_67ck770 FIND v(dout1_67) AT=780.05n

.meas tran vdout1_68ck770 FIND v(dout1_68) AT=780.05n

.meas tran vdout1_69ck770 FIND v(dout1_69) AT=780.05n

.meas tran vdout1_70ck770 FIND v(dout1_70) AT=780.05n

.meas tran vdout1_71ck770 FIND v(dout1_71) AT=780.05n

.meas tran vdout1_72ck770 FIND v(dout1_72) AT=780.05n

.meas tran vdout1_73ck770 FIND v(dout1_73) AT=780.05n

.meas tran vdout1_74ck770 FIND v(dout1_74) AT=780.05n

.meas tran vdout1_75ck770 FIND v(dout1_75) AT=780.05n

.meas tran vdout1_76ck770 FIND v(dout1_76) AT=780.05n

.meas tran vdout1_77ck770 FIND v(dout1_77) AT=780.05n

.meas tran vdout1_78ck770 FIND v(dout1_78) AT=780.05n

.meas tran vdout1_79ck770 FIND v(dout1_79) AT=780.05n

.meas tran vdout1_80ck770 FIND v(dout1_80) AT=780.05n

.meas tran vdout1_81ck770 FIND v(dout1_81) AT=780.05n

.meas tran vdout1_82ck770 FIND v(dout1_82) AT=780.05n

.meas tran vdout1_83ck770 FIND v(dout1_83) AT=780.05n

.meas tran vdout1_84ck770 FIND v(dout1_84) AT=780.05n

.meas tran vdout1_85ck770 FIND v(dout1_85) AT=780.05n

.meas tran vdout1_86ck770 FIND v(dout1_86) AT=780.05n

.meas tran vdout1_87ck770 FIND v(dout1_87) AT=780.05n

.meas tran vdout1_88ck770 FIND v(dout1_88) AT=780.05n

.meas tran vdout1_89ck770 FIND v(dout1_89) AT=780.05n

.meas tran vdout1_90ck770 FIND v(dout1_90) AT=780.05n

.meas tran vdout1_91ck770 FIND v(dout1_91) AT=780.05n

.meas tran vdout1_92ck770 FIND v(dout1_92) AT=780.05n

.meas tran vdout1_93ck770 FIND v(dout1_93) AT=780.05n

.meas tran vdout1_94ck770 FIND v(dout1_94) AT=780.05n

.meas tran vdout1_95ck770 FIND v(dout1_95) AT=780.05n

.meas tran vdout1_96ck770 FIND v(dout1_96) AT=780.05n

.meas tran vdout1_97ck770 FIND v(dout1_97) AT=780.05n

.meas tran vdout1_98ck770 FIND v(dout1_98) AT=780.05n

.meas tran vdout1_99ck770 FIND v(dout1_99) AT=780.05n

.meas tran vdout1_100ck770 FIND v(dout1_100) AT=780.05n

.meas tran vdout1_101ck770 FIND v(dout1_101) AT=780.05n

.meas tran vdout1_102ck770 FIND v(dout1_102) AT=780.05n

.meas tran vdout1_103ck770 FIND v(dout1_103) AT=780.05n

.meas tran vdout1_104ck770 FIND v(dout1_104) AT=780.05n

.meas tran vdout1_105ck770 FIND v(dout1_105) AT=780.05n

.meas tran vdout1_106ck770 FIND v(dout1_106) AT=780.05n

.meas tran vdout1_107ck770 FIND v(dout1_107) AT=780.05n

.meas tran vdout1_108ck770 FIND v(dout1_108) AT=780.05n

.meas tran vdout1_109ck770 FIND v(dout1_109) AT=780.05n

.meas tran vdout1_110ck770 FIND v(dout1_110) AT=780.05n

.meas tran vdout1_111ck770 FIND v(dout1_111) AT=780.05n

.meas tran vdout1_112ck770 FIND v(dout1_112) AT=780.05n

.meas tran vdout1_113ck770 FIND v(dout1_113) AT=780.05n

.meas tran vdout1_114ck770 FIND v(dout1_114) AT=780.05n

.meas tran vdout1_115ck770 FIND v(dout1_115) AT=780.05n

.meas tran vdout1_116ck770 FIND v(dout1_116) AT=780.05n

.meas tran vdout1_117ck770 FIND v(dout1_117) AT=780.05n

.meas tran vdout1_118ck770 FIND v(dout1_118) AT=780.05n

.meas tran vdout1_119ck770 FIND v(dout1_119) AT=780.05n

.meas tran vdout1_120ck770 FIND v(dout1_120) AT=780.05n

.meas tran vdout1_121ck770 FIND v(dout1_121) AT=780.05n

.meas tran vdout1_122ck770 FIND v(dout1_122) AT=780.05n

.meas tran vdout1_123ck770 FIND v(dout1_123) AT=780.05n

.meas tran vdout1_124ck770 FIND v(dout1_124) AT=780.05n

.meas tran vdout1_125ck770 FIND v(dout1_125) AT=780.05n

.meas tran vdout1_126ck770 FIND v(dout1_126) AT=780.05n

.meas tran vdout1_127ck770 FIND v(dout1_127) AT=780.05n

.meas tran vdout1_128ck770 FIND v(dout1_128) AT=780.05n

.meas tran vdout1_129ck770 FIND v(dout1_129) AT=780.05n

.meas tran vdout1_130ck770 FIND v(dout1_130) AT=780.05n

.meas tran vdout1_131ck770 FIND v(dout1_131) AT=780.05n

.meas tran vdout1_132ck770 FIND v(dout1_132) AT=780.05n

.meas tran vdout1_133ck770 FIND v(dout1_133) AT=780.05n

.meas tran vdout1_134ck770 FIND v(dout1_134) AT=780.05n

.meas tran vdout1_0ck810 FIND v(dout1_0) AT=820.05n

.meas tran vdout1_1ck810 FIND v(dout1_1) AT=820.05n

.meas tran vdout1_2ck810 FIND v(dout1_2) AT=820.05n

.meas tran vdout1_3ck810 FIND v(dout1_3) AT=820.05n

.meas tran vdout1_4ck810 FIND v(dout1_4) AT=820.05n

.meas tran vdout1_5ck810 FIND v(dout1_5) AT=820.05n

.meas tran vdout1_6ck810 FIND v(dout1_6) AT=820.05n

.meas tran vdout1_7ck810 FIND v(dout1_7) AT=820.05n

.meas tran vdout1_8ck810 FIND v(dout1_8) AT=820.05n

.meas tran vdout1_9ck810 FIND v(dout1_9) AT=820.05n

.meas tran vdout1_10ck810 FIND v(dout1_10) AT=820.05n

.meas tran vdout1_11ck810 FIND v(dout1_11) AT=820.05n

.meas tran vdout1_12ck810 FIND v(dout1_12) AT=820.05n

.meas tran vdout1_13ck810 FIND v(dout1_13) AT=820.05n

.meas tran vdout1_14ck810 FIND v(dout1_14) AT=820.05n

.meas tran vdout1_15ck810 FIND v(dout1_15) AT=820.05n

.meas tran vdout1_16ck810 FIND v(dout1_16) AT=820.05n

.meas tran vdout1_17ck810 FIND v(dout1_17) AT=820.05n

.meas tran vdout1_18ck810 FIND v(dout1_18) AT=820.05n

.meas tran vdout1_19ck810 FIND v(dout1_19) AT=820.05n

.meas tran vdout1_20ck810 FIND v(dout1_20) AT=820.05n

.meas tran vdout1_21ck810 FIND v(dout1_21) AT=820.05n

.meas tran vdout1_22ck810 FIND v(dout1_22) AT=820.05n

.meas tran vdout1_23ck810 FIND v(dout1_23) AT=820.05n

.meas tran vdout1_24ck810 FIND v(dout1_24) AT=820.05n

.meas tran vdout1_25ck810 FIND v(dout1_25) AT=820.05n

.meas tran vdout1_26ck810 FIND v(dout1_26) AT=820.05n

.meas tran vdout1_27ck810 FIND v(dout1_27) AT=820.05n

.meas tran vdout1_28ck810 FIND v(dout1_28) AT=820.05n

.meas tran vdout1_29ck810 FIND v(dout1_29) AT=820.05n

.meas tran vdout1_30ck810 FIND v(dout1_30) AT=820.05n

.meas tran vdout1_31ck810 FIND v(dout1_31) AT=820.05n

.meas tran vdout1_32ck810 FIND v(dout1_32) AT=820.05n

.meas tran vdout1_33ck810 FIND v(dout1_33) AT=820.05n

.meas tran vdout1_34ck810 FIND v(dout1_34) AT=820.05n

.meas tran vdout1_35ck810 FIND v(dout1_35) AT=820.05n

.meas tran vdout1_36ck810 FIND v(dout1_36) AT=820.05n

.meas tran vdout1_37ck810 FIND v(dout1_37) AT=820.05n

.meas tran vdout1_38ck810 FIND v(dout1_38) AT=820.05n

.meas tran vdout1_39ck810 FIND v(dout1_39) AT=820.05n

.meas tran vdout1_40ck810 FIND v(dout1_40) AT=820.05n

.meas tran vdout1_41ck810 FIND v(dout1_41) AT=820.05n

.meas tran vdout1_42ck810 FIND v(dout1_42) AT=820.05n

.meas tran vdout1_43ck810 FIND v(dout1_43) AT=820.05n

.meas tran vdout1_44ck810 FIND v(dout1_44) AT=820.05n

.meas tran vdout1_45ck810 FIND v(dout1_45) AT=820.05n

.meas tran vdout1_46ck810 FIND v(dout1_46) AT=820.05n

.meas tran vdout1_47ck810 FIND v(dout1_47) AT=820.05n

.meas tran vdout1_48ck810 FIND v(dout1_48) AT=820.05n

.meas tran vdout1_49ck810 FIND v(dout1_49) AT=820.05n

.meas tran vdout1_50ck810 FIND v(dout1_50) AT=820.05n

.meas tran vdout1_51ck810 FIND v(dout1_51) AT=820.05n

.meas tran vdout1_52ck810 FIND v(dout1_52) AT=820.05n

.meas tran vdout1_53ck810 FIND v(dout1_53) AT=820.05n

.meas tran vdout1_54ck810 FIND v(dout1_54) AT=820.05n

.meas tran vdout1_55ck810 FIND v(dout1_55) AT=820.05n

.meas tran vdout1_56ck810 FIND v(dout1_56) AT=820.05n

.meas tran vdout1_57ck810 FIND v(dout1_57) AT=820.05n

.meas tran vdout1_58ck810 FIND v(dout1_58) AT=820.05n

.meas tran vdout1_59ck810 FIND v(dout1_59) AT=820.05n

.meas tran vdout1_60ck810 FIND v(dout1_60) AT=820.05n

.meas tran vdout1_61ck810 FIND v(dout1_61) AT=820.05n

.meas tran vdout1_62ck810 FIND v(dout1_62) AT=820.05n

.meas tran vdout1_63ck810 FIND v(dout1_63) AT=820.05n

.meas tran vdout1_64ck810 FIND v(dout1_64) AT=820.05n

.meas tran vdout1_65ck810 FIND v(dout1_65) AT=820.05n

.meas tran vdout1_66ck810 FIND v(dout1_66) AT=820.05n

.meas tran vdout1_67ck810 FIND v(dout1_67) AT=820.05n

.meas tran vdout1_68ck810 FIND v(dout1_68) AT=820.05n

.meas tran vdout1_69ck810 FIND v(dout1_69) AT=820.05n

.meas tran vdout1_70ck810 FIND v(dout1_70) AT=820.05n

.meas tran vdout1_71ck810 FIND v(dout1_71) AT=820.05n

.meas tran vdout1_72ck810 FIND v(dout1_72) AT=820.05n

.meas tran vdout1_73ck810 FIND v(dout1_73) AT=820.05n

.meas tran vdout1_74ck810 FIND v(dout1_74) AT=820.05n

.meas tran vdout1_75ck810 FIND v(dout1_75) AT=820.05n

.meas tran vdout1_76ck810 FIND v(dout1_76) AT=820.05n

.meas tran vdout1_77ck810 FIND v(dout1_77) AT=820.05n

.meas tran vdout1_78ck810 FIND v(dout1_78) AT=820.05n

.meas tran vdout1_79ck810 FIND v(dout1_79) AT=820.05n

.meas tran vdout1_80ck810 FIND v(dout1_80) AT=820.05n

.meas tran vdout1_81ck810 FIND v(dout1_81) AT=820.05n

.meas tran vdout1_82ck810 FIND v(dout1_82) AT=820.05n

.meas tran vdout1_83ck810 FIND v(dout1_83) AT=820.05n

.meas tran vdout1_84ck810 FIND v(dout1_84) AT=820.05n

.meas tran vdout1_85ck810 FIND v(dout1_85) AT=820.05n

.meas tran vdout1_86ck810 FIND v(dout1_86) AT=820.05n

.meas tran vdout1_87ck810 FIND v(dout1_87) AT=820.05n

.meas tran vdout1_88ck810 FIND v(dout1_88) AT=820.05n

.meas tran vdout1_89ck810 FIND v(dout1_89) AT=820.05n

.meas tran vdout1_90ck810 FIND v(dout1_90) AT=820.05n

.meas tran vdout1_91ck810 FIND v(dout1_91) AT=820.05n

.meas tran vdout1_92ck810 FIND v(dout1_92) AT=820.05n

.meas tran vdout1_93ck810 FIND v(dout1_93) AT=820.05n

.meas tran vdout1_94ck810 FIND v(dout1_94) AT=820.05n

.meas tran vdout1_95ck810 FIND v(dout1_95) AT=820.05n

.meas tran vdout1_96ck810 FIND v(dout1_96) AT=820.05n

.meas tran vdout1_97ck810 FIND v(dout1_97) AT=820.05n

.meas tran vdout1_98ck810 FIND v(dout1_98) AT=820.05n

.meas tran vdout1_99ck810 FIND v(dout1_99) AT=820.05n

.meas tran vdout1_100ck810 FIND v(dout1_100) AT=820.05n

.meas tran vdout1_101ck810 FIND v(dout1_101) AT=820.05n

.meas tran vdout1_102ck810 FIND v(dout1_102) AT=820.05n

.meas tran vdout1_103ck810 FIND v(dout1_103) AT=820.05n

.meas tran vdout1_104ck810 FIND v(dout1_104) AT=820.05n

.meas tran vdout1_105ck810 FIND v(dout1_105) AT=820.05n

.meas tran vdout1_106ck810 FIND v(dout1_106) AT=820.05n

.meas tran vdout1_107ck810 FIND v(dout1_107) AT=820.05n

.meas tran vdout1_108ck810 FIND v(dout1_108) AT=820.05n

.meas tran vdout1_109ck810 FIND v(dout1_109) AT=820.05n

.meas tran vdout1_110ck810 FIND v(dout1_110) AT=820.05n

.meas tran vdout1_111ck810 FIND v(dout1_111) AT=820.05n

.meas tran vdout1_112ck810 FIND v(dout1_112) AT=820.05n

.meas tran vdout1_113ck810 FIND v(dout1_113) AT=820.05n

.meas tran vdout1_114ck810 FIND v(dout1_114) AT=820.05n

.meas tran vdout1_115ck810 FIND v(dout1_115) AT=820.05n

.meas tran vdout1_116ck810 FIND v(dout1_116) AT=820.05n

.meas tran vdout1_117ck810 FIND v(dout1_117) AT=820.05n

.meas tran vdout1_118ck810 FIND v(dout1_118) AT=820.05n

.meas tran vdout1_119ck810 FIND v(dout1_119) AT=820.05n

.meas tran vdout1_120ck810 FIND v(dout1_120) AT=820.05n

.meas tran vdout1_121ck810 FIND v(dout1_121) AT=820.05n

.meas tran vdout1_122ck810 FIND v(dout1_122) AT=820.05n

.meas tran vdout1_123ck810 FIND v(dout1_123) AT=820.05n

.meas tran vdout1_124ck810 FIND v(dout1_124) AT=820.05n

.meas tran vdout1_125ck810 FIND v(dout1_125) AT=820.05n

.meas tran vdout1_126ck810 FIND v(dout1_126) AT=820.05n

.meas tran vdout1_127ck810 FIND v(dout1_127) AT=820.05n

.meas tran vdout1_128ck810 FIND v(dout1_128) AT=820.05n

.meas tran vdout1_129ck810 FIND v(dout1_129) AT=820.05n

.meas tran vdout1_130ck810 FIND v(dout1_130) AT=820.05n

.meas tran vdout1_131ck810 FIND v(dout1_131) AT=820.05n

.meas tran vdout1_132ck810 FIND v(dout1_132) AT=820.05n

.meas tran vdout1_133ck810 FIND v(dout1_133) AT=820.05n

.meas tran vdout1_134ck810 FIND v(dout1_134) AT=820.05n

.meas tran vdout1_0ck830 FIND v(dout1_0) AT=840.05n

.meas tran vdout1_1ck830 FIND v(dout1_1) AT=840.05n

.meas tran vdout1_2ck830 FIND v(dout1_2) AT=840.05n

.meas tran vdout1_3ck830 FIND v(dout1_3) AT=840.05n

.meas tran vdout1_4ck830 FIND v(dout1_4) AT=840.05n

.meas tran vdout1_5ck830 FIND v(dout1_5) AT=840.05n

.meas tran vdout1_6ck830 FIND v(dout1_6) AT=840.05n

.meas tran vdout1_7ck830 FIND v(dout1_7) AT=840.05n

.meas tran vdout1_8ck830 FIND v(dout1_8) AT=840.05n

.meas tran vdout1_9ck830 FIND v(dout1_9) AT=840.05n

.meas tran vdout1_10ck830 FIND v(dout1_10) AT=840.05n

.meas tran vdout1_11ck830 FIND v(dout1_11) AT=840.05n

.meas tran vdout1_12ck830 FIND v(dout1_12) AT=840.05n

.meas tran vdout1_13ck830 FIND v(dout1_13) AT=840.05n

.meas tran vdout1_14ck830 FIND v(dout1_14) AT=840.05n

.meas tran vdout1_15ck830 FIND v(dout1_15) AT=840.05n

.meas tran vdout1_16ck830 FIND v(dout1_16) AT=840.05n

.meas tran vdout1_17ck830 FIND v(dout1_17) AT=840.05n

.meas tran vdout1_18ck830 FIND v(dout1_18) AT=840.05n

.meas tran vdout1_19ck830 FIND v(dout1_19) AT=840.05n

.meas tran vdout1_20ck830 FIND v(dout1_20) AT=840.05n

.meas tran vdout1_21ck830 FIND v(dout1_21) AT=840.05n

.meas tran vdout1_22ck830 FIND v(dout1_22) AT=840.05n

.meas tran vdout1_23ck830 FIND v(dout1_23) AT=840.05n

.meas tran vdout1_24ck830 FIND v(dout1_24) AT=840.05n

.meas tran vdout1_25ck830 FIND v(dout1_25) AT=840.05n

.meas tran vdout1_26ck830 FIND v(dout1_26) AT=840.05n

.meas tran vdout1_27ck830 FIND v(dout1_27) AT=840.05n

.meas tran vdout1_28ck830 FIND v(dout1_28) AT=840.05n

.meas tran vdout1_29ck830 FIND v(dout1_29) AT=840.05n

.meas tran vdout1_30ck830 FIND v(dout1_30) AT=840.05n

.meas tran vdout1_31ck830 FIND v(dout1_31) AT=840.05n

.meas tran vdout1_32ck830 FIND v(dout1_32) AT=840.05n

.meas tran vdout1_33ck830 FIND v(dout1_33) AT=840.05n

.meas tran vdout1_34ck830 FIND v(dout1_34) AT=840.05n

.meas tran vdout1_35ck830 FIND v(dout1_35) AT=840.05n

.meas tran vdout1_36ck830 FIND v(dout1_36) AT=840.05n

.meas tran vdout1_37ck830 FIND v(dout1_37) AT=840.05n

.meas tran vdout1_38ck830 FIND v(dout1_38) AT=840.05n

.meas tran vdout1_39ck830 FIND v(dout1_39) AT=840.05n

.meas tran vdout1_40ck830 FIND v(dout1_40) AT=840.05n

.meas tran vdout1_41ck830 FIND v(dout1_41) AT=840.05n

.meas tran vdout1_42ck830 FIND v(dout1_42) AT=840.05n

.meas tran vdout1_43ck830 FIND v(dout1_43) AT=840.05n

.meas tran vdout1_44ck830 FIND v(dout1_44) AT=840.05n

.meas tran vdout1_45ck830 FIND v(dout1_45) AT=840.05n

.meas tran vdout1_46ck830 FIND v(dout1_46) AT=840.05n

.meas tran vdout1_47ck830 FIND v(dout1_47) AT=840.05n

.meas tran vdout1_48ck830 FIND v(dout1_48) AT=840.05n

.meas tran vdout1_49ck830 FIND v(dout1_49) AT=840.05n

.meas tran vdout1_50ck830 FIND v(dout1_50) AT=840.05n

.meas tran vdout1_51ck830 FIND v(dout1_51) AT=840.05n

.meas tran vdout1_52ck830 FIND v(dout1_52) AT=840.05n

.meas tran vdout1_53ck830 FIND v(dout1_53) AT=840.05n

.meas tran vdout1_54ck830 FIND v(dout1_54) AT=840.05n

.meas tran vdout1_55ck830 FIND v(dout1_55) AT=840.05n

.meas tran vdout1_56ck830 FIND v(dout1_56) AT=840.05n

.meas tran vdout1_57ck830 FIND v(dout1_57) AT=840.05n

.meas tran vdout1_58ck830 FIND v(dout1_58) AT=840.05n

.meas tran vdout1_59ck830 FIND v(dout1_59) AT=840.05n

.meas tran vdout1_60ck830 FIND v(dout1_60) AT=840.05n

.meas tran vdout1_61ck830 FIND v(dout1_61) AT=840.05n

.meas tran vdout1_62ck830 FIND v(dout1_62) AT=840.05n

.meas tran vdout1_63ck830 FIND v(dout1_63) AT=840.05n

.meas tran vdout1_64ck830 FIND v(dout1_64) AT=840.05n

.meas tran vdout1_65ck830 FIND v(dout1_65) AT=840.05n

.meas tran vdout1_66ck830 FIND v(dout1_66) AT=840.05n

.meas tran vdout1_67ck830 FIND v(dout1_67) AT=840.05n

.meas tran vdout1_68ck830 FIND v(dout1_68) AT=840.05n

.meas tran vdout1_69ck830 FIND v(dout1_69) AT=840.05n

.meas tran vdout1_70ck830 FIND v(dout1_70) AT=840.05n

.meas tran vdout1_71ck830 FIND v(dout1_71) AT=840.05n

.meas tran vdout1_72ck830 FIND v(dout1_72) AT=840.05n

.meas tran vdout1_73ck830 FIND v(dout1_73) AT=840.05n

.meas tran vdout1_74ck830 FIND v(dout1_74) AT=840.05n

.meas tran vdout1_75ck830 FIND v(dout1_75) AT=840.05n

.meas tran vdout1_76ck830 FIND v(dout1_76) AT=840.05n

.meas tran vdout1_77ck830 FIND v(dout1_77) AT=840.05n

.meas tran vdout1_78ck830 FIND v(dout1_78) AT=840.05n

.meas tran vdout1_79ck830 FIND v(dout1_79) AT=840.05n

.meas tran vdout1_80ck830 FIND v(dout1_80) AT=840.05n

.meas tran vdout1_81ck830 FIND v(dout1_81) AT=840.05n

.meas tran vdout1_82ck830 FIND v(dout1_82) AT=840.05n

.meas tran vdout1_83ck830 FIND v(dout1_83) AT=840.05n

.meas tran vdout1_84ck830 FIND v(dout1_84) AT=840.05n

.meas tran vdout1_85ck830 FIND v(dout1_85) AT=840.05n

.meas tran vdout1_86ck830 FIND v(dout1_86) AT=840.05n

.meas tran vdout1_87ck830 FIND v(dout1_87) AT=840.05n

.meas tran vdout1_88ck830 FIND v(dout1_88) AT=840.05n

.meas tran vdout1_89ck830 FIND v(dout1_89) AT=840.05n

.meas tran vdout1_90ck830 FIND v(dout1_90) AT=840.05n

.meas tran vdout1_91ck830 FIND v(dout1_91) AT=840.05n

.meas tran vdout1_92ck830 FIND v(dout1_92) AT=840.05n

.meas tran vdout1_93ck830 FIND v(dout1_93) AT=840.05n

.meas tran vdout1_94ck830 FIND v(dout1_94) AT=840.05n

.meas tran vdout1_95ck830 FIND v(dout1_95) AT=840.05n

.meas tran vdout1_96ck830 FIND v(dout1_96) AT=840.05n

.meas tran vdout1_97ck830 FIND v(dout1_97) AT=840.05n

.meas tran vdout1_98ck830 FIND v(dout1_98) AT=840.05n

.meas tran vdout1_99ck830 FIND v(dout1_99) AT=840.05n

.meas tran vdout1_100ck830 FIND v(dout1_100) AT=840.05n

.meas tran vdout1_101ck830 FIND v(dout1_101) AT=840.05n

.meas tran vdout1_102ck830 FIND v(dout1_102) AT=840.05n

.meas tran vdout1_103ck830 FIND v(dout1_103) AT=840.05n

.meas tran vdout1_104ck830 FIND v(dout1_104) AT=840.05n

.meas tran vdout1_105ck830 FIND v(dout1_105) AT=840.05n

.meas tran vdout1_106ck830 FIND v(dout1_106) AT=840.05n

.meas tran vdout1_107ck830 FIND v(dout1_107) AT=840.05n

.meas tran vdout1_108ck830 FIND v(dout1_108) AT=840.05n

.meas tran vdout1_109ck830 FIND v(dout1_109) AT=840.05n

.meas tran vdout1_110ck830 FIND v(dout1_110) AT=840.05n

.meas tran vdout1_111ck830 FIND v(dout1_111) AT=840.05n

.meas tran vdout1_112ck830 FIND v(dout1_112) AT=840.05n

.meas tran vdout1_113ck830 FIND v(dout1_113) AT=840.05n

.meas tran vdout1_114ck830 FIND v(dout1_114) AT=840.05n

.meas tran vdout1_115ck830 FIND v(dout1_115) AT=840.05n

.meas tran vdout1_116ck830 FIND v(dout1_116) AT=840.05n

.meas tran vdout1_117ck830 FIND v(dout1_117) AT=840.05n

.meas tran vdout1_118ck830 FIND v(dout1_118) AT=840.05n

.meas tran vdout1_119ck830 FIND v(dout1_119) AT=840.05n

.meas tran vdout1_120ck830 FIND v(dout1_120) AT=840.05n

.meas tran vdout1_121ck830 FIND v(dout1_121) AT=840.05n

.meas tran vdout1_122ck830 FIND v(dout1_122) AT=840.05n

.meas tran vdout1_123ck830 FIND v(dout1_123) AT=840.05n

.meas tran vdout1_124ck830 FIND v(dout1_124) AT=840.05n

.meas tran vdout1_125ck830 FIND v(dout1_125) AT=840.05n

.meas tran vdout1_126ck830 FIND v(dout1_126) AT=840.05n

.meas tran vdout1_127ck830 FIND v(dout1_127) AT=840.05n

.meas tran vdout1_128ck830 FIND v(dout1_128) AT=840.05n

.meas tran vdout1_129ck830 FIND v(dout1_129) AT=840.05n

.meas tran vdout1_130ck830 FIND v(dout1_130) AT=840.05n

.meas tran vdout1_131ck830 FIND v(dout1_131) AT=840.05n

.meas tran vdout1_132ck830 FIND v(dout1_132) AT=840.05n

.meas tran vdout1_133ck830 FIND v(dout1_133) AT=840.05n

.meas tran vdout1_134ck830 FIND v(dout1_134) AT=840.05n

.meas tran vdout1_0ck840 FIND v(dout1_0) AT=850.05n

.meas tran vdout1_1ck840 FIND v(dout1_1) AT=850.05n

.meas tran vdout1_2ck840 FIND v(dout1_2) AT=850.05n

.meas tran vdout1_3ck840 FIND v(dout1_3) AT=850.05n

.meas tran vdout1_4ck840 FIND v(dout1_4) AT=850.05n

.meas tran vdout1_5ck840 FIND v(dout1_5) AT=850.05n

.meas tran vdout1_6ck840 FIND v(dout1_6) AT=850.05n

.meas tran vdout1_7ck840 FIND v(dout1_7) AT=850.05n

.meas tran vdout1_8ck840 FIND v(dout1_8) AT=850.05n

.meas tran vdout1_9ck840 FIND v(dout1_9) AT=850.05n

.meas tran vdout1_10ck840 FIND v(dout1_10) AT=850.05n

.meas tran vdout1_11ck840 FIND v(dout1_11) AT=850.05n

.meas tran vdout1_12ck840 FIND v(dout1_12) AT=850.05n

.meas tran vdout1_13ck840 FIND v(dout1_13) AT=850.05n

.meas tran vdout1_14ck840 FIND v(dout1_14) AT=850.05n

.meas tran vdout1_15ck840 FIND v(dout1_15) AT=850.05n

.meas tran vdout1_16ck840 FIND v(dout1_16) AT=850.05n

.meas tran vdout1_17ck840 FIND v(dout1_17) AT=850.05n

.meas tran vdout1_18ck840 FIND v(dout1_18) AT=850.05n

.meas tran vdout1_19ck840 FIND v(dout1_19) AT=850.05n

.meas tran vdout1_20ck840 FIND v(dout1_20) AT=850.05n

.meas tran vdout1_21ck840 FIND v(dout1_21) AT=850.05n

.meas tran vdout1_22ck840 FIND v(dout1_22) AT=850.05n

.meas tran vdout1_23ck840 FIND v(dout1_23) AT=850.05n

.meas tran vdout1_24ck840 FIND v(dout1_24) AT=850.05n

.meas tran vdout1_25ck840 FIND v(dout1_25) AT=850.05n

.meas tran vdout1_26ck840 FIND v(dout1_26) AT=850.05n

.meas tran vdout1_27ck840 FIND v(dout1_27) AT=850.05n

.meas tran vdout1_28ck840 FIND v(dout1_28) AT=850.05n

.meas tran vdout1_29ck840 FIND v(dout1_29) AT=850.05n

.meas tran vdout1_30ck840 FIND v(dout1_30) AT=850.05n

.meas tran vdout1_31ck840 FIND v(dout1_31) AT=850.05n

.meas tran vdout1_32ck840 FIND v(dout1_32) AT=850.05n

.meas tran vdout1_33ck840 FIND v(dout1_33) AT=850.05n

.meas tran vdout1_34ck840 FIND v(dout1_34) AT=850.05n

.meas tran vdout1_35ck840 FIND v(dout1_35) AT=850.05n

.meas tran vdout1_36ck840 FIND v(dout1_36) AT=850.05n

.meas tran vdout1_37ck840 FIND v(dout1_37) AT=850.05n

.meas tran vdout1_38ck840 FIND v(dout1_38) AT=850.05n

.meas tran vdout1_39ck840 FIND v(dout1_39) AT=850.05n

.meas tran vdout1_40ck840 FIND v(dout1_40) AT=850.05n

.meas tran vdout1_41ck840 FIND v(dout1_41) AT=850.05n

.meas tran vdout1_42ck840 FIND v(dout1_42) AT=850.05n

.meas tran vdout1_43ck840 FIND v(dout1_43) AT=850.05n

.meas tran vdout1_44ck840 FIND v(dout1_44) AT=850.05n

.meas tran vdout1_45ck840 FIND v(dout1_45) AT=850.05n

.meas tran vdout1_46ck840 FIND v(dout1_46) AT=850.05n

.meas tran vdout1_47ck840 FIND v(dout1_47) AT=850.05n

.meas tran vdout1_48ck840 FIND v(dout1_48) AT=850.05n

.meas tran vdout1_49ck840 FIND v(dout1_49) AT=850.05n

.meas tran vdout1_50ck840 FIND v(dout1_50) AT=850.05n

.meas tran vdout1_51ck840 FIND v(dout1_51) AT=850.05n

.meas tran vdout1_52ck840 FIND v(dout1_52) AT=850.05n

.meas tran vdout1_53ck840 FIND v(dout1_53) AT=850.05n

.meas tran vdout1_54ck840 FIND v(dout1_54) AT=850.05n

.meas tran vdout1_55ck840 FIND v(dout1_55) AT=850.05n

.meas tran vdout1_56ck840 FIND v(dout1_56) AT=850.05n

.meas tran vdout1_57ck840 FIND v(dout1_57) AT=850.05n

.meas tran vdout1_58ck840 FIND v(dout1_58) AT=850.05n

.meas tran vdout1_59ck840 FIND v(dout1_59) AT=850.05n

.meas tran vdout1_60ck840 FIND v(dout1_60) AT=850.05n

.meas tran vdout1_61ck840 FIND v(dout1_61) AT=850.05n

.meas tran vdout1_62ck840 FIND v(dout1_62) AT=850.05n

.meas tran vdout1_63ck840 FIND v(dout1_63) AT=850.05n

.meas tran vdout1_64ck840 FIND v(dout1_64) AT=850.05n

.meas tran vdout1_65ck840 FIND v(dout1_65) AT=850.05n

.meas tran vdout1_66ck840 FIND v(dout1_66) AT=850.05n

.meas tran vdout1_67ck840 FIND v(dout1_67) AT=850.05n

.meas tran vdout1_68ck840 FIND v(dout1_68) AT=850.05n

.meas tran vdout1_69ck840 FIND v(dout1_69) AT=850.05n

.meas tran vdout1_70ck840 FIND v(dout1_70) AT=850.05n

.meas tran vdout1_71ck840 FIND v(dout1_71) AT=850.05n

.meas tran vdout1_72ck840 FIND v(dout1_72) AT=850.05n

.meas tran vdout1_73ck840 FIND v(dout1_73) AT=850.05n

.meas tran vdout1_74ck840 FIND v(dout1_74) AT=850.05n

.meas tran vdout1_75ck840 FIND v(dout1_75) AT=850.05n

.meas tran vdout1_76ck840 FIND v(dout1_76) AT=850.05n

.meas tran vdout1_77ck840 FIND v(dout1_77) AT=850.05n

.meas tran vdout1_78ck840 FIND v(dout1_78) AT=850.05n

.meas tran vdout1_79ck840 FIND v(dout1_79) AT=850.05n

.meas tran vdout1_80ck840 FIND v(dout1_80) AT=850.05n

.meas tran vdout1_81ck840 FIND v(dout1_81) AT=850.05n

.meas tran vdout1_82ck840 FIND v(dout1_82) AT=850.05n

.meas tran vdout1_83ck840 FIND v(dout1_83) AT=850.05n

.meas tran vdout1_84ck840 FIND v(dout1_84) AT=850.05n

.meas tran vdout1_85ck840 FIND v(dout1_85) AT=850.05n

.meas tran vdout1_86ck840 FIND v(dout1_86) AT=850.05n

.meas tran vdout1_87ck840 FIND v(dout1_87) AT=850.05n

.meas tran vdout1_88ck840 FIND v(dout1_88) AT=850.05n

.meas tran vdout1_89ck840 FIND v(dout1_89) AT=850.05n

.meas tran vdout1_90ck840 FIND v(dout1_90) AT=850.05n

.meas tran vdout1_91ck840 FIND v(dout1_91) AT=850.05n

.meas tran vdout1_92ck840 FIND v(dout1_92) AT=850.05n

.meas tran vdout1_93ck840 FIND v(dout1_93) AT=850.05n

.meas tran vdout1_94ck840 FIND v(dout1_94) AT=850.05n

.meas tran vdout1_95ck840 FIND v(dout1_95) AT=850.05n

.meas tran vdout1_96ck840 FIND v(dout1_96) AT=850.05n

.meas tran vdout1_97ck840 FIND v(dout1_97) AT=850.05n

.meas tran vdout1_98ck840 FIND v(dout1_98) AT=850.05n

.meas tran vdout1_99ck840 FIND v(dout1_99) AT=850.05n

.meas tran vdout1_100ck840 FIND v(dout1_100) AT=850.05n

.meas tran vdout1_101ck840 FIND v(dout1_101) AT=850.05n

.meas tran vdout1_102ck840 FIND v(dout1_102) AT=850.05n

.meas tran vdout1_103ck840 FIND v(dout1_103) AT=850.05n

.meas tran vdout1_104ck840 FIND v(dout1_104) AT=850.05n

.meas tran vdout1_105ck840 FIND v(dout1_105) AT=850.05n

.meas tran vdout1_106ck840 FIND v(dout1_106) AT=850.05n

.meas tran vdout1_107ck840 FIND v(dout1_107) AT=850.05n

.meas tran vdout1_108ck840 FIND v(dout1_108) AT=850.05n

.meas tran vdout1_109ck840 FIND v(dout1_109) AT=850.05n

.meas tran vdout1_110ck840 FIND v(dout1_110) AT=850.05n

.meas tran vdout1_111ck840 FIND v(dout1_111) AT=850.05n

.meas tran vdout1_112ck840 FIND v(dout1_112) AT=850.05n

.meas tran vdout1_113ck840 FIND v(dout1_113) AT=850.05n

.meas tran vdout1_114ck840 FIND v(dout1_114) AT=850.05n

.meas tran vdout1_115ck840 FIND v(dout1_115) AT=850.05n

.meas tran vdout1_116ck840 FIND v(dout1_116) AT=850.05n

.meas tran vdout1_117ck840 FIND v(dout1_117) AT=850.05n

.meas tran vdout1_118ck840 FIND v(dout1_118) AT=850.05n

.meas tran vdout1_119ck840 FIND v(dout1_119) AT=850.05n

.meas tran vdout1_120ck840 FIND v(dout1_120) AT=850.05n

.meas tran vdout1_121ck840 FIND v(dout1_121) AT=850.05n

.meas tran vdout1_122ck840 FIND v(dout1_122) AT=850.05n

.meas tran vdout1_123ck840 FIND v(dout1_123) AT=850.05n

.meas tran vdout1_124ck840 FIND v(dout1_124) AT=850.05n

.meas tran vdout1_125ck840 FIND v(dout1_125) AT=850.05n

.meas tran vdout1_126ck840 FIND v(dout1_126) AT=850.05n

.meas tran vdout1_127ck840 FIND v(dout1_127) AT=850.05n

.meas tran vdout1_128ck840 FIND v(dout1_128) AT=850.05n

.meas tran vdout1_129ck840 FIND v(dout1_129) AT=850.05n

.meas tran vdout1_130ck840 FIND v(dout1_130) AT=850.05n

.meas tran vdout1_131ck840 FIND v(dout1_131) AT=850.05n

.meas tran vdout1_132ck840 FIND v(dout1_132) AT=850.05n

.meas tran vdout1_133ck840 FIND v(dout1_133) AT=850.05n

.meas tran vdout1_134ck840 FIND v(dout1_134) AT=850.05n

.meas tran vdout1_0ck850 FIND v(dout1_0) AT=860.05n

.meas tran vdout1_1ck850 FIND v(dout1_1) AT=860.05n

.meas tran vdout1_2ck850 FIND v(dout1_2) AT=860.05n

.meas tran vdout1_3ck850 FIND v(dout1_3) AT=860.05n

.meas tran vdout1_4ck850 FIND v(dout1_4) AT=860.05n

.meas tran vdout1_5ck850 FIND v(dout1_5) AT=860.05n

.meas tran vdout1_6ck850 FIND v(dout1_6) AT=860.05n

.meas tran vdout1_7ck850 FIND v(dout1_7) AT=860.05n

.meas tran vdout1_8ck850 FIND v(dout1_8) AT=860.05n

.meas tran vdout1_9ck850 FIND v(dout1_9) AT=860.05n

.meas tran vdout1_10ck850 FIND v(dout1_10) AT=860.05n

.meas tran vdout1_11ck850 FIND v(dout1_11) AT=860.05n

.meas tran vdout1_12ck850 FIND v(dout1_12) AT=860.05n

.meas tran vdout1_13ck850 FIND v(dout1_13) AT=860.05n

.meas tran vdout1_14ck850 FIND v(dout1_14) AT=860.05n

.meas tran vdout1_15ck850 FIND v(dout1_15) AT=860.05n

.meas tran vdout1_16ck850 FIND v(dout1_16) AT=860.05n

.meas tran vdout1_17ck850 FIND v(dout1_17) AT=860.05n

.meas tran vdout1_18ck850 FIND v(dout1_18) AT=860.05n

.meas tran vdout1_19ck850 FIND v(dout1_19) AT=860.05n

.meas tran vdout1_20ck850 FIND v(dout1_20) AT=860.05n

.meas tran vdout1_21ck850 FIND v(dout1_21) AT=860.05n

.meas tran vdout1_22ck850 FIND v(dout1_22) AT=860.05n

.meas tran vdout1_23ck850 FIND v(dout1_23) AT=860.05n

.meas tran vdout1_24ck850 FIND v(dout1_24) AT=860.05n

.meas tran vdout1_25ck850 FIND v(dout1_25) AT=860.05n

.meas tran vdout1_26ck850 FIND v(dout1_26) AT=860.05n

.meas tran vdout1_27ck850 FIND v(dout1_27) AT=860.05n

.meas tran vdout1_28ck850 FIND v(dout1_28) AT=860.05n

.meas tran vdout1_29ck850 FIND v(dout1_29) AT=860.05n

.meas tran vdout1_30ck850 FIND v(dout1_30) AT=860.05n

.meas tran vdout1_31ck850 FIND v(dout1_31) AT=860.05n

.meas tran vdout1_32ck850 FIND v(dout1_32) AT=860.05n

.meas tran vdout1_33ck850 FIND v(dout1_33) AT=860.05n

.meas tran vdout1_34ck850 FIND v(dout1_34) AT=860.05n

.meas tran vdout1_35ck850 FIND v(dout1_35) AT=860.05n

.meas tran vdout1_36ck850 FIND v(dout1_36) AT=860.05n

.meas tran vdout1_37ck850 FIND v(dout1_37) AT=860.05n

.meas tran vdout1_38ck850 FIND v(dout1_38) AT=860.05n

.meas tran vdout1_39ck850 FIND v(dout1_39) AT=860.05n

.meas tran vdout1_40ck850 FIND v(dout1_40) AT=860.05n

.meas tran vdout1_41ck850 FIND v(dout1_41) AT=860.05n

.meas tran vdout1_42ck850 FIND v(dout1_42) AT=860.05n

.meas tran vdout1_43ck850 FIND v(dout1_43) AT=860.05n

.meas tran vdout1_44ck850 FIND v(dout1_44) AT=860.05n

.meas tran vdout1_45ck850 FIND v(dout1_45) AT=860.05n

.meas tran vdout1_46ck850 FIND v(dout1_46) AT=860.05n

.meas tran vdout1_47ck850 FIND v(dout1_47) AT=860.05n

.meas tran vdout1_48ck850 FIND v(dout1_48) AT=860.05n

.meas tran vdout1_49ck850 FIND v(dout1_49) AT=860.05n

.meas tran vdout1_50ck850 FIND v(dout1_50) AT=860.05n

.meas tran vdout1_51ck850 FIND v(dout1_51) AT=860.05n

.meas tran vdout1_52ck850 FIND v(dout1_52) AT=860.05n

.meas tran vdout1_53ck850 FIND v(dout1_53) AT=860.05n

.meas tran vdout1_54ck850 FIND v(dout1_54) AT=860.05n

.meas tran vdout1_55ck850 FIND v(dout1_55) AT=860.05n

.meas tran vdout1_56ck850 FIND v(dout1_56) AT=860.05n

.meas tran vdout1_57ck850 FIND v(dout1_57) AT=860.05n

.meas tran vdout1_58ck850 FIND v(dout1_58) AT=860.05n

.meas tran vdout1_59ck850 FIND v(dout1_59) AT=860.05n

.meas tran vdout1_60ck850 FIND v(dout1_60) AT=860.05n

.meas tran vdout1_61ck850 FIND v(dout1_61) AT=860.05n

.meas tran vdout1_62ck850 FIND v(dout1_62) AT=860.05n

.meas tran vdout1_63ck850 FIND v(dout1_63) AT=860.05n

.meas tran vdout1_64ck850 FIND v(dout1_64) AT=860.05n

.meas tran vdout1_65ck850 FIND v(dout1_65) AT=860.05n

.meas tran vdout1_66ck850 FIND v(dout1_66) AT=860.05n

.meas tran vdout1_67ck850 FIND v(dout1_67) AT=860.05n

.meas tran vdout1_68ck850 FIND v(dout1_68) AT=860.05n

.meas tran vdout1_69ck850 FIND v(dout1_69) AT=860.05n

.meas tran vdout1_70ck850 FIND v(dout1_70) AT=860.05n

.meas tran vdout1_71ck850 FIND v(dout1_71) AT=860.05n

.meas tran vdout1_72ck850 FIND v(dout1_72) AT=860.05n

.meas tran vdout1_73ck850 FIND v(dout1_73) AT=860.05n

.meas tran vdout1_74ck850 FIND v(dout1_74) AT=860.05n

.meas tran vdout1_75ck850 FIND v(dout1_75) AT=860.05n

.meas tran vdout1_76ck850 FIND v(dout1_76) AT=860.05n

.meas tran vdout1_77ck850 FIND v(dout1_77) AT=860.05n

.meas tran vdout1_78ck850 FIND v(dout1_78) AT=860.05n

.meas tran vdout1_79ck850 FIND v(dout1_79) AT=860.05n

.meas tran vdout1_80ck850 FIND v(dout1_80) AT=860.05n

.meas tran vdout1_81ck850 FIND v(dout1_81) AT=860.05n

.meas tran vdout1_82ck850 FIND v(dout1_82) AT=860.05n

.meas tran vdout1_83ck850 FIND v(dout1_83) AT=860.05n

.meas tran vdout1_84ck850 FIND v(dout1_84) AT=860.05n

.meas tran vdout1_85ck850 FIND v(dout1_85) AT=860.05n

.meas tran vdout1_86ck850 FIND v(dout1_86) AT=860.05n

.meas tran vdout1_87ck850 FIND v(dout1_87) AT=860.05n

.meas tran vdout1_88ck850 FIND v(dout1_88) AT=860.05n

.meas tran vdout1_89ck850 FIND v(dout1_89) AT=860.05n

.meas tran vdout1_90ck850 FIND v(dout1_90) AT=860.05n

.meas tran vdout1_91ck850 FIND v(dout1_91) AT=860.05n

.meas tran vdout1_92ck850 FIND v(dout1_92) AT=860.05n

.meas tran vdout1_93ck850 FIND v(dout1_93) AT=860.05n

.meas tran vdout1_94ck850 FIND v(dout1_94) AT=860.05n

.meas tran vdout1_95ck850 FIND v(dout1_95) AT=860.05n

.meas tran vdout1_96ck850 FIND v(dout1_96) AT=860.05n

.meas tran vdout1_97ck850 FIND v(dout1_97) AT=860.05n

.meas tran vdout1_98ck850 FIND v(dout1_98) AT=860.05n

.meas tran vdout1_99ck850 FIND v(dout1_99) AT=860.05n

.meas tran vdout1_100ck850 FIND v(dout1_100) AT=860.05n

.meas tran vdout1_101ck850 FIND v(dout1_101) AT=860.05n

.meas tran vdout1_102ck850 FIND v(dout1_102) AT=860.05n

.meas tran vdout1_103ck850 FIND v(dout1_103) AT=860.05n

.meas tran vdout1_104ck850 FIND v(dout1_104) AT=860.05n

.meas tran vdout1_105ck850 FIND v(dout1_105) AT=860.05n

.meas tran vdout1_106ck850 FIND v(dout1_106) AT=860.05n

.meas tran vdout1_107ck850 FIND v(dout1_107) AT=860.05n

.meas tran vdout1_108ck850 FIND v(dout1_108) AT=860.05n

.meas tran vdout1_109ck850 FIND v(dout1_109) AT=860.05n

.meas tran vdout1_110ck850 FIND v(dout1_110) AT=860.05n

.meas tran vdout1_111ck850 FIND v(dout1_111) AT=860.05n

.meas tran vdout1_112ck850 FIND v(dout1_112) AT=860.05n

.meas tran vdout1_113ck850 FIND v(dout1_113) AT=860.05n

.meas tran vdout1_114ck850 FIND v(dout1_114) AT=860.05n

.meas tran vdout1_115ck850 FIND v(dout1_115) AT=860.05n

.meas tran vdout1_116ck850 FIND v(dout1_116) AT=860.05n

.meas tran vdout1_117ck850 FIND v(dout1_117) AT=860.05n

.meas tran vdout1_118ck850 FIND v(dout1_118) AT=860.05n

.meas tran vdout1_119ck850 FIND v(dout1_119) AT=860.05n

.meas tran vdout1_120ck850 FIND v(dout1_120) AT=860.05n

.meas tran vdout1_121ck850 FIND v(dout1_121) AT=860.05n

.meas tran vdout1_122ck850 FIND v(dout1_122) AT=860.05n

.meas tran vdout1_123ck850 FIND v(dout1_123) AT=860.05n

.meas tran vdout1_124ck850 FIND v(dout1_124) AT=860.05n

.meas tran vdout1_125ck850 FIND v(dout1_125) AT=860.05n

.meas tran vdout1_126ck850 FIND v(dout1_126) AT=860.05n

.meas tran vdout1_127ck850 FIND v(dout1_127) AT=860.05n

.meas tran vdout1_128ck850 FIND v(dout1_128) AT=860.05n

.meas tran vdout1_129ck850 FIND v(dout1_129) AT=860.05n

.meas tran vdout1_130ck850 FIND v(dout1_130) AT=860.05n

.meas tran vdout1_131ck850 FIND v(dout1_131) AT=860.05n

.meas tran vdout1_132ck850 FIND v(dout1_132) AT=860.05n

.meas tran vdout1_133ck850 FIND v(dout1_133) AT=860.05n

.meas tran vdout1_134ck850 FIND v(dout1_134) AT=860.05n

.meas tran vdout1_0ck870 FIND v(dout1_0) AT=880.05n

.meas tran vdout1_1ck870 FIND v(dout1_1) AT=880.05n

.meas tran vdout1_2ck870 FIND v(dout1_2) AT=880.05n

.meas tran vdout1_3ck870 FIND v(dout1_3) AT=880.05n

.meas tran vdout1_4ck870 FIND v(dout1_4) AT=880.05n

.meas tran vdout1_5ck870 FIND v(dout1_5) AT=880.05n

.meas tran vdout1_6ck870 FIND v(dout1_6) AT=880.05n

.meas tran vdout1_7ck870 FIND v(dout1_7) AT=880.05n

.meas tran vdout1_8ck870 FIND v(dout1_8) AT=880.05n

.meas tran vdout1_9ck870 FIND v(dout1_9) AT=880.05n

.meas tran vdout1_10ck870 FIND v(dout1_10) AT=880.05n

.meas tran vdout1_11ck870 FIND v(dout1_11) AT=880.05n

.meas tran vdout1_12ck870 FIND v(dout1_12) AT=880.05n

.meas tran vdout1_13ck870 FIND v(dout1_13) AT=880.05n

.meas tran vdout1_14ck870 FIND v(dout1_14) AT=880.05n

.meas tran vdout1_15ck870 FIND v(dout1_15) AT=880.05n

.meas tran vdout1_16ck870 FIND v(dout1_16) AT=880.05n

.meas tran vdout1_17ck870 FIND v(dout1_17) AT=880.05n

.meas tran vdout1_18ck870 FIND v(dout1_18) AT=880.05n

.meas tran vdout1_19ck870 FIND v(dout1_19) AT=880.05n

.meas tran vdout1_20ck870 FIND v(dout1_20) AT=880.05n

.meas tran vdout1_21ck870 FIND v(dout1_21) AT=880.05n

.meas tran vdout1_22ck870 FIND v(dout1_22) AT=880.05n

.meas tran vdout1_23ck870 FIND v(dout1_23) AT=880.05n

.meas tran vdout1_24ck870 FIND v(dout1_24) AT=880.05n

.meas tran vdout1_25ck870 FIND v(dout1_25) AT=880.05n

.meas tran vdout1_26ck870 FIND v(dout1_26) AT=880.05n

.meas tran vdout1_27ck870 FIND v(dout1_27) AT=880.05n

.meas tran vdout1_28ck870 FIND v(dout1_28) AT=880.05n

.meas tran vdout1_29ck870 FIND v(dout1_29) AT=880.05n

.meas tran vdout1_30ck870 FIND v(dout1_30) AT=880.05n

.meas tran vdout1_31ck870 FIND v(dout1_31) AT=880.05n

.meas tran vdout1_32ck870 FIND v(dout1_32) AT=880.05n

.meas tran vdout1_33ck870 FIND v(dout1_33) AT=880.05n

.meas tran vdout1_34ck870 FIND v(dout1_34) AT=880.05n

.meas tran vdout1_35ck870 FIND v(dout1_35) AT=880.05n

.meas tran vdout1_36ck870 FIND v(dout1_36) AT=880.05n

.meas tran vdout1_37ck870 FIND v(dout1_37) AT=880.05n

.meas tran vdout1_38ck870 FIND v(dout1_38) AT=880.05n

.meas tran vdout1_39ck870 FIND v(dout1_39) AT=880.05n

.meas tran vdout1_40ck870 FIND v(dout1_40) AT=880.05n

.meas tran vdout1_41ck870 FIND v(dout1_41) AT=880.05n

.meas tran vdout1_42ck870 FIND v(dout1_42) AT=880.05n

.meas tran vdout1_43ck870 FIND v(dout1_43) AT=880.05n

.meas tran vdout1_44ck870 FIND v(dout1_44) AT=880.05n

.meas tran vdout1_45ck870 FIND v(dout1_45) AT=880.05n

.meas tran vdout1_46ck870 FIND v(dout1_46) AT=880.05n

.meas tran vdout1_47ck870 FIND v(dout1_47) AT=880.05n

.meas tran vdout1_48ck870 FIND v(dout1_48) AT=880.05n

.meas tran vdout1_49ck870 FIND v(dout1_49) AT=880.05n

.meas tran vdout1_50ck870 FIND v(dout1_50) AT=880.05n

.meas tran vdout1_51ck870 FIND v(dout1_51) AT=880.05n

.meas tran vdout1_52ck870 FIND v(dout1_52) AT=880.05n

.meas tran vdout1_53ck870 FIND v(dout1_53) AT=880.05n

.meas tran vdout1_54ck870 FIND v(dout1_54) AT=880.05n

.meas tran vdout1_55ck870 FIND v(dout1_55) AT=880.05n

.meas tran vdout1_56ck870 FIND v(dout1_56) AT=880.05n

.meas tran vdout1_57ck870 FIND v(dout1_57) AT=880.05n

.meas tran vdout1_58ck870 FIND v(dout1_58) AT=880.05n

.meas tran vdout1_59ck870 FIND v(dout1_59) AT=880.05n

.meas tran vdout1_60ck870 FIND v(dout1_60) AT=880.05n

.meas tran vdout1_61ck870 FIND v(dout1_61) AT=880.05n

.meas tran vdout1_62ck870 FIND v(dout1_62) AT=880.05n

.meas tran vdout1_63ck870 FIND v(dout1_63) AT=880.05n

.meas tran vdout1_64ck870 FIND v(dout1_64) AT=880.05n

.meas tran vdout1_65ck870 FIND v(dout1_65) AT=880.05n

.meas tran vdout1_66ck870 FIND v(dout1_66) AT=880.05n

.meas tran vdout1_67ck870 FIND v(dout1_67) AT=880.05n

.meas tran vdout1_68ck870 FIND v(dout1_68) AT=880.05n

.meas tran vdout1_69ck870 FIND v(dout1_69) AT=880.05n

.meas tran vdout1_70ck870 FIND v(dout1_70) AT=880.05n

.meas tran vdout1_71ck870 FIND v(dout1_71) AT=880.05n

.meas tran vdout1_72ck870 FIND v(dout1_72) AT=880.05n

.meas tran vdout1_73ck870 FIND v(dout1_73) AT=880.05n

.meas tran vdout1_74ck870 FIND v(dout1_74) AT=880.05n

.meas tran vdout1_75ck870 FIND v(dout1_75) AT=880.05n

.meas tran vdout1_76ck870 FIND v(dout1_76) AT=880.05n

.meas tran vdout1_77ck870 FIND v(dout1_77) AT=880.05n

.meas tran vdout1_78ck870 FIND v(dout1_78) AT=880.05n

.meas tran vdout1_79ck870 FIND v(dout1_79) AT=880.05n

.meas tran vdout1_80ck870 FIND v(dout1_80) AT=880.05n

.meas tran vdout1_81ck870 FIND v(dout1_81) AT=880.05n

.meas tran vdout1_82ck870 FIND v(dout1_82) AT=880.05n

.meas tran vdout1_83ck870 FIND v(dout1_83) AT=880.05n

.meas tran vdout1_84ck870 FIND v(dout1_84) AT=880.05n

.meas tran vdout1_85ck870 FIND v(dout1_85) AT=880.05n

.meas tran vdout1_86ck870 FIND v(dout1_86) AT=880.05n

.meas tran vdout1_87ck870 FIND v(dout1_87) AT=880.05n

.meas tran vdout1_88ck870 FIND v(dout1_88) AT=880.05n

.meas tran vdout1_89ck870 FIND v(dout1_89) AT=880.05n

.meas tran vdout1_90ck870 FIND v(dout1_90) AT=880.05n

.meas tran vdout1_91ck870 FIND v(dout1_91) AT=880.05n

.meas tran vdout1_92ck870 FIND v(dout1_92) AT=880.05n

.meas tran vdout1_93ck870 FIND v(dout1_93) AT=880.05n

.meas tran vdout1_94ck870 FIND v(dout1_94) AT=880.05n

.meas tran vdout1_95ck870 FIND v(dout1_95) AT=880.05n

.meas tran vdout1_96ck870 FIND v(dout1_96) AT=880.05n

.meas tran vdout1_97ck870 FIND v(dout1_97) AT=880.05n

.meas tran vdout1_98ck870 FIND v(dout1_98) AT=880.05n

.meas tran vdout1_99ck870 FIND v(dout1_99) AT=880.05n

.meas tran vdout1_100ck870 FIND v(dout1_100) AT=880.05n

.meas tran vdout1_101ck870 FIND v(dout1_101) AT=880.05n

.meas tran vdout1_102ck870 FIND v(dout1_102) AT=880.05n

.meas tran vdout1_103ck870 FIND v(dout1_103) AT=880.05n

.meas tran vdout1_104ck870 FIND v(dout1_104) AT=880.05n

.meas tran vdout1_105ck870 FIND v(dout1_105) AT=880.05n

.meas tran vdout1_106ck870 FIND v(dout1_106) AT=880.05n

.meas tran vdout1_107ck870 FIND v(dout1_107) AT=880.05n

.meas tran vdout1_108ck870 FIND v(dout1_108) AT=880.05n

.meas tran vdout1_109ck870 FIND v(dout1_109) AT=880.05n

.meas tran vdout1_110ck870 FIND v(dout1_110) AT=880.05n

.meas tran vdout1_111ck870 FIND v(dout1_111) AT=880.05n

.meas tran vdout1_112ck870 FIND v(dout1_112) AT=880.05n

.meas tran vdout1_113ck870 FIND v(dout1_113) AT=880.05n

.meas tran vdout1_114ck870 FIND v(dout1_114) AT=880.05n

.meas tran vdout1_115ck870 FIND v(dout1_115) AT=880.05n

.meas tran vdout1_116ck870 FIND v(dout1_116) AT=880.05n

.meas tran vdout1_117ck870 FIND v(dout1_117) AT=880.05n

.meas tran vdout1_118ck870 FIND v(dout1_118) AT=880.05n

.meas tran vdout1_119ck870 FIND v(dout1_119) AT=880.05n

.meas tran vdout1_120ck870 FIND v(dout1_120) AT=880.05n

.meas tran vdout1_121ck870 FIND v(dout1_121) AT=880.05n

.meas tran vdout1_122ck870 FIND v(dout1_122) AT=880.05n

.meas tran vdout1_123ck870 FIND v(dout1_123) AT=880.05n

.meas tran vdout1_124ck870 FIND v(dout1_124) AT=880.05n

.meas tran vdout1_125ck870 FIND v(dout1_125) AT=880.05n

.meas tran vdout1_126ck870 FIND v(dout1_126) AT=880.05n

.meas tran vdout1_127ck870 FIND v(dout1_127) AT=880.05n

.meas tran vdout1_128ck870 FIND v(dout1_128) AT=880.05n

.meas tran vdout1_129ck870 FIND v(dout1_129) AT=880.05n

.meas tran vdout1_130ck870 FIND v(dout1_130) AT=880.05n

.meas tran vdout1_131ck870 FIND v(dout1_131) AT=880.05n

.meas tran vdout1_132ck870 FIND v(dout1_132) AT=880.05n

.meas tran vdout1_133ck870 FIND v(dout1_133) AT=880.05n

.meas tran vdout1_134ck870 FIND v(dout1_134) AT=880.05n

.meas tran vdout1_0ck910 FIND v(dout1_0) AT=920.05n

.meas tran vdout1_1ck910 FIND v(dout1_1) AT=920.05n

.meas tran vdout1_2ck910 FIND v(dout1_2) AT=920.05n

.meas tran vdout1_3ck910 FIND v(dout1_3) AT=920.05n

.meas tran vdout1_4ck910 FIND v(dout1_4) AT=920.05n

.meas tran vdout1_5ck910 FIND v(dout1_5) AT=920.05n

.meas tran vdout1_6ck910 FIND v(dout1_6) AT=920.05n

.meas tran vdout1_7ck910 FIND v(dout1_7) AT=920.05n

.meas tran vdout1_8ck910 FIND v(dout1_8) AT=920.05n

.meas tran vdout1_9ck910 FIND v(dout1_9) AT=920.05n

.meas tran vdout1_10ck910 FIND v(dout1_10) AT=920.05n

.meas tran vdout1_11ck910 FIND v(dout1_11) AT=920.05n

.meas tran vdout1_12ck910 FIND v(dout1_12) AT=920.05n

.meas tran vdout1_13ck910 FIND v(dout1_13) AT=920.05n

.meas tran vdout1_14ck910 FIND v(dout1_14) AT=920.05n

.meas tran vdout1_15ck910 FIND v(dout1_15) AT=920.05n

.meas tran vdout1_16ck910 FIND v(dout1_16) AT=920.05n

.meas tran vdout1_17ck910 FIND v(dout1_17) AT=920.05n

.meas tran vdout1_18ck910 FIND v(dout1_18) AT=920.05n

.meas tran vdout1_19ck910 FIND v(dout1_19) AT=920.05n

.meas tran vdout1_20ck910 FIND v(dout1_20) AT=920.05n

.meas tran vdout1_21ck910 FIND v(dout1_21) AT=920.05n

.meas tran vdout1_22ck910 FIND v(dout1_22) AT=920.05n

.meas tran vdout1_23ck910 FIND v(dout1_23) AT=920.05n

.meas tran vdout1_24ck910 FIND v(dout1_24) AT=920.05n

.meas tran vdout1_25ck910 FIND v(dout1_25) AT=920.05n

.meas tran vdout1_26ck910 FIND v(dout1_26) AT=920.05n

.meas tran vdout1_27ck910 FIND v(dout1_27) AT=920.05n

.meas tran vdout1_28ck910 FIND v(dout1_28) AT=920.05n

.meas tran vdout1_29ck910 FIND v(dout1_29) AT=920.05n

.meas tran vdout1_30ck910 FIND v(dout1_30) AT=920.05n

.meas tran vdout1_31ck910 FIND v(dout1_31) AT=920.05n

.meas tran vdout1_32ck910 FIND v(dout1_32) AT=920.05n

.meas tran vdout1_33ck910 FIND v(dout1_33) AT=920.05n

.meas tran vdout1_34ck910 FIND v(dout1_34) AT=920.05n

.meas tran vdout1_35ck910 FIND v(dout1_35) AT=920.05n

.meas tran vdout1_36ck910 FIND v(dout1_36) AT=920.05n

.meas tran vdout1_37ck910 FIND v(dout1_37) AT=920.05n

.meas tran vdout1_38ck910 FIND v(dout1_38) AT=920.05n

.meas tran vdout1_39ck910 FIND v(dout1_39) AT=920.05n

.meas tran vdout1_40ck910 FIND v(dout1_40) AT=920.05n

.meas tran vdout1_41ck910 FIND v(dout1_41) AT=920.05n

.meas tran vdout1_42ck910 FIND v(dout1_42) AT=920.05n

.meas tran vdout1_43ck910 FIND v(dout1_43) AT=920.05n

.meas tran vdout1_44ck910 FIND v(dout1_44) AT=920.05n

.meas tran vdout1_45ck910 FIND v(dout1_45) AT=920.05n

.meas tran vdout1_46ck910 FIND v(dout1_46) AT=920.05n

.meas tran vdout1_47ck910 FIND v(dout1_47) AT=920.05n

.meas tran vdout1_48ck910 FIND v(dout1_48) AT=920.05n

.meas tran vdout1_49ck910 FIND v(dout1_49) AT=920.05n

.meas tran vdout1_50ck910 FIND v(dout1_50) AT=920.05n

.meas tran vdout1_51ck910 FIND v(dout1_51) AT=920.05n

.meas tran vdout1_52ck910 FIND v(dout1_52) AT=920.05n

.meas tran vdout1_53ck910 FIND v(dout1_53) AT=920.05n

.meas tran vdout1_54ck910 FIND v(dout1_54) AT=920.05n

.meas tran vdout1_55ck910 FIND v(dout1_55) AT=920.05n

.meas tran vdout1_56ck910 FIND v(dout1_56) AT=920.05n

.meas tran vdout1_57ck910 FIND v(dout1_57) AT=920.05n

.meas tran vdout1_58ck910 FIND v(dout1_58) AT=920.05n

.meas tran vdout1_59ck910 FIND v(dout1_59) AT=920.05n

.meas tran vdout1_60ck910 FIND v(dout1_60) AT=920.05n

.meas tran vdout1_61ck910 FIND v(dout1_61) AT=920.05n

.meas tran vdout1_62ck910 FIND v(dout1_62) AT=920.05n

.meas tran vdout1_63ck910 FIND v(dout1_63) AT=920.05n

.meas tran vdout1_64ck910 FIND v(dout1_64) AT=920.05n

.meas tran vdout1_65ck910 FIND v(dout1_65) AT=920.05n

.meas tran vdout1_66ck910 FIND v(dout1_66) AT=920.05n

.meas tran vdout1_67ck910 FIND v(dout1_67) AT=920.05n

.meas tran vdout1_68ck910 FIND v(dout1_68) AT=920.05n

.meas tran vdout1_69ck910 FIND v(dout1_69) AT=920.05n

.meas tran vdout1_70ck910 FIND v(dout1_70) AT=920.05n

.meas tran vdout1_71ck910 FIND v(dout1_71) AT=920.05n

.meas tran vdout1_72ck910 FIND v(dout1_72) AT=920.05n

.meas tran vdout1_73ck910 FIND v(dout1_73) AT=920.05n

.meas tran vdout1_74ck910 FIND v(dout1_74) AT=920.05n

.meas tran vdout1_75ck910 FIND v(dout1_75) AT=920.05n

.meas tran vdout1_76ck910 FIND v(dout1_76) AT=920.05n

.meas tran vdout1_77ck910 FIND v(dout1_77) AT=920.05n

.meas tran vdout1_78ck910 FIND v(dout1_78) AT=920.05n

.meas tran vdout1_79ck910 FIND v(dout1_79) AT=920.05n

.meas tran vdout1_80ck910 FIND v(dout1_80) AT=920.05n

.meas tran vdout1_81ck910 FIND v(dout1_81) AT=920.05n

.meas tran vdout1_82ck910 FIND v(dout1_82) AT=920.05n

.meas tran vdout1_83ck910 FIND v(dout1_83) AT=920.05n

.meas tran vdout1_84ck910 FIND v(dout1_84) AT=920.05n

.meas tran vdout1_85ck910 FIND v(dout1_85) AT=920.05n

.meas tran vdout1_86ck910 FIND v(dout1_86) AT=920.05n

.meas tran vdout1_87ck910 FIND v(dout1_87) AT=920.05n

.meas tran vdout1_88ck910 FIND v(dout1_88) AT=920.05n

.meas tran vdout1_89ck910 FIND v(dout1_89) AT=920.05n

.meas tran vdout1_90ck910 FIND v(dout1_90) AT=920.05n

.meas tran vdout1_91ck910 FIND v(dout1_91) AT=920.05n

.meas tran vdout1_92ck910 FIND v(dout1_92) AT=920.05n

.meas tran vdout1_93ck910 FIND v(dout1_93) AT=920.05n

.meas tran vdout1_94ck910 FIND v(dout1_94) AT=920.05n

.meas tran vdout1_95ck910 FIND v(dout1_95) AT=920.05n

.meas tran vdout1_96ck910 FIND v(dout1_96) AT=920.05n

.meas tran vdout1_97ck910 FIND v(dout1_97) AT=920.05n

.meas tran vdout1_98ck910 FIND v(dout1_98) AT=920.05n

.meas tran vdout1_99ck910 FIND v(dout1_99) AT=920.05n

.meas tran vdout1_100ck910 FIND v(dout1_100) AT=920.05n

.meas tran vdout1_101ck910 FIND v(dout1_101) AT=920.05n

.meas tran vdout1_102ck910 FIND v(dout1_102) AT=920.05n

.meas tran vdout1_103ck910 FIND v(dout1_103) AT=920.05n

.meas tran vdout1_104ck910 FIND v(dout1_104) AT=920.05n

.meas tran vdout1_105ck910 FIND v(dout1_105) AT=920.05n

.meas tran vdout1_106ck910 FIND v(dout1_106) AT=920.05n

.meas tran vdout1_107ck910 FIND v(dout1_107) AT=920.05n

.meas tran vdout1_108ck910 FIND v(dout1_108) AT=920.05n

.meas tran vdout1_109ck910 FIND v(dout1_109) AT=920.05n

.meas tran vdout1_110ck910 FIND v(dout1_110) AT=920.05n

.meas tran vdout1_111ck910 FIND v(dout1_111) AT=920.05n

.meas tran vdout1_112ck910 FIND v(dout1_112) AT=920.05n

.meas tran vdout1_113ck910 FIND v(dout1_113) AT=920.05n

.meas tran vdout1_114ck910 FIND v(dout1_114) AT=920.05n

.meas tran vdout1_115ck910 FIND v(dout1_115) AT=920.05n

.meas tran vdout1_116ck910 FIND v(dout1_116) AT=920.05n

.meas tran vdout1_117ck910 FIND v(dout1_117) AT=920.05n

.meas tran vdout1_118ck910 FIND v(dout1_118) AT=920.05n

.meas tran vdout1_119ck910 FIND v(dout1_119) AT=920.05n

.meas tran vdout1_120ck910 FIND v(dout1_120) AT=920.05n

.meas tran vdout1_121ck910 FIND v(dout1_121) AT=920.05n

.meas tran vdout1_122ck910 FIND v(dout1_122) AT=920.05n

.meas tran vdout1_123ck910 FIND v(dout1_123) AT=920.05n

.meas tran vdout1_124ck910 FIND v(dout1_124) AT=920.05n

.meas tran vdout1_125ck910 FIND v(dout1_125) AT=920.05n

.meas tran vdout1_126ck910 FIND v(dout1_126) AT=920.05n

.meas tran vdout1_127ck910 FIND v(dout1_127) AT=920.05n

.meas tran vdout1_128ck910 FIND v(dout1_128) AT=920.05n

.meas tran vdout1_129ck910 FIND v(dout1_129) AT=920.05n

.meas tran vdout1_130ck910 FIND v(dout1_130) AT=920.05n

.meas tran vdout1_131ck910 FIND v(dout1_131) AT=920.05n

.meas tran vdout1_132ck910 FIND v(dout1_132) AT=920.05n

.meas tran vdout1_133ck910 FIND v(dout1_133) AT=920.05n

.meas tran vdout1_134ck910 FIND v(dout1_134) AT=920.05n

.meas tran vdout1_0ck920 FIND v(dout1_0) AT=930.05n

.meas tran vdout1_1ck920 FIND v(dout1_1) AT=930.05n

.meas tran vdout1_2ck920 FIND v(dout1_2) AT=930.05n

.meas tran vdout1_3ck920 FIND v(dout1_3) AT=930.05n

.meas tran vdout1_4ck920 FIND v(dout1_4) AT=930.05n

.meas tran vdout1_5ck920 FIND v(dout1_5) AT=930.05n

.meas tran vdout1_6ck920 FIND v(dout1_6) AT=930.05n

.meas tran vdout1_7ck920 FIND v(dout1_7) AT=930.05n

.meas tran vdout1_8ck920 FIND v(dout1_8) AT=930.05n

.meas tran vdout1_9ck920 FIND v(dout1_9) AT=930.05n

.meas tran vdout1_10ck920 FIND v(dout1_10) AT=930.05n

.meas tran vdout1_11ck920 FIND v(dout1_11) AT=930.05n

.meas tran vdout1_12ck920 FIND v(dout1_12) AT=930.05n

.meas tran vdout1_13ck920 FIND v(dout1_13) AT=930.05n

.meas tran vdout1_14ck920 FIND v(dout1_14) AT=930.05n

.meas tran vdout1_15ck920 FIND v(dout1_15) AT=930.05n

.meas tran vdout1_16ck920 FIND v(dout1_16) AT=930.05n

.meas tran vdout1_17ck920 FIND v(dout1_17) AT=930.05n

.meas tran vdout1_18ck920 FIND v(dout1_18) AT=930.05n

.meas tran vdout1_19ck920 FIND v(dout1_19) AT=930.05n

.meas tran vdout1_20ck920 FIND v(dout1_20) AT=930.05n

.meas tran vdout1_21ck920 FIND v(dout1_21) AT=930.05n

.meas tran vdout1_22ck920 FIND v(dout1_22) AT=930.05n

.meas tran vdout1_23ck920 FIND v(dout1_23) AT=930.05n

.meas tran vdout1_24ck920 FIND v(dout1_24) AT=930.05n

.meas tran vdout1_25ck920 FIND v(dout1_25) AT=930.05n

.meas tran vdout1_26ck920 FIND v(dout1_26) AT=930.05n

.meas tran vdout1_27ck920 FIND v(dout1_27) AT=930.05n

.meas tran vdout1_28ck920 FIND v(dout1_28) AT=930.05n

.meas tran vdout1_29ck920 FIND v(dout1_29) AT=930.05n

.meas tran vdout1_30ck920 FIND v(dout1_30) AT=930.05n

.meas tran vdout1_31ck920 FIND v(dout1_31) AT=930.05n

.meas tran vdout1_32ck920 FIND v(dout1_32) AT=930.05n

.meas tran vdout1_33ck920 FIND v(dout1_33) AT=930.05n

.meas tran vdout1_34ck920 FIND v(dout1_34) AT=930.05n

.meas tran vdout1_35ck920 FIND v(dout1_35) AT=930.05n

.meas tran vdout1_36ck920 FIND v(dout1_36) AT=930.05n

.meas tran vdout1_37ck920 FIND v(dout1_37) AT=930.05n

.meas tran vdout1_38ck920 FIND v(dout1_38) AT=930.05n

.meas tran vdout1_39ck920 FIND v(dout1_39) AT=930.05n

.meas tran vdout1_40ck920 FIND v(dout1_40) AT=930.05n

.meas tran vdout1_41ck920 FIND v(dout1_41) AT=930.05n

.meas tran vdout1_42ck920 FIND v(dout1_42) AT=930.05n

.meas tran vdout1_43ck920 FIND v(dout1_43) AT=930.05n

.meas tran vdout1_44ck920 FIND v(dout1_44) AT=930.05n

.meas tran vdout1_45ck920 FIND v(dout1_45) AT=930.05n

.meas tran vdout1_46ck920 FIND v(dout1_46) AT=930.05n

.meas tran vdout1_47ck920 FIND v(dout1_47) AT=930.05n

.meas tran vdout1_48ck920 FIND v(dout1_48) AT=930.05n

.meas tran vdout1_49ck920 FIND v(dout1_49) AT=930.05n

.meas tran vdout1_50ck920 FIND v(dout1_50) AT=930.05n

.meas tran vdout1_51ck920 FIND v(dout1_51) AT=930.05n

.meas tran vdout1_52ck920 FIND v(dout1_52) AT=930.05n

.meas tran vdout1_53ck920 FIND v(dout1_53) AT=930.05n

.meas tran vdout1_54ck920 FIND v(dout1_54) AT=930.05n

.meas tran vdout1_55ck920 FIND v(dout1_55) AT=930.05n

.meas tran vdout1_56ck920 FIND v(dout1_56) AT=930.05n

.meas tran vdout1_57ck920 FIND v(dout1_57) AT=930.05n

.meas tran vdout1_58ck920 FIND v(dout1_58) AT=930.05n

.meas tran vdout1_59ck920 FIND v(dout1_59) AT=930.05n

.meas tran vdout1_60ck920 FIND v(dout1_60) AT=930.05n

.meas tran vdout1_61ck920 FIND v(dout1_61) AT=930.05n

.meas tran vdout1_62ck920 FIND v(dout1_62) AT=930.05n

.meas tran vdout1_63ck920 FIND v(dout1_63) AT=930.05n

.meas tran vdout1_64ck920 FIND v(dout1_64) AT=930.05n

.meas tran vdout1_65ck920 FIND v(dout1_65) AT=930.05n

.meas tran vdout1_66ck920 FIND v(dout1_66) AT=930.05n

.meas tran vdout1_67ck920 FIND v(dout1_67) AT=930.05n

.meas tran vdout1_68ck920 FIND v(dout1_68) AT=930.05n

.meas tran vdout1_69ck920 FIND v(dout1_69) AT=930.05n

.meas tran vdout1_70ck920 FIND v(dout1_70) AT=930.05n

.meas tran vdout1_71ck920 FIND v(dout1_71) AT=930.05n

.meas tran vdout1_72ck920 FIND v(dout1_72) AT=930.05n

.meas tran vdout1_73ck920 FIND v(dout1_73) AT=930.05n

.meas tran vdout1_74ck920 FIND v(dout1_74) AT=930.05n

.meas tran vdout1_75ck920 FIND v(dout1_75) AT=930.05n

.meas tran vdout1_76ck920 FIND v(dout1_76) AT=930.05n

.meas tran vdout1_77ck920 FIND v(dout1_77) AT=930.05n

.meas tran vdout1_78ck920 FIND v(dout1_78) AT=930.05n

.meas tran vdout1_79ck920 FIND v(dout1_79) AT=930.05n

.meas tran vdout1_80ck920 FIND v(dout1_80) AT=930.05n

.meas tran vdout1_81ck920 FIND v(dout1_81) AT=930.05n

.meas tran vdout1_82ck920 FIND v(dout1_82) AT=930.05n

.meas tran vdout1_83ck920 FIND v(dout1_83) AT=930.05n

.meas tran vdout1_84ck920 FIND v(dout1_84) AT=930.05n

.meas tran vdout1_85ck920 FIND v(dout1_85) AT=930.05n

.meas tran vdout1_86ck920 FIND v(dout1_86) AT=930.05n

.meas tran vdout1_87ck920 FIND v(dout1_87) AT=930.05n

.meas tran vdout1_88ck920 FIND v(dout1_88) AT=930.05n

.meas tran vdout1_89ck920 FIND v(dout1_89) AT=930.05n

.meas tran vdout1_90ck920 FIND v(dout1_90) AT=930.05n

.meas tran vdout1_91ck920 FIND v(dout1_91) AT=930.05n

.meas tran vdout1_92ck920 FIND v(dout1_92) AT=930.05n

.meas tran vdout1_93ck920 FIND v(dout1_93) AT=930.05n

.meas tran vdout1_94ck920 FIND v(dout1_94) AT=930.05n

.meas tran vdout1_95ck920 FIND v(dout1_95) AT=930.05n

.meas tran vdout1_96ck920 FIND v(dout1_96) AT=930.05n

.meas tran vdout1_97ck920 FIND v(dout1_97) AT=930.05n

.meas tran vdout1_98ck920 FIND v(dout1_98) AT=930.05n

.meas tran vdout1_99ck920 FIND v(dout1_99) AT=930.05n

.meas tran vdout1_100ck920 FIND v(dout1_100) AT=930.05n

.meas tran vdout1_101ck920 FIND v(dout1_101) AT=930.05n

.meas tran vdout1_102ck920 FIND v(dout1_102) AT=930.05n

.meas tran vdout1_103ck920 FIND v(dout1_103) AT=930.05n

.meas tran vdout1_104ck920 FIND v(dout1_104) AT=930.05n

.meas tran vdout1_105ck920 FIND v(dout1_105) AT=930.05n

.meas tran vdout1_106ck920 FIND v(dout1_106) AT=930.05n

.meas tran vdout1_107ck920 FIND v(dout1_107) AT=930.05n

.meas tran vdout1_108ck920 FIND v(dout1_108) AT=930.05n

.meas tran vdout1_109ck920 FIND v(dout1_109) AT=930.05n

.meas tran vdout1_110ck920 FIND v(dout1_110) AT=930.05n

.meas tran vdout1_111ck920 FIND v(dout1_111) AT=930.05n

.meas tran vdout1_112ck920 FIND v(dout1_112) AT=930.05n

.meas tran vdout1_113ck920 FIND v(dout1_113) AT=930.05n

.meas tran vdout1_114ck920 FIND v(dout1_114) AT=930.05n

.meas tran vdout1_115ck920 FIND v(dout1_115) AT=930.05n

.meas tran vdout1_116ck920 FIND v(dout1_116) AT=930.05n

.meas tran vdout1_117ck920 FIND v(dout1_117) AT=930.05n

.meas tran vdout1_118ck920 FIND v(dout1_118) AT=930.05n

.meas tran vdout1_119ck920 FIND v(dout1_119) AT=930.05n

.meas tran vdout1_120ck920 FIND v(dout1_120) AT=930.05n

.meas tran vdout1_121ck920 FIND v(dout1_121) AT=930.05n

.meas tran vdout1_122ck920 FIND v(dout1_122) AT=930.05n

.meas tran vdout1_123ck920 FIND v(dout1_123) AT=930.05n

.meas tran vdout1_124ck920 FIND v(dout1_124) AT=930.05n

.meas tran vdout1_125ck920 FIND v(dout1_125) AT=930.05n

.meas tran vdout1_126ck920 FIND v(dout1_126) AT=930.05n

.meas tran vdout1_127ck920 FIND v(dout1_127) AT=930.05n

.meas tran vdout1_128ck920 FIND v(dout1_128) AT=930.05n

.meas tran vdout1_129ck920 FIND v(dout1_129) AT=930.05n

.meas tran vdout1_130ck920 FIND v(dout1_130) AT=930.05n

.meas tran vdout1_131ck920 FIND v(dout1_131) AT=930.05n

.meas tran vdout1_132ck920 FIND v(dout1_132) AT=930.05n

.meas tran vdout1_133ck920 FIND v(dout1_133) AT=930.05n

.meas tran vdout1_134ck920 FIND v(dout1_134) AT=930.05n

.meas tran vdout1_0ck950 FIND v(dout1_0) AT=960.05n

.meas tran vdout1_1ck950 FIND v(dout1_1) AT=960.05n

.meas tran vdout1_2ck950 FIND v(dout1_2) AT=960.05n

.meas tran vdout1_3ck950 FIND v(dout1_3) AT=960.05n

.meas tran vdout1_4ck950 FIND v(dout1_4) AT=960.05n

.meas tran vdout1_5ck950 FIND v(dout1_5) AT=960.05n

.meas tran vdout1_6ck950 FIND v(dout1_6) AT=960.05n

.meas tran vdout1_7ck950 FIND v(dout1_7) AT=960.05n

.meas tran vdout1_8ck950 FIND v(dout1_8) AT=960.05n

.meas tran vdout1_9ck950 FIND v(dout1_9) AT=960.05n

.meas tran vdout1_10ck950 FIND v(dout1_10) AT=960.05n

.meas tran vdout1_11ck950 FIND v(dout1_11) AT=960.05n

.meas tran vdout1_12ck950 FIND v(dout1_12) AT=960.05n

.meas tran vdout1_13ck950 FIND v(dout1_13) AT=960.05n

.meas tran vdout1_14ck950 FIND v(dout1_14) AT=960.05n

.meas tran vdout1_15ck950 FIND v(dout1_15) AT=960.05n

.meas tran vdout1_16ck950 FIND v(dout1_16) AT=960.05n

.meas tran vdout1_17ck950 FIND v(dout1_17) AT=960.05n

.meas tran vdout1_18ck950 FIND v(dout1_18) AT=960.05n

.meas tran vdout1_19ck950 FIND v(dout1_19) AT=960.05n

.meas tran vdout1_20ck950 FIND v(dout1_20) AT=960.05n

.meas tran vdout1_21ck950 FIND v(dout1_21) AT=960.05n

.meas tran vdout1_22ck950 FIND v(dout1_22) AT=960.05n

.meas tran vdout1_23ck950 FIND v(dout1_23) AT=960.05n

.meas tran vdout1_24ck950 FIND v(dout1_24) AT=960.05n

.meas tran vdout1_25ck950 FIND v(dout1_25) AT=960.05n

.meas tran vdout1_26ck950 FIND v(dout1_26) AT=960.05n

.meas tran vdout1_27ck950 FIND v(dout1_27) AT=960.05n

.meas tran vdout1_28ck950 FIND v(dout1_28) AT=960.05n

.meas tran vdout1_29ck950 FIND v(dout1_29) AT=960.05n

.meas tran vdout1_30ck950 FIND v(dout1_30) AT=960.05n

.meas tran vdout1_31ck950 FIND v(dout1_31) AT=960.05n

.meas tran vdout1_32ck950 FIND v(dout1_32) AT=960.05n

.meas tran vdout1_33ck950 FIND v(dout1_33) AT=960.05n

.meas tran vdout1_34ck950 FIND v(dout1_34) AT=960.05n

.meas tran vdout1_35ck950 FIND v(dout1_35) AT=960.05n

.meas tran vdout1_36ck950 FIND v(dout1_36) AT=960.05n

.meas tran vdout1_37ck950 FIND v(dout1_37) AT=960.05n

.meas tran vdout1_38ck950 FIND v(dout1_38) AT=960.05n

.meas tran vdout1_39ck950 FIND v(dout1_39) AT=960.05n

.meas tran vdout1_40ck950 FIND v(dout1_40) AT=960.05n

.meas tran vdout1_41ck950 FIND v(dout1_41) AT=960.05n

.meas tran vdout1_42ck950 FIND v(dout1_42) AT=960.05n

.meas tran vdout1_43ck950 FIND v(dout1_43) AT=960.05n

.meas tran vdout1_44ck950 FIND v(dout1_44) AT=960.05n

.meas tran vdout1_45ck950 FIND v(dout1_45) AT=960.05n

.meas tran vdout1_46ck950 FIND v(dout1_46) AT=960.05n

.meas tran vdout1_47ck950 FIND v(dout1_47) AT=960.05n

.meas tran vdout1_48ck950 FIND v(dout1_48) AT=960.05n

.meas tran vdout1_49ck950 FIND v(dout1_49) AT=960.05n

.meas tran vdout1_50ck950 FIND v(dout1_50) AT=960.05n

.meas tran vdout1_51ck950 FIND v(dout1_51) AT=960.05n

.meas tran vdout1_52ck950 FIND v(dout1_52) AT=960.05n

.meas tran vdout1_53ck950 FIND v(dout1_53) AT=960.05n

.meas tran vdout1_54ck950 FIND v(dout1_54) AT=960.05n

.meas tran vdout1_55ck950 FIND v(dout1_55) AT=960.05n

.meas tran vdout1_56ck950 FIND v(dout1_56) AT=960.05n

.meas tran vdout1_57ck950 FIND v(dout1_57) AT=960.05n

.meas tran vdout1_58ck950 FIND v(dout1_58) AT=960.05n

.meas tran vdout1_59ck950 FIND v(dout1_59) AT=960.05n

.meas tran vdout1_60ck950 FIND v(dout1_60) AT=960.05n

.meas tran vdout1_61ck950 FIND v(dout1_61) AT=960.05n

.meas tran vdout1_62ck950 FIND v(dout1_62) AT=960.05n

.meas tran vdout1_63ck950 FIND v(dout1_63) AT=960.05n

.meas tran vdout1_64ck950 FIND v(dout1_64) AT=960.05n

.meas tran vdout1_65ck950 FIND v(dout1_65) AT=960.05n

.meas tran vdout1_66ck950 FIND v(dout1_66) AT=960.05n

.meas tran vdout1_67ck950 FIND v(dout1_67) AT=960.05n

.meas tran vdout1_68ck950 FIND v(dout1_68) AT=960.05n

.meas tran vdout1_69ck950 FIND v(dout1_69) AT=960.05n

.meas tran vdout1_70ck950 FIND v(dout1_70) AT=960.05n

.meas tran vdout1_71ck950 FIND v(dout1_71) AT=960.05n

.meas tran vdout1_72ck950 FIND v(dout1_72) AT=960.05n

.meas tran vdout1_73ck950 FIND v(dout1_73) AT=960.05n

.meas tran vdout1_74ck950 FIND v(dout1_74) AT=960.05n

.meas tran vdout1_75ck950 FIND v(dout1_75) AT=960.05n

.meas tran vdout1_76ck950 FIND v(dout1_76) AT=960.05n

.meas tran vdout1_77ck950 FIND v(dout1_77) AT=960.05n

.meas tran vdout1_78ck950 FIND v(dout1_78) AT=960.05n

.meas tran vdout1_79ck950 FIND v(dout1_79) AT=960.05n

.meas tran vdout1_80ck950 FIND v(dout1_80) AT=960.05n

.meas tran vdout1_81ck950 FIND v(dout1_81) AT=960.05n

.meas tran vdout1_82ck950 FIND v(dout1_82) AT=960.05n

.meas tran vdout1_83ck950 FIND v(dout1_83) AT=960.05n

.meas tran vdout1_84ck950 FIND v(dout1_84) AT=960.05n

.meas tran vdout1_85ck950 FIND v(dout1_85) AT=960.05n

.meas tran vdout1_86ck950 FIND v(dout1_86) AT=960.05n

.meas tran vdout1_87ck950 FIND v(dout1_87) AT=960.05n

.meas tran vdout1_88ck950 FIND v(dout1_88) AT=960.05n

.meas tran vdout1_89ck950 FIND v(dout1_89) AT=960.05n

.meas tran vdout1_90ck950 FIND v(dout1_90) AT=960.05n

.meas tran vdout1_91ck950 FIND v(dout1_91) AT=960.05n

.meas tran vdout1_92ck950 FIND v(dout1_92) AT=960.05n

.meas tran vdout1_93ck950 FIND v(dout1_93) AT=960.05n

.meas tran vdout1_94ck950 FIND v(dout1_94) AT=960.05n

.meas tran vdout1_95ck950 FIND v(dout1_95) AT=960.05n

.meas tran vdout1_96ck950 FIND v(dout1_96) AT=960.05n

.meas tran vdout1_97ck950 FIND v(dout1_97) AT=960.05n

.meas tran vdout1_98ck950 FIND v(dout1_98) AT=960.05n

.meas tran vdout1_99ck950 FIND v(dout1_99) AT=960.05n

.meas tran vdout1_100ck950 FIND v(dout1_100) AT=960.05n

.meas tran vdout1_101ck950 FIND v(dout1_101) AT=960.05n

.meas tran vdout1_102ck950 FIND v(dout1_102) AT=960.05n

.meas tran vdout1_103ck950 FIND v(dout1_103) AT=960.05n

.meas tran vdout1_104ck950 FIND v(dout1_104) AT=960.05n

.meas tran vdout1_105ck950 FIND v(dout1_105) AT=960.05n

.meas tran vdout1_106ck950 FIND v(dout1_106) AT=960.05n

.meas tran vdout1_107ck950 FIND v(dout1_107) AT=960.05n

.meas tran vdout1_108ck950 FIND v(dout1_108) AT=960.05n

.meas tran vdout1_109ck950 FIND v(dout1_109) AT=960.05n

.meas tran vdout1_110ck950 FIND v(dout1_110) AT=960.05n

.meas tran vdout1_111ck950 FIND v(dout1_111) AT=960.05n

.meas tran vdout1_112ck950 FIND v(dout1_112) AT=960.05n

.meas tran vdout1_113ck950 FIND v(dout1_113) AT=960.05n

.meas tran vdout1_114ck950 FIND v(dout1_114) AT=960.05n

.meas tran vdout1_115ck950 FIND v(dout1_115) AT=960.05n

.meas tran vdout1_116ck950 FIND v(dout1_116) AT=960.05n

.meas tran vdout1_117ck950 FIND v(dout1_117) AT=960.05n

.meas tran vdout1_118ck950 FIND v(dout1_118) AT=960.05n

.meas tran vdout1_119ck950 FIND v(dout1_119) AT=960.05n

.meas tran vdout1_120ck950 FIND v(dout1_120) AT=960.05n

.meas tran vdout1_121ck950 FIND v(dout1_121) AT=960.05n

.meas tran vdout1_122ck950 FIND v(dout1_122) AT=960.05n

.meas tran vdout1_123ck950 FIND v(dout1_123) AT=960.05n

.meas tran vdout1_124ck950 FIND v(dout1_124) AT=960.05n

.meas tran vdout1_125ck950 FIND v(dout1_125) AT=960.05n

.meas tran vdout1_126ck950 FIND v(dout1_126) AT=960.05n

.meas tran vdout1_127ck950 FIND v(dout1_127) AT=960.05n

.meas tran vdout1_128ck950 FIND v(dout1_128) AT=960.05n

.meas tran vdout1_129ck950 FIND v(dout1_129) AT=960.05n

.meas tran vdout1_130ck950 FIND v(dout1_130) AT=960.05n

.meas tran vdout1_131ck950 FIND v(dout1_131) AT=960.05n

.meas tran vdout1_132ck950 FIND v(dout1_132) AT=960.05n

.meas tran vdout1_133ck950 FIND v(dout1_133) AT=960.05n

.meas tran vdout1_134ck950 FIND v(dout1_134) AT=960.05n

.meas tran vdout1_0ck960 FIND v(dout1_0) AT=970.05n

.meas tran vdout1_1ck960 FIND v(dout1_1) AT=970.05n

.meas tran vdout1_2ck960 FIND v(dout1_2) AT=970.05n

.meas tran vdout1_3ck960 FIND v(dout1_3) AT=970.05n

.meas tran vdout1_4ck960 FIND v(dout1_4) AT=970.05n

.meas tran vdout1_5ck960 FIND v(dout1_5) AT=970.05n

.meas tran vdout1_6ck960 FIND v(dout1_6) AT=970.05n

.meas tran vdout1_7ck960 FIND v(dout1_7) AT=970.05n

.meas tran vdout1_8ck960 FIND v(dout1_8) AT=970.05n

.meas tran vdout1_9ck960 FIND v(dout1_9) AT=970.05n

.meas tran vdout1_10ck960 FIND v(dout1_10) AT=970.05n

.meas tran vdout1_11ck960 FIND v(dout1_11) AT=970.05n

.meas tran vdout1_12ck960 FIND v(dout1_12) AT=970.05n

.meas tran vdout1_13ck960 FIND v(dout1_13) AT=970.05n

.meas tran vdout1_14ck960 FIND v(dout1_14) AT=970.05n

.meas tran vdout1_15ck960 FIND v(dout1_15) AT=970.05n

.meas tran vdout1_16ck960 FIND v(dout1_16) AT=970.05n

.meas tran vdout1_17ck960 FIND v(dout1_17) AT=970.05n

.meas tran vdout1_18ck960 FIND v(dout1_18) AT=970.05n

.meas tran vdout1_19ck960 FIND v(dout1_19) AT=970.05n

.meas tran vdout1_20ck960 FIND v(dout1_20) AT=970.05n

.meas tran vdout1_21ck960 FIND v(dout1_21) AT=970.05n

.meas tran vdout1_22ck960 FIND v(dout1_22) AT=970.05n

.meas tran vdout1_23ck960 FIND v(dout1_23) AT=970.05n

.meas tran vdout1_24ck960 FIND v(dout1_24) AT=970.05n

.meas tran vdout1_25ck960 FIND v(dout1_25) AT=970.05n

.meas tran vdout1_26ck960 FIND v(dout1_26) AT=970.05n

.meas tran vdout1_27ck960 FIND v(dout1_27) AT=970.05n

.meas tran vdout1_28ck960 FIND v(dout1_28) AT=970.05n

.meas tran vdout1_29ck960 FIND v(dout1_29) AT=970.05n

.meas tran vdout1_30ck960 FIND v(dout1_30) AT=970.05n

.meas tran vdout1_31ck960 FIND v(dout1_31) AT=970.05n

.meas tran vdout1_32ck960 FIND v(dout1_32) AT=970.05n

.meas tran vdout1_33ck960 FIND v(dout1_33) AT=970.05n

.meas tran vdout1_34ck960 FIND v(dout1_34) AT=970.05n

.meas tran vdout1_35ck960 FIND v(dout1_35) AT=970.05n

.meas tran vdout1_36ck960 FIND v(dout1_36) AT=970.05n

.meas tran vdout1_37ck960 FIND v(dout1_37) AT=970.05n

.meas tran vdout1_38ck960 FIND v(dout1_38) AT=970.05n

.meas tran vdout1_39ck960 FIND v(dout1_39) AT=970.05n

.meas tran vdout1_40ck960 FIND v(dout1_40) AT=970.05n

.meas tran vdout1_41ck960 FIND v(dout1_41) AT=970.05n

.meas tran vdout1_42ck960 FIND v(dout1_42) AT=970.05n

.meas tran vdout1_43ck960 FIND v(dout1_43) AT=970.05n

.meas tran vdout1_44ck960 FIND v(dout1_44) AT=970.05n

.meas tran vdout1_45ck960 FIND v(dout1_45) AT=970.05n

.meas tran vdout1_46ck960 FIND v(dout1_46) AT=970.05n

.meas tran vdout1_47ck960 FIND v(dout1_47) AT=970.05n

.meas tran vdout1_48ck960 FIND v(dout1_48) AT=970.05n

.meas tran vdout1_49ck960 FIND v(dout1_49) AT=970.05n

.meas tran vdout1_50ck960 FIND v(dout1_50) AT=970.05n

.meas tran vdout1_51ck960 FIND v(dout1_51) AT=970.05n

.meas tran vdout1_52ck960 FIND v(dout1_52) AT=970.05n

.meas tran vdout1_53ck960 FIND v(dout1_53) AT=970.05n

.meas tran vdout1_54ck960 FIND v(dout1_54) AT=970.05n

.meas tran vdout1_55ck960 FIND v(dout1_55) AT=970.05n

.meas tran vdout1_56ck960 FIND v(dout1_56) AT=970.05n

.meas tran vdout1_57ck960 FIND v(dout1_57) AT=970.05n

.meas tran vdout1_58ck960 FIND v(dout1_58) AT=970.05n

.meas tran vdout1_59ck960 FIND v(dout1_59) AT=970.05n

.meas tran vdout1_60ck960 FIND v(dout1_60) AT=970.05n

.meas tran vdout1_61ck960 FIND v(dout1_61) AT=970.05n

.meas tran vdout1_62ck960 FIND v(dout1_62) AT=970.05n

.meas tran vdout1_63ck960 FIND v(dout1_63) AT=970.05n

.meas tran vdout1_64ck960 FIND v(dout1_64) AT=970.05n

.meas tran vdout1_65ck960 FIND v(dout1_65) AT=970.05n

.meas tran vdout1_66ck960 FIND v(dout1_66) AT=970.05n

.meas tran vdout1_67ck960 FIND v(dout1_67) AT=970.05n

.meas tran vdout1_68ck960 FIND v(dout1_68) AT=970.05n

.meas tran vdout1_69ck960 FIND v(dout1_69) AT=970.05n

.meas tran vdout1_70ck960 FIND v(dout1_70) AT=970.05n

.meas tran vdout1_71ck960 FIND v(dout1_71) AT=970.05n

.meas tran vdout1_72ck960 FIND v(dout1_72) AT=970.05n

.meas tran vdout1_73ck960 FIND v(dout1_73) AT=970.05n

.meas tran vdout1_74ck960 FIND v(dout1_74) AT=970.05n

.meas tran vdout1_75ck960 FIND v(dout1_75) AT=970.05n

.meas tran vdout1_76ck960 FIND v(dout1_76) AT=970.05n

.meas tran vdout1_77ck960 FIND v(dout1_77) AT=970.05n

.meas tran vdout1_78ck960 FIND v(dout1_78) AT=970.05n

.meas tran vdout1_79ck960 FIND v(dout1_79) AT=970.05n

.meas tran vdout1_80ck960 FIND v(dout1_80) AT=970.05n

.meas tran vdout1_81ck960 FIND v(dout1_81) AT=970.05n

.meas tran vdout1_82ck960 FIND v(dout1_82) AT=970.05n

.meas tran vdout1_83ck960 FIND v(dout1_83) AT=970.05n

.meas tran vdout1_84ck960 FIND v(dout1_84) AT=970.05n

.meas tran vdout1_85ck960 FIND v(dout1_85) AT=970.05n

.meas tran vdout1_86ck960 FIND v(dout1_86) AT=970.05n

.meas tran vdout1_87ck960 FIND v(dout1_87) AT=970.05n

.meas tran vdout1_88ck960 FIND v(dout1_88) AT=970.05n

.meas tran vdout1_89ck960 FIND v(dout1_89) AT=970.05n

.meas tran vdout1_90ck960 FIND v(dout1_90) AT=970.05n

.meas tran vdout1_91ck960 FIND v(dout1_91) AT=970.05n

.meas tran vdout1_92ck960 FIND v(dout1_92) AT=970.05n

.meas tran vdout1_93ck960 FIND v(dout1_93) AT=970.05n

.meas tran vdout1_94ck960 FIND v(dout1_94) AT=970.05n

.meas tran vdout1_95ck960 FIND v(dout1_95) AT=970.05n

.meas tran vdout1_96ck960 FIND v(dout1_96) AT=970.05n

.meas tran vdout1_97ck960 FIND v(dout1_97) AT=970.05n

.meas tran vdout1_98ck960 FIND v(dout1_98) AT=970.05n

.meas tran vdout1_99ck960 FIND v(dout1_99) AT=970.05n

.meas tran vdout1_100ck960 FIND v(dout1_100) AT=970.05n

.meas tran vdout1_101ck960 FIND v(dout1_101) AT=970.05n

.meas tran vdout1_102ck960 FIND v(dout1_102) AT=970.05n

.meas tran vdout1_103ck960 FIND v(dout1_103) AT=970.05n

.meas tran vdout1_104ck960 FIND v(dout1_104) AT=970.05n

.meas tran vdout1_105ck960 FIND v(dout1_105) AT=970.05n

.meas tran vdout1_106ck960 FIND v(dout1_106) AT=970.05n

.meas tran vdout1_107ck960 FIND v(dout1_107) AT=970.05n

.meas tran vdout1_108ck960 FIND v(dout1_108) AT=970.05n

.meas tran vdout1_109ck960 FIND v(dout1_109) AT=970.05n

.meas tran vdout1_110ck960 FIND v(dout1_110) AT=970.05n

.meas tran vdout1_111ck960 FIND v(dout1_111) AT=970.05n

.meas tran vdout1_112ck960 FIND v(dout1_112) AT=970.05n

.meas tran vdout1_113ck960 FIND v(dout1_113) AT=970.05n

.meas tran vdout1_114ck960 FIND v(dout1_114) AT=970.05n

.meas tran vdout1_115ck960 FIND v(dout1_115) AT=970.05n

.meas tran vdout1_116ck960 FIND v(dout1_116) AT=970.05n

.meas tran vdout1_117ck960 FIND v(dout1_117) AT=970.05n

.meas tran vdout1_118ck960 FIND v(dout1_118) AT=970.05n

.meas tran vdout1_119ck960 FIND v(dout1_119) AT=970.05n

.meas tran vdout1_120ck960 FIND v(dout1_120) AT=970.05n

.meas tran vdout1_121ck960 FIND v(dout1_121) AT=970.05n

.meas tran vdout1_122ck960 FIND v(dout1_122) AT=970.05n

.meas tran vdout1_123ck960 FIND v(dout1_123) AT=970.05n

.meas tran vdout1_124ck960 FIND v(dout1_124) AT=970.05n

.meas tran vdout1_125ck960 FIND v(dout1_125) AT=970.05n

.meas tran vdout1_126ck960 FIND v(dout1_126) AT=970.05n

.meas tran vdout1_127ck960 FIND v(dout1_127) AT=970.05n

.meas tran vdout1_128ck960 FIND v(dout1_128) AT=970.05n

.meas tran vdout1_129ck960 FIND v(dout1_129) AT=970.05n

.meas tran vdout1_130ck960 FIND v(dout1_130) AT=970.05n

.meas tran vdout1_131ck960 FIND v(dout1_131) AT=970.05n

.meas tran vdout1_132ck960 FIND v(dout1_132) AT=970.05n

.meas tran vdout1_133ck960 FIND v(dout1_133) AT=970.05n

.meas tran vdout1_134ck960 FIND v(dout1_134) AT=970.05n

.meas tran vdout1_0ck1000 FIND v(dout1_0) AT=1010.05n

.meas tran vdout1_1ck1000 FIND v(dout1_1) AT=1010.05n

.meas tran vdout1_2ck1000 FIND v(dout1_2) AT=1010.05n

.meas tran vdout1_3ck1000 FIND v(dout1_3) AT=1010.05n

.meas tran vdout1_4ck1000 FIND v(dout1_4) AT=1010.05n

.meas tran vdout1_5ck1000 FIND v(dout1_5) AT=1010.05n

.meas tran vdout1_6ck1000 FIND v(dout1_6) AT=1010.05n

.meas tran vdout1_7ck1000 FIND v(dout1_7) AT=1010.05n

.meas tran vdout1_8ck1000 FIND v(dout1_8) AT=1010.05n

.meas tran vdout1_9ck1000 FIND v(dout1_9) AT=1010.05n

.meas tran vdout1_10ck1000 FIND v(dout1_10) AT=1010.05n

.meas tran vdout1_11ck1000 FIND v(dout1_11) AT=1010.05n

.meas tran vdout1_12ck1000 FIND v(dout1_12) AT=1010.05n

.meas tran vdout1_13ck1000 FIND v(dout1_13) AT=1010.05n

.meas tran vdout1_14ck1000 FIND v(dout1_14) AT=1010.05n

.meas tran vdout1_15ck1000 FIND v(dout1_15) AT=1010.05n

.meas tran vdout1_16ck1000 FIND v(dout1_16) AT=1010.05n

.meas tran vdout1_17ck1000 FIND v(dout1_17) AT=1010.05n

.meas tran vdout1_18ck1000 FIND v(dout1_18) AT=1010.05n

.meas tran vdout1_19ck1000 FIND v(dout1_19) AT=1010.05n

.meas tran vdout1_20ck1000 FIND v(dout1_20) AT=1010.05n

.meas tran vdout1_21ck1000 FIND v(dout1_21) AT=1010.05n

.meas tran vdout1_22ck1000 FIND v(dout1_22) AT=1010.05n

.meas tran vdout1_23ck1000 FIND v(dout1_23) AT=1010.05n

.meas tran vdout1_24ck1000 FIND v(dout1_24) AT=1010.05n

.meas tran vdout1_25ck1000 FIND v(dout1_25) AT=1010.05n

.meas tran vdout1_26ck1000 FIND v(dout1_26) AT=1010.05n

.meas tran vdout1_27ck1000 FIND v(dout1_27) AT=1010.05n

.meas tran vdout1_28ck1000 FIND v(dout1_28) AT=1010.05n

.meas tran vdout1_29ck1000 FIND v(dout1_29) AT=1010.05n

.meas tran vdout1_30ck1000 FIND v(dout1_30) AT=1010.05n

.meas tran vdout1_31ck1000 FIND v(dout1_31) AT=1010.05n

.meas tran vdout1_32ck1000 FIND v(dout1_32) AT=1010.05n

.meas tran vdout1_33ck1000 FIND v(dout1_33) AT=1010.05n

.meas tran vdout1_34ck1000 FIND v(dout1_34) AT=1010.05n

.meas tran vdout1_35ck1000 FIND v(dout1_35) AT=1010.05n

.meas tran vdout1_36ck1000 FIND v(dout1_36) AT=1010.05n

.meas tran vdout1_37ck1000 FIND v(dout1_37) AT=1010.05n

.meas tran vdout1_38ck1000 FIND v(dout1_38) AT=1010.05n

.meas tran vdout1_39ck1000 FIND v(dout1_39) AT=1010.05n

.meas tran vdout1_40ck1000 FIND v(dout1_40) AT=1010.05n

.meas tran vdout1_41ck1000 FIND v(dout1_41) AT=1010.05n

.meas tran vdout1_42ck1000 FIND v(dout1_42) AT=1010.05n

.meas tran vdout1_43ck1000 FIND v(dout1_43) AT=1010.05n

.meas tran vdout1_44ck1000 FIND v(dout1_44) AT=1010.05n

.meas tran vdout1_45ck1000 FIND v(dout1_45) AT=1010.05n

.meas tran vdout1_46ck1000 FIND v(dout1_46) AT=1010.05n

.meas tran vdout1_47ck1000 FIND v(dout1_47) AT=1010.05n

.meas tran vdout1_48ck1000 FIND v(dout1_48) AT=1010.05n

.meas tran vdout1_49ck1000 FIND v(dout1_49) AT=1010.05n

.meas tran vdout1_50ck1000 FIND v(dout1_50) AT=1010.05n

.meas tran vdout1_51ck1000 FIND v(dout1_51) AT=1010.05n

.meas tran vdout1_52ck1000 FIND v(dout1_52) AT=1010.05n

.meas tran vdout1_53ck1000 FIND v(dout1_53) AT=1010.05n

.meas tran vdout1_54ck1000 FIND v(dout1_54) AT=1010.05n

.meas tran vdout1_55ck1000 FIND v(dout1_55) AT=1010.05n

.meas tran vdout1_56ck1000 FIND v(dout1_56) AT=1010.05n

.meas tran vdout1_57ck1000 FIND v(dout1_57) AT=1010.05n

.meas tran vdout1_58ck1000 FIND v(dout1_58) AT=1010.05n

.meas tran vdout1_59ck1000 FIND v(dout1_59) AT=1010.05n

.meas tran vdout1_60ck1000 FIND v(dout1_60) AT=1010.05n

.meas tran vdout1_61ck1000 FIND v(dout1_61) AT=1010.05n

.meas tran vdout1_62ck1000 FIND v(dout1_62) AT=1010.05n

.meas tran vdout1_63ck1000 FIND v(dout1_63) AT=1010.05n

.meas tran vdout1_64ck1000 FIND v(dout1_64) AT=1010.05n

.meas tran vdout1_65ck1000 FIND v(dout1_65) AT=1010.05n

.meas tran vdout1_66ck1000 FIND v(dout1_66) AT=1010.05n

.meas tran vdout1_67ck1000 FIND v(dout1_67) AT=1010.05n

.meas tran vdout1_68ck1000 FIND v(dout1_68) AT=1010.05n

.meas tran vdout1_69ck1000 FIND v(dout1_69) AT=1010.05n

.meas tran vdout1_70ck1000 FIND v(dout1_70) AT=1010.05n

.meas tran vdout1_71ck1000 FIND v(dout1_71) AT=1010.05n

.meas tran vdout1_72ck1000 FIND v(dout1_72) AT=1010.05n

.meas tran vdout1_73ck1000 FIND v(dout1_73) AT=1010.05n

.meas tran vdout1_74ck1000 FIND v(dout1_74) AT=1010.05n

.meas tran vdout1_75ck1000 FIND v(dout1_75) AT=1010.05n

.meas tran vdout1_76ck1000 FIND v(dout1_76) AT=1010.05n

.meas tran vdout1_77ck1000 FIND v(dout1_77) AT=1010.05n

.meas tran vdout1_78ck1000 FIND v(dout1_78) AT=1010.05n

.meas tran vdout1_79ck1000 FIND v(dout1_79) AT=1010.05n

.meas tran vdout1_80ck1000 FIND v(dout1_80) AT=1010.05n

.meas tran vdout1_81ck1000 FIND v(dout1_81) AT=1010.05n

.meas tran vdout1_82ck1000 FIND v(dout1_82) AT=1010.05n

.meas tran vdout1_83ck1000 FIND v(dout1_83) AT=1010.05n

.meas tran vdout1_84ck1000 FIND v(dout1_84) AT=1010.05n

.meas tran vdout1_85ck1000 FIND v(dout1_85) AT=1010.05n

.meas tran vdout1_86ck1000 FIND v(dout1_86) AT=1010.05n

.meas tran vdout1_87ck1000 FIND v(dout1_87) AT=1010.05n

.meas tran vdout1_88ck1000 FIND v(dout1_88) AT=1010.05n

.meas tran vdout1_89ck1000 FIND v(dout1_89) AT=1010.05n

.meas tran vdout1_90ck1000 FIND v(dout1_90) AT=1010.05n

.meas tran vdout1_91ck1000 FIND v(dout1_91) AT=1010.05n

.meas tran vdout1_92ck1000 FIND v(dout1_92) AT=1010.05n

.meas tran vdout1_93ck1000 FIND v(dout1_93) AT=1010.05n

.meas tran vdout1_94ck1000 FIND v(dout1_94) AT=1010.05n

.meas tran vdout1_95ck1000 FIND v(dout1_95) AT=1010.05n

.meas tran vdout1_96ck1000 FIND v(dout1_96) AT=1010.05n

.meas tran vdout1_97ck1000 FIND v(dout1_97) AT=1010.05n

.meas tran vdout1_98ck1000 FIND v(dout1_98) AT=1010.05n

.meas tran vdout1_99ck1000 FIND v(dout1_99) AT=1010.05n

.meas tran vdout1_100ck1000 FIND v(dout1_100) AT=1010.05n

.meas tran vdout1_101ck1000 FIND v(dout1_101) AT=1010.05n

.meas tran vdout1_102ck1000 FIND v(dout1_102) AT=1010.05n

.meas tran vdout1_103ck1000 FIND v(dout1_103) AT=1010.05n

.meas tran vdout1_104ck1000 FIND v(dout1_104) AT=1010.05n

.meas tran vdout1_105ck1000 FIND v(dout1_105) AT=1010.05n

.meas tran vdout1_106ck1000 FIND v(dout1_106) AT=1010.05n

.meas tran vdout1_107ck1000 FIND v(dout1_107) AT=1010.05n

.meas tran vdout1_108ck1000 FIND v(dout1_108) AT=1010.05n

.meas tran vdout1_109ck1000 FIND v(dout1_109) AT=1010.05n

.meas tran vdout1_110ck1000 FIND v(dout1_110) AT=1010.05n

.meas tran vdout1_111ck1000 FIND v(dout1_111) AT=1010.05n

.meas tran vdout1_112ck1000 FIND v(dout1_112) AT=1010.05n

.meas tran vdout1_113ck1000 FIND v(dout1_113) AT=1010.05n

.meas tran vdout1_114ck1000 FIND v(dout1_114) AT=1010.05n

.meas tran vdout1_115ck1000 FIND v(dout1_115) AT=1010.05n

.meas tran vdout1_116ck1000 FIND v(dout1_116) AT=1010.05n

.meas tran vdout1_117ck1000 FIND v(dout1_117) AT=1010.05n

.meas tran vdout1_118ck1000 FIND v(dout1_118) AT=1010.05n

.meas tran vdout1_119ck1000 FIND v(dout1_119) AT=1010.05n

.meas tran vdout1_120ck1000 FIND v(dout1_120) AT=1010.05n

.meas tran vdout1_121ck1000 FIND v(dout1_121) AT=1010.05n

.meas tran vdout1_122ck1000 FIND v(dout1_122) AT=1010.05n

.meas tran vdout1_123ck1000 FIND v(dout1_123) AT=1010.05n

.meas tran vdout1_124ck1000 FIND v(dout1_124) AT=1010.05n

.meas tran vdout1_125ck1000 FIND v(dout1_125) AT=1010.05n

.meas tran vdout1_126ck1000 FIND v(dout1_126) AT=1010.05n

.meas tran vdout1_127ck1000 FIND v(dout1_127) AT=1010.05n

.meas tran vdout1_128ck1000 FIND v(dout1_128) AT=1010.05n

.meas tran vdout1_129ck1000 FIND v(dout1_129) AT=1010.05n

.meas tran vdout1_130ck1000 FIND v(dout1_130) AT=1010.05n

.meas tran vdout1_131ck1000 FIND v(dout1_131) AT=1010.05n

.meas tran vdout1_132ck1000 FIND v(dout1_132) AT=1010.05n

.meas tran vdout1_133ck1000 FIND v(dout1_133) AT=1010.05n

.meas tran vdout1_134ck1000 FIND v(dout1_134) AT=1010.05n

.meas tran vdout1_0ck1010 FIND v(dout1_0) AT=1020.05n

.meas tran vdout1_1ck1010 FIND v(dout1_1) AT=1020.05n

.meas tran vdout1_2ck1010 FIND v(dout1_2) AT=1020.05n

.meas tran vdout1_3ck1010 FIND v(dout1_3) AT=1020.05n

.meas tran vdout1_4ck1010 FIND v(dout1_4) AT=1020.05n

.meas tran vdout1_5ck1010 FIND v(dout1_5) AT=1020.05n

.meas tran vdout1_6ck1010 FIND v(dout1_6) AT=1020.05n

.meas tran vdout1_7ck1010 FIND v(dout1_7) AT=1020.05n

.meas tran vdout1_8ck1010 FIND v(dout1_8) AT=1020.05n

.meas tran vdout1_9ck1010 FIND v(dout1_9) AT=1020.05n

.meas tran vdout1_10ck1010 FIND v(dout1_10) AT=1020.05n

.meas tran vdout1_11ck1010 FIND v(dout1_11) AT=1020.05n

.meas tran vdout1_12ck1010 FIND v(dout1_12) AT=1020.05n

.meas tran vdout1_13ck1010 FIND v(dout1_13) AT=1020.05n

.meas tran vdout1_14ck1010 FIND v(dout1_14) AT=1020.05n

.meas tran vdout1_15ck1010 FIND v(dout1_15) AT=1020.05n

.meas tran vdout1_16ck1010 FIND v(dout1_16) AT=1020.05n

.meas tran vdout1_17ck1010 FIND v(dout1_17) AT=1020.05n

.meas tran vdout1_18ck1010 FIND v(dout1_18) AT=1020.05n

.meas tran vdout1_19ck1010 FIND v(dout1_19) AT=1020.05n

.meas tran vdout1_20ck1010 FIND v(dout1_20) AT=1020.05n

.meas tran vdout1_21ck1010 FIND v(dout1_21) AT=1020.05n

.meas tran vdout1_22ck1010 FIND v(dout1_22) AT=1020.05n

.meas tran vdout1_23ck1010 FIND v(dout1_23) AT=1020.05n

.meas tran vdout1_24ck1010 FIND v(dout1_24) AT=1020.05n

.meas tran vdout1_25ck1010 FIND v(dout1_25) AT=1020.05n

.meas tran vdout1_26ck1010 FIND v(dout1_26) AT=1020.05n

.meas tran vdout1_27ck1010 FIND v(dout1_27) AT=1020.05n

.meas tran vdout1_28ck1010 FIND v(dout1_28) AT=1020.05n

.meas tran vdout1_29ck1010 FIND v(dout1_29) AT=1020.05n

.meas tran vdout1_30ck1010 FIND v(dout1_30) AT=1020.05n

.meas tran vdout1_31ck1010 FIND v(dout1_31) AT=1020.05n

.meas tran vdout1_32ck1010 FIND v(dout1_32) AT=1020.05n

.meas tran vdout1_33ck1010 FIND v(dout1_33) AT=1020.05n

.meas tran vdout1_34ck1010 FIND v(dout1_34) AT=1020.05n

.meas tran vdout1_35ck1010 FIND v(dout1_35) AT=1020.05n

.meas tran vdout1_36ck1010 FIND v(dout1_36) AT=1020.05n

.meas tran vdout1_37ck1010 FIND v(dout1_37) AT=1020.05n

.meas tran vdout1_38ck1010 FIND v(dout1_38) AT=1020.05n

.meas tran vdout1_39ck1010 FIND v(dout1_39) AT=1020.05n

.meas tran vdout1_40ck1010 FIND v(dout1_40) AT=1020.05n

.meas tran vdout1_41ck1010 FIND v(dout1_41) AT=1020.05n

.meas tran vdout1_42ck1010 FIND v(dout1_42) AT=1020.05n

.meas tran vdout1_43ck1010 FIND v(dout1_43) AT=1020.05n

.meas tran vdout1_44ck1010 FIND v(dout1_44) AT=1020.05n

.meas tran vdout1_45ck1010 FIND v(dout1_45) AT=1020.05n

.meas tran vdout1_46ck1010 FIND v(dout1_46) AT=1020.05n

.meas tran vdout1_47ck1010 FIND v(dout1_47) AT=1020.05n

.meas tran vdout1_48ck1010 FIND v(dout1_48) AT=1020.05n

.meas tran vdout1_49ck1010 FIND v(dout1_49) AT=1020.05n

.meas tran vdout1_50ck1010 FIND v(dout1_50) AT=1020.05n

.meas tran vdout1_51ck1010 FIND v(dout1_51) AT=1020.05n

.meas tran vdout1_52ck1010 FIND v(dout1_52) AT=1020.05n

.meas tran vdout1_53ck1010 FIND v(dout1_53) AT=1020.05n

.meas tran vdout1_54ck1010 FIND v(dout1_54) AT=1020.05n

.meas tran vdout1_55ck1010 FIND v(dout1_55) AT=1020.05n

.meas tran vdout1_56ck1010 FIND v(dout1_56) AT=1020.05n

.meas tran vdout1_57ck1010 FIND v(dout1_57) AT=1020.05n

.meas tran vdout1_58ck1010 FIND v(dout1_58) AT=1020.05n

.meas tran vdout1_59ck1010 FIND v(dout1_59) AT=1020.05n

.meas tran vdout1_60ck1010 FIND v(dout1_60) AT=1020.05n

.meas tran vdout1_61ck1010 FIND v(dout1_61) AT=1020.05n

.meas tran vdout1_62ck1010 FIND v(dout1_62) AT=1020.05n

.meas tran vdout1_63ck1010 FIND v(dout1_63) AT=1020.05n

.meas tran vdout1_64ck1010 FIND v(dout1_64) AT=1020.05n

.meas tran vdout1_65ck1010 FIND v(dout1_65) AT=1020.05n

.meas tran vdout1_66ck1010 FIND v(dout1_66) AT=1020.05n

.meas tran vdout1_67ck1010 FIND v(dout1_67) AT=1020.05n

.meas tran vdout1_68ck1010 FIND v(dout1_68) AT=1020.05n

.meas tran vdout1_69ck1010 FIND v(dout1_69) AT=1020.05n

.meas tran vdout1_70ck1010 FIND v(dout1_70) AT=1020.05n

.meas tran vdout1_71ck1010 FIND v(dout1_71) AT=1020.05n

.meas tran vdout1_72ck1010 FIND v(dout1_72) AT=1020.05n

.meas tran vdout1_73ck1010 FIND v(dout1_73) AT=1020.05n

.meas tran vdout1_74ck1010 FIND v(dout1_74) AT=1020.05n

.meas tran vdout1_75ck1010 FIND v(dout1_75) AT=1020.05n

.meas tran vdout1_76ck1010 FIND v(dout1_76) AT=1020.05n

.meas tran vdout1_77ck1010 FIND v(dout1_77) AT=1020.05n

.meas tran vdout1_78ck1010 FIND v(dout1_78) AT=1020.05n

.meas tran vdout1_79ck1010 FIND v(dout1_79) AT=1020.05n

.meas tran vdout1_80ck1010 FIND v(dout1_80) AT=1020.05n

.meas tran vdout1_81ck1010 FIND v(dout1_81) AT=1020.05n

.meas tran vdout1_82ck1010 FIND v(dout1_82) AT=1020.05n

.meas tran vdout1_83ck1010 FIND v(dout1_83) AT=1020.05n

.meas tran vdout1_84ck1010 FIND v(dout1_84) AT=1020.05n

.meas tran vdout1_85ck1010 FIND v(dout1_85) AT=1020.05n

.meas tran vdout1_86ck1010 FIND v(dout1_86) AT=1020.05n

.meas tran vdout1_87ck1010 FIND v(dout1_87) AT=1020.05n

.meas tran vdout1_88ck1010 FIND v(dout1_88) AT=1020.05n

.meas tran vdout1_89ck1010 FIND v(dout1_89) AT=1020.05n

.meas tran vdout1_90ck1010 FIND v(dout1_90) AT=1020.05n

.meas tran vdout1_91ck1010 FIND v(dout1_91) AT=1020.05n

.meas tran vdout1_92ck1010 FIND v(dout1_92) AT=1020.05n

.meas tran vdout1_93ck1010 FIND v(dout1_93) AT=1020.05n

.meas tran vdout1_94ck1010 FIND v(dout1_94) AT=1020.05n

.meas tran vdout1_95ck1010 FIND v(dout1_95) AT=1020.05n

.meas tran vdout1_96ck1010 FIND v(dout1_96) AT=1020.05n

.meas tran vdout1_97ck1010 FIND v(dout1_97) AT=1020.05n

.meas tran vdout1_98ck1010 FIND v(dout1_98) AT=1020.05n

.meas tran vdout1_99ck1010 FIND v(dout1_99) AT=1020.05n

.meas tran vdout1_100ck1010 FIND v(dout1_100) AT=1020.05n

.meas tran vdout1_101ck1010 FIND v(dout1_101) AT=1020.05n

.meas tran vdout1_102ck1010 FIND v(dout1_102) AT=1020.05n

.meas tran vdout1_103ck1010 FIND v(dout1_103) AT=1020.05n

.meas tran vdout1_104ck1010 FIND v(dout1_104) AT=1020.05n

.meas tran vdout1_105ck1010 FIND v(dout1_105) AT=1020.05n

.meas tran vdout1_106ck1010 FIND v(dout1_106) AT=1020.05n

.meas tran vdout1_107ck1010 FIND v(dout1_107) AT=1020.05n

.meas tran vdout1_108ck1010 FIND v(dout1_108) AT=1020.05n

.meas tran vdout1_109ck1010 FIND v(dout1_109) AT=1020.05n

.meas tran vdout1_110ck1010 FIND v(dout1_110) AT=1020.05n

.meas tran vdout1_111ck1010 FIND v(dout1_111) AT=1020.05n

.meas tran vdout1_112ck1010 FIND v(dout1_112) AT=1020.05n

.meas tran vdout1_113ck1010 FIND v(dout1_113) AT=1020.05n

.meas tran vdout1_114ck1010 FIND v(dout1_114) AT=1020.05n

.meas tran vdout1_115ck1010 FIND v(dout1_115) AT=1020.05n

.meas tran vdout1_116ck1010 FIND v(dout1_116) AT=1020.05n

.meas tran vdout1_117ck1010 FIND v(dout1_117) AT=1020.05n

.meas tran vdout1_118ck1010 FIND v(dout1_118) AT=1020.05n

.meas tran vdout1_119ck1010 FIND v(dout1_119) AT=1020.05n

.meas tran vdout1_120ck1010 FIND v(dout1_120) AT=1020.05n

.meas tran vdout1_121ck1010 FIND v(dout1_121) AT=1020.05n

.meas tran vdout1_122ck1010 FIND v(dout1_122) AT=1020.05n

.meas tran vdout1_123ck1010 FIND v(dout1_123) AT=1020.05n

.meas tran vdout1_124ck1010 FIND v(dout1_124) AT=1020.05n

.meas tran vdout1_125ck1010 FIND v(dout1_125) AT=1020.05n

.meas tran vdout1_126ck1010 FIND v(dout1_126) AT=1020.05n

.meas tran vdout1_127ck1010 FIND v(dout1_127) AT=1020.05n

.meas tran vdout1_128ck1010 FIND v(dout1_128) AT=1020.05n

.meas tran vdout1_129ck1010 FIND v(dout1_129) AT=1020.05n

.meas tran vdout1_130ck1010 FIND v(dout1_130) AT=1020.05n

.meas tran vdout1_131ck1010 FIND v(dout1_131) AT=1020.05n

.meas tran vdout1_132ck1010 FIND v(dout1_132) AT=1020.05n

.meas tran vdout1_133ck1010 FIND v(dout1_133) AT=1020.05n

.meas tran vdout1_134ck1010 FIND v(dout1_134) AT=1020.05n

.meas tran vdout1_0ck1020 FIND v(dout1_0) AT=1030.05n

.meas tran vdout1_1ck1020 FIND v(dout1_1) AT=1030.05n

.meas tran vdout1_2ck1020 FIND v(dout1_2) AT=1030.05n

.meas tran vdout1_3ck1020 FIND v(dout1_3) AT=1030.05n

.meas tran vdout1_4ck1020 FIND v(dout1_4) AT=1030.05n

.meas tran vdout1_5ck1020 FIND v(dout1_5) AT=1030.05n

.meas tran vdout1_6ck1020 FIND v(dout1_6) AT=1030.05n

.meas tran vdout1_7ck1020 FIND v(dout1_7) AT=1030.05n

.meas tran vdout1_8ck1020 FIND v(dout1_8) AT=1030.05n

.meas tran vdout1_9ck1020 FIND v(dout1_9) AT=1030.05n

.meas tran vdout1_10ck1020 FIND v(dout1_10) AT=1030.05n

.meas tran vdout1_11ck1020 FIND v(dout1_11) AT=1030.05n

.meas tran vdout1_12ck1020 FIND v(dout1_12) AT=1030.05n

.meas tran vdout1_13ck1020 FIND v(dout1_13) AT=1030.05n

.meas tran vdout1_14ck1020 FIND v(dout1_14) AT=1030.05n

.meas tran vdout1_15ck1020 FIND v(dout1_15) AT=1030.05n

.meas tran vdout1_16ck1020 FIND v(dout1_16) AT=1030.05n

.meas tran vdout1_17ck1020 FIND v(dout1_17) AT=1030.05n

.meas tran vdout1_18ck1020 FIND v(dout1_18) AT=1030.05n

.meas tran vdout1_19ck1020 FIND v(dout1_19) AT=1030.05n

.meas tran vdout1_20ck1020 FIND v(dout1_20) AT=1030.05n

.meas tran vdout1_21ck1020 FIND v(dout1_21) AT=1030.05n

.meas tran vdout1_22ck1020 FIND v(dout1_22) AT=1030.05n

.meas tran vdout1_23ck1020 FIND v(dout1_23) AT=1030.05n

.meas tran vdout1_24ck1020 FIND v(dout1_24) AT=1030.05n

.meas tran vdout1_25ck1020 FIND v(dout1_25) AT=1030.05n

.meas tran vdout1_26ck1020 FIND v(dout1_26) AT=1030.05n

.meas tran vdout1_27ck1020 FIND v(dout1_27) AT=1030.05n

.meas tran vdout1_28ck1020 FIND v(dout1_28) AT=1030.05n

.meas tran vdout1_29ck1020 FIND v(dout1_29) AT=1030.05n

.meas tran vdout1_30ck1020 FIND v(dout1_30) AT=1030.05n

.meas tran vdout1_31ck1020 FIND v(dout1_31) AT=1030.05n

.meas tran vdout1_32ck1020 FIND v(dout1_32) AT=1030.05n

.meas tran vdout1_33ck1020 FIND v(dout1_33) AT=1030.05n

.meas tran vdout1_34ck1020 FIND v(dout1_34) AT=1030.05n

.meas tran vdout1_35ck1020 FIND v(dout1_35) AT=1030.05n

.meas tran vdout1_36ck1020 FIND v(dout1_36) AT=1030.05n

.meas tran vdout1_37ck1020 FIND v(dout1_37) AT=1030.05n

.meas tran vdout1_38ck1020 FIND v(dout1_38) AT=1030.05n

.meas tran vdout1_39ck1020 FIND v(dout1_39) AT=1030.05n

.meas tran vdout1_40ck1020 FIND v(dout1_40) AT=1030.05n

.meas tran vdout1_41ck1020 FIND v(dout1_41) AT=1030.05n

.meas tran vdout1_42ck1020 FIND v(dout1_42) AT=1030.05n

.meas tran vdout1_43ck1020 FIND v(dout1_43) AT=1030.05n

.meas tran vdout1_44ck1020 FIND v(dout1_44) AT=1030.05n

.meas tran vdout1_45ck1020 FIND v(dout1_45) AT=1030.05n

.meas tran vdout1_46ck1020 FIND v(dout1_46) AT=1030.05n

.meas tran vdout1_47ck1020 FIND v(dout1_47) AT=1030.05n

.meas tran vdout1_48ck1020 FIND v(dout1_48) AT=1030.05n

.meas tran vdout1_49ck1020 FIND v(dout1_49) AT=1030.05n

.meas tran vdout1_50ck1020 FIND v(dout1_50) AT=1030.05n

.meas tran vdout1_51ck1020 FIND v(dout1_51) AT=1030.05n

.meas tran vdout1_52ck1020 FIND v(dout1_52) AT=1030.05n

.meas tran vdout1_53ck1020 FIND v(dout1_53) AT=1030.05n

.meas tran vdout1_54ck1020 FIND v(dout1_54) AT=1030.05n

.meas tran vdout1_55ck1020 FIND v(dout1_55) AT=1030.05n

.meas tran vdout1_56ck1020 FIND v(dout1_56) AT=1030.05n

.meas tran vdout1_57ck1020 FIND v(dout1_57) AT=1030.05n

.meas tran vdout1_58ck1020 FIND v(dout1_58) AT=1030.05n

.meas tran vdout1_59ck1020 FIND v(dout1_59) AT=1030.05n

.meas tran vdout1_60ck1020 FIND v(dout1_60) AT=1030.05n

.meas tran vdout1_61ck1020 FIND v(dout1_61) AT=1030.05n

.meas tran vdout1_62ck1020 FIND v(dout1_62) AT=1030.05n

.meas tran vdout1_63ck1020 FIND v(dout1_63) AT=1030.05n

.meas tran vdout1_64ck1020 FIND v(dout1_64) AT=1030.05n

.meas tran vdout1_65ck1020 FIND v(dout1_65) AT=1030.05n

.meas tran vdout1_66ck1020 FIND v(dout1_66) AT=1030.05n

.meas tran vdout1_67ck1020 FIND v(dout1_67) AT=1030.05n

.meas tran vdout1_68ck1020 FIND v(dout1_68) AT=1030.05n

.meas tran vdout1_69ck1020 FIND v(dout1_69) AT=1030.05n

.meas tran vdout1_70ck1020 FIND v(dout1_70) AT=1030.05n

.meas tran vdout1_71ck1020 FIND v(dout1_71) AT=1030.05n

.meas tran vdout1_72ck1020 FIND v(dout1_72) AT=1030.05n

.meas tran vdout1_73ck1020 FIND v(dout1_73) AT=1030.05n

.meas tran vdout1_74ck1020 FIND v(dout1_74) AT=1030.05n

.meas tran vdout1_75ck1020 FIND v(dout1_75) AT=1030.05n

.meas tran vdout1_76ck1020 FIND v(dout1_76) AT=1030.05n

.meas tran vdout1_77ck1020 FIND v(dout1_77) AT=1030.05n

.meas tran vdout1_78ck1020 FIND v(dout1_78) AT=1030.05n

.meas tran vdout1_79ck1020 FIND v(dout1_79) AT=1030.05n

.meas tran vdout1_80ck1020 FIND v(dout1_80) AT=1030.05n

.meas tran vdout1_81ck1020 FIND v(dout1_81) AT=1030.05n

.meas tran vdout1_82ck1020 FIND v(dout1_82) AT=1030.05n

.meas tran vdout1_83ck1020 FIND v(dout1_83) AT=1030.05n

.meas tran vdout1_84ck1020 FIND v(dout1_84) AT=1030.05n

.meas tran vdout1_85ck1020 FIND v(dout1_85) AT=1030.05n

.meas tran vdout1_86ck1020 FIND v(dout1_86) AT=1030.05n

.meas tran vdout1_87ck1020 FIND v(dout1_87) AT=1030.05n

.meas tran vdout1_88ck1020 FIND v(dout1_88) AT=1030.05n

.meas tran vdout1_89ck1020 FIND v(dout1_89) AT=1030.05n

.meas tran vdout1_90ck1020 FIND v(dout1_90) AT=1030.05n

.meas tran vdout1_91ck1020 FIND v(dout1_91) AT=1030.05n

.meas tran vdout1_92ck1020 FIND v(dout1_92) AT=1030.05n

.meas tran vdout1_93ck1020 FIND v(dout1_93) AT=1030.05n

.meas tran vdout1_94ck1020 FIND v(dout1_94) AT=1030.05n

.meas tran vdout1_95ck1020 FIND v(dout1_95) AT=1030.05n

.meas tran vdout1_96ck1020 FIND v(dout1_96) AT=1030.05n

.meas tran vdout1_97ck1020 FIND v(dout1_97) AT=1030.05n

.meas tran vdout1_98ck1020 FIND v(dout1_98) AT=1030.05n

.meas tran vdout1_99ck1020 FIND v(dout1_99) AT=1030.05n

.meas tran vdout1_100ck1020 FIND v(dout1_100) AT=1030.05n

.meas tran vdout1_101ck1020 FIND v(dout1_101) AT=1030.05n

.meas tran vdout1_102ck1020 FIND v(dout1_102) AT=1030.05n

.meas tran vdout1_103ck1020 FIND v(dout1_103) AT=1030.05n

.meas tran vdout1_104ck1020 FIND v(dout1_104) AT=1030.05n

.meas tran vdout1_105ck1020 FIND v(dout1_105) AT=1030.05n

.meas tran vdout1_106ck1020 FIND v(dout1_106) AT=1030.05n

.meas tran vdout1_107ck1020 FIND v(dout1_107) AT=1030.05n

.meas tran vdout1_108ck1020 FIND v(dout1_108) AT=1030.05n

.meas tran vdout1_109ck1020 FIND v(dout1_109) AT=1030.05n

.meas tran vdout1_110ck1020 FIND v(dout1_110) AT=1030.05n

.meas tran vdout1_111ck1020 FIND v(dout1_111) AT=1030.05n

.meas tran vdout1_112ck1020 FIND v(dout1_112) AT=1030.05n

.meas tran vdout1_113ck1020 FIND v(dout1_113) AT=1030.05n

.meas tran vdout1_114ck1020 FIND v(dout1_114) AT=1030.05n

.meas tran vdout1_115ck1020 FIND v(dout1_115) AT=1030.05n

.meas tran vdout1_116ck1020 FIND v(dout1_116) AT=1030.05n

.meas tran vdout1_117ck1020 FIND v(dout1_117) AT=1030.05n

.meas tran vdout1_118ck1020 FIND v(dout1_118) AT=1030.05n

.meas tran vdout1_119ck1020 FIND v(dout1_119) AT=1030.05n

.meas tran vdout1_120ck1020 FIND v(dout1_120) AT=1030.05n

.meas tran vdout1_121ck1020 FIND v(dout1_121) AT=1030.05n

.meas tran vdout1_122ck1020 FIND v(dout1_122) AT=1030.05n

.meas tran vdout1_123ck1020 FIND v(dout1_123) AT=1030.05n

.meas tran vdout1_124ck1020 FIND v(dout1_124) AT=1030.05n

.meas tran vdout1_125ck1020 FIND v(dout1_125) AT=1030.05n

.meas tran vdout1_126ck1020 FIND v(dout1_126) AT=1030.05n

.meas tran vdout1_127ck1020 FIND v(dout1_127) AT=1030.05n

.meas tran vdout1_128ck1020 FIND v(dout1_128) AT=1030.05n

.meas tran vdout1_129ck1020 FIND v(dout1_129) AT=1030.05n

.meas tran vdout1_130ck1020 FIND v(dout1_130) AT=1030.05n

.meas tran vdout1_131ck1020 FIND v(dout1_131) AT=1030.05n

.meas tran vdout1_132ck1020 FIND v(dout1_132) AT=1030.05n

.meas tran vdout1_133ck1020 FIND v(dout1_133) AT=1030.05n

.meas tran vdout1_134ck1020 FIND v(dout1_134) AT=1030.05n

.meas tran vdout1_0ck1040 FIND v(dout1_0) AT=1050.05n

.meas tran vdout1_1ck1040 FIND v(dout1_1) AT=1050.05n

.meas tran vdout1_2ck1040 FIND v(dout1_2) AT=1050.05n

.meas tran vdout1_3ck1040 FIND v(dout1_3) AT=1050.05n

.meas tran vdout1_4ck1040 FIND v(dout1_4) AT=1050.05n

.meas tran vdout1_5ck1040 FIND v(dout1_5) AT=1050.05n

.meas tran vdout1_6ck1040 FIND v(dout1_6) AT=1050.05n

.meas tran vdout1_7ck1040 FIND v(dout1_7) AT=1050.05n

.meas tran vdout1_8ck1040 FIND v(dout1_8) AT=1050.05n

.meas tran vdout1_9ck1040 FIND v(dout1_9) AT=1050.05n

.meas tran vdout1_10ck1040 FIND v(dout1_10) AT=1050.05n

.meas tran vdout1_11ck1040 FIND v(dout1_11) AT=1050.05n

.meas tran vdout1_12ck1040 FIND v(dout1_12) AT=1050.05n

.meas tran vdout1_13ck1040 FIND v(dout1_13) AT=1050.05n

.meas tran vdout1_14ck1040 FIND v(dout1_14) AT=1050.05n

.meas tran vdout1_15ck1040 FIND v(dout1_15) AT=1050.05n

.meas tran vdout1_16ck1040 FIND v(dout1_16) AT=1050.05n

.meas tran vdout1_17ck1040 FIND v(dout1_17) AT=1050.05n

.meas tran vdout1_18ck1040 FIND v(dout1_18) AT=1050.05n

.meas tran vdout1_19ck1040 FIND v(dout1_19) AT=1050.05n

.meas tran vdout1_20ck1040 FIND v(dout1_20) AT=1050.05n

.meas tran vdout1_21ck1040 FIND v(dout1_21) AT=1050.05n

.meas tran vdout1_22ck1040 FIND v(dout1_22) AT=1050.05n

.meas tran vdout1_23ck1040 FIND v(dout1_23) AT=1050.05n

.meas tran vdout1_24ck1040 FIND v(dout1_24) AT=1050.05n

.meas tran vdout1_25ck1040 FIND v(dout1_25) AT=1050.05n

.meas tran vdout1_26ck1040 FIND v(dout1_26) AT=1050.05n

.meas tran vdout1_27ck1040 FIND v(dout1_27) AT=1050.05n

.meas tran vdout1_28ck1040 FIND v(dout1_28) AT=1050.05n

.meas tran vdout1_29ck1040 FIND v(dout1_29) AT=1050.05n

.meas tran vdout1_30ck1040 FIND v(dout1_30) AT=1050.05n

.meas tran vdout1_31ck1040 FIND v(dout1_31) AT=1050.05n

.meas tran vdout1_32ck1040 FIND v(dout1_32) AT=1050.05n

.meas tran vdout1_33ck1040 FIND v(dout1_33) AT=1050.05n

.meas tran vdout1_34ck1040 FIND v(dout1_34) AT=1050.05n

.meas tran vdout1_35ck1040 FIND v(dout1_35) AT=1050.05n

.meas tran vdout1_36ck1040 FIND v(dout1_36) AT=1050.05n

.meas tran vdout1_37ck1040 FIND v(dout1_37) AT=1050.05n

.meas tran vdout1_38ck1040 FIND v(dout1_38) AT=1050.05n

.meas tran vdout1_39ck1040 FIND v(dout1_39) AT=1050.05n

.meas tran vdout1_40ck1040 FIND v(dout1_40) AT=1050.05n

.meas tran vdout1_41ck1040 FIND v(dout1_41) AT=1050.05n

.meas tran vdout1_42ck1040 FIND v(dout1_42) AT=1050.05n

.meas tran vdout1_43ck1040 FIND v(dout1_43) AT=1050.05n

.meas tran vdout1_44ck1040 FIND v(dout1_44) AT=1050.05n

.meas tran vdout1_45ck1040 FIND v(dout1_45) AT=1050.05n

.meas tran vdout1_46ck1040 FIND v(dout1_46) AT=1050.05n

.meas tran vdout1_47ck1040 FIND v(dout1_47) AT=1050.05n

.meas tran vdout1_48ck1040 FIND v(dout1_48) AT=1050.05n

.meas tran vdout1_49ck1040 FIND v(dout1_49) AT=1050.05n

.meas tran vdout1_50ck1040 FIND v(dout1_50) AT=1050.05n

.meas tran vdout1_51ck1040 FIND v(dout1_51) AT=1050.05n

.meas tran vdout1_52ck1040 FIND v(dout1_52) AT=1050.05n

.meas tran vdout1_53ck1040 FIND v(dout1_53) AT=1050.05n

.meas tran vdout1_54ck1040 FIND v(dout1_54) AT=1050.05n

.meas tran vdout1_55ck1040 FIND v(dout1_55) AT=1050.05n

.meas tran vdout1_56ck1040 FIND v(dout1_56) AT=1050.05n

.meas tran vdout1_57ck1040 FIND v(dout1_57) AT=1050.05n

.meas tran vdout1_58ck1040 FIND v(dout1_58) AT=1050.05n

.meas tran vdout1_59ck1040 FIND v(dout1_59) AT=1050.05n

.meas tran vdout1_60ck1040 FIND v(dout1_60) AT=1050.05n

.meas tran vdout1_61ck1040 FIND v(dout1_61) AT=1050.05n

.meas tran vdout1_62ck1040 FIND v(dout1_62) AT=1050.05n

.meas tran vdout1_63ck1040 FIND v(dout1_63) AT=1050.05n

.meas tran vdout1_64ck1040 FIND v(dout1_64) AT=1050.05n

.meas tran vdout1_65ck1040 FIND v(dout1_65) AT=1050.05n

.meas tran vdout1_66ck1040 FIND v(dout1_66) AT=1050.05n

.meas tran vdout1_67ck1040 FIND v(dout1_67) AT=1050.05n

.meas tran vdout1_68ck1040 FIND v(dout1_68) AT=1050.05n

.meas tran vdout1_69ck1040 FIND v(dout1_69) AT=1050.05n

.meas tran vdout1_70ck1040 FIND v(dout1_70) AT=1050.05n

.meas tran vdout1_71ck1040 FIND v(dout1_71) AT=1050.05n

.meas tran vdout1_72ck1040 FIND v(dout1_72) AT=1050.05n

.meas tran vdout1_73ck1040 FIND v(dout1_73) AT=1050.05n

.meas tran vdout1_74ck1040 FIND v(dout1_74) AT=1050.05n

.meas tran vdout1_75ck1040 FIND v(dout1_75) AT=1050.05n

.meas tran vdout1_76ck1040 FIND v(dout1_76) AT=1050.05n

.meas tran vdout1_77ck1040 FIND v(dout1_77) AT=1050.05n

.meas tran vdout1_78ck1040 FIND v(dout1_78) AT=1050.05n

.meas tran vdout1_79ck1040 FIND v(dout1_79) AT=1050.05n

.meas tran vdout1_80ck1040 FIND v(dout1_80) AT=1050.05n

.meas tran vdout1_81ck1040 FIND v(dout1_81) AT=1050.05n

.meas tran vdout1_82ck1040 FIND v(dout1_82) AT=1050.05n

.meas tran vdout1_83ck1040 FIND v(dout1_83) AT=1050.05n

.meas tran vdout1_84ck1040 FIND v(dout1_84) AT=1050.05n

.meas tran vdout1_85ck1040 FIND v(dout1_85) AT=1050.05n

.meas tran vdout1_86ck1040 FIND v(dout1_86) AT=1050.05n

.meas tran vdout1_87ck1040 FIND v(dout1_87) AT=1050.05n

.meas tran vdout1_88ck1040 FIND v(dout1_88) AT=1050.05n

.meas tran vdout1_89ck1040 FIND v(dout1_89) AT=1050.05n

.meas tran vdout1_90ck1040 FIND v(dout1_90) AT=1050.05n

.meas tran vdout1_91ck1040 FIND v(dout1_91) AT=1050.05n

.meas tran vdout1_92ck1040 FIND v(dout1_92) AT=1050.05n

.meas tran vdout1_93ck1040 FIND v(dout1_93) AT=1050.05n

.meas tran vdout1_94ck1040 FIND v(dout1_94) AT=1050.05n

.meas tran vdout1_95ck1040 FIND v(dout1_95) AT=1050.05n

.meas tran vdout1_96ck1040 FIND v(dout1_96) AT=1050.05n

.meas tran vdout1_97ck1040 FIND v(dout1_97) AT=1050.05n

.meas tran vdout1_98ck1040 FIND v(dout1_98) AT=1050.05n

.meas tran vdout1_99ck1040 FIND v(dout1_99) AT=1050.05n

.meas tran vdout1_100ck1040 FIND v(dout1_100) AT=1050.05n

.meas tran vdout1_101ck1040 FIND v(dout1_101) AT=1050.05n

.meas tran vdout1_102ck1040 FIND v(dout1_102) AT=1050.05n

.meas tran vdout1_103ck1040 FIND v(dout1_103) AT=1050.05n

.meas tran vdout1_104ck1040 FIND v(dout1_104) AT=1050.05n

.meas tran vdout1_105ck1040 FIND v(dout1_105) AT=1050.05n

.meas tran vdout1_106ck1040 FIND v(dout1_106) AT=1050.05n

.meas tran vdout1_107ck1040 FIND v(dout1_107) AT=1050.05n

.meas tran vdout1_108ck1040 FIND v(dout1_108) AT=1050.05n

.meas tran vdout1_109ck1040 FIND v(dout1_109) AT=1050.05n

.meas tran vdout1_110ck1040 FIND v(dout1_110) AT=1050.05n

.meas tran vdout1_111ck1040 FIND v(dout1_111) AT=1050.05n

.meas tran vdout1_112ck1040 FIND v(dout1_112) AT=1050.05n

.meas tran vdout1_113ck1040 FIND v(dout1_113) AT=1050.05n

.meas tran vdout1_114ck1040 FIND v(dout1_114) AT=1050.05n

.meas tran vdout1_115ck1040 FIND v(dout1_115) AT=1050.05n

.meas tran vdout1_116ck1040 FIND v(dout1_116) AT=1050.05n

.meas tran vdout1_117ck1040 FIND v(dout1_117) AT=1050.05n

.meas tran vdout1_118ck1040 FIND v(dout1_118) AT=1050.05n

.meas tran vdout1_119ck1040 FIND v(dout1_119) AT=1050.05n

.meas tran vdout1_120ck1040 FIND v(dout1_120) AT=1050.05n

.meas tran vdout1_121ck1040 FIND v(dout1_121) AT=1050.05n

.meas tran vdout1_122ck1040 FIND v(dout1_122) AT=1050.05n

.meas tran vdout1_123ck1040 FIND v(dout1_123) AT=1050.05n

.meas tran vdout1_124ck1040 FIND v(dout1_124) AT=1050.05n

.meas tran vdout1_125ck1040 FIND v(dout1_125) AT=1050.05n

.meas tran vdout1_126ck1040 FIND v(dout1_126) AT=1050.05n

.meas tran vdout1_127ck1040 FIND v(dout1_127) AT=1050.05n

.meas tran vdout1_128ck1040 FIND v(dout1_128) AT=1050.05n

.meas tran vdout1_129ck1040 FIND v(dout1_129) AT=1050.05n

.meas tran vdout1_130ck1040 FIND v(dout1_130) AT=1050.05n

.meas tran vdout1_131ck1040 FIND v(dout1_131) AT=1050.05n

.meas tran vdout1_132ck1040 FIND v(dout1_132) AT=1050.05n

.meas tran vdout1_133ck1040 FIND v(dout1_133) AT=1050.05n

.meas tran vdout1_134ck1040 FIND v(dout1_134) AT=1050.05n

.meas tran vdout1_0ck1090 FIND v(dout1_0) AT=1100.05n

.meas tran vdout1_1ck1090 FIND v(dout1_1) AT=1100.05n

.meas tran vdout1_2ck1090 FIND v(dout1_2) AT=1100.05n

.meas tran vdout1_3ck1090 FIND v(dout1_3) AT=1100.05n

.meas tran vdout1_4ck1090 FIND v(dout1_4) AT=1100.05n

.meas tran vdout1_5ck1090 FIND v(dout1_5) AT=1100.05n

.meas tran vdout1_6ck1090 FIND v(dout1_6) AT=1100.05n

.meas tran vdout1_7ck1090 FIND v(dout1_7) AT=1100.05n

.meas tran vdout1_8ck1090 FIND v(dout1_8) AT=1100.05n

.meas tran vdout1_9ck1090 FIND v(dout1_9) AT=1100.05n

.meas tran vdout1_10ck1090 FIND v(dout1_10) AT=1100.05n

.meas tran vdout1_11ck1090 FIND v(dout1_11) AT=1100.05n

.meas tran vdout1_12ck1090 FIND v(dout1_12) AT=1100.05n

.meas tran vdout1_13ck1090 FIND v(dout1_13) AT=1100.05n

.meas tran vdout1_14ck1090 FIND v(dout1_14) AT=1100.05n

.meas tran vdout1_15ck1090 FIND v(dout1_15) AT=1100.05n

.meas tran vdout1_16ck1090 FIND v(dout1_16) AT=1100.05n

.meas tran vdout1_17ck1090 FIND v(dout1_17) AT=1100.05n

.meas tran vdout1_18ck1090 FIND v(dout1_18) AT=1100.05n

.meas tran vdout1_19ck1090 FIND v(dout1_19) AT=1100.05n

.meas tran vdout1_20ck1090 FIND v(dout1_20) AT=1100.05n

.meas tran vdout1_21ck1090 FIND v(dout1_21) AT=1100.05n

.meas tran vdout1_22ck1090 FIND v(dout1_22) AT=1100.05n

.meas tran vdout1_23ck1090 FIND v(dout1_23) AT=1100.05n

.meas tran vdout1_24ck1090 FIND v(dout1_24) AT=1100.05n

.meas tran vdout1_25ck1090 FIND v(dout1_25) AT=1100.05n

.meas tran vdout1_26ck1090 FIND v(dout1_26) AT=1100.05n

.meas tran vdout1_27ck1090 FIND v(dout1_27) AT=1100.05n

.meas tran vdout1_28ck1090 FIND v(dout1_28) AT=1100.05n

.meas tran vdout1_29ck1090 FIND v(dout1_29) AT=1100.05n

.meas tran vdout1_30ck1090 FIND v(dout1_30) AT=1100.05n

.meas tran vdout1_31ck1090 FIND v(dout1_31) AT=1100.05n

.meas tran vdout1_32ck1090 FIND v(dout1_32) AT=1100.05n

.meas tran vdout1_33ck1090 FIND v(dout1_33) AT=1100.05n

.meas tran vdout1_34ck1090 FIND v(dout1_34) AT=1100.05n

.meas tran vdout1_35ck1090 FIND v(dout1_35) AT=1100.05n

.meas tran vdout1_36ck1090 FIND v(dout1_36) AT=1100.05n

.meas tran vdout1_37ck1090 FIND v(dout1_37) AT=1100.05n

.meas tran vdout1_38ck1090 FIND v(dout1_38) AT=1100.05n

.meas tran vdout1_39ck1090 FIND v(dout1_39) AT=1100.05n

.meas tran vdout1_40ck1090 FIND v(dout1_40) AT=1100.05n

.meas tran vdout1_41ck1090 FIND v(dout1_41) AT=1100.05n

.meas tran vdout1_42ck1090 FIND v(dout1_42) AT=1100.05n

.meas tran vdout1_43ck1090 FIND v(dout1_43) AT=1100.05n

.meas tran vdout1_44ck1090 FIND v(dout1_44) AT=1100.05n

.meas tran vdout1_45ck1090 FIND v(dout1_45) AT=1100.05n

.meas tran vdout1_46ck1090 FIND v(dout1_46) AT=1100.05n

.meas tran vdout1_47ck1090 FIND v(dout1_47) AT=1100.05n

.meas tran vdout1_48ck1090 FIND v(dout1_48) AT=1100.05n

.meas tran vdout1_49ck1090 FIND v(dout1_49) AT=1100.05n

.meas tran vdout1_50ck1090 FIND v(dout1_50) AT=1100.05n

.meas tran vdout1_51ck1090 FIND v(dout1_51) AT=1100.05n

.meas tran vdout1_52ck1090 FIND v(dout1_52) AT=1100.05n

.meas tran vdout1_53ck1090 FIND v(dout1_53) AT=1100.05n

.meas tran vdout1_54ck1090 FIND v(dout1_54) AT=1100.05n

.meas tran vdout1_55ck1090 FIND v(dout1_55) AT=1100.05n

.meas tran vdout1_56ck1090 FIND v(dout1_56) AT=1100.05n

.meas tran vdout1_57ck1090 FIND v(dout1_57) AT=1100.05n

.meas tran vdout1_58ck1090 FIND v(dout1_58) AT=1100.05n

.meas tran vdout1_59ck1090 FIND v(dout1_59) AT=1100.05n

.meas tran vdout1_60ck1090 FIND v(dout1_60) AT=1100.05n

.meas tran vdout1_61ck1090 FIND v(dout1_61) AT=1100.05n

.meas tran vdout1_62ck1090 FIND v(dout1_62) AT=1100.05n

.meas tran vdout1_63ck1090 FIND v(dout1_63) AT=1100.05n

.meas tran vdout1_64ck1090 FIND v(dout1_64) AT=1100.05n

.meas tran vdout1_65ck1090 FIND v(dout1_65) AT=1100.05n

.meas tran vdout1_66ck1090 FIND v(dout1_66) AT=1100.05n

.meas tran vdout1_67ck1090 FIND v(dout1_67) AT=1100.05n

.meas tran vdout1_68ck1090 FIND v(dout1_68) AT=1100.05n

.meas tran vdout1_69ck1090 FIND v(dout1_69) AT=1100.05n

.meas tran vdout1_70ck1090 FIND v(dout1_70) AT=1100.05n

.meas tran vdout1_71ck1090 FIND v(dout1_71) AT=1100.05n

.meas tran vdout1_72ck1090 FIND v(dout1_72) AT=1100.05n

.meas tran vdout1_73ck1090 FIND v(dout1_73) AT=1100.05n

.meas tran vdout1_74ck1090 FIND v(dout1_74) AT=1100.05n

.meas tran vdout1_75ck1090 FIND v(dout1_75) AT=1100.05n

.meas tran vdout1_76ck1090 FIND v(dout1_76) AT=1100.05n

.meas tran vdout1_77ck1090 FIND v(dout1_77) AT=1100.05n

.meas tran vdout1_78ck1090 FIND v(dout1_78) AT=1100.05n

.meas tran vdout1_79ck1090 FIND v(dout1_79) AT=1100.05n

.meas tran vdout1_80ck1090 FIND v(dout1_80) AT=1100.05n

.meas tran vdout1_81ck1090 FIND v(dout1_81) AT=1100.05n

.meas tran vdout1_82ck1090 FIND v(dout1_82) AT=1100.05n

.meas tran vdout1_83ck1090 FIND v(dout1_83) AT=1100.05n

.meas tran vdout1_84ck1090 FIND v(dout1_84) AT=1100.05n

.meas tran vdout1_85ck1090 FIND v(dout1_85) AT=1100.05n

.meas tran vdout1_86ck1090 FIND v(dout1_86) AT=1100.05n

.meas tran vdout1_87ck1090 FIND v(dout1_87) AT=1100.05n

.meas tran vdout1_88ck1090 FIND v(dout1_88) AT=1100.05n

.meas tran vdout1_89ck1090 FIND v(dout1_89) AT=1100.05n

.meas tran vdout1_90ck1090 FIND v(dout1_90) AT=1100.05n

.meas tran vdout1_91ck1090 FIND v(dout1_91) AT=1100.05n

.meas tran vdout1_92ck1090 FIND v(dout1_92) AT=1100.05n

.meas tran vdout1_93ck1090 FIND v(dout1_93) AT=1100.05n

.meas tran vdout1_94ck1090 FIND v(dout1_94) AT=1100.05n

.meas tran vdout1_95ck1090 FIND v(dout1_95) AT=1100.05n

.meas tran vdout1_96ck1090 FIND v(dout1_96) AT=1100.05n

.meas tran vdout1_97ck1090 FIND v(dout1_97) AT=1100.05n

.meas tran vdout1_98ck1090 FIND v(dout1_98) AT=1100.05n

.meas tran vdout1_99ck1090 FIND v(dout1_99) AT=1100.05n

.meas tran vdout1_100ck1090 FIND v(dout1_100) AT=1100.05n

.meas tran vdout1_101ck1090 FIND v(dout1_101) AT=1100.05n

.meas tran vdout1_102ck1090 FIND v(dout1_102) AT=1100.05n

.meas tran vdout1_103ck1090 FIND v(dout1_103) AT=1100.05n

.meas tran vdout1_104ck1090 FIND v(dout1_104) AT=1100.05n

.meas tran vdout1_105ck1090 FIND v(dout1_105) AT=1100.05n

.meas tran vdout1_106ck1090 FIND v(dout1_106) AT=1100.05n

.meas tran vdout1_107ck1090 FIND v(dout1_107) AT=1100.05n

.meas tran vdout1_108ck1090 FIND v(dout1_108) AT=1100.05n

.meas tran vdout1_109ck1090 FIND v(dout1_109) AT=1100.05n

.meas tran vdout1_110ck1090 FIND v(dout1_110) AT=1100.05n

.meas tran vdout1_111ck1090 FIND v(dout1_111) AT=1100.05n

.meas tran vdout1_112ck1090 FIND v(dout1_112) AT=1100.05n

.meas tran vdout1_113ck1090 FIND v(dout1_113) AT=1100.05n

.meas tran vdout1_114ck1090 FIND v(dout1_114) AT=1100.05n

.meas tran vdout1_115ck1090 FIND v(dout1_115) AT=1100.05n

.meas tran vdout1_116ck1090 FIND v(dout1_116) AT=1100.05n

.meas tran vdout1_117ck1090 FIND v(dout1_117) AT=1100.05n

.meas tran vdout1_118ck1090 FIND v(dout1_118) AT=1100.05n

.meas tran vdout1_119ck1090 FIND v(dout1_119) AT=1100.05n

.meas tran vdout1_120ck1090 FIND v(dout1_120) AT=1100.05n

.meas tran vdout1_121ck1090 FIND v(dout1_121) AT=1100.05n

.meas tran vdout1_122ck1090 FIND v(dout1_122) AT=1100.05n

.meas tran vdout1_123ck1090 FIND v(dout1_123) AT=1100.05n

.meas tran vdout1_124ck1090 FIND v(dout1_124) AT=1100.05n

.meas tran vdout1_125ck1090 FIND v(dout1_125) AT=1100.05n

.meas tran vdout1_126ck1090 FIND v(dout1_126) AT=1100.05n

.meas tran vdout1_127ck1090 FIND v(dout1_127) AT=1100.05n

.meas tran vdout1_128ck1090 FIND v(dout1_128) AT=1100.05n

.meas tran vdout1_129ck1090 FIND v(dout1_129) AT=1100.05n

.meas tran vdout1_130ck1090 FIND v(dout1_130) AT=1100.05n

.meas tran vdout1_131ck1090 FIND v(dout1_131) AT=1100.05n

.meas tran vdout1_132ck1090 FIND v(dout1_132) AT=1100.05n

.meas tran vdout1_133ck1090 FIND v(dout1_133) AT=1100.05n

.meas tran vdout1_134ck1090 FIND v(dout1_134) AT=1100.05n

.meas tran vdout1_0ck1120 FIND v(dout1_0) AT=1130.05n

.meas tran vdout1_1ck1120 FIND v(dout1_1) AT=1130.05n

.meas tran vdout1_2ck1120 FIND v(dout1_2) AT=1130.05n

.meas tran vdout1_3ck1120 FIND v(dout1_3) AT=1130.05n

.meas tran vdout1_4ck1120 FIND v(dout1_4) AT=1130.05n

.meas tran vdout1_5ck1120 FIND v(dout1_5) AT=1130.05n

.meas tran vdout1_6ck1120 FIND v(dout1_6) AT=1130.05n

.meas tran vdout1_7ck1120 FIND v(dout1_7) AT=1130.05n

.meas tran vdout1_8ck1120 FIND v(dout1_8) AT=1130.05n

.meas tran vdout1_9ck1120 FIND v(dout1_9) AT=1130.05n

.meas tran vdout1_10ck1120 FIND v(dout1_10) AT=1130.05n

.meas tran vdout1_11ck1120 FIND v(dout1_11) AT=1130.05n

.meas tran vdout1_12ck1120 FIND v(dout1_12) AT=1130.05n

.meas tran vdout1_13ck1120 FIND v(dout1_13) AT=1130.05n

.meas tran vdout1_14ck1120 FIND v(dout1_14) AT=1130.05n

.meas tran vdout1_15ck1120 FIND v(dout1_15) AT=1130.05n

.meas tran vdout1_16ck1120 FIND v(dout1_16) AT=1130.05n

.meas tran vdout1_17ck1120 FIND v(dout1_17) AT=1130.05n

.meas tran vdout1_18ck1120 FIND v(dout1_18) AT=1130.05n

.meas tran vdout1_19ck1120 FIND v(dout1_19) AT=1130.05n

.meas tran vdout1_20ck1120 FIND v(dout1_20) AT=1130.05n

.meas tran vdout1_21ck1120 FIND v(dout1_21) AT=1130.05n

.meas tran vdout1_22ck1120 FIND v(dout1_22) AT=1130.05n

.meas tran vdout1_23ck1120 FIND v(dout1_23) AT=1130.05n

.meas tran vdout1_24ck1120 FIND v(dout1_24) AT=1130.05n

.meas tran vdout1_25ck1120 FIND v(dout1_25) AT=1130.05n

.meas tran vdout1_26ck1120 FIND v(dout1_26) AT=1130.05n

.meas tran vdout1_27ck1120 FIND v(dout1_27) AT=1130.05n

.meas tran vdout1_28ck1120 FIND v(dout1_28) AT=1130.05n

.meas tran vdout1_29ck1120 FIND v(dout1_29) AT=1130.05n

.meas tran vdout1_30ck1120 FIND v(dout1_30) AT=1130.05n

.meas tran vdout1_31ck1120 FIND v(dout1_31) AT=1130.05n

.meas tran vdout1_32ck1120 FIND v(dout1_32) AT=1130.05n

.meas tran vdout1_33ck1120 FIND v(dout1_33) AT=1130.05n

.meas tran vdout1_34ck1120 FIND v(dout1_34) AT=1130.05n

.meas tran vdout1_35ck1120 FIND v(dout1_35) AT=1130.05n

.meas tran vdout1_36ck1120 FIND v(dout1_36) AT=1130.05n

.meas tran vdout1_37ck1120 FIND v(dout1_37) AT=1130.05n

.meas tran vdout1_38ck1120 FIND v(dout1_38) AT=1130.05n

.meas tran vdout1_39ck1120 FIND v(dout1_39) AT=1130.05n

.meas tran vdout1_40ck1120 FIND v(dout1_40) AT=1130.05n

.meas tran vdout1_41ck1120 FIND v(dout1_41) AT=1130.05n

.meas tran vdout1_42ck1120 FIND v(dout1_42) AT=1130.05n

.meas tran vdout1_43ck1120 FIND v(dout1_43) AT=1130.05n

.meas tran vdout1_44ck1120 FIND v(dout1_44) AT=1130.05n

.meas tran vdout1_45ck1120 FIND v(dout1_45) AT=1130.05n

.meas tran vdout1_46ck1120 FIND v(dout1_46) AT=1130.05n

.meas tran vdout1_47ck1120 FIND v(dout1_47) AT=1130.05n

.meas tran vdout1_48ck1120 FIND v(dout1_48) AT=1130.05n

.meas tran vdout1_49ck1120 FIND v(dout1_49) AT=1130.05n

.meas tran vdout1_50ck1120 FIND v(dout1_50) AT=1130.05n

.meas tran vdout1_51ck1120 FIND v(dout1_51) AT=1130.05n

.meas tran vdout1_52ck1120 FIND v(dout1_52) AT=1130.05n

.meas tran vdout1_53ck1120 FIND v(dout1_53) AT=1130.05n

.meas tran vdout1_54ck1120 FIND v(dout1_54) AT=1130.05n

.meas tran vdout1_55ck1120 FIND v(dout1_55) AT=1130.05n

.meas tran vdout1_56ck1120 FIND v(dout1_56) AT=1130.05n

.meas tran vdout1_57ck1120 FIND v(dout1_57) AT=1130.05n

.meas tran vdout1_58ck1120 FIND v(dout1_58) AT=1130.05n

.meas tran vdout1_59ck1120 FIND v(dout1_59) AT=1130.05n

.meas tran vdout1_60ck1120 FIND v(dout1_60) AT=1130.05n

.meas tran vdout1_61ck1120 FIND v(dout1_61) AT=1130.05n

.meas tran vdout1_62ck1120 FIND v(dout1_62) AT=1130.05n

.meas tran vdout1_63ck1120 FIND v(dout1_63) AT=1130.05n

.meas tran vdout1_64ck1120 FIND v(dout1_64) AT=1130.05n

.meas tran vdout1_65ck1120 FIND v(dout1_65) AT=1130.05n

.meas tran vdout1_66ck1120 FIND v(dout1_66) AT=1130.05n

.meas tran vdout1_67ck1120 FIND v(dout1_67) AT=1130.05n

.meas tran vdout1_68ck1120 FIND v(dout1_68) AT=1130.05n

.meas tran vdout1_69ck1120 FIND v(dout1_69) AT=1130.05n

.meas tran vdout1_70ck1120 FIND v(dout1_70) AT=1130.05n

.meas tran vdout1_71ck1120 FIND v(dout1_71) AT=1130.05n

.meas tran vdout1_72ck1120 FIND v(dout1_72) AT=1130.05n

.meas tran vdout1_73ck1120 FIND v(dout1_73) AT=1130.05n

.meas tran vdout1_74ck1120 FIND v(dout1_74) AT=1130.05n

.meas tran vdout1_75ck1120 FIND v(dout1_75) AT=1130.05n

.meas tran vdout1_76ck1120 FIND v(dout1_76) AT=1130.05n

.meas tran vdout1_77ck1120 FIND v(dout1_77) AT=1130.05n

.meas tran vdout1_78ck1120 FIND v(dout1_78) AT=1130.05n

.meas tran vdout1_79ck1120 FIND v(dout1_79) AT=1130.05n

.meas tran vdout1_80ck1120 FIND v(dout1_80) AT=1130.05n

.meas tran vdout1_81ck1120 FIND v(dout1_81) AT=1130.05n

.meas tran vdout1_82ck1120 FIND v(dout1_82) AT=1130.05n

.meas tran vdout1_83ck1120 FIND v(dout1_83) AT=1130.05n

.meas tran vdout1_84ck1120 FIND v(dout1_84) AT=1130.05n

.meas tran vdout1_85ck1120 FIND v(dout1_85) AT=1130.05n

.meas tran vdout1_86ck1120 FIND v(dout1_86) AT=1130.05n

.meas tran vdout1_87ck1120 FIND v(dout1_87) AT=1130.05n

.meas tran vdout1_88ck1120 FIND v(dout1_88) AT=1130.05n

.meas tran vdout1_89ck1120 FIND v(dout1_89) AT=1130.05n

.meas tran vdout1_90ck1120 FIND v(dout1_90) AT=1130.05n

.meas tran vdout1_91ck1120 FIND v(dout1_91) AT=1130.05n

.meas tran vdout1_92ck1120 FIND v(dout1_92) AT=1130.05n

.meas tran vdout1_93ck1120 FIND v(dout1_93) AT=1130.05n

.meas tran vdout1_94ck1120 FIND v(dout1_94) AT=1130.05n

.meas tran vdout1_95ck1120 FIND v(dout1_95) AT=1130.05n

.meas tran vdout1_96ck1120 FIND v(dout1_96) AT=1130.05n

.meas tran vdout1_97ck1120 FIND v(dout1_97) AT=1130.05n

.meas tran vdout1_98ck1120 FIND v(dout1_98) AT=1130.05n

.meas tran vdout1_99ck1120 FIND v(dout1_99) AT=1130.05n

.meas tran vdout1_100ck1120 FIND v(dout1_100) AT=1130.05n

.meas tran vdout1_101ck1120 FIND v(dout1_101) AT=1130.05n

.meas tran vdout1_102ck1120 FIND v(dout1_102) AT=1130.05n

.meas tran vdout1_103ck1120 FIND v(dout1_103) AT=1130.05n

.meas tran vdout1_104ck1120 FIND v(dout1_104) AT=1130.05n

.meas tran vdout1_105ck1120 FIND v(dout1_105) AT=1130.05n

.meas tran vdout1_106ck1120 FIND v(dout1_106) AT=1130.05n

.meas tran vdout1_107ck1120 FIND v(dout1_107) AT=1130.05n

.meas tran vdout1_108ck1120 FIND v(dout1_108) AT=1130.05n

.meas tran vdout1_109ck1120 FIND v(dout1_109) AT=1130.05n

.meas tran vdout1_110ck1120 FIND v(dout1_110) AT=1130.05n

.meas tran vdout1_111ck1120 FIND v(dout1_111) AT=1130.05n

.meas tran vdout1_112ck1120 FIND v(dout1_112) AT=1130.05n

.meas tran vdout1_113ck1120 FIND v(dout1_113) AT=1130.05n

.meas tran vdout1_114ck1120 FIND v(dout1_114) AT=1130.05n

.meas tran vdout1_115ck1120 FIND v(dout1_115) AT=1130.05n

.meas tran vdout1_116ck1120 FIND v(dout1_116) AT=1130.05n

.meas tran vdout1_117ck1120 FIND v(dout1_117) AT=1130.05n

.meas tran vdout1_118ck1120 FIND v(dout1_118) AT=1130.05n

.meas tran vdout1_119ck1120 FIND v(dout1_119) AT=1130.05n

.meas tran vdout1_120ck1120 FIND v(dout1_120) AT=1130.05n

.meas tran vdout1_121ck1120 FIND v(dout1_121) AT=1130.05n

.meas tran vdout1_122ck1120 FIND v(dout1_122) AT=1130.05n

.meas tran vdout1_123ck1120 FIND v(dout1_123) AT=1130.05n

.meas tran vdout1_124ck1120 FIND v(dout1_124) AT=1130.05n

.meas tran vdout1_125ck1120 FIND v(dout1_125) AT=1130.05n

.meas tran vdout1_126ck1120 FIND v(dout1_126) AT=1130.05n

.meas tran vdout1_127ck1120 FIND v(dout1_127) AT=1130.05n

.meas tran vdout1_128ck1120 FIND v(dout1_128) AT=1130.05n

.meas tran vdout1_129ck1120 FIND v(dout1_129) AT=1130.05n

.meas tran vdout1_130ck1120 FIND v(dout1_130) AT=1130.05n

.meas tran vdout1_131ck1120 FIND v(dout1_131) AT=1130.05n

.meas tran vdout1_132ck1120 FIND v(dout1_132) AT=1130.05n

.meas tran vdout1_133ck1120 FIND v(dout1_133) AT=1130.05n

.meas tran vdout1_134ck1120 FIND v(dout1_134) AT=1130.05n

.meas tran vdout1_0ck1130 FIND v(dout1_0) AT=1140.05n

.meas tran vdout1_1ck1130 FIND v(dout1_1) AT=1140.05n

.meas tran vdout1_2ck1130 FIND v(dout1_2) AT=1140.05n

.meas tran vdout1_3ck1130 FIND v(dout1_3) AT=1140.05n

.meas tran vdout1_4ck1130 FIND v(dout1_4) AT=1140.05n

.meas tran vdout1_5ck1130 FIND v(dout1_5) AT=1140.05n

.meas tran vdout1_6ck1130 FIND v(dout1_6) AT=1140.05n

.meas tran vdout1_7ck1130 FIND v(dout1_7) AT=1140.05n

.meas tran vdout1_8ck1130 FIND v(dout1_8) AT=1140.05n

.meas tran vdout1_9ck1130 FIND v(dout1_9) AT=1140.05n

.meas tran vdout1_10ck1130 FIND v(dout1_10) AT=1140.05n

.meas tran vdout1_11ck1130 FIND v(dout1_11) AT=1140.05n

.meas tran vdout1_12ck1130 FIND v(dout1_12) AT=1140.05n

.meas tran vdout1_13ck1130 FIND v(dout1_13) AT=1140.05n

.meas tran vdout1_14ck1130 FIND v(dout1_14) AT=1140.05n

.meas tran vdout1_15ck1130 FIND v(dout1_15) AT=1140.05n

.meas tran vdout1_16ck1130 FIND v(dout1_16) AT=1140.05n

.meas tran vdout1_17ck1130 FIND v(dout1_17) AT=1140.05n

.meas tran vdout1_18ck1130 FIND v(dout1_18) AT=1140.05n

.meas tran vdout1_19ck1130 FIND v(dout1_19) AT=1140.05n

.meas tran vdout1_20ck1130 FIND v(dout1_20) AT=1140.05n

.meas tran vdout1_21ck1130 FIND v(dout1_21) AT=1140.05n

.meas tran vdout1_22ck1130 FIND v(dout1_22) AT=1140.05n

.meas tran vdout1_23ck1130 FIND v(dout1_23) AT=1140.05n

.meas tran vdout1_24ck1130 FIND v(dout1_24) AT=1140.05n

.meas tran vdout1_25ck1130 FIND v(dout1_25) AT=1140.05n

.meas tran vdout1_26ck1130 FIND v(dout1_26) AT=1140.05n

.meas tran vdout1_27ck1130 FIND v(dout1_27) AT=1140.05n

.meas tran vdout1_28ck1130 FIND v(dout1_28) AT=1140.05n

.meas tran vdout1_29ck1130 FIND v(dout1_29) AT=1140.05n

.meas tran vdout1_30ck1130 FIND v(dout1_30) AT=1140.05n

.meas tran vdout1_31ck1130 FIND v(dout1_31) AT=1140.05n

.meas tran vdout1_32ck1130 FIND v(dout1_32) AT=1140.05n

.meas tran vdout1_33ck1130 FIND v(dout1_33) AT=1140.05n

.meas tran vdout1_34ck1130 FIND v(dout1_34) AT=1140.05n

.meas tran vdout1_35ck1130 FIND v(dout1_35) AT=1140.05n

.meas tran vdout1_36ck1130 FIND v(dout1_36) AT=1140.05n

.meas tran vdout1_37ck1130 FIND v(dout1_37) AT=1140.05n

.meas tran vdout1_38ck1130 FIND v(dout1_38) AT=1140.05n

.meas tran vdout1_39ck1130 FIND v(dout1_39) AT=1140.05n

.meas tran vdout1_40ck1130 FIND v(dout1_40) AT=1140.05n

.meas tran vdout1_41ck1130 FIND v(dout1_41) AT=1140.05n

.meas tran vdout1_42ck1130 FIND v(dout1_42) AT=1140.05n

.meas tran vdout1_43ck1130 FIND v(dout1_43) AT=1140.05n

.meas tran vdout1_44ck1130 FIND v(dout1_44) AT=1140.05n

.meas tran vdout1_45ck1130 FIND v(dout1_45) AT=1140.05n

.meas tran vdout1_46ck1130 FIND v(dout1_46) AT=1140.05n

.meas tran vdout1_47ck1130 FIND v(dout1_47) AT=1140.05n

.meas tran vdout1_48ck1130 FIND v(dout1_48) AT=1140.05n

.meas tran vdout1_49ck1130 FIND v(dout1_49) AT=1140.05n

.meas tran vdout1_50ck1130 FIND v(dout1_50) AT=1140.05n

.meas tran vdout1_51ck1130 FIND v(dout1_51) AT=1140.05n

.meas tran vdout1_52ck1130 FIND v(dout1_52) AT=1140.05n

.meas tran vdout1_53ck1130 FIND v(dout1_53) AT=1140.05n

.meas tran vdout1_54ck1130 FIND v(dout1_54) AT=1140.05n

.meas tran vdout1_55ck1130 FIND v(dout1_55) AT=1140.05n

.meas tran vdout1_56ck1130 FIND v(dout1_56) AT=1140.05n

.meas tran vdout1_57ck1130 FIND v(dout1_57) AT=1140.05n

.meas tran vdout1_58ck1130 FIND v(dout1_58) AT=1140.05n

.meas tran vdout1_59ck1130 FIND v(dout1_59) AT=1140.05n

.meas tran vdout1_60ck1130 FIND v(dout1_60) AT=1140.05n

.meas tran vdout1_61ck1130 FIND v(dout1_61) AT=1140.05n

.meas tran vdout1_62ck1130 FIND v(dout1_62) AT=1140.05n

.meas tran vdout1_63ck1130 FIND v(dout1_63) AT=1140.05n

.meas tran vdout1_64ck1130 FIND v(dout1_64) AT=1140.05n

.meas tran vdout1_65ck1130 FIND v(dout1_65) AT=1140.05n

.meas tran vdout1_66ck1130 FIND v(dout1_66) AT=1140.05n

.meas tran vdout1_67ck1130 FIND v(dout1_67) AT=1140.05n

.meas tran vdout1_68ck1130 FIND v(dout1_68) AT=1140.05n

.meas tran vdout1_69ck1130 FIND v(dout1_69) AT=1140.05n

.meas tran vdout1_70ck1130 FIND v(dout1_70) AT=1140.05n

.meas tran vdout1_71ck1130 FIND v(dout1_71) AT=1140.05n

.meas tran vdout1_72ck1130 FIND v(dout1_72) AT=1140.05n

.meas tran vdout1_73ck1130 FIND v(dout1_73) AT=1140.05n

.meas tran vdout1_74ck1130 FIND v(dout1_74) AT=1140.05n

.meas tran vdout1_75ck1130 FIND v(dout1_75) AT=1140.05n

.meas tran vdout1_76ck1130 FIND v(dout1_76) AT=1140.05n

.meas tran vdout1_77ck1130 FIND v(dout1_77) AT=1140.05n

.meas tran vdout1_78ck1130 FIND v(dout1_78) AT=1140.05n

.meas tran vdout1_79ck1130 FIND v(dout1_79) AT=1140.05n

.meas tran vdout1_80ck1130 FIND v(dout1_80) AT=1140.05n

.meas tran vdout1_81ck1130 FIND v(dout1_81) AT=1140.05n

.meas tran vdout1_82ck1130 FIND v(dout1_82) AT=1140.05n

.meas tran vdout1_83ck1130 FIND v(dout1_83) AT=1140.05n

.meas tran vdout1_84ck1130 FIND v(dout1_84) AT=1140.05n

.meas tran vdout1_85ck1130 FIND v(dout1_85) AT=1140.05n

.meas tran vdout1_86ck1130 FIND v(dout1_86) AT=1140.05n

.meas tran vdout1_87ck1130 FIND v(dout1_87) AT=1140.05n

.meas tran vdout1_88ck1130 FIND v(dout1_88) AT=1140.05n

.meas tran vdout1_89ck1130 FIND v(dout1_89) AT=1140.05n

.meas tran vdout1_90ck1130 FIND v(dout1_90) AT=1140.05n

.meas tran vdout1_91ck1130 FIND v(dout1_91) AT=1140.05n

.meas tran vdout1_92ck1130 FIND v(dout1_92) AT=1140.05n

.meas tran vdout1_93ck1130 FIND v(dout1_93) AT=1140.05n

.meas tran vdout1_94ck1130 FIND v(dout1_94) AT=1140.05n

.meas tran vdout1_95ck1130 FIND v(dout1_95) AT=1140.05n

.meas tran vdout1_96ck1130 FIND v(dout1_96) AT=1140.05n

.meas tran vdout1_97ck1130 FIND v(dout1_97) AT=1140.05n

.meas tran vdout1_98ck1130 FIND v(dout1_98) AT=1140.05n

.meas tran vdout1_99ck1130 FIND v(dout1_99) AT=1140.05n

.meas tran vdout1_100ck1130 FIND v(dout1_100) AT=1140.05n

.meas tran vdout1_101ck1130 FIND v(dout1_101) AT=1140.05n

.meas tran vdout1_102ck1130 FIND v(dout1_102) AT=1140.05n

.meas tran vdout1_103ck1130 FIND v(dout1_103) AT=1140.05n

.meas tran vdout1_104ck1130 FIND v(dout1_104) AT=1140.05n

.meas tran vdout1_105ck1130 FIND v(dout1_105) AT=1140.05n

.meas tran vdout1_106ck1130 FIND v(dout1_106) AT=1140.05n

.meas tran vdout1_107ck1130 FIND v(dout1_107) AT=1140.05n

.meas tran vdout1_108ck1130 FIND v(dout1_108) AT=1140.05n

.meas tran vdout1_109ck1130 FIND v(dout1_109) AT=1140.05n

.meas tran vdout1_110ck1130 FIND v(dout1_110) AT=1140.05n

.meas tran vdout1_111ck1130 FIND v(dout1_111) AT=1140.05n

.meas tran vdout1_112ck1130 FIND v(dout1_112) AT=1140.05n

.meas tran vdout1_113ck1130 FIND v(dout1_113) AT=1140.05n

.meas tran vdout1_114ck1130 FIND v(dout1_114) AT=1140.05n

.meas tran vdout1_115ck1130 FIND v(dout1_115) AT=1140.05n

.meas tran vdout1_116ck1130 FIND v(dout1_116) AT=1140.05n

.meas tran vdout1_117ck1130 FIND v(dout1_117) AT=1140.05n

.meas tran vdout1_118ck1130 FIND v(dout1_118) AT=1140.05n

.meas tran vdout1_119ck1130 FIND v(dout1_119) AT=1140.05n

.meas tran vdout1_120ck1130 FIND v(dout1_120) AT=1140.05n

.meas tran vdout1_121ck1130 FIND v(dout1_121) AT=1140.05n

.meas tran vdout1_122ck1130 FIND v(dout1_122) AT=1140.05n

.meas tran vdout1_123ck1130 FIND v(dout1_123) AT=1140.05n

.meas tran vdout1_124ck1130 FIND v(dout1_124) AT=1140.05n

.meas tran vdout1_125ck1130 FIND v(dout1_125) AT=1140.05n

.meas tran vdout1_126ck1130 FIND v(dout1_126) AT=1140.05n

.meas tran vdout1_127ck1130 FIND v(dout1_127) AT=1140.05n

.meas tran vdout1_128ck1130 FIND v(dout1_128) AT=1140.05n

.meas tran vdout1_129ck1130 FIND v(dout1_129) AT=1140.05n

.meas tran vdout1_130ck1130 FIND v(dout1_130) AT=1140.05n

.meas tran vdout1_131ck1130 FIND v(dout1_131) AT=1140.05n

.meas tran vdout1_132ck1130 FIND v(dout1_132) AT=1140.05n

.meas tran vdout1_133ck1130 FIND v(dout1_133) AT=1140.05n

.meas tran vdout1_134ck1130 FIND v(dout1_134) AT=1140.05n

.meas tran vdout1_0ck1150 FIND v(dout1_0) AT=1160.05n

.meas tran vdout1_1ck1150 FIND v(dout1_1) AT=1160.05n

.meas tran vdout1_2ck1150 FIND v(dout1_2) AT=1160.05n

.meas tran vdout1_3ck1150 FIND v(dout1_3) AT=1160.05n

.meas tran vdout1_4ck1150 FIND v(dout1_4) AT=1160.05n

.meas tran vdout1_5ck1150 FIND v(dout1_5) AT=1160.05n

.meas tran vdout1_6ck1150 FIND v(dout1_6) AT=1160.05n

.meas tran vdout1_7ck1150 FIND v(dout1_7) AT=1160.05n

.meas tran vdout1_8ck1150 FIND v(dout1_8) AT=1160.05n

.meas tran vdout1_9ck1150 FIND v(dout1_9) AT=1160.05n

.meas tran vdout1_10ck1150 FIND v(dout1_10) AT=1160.05n

.meas tran vdout1_11ck1150 FIND v(dout1_11) AT=1160.05n

.meas tran vdout1_12ck1150 FIND v(dout1_12) AT=1160.05n

.meas tran vdout1_13ck1150 FIND v(dout1_13) AT=1160.05n

.meas tran vdout1_14ck1150 FIND v(dout1_14) AT=1160.05n

.meas tran vdout1_15ck1150 FIND v(dout1_15) AT=1160.05n

.meas tran vdout1_16ck1150 FIND v(dout1_16) AT=1160.05n

.meas tran vdout1_17ck1150 FIND v(dout1_17) AT=1160.05n

.meas tran vdout1_18ck1150 FIND v(dout1_18) AT=1160.05n

.meas tran vdout1_19ck1150 FIND v(dout1_19) AT=1160.05n

.meas tran vdout1_20ck1150 FIND v(dout1_20) AT=1160.05n

.meas tran vdout1_21ck1150 FIND v(dout1_21) AT=1160.05n

.meas tran vdout1_22ck1150 FIND v(dout1_22) AT=1160.05n

.meas tran vdout1_23ck1150 FIND v(dout1_23) AT=1160.05n

.meas tran vdout1_24ck1150 FIND v(dout1_24) AT=1160.05n

.meas tran vdout1_25ck1150 FIND v(dout1_25) AT=1160.05n

.meas tran vdout1_26ck1150 FIND v(dout1_26) AT=1160.05n

.meas tran vdout1_27ck1150 FIND v(dout1_27) AT=1160.05n

.meas tran vdout1_28ck1150 FIND v(dout1_28) AT=1160.05n

.meas tran vdout1_29ck1150 FIND v(dout1_29) AT=1160.05n

.meas tran vdout1_30ck1150 FIND v(dout1_30) AT=1160.05n

.meas tran vdout1_31ck1150 FIND v(dout1_31) AT=1160.05n

.meas tran vdout1_32ck1150 FIND v(dout1_32) AT=1160.05n

.meas tran vdout1_33ck1150 FIND v(dout1_33) AT=1160.05n

.meas tran vdout1_34ck1150 FIND v(dout1_34) AT=1160.05n

.meas tran vdout1_35ck1150 FIND v(dout1_35) AT=1160.05n

.meas tran vdout1_36ck1150 FIND v(dout1_36) AT=1160.05n

.meas tran vdout1_37ck1150 FIND v(dout1_37) AT=1160.05n

.meas tran vdout1_38ck1150 FIND v(dout1_38) AT=1160.05n

.meas tran vdout1_39ck1150 FIND v(dout1_39) AT=1160.05n

.meas tran vdout1_40ck1150 FIND v(dout1_40) AT=1160.05n

.meas tran vdout1_41ck1150 FIND v(dout1_41) AT=1160.05n

.meas tran vdout1_42ck1150 FIND v(dout1_42) AT=1160.05n

.meas tran vdout1_43ck1150 FIND v(dout1_43) AT=1160.05n

.meas tran vdout1_44ck1150 FIND v(dout1_44) AT=1160.05n

.meas tran vdout1_45ck1150 FIND v(dout1_45) AT=1160.05n

.meas tran vdout1_46ck1150 FIND v(dout1_46) AT=1160.05n

.meas tran vdout1_47ck1150 FIND v(dout1_47) AT=1160.05n

.meas tran vdout1_48ck1150 FIND v(dout1_48) AT=1160.05n

.meas tran vdout1_49ck1150 FIND v(dout1_49) AT=1160.05n

.meas tran vdout1_50ck1150 FIND v(dout1_50) AT=1160.05n

.meas tran vdout1_51ck1150 FIND v(dout1_51) AT=1160.05n

.meas tran vdout1_52ck1150 FIND v(dout1_52) AT=1160.05n

.meas tran vdout1_53ck1150 FIND v(dout1_53) AT=1160.05n

.meas tran vdout1_54ck1150 FIND v(dout1_54) AT=1160.05n

.meas tran vdout1_55ck1150 FIND v(dout1_55) AT=1160.05n

.meas tran vdout1_56ck1150 FIND v(dout1_56) AT=1160.05n

.meas tran vdout1_57ck1150 FIND v(dout1_57) AT=1160.05n

.meas tran vdout1_58ck1150 FIND v(dout1_58) AT=1160.05n

.meas tran vdout1_59ck1150 FIND v(dout1_59) AT=1160.05n

.meas tran vdout1_60ck1150 FIND v(dout1_60) AT=1160.05n

.meas tran vdout1_61ck1150 FIND v(dout1_61) AT=1160.05n

.meas tran vdout1_62ck1150 FIND v(dout1_62) AT=1160.05n

.meas tran vdout1_63ck1150 FIND v(dout1_63) AT=1160.05n

.meas tran vdout1_64ck1150 FIND v(dout1_64) AT=1160.05n

.meas tran vdout1_65ck1150 FIND v(dout1_65) AT=1160.05n

.meas tran vdout1_66ck1150 FIND v(dout1_66) AT=1160.05n

.meas tran vdout1_67ck1150 FIND v(dout1_67) AT=1160.05n

.meas tran vdout1_68ck1150 FIND v(dout1_68) AT=1160.05n

.meas tran vdout1_69ck1150 FIND v(dout1_69) AT=1160.05n

.meas tran vdout1_70ck1150 FIND v(dout1_70) AT=1160.05n

.meas tran vdout1_71ck1150 FIND v(dout1_71) AT=1160.05n

.meas tran vdout1_72ck1150 FIND v(dout1_72) AT=1160.05n

.meas tran vdout1_73ck1150 FIND v(dout1_73) AT=1160.05n

.meas tran vdout1_74ck1150 FIND v(dout1_74) AT=1160.05n

.meas tran vdout1_75ck1150 FIND v(dout1_75) AT=1160.05n

.meas tran vdout1_76ck1150 FIND v(dout1_76) AT=1160.05n

.meas tran vdout1_77ck1150 FIND v(dout1_77) AT=1160.05n

.meas tran vdout1_78ck1150 FIND v(dout1_78) AT=1160.05n

.meas tran vdout1_79ck1150 FIND v(dout1_79) AT=1160.05n

.meas tran vdout1_80ck1150 FIND v(dout1_80) AT=1160.05n

.meas tran vdout1_81ck1150 FIND v(dout1_81) AT=1160.05n

.meas tran vdout1_82ck1150 FIND v(dout1_82) AT=1160.05n

.meas tran vdout1_83ck1150 FIND v(dout1_83) AT=1160.05n

.meas tran vdout1_84ck1150 FIND v(dout1_84) AT=1160.05n

.meas tran vdout1_85ck1150 FIND v(dout1_85) AT=1160.05n

.meas tran vdout1_86ck1150 FIND v(dout1_86) AT=1160.05n

.meas tran vdout1_87ck1150 FIND v(dout1_87) AT=1160.05n

.meas tran vdout1_88ck1150 FIND v(dout1_88) AT=1160.05n

.meas tran vdout1_89ck1150 FIND v(dout1_89) AT=1160.05n

.meas tran vdout1_90ck1150 FIND v(dout1_90) AT=1160.05n

.meas tran vdout1_91ck1150 FIND v(dout1_91) AT=1160.05n

.meas tran vdout1_92ck1150 FIND v(dout1_92) AT=1160.05n

.meas tran vdout1_93ck1150 FIND v(dout1_93) AT=1160.05n

.meas tran vdout1_94ck1150 FIND v(dout1_94) AT=1160.05n

.meas tran vdout1_95ck1150 FIND v(dout1_95) AT=1160.05n

.meas tran vdout1_96ck1150 FIND v(dout1_96) AT=1160.05n

.meas tran vdout1_97ck1150 FIND v(dout1_97) AT=1160.05n

.meas tran vdout1_98ck1150 FIND v(dout1_98) AT=1160.05n

.meas tran vdout1_99ck1150 FIND v(dout1_99) AT=1160.05n

.meas tran vdout1_100ck1150 FIND v(dout1_100) AT=1160.05n

.meas tran vdout1_101ck1150 FIND v(dout1_101) AT=1160.05n

.meas tran vdout1_102ck1150 FIND v(dout1_102) AT=1160.05n

.meas tran vdout1_103ck1150 FIND v(dout1_103) AT=1160.05n

.meas tran vdout1_104ck1150 FIND v(dout1_104) AT=1160.05n

.meas tran vdout1_105ck1150 FIND v(dout1_105) AT=1160.05n

.meas tran vdout1_106ck1150 FIND v(dout1_106) AT=1160.05n

.meas tran vdout1_107ck1150 FIND v(dout1_107) AT=1160.05n

.meas tran vdout1_108ck1150 FIND v(dout1_108) AT=1160.05n

.meas tran vdout1_109ck1150 FIND v(dout1_109) AT=1160.05n

.meas tran vdout1_110ck1150 FIND v(dout1_110) AT=1160.05n

.meas tran vdout1_111ck1150 FIND v(dout1_111) AT=1160.05n

.meas tran vdout1_112ck1150 FIND v(dout1_112) AT=1160.05n

.meas tran vdout1_113ck1150 FIND v(dout1_113) AT=1160.05n

.meas tran vdout1_114ck1150 FIND v(dout1_114) AT=1160.05n

.meas tran vdout1_115ck1150 FIND v(dout1_115) AT=1160.05n

.meas tran vdout1_116ck1150 FIND v(dout1_116) AT=1160.05n

.meas tran vdout1_117ck1150 FIND v(dout1_117) AT=1160.05n

.meas tran vdout1_118ck1150 FIND v(dout1_118) AT=1160.05n

.meas tran vdout1_119ck1150 FIND v(dout1_119) AT=1160.05n

.meas tran vdout1_120ck1150 FIND v(dout1_120) AT=1160.05n

.meas tran vdout1_121ck1150 FIND v(dout1_121) AT=1160.05n

.meas tran vdout1_122ck1150 FIND v(dout1_122) AT=1160.05n

.meas tran vdout1_123ck1150 FIND v(dout1_123) AT=1160.05n

.meas tran vdout1_124ck1150 FIND v(dout1_124) AT=1160.05n

.meas tran vdout1_125ck1150 FIND v(dout1_125) AT=1160.05n

.meas tran vdout1_126ck1150 FIND v(dout1_126) AT=1160.05n

.meas tran vdout1_127ck1150 FIND v(dout1_127) AT=1160.05n

.meas tran vdout1_128ck1150 FIND v(dout1_128) AT=1160.05n

.meas tran vdout1_129ck1150 FIND v(dout1_129) AT=1160.05n

.meas tran vdout1_130ck1150 FIND v(dout1_130) AT=1160.05n

.meas tran vdout1_131ck1150 FIND v(dout1_131) AT=1160.05n

.meas tran vdout1_132ck1150 FIND v(dout1_132) AT=1160.05n

.meas tran vdout1_133ck1150 FIND v(dout1_133) AT=1160.05n

.meas tran vdout1_134ck1150 FIND v(dout1_134) AT=1160.05n

.meas tran vdout1_0ck1190 FIND v(dout1_0) AT=1200.05n

.meas tran vdout1_1ck1190 FIND v(dout1_1) AT=1200.05n

.meas tran vdout1_2ck1190 FIND v(dout1_2) AT=1200.05n

.meas tran vdout1_3ck1190 FIND v(dout1_3) AT=1200.05n

.meas tran vdout1_4ck1190 FIND v(dout1_4) AT=1200.05n

.meas tran vdout1_5ck1190 FIND v(dout1_5) AT=1200.05n

.meas tran vdout1_6ck1190 FIND v(dout1_6) AT=1200.05n

.meas tran vdout1_7ck1190 FIND v(dout1_7) AT=1200.05n

.meas tran vdout1_8ck1190 FIND v(dout1_8) AT=1200.05n

.meas tran vdout1_9ck1190 FIND v(dout1_9) AT=1200.05n

.meas tran vdout1_10ck1190 FIND v(dout1_10) AT=1200.05n

.meas tran vdout1_11ck1190 FIND v(dout1_11) AT=1200.05n

.meas tran vdout1_12ck1190 FIND v(dout1_12) AT=1200.05n

.meas tran vdout1_13ck1190 FIND v(dout1_13) AT=1200.05n

.meas tran vdout1_14ck1190 FIND v(dout1_14) AT=1200.05n

.meas tran vdout1_15ck1190 FIND v(dout1_15) AT=1200.05n

.meas tran vdout1_16ck1190 FIND v(dout1_16) AT=1200.05n

.meas tran vdout1_17ck1190 FIND v(dout1_17) AT=1200.05n

.meas tran vdout1_18ck1190 FIND v(dout1_18) AT=1200.05n

.meas tran vdout1_19ck1190 FIND v(dout1_19) AT=1200.05n

.meas tran vdout1_20ck1190 FIND v(dout1_20) AT=1200.05n

.meas tran vdout1_21ck1190 FIND v(dout1_21) AT=1200.05n

.meas tran vdout1_22ck1190 FIND v(dout1_22) AT=1200.05n

.meas tran vdout1_23ck1190 FIND v(dout1_23) AT=1200.05n

.meas tran vdout1_24ck1190 FIND v(dout1_24) AT=1200.05n

.meas tran vdout1_25ck1190 FIND v(dout1_25) AT=1200.05n

.meas tran vdout1_26ck1190 FIND v(dout1_26) AT=1200.05n

.meas tran vdout1_27ck1190 FIND v(dout1_27) AT=1200.05n

.meas tran vdout1_28ck1190 FIND v(dout1_28) AT=1200.05n

.meas tran vdout1_29ck1190 FIND v(dout1_29) AT=1200.05n

.meas tran vdout1_30ck1190 FIND v(dout1_30) AT=1200.05n

.meas tran vdout1_31ck1190 FIND v(dout1_31) AT=1200.05n

.meas tran vdout1_32ck1190 FIND v(dout1_32) AT=1200.05n

.meas tran vdout1_33ck1190 FIND v(dout1_33) AT=1200.05n

.meas tran vdout1_34ck1190 FIND v(dout1_34) AT=1200.05n

.meas tran vdout1_35ck1190 FIND v(dout1_35) AT=1200.05n

.meas tran vdout1_36ck1190 FIND v(dout1_36) AT=1200.05n

.meas tran vdout1_37ck1190 FIND v(dout1_37) AT=1200.05n

.meas tran vdout1_38ck1190 FIND v(dout1_38) AT=1200.05n

.meas tran vdout1_39ck1190 FIND v(dout1_39) AT=1200.05n

.meas tran vdout1_40ck1190 FIND v(dout1_40) AT=1200.05n

.meas tran vdout1_41ck1190 FIND v(dout1_41) AT=1200.05n

.meas tran vdout1_42ck1190 FIND v(dout1_42) AT=1200.05n

.meas tran vdout1_43ck1190 FIND v(dout1_43) AT=1200.05n

.meas tran vdout1_44ck1190 FIND v(dout1_44) AT=1200.05n

.meas tran vdout1_45ck1190 FIND v(dout1_45) AT=1200.05n

.meas tran vdout1_46ck1190 FIND v(dout1_46) AT=1200.05n

.meas tran vdout1_47ck1190 FIND v(dout1_47) AT=1200.05n

.meas tran vdout1_48ck1190 FIND v(dout1_48) AT=1200.05n

.meas tran vdout1_49ck1190 FIND v(dout1_49) AT=1200.05n

.meas tran vdout1_50ck1190 FIND v(dout1_50) AT=1200.05n

.meas tran vdout1_51ck1190 FIND v(dout1_51) AT=1200.05n

.meas tran vdout1_52ck1190 FIND v(dout1_52) AT=1200.05n

.meas tran vdout1_53ck1190 FIND v(dout1_53) AT=1200.05n

.meas tran vdout1_54ck1190 FIND v(dout1_54) AT=1200.05n

.meas tran vdout1_55ck1190 FIND v(dout1_55) AT=1200.05n

.meas tran vdout1_56ck1190 FIND v(dout1_56) AT=1200.05n

.meas tran vdout1_57ck1190 FIND v(dout1_57) AT=1200.05n

.meas tran vdout1_58ck1190 FIND v(dout1_58) AT=1200.05n

.meas tran vdout1_59ck1190 FIND v(dout1_59) AT=1200.05n

.meas tran vdout1_60ck1190 FIND v(dout1_60) AT=1200.05n

.meas tran vdout1_61ck1190 FIND v(dout1_61) AT=1200.05n

.meas tran vdout1_62ck1190 FIND v(dout1_62) AT=1200.05n

.meas tran vdout1_63ck1190 FIND v(dout1_63) AT=1200.05n

.meas tran vdout1_64ck1190 FIND v(dout1_64) AT=1200.05n

.meas tran vdout1_65ck1190 FIND v(dout1_65) AT=1200.05n

.meas tran vdout1_66ck1190 FIND v(dout1_66) AT=1200.05n

.meas tran vdout1_67ck1190 FIND v(dout1_67) AT=1200.05n

.meas tran vdout1_68ck1190 FIND v(dout1_68) AT=1200.05n

.meas tran vdout1_69ck1190 FIND v(dout1_69) AT=1200.05n

.meas tran vdout1_70ck1190 FIND v(dout1_70) AT=1200.05n

.meas tran vdout1_71ck1190 FIND v(dout1_71) AT=1200.05n

.meas tran vdout1_72ck1190 FIND v(dout1_72) AT=1200.05n

.meas tran vdout1_73ck1190 FIND v(dout1_73) AT=1200.05n

.meas tran vdout1_74ck1190 FIND v(dout1_74) AT=1200.05n

.meas tran vdout1_75ck1190 FIND v(dout1_75) AT=1200.05n

.meas tran vdout1_76ck1190 FIND v(dout1_76) AT=1200.05n

.meas tran vdout1_77ck1190 FIND v(dout1_77) AT=1200.05n

.meas tran vdout1_78ck1190 FIND v(dout1_78) AT=1200.05n

.meas tran vdout1_79ck1190 FIND v(dout1_79) AT=1200.05n

.meas tran vdout1_80ck1190 FIND v(dout1_80) AT=1200.05n

.meas tran vdout1_81ck1190 FIND v(dout1_81) AT=1200.05n

.meas tran vdout1_82ck1190 FIND v(dout1_82) AT=1200.05n

.meas tran vdout1_83ck1190 FIND v(dout1_83) AT=1200.05n

.meas tran vdout1_84ck1190 FIND v(dout1_84) AT=1200.05n

.meas tran vdout1_85ck1190 FIND v(dout1_85) AT=1200.05n

.meas tran vdout1_86ck1190 FIND v(dout1_86) AT=1200.05n

.meas tran vdout1_87ck1190 FIND v(dout1_87) AT=1200.05n

.meas tran vdout1_88ck1190 FIND v(dout1_88) AT=1200.05n

.meas tran vdout1_89ck1190 FIND v(dout1_89) AT=1200.05n

.meas tran vdout1_90ck1190 FIND v(dout1_90) AT=1200.05n

.meas tran vdout1_91ck1190 FIND v(dout1_91) AT=1200.05n

.meas tran vdout1_92ck1190 FIND v(dout1_92) AT=1200.05n

.meas tran vdout1_93ck1190 FIND v(dout1_93) AT=1200.05n

.meas tran vdout1_94ck1190 FIND v(dout1_94) AT=1200.05n

.meas tran vdout1_95ck1190 FIND v(dout1_95) AT=1200.05n

.meas tran vdout1_96ck1190 FIND v(dout1_96) AT=1200.05n

.meas tran vdout1_97ck1190 FIND v(dout1_97) AT=1200.05n

.meas tran vdout1_98ck1190 FIND v(dout1_98) AT=1200.05n

.meas tran vdout1_99ck1190 FIND v(dout1_99) AT=1200.05n

.meas tran vdout1_100ck1190 FIND v(dout1_100) AT=1200.05n

.meas tran vdout1_101ck1190 FIND v(dout1_101) AT=1200.05n

.meas tran vdout1_102ck1190 FIND v(dout1_102) AT=1200.05n

.meas tran vdout1_103ck1190 FIND v(dout1_103) AT=1200.05n

.meas tran vdout1_104ck1190 FIND v(dout1_104) AT=1200.05n

.meas tran vdout1_105ck1190 FIND v(dout1_105) AT=1200.05n

.meas tran vdout1_106ck1190 FIND v(dout1_106) AT=1200.05n

.meas tran vdout1_107ck1190 FIND v(dout1_107) AT=1200.05n

.meas tran vdout1_108ck1190 FIND v(dout1_108) AT=1200.05n

.meas tran vdout1_109ck1190 FIND v(dout1_109) AT=1200.05n

.meas tran vdout1_110ck1190 FIND v(dout1_110) AT=1200.05n

.meas tran vdout1_111ck1190 FIND v(dout1_111) AT=1200.05n

.meas tran vdout1_112ck1190 FIND v(dout1_112) AT=1200.05n

.meas tran vdout1_113ck1190 FIND v(dout1_113) AT=1200.05n

.meas tran vdout1_114ck1190 FIND v(dout1_114) AT=1200.05n

.meas tran vdout1_115ck1190 FIND v(dout1_115) AT=1200.05n

.meas tran vdout1_116ck1190 FIND v(dout1_116) AT=1200.05n

.meas tran vdout1_117ck1190 FIND v(dout1_117) AT=1200.05n

.meas tran vdout1_118ck1190 FIND v(dout1_118) AT=1200.05n

.meas tran vdout1_119ck1190 FIND v(dout1_119) AT=1200.05n

.meas tran vdout1_120ck1190 FIND v(dout1_120) AT=1200.05n

.meas tran vdout1_121ck1190 FIND v(dout1_121) AT=1200.05n

.meas tran vdout1_122ck1190 FIND v(dout1_122) AT=1200.05n

.meas tran vdout1_123ck1190 FIND v(dout1_123) AT=1200.05n

.meas tran vdout1_124ck1190 FIND v(dout1_124) AT=1200.05n

.meas tran vdout1_125ck1190 FIND v(dout1_125) AT=1200.05n

.meas tran vdout1_126ck1190 FIND v(dout1_126) AT=1200.05n

.meas tran vdout1_127ck1190 FIND v(dout1_127) AT=1200.05n

.meas tran vdout1_128ck1190 FIND v(dout1_128) AT=1200.05n

.meas tran vdout1_129ck1190 FIND v(dout1_129) AT=1200.05n

.meas tran vdout1_130ck1190 FIND v(dout1_130) AT=1200.05n

.meas tran vdout1_131ck1190 FIND v(dout1_131) AT=1200.05n

.meas tran vdout1_132ck1190 FIND v(dout1_132) AT=1200.05n

.meas tran vdout1_133ck1190 FIND v(dout1_133) AT=1200.05n

.meas tran vdout1_134ck1190 FIND v(dout1_134) AT=1200.05n

.meas tran vdout1_0ck1220 FIND v(dout1_0) AT=1230.05n

.meas tran vdout1_1ck1220 FIND v(dout1_1) AT=1230.05n

.meas tran vdout1_2ck1220 FIND v(dout1_2) AT=1230.05n

.meas tran vdout1_3ck1220 FIND v(dout1_3) AT=1230.05n

.meas tran vdout1_4ck1220 FIND v(dout1_4) AT=1230.05n

.meas tran vdout1_5ck1220 FIND v(dout1_5) AT=1230.05n

.meas tran vdout1_6ck1220 FIND v(dout1_6) AT=1230.05n

.meas tran vdout1_7ck1220 FIND v(dout1_7) AT=1230.05n

.meas tran vdout1_8ck1220 FIND v(dout1_8) AT=1230.05n

.meas tran vdout1_9ck1220 FIND v(dout1_9) AT=1230.05n

.meas tran vdout1_10ck1220 FIND v(dout1_10) AT=1230.05n

.meas tran vdout1_11ck1220 FIND v(dout1_11) AT=1230.05n

.meas tran vdout1_12ck1220 FIND v(dout1_12) AT=1230.05n

.meas tran vdout1_13ck1220 FIND v(dout1_13) AT=1230.05n

.meas tran vdout1_14ck1220 FIND v(dout1_14) AT=1230.05n

.meas tran vdout1_15ck1220 FIND v(dout1_15) AT=1230.05n

.meas tran vdout1_16ck1220 FIND v(dout1_16) AT=1230.05n

.meas tran vdout1_17ck1220 FIND v(dout1_17) AT=1230.05n

.meas tran vdout1_18ck1220 FIND v(dout1_18) AT=1230.05n

.meas tran vdout1_19ck1220 FIND v(dout1_19) AT=1230.05n

.meas tran vdout1_20ck1220 FIND v(dout1_20) AT=1230.05n

.meas tran vdout1_21ck1220 FIND v(dout1_21) AT=1230.05n

.meas tran vdout1_22ck1220 FIND v(dout1_22) AT=1230.05n

.meas tran vdout1_23ck1220 FIND v(dout1_23) AT=1230.05n

.meas tran vdout1_24ck1220 FIND v(dout1_24) AT=1230.05n

.meas tran vdout1_25ck1220 FIND v(dout1_25) AT=1230.05n

.meas tran vdout1_26ck1220 FIND v(dout1_26) AT=1230.05n

.meas tran vdout1_27ck1220 FIND v(dout1_27) AT=1230.05n

.meas tran vdout1_28ck1220 FIND v(dout1_28) AT=1230.05n

.meas tran vdout1_29ck1220 FIND v(dout1_29) AT=1230.05n

.meas tran vdout1_30ck1220 FIND v(dout1_30) AT=1230.05n

.meas tran vdout1_31ck1220 FIND v(dout1_31) AT=1230.05n

.meas tran vdout1_32ck1220 FIND v(dout1_32) AT=1230.05n

.meas tran vdout1_33ck1220 FIND v(dout1_33) AT=1230.05n

.meas tran vdout1_34ck1220 FIND v(dout1_34) AT=1230.05n

.meas tran vdout1_35ck1220 FIND v(dout1_35) AT=1230.05n

.meas tran vdout1_36ck1220 FIND v(dout1_36) AT=1230.05n

.meas tran vdout1_37ck1220 FIND v(dout1_37) AT=1230.05n

.meas tran vdout1_38ck1220 FIND v(dout1_38) AT=1230.05n

.meas tran vdout1_39ck1220 FIND v(dout1_39) AT=1230.05n

.meas tran vdout1_40ck1220 FIND v(dout1_40) AT=1230.05n

.meas tran vdout1_41ck1220 FIND v(dout1_41) AT=1230.05n

.meas tran vdout1_42ck1220 FIND v(dout1_42) AT=1230.05n

.meas tran vdout1_43ck1220 FIND v(dout1_43) AT=1230.05n

.meas tran vdout1_44ck1220 FIND v(dout1_44) AT=1230.05n

.meas tran vdout1_45ck1220 FIND v(dout1_45) AT=1230.05n

.meas tran vdout1_46ck1220 FIND v(dout1_46) AT=1230.05n

.meas tran vdout1_47ck1220 FIND v(dout1_47) AT=1230.05n

.meas tran vdout1_48ck1220 FIND v(dout1_48) AT=1230.05n

.meas tran vdout1_49ck1220 FIND v(dout1_49) AT=1230.05n

.meas tran vdout1_50ck1220 FIND v(dout1_50) AT=1230.05n

.meas tran vdout1_51ck1220 FIND v(dout1_51) AT=1230.05n

.meas tran vdout1_52ck1220 FIND v(dout1_52) AT=1230.05n

.meas tran vdout1_53ck1220 FIND v(dout1_53) AT=1230.05n

.meas tran vdout1_54ck1220 FIND v(dout1_54) AT=1230.05n

.meas tran vdout1_55ck1220 FIND v(dout1_55) AT=1230.05n

.meas tran vdout1_56ck1220 FIND v(dout1_56) AT=1230.05n

.meas tran vdout1_57ck1220 FIND v(dout1_57) AT=1230.05n

.meas tran vdout1_58ck1220 FIND v(dout1_58) AT=1230.05n

.meas tran vdout1_59ck1220 FIND v(dout1_59) AT=1230.05n

.meas tran vdout1_60ck1220 FIND v(dout1_60) AT=1230.05n

.meas tran vdout1_61ck1220 FIND v(dout1_61) AT=1230.05n

.meas tran vdout1_62ck1220 FIND v(dout1_62) AT=1230.05n

.meas tran vdout1_63ck1220 FIND v(dout1_63) AT=1230.05n

.meas tran vdout1_64ck1220 FIND v(dout1_64) AT=1230.05n

.meas tran vdout1_65ck1220 FIND v(dout1_65) AT=1230.05n

.meas tran vdout1_66ck1220 FIND v(dout1_66) AT=1230.05n

.meas tran vdout1_67ck1220 FIND v(dout1_67) AT=1230.05n

.meas tran vdout1_68ck1220 FIND v(dout1_68) AT=1230.05n

.meas tran vdout1_69ck1220 FIND v(dout1_69) AT=1230.05n

.meas tran vdout1_70ck1220 FIND v(dout1_70) AT=1230.05n

.meas tran vdout1_71ck1220 FIND v(dout1_71) AT=1230.05n

.meas tran vdout1_72ck1220 FIND v(dout1_72) AT=1230.05n

.meas tran vdout1_73ck1220 FIND v(dout1_73) AT=1230.05n

.meas tran vdout1_74ck1220 FIND v(dout1_74) AT=1230.05n

.meas tran vdout1_75ck1220 FIND v(dout1_75) AT=1230.05n

.meas tran vdout1_76ck1220 FIND v(dout1_76) AT=1230.05n

.meas tran vdout1_77ck1220 FIND v(dout1_77) AT=1230.05n

.meas tran vdout1_78ck1220 FIND v(dout1_78) AT=1230.05n

.meas tran vdout1_79ck1220 FIND v(dout1_79) AT=1230.05n

.meas tran vdout1_80ck1220 FIND v(dout1_80) AT=1230.05n

.meas tran vdout1_81ck1220 FIND v(dout1_81) AT=1230.05n

.meas tran vdout1_82ck1220 FIND v(dout1_82) AT=1230.05n

.meas tran vdout1_83ck1220 FIND v(dout1_83) AT=1230.05n

.meas tran vdout1_84ck1220 FIND v(dout1_84) AT=1230.05n

.meas tran vdout1_85ck1220 FIND v(dout1_85) AT=1230.05n

.meas tran vdout1_86ck1220 FIND v(dout1_86) AT=1230.05n

.meas tran vdout1_87ck1220 FIND v(dout1_87) AT=1230.05n

.meas tran vdout1_88ck1220 FIND v(dout1_88) AT=1230.05n

.meas tran vdout1_89ck1220 FIND v(dout1_89) AT=1230.05n

.meas tran vdout1_90ck1220 FIND v(dout1_90) AT=1230.05n

.meas tran vdout1_91ck1220 FIND v(dout1_91) AT=1230.05n

.meas tran vdout1_92ck1220 FIND v(dout1_92) AT=1230.05n

.meas tran vdout1_93ck1220 FIND v(dout1_93) AT=1230.05n

.meas tran vdout1_94ck1220 FIND v(dout1_94) AT=1230.05n

.meas tran vdout1_95ck1220 FIND v(dout1_95) AT=1230.05n

.meas tran vdout1_96ck1220 FIND v(dout1_96) AT=1230.05n

.meas tran vdout1_97ck1220 FIND v(dout1_97) AT=1230.05n

.meas tran vdout1_98ck1220 FIND v(dout1_98) AT=1230.05n

.meas tran vdout1_99ck1220 FIND v(dout1_99) AT=1230.05n

.meas tran vdout1_100ck1220 FIND v(dout1_100) AT=1230.05n

.meas tran vdout1_101ck1220 FIND v(dout1_101) AT=1230.05n

.meas tran vdout1_102ck1220 FIND v(dout1_102) AT=1230.05n

.meas tran vdout1_103ck1220 FIND v(dout1_103) AT=1230.05n

.meas tran vdout1_104ck1220 FIND v(dout1_104) AT=1230.05n

.meas tran vdout1_105ck1220 FIND v(dout1_105) AT=1230.05n

.meas tran vdout1_106ck1220 FIND v(dout1_106) AT=1230.05n

.meas tran vdout1_107ck1220 FIND v(dout1_107) AT=1230.05n

.meas tran vdout1_108ck1220 FIND v(dout1_108) AT=1230.05n

.meas tran vdout1_109ck1220 FIND v(dout1_109) AT=1230.05n

.meas tran vdout1_110ck1220 FIND v(dout1_110) AT=1230.05n

.meas tran vdout1_111ck1220 FIND v(dout1_111) AT=1230.05n

.meas tran vdout1_112ck1220 FIND v(dout1_112) AT=1230.05n

.meas tran vdout1_113ck1220 FIND v(dout1_113) AT=1230.05n

.meas tran vdout1_114ck1220 FIND v(dout1_114) AT=1230.05n

.meas tran vdout1_115ck1220 FIND v(dout1_115) AT=1230.05n

.meas tran vdout1_116ck1220 FIND v(dout1_116) AT=1230.05n

.meas tran vdout1_117ck1220 FIND v(dout1_117) AT=1230.05n

.meas tran vdout1_118ck1220 FIND v(dout1_118) AT=1230.05n

.meas tran vdout1_119ck1220 FIND v(dout1_119) AT=1230.05n

.meas tran vdout1_120ck1220 FIND v(dout1_120) AT=1230.05n

.meas tran vdout1_121ck1220 FIND v(dout1_121) AT=1230.05n

.meas tran vdout1_122ck1220 FIND v(dout1_122) AT=1230.05n

.meas tran vdout1_123ck1220 FIND v(dout1_123) AT=1230.05n

.meas tran vdout1_124ck1220 FIND v(dout1_124) AT=1230.05n

.meas tran vdout1_125ck1220 FIND v(dout1_125) AT=1230.05n

.meas tran vdout1_126ck1220 FIND v(dout1_126) AT=1230.05n

.meas tran vdout1_127ck1220 FIND v(dout1_127) AT=1230.05n

.meas tran vdout1_128ck1220 FIND v(dout1_128) AT=1230.05n

.meas tran vdout1_129ck1220 FIND v(dout1_129) AT=1230.05n

.meas tran vdout1_130ck1220 FIND v(dout1_130) AT=1230.05n

.meas tran vdout1_131ck1220 FIND v(dout1_131) AT=1230.05n

.meas tran vdout1_132ck1220 FIND v(dout1_132) AT=1230.05n

.meas tran vdout1_133ck1220 FIND v(dout1_133) AT=1230.05n

.meas tran vdout1_134ck1220 FIND v(dout1_134) AT=1230.05n

.meas tran vdout1_0ck1240 FIND v(dout1_0) AT=1250.05n

.meas tran vdout1_1ck1240 FIND v(dout1_1) AT=1250.05n

.meas tran vdout1_2ck1240 FIND v(dout1_2) AT=1250.05n

.meas tran vdout1_3ck1240 FIND v(dout1_3) AT=1250.05n

.meas tran vdout1_4ck1240 FIND v(dout1_4) AT=1250.05n

.meas tran vdout1_5ck1240 FIND v(dout1_5) AT=1250.05n

.meas tran vdout1_6ck1240 FIND v(dout1_6) AT=1250.05n

.meas tran vdout1_7ck1240 FIND v(dout1_7) AT=1250.05n

.meas tran vdout1_8ck1240 FIND v(dout1_8) AT=1250.05n

.meas tran vdout1_9ck1240 FIND v(dout1_9) AT=1250.05n

.meas tran vdout1_10ck1240 FIND v(dout1_10) AT=1250.05n

.meas tran vdout1_11ck1240 FIND v(dout1_11) AT=1250.05n

.meas tran vdout1_12ck1240 FIND v(dout1_12) AT=1250.05n

.meas tran vdout1_13ck1240 FIND v(dout1_13) AT=1250.05n

.meas tran vdout1_14ck1240 FIND v(dout1_14) AT=1250.05n

.meas tran vdout1_15ck1240 FIND v(dout1_15) AT=1250.05n

.meas tran vdout1_16ck1240 FIND v(dout1_16) AT=1250.05n

.meas tran vdout1_17ck1240 FIND v(dout1_17) AT=1250.05n

.meas tran vdout1_18ck1240 FIND v(dout1_18) AT=1250.05n

.meas tran vdout1_19ck1240 FIND v(dout1_19) AT=1250.05n

.meas tran vdout1_20ck1240 FIND v(dout1_20) AT=1250.05n

.meas tran vdout1_21ck1240 FIND v(dout1_21) AT=1250.05n

.meas tran vdout1_22ck1240 FIND v(dout1_22) AT=1250.05n

.meas tran vdout1_23ck1240 FIND v(dout1_23) AT=1250.05n

.meas tran vdout1_24ck1240 FIND v(dout1_24) AT=1250.05n

.meas tran vdout1_25ck1240 FIND v(dout1_25) AT=1250.05n

.meas tran vdout1_26ck1240 FIND v(dout1_26) AT=1250.05n

.meas tran vdout1_27ck1240 FIND v(dout1_27) AT=1250.05n

.meas tran vdout1_28ck1240 FIND v(dout1_28) AT=1250.05n

.meas tran vdout1_29ck1240 FIND v(dout1_29) AT=1250.05n

.meas tran vdout1_30ck1240 FIND v(dout1_30) AT=1250.05n

.meas tran vdout1_31ck1240 FIND v(dout1_31) AT=1250.05n

.meas tran vdout1_32ck1240 FIND v(dout1_32) AT=1250.05n

.meas tran vdout1_33ck1240 FIND v(dout1_33) AT=1250.05n

.meas tran vdout1_34ck1240 FIND v(dout1_34) AT=1250.05n

.meas tran vdout1_35ck1240 FIND v(dout1_35) AT=1250.05n

.meas tran vdout1_36ck1240 FIND v(dout1_36) AT=1250.05n

.meas tran vdout1_37ck1240 FIND v(dout1_37) AT=1250.05n

.meas tran vdout1_38ck1240 FIND v(dout1_38) AT=1250.05n

.meas tran vdout1_39ck1240 FIND v(dout1_39) AT=1250.05n

.meas tran vdout1_40ck1240 FIND v(dout1_40) AT=1250.05n

.meas tran vdout1_41ck1240 FIND v(dout1_41) AT=1250.05n

.meas tran vdout1_42ck1240 FIND v(dout1_42) AT=1250.05n

.meas tran vdout1_43ck1240 FIND v(dout1_43) AT=1250.05n

.meas tran vdout1_44ck1240 FIND v(dout1_44) AT=1250.05n

.meas tran vdout1_45ck1240 FIND v(dout1_45) AT=1250.05n

.meas tran vdout1_46ck1240 FIND v(dout1_46) AT=1250.05n

.meas tran vdout1_47ck1240 FIND v(dout1_47) AT=1250.05n

.meas tran vdout1_48ck1240 FIND v(dout1_48) AT=1250.05n

.meas tran vdout1_49ck1240 FIND v(dout1_49) AT=1250.05n

.meas tran vdout1_50ck1240 FIND v(dout1_50) AT=1250.05n

.meas tran vdout1_51ck1240 FIND v(dout1_51) AT=1250.05n

.meas tran vdout1_52ck1240 FIND v(dout1_52) AT=1250.05n

.meas tran vdout1_53ck1240 FIND v(dout1_53) AT=1250.05n

.meas tran vdout1_54ck1240 FIND v(dout1_54) AT=1250.05n

.meas tran vdout1_55ck1240 FIND v(dout1_55) AT=1250.05n

.meas tran vdout1_56ck1240 FIND v(dout1_56) AT=1250.05n

.meas tran vdout1_57ck1240 FIND v(dout1_57) AT=1250.05n

.meas tran vdout1_58ck1240 FIND v(dout1_58) AT=1250.05n

.meas tran vdout1_59ck1240 FIND v(dout1_59) AT=1250.05n

.meas tran vdout1_60ck1240 FIND v(dout1_60) AT=1250.05n

.meas tran vdout1_61ck1240 FIND v(dout1_61) AT=1250.05n

.meas tran vdout1_62ck1240 FIND v(dout1_62) AT=1250.05n

.meas tran vdout1_63ck1240 FIND v(dout1_63) AT=1250.05n

.meas tran vdout1_64ck1240 FIND v(dout1_64) AT=1250.05n

.meas tran vdout1_65ck1240 FIND v(dout1_65) AT=1250.05n

.meas tran vdout1_66ck1240 FIND v(dout1_66) AT=1250.05n

.meas tran vdout1_67ck1240 FIND v(dout1_67) AT=1250.05n

.meas tran vdout1_68ck1240 FIND v(dout1_68) AT=1250.05n

.meas tran vdout1_69ck1240 FIND v(dout1_69) AT=1250.05n

.meas tran vdout1_70ck1240 FIND v(dout1_70) AT=1250.05n

.meas tran vdout1_71ck1240 FIND v(dout1_71) AT=1250.05n

.meas tran vdout1_72ck1240 FIND v(dout1_72) AT=1250.05n

.meas tran vdout1_73ck1240 FIND v(dout1_73) AT=1250.05n

.meas tran vdout1_74ck1240 FIND v(dout1_74) AT=1250.05n

.meas tran vdout1_75ck1240 FIND v(dout1_75) AT=1250.05n

.meas tran vdout1_76ck1240 FIND v(dout1_76) AT=1250.05n

.meas tran vdout1_77ck1240 FIND v(dout1_77) AT=1250.05n

.meas tran vdout1_78ck1240 FIND v(dout1_78) AT=1250.05n

.meas tran vdout1_79ck1240 FIND v(dout1_79) AT=1250.05n

.meas tran vdout1_80ck1240 FIND v(dout1_80) AT=1250.05n

.meas tran vdout1_81ck1240 FIND v(dout1_81) AT=1250.05n

.meas tran vdout1_82ck1240 FIND v(dout1_82) AT=1250.05n

.meas tran vdout1_83ck1240 FIND v(dout1_83) AT=1250.05n

.meas tran vdout1_84ck1240 FIND v(dout1_84) AT=1250.05n

.meas tran vdout1_85ck1240 FIND v(dout1_85) AT=1250.05n

.meas tran vdout1_86ck1240 FIND v(dout1_86) AT=1250.05n

.meas tran vdout1_87ck1240 FIND v(dout1_87) AT=1250.05n

.meas tran vdout1_88ck1240 FIND v(dout1_88) AT=1250.05n

.meas tran vdout1_89ck1240 FIND v(dout1_89) AT=1250.05n

.meas tran vdout1_90ck1240 FIND v(dout1_90) AT=1250.05n

.meas tran vdout1_91ck1240 FIND v(dout1_91) AT=1250.05n

.meas tran vdout1_92ck1240 FIND v(dout1_92) AT=1250.05n

.meas tran vdout1_93ck1240 FIND v(dout1_93) AT=1250.05n

.meas tran vdout1_94ck1240 FIND v(dout1_94) AT=1250.05n

.meas tran vdout1_95ck1240 FIND v(dout1_95) AT=1250.05n

.meas tran vdout1_96ck1240 FIND v(dout1_96) AT=1250.05n

.meas tran vdout1_97ck1240 FIND v(dout1_97) AT=1250.05n

.meas tran vdout1_98ck1240 FIND v(dout1_98) AT=1250.05n

.meas tran vdout1_99ck1240 FIND v(dout1_99) AT=1250.05n

.meas tran vdout1_100ck1240 FIND v(dout1_100) AT=1250.05n

.meas tran vdout1_101ck1240 FIND v(dout1_101) AT=1250.05n

.meas tran vdout1_102ck1240 FIND v(dout1_102) AT=1250.05n

.meas tran vdout1_103ck1240 FIND v(dout1_103) AT=1250.05n

.meas tran vdout1_104ck1240 FIND v(dout1_104) AT=1250.05n

.meas tran vdout1_105ck1240 FIND v(dout1_105) AT=1250.05n

.meas tran vdout1_106ck1240 FIND v(dout1_106) AT=1250.05n

.meas tran vdout1_107ck1240 FIND v(dout1_107) AT=1250.05n

.meas tran vdout1_108ck1240 FIND v(dout1_108) AT=1250.05n

.meas tran vdout1_109ck1240 FIND v(dout1_109) AT=1250.05n

.meas tran vdout1_110ck1240 FIND v(dout1_110) AT=1250.05n

.meas tran vdout1_111ck1240 FIND v(dout1_111) AT=1250.05n

.meas tran vdout1_112ck1240 FIND v(dout1_112) AT=1250.05n

.meas tran vdout1_113ck1240 FIND v(dout1_113) AT=1250.05n

.meas tran vdout1_114ck1240 FIND v(dout1_114) AT=1250.05n

.meas tran vdout1_115ck1240 FIND v(dout1_115) AT=1250.05n

.meas tran vdout1_116ck1240 FIND v(dout1_116) AT=1250.05n

.meas tran vdout1_117ck1240 FIND v(dout1_117) AT=1250.05n

.meas tran vdout1_118ck1240 FIND v(dout1_118) AT=1250.05n

.meas tran vdout1_119ck1240 FIND v(dout1_119) AT=1250.05n

.meas tran vdout1_120ck1240 FIND v(dout1_120) AT=1250.05n

.meas tran vdout1_121ck1240 FIND v(dout1_121) AT=1250.05n

.meas tran vdout1_122ck1240 FIND v(dout1_122) AT=1250.05n

.meas tran vdout1_123ck1240 FIND v(dout1_123) AT=1250.05n

.meas tran vdout1_124ck1240 FIND v(dout1_124) AT=1250.05n

.meas tran vdout1_125ck1240 FIND v(dout1_125) AT=1250.05n

.meas tran vdout1_126ck1240 FIND v(dout1_126) AT=1250.05n

.meas tran vdout1_127ck1240 FIND v(dout1_127) AT=1250.05n

.meas tran vdout1_128ck1240 FIND v(dout1_128) AT=1250.05n

.meas tran vdout1_129ck1240 FIND v(dout1_129) AT=1250.05n

.meas tran vdout1_130ck1240 FIND v(dout1_130) AT=1250.05n

.meas tran vdout1_131ck1240 FIND v(dout1_131) AT=1250.05n

.meas tran vdout1_132ck1240 FIND v(dout1_132) AT=1250.05n

.meas tran vdout1_133ck1240 FIND v(dout1_133) AT=1250.05n

.meas tran vdout1_134ck1240 FIND v(dout1_134) AT=1250.05n

.meas tran vdout1_0ck1250 FIND v(dout1_0) AT=1260.05n

.meas tran vdout1_1ck1250 FIND v(dout1_1) AT=1260.05n

.meas tran vdout1_2ck1250 FIND v(dout1_2) AT=1260.05n

.meas tran vdout1_3ck1250 FIND v(dout1_3) AT=1260.05n

.meas tran vdout1_4ck1250 FIND v(dout1_4) AT=1260.05n

.meas tran vdout1_5ck1250 FIND v(dout1_5) AT=1260.05n

.meas tran vdout1_6ck1250 FIND v(dout1_6) AT=1260.05n

.meas tran vdout1_7ck1250 FIND v(dout1_7) AT=1260.05n

.meas tran vdout1_8ck1250 FIND v(dout1_8) AT=1260.05n

.meas tran vdout1_9ck1250 FIND v(dout1_9) AT=1260.05n

.meas tran vdout1_10ck1250 FIND v(dout1_10) AT=1260.05n

.meas tran vdout1_11ck1250 FIND v(dout1_11) AT=1260.05n

.meas tran vdout1_12ck1250 FIND v(dout1_12) AT=1260.05n

.meas tran vdout1_13ck1250 FIND v(dout1_13) AT=1260.05n

.meas tran vdout1_14ck1250 FIND v(dout1_14) AT=1260.05n

.meas tran vdout1_15ck1250 FIND v(dout1_15) AT=1260.05n

.meas tran vdout1_16ck1250 FIND v(dout1_16) AT=1260.05n

.meas tran vdout1_17ck1250 FIND v(dout1_17) AT=1260.05n

.meas tran vdout1_18ck1250 FIND v(dout1_18) AT=1260.05n

.meas tran vdout1_19ck1250 FIND v(dout1_19) AT=1260.05n

.meas tran vdout1_20ck1250 FIND v(dout1_20) AT=1260.05n

.meas tran vdout1_21ck1250 FIND v(dout1_21) AT=1260.05n

.meas tran vdout1_22ck1250 FIND v(dout1_22) AT=1260.05n

.meas tran vdout1_23ck1250 FIND v(dout1_23) AT=1260.05n

.meas tran vdout1_24ck1250 FIND v(dout1_24) AT=1260.05n

.meas tran vdout1_25ck1250 FIND v(dout1_25) AT=1260.05n

.meas tran vdout1_26ck1250 FIND v(dout1_26) AT=1260.05n

.meas tran vdout1_27ck1250 FIND v(dout1_27) AT=1260.05n

.meas tran vdout1_28ck1250 FIND v(dout1_28) AT=1260.05n

.meas tran vdout1_29ck1250 FIND v(dout1_29) AT=1260.05n

.meas tran vdout1_30ck1250 FIND v(dout1_30) AT=1260.05n

.meas tran vdout1_31ck1250 FIND v(dout1_31) AT=1260.05n

.meas tran vdout1_32ck1250 FIND v(dout1_32) AT=1260.05n

.meas tran vdout1_33ck1250 FIND v(dout1_33) AT=1260.05n

.meas tran vdout1_34ck1250 FIND v(dout1_34) AT=1260.05n

.meas tran vdout1_35ck1250 FIND v(dout1_35) AT=1260.05n

.meas tran vdout1_36ck1250 FIND v(dout1_36) AT=1260.05n

.meas tran vdout1_37ck1250 FIND v(dout1_37) AT=1260.05n

.meas tran vdout1_38ck1250 FIND v(dout1_38) AT=1260.05n

.meas tran vdout1_39ck1250 FIND v(dout1_39) AT=1260.05n

.meas tran vdout1_40ck1250 FIND v(dout1_40) AT=1260.05n

.meas tran vdout1_41ck1250 FIND v(dout1_41) AT=1260.05n

.meas tran vdout1_42ck1250 FIND v(dout1_42) AT=1260.05n

.meas tran vdout1_43ck1250 FIND v(dout1_43) AT=1260.05n

.meas tran vdout1_44ck1250 FIND v(dout1_44) AT=1260.05n

.meas tran vdout1_45ck1250 FIND v(dout1_45) AT=1260.05n

.meas tran vdout1_46ck1250 FIND v(dout1_46) AT=1260.05n

.meas tran vdout1_47ck1250 FIND v(dout1_47) AT=1260.05n

.meas tran vdout1_48ck1250 FIND v(dout1_48) AT=1260.05n

.meas tran vdout1_49ck1250 FIND v(dout1_49) AT=1260.05n

.meas tran vdout1_50ck1250 FIND v(dout1_50) AT=1260.05n

.meas tran vdout1_51ck1250 FIND v(dout1_51) AT=1260.05n

.meas tran vdout1_52ck1250 FIND v(dout1_52) AT=1260.05n

.meas tran vdout1_53ck1250 FIND v(dout1_53) AT=1260.05n

.meas tran vdout1_54ck1250 FIND v(dout1_54) AT=1260.05n

.meas tran vdout1_55ck1250 FIND v(dout1_55) AT=1260.05n

.meas tran vdout1_56ck1250 FIND v(dout1_56) AT=1260.05n

.meas tran vdout1_57ck1250 FIND v(dout1_57) AT=1260.05n

.meas tran vdout1_58ck1250 FIND v(dout1_58) AT=1260.05n

.meas tran vdout1_59ck1250 FIND v(dout1_59) AT=1260.05n

.meas tran vdout1_60ck1250 FIND v(dout1_60) AT=1260.05n

.meas tran vdout1_61ck1250 FIND v(dout1_61) AT=1260.05n

.meas tran vdout1_62ck1250 FIND v(dout1_62) AT=1260.05n

.meas tran vdout1_63ck1250 FIND v(dout1_63) AT=1260.05n

.meas tran vdout1_64ck1250 FIND v(dout1_64) AT=1260.05n

.meas tran vdout1_65ck1250 FIND v(dout1_65) AT=1260.05n

.meas tran vdout1_66ck1250 FIND v(dout1_66) AT=1260.05n

.meas tran vdout1_67ck1250 FIND v(dout1_67) AT=1260.05n

.meas tran vdout1_68ck1250 FIND v(dout1_68) AT=1260.05n

.meas tran vdout1_69ck1250 FIND v(dout1_69) AT=1260.05n

.meas tran vdout1_70ck1250 FIND v(dout1_70) AT=1260.05n

.meas tran vdout1_71ck1250 FIND v(dout1_71) AT=1260.05n

.meas tran vdout1_72ck1250 FIND v(dout1_72) AT=1260.05n

.meas tran vdout1_73ck1250 FIND v(dout1_73) AT=1260.05n

.meas tran vdout1_74ck1250 FIND v(dout1_74) AT=1260.05n

.meas tran vdout1_75ck1250 FIND v(dout1_75) AT=1260.05n

.meas tran vdout1_76ck1250 FIND v(dout1_76) AT=1260.05n

.meas tran vdout1_77ck1250 FIND v(dout1_77) AT=1260.05n

.meas tran vdout1_78ck1250 FIND v(dout1_78) AT=1260.05n

.meas tran vdout1_79ck1250 FIND v(dout1_79) AT=1260.05n

.meas tran vdout1_80ck1250 FIND v(dout1_80) AT=1260.05n

.meas tran vdout1_81ck1250 FIND v(dout1_81) AT=1260.05n

.meas tran vdout1_82ck1250 FIND v(dout1_82) AT=1260.05n

.meas tran vdout1_83ck1250 FIND v(dout1_83) AT=1260.05n

.meas tran vdout1_84ck1250 FIND v(dout1_84) AT=1260.05n

.meas tran vdout1_85ck1250 FIND v(dout1_85) AT=1260.05n

.meas tran vdout1_86ck1250 FIND v(dout1_86) AT=1260.05n

.meas tran vdout1_87ck1250 FIND v(dout1_87) AT=1260.05n

.meas tran vdout1_88ck1250 FIND v(dout1_88) AT=1260.05n

.meas tran vdout1_89ck1250 FIND v(dout1_89) AT=1260.05n

.meas tran vdout1_90ck1250 FIND v(dout1_90) AT=1260.05n

.meas tran vdout1_91ck1250 FIND v(dout1_91) AT=1260.05n

.meas tran vdout1_92ck1250 FIND v(dout1_92) AT=1260.05n

.meas tran vdout1_93ck1250 FIND v(dout1_93) AT=1260.05n

.meas tran vdout1_94ck1250 FIND v(dout1_94) AT=1260.05n

.meas tran vdout1_95ck1250 FIND v(dout1_95) AT=1260.05n

.meas tran vdout1_96ck1250 FIND v(dout1_96) AT=1260.05n

.meas tran vdout1_97ck1250 FIND v(dout1_97) AT=1260.05n

.meas tran vdout1_98ck1250 FIND v(dout1_98) AT=1260.05n

.meas tran vdout1_99ck1250 FIND v(dout1_99) AT=1260.05n

.meas tran vdout1_100ck1250 FIND v(dout1_100) AT=1260.05n

.meas tran vdout1_101ck1250 FIND v(dout1_101) AT=1260.05n

.meas tran vdout1_102ck1250 FIND v(dout1_102) AT=1260.05n

.meas tran vdout1_103ck1250 FIND v(dout1_103) AT=1260.05n

.meas tran vdout1_104ck1250 FIND v(dout1_104) AT=1260.05n

.meas tran vdout1_105ck1250 FIND v(dout1_105) AT=1260.05n

.meas tran vdout1_106ck1250 FIND v(dout1_106) AT=1260.05n

.meas tran vdout1_107ck1250 FIND v(dout1_107) AT=1260.05n

.meas tran vdout1_108ck1250 FIND v(dout1_108) AT=1260.05n

.meas tran vdout1_109ck1250 FIND v(dout1_109) AT=1260.05n

.meas tran vdout1_110ck1250 FIND v(dout1_110) AT=1260.05n

.meas tran vdout1_111ck1250 FIND v(dout1_111) AT=1260.05n

.meas tran vdout1_112ck1250 FIND v(dout1_112) AT=1260.05n

.meas tran vdout1_113ck1250 FIND v(dout1_113) AT=1260.05n

.meas tran vdout1_114ck1250 FIND v(dout1_114) AT=1260.05n

.meas tran vdout1_115ck1250 FIND v(dout1_115) AT=1260.05n

.meas tran vdout1_116ck1250 FIND v(dout1_116) AT=1260.05n

.meas tran vdout1_117ck1250 FIND v(dout1_117) AT=1260.05n

.meas tran vdout1_118ck1250 FIND v(dout1_118) AT=1260.05n

.meas tran vdout1_119ck1250 FIND v(dout1_119) AT=1260.05n

.meas tran vdout1_120ck1250 FIND v(dout1_120) AT=1260.05n

.meas tran vdout1_121ck1250 FIND v(dout1_121) AT=1260.05n

.meas tran vdout1_122ck1250 FIND v(dout1_122) AT=1260.05n

.meas tran vdout1_123ck1250 FIND v(dout1_123) AT=1260.05n

.meas tran vdout1_124ck1250 FIND v(dout1_124) AT=1260.05n

.meas tran vdout1_125ck1250 FIND v(dout1_125) AT=1260.05n

.meas tran vdout1_126ck1250 FIND v(dout1_126) AT=1260.05n

.meas tran vdout1_127ck1250 FIND v(dout1_127) AT=1260.05n

.meas tran vdout1_128ck1250 FIND v(dout1_128) AT=1260.05n

.meas tran vdout1_129ck1250 FIND v(dout1_129) AT=1260.05n

.meas tran vdout1_130ck1250 FIND v(dout1_130) AT=1260.05n

.meas tran vdout1_131ck1250 FIND v(dout1_131) AT=1260.05n

.meas tran vdout1_132ck1250 FIND v(dout1_132) AT=1260.05n

.meas tran vdout1_133ck1250 FIND v(dout1_133) AT=1260.05n

.meas tran vdout1_134ck1250 FIND v(dout1_134) AT=1260.05n

.meas tran vdout1_0ck1260 FIND v(dout1_0) AT=1270.05n

.meas tran vdout1_1ck1260 FIND v(dout1_1) AT=1270.05n

.meas tran vdout1_2ck1260 FIND v(dout1_2) AT=1270.05n

.meas tran vdout1_3ck1260 FIND v(dout1_3) AT=1270.05n

.meas tran vdout1_4ck1260 FIND v(dout1_4) AT=1270.05n

.meas tran vdout1_5ck1260 FIND v(dout1_5) AT=1270.05n

.meas tran vdout1_6ck1260 FIND v(dout1_6) AT=1270.05n

.meas tran vdout1_7ck1260 FIND v(dout1_7) AT=1270.05n

.meas tran vdout1_8ck1260 FIND v(dout1_8) AT=1270.05n

.meas tran vdout1_9ck1260 FIND v(dout1_9) AT=1270.05n

.meas tran vdout1_10ck1260 FIND v(dout1_10) AT=1270.05n

.meas tran vdout1_11ck1260 FIND v(dout1_11) AT=1270.05n

.meas tran vdout1_12ck1260 FIND v(dout1_12) AT=1270.05n

.meas tran vdout1_13ck1260 FIND v(dout1_13) AT=1270.05n

.meas tran vdout1_14ck1260 FIND v(dout1_14) AT=1270.05n

.meas tran vdout1_15ck1260 FIND v(dout1_15) AT=1270.05n

.meas tran vdout1_16ck1260 FIND v(dout1_16) AT=1270.05n

.meas tran vdout1_17ck1260 FIND v(dout1_17) AT=1270.05n

.meas tran vdout1_18ck1260 FIND v(dout1_18) AT=1270.05n

.meas tran vdout1_19ck1260 FIND v(dout1_19) AT=1270.05n

.meas tran vdout1_20ck1260 FIND v(dout1_20) AT=1270.05n

.meas tran vdout1_21ck1260 FIND v(dout1_21) AT=1270.05n

.meas tran vdout1_22ck1260 FIND v(dout1_22) AT=1270.05n

.meas tran vdout1_23ck1260 FIND v(dout1_23) AT=1270.05n

.meas tran vdout1_24ck1260 FIND v(dout1_24) AT=1270.05n

.meas tran vdout1_25ck1260 FIND v(dout1_25) AT=1270.05n

.meas tran vdout1_26ck1260 FIND v(dout1_26) AT=1270.05n

.meas tran vdout1_27ck1260 FIND v(dout1_27) AT=1270.05n

.meas tran vdout1_28ck1260 FIND v(dout1_28) AT=1270.05n

.meas tran vdout1_29ck1260 FIND v(dout1_29) AT=1270.05n

.meas tran vdout1_30ck1260 FIND v(dout1_30) AT=1270.05n

.meas tran vdout1_31ck1260 FIND v(dout1_31) AT=1270.05n

.meas tran vdout1_32ck1260 FIND v(dout1_32) AT=1270.05n

.meas tran vdout1_33ck1260 FIND v(dout1_33) AT=1270.05n

.meas tran vdout1_34ck1260 FIND v(dout1_34) AT=1270.05n

.meas tran vdout1_35ck1260 FIND v(dout1_35) AT=1270.05n

.meas tran vdout1_36ck1260 FIND v(dout1_36) AT=1270.05n

.meas tran vdout1_37ck1260 FIND v(dout1_37) AT=1270.05n

.meas tran vdout1_38ck1260 FIND v(dout1_38) AT=1270.05n

.meas tran vdout1_39ck1260 FIND v(dout1_39) AT=1270.05n

.meas tran vdout1_40ck1260 FIND v(dout1_40) AT=1270.05n

.meas tran vdout1_41ck1260 FIND v(dout1_41) AT=1270.05n

.meas tran vdout1_42ck1260 FIND v(dout1_42) AT=1270.05n

.meas tran vdout1_43ck1260 FIND v(dout1_43) AT=1270.05n

.meas tran vdout1_44ck1260 FIND v(dout1_44) AT=1270.05n

.meas tran vdout1_45ck1260 FIND v(dout1_45) AT=1270.05n

.meas tran vdout1_46ck1260 FIND v(dout1_46) AT=1270.05n

.meas tran vdout1_47ck1260 FIND v(dout1_47) AT=1270.05n

.meas tran vdout1_48ck1260 FIND v(dout1_48) AT=1270.05n

.meas tran vdout1_49ck1260 FIND v(dout1_49) AT=1270.05n

.meas tran vdout1_50ck1260 FIND v(dout1_50) AT=1270.05n

.meas tran vdout1_51ck1260 FIND v(dout1_51) AT=1270.05n

.meas tran vdout1_52ck1260 FIND v(dout1_52) AT=1270.05n

.meas tran vdout1_53ck1260 FIND v(dout1_53) AT=1270.05n

.meas tran vdout1_54ck1260 FIND v(dout1_54) AT=1270.05n

.meas tran vdout1_55ck1260 FIND v(dout1_55) AT=1270.05n

.meas tran vdout1_56ck1260 FIND v(dout1_56) AT=1270.05n

.meas tran vdout1_57ck1260 FIND v(dout1_57) AT=1270.05n

.meas tran vdout1_58ck1260 FIND v(dout1_58) AT=1270.05n

.meas tran vdout1_59ck1260 FIND v(dout1_59) AT=1270.05n

.meas tran vdout1_60ck1260 FIND v(dout1_60) AT=1270.05n

.meas tran vdout1_61ck1260 FIND v(dout1_61) AT=1270.05n

.meas tran vdout1_62ck1260 FIND v(dout1_62) AT=1270.05n

.meas tran vdout1_63ck1260 FIND v(dout1_63) AT=1270.05n

.meas tran vdout1_64ck1260 FIND v(dout1_64) AT=1270.05n

.meas tran vdout1_65ck1260 FIND v(dout1_65) AT=1270.05n

.meas tran vdout1_66ck1260 FIND v(dout1_66) AT=1270.05n

.meas tran vdout1_67ck1260 FIND v(dout1_67) AT=1270.05n

.meas tran vdout1_68ck1260 FIND v(dout1_68) AT=1270.05n

.meas tran vdout1_69ck1260 FIND v(dout1_69) AT=1270.05n

.meas tran vdout1_70ck1260 FIND v(dout1_70) AT=1270.05n

.meas tran vdout1_71ck1260 FIND v(dout1_71) AT=1270.05n

.meas tran vdout1_72ck1260 FIND v(dout1_72) AT=1270.05n

.meas tran vdout1_73ck1260 FIND v(dout1_73) AT=1270.05n

.meas tran vdout1_74ck1260 FIND v(dout1_74) AT=1270.05n

.meas tran vdout1_75ck1260 FIND v(dout1_75) AT=1270.05n

.meas tran vdout1_76ck1260 FIND v(dout1_76) AT=1270.05n

.meas tran vdout1_77ck1260 FIND v(dout1_77) AT=1270.05n

.meas tran vdout1_78ck1260 FIND v(dout1_78) AT=1270.05n

.meas tran vdout1_79ck1260 FIND v(dout1_79) AT=1270.05n

.meas tran vdout1_80ck1260 FIND v(dout1_80) AT=1270.05n

.meas tran vdout1_81ck1260 FIND v(dout1_81) AT=1270.05n

.meas tran vdout1_82ck1260 FIND v(dout1_82) AT=1270.05n

.meas tran vdout1_83ck1260 FIND v(dout1_83) AT=1270.05n

.meas tran vdout1_84ck1260 FIND v(dout1_84) AT=1270.05n

.meas tran vdout1_85ck1260 FIND v(dout1_85) AT=1270.05n

.meas tran vdout1_86ck1260 FIND v(dout1_86) AT=1270.05n

.meas tran vdout1_87ck1260 FIND v(dout1_87) AT=1270.05n

.meas tran vdout1_88ck1260 FIND v(dout1_88) AT=1270.05n

.meas tran vdout1_89ck1260 FIND v(dout1_89) AT=1270.05n

.meas tran vdout1_90ck1260 FIND v(dout1_90) AT=1270.05n

.meas tran vdout1_91ck1260 FIND v(dout1_91) AT=1270.05n

.meas tran vdout1_92ck1260 FIND v(dout1_92) AT=1270.05n

.meas tran vdout1_93ck1260 FIND v(dout1_93) AT=1270.05n

.meas tran vdout1_94ck1260 FIND v(dout1_94) AT=1270.05n

.meas tran vdout1_95ck1260 FIND v(dout1_95) AT=1270.05n

.meas tran vdout1_96ck1260 FIND v(dout1_96) AT=1270.05n

.meas tran vdout1_97ck1260 FIND v(dout1_97) AT=1270.05n

.meas tran vdout1_98ck1260 FIND v(dout1_98) AT=1270.05n

.meas tran vdout1_99ck1260 FIND v(dout1_99) AT=1270.05n

.meas tran vdout1_100ck1260 FIND v(dout1_100) AT=1270.05n

.meas tran vdout1_101ck1260 FIND v(dout1_101) AT=1270.05n

.meas tran vdout1_102ck1260 FIND v(dout1_102) AT=1270.05n

.meas tran vdout1_103ck1260 FIND v(dout1_103) AT=1270.05n

.meas tran vdout1_104ck1260 FIND v(dout1_104) AT=1270.05n

.meas tran vdout1_105ck1260 FIND v(dout1_105) AT=1270.05n

.meas tran vdout1_106ck1260 FIND v(dout1_106) AT=1270.05n

.meas tran vdout1_107ck1260 FIND v(dout1_107) AT=1270.05n

.meas tran vdout1_108ck1260 FIND v(dout1_108) AT=1270.05n

.meas tran vdout1_109ck1260 FIND v(dout1_109) AT=1270.05n

.meas tran vdout1_110ck1260 FIND v(dout1_110) AT=1270.05n

.meas tran vdout1_111ck1260 FIND v(dout1_111) AT=1270.05n

.meas tran vdout1_112ck1260 FIND v(dout1_112) AT=1270.05n

.meas tran vdout1_113ck1260 FIND v(dout1_113) AT=1270.05n

.meas tran vdout1_114ck1260 FIND v(dout1_114) AT=1270.05n

.meas tran vdout1_115ck1260 FIND v(dout1_115) AT=1270.05n

.meas tran vdout1_116ck1260 FIND v(dout1_116) AT=1270.05n

.meas tran vdout1_117ck1260 FIND v(dout1_117) AT=1270.05n

.meas tran vdout1_118ck1260 FIND v(dout1_118) AT=1270.05n

.meas tran vdout1_119ck1260 FIND v(dout1_119) AT=1270.05n

.meas tran vdout1_120ck1260 FIND v(dout1_120) AT=1270.05n

.meas tran vdout1_121ck1260 FIND v(dout1_121) AT=1270.05n

.meas tran vdout1_122ck1260 FIND v(dout1_122) AT=1270.05n

.meas tran vdout1_123ck1260 FIND v(dout1_123) AT=1270.05n

.meas tran vdout1_124ck1260 FIND v(dout1_124) AT=1270.05n

.meas tran vdout1_125ck1260 FIND v(dout1_125) AT=1270.05n

.meas tran vdout1_126ck1260 FIND v(dout1_126) AT=1270.05n

.meas tran vdout1_127ck1260 FIND v(dout1_127) AT=1270.05n

.meas tran vdout1_128ck1260 FIND v(dout1_128) AT=1270.05n

.meas tran vdout1_129ck1260 FIND v(dout1_129) AT=1270.05n

.meas tran vdout1_130ck1260 FIND v(dout1_130) AT=1270.05n

.meas tran vdout1_131ck1260 FIND v(dout1_131) AT=1270.05n

.meas tran vdout1_132ck1260 FIND v(dout1_132) AT=1270.05n

.meas tran vdout1_133ck1260 FIND v(dout1_133) AT=1270.05n

.meas tran vdout1_134ck1260 FIND v(dout1_134) AT=1270.05n

.meas tran vdout1_0ck1320 FIND v(dout1_0) AT=1330.05n

.meas tran vdout1_1ck1320 FIND v(dout1_1) AT=1330.05n

.meas tran vdout1_2ck1320 FIND v(dout1_2) AT=1330.05n

.meas tran vdout1_3ck1320 FIND v(dout1_3) AT=1330.05n

.meas tran vdout1_4ck1320 FIND v(dout1_4) AT=1330.05n

.meas tran vdout1_5ck1320 FIND v(dout1_5) AT=1330.05n

.meas tran vdout1_6ck1320 FIND v(dout1_6) AT=1330.05n

.meas tran vdout1_7ck1320 FIND v(dout1_7) AT=1330.05n

.meas tran vdout1_8ck1320 FIND v(dout1_8) AT=1330.05n

.meas tran vdout1_9ck1320 FIND v(dout1_9) AT=1330.05n

.meas tran vdout1_10ck1320 FIND v(dout1_10) AT=1330.05n

.meas tran vdout1_11ck1320 FIND v(dout1_11) AT=1330.05n

.meas tran vdout1_12ck1320 FIND v(dout1_12) AT=1330.05n

.meas tran vdout1_13ck1320 FIND v(dout1_13) AT=1330.05n

.meas tran vdout1_14ck1320 FIND v(dout1_14) AT=1330.05n

.meas tran vdout1_15ck1320 FIND v(dout1_15) AT=1330.05n

.meas tran vdout1_16ck1320 FIND v(dout1_16) AT=1330.05n

.meas tran vdout1_17ck1320 FIND v(dout1_17) AT=1330.05n

.meas tran vdout1_18ck1320 FIND v(dout1_18) AT=1330.05n

.meas tran vdout1_19ck1320 FIND v(dout1_19) AT=1330.05n

.meas tran vdout1_20ck1320 FIND v(dout1_20) AT=1330.05n

.meas tran vdout1_21ck1320 FIND v(dout1_21) AT=1330.05n

.meas tran vdout1_22ck1320 FIND v(dout1_22) AT=1330.05n

.meas tran vdout1_23ck1320 FIND v(dout1_23) AT=1330.05n

.meas tran vdout1_24ck1320 FIND v(dout1_24) AT=1330.05n

.meas tran vdout1_25ck1320 FIND v(dout1_25) AT=1330.05n

.meas tran vdout1_26ck1320 FIND v(dout1_26) AT=1330.05n

.meas tran vdout1_27ck1320 FIND v(dout1_27) AT=1330.05n

.meas tran vdout1_28ck1320 FIND v(dout1_28) AT=1330.05n

.meas tran vdout1_29ck1320 FIND v(dout1_29) AT=1330.05n

.meas tran vdout1_30ck1320 FIND v(dout1_30) AT=1330.05n

.meas tran vdout1_31ck1320 FIND v(dout1_31) AT=1330.05n

.meas tran vdout1_32ck1320 FIND v(dout1_32) AT=1330.05n

.meas tran vdout1_33ck1320 FIND v(dout1_33) AT=1330.05n

.meas tran vdout1_34ck1320 FIND v(dout1_34) AT=1330.05n

.meas tran vdout1_35ck1320 FIND v(dout1_35) AT=1330.05n

.meas tran vdout1_36ck1320 FIND v(dout1_36) AT=1330.05n

.meas tran vdout1_37ck1320 FIND v(dout1_37) AT=1330.05n

.meas tran vdout1_38ck1320 FIND v(dout1_38) AT=1330.05n

.meas tran vdout1_39ck1320 FIND v(dout1_39) AT=1330.05n

.meas tran vdout1_40ck1320 FIND v(dout1_40) AT=1330.05n

.meas tran vdout1_41ck1320 FIND v(dout1_41) AT=1330.05n

.meas tran vdout1_42ck1320 FIND v(dout1_42) AT=1330.05n

.meas tran vdout1_43ck1320 FIND v(dout1_43) AT=1330.05n

.meas tran vdout1_44ck1320 FIND v(dout1_44) AT=1330.05n

.meas tran vdout1_45ck1320 FIND v(dout1_45) AT=1330.05n

.meas tran vdout1_46ck1320 FIND v(dout1_46) AT=1330.05n

.meas tran vdout1_47ck1320 FIND v(dout1_47) AT=1330.05n

.meas tran vdout1_48ck1320 FIND v(dout1_48) AT=1330.05n

.meas tran vdout1_49ck1320 FIND v(dout1_49) AT=1330.05n

.meas tran vdout1_50ck1320 FIND v(dout1_50) AT=1330.05n

.meas tran vdout1_51ck1320 FIND v(dout1_51) AT=1330.05n

.meas tran vdout1_52ck1320 FIND v(dout1_52) AT=1330.05n

.meas tran vdout1_53ck1320 FIND v(dout1_53) AT=1330.05n

.meas tran vdout1_54ck1320 FIND v(dout1_54) AT=1330.05n

.meas tran vdout1_55ck1320 FIND v(dout1_55) AT=1330.05n

.meas tran vdout1_56ck1320 FIND v(dout1_56) AT=1330.05n

.meas tran vdout1_57ck1320 FIND v(dout1_57) AT=1330.05n

.meas tran vdout1_58ck1320 FIND v(dout1_58) AT=1330.05n

.meas tran vdout1_59ck1320 FIND v(dout1_59) AT=1330.05n

.meas tran vdout1_60ck1320 FIND v(dout1_60) AT=1330.05n

.meas tran vdout1_61ck1320 FIND v(dout1_61) AT=1330.05n

.meas tran vdout1_62ck1320 FIND v(dout1_62) AT=1330.05n

.meas tran vdout1_63ck1320 FIND v(dout1_63) AT=1330.05n

.meas tran vdout1_64ck1320 FIND v(dout1_64) AT=1330.05n

.meas tran vdout1_65ck1320 FIND v(dout1_65) AT=1330.05n

.meas tran vdout1_66ck1320 FIND v(dout1_66) AT=1330.05n

.meas tran vdout1_67ck1320 FIND v(dout1_67) AT=1330.05n

.meas tran vdout1_68ck1320 FIND v(dout1_68) AT=1330.05n

.meas tran vdout1_69ck1320 FIND v(dout1_69) AT=1330.05n

.meas tran vdout1_70ck1320 FIND v(dout1_70) AT=1330.05n

.meas tran vdout1_71ck1320 FIND v(dout1_71) AT=1330.05n

.meas tran vdout1_72ck1320 FIND v(dout1_72) AT=1330.05n

.meas tran vdout1_73ck1320 FIND v(dout1_73) AT=1330.05n

.meas tran vdout1_74ck1320 FIND v(dout1_74) AT=1330.05n

.meas tran vdout1_75ck1320 FIND v(dout1_75) AT=1330.05n

.meas tran vdout1_76ck1320 FIND v(dout1_76) AT=1330.05n

.meas tran vdout1_77ck1320 FIND v(dout1_77) AT=1330.05n

.meas tran vdout1_78ck1320 FIND v(dout1_78) AT=1330.05n

.meas tran vdout1_79ck1320 FIND v(dout1_79) AT=1330.05n

.meas tran vdout1_80ck1320 FIND v(dout1_80) AT=1330.05n

.meas tran vdout1_81ck1320 FIND v(dout1_81) AT=1330.05n

.meas tran vdout1_82ck1320 FIND v(dout1_82) AT=1330.05n

.meas tran vdout1_83ck1320 FIND v(dout1_83) AT=1330.05n

.meas tran vdout1_84ck1320 FIND v(dout1_84) AT=1330.05n

.meas tran vdout1_85ck1320 FIND v(dout1_85) AT=1330.05n

.meas tran vdout1_86ck1320 FIND v(dout1_86) AT=1330.05n

.meas tran vdout1_87ck1320 FIND v(dout1_87) AT=1330.05n

.meas tran vdout1_88ck1320 FIND v(dout1_88) AT=1330.05n

.meas tran vdout1_89ck1320 FIND v(dout1_89) AT=1330.05n

.meas tran vdout1_90ck1320 FIND v(dout1_90) AT=1330.05n

.meas tran vdout1_91ck1320 FIND v(dout1_91) AT=1330.05n

.meas tran vdout1_92ck1320 FIND v(dout1_92) AT=1330.05n

.meas tran vdout1_93ck1320 FIND v(dout1_93) AT=1330.05n

.meas tran vdout1_94ck1320 FIND v(dout1_94) AT=1330.05n

.meas tran vdout1_95ck1320 FIND v(dout1_95) AT=1330.05n

.meas tran vdout1_96ck1320 FIND v(dout1_96) AT=1330.05n

.meas tran vdout1_97ck1320 FIND v(dout1_97) AT=1330.05n

.meas tran vdout1_98ck1320 FIND v(dout1_98) AT=1330.05n

.meas tran vdout1_99ck1320 FIND v(dout1_99) AT=1330.05n

.meas tran vdout1_100ck1320 FIND v(dout1_100) AT=1330.05n

.meas tran vdout1_101ck1320 FIND v(dout1_101) AT=1330.05n

.meas tran vdout1_102ck1320 FIND v(dout1_102) AT=1330.05n

.meas tran vdout1_103ck1320 FIND v(dout1_103) AT=1330.05n

.meas tran vdout1_104ck1320 FIND v(dout1_104) AT=1330.05n

.meas tran vdout1_105ck1320 FIND v(dout1_105) AT=1330.05n

.meas tran vdout1_106ck1320 FIND v(dout1_106) AT=1330.05n

.meas tran vdout1_107ck1320 FIND v(dout1_107) AT=1330.05n

.meas tran vdout1_108ck1320 FIND v(dout1_108) AT=1330.05n

.meas tran vdout1_109ck1320 FIND v(dout1_109) AT=1330.05n

.meas tran vdout1_110ck1320 FIND v(dout1_110) AT=1330.05n

.meas tran vdout1_111ck1320 FIND v(dout1_111) AT=1330.05n

.meas tran vdout1_112ck1320 FIND v(dout1_112) AT=1330.05n

.meas tran vdout1_113ck1320 FIND v(dout1_113) AT=1330.05n

.meas tran vdout1_114ck1320 FIND v(dout1_114) AT=1330.05n

.meas tran vdout1_115ck1320 FIND v(dout1_115) AT=1330.05n

.meas tran vdout1_116ck1320 FIND v(dout1_116) AT=1330.05n

.meas tran vdout1_117ck1320 FIND v(dout1_117) AT=1330.05n

.meas tran vdout1_118ck1320 FIND v(dout1_118) AT=1330.05n

.meas tran vdout1_119ck1320 FIND v(dout1_119) AT=1330.05n

.meas tran vdout1_120ck1320 FIND v(dout1_120) AT=1330.05n

.meas tran vdout1_121ck1320 FIND v(dout1_121) AT=1330.05n

.meas tran vdout1_122ck1320 FIND v(dout1_122) AT=1330.05n

.meas tran vdout1_123ck1320 FIND v(dout1_123) AT=1330.05n

.meas tran vdout1_124ck1320 FIND v(dout1_124) AT=1330.05n

.meas tran vdout1_125ck1320 FIND v(dout1_125) AT=1330.05n

.meas tran vdout1_126ck1320 FIND v(dout1_126) AT=1330.05n

.meas tran vdout1_127ck1320 FIND v(dout1_127) AT=1330.05n

.meas tran vdout1_128ck1320 FIND v(dout1_128) AT=1330.05n

.meas tran vdout1_129ck1320 FIND v(dout1_129) AT=1330.05n

.meas tran vdout1_130ck1320 FIND v(dout1_130) AT=1330.05n

.meas tran vdout1_131ck1320 FIND v(dout1_131) AT=1330.05n

.meas tran vdout1_132ck1320 FIND v(dout1_132) AT=1330.05n

.meas tran vdout1_133ck1320 FIND v(dout1_133) AT=1330.05n

.meas tran vdout1_134ck1320 FIND v(dout1_134) AT=1330.05n

.meas tran vdout1_0ck1360 FIND v(dout1_0) AT=1370.05n

.meas tran vdout1_1ck1360 FIND v(dout1_1) AT=1370.05n

.meas tran vdout1_2ck1360 FIND v(dout1_2) AT=1370.05n

.meas tran vdout1_3ck1360 FIND v(dout1_3) AT=1370.05n

.meas tran vdout1_4ck1360 FIND v(dout1_4) AT=1370.05n

.meas tran vdout1_5ck1360 FIND v(dout1_5) AT=1370.05n

.meas tran vdout1_6ck1360 FIND v(dout1_6) AT=1370.05n

.meas tran vdout1_7ck1360 FIND v(dout1_7) AT=1370.05n

.meas tran vdout1_8ck1360 FIND v(dout1_8) AT=1370.05n

.meas tran vdout1_9ck1360 FIND v(dout1_9) AT=1370.05n

.meas tran vdout1_10ck1360 FIND v(dout1_10) AT=1370.05n

.meas tran vdout1_11ck1360 FIND v(dout1_11) AT=1370.05n

.meas tran vdout1_12ck1360 FIND v(dout1_12) AT=1370.05n

.meas tran vdout1_13ck1360 FIND v(dout1_13) AT=1370.05n

.meas tran vdout1_14ck1360 FIND v(dout1_14) AT=1370.05n

.meas tran vdout1_15ck1360 FIND v(dout1_15) AT=1370.05n

.meas tran vdout1_16ck1360 FIND v(dout1_16) AT=1370.05n

.meas tran vdout1_17ck1360 FIND v(dout1_17) AT=1370.05n

.meas tran vdout1_18ck1360 FIND v(dout1_18) AT=1370.05n

.meas tran vdout1_19ck1360 FIND v(dout1_19) AT=1370.05n

.meas tran vdout1_20ck1360 FIND v(dout1_20) AT=1370.05n

.meas tran vdout1_21ck1360 FIND v(dout1_21) AT=1370.05n

.meas tran vdout1_22ck1360 FIND v(dout1_22) AT=1370.05n

.meas tran vdout1_23ck1360 FIND v(dout1_23) AT=1370.05n

.meas tran vdout1_24ck1360 FIND v(dout1_24) AT=1370.05n

.meas tran vdout1_25ck1360 FIND v(dout1_25) AT=1370.05n

.meas tran vdout1_26ck1360 FIND v(dout1_26) AT=1370.05n

.meas tran vdout1_27ck1360 FIND v(dout1_27) AT=1370.05n

.meas tran vdout1_28ck1360 FIND v(dout1_28) AT=1370.05n

.meas tran vdout1_29ck1360 FIND v(dout1_29) AT=1370.05n

.meas tran vdout1_30ck1360 FIND v(dout1_30) AT=1370.05n

.meas tran vdout1_31ck1360 FIND v(dout1_31) AT=1370.05n

.meas tran vdout1_32ck1360 FIND v(dout1_32) AT=1370.05n

.meas tran vdout1_33ck1360 FIND v(dout1_33) AT=1370.05n

.meas tran vdout1_34ck1360 FIND v(dout1_34) AT=1370.05n

.meas tran vdout1_35ck1360 FIND v(dout1_35) AT=1370.05n

.meas tran vdout1_36ck1360 FIND v(dout1_36) AT=1370.05n

.meas tran vdout1_37ck1360 FIND v(dout1_37) AT=1370.05n

.meas tran vdout1_38ck1360 FIND v(dout1_38) AT=1370.05n

.meas tran vdout1_39ck1360 FIND v(dout1_39) AT=1370.05n

.meas tran vdout1_40ck1360 FIND v(dout1_40) AT=1370.05n

.meas tran vdout1_41ck1360 FIND v(dout1_41) AT=1370.05n

.meas tran vdout1_42ck1360 FIND v(dout1_42) AT=1370.05n

.meas tran vdout1_43ck1360 FIND v(dout1_43) AT=1370.05n

.meas tran vdout1_44ck1360 FIND v(dout1_44) AT=1370.05n

.meas tran vdout1_45ck1360 FIND v(dout1_45) AT=1370.05n

.meas tran vdout1_46ck1360 FIND v(dout1_46) AT=1370.05n

.meas tran vdout1_47ck1360 FIND v(dout1_47) AT=1370.05n

.meas tran vdout1_48ck1360 FIND v(dout1_48) AT=1370.05n

.meas tran vdout1_49ck1360 FIND v(dout1_49) AT=1370.05n

.meas tran vdout1_50ck1360 FIND v(dout1_50) AT=1370.05n

.meas tran vdout1_51ck1360 FIND v(dout1_51) AT=1370.05n

.meas tran vdout1_52ck1360 FIND v(dout1_52) AT=1370.05n

.meas tran vdout1_53ck1360 FIND v(dout1_53) AT=1370.05n

.meas tran vdout1_54ck1360 FIND v(dout1_54) AT=1370.05n

.meas tran vdout1_55ck1360 FIND v(dout1_55) AT=1370.05n

.meas tran vdout1_56ck1360 FIND v(dout1_56) AT=1370.05n

.meas tran vdout1_57ck1360 FIND v(dout1_57) AT=1370.05n

.meas tran vdout1_58ck1360 FIND v(dout1_58) AT=1370.05n

.meas tran vdout1_59ck1360 FIND v(dout1_59) AT=1370.05n

.meas tran vdout1_60ck1360 FIND v(dout1_60) AT=1370.05n

.meas tran vdout1_61ck1360 FIND v(dout1_61) AT=1370.05n

.meas tran vdout1_62ck1360 FIND v(dout1_62) AT=1370.05n

.meas tran vdout1_63ck1360 FIND v(dout1_63) AT=1370.05n

.meas tran vdout1_64ck1360 FIND v(dout1_64) AT=1370.05n

.meas tran vdout1_65ck1360 FIND v(dout1_65) AT=1370.05n

.meas tran vdout1_66ck1360 FIND v(dout1_66) AT=1370.05n

.meas tran vdout1_67ck1360 FIND v(dout1_67) AT=1370.05n

.meas tran vdout1_68ck1360 FIND v(dout1_68) AT=1370.05n

.meas tran vdout1_69ck1360 FIND v(dout1_69) AT=1370.05n

.meas tran vdout1_70ck1360 FIND v(dout1_70) AT=1370.05n

.meas tran vdout1_71ck1360 FIND v(dout1_71) AT=1370.05n

.meas tran vdout1_72ck1360 FIND v(dout1_72) AT=1370.05n

.meas tran vdout1_73ck1360 FIND v(dout1_73) AT=1370.05n

.meas tran vdout1_74ck1360 FIND v(dout1_74) AT=1370.05n

.meas tran vdout1_75ck1360 FIND v(dout1_75) AT=1370.05n

.meas tran vdout1_76ck1360 FIND v(dout1_76) AT=1370.05n

.meas tran vdout1_77ck1360 FIND v(dout1_77) AT=1370.05n

.meas tran vdout1_78ck1360 FIND v(dout1_78) AT=1370.05n

.meas tran vdout1_79ck1360 FIND v(dout1_79) AT=1370.05n

.meas tran vdout1_80ck1360 FIND v(dout1_80) AT=1370.05n

.meas tran vdout1_81ck1360 FIND v(dout1_81) AT=1370.05n

.meas tran vdout1_82ck1360 FIND v(dout1_82) AT=1370.05n

.meas tran vdout1_83ck1360 FIND v(dout1_83) AT=1370.05n

.meas tran vdout1_84ck1360 FIND v(dout1_84) AT=1370.05n

.meas tran vdout1_85ck1360 FIND v(dout1_85) AT=1370.05n

.meas tran vdout1_86ck1360 FIND v(dout1_86) AT=1370.05n

.meas tran vdout1_87ck1360 FIND v(dout1_87) AT=1370.05n

.meas tran vdout1_88ck1360 FIND v(dout1_88) AT=1370.05n

.meas tran vdout1_89ck1360 FIND v(dout1_89) AT=1370.05n

.meas tran vdout1_90ck1360 FIND v(dout1_90) AT=1370.05n

.meas tran vdout1_91ck1360 FIND v(dout1_91) AT=1370.05n

.meas tran vdout1_92ck1360 FIND v(dout1_92) AT=1370.05n

.meas tran vdout1_93ck1360 FIND v(dout1_93) AT=1370.05n

.meas tran vdout1_94ck1360 FIND v(dout1_94) AT=1370.05n

.meas tran vdout1_95ck1360 FIND v(dout1_95) AT=1370.05n

.meas tran vdout1_96ck1360 FIND v(dout1_96) AT=1370.05n

.meas tran vdout1_97ck1360 FIND v(dout1_97) AT=1370.05n

.meas tran vdout1_98ck1360 FIND v(dout1_98) AT=1370.05n

.meas tran vdout1_99ck1360 FIND v(dout1_99) AT=1370.05n

.meas tran vdout1_100ck1360 FIND v(dout1_100) AT=1370.05n

.meas tran vdout1_101ck1360 FIND v(dout1_101) AT=1370.05n

.meas tran vdout1_102ck1360 FIND v(dout1_102) AT=1370.05n

.meas tran vdout1_103ck1360 FIND v(dout1_103) AT=1370.05n

.meas tran vdout1_104ck1360 FIND v(dout1_104) AT=1370.05n

.meas tran vdout1_105ck1360 FIND v(dout1_105) AT=1370.05n

.meas tran vdout1_106ck1360 FIND v(dout1_106) AT=1370.05n

.meas tran vdout1_107ck1360 FIND v(dout1_107) AT=1370.05n

.meas tran vdout1_108ck1360 FIND v(dout1_108) AT=1370.05n

.meas tran vdout1_109ck1360 FIND v(dout1_109) AT=1370.05n

.meas tran vdout1_110ck1360 FIND v(dout1_110) AT=1370.05n

.meas tran vdout1_111ck1360 FIND v(dout1_111) AT=1370.05n

.meas tran vdout1_112ck1360 FIND v(dout1_112) AT=1370.05n

.meas tran vdout1_113ck1360 FIND v(dout1_113) AT=1370.05n

.meas tran vdout1_114ck1360 FIND v(dout1_114) AT=1370.05n

.meas tran vdout1_115ck1360 FIND v(dout1_115) AT=1370.05n

.meas tran vdout1_116ck1360 FIND v(dout1_116) AT=1370.05n

.meas tran vdout1_117ck1360 FIND v(dout1_117) AT=1370.05n

.meas tran vdout1_118ck1360 FIND v(dout1_118) AT=1370.05n

.meas tran vdout1_119ck1360 FIND v(dout1_119) AT=1370.05n

.meas tran vdout1_120ck1360 FIND v(dout1_120) AT=1370.05n

.meas tran vdout1_121ck1360 FIND v(dout1_121) AT=1370.05n

.meas tran vdout1_122ck1360 FIND v(dout1_122) AT=1370.05n

.meas tran vdout1_123ck1360 FIND v(dout1_123) AT=1370.05n

.meas tran vdout1_124ck1360 FIND v(dout1_124) AT=1370.05n

.meas tran vdout1_125ck1360 FIND v(dout1_125) AT=1370.05n

.meas tran vdout1_126ck1360 FIND v(dout1_126) AT=1370.05n

.meas tran vdout1_127ck1360 FIND v(dout1_127) AT=1370.05n

.meas tran vdout1_128ck1360 FIND v(dout1_128) AT=1370.05n

.meas tran vdout1_129ck1360 FIND v(dout1_129) AT=1370.05n

.meas tran vdout1_130ck1360 FIND v(dout1_130) AT=1370.05n

.meas tran vdout1_131ck1360 FIND v(dout1_131) AT=1370.05n

.meas tran vdout1_132ck1360 FIND v(dout1_132) AT=1370.05n

.meas tran vdout1_133ck1360 FIND v(dout1_133) AT=1370.05n

.meas tran vdout1_134ck1360 FIND v(dout1_134) AT=1370.05n

.meas tran vdout1_0ck1380 FIND v(dout1_0) AT=1390.05n

.meas tran vdout1_1ck1380 FIND v(dout1_1) AT=1390.05n

.meas tran vdout1_2ck1380 FIND v(dout1_2) AT=1390.05n

.meas tran vdout1_3ck1380 FIND v(dout1_3) AT=1390.05n

.meas tran vdout1_4ck1380 FIND v(dout1_4) AT=1390.05n

.meas tran vdout1_5ck1380 FIND v(dout1_5) AT=1390.05n

.meas tran vdout1_6ck1380 FIND v(dout1_6) AT=1390.05n

.meas tran vdout1_7ck1380 FIND v(dout1_7) AT=1390.05n

.meas tran vdout1_8ck1380 FIND v(dout1_8) AT=1390.05n

.meas tran vdout1_9ck1380 FIND v(dout1_9) AT=1390.05n

.meas tran vdout1_10ck1380 FIND v(dout1_10) AT=1390.05n

.meas tran vdout1_11ck1380 FIND v(dout1_11) AT=1390.05n

.meas tran vdout1_12ck1380 FIND v(dout1_12) AT=1390.05n

.meas tran vdout1_13ck1380 FIND v(dout1_13) AT=1390.05n

.meas tran vdout1_14ck1380 FIND v(dout1_14) AT=1390.05n

.meas tran vdout1_15ck1380 FIND v(dout1_15) AT=1390.05n

.meas tran vdout1_16ck1380 FIND v(dout1_16) AT=1390.05n

.meas tran vdout1_17ck1380 FIND v(dout1_17) AT=1390.05n

.meas tran vdout1_18ck1380 FIND v(dout1_18) AT=1390.05n

.meas tran vdout1_19ck1380 FIND v(dout1_19) AT=1390.05n

.meas tran vdout1_20ck1380 FIND v(dout1_20) AT=1390.05n

.meas tran vdout1_21ck1380 FIND v(dout1_21) AT=1390.05n

.meas tran vdout1_22ck1380 FIND v(dout1_22) AT=1390.05n

.meas tran vdout1_23ck1380 FIND v(dout1_23) AT=1390.05n

.meas tran vdout1_24ck1380 FIND v(dout1_24) AT=1390.05n

.meas tran vdout1_25ck1380 FIND v(dout1_25) AT=1390.05n

.meas tran vdout1_26ck1380 FIND v(dout1_26) AT=1390.05n

.meas tran vdout1_27ck1380 FIND v(dout1_27) AT=1390.05n

.meas tran vdout1_28ck1380 FIND v(dout1_28) AT=1390.05n

.meas tran vdout1_29ck1380 FIND v(dout1_29) AT=1390.05n

.meas tran vdout1_30ck1380 FIND v(dout1_30) AT=1390.05n

.meas tran vdout1_31ck1380 FIND v(dout1_31) AT=1390.05n

.meas tran vdout1_32ck1380 FIND v(dout1_32) AT=1390.05n

.meas tran vdout1_33ck1380 FIND v(dout1_33) AT=1390.05n

.meas tran vdout1_34ck1380 FIND v(dout1_34) AT=1390.05n

.meas tran vdout1_35ck1380 FIND v(dout1_35) AT=1390.05n

.meas tran vdout1_36ck1380 FIND v(dout1_36) AT=1390.05n

.meas tran vdout1_37ck1380 FIND v(dout1_37) AT=1390.05n

.meas tran vdout1_38ck1380 FIND v(dout1_38) AT=1390.05n

.meas tran vdout1_39ck1380 FIND v(dout1_39) AT=1390.05n

.meas tran vdout1_40ck1380 FIND v(dout1_40) AT=1390.05n

.meas tran vdout1_41ck1380 FIND v(dout1_41) AT=1390.05n

.meas tran vdout1_42ck1380 FIND v(dout1_42) AT=1390.05n

.meas tran vdout1_43ck1380 FIND v(dout1_43) AT=1390.05n

.meas tran vdout1_44ck1380 FIND v(dout1_44) AT=1390.05n

.meas tran vdout1_45ck1380 FIND v(dout1_45) AT=1390.05n

.meas tran vdout1_46ck1380 FIND v(dout1_46) AT=1390.05n

.meas tran vdout1_47ck1380 FIND v(dout1_47) AT=1390.05n

.meas tran vdout1_48ck1380 FIND v(dout1_48) AT=1390.05n

.meas tran vdout1_49ck1380 FIND v(dout1_49) AT=1390.05n

.meas tran vdout1_50ck1380 FIND v(dout1_50) AT=1390.05n

.meas tran vdout1_51ck1380 FIND v(dout1_51) AT=1390.05n

.meas tran vdout1_52ck1380 FIND v(dout1_52) AT=1390.05n

.meas tran vdout1_53ck1380 FIND v(dout1_53) AT=1390.05n

.meas tran vdout1_54ck1380 FIND v(dout1_54) AT=1390.05n

.meas tran vdout1_55ck1380 FIND v(dout1_55) AT=1390.05n

.meas tran vdout1_56ck1380 FIND v(dout1_56) AT=1390.05n

.meas tran vdout1_57ck1380 FIND v(dout1_57) AT=1390.05n

.meas tran vdout1_58ck1380 FIND v(dout1_58) AT=1390.05n

.meas tran vdout1_59ck1380 FIND v(dout1_59) AT=1390.05n

.meas tran vdout1_60ck1380 FIND v(dout1_60) AT=1390.05n

.meas tran vdout1_61ck1380 FIND v(dout1_61) AT=1390.05n

.meas tran vdout1_62ck1380 FIND v(dout1_62) AT=1390.05n

.meas tran vdout1_63ck1380 FIND v(dout1_63) AT=1390.05n

.meas tran vdout1_64ck1380 FIND v(dout1_64) AT=1390.05n

.meas tran vdout1_65ck1380 FIND v(dout1_65) AT=1390.05n

.meas tran vdout1_66ck1380 FIND v(dout1_66) AT=1390.05n

.meas tran vdout1_67ck1380 FIND v(dout1_67) AT=1390.05n

.meas tran vdout1_68ck1380 FIND v(dout1_68) AT=1390.05n

.meas tran vdout1_69ck1380 FIND v(dout1_69) AT=1390.05n

.meas tran vdout1_70ck1380 FIND v(dout1_70) AT=1390.05n

.meas tran vdout1_71ck1380 FIND v(dout1_71) AT=1390.05n

.meas tran vdout1_72ck1380 FIND v(dout1_72) AT=1390.05n

.meas tran vdout1_73ck1380 FIND v(dout1_73) AT=1390.05n

.meas tran vdout1_74ck1380 FIND v(dout1_74) AT=1390.05n

.meas tran vdout1_75ck1380 FIND v(dout1_75) AT=1390.05n

.meas tran vdout1_76ck1380 FIND v(dout1_76) AT=1390.05n

.meas tran vdout1_77ck1380 FIND v(dout1_77) AT=1390.05n

.meas tran vdout1_78ck1380 FIND v(dout1_78) AT=1390.05n

.meas tran vdout1_79ck1380 FIND v(dout1_79) AT=1390.05n

.meas tran vdout1_80ck1380 FIND v(dout1_80) AT=1390.05n

.meas tran vdout1_81ck1380 FIND v(dout1_81) AT=1390.05n

.meas tran vdout1_82ck1380 FIND v(dout1_82) AT=1390.05n

.meas tran vdout1_83ck1380 FIND v(dout1_83) AT=1390.05n

.meas tran vdout1_84ck1380 FIND v(dout1_84) AT=1390.05n

.meas tran vdout1_85ck1380 FIND v(dout1_85) AT=1390.05n

.meas tran vdout1_86ck1380 FIND v(dout1_86) AT=1390.05n

.meas tran vdout1_87ck1380 FIND v(dout1_87) AT=1390.05n

.meas tran vdout1_88ck1380 FIND v(dout1_88) AT=1390.05n

.meas tran vdout1_89ck1380 FIND v(dout1_89) AT=1390.05n

.meas tran vdout1_90ck1380 FIND v(dout1_90) AT=1390.05n

.meas tran vdout1_91ck1380 FIND v(dout1_91) AT=1390.05n

.meas tran vdout1_92ck1380 FIND v(dout1_92) AT=1390.05n

.meas tran vdout1_93ck1380 FIND v(dout1_93) AT=1390.05n

.meas tran vdout1_94ck1380 FIND v(dout1_94) AT=1390.05n

.meas tran vdout1_95ck1380 FIND v(dout1_95) AT=1390.05n

.meas tran vdout1_96ck1380 FIND v(dout1_96) AT=1390.05n

.meas tran vdout1_97ck1380 FIND v(dout1_97) AT=1390.05n

.meas tran vdout1_98ck1380 FIND v(dout1_98) AT=1390.05n

.meas tran vdout1_99ck1380 FIND v(dout1_99) AT=1390.05n

.meas tran vdout1_100ck1380 FIND v(dout1_100) AT=1390.05n

.meas tran vdout1_101ck1380 FIND v(dout1_101) AT=1390.05n

.meas tran vdout1_102ck1380 FIND v(dout1_102) AT=1390.05n

.meas tran vdout1_103ck1380 FIND v(dout1_103) AT=1390.05n

.meas tran vdout1_104ck1380 FIND v(dout1_104) AT=1390.05n

.meas tran vdout1_105ck1380 FIND v(dout1_105) AT=1390.05n

.meas tran vdout1_106ck1380 FIND v(dout1_106) AT=1390.05n

.meas tran vdout1_107ck1380 FIND v(dout1_107) AT=1390.05n

.meas tran vdout1_108ck1380 FIND v(dout1_108) AT=1390.05n

.meas tran vdout1_109ck1380 FIND v(dout1_109) AT=1390.05n

.meas tran vdout1_110ck1380 FIND v(dout1_110) AT=1390.05n

.meas tran vdout1_111ck1380 FIND v(dout1_111) AT=1390.05n

.meas tran vdout1_112ck1380 FIND v(dout1_112) AT=1390.05n

.meas tran vdout1_113ck1380 FIND v(dout1_113) AT=1390.05n

.meas tran vdout1_114ck1380 FIND v(dout1_114) AT=1390.05n

.meas tran vdout1_115ck1380 FIND v(dout1_115) AT=1390.05n

.meas tran vdout1_116ck1380 FIND v(dout1_116) AT=1390.05n

.meas tran vdout1_117ck1380 FIND v(dout1_117) AT=1390.05n

.meas tran vdout1_118ck1380 FIND v(dout1_118) AT=1390.05n

.meas tran vdout1_119ck1380 FIND v(dout1_119) AT=1390.05n

.meas tran vdout1_120ck1380 FIND v(dout1_120) AT=1390.05n

.meas tran vdout1_121ck1380 FIND v(dout1_121) AT=1390.05n

.meas tran vdout1_122ck1380 FIND v(dout1_122) AT=1390.05n

.meas tran vdout1_123ck1380 FIND v(dout1_123) AT=1390.05n

.meas tran vdout1_124ck1380 FIND v(dout1_124) AT=1390.05n

.meas tran vdout1_125ck1380 FIND v(dout1_125) AT=1390.05n

.meas tran vdout1_126ck1380 FIND v(dout1_126) AT=1390.05n

.meas tran vdout1_127ck1380 FIND v(dout1_127) AT=1390.05n

.meas tran vdout1_128ck1380 FIND v(dout1_128) AT=1390.05n

.meas tran vdout1_129ck1380 FIND v(dout1_129) AT=1390.05n

.meas tran vdout1_130ck1380 FIND v(dout1_130) AT=1390.05n

.meas tran vdout1_131ck1380 FIND v(dout1_131) AT=1390.05n

.meas tran vdout1_132ck1380 FIND v(dout1_132) AT=1390.05n

.meas tran vdout1_133ck1380 FIND v(dout1_133) AT=1390.05n

.meas tran vdout1_134ck1380 FIND v(dout1_134) AT=1390.05n

.meas tran vdout1_0ck1390 FIND v(dout1_0) AT=1400.05n

.meas tran vdout1_1ck1390 FIND v(dout1_1) AT=1400.05n

.meas tran vdout1_2ck1390 FIND v(dout1_2) AT=1400.05n

.meas tran vdout1_3ck1390 FIND v(dout1_3) AT=1400.05n

.meas tran vdout1_4ck1390 FIND v(dout1_4) AT=1400.05n

.meas tran vdout1_5ck1390 FIND v(dout1_5) AT=1400.05n

.meas tran vdout1_6ck1390 FIND v(dout1_6) AT=1400.05n

.meas tran vdout1_7ck1390 FIND v(dout1_7) AT=1400.05n

.meas tran vdout1_8ck1390 FIND v(dout1_8) AT=1400.05n

.meas tran vdout1_9ck1390 FIND v(dout1_9) AT=1400.05n

.meas tran vdout1_10ck1390 FIND v(dout1_10) AT=1400.05n

.meas tran vdout1_11ck1390 FIND v(dout1_11) AT=1400.05n

.meas tran vdout1_12ck1390 FIND v(dout1_12) AT=1400.05n

.meas tran vdout1_13ck1390 FIND v(dout1_13) AT=1400.05n

.meas tran vdout1_14ck1390 FIND v(dout1_14) AT=1400.05n

.meas tran vdout1_15ck1390 FIND v(dout1_15) AT=1400.05n

.meas tran vdout1_16ck1390 FIND v(dout1_16) AT=1400.05n

.meas tran vdout1_17ck1390 FIND v(dout1_17) AT=1400.05n

.meas tran vdout1_18ck1390 FIND v(dout1_18) AT=1400.05n

.meas tran vdout1_19ck1390 FIND v(dout1_19) AT=1400.05n

.meas tran vdout1_20ck1390 FIND v(dout1_20) AT=1400.05n

.meas tran vdout1_21ck1390 FIND v(dout1_21) AT=1400.05n

.meas tran vdout1_22ck1390 FIND v(dout1_22) AT=1400.05n

.meas tran vdout1_23ck1390 FIND v(dout1_23) AT=1400.05n

.meas tran vdout1_24ck1390 FIND v(dout1_24) AT=1400.05n

.meas tran vdout1_25ck1390 FIND v(dout1_25) AT=1400.05n

.meas tran vdout1_26ck1390 FIND v(dout1_26) AT=1400.05n

.meas tran vdout1_27ck1390 FIND v(dout1_27) AT=1400.05n

.meas tran vdout1_28ck1390 FIND v(dout1_28) AT=1400.05n

.meas tran vdout1_29ck1390 FIND v(dout1_29) AT=1400.05n

.meas tran vdout1_30ck1390 FIND v(dout1_30) AT=1400.05n

.meas tran vdout1_31ck1390 FIND v(dout1_31) AT=1400.05n

.meas tran vdout1_32ck1390 FIND v(dout1_32) AT=1400.05n

.meas tran vdout1_33ck1390 FIND v(dout1_33) AT=1400.05n

.meas tran vdout1_34ck1390 FIND v(dout1_34) AT=1400.05n

.meas tran vdout1_35ck1390 FIND v(dout1_35) AT=1400.05n

.meas tran vdout1_36ck1390 FIND v(dout1_36) AT=1400.05n

.meas tran vdout1_37ck1390 FIND v(dout1_37) AT=1400.05n

.meas tran vdout1_38ck1390 FIND v(dout1_38) AT=1400.05n

.meas tran vdout1_39ck1390 FIND v(dout1_39) AT=1400.05n

.meas tran vdout1_40ck1390 FIND v(dout1_40) AT=1400.05n

.meas tran vdout1_41ck1390 FIND v(dout1_41) AT=1400.05n

.meas tran vdout1_42ck1390 FIND v(dout1_42) AT=1400.05n

.meas tran vdout1_43ck1390 FIND v(dout1_43) AT=1400.05n

.meas tran vdout1_44ck1390 FIND v(dout1_44) AT=1400.05n

.meas tran vdout1_45ck1390 FIND v(dout1_45) AT=1400.05n

.meas tran vdout1_46ck1390 FIND v(dout1_46) AT=1400.05n

.meas tran vdout1_47ck1390 FIND v(dout1_47) AT=1400.05n

.meas tran vdout1_48ck1390 FIND v(dout1_48) AT=1400.05n

.meas tran vdout1_49ck1390 FIND v(dout1_49) AT=1400.05n

.meas tran vdout1_50ck1390 FIND v(dout1_50) AT=1400.05n

.meas tran vdout1_51ck1390 FIND v(dout1_51) AT=1400.05n

.meas tran vdout1_52ck1390 FIND v(dout1_52) AT=1400.05n

.meas tran vdout1_53ck1390 FIND v(dout1_53) AT=1400.05n

.meas tran vdout1_54ck1390 FIND v(dout1_54) AT=1400.05n

.meas tran vdout1_55ck1390 FIND v(dout1_55) AT=1400.05n

.meas tran vdout1_56ck1390 FIND v(dout1_56) AT=1400.05n

.meas tran vdout1_57ck1390 FIND v(dout1_57) AT=1400.05n

.meas tran vdout1_58ck1390 FIND v(dout1_58) AT=1400.05n

.meas tran vdout1_59ck1390 FIND v(dout1_59) AT=1400.05n

.meas tran vdout1_60ck1390 FIND v(dout1_60) AT=1400.05n

.meas tran vdout1_61ck1390 FIND v(dout1_61) AT=1400.05n

.meas tran vdout1_62ck1390 FIND v(dout1_62) AT=1400.05n

.meas tran vdout1_63ck1390 FIND v(dout1_63) AT=1400.05n

.meas tran vdout1_64ck1390 FIND v(dout1_64) AT=1400.05n

.meas tran vdout1_65ck1390 FIND v(dout1_65) AT=1400.05n

.meas tran vdout1_66ck1390 FIND v(dout1_66) AT=1400.05n

.meas tran vdout1_67ck1390 FIND v(dout1_67) AT=1400.05n

.meas tran vdout1_68ck1390 FIND v(dout1_68) AT=1400.05n

.meas tran vdout1_69ck1390 FIND v(dout1_69) AT=1400.05n

.meas tran vdout1_70ck1390 FIND v(dout1_70) AT=1400.05n

.meas tran vdout1_71ck1390 FIND v(dout1_71) AT=1400.05n

.meas tran vdout1_72ck1390 FIND v(dout1_72) AT=1400.05n

.meas tran vdout1_73ck1390 FIND v(dout1_73) AT=1400.05n

.meas tran vdout1_74ck1390 FIND v(dout1_74) AT=1400.05n

.meas tran vdout1_75ck1390 FIND v(dout1_75) AT=1400.05n

.meas tran vdout1_76ck1390 FIND v(dout1_76) AT=1400.05n

.meas tran vdout1_77ck1390 FIND v(dout1_77) AT=1400.05n

.meas tran vdout1_78ck1390 FIND v(dout1_78) AT=1400.05n

.meas tran vdout1_79ck1390 FIND v(dout1_79) AT=1400.05n

.meas tran vdout1_80ck1390 FIND v(dout1_80) AT=1400.05n

.meas tran vdout1_81ck1390 FIND v(dout1_81) AT=1400.05n

.meas tran vdout1_82ck1390 FIND v(dout1_82) AT=1400.05n

.meas tran vdout1_83ck1390 FIND v(dout1_83) AT=1400.05n

.meas tran vdout1_84ck1390 FIND v(dout1_84) AT=1400.05n

.meas tran vdout1_85ck1390 FIND v(dout1_85) AT=1400.05n

.meas tran vdout1_86ck1390 FIND v(dout1_86) AT=1400.05n

.meas tran vdout1_87ck1390 FIND v(dout1_87) AT=1400.05n

.meas tran vdout1_88ck1390 FIND v(dout1_88) AT=1400.05n

.meas tran vdout1_89ck1390 FIND v(dout1_89) AT=1400.05n

.meas tran vdout1_90ck1390 FIND v(dout1_90) AT=1400.05n

.meas tran vdout1_91ck1390 FIND v(dout1_91) AT=1400.05n

.meas tran vdout1_92ck1390 FIND v(dout1_92) AT=1400.05n

.meas tran vdout1_93ck1390 FIND v(dout1_93) AT=1400.05n

.meas tran vdout1_94ck1390 FIND v(dout1_94) AT=1400.05n

.meas tran vdout1_95ck1390 FIND v(dout1_95) AT=1400.05n

.meas tran vdout1_96ck1390 FIND v(dout1_96) AT=1400.05n

.meas tran vdout1_97ck1390 FIND v(dout1_97) AT=1400.05n

.meas tran vdout1_98ck1390 FIND v(dout1_98) AT=1400.05n

.meas tran vdout1_99ck1390 FIND v(dout1_99) AT=1400.05n

.meas tran vdout1_100ck1390 FIND v(dout1_100) AT=1400.05n

.meas tran vdout1_101ck1390 FIND v(dout1_101) AT=1400.05n

.meas tran vdout1_102ck1390 FIND v(dout1_102) AT=1400.05n

.meas tran vdout1_103ck1390 FIND v(dout1_103) AT=1400.05n

.meas tran vdout1_104ck1390 FIND v(dout1_104) AT=1400.05n

.meas tran vdout1_105ck1390 FIND v(dout1_105) AT=1400.05n

.meas tran vdout1_106ck1390 FIND v(dout1_106) AT=1400.05n

.meas tran vdout1_107ck1390 FIND v(dout1_107) AT=1400.05n

.meas tran vdout1_108ck1390 FIND v(dout1_108) AT=1400.05n

.meas tran vdout1_109ck1390 FIND v(dout1_109) AT=1400.05n

.meas tran vdout1_110ck1390 FIND v(dout1_110) AT=1400.05n

.meas tran vdout1_111ck1390 FIND v(dout1_111) AT=1400.05n

.meas tran vdout1_112ck1390 FIND v(dout1_112) AT=1400.05n

.meas tran vdout1_113ck1390 FIND v(dout1_113) AT=1400.05n

.meas tran vdout1_114ck1390 FIND v(dout1_114) AT=1400.05n

.meas tran vdout1_115ck1390 FIND v(dout1_115) AT=1400.05n

.meas tran vdout1_116ck1390 FIND v(dout1_116) AT=1400.05n

.meas tran vdout1_117ck1390 FIND v(dout1_117) AT=1400.05n

.meas tran vdout1_118ck1390 FIND v(dout1_118) AT=1400.05n

.meas tran vdout1_119ck1390 FIND v(dout1_119) AT=1400.05n

.meas tran vdout1_120ck1390 FIND v(dout1_120) AT=1400.05n

.meas tran vdout1_121ck1390 FIND v(dout1_121) AT=1400.05n

.meas tran vdout1_122ck1390 FIND v(dout1_122) AT=1400.05n

.meas tran vdout1_123ck1390 FIND v(dout1_123) AT=1400.05n

.meas tran vdout1_124ck1390 FIND v(dout1_124) AT=1400.05n

.meas tran vdout1_125ck1390 FIND v(dout1_125) AT=1400.05n

.meas tran vdout1_126ck1390 FIND v(dout1_126) AT=1400.05n

.meas tran vdout1_127ck1390 FIND v(dout1_127) AT=1400.05n

.meas tran vdout1_128ck1390 FIND v(dout1_128) AT=1400.05n

.meas tran vdout1_129ck1390 FIND v(dout1_129) AT=1400.05n

.meas tran vdout1_130ck1390 FIND v(dout1_130) AT=1400.05n

.meas tran vdout1_131ck1390 FIND v(dout1_131) AT=1400.05n

.meas tran vdout1_132ck1390 FIND v(dout1_132) AT=1400.05n

.meas tran vdout1_133ck1390 FIND v(dout1_133) AT=1400.05n

.meas tran vdout1_134ck1390 FIND v(dout1_134) AT=1400.05n

.meas tran vdout1_0ck1400 FIND v(dout1_0) AT=1410.05n

.meas tran vdout1_1ck1400 FIND v(dout1_1) AT=1410.05n

.meas tran vdout1_2ck1400 FIND v(dout1_2) AT=1410.05n

.meas tran vdout1_3ck1400 FIND v(dout1_3) AT=1410.05n

.meas tran vdout1_4ck1400 FIND v(dout1_4) AT=1410.05n

.meas tran vdout1_5ck1400 FIND v(dout1_5) AT=1410.05n

.meas tran vdout1_6ck1400 FIND v(dout1_6) AT=1410.05n

.meas tran vdout1_7ck1400 FIND v(dout1_7) AT=1410.05n

.meas tran vdout1_8ck1400 FIND v(dout1_8) AT=1410.05n

.meas tran vdout1_9ck1400 FIND v(dout1_9) AT=1410.05n

.meas tran vdout1_10ck1400 FIND v(dout1_10) AT=1410.05n

.meas tran vdout1_11ck1400 FIND v(dout1_11) AT=1410.05n

.meas tran vdout1_12ck1400 FIND v(dout1_12) AT=1410.05n

.meas tran vdout1_13ck1400 FIND v(dout1_13) AT=1410.05n

.meas tran vdout1_14ck1400 FIND v(dout1_14) AT=1410.05n

.meas tran vdout1_15ck1400 FIND v(dout1_15) AT=1410.05n

.meas tran vdout1_16ck1400 FIND v(dout1_16) AT=1410.05n

.meas tran vdout1_17ck1400 FIND v(dout1_17) AT=1410.05n

.meas tran vdout1_18ck1400 FIND v(dout1_18) AT=1410.05n

.meas tran vdout1_19ck1400 FIND v(dout1_19) AT=1410.05n

.meas tran vdout1_20ck1400 FIND v(dout1_20) AT=1410.05n

.meas tran vdout1_21ck1400 FIND v(dout1_21) AT=1410.05n

.meas tran vdout1_22ck1400 FIND v(dout1_22) AT=1410.05n

.meas tran vdout1_23ck1400 FIND v(dout1_23) AT=1410.05n

.meas tran vdout1_24ck1400 FIND v(dout1_24) AT=1410.05n

.meas tran vdout1_25ck1400 FIND v(dout1_25) AT=1410.05n

.meas tran vdout1_26ck1400 FIND v(dout1_26) AT=1410.05n

.meas tran vdout1_27ck1400 FIND v(dout1_27) AT=1410.05n

.meas tran vdout1_28ck1400 FIND v(dout1_28) AT=1410.05n

.meas tran vdout1_29ck1400 FIND v(dout1_29) AT=1410.05n

.meas tran vdout1_30ck1400 FIND v(dout1_30) AT=1410.05n

.meas tran vdout1_31ck1400 FIND v(dout1_31) AT=1410.05n

.meas tran vdout1_32ck1400 FIND v(dout1_32) AT=1410.05n

.meas tran vdout1_33ck1400 FIND v(dout1_33) AT=1410.05n

.meas tran vdout1_34ck1400 FIND v(dout1_34) AT=1410.05n

.meas tran vdout1_35ck1400 FIND v(dout1_35) AT=1410.05n

.meas tran vdout1_36ck1400 FIND v(dout1_36) AT=1410.05n

.meas tran vdout1_37ck1400 FIND v(dout1_37) AT=1410.05n

.meas tran vdout1_38ck1400 FIND v(dout1_38) AT=1410.05n

.meas tran vdout1_39ck1400 FIND v(dout1_39) AT=1410.05n

.meas tran vdout1_40ck1400 FIND v(dout1_40) AT=1410.05n

.meas tran vdout1_41ck1400 FIND v(dout1_41) AT=1410.05n

.meas tran vdout1_42ck1400 FIND v(dout1_42) AT=1410.05n

.meas tran vdout1_43ck1400 FIND v(dout1_43) AT=1410.05n

.meas tran vdout1_44ck1400 FIND v(dout1_44) AT=1410.05n

.meas tran vdout1_45ck1400 FIND v(dout1_45) AT=1410.05n

.meas tran vdout1_46ck1400 FIND v(dout1_46) AT=1410.05n

.meas tran vdout1_47ck1400 FIND v(dout1_47) AT=1410.05n

.meas tran vdout1_48ck1400 FIND v(dout1_48) AT=1410.05n

.meas tran vdout1_49ck1400 FIND v(dout1_49) AT=1410.05n

.meas tran vdout1_50ck1400 FIND v(dout1_50) AT=1410.05n

.meas tran vdout1_51ck1400 FIND v(dout1_51) AT=1410.05n

.meas tran vdout1_52ck1400 FIND v(dout1_52) AT=1410.05n

.meas tran vdout1_53ck1400 FIND v(dout1_53) AT=1410.05n

.meas tran vdout1_54ck1400 FIND v(dout1_54) AT=1410.05n

.meas tran vdout1_55ck1400 FIND v(dout1_55) AT=1410.05n

.meas tran vdout1_56ck1400 FIND v(dout1_56) AT=1410.05n

.meas tran vdout1_57ck1400 FIND v(dout1_57) AT=1410.05n

.meas tran vdout1_58ck1400 FIND v(dout1_58) AT=1410.05n

.meas tran vdout1_59ck1400 FIND v(dout1_59) AT=1410.05n

.meas tran vdout1_60ck1400 FIND v(dout1_60) AT=1410.05n

.meas tran vdout1_61ck1400 FIND v(dout1_61) AT=1410.05n

.meas tran vdout1_62ck1400 FIND v(dout1_62) AT=1410.05n

.meas tran vdout1_63ck1400 FIND v(dout1_63) AT=1410.05n

.meas tran vdout1_64ck1400 FIND v(dout1_64) AT=1410.05n

.meas tran vdout1_65ck1400 FIND v(dout1_65) AT=1410.05n

.meas tran vdout1_66ck1400 FIND v(dout1_66) AT=1410.05n

.meas tran vdout1_67ck1400 FIND v(dout1_67) AT=1410.05n

.meas tran vdout1_68ck1400 FIND v(dout1_68) AT=1410.05n

.meas tran vdout1_69ck1400 FIND v(dout1_69) AT=1410.05n

.meas tran vdout1_70ck1400 FIND v(dout1_70) AT=1410.05n

.meas tran vdout1_71ck1400 FIND v(dout1_71) AT=1410.05n

.meas tran vdout1_72ck1400 FIND v(dout1_72) AT=1410.05n

.meas tran vdout1_73ck1400 FIND v(dout1_73) AT=1410.05n

.meas tran vdout1_74ck1400 FIND v(dout1_74) AT=1410.05n

.meas tran vdout1_75ck1400 FIND v(dout1_75) AT=1410.05n

.meas tran vdout1_76ck1400 FIND v(dout1_76) AT=1410.05n

.meas tran vdout1_77ck1400 FIND v(dout1_77) AT=1410.05n

.meas tran vdout1_78ck1400 FIND v(dout1_78) AT=1410.05n

.meas tran vdout1_79ck1400 FIND v(dout1_79) AT=1410.05n

.meas tran vdout1_80ck1400 FIND v(dout1_80) AT=1410.05n

.meas tran vdout1_81ck1400 FIND v(dout1_81) AT=1410.05n

.meas tran vdout1_82ck1400 FIND v(dout1_82) AT=1410.05n

.meas tran vdout1_83ck1400 FIND v(dout1_83) AT=1410.05n

.meas tran vdout1_84ck1400 FIND v(dout1_84) AT=1410.05n

.meas tran vdout1_85ck1400 FIND v(dout1_85) AT=1410.05n

.meas tran vdout1_86ck1400 FIND v(dout1_86) AT=1410.05n

.meas tran vdout1_87ck1400 FIND v(dout1_87) AT=1410.05n

.meas tran vdout1_88ck1400 FIND v(dout1_88) AT=1410.05n

.meas tran vdout1_89ck1400 FIND v(dout1_89) AT=1410.05n

.meas tran vdout1_90ck1400 FIND v(dout1_90) AT=1410.05n

.meas tran vdout1_91ck1400 FIND v(dout1_91) AT=1410.05n

.meas tran vdout1_92ck1400 FIND v(dout1_92) AT=1410.05n

.meas tran vdout1_93ck1400 FIND v(dout1_93) AT=1410.05n

.meas tran vdout1_94ck1400 FIND v(dout1_94) AT=1410.05n

.meas tran vdout1_95ck1400 FIND v(dout1_95) AT=1410.05n

.meas tran vdout1_96ck1400 FIND v(dout1_96) AT=1410.05n

.meas tran vdout1_97ck1400 FIND v(dout1_97) AT=1410.05n

.meas tran vdout1_98ck1400 FIND v(dout1_98) AT=1410.05n

.meas tran vdout1_99ck1400 FIND v(dout1_99) AT=1410.05n

.meas tran vdout1_100ck1400 FIND v(dout1_100) AT=1410.05n

.meas tran vdout1_101ck1400 FIND v(dout1_101) AT=1410.05n

.meas tran vdout1_102ck1400 FIND v(dout1_102) AT=1410.05n

.meas tran vdout1_103ck1400 FIND v(dout1_103) AT=1410.05n

.meas tran vdout1_104ck1400 FIND v(dout1_104) AT=1410.05n

.meas tran vdout1_105ck1400 FIND v(dout1_105) AT=1410.05n

.meas tran vdout1_106ck1400 FIND v(dout1_106) AT=1410.05n

.meas tran vdout1_107ck1400 FIND v(dout1_107) AT=1410.05n

.meas tran vdout1_108ck1400 FIND v(dout1_108) AT=1410.05n

.meas tran vdout1_109ck1400 FIND v(dout1_109) AT=1410.05n

.meas tran vdout1_110ck1400 FIND v(dout1_110) AT=1410.05n

.meas tran vdout1_111ck1400 FIND v(dout1_111) AT=1410.05n

.meas tran vdout1_112ck1400 FIND v(dout1_112) AT=1410.05n

.meas tran vdout1_113ck1400 FIND v(dout1_113) AT=1410.05n

.meas tran vdout1_114ck1400 FIND v(dout1_114) AT=1410.05n

.meas tran vdout1_115ck1400 FIND v(dout1_115) AT=1410.05n

.meas tran vdout1_116ck1400 FIND v(dout1_116) AT=1410.05n

.meas tran vdout1_117ck1400 FIND v(dout1_117) AT=1410.05n

.meas tran vdout1_118ck1400 FIND v(dout1_118) AT=1410.05n

.meas tran vdout1_119ck1400 FIND v(dout1_119) AT=1410.05n

.meas tran vdout1_120ck1400 FIND v(dout1_120) AT=1410.05n

.meas tran vdout1_121ck1400 FIND v(dout1_121) AT=1410.05n

.meas tran vdout1_122ck1400 FIND v(dout1_122) AT=1410.05n

.meas tran vdout1_123ck1400 FIND v(dout1_123) AT=1410.05n

.meas tran vdout1_124ck1400 FIND v(dout1_124) AT=1410.05n

.meas tran vdout1_125ck1400 FIND v(dout1_125) AT=1410.05n

.meas tran vdout1_126ck1400 FIND v(dout1_126) AT=1410.05n

.meas tran vdout1_127ck1400 FIND v(dout1_127) AT=1410.05n

.meas tran vdout1_128ck1400 FIND v(dout1_128) AT=1410.05n

.meas tran vdout1_129ck1400 FIND v(dout1_129) AT=1410.05n

.meas tran vdout1_130ck1400 FIND v(dout1_130) AT=1410.05n

.meas tran vdout1_131ck1400 FIND v(dout1_131) AT=1410.05n

.meas tran vdout1_132ck1400 FIND v(dout1_132) AT=1410.05n

.meas tran vdout1_133ck1400 FIND v(dout1_133) AT=1410.05n

.meas tran vdout1_134ck1400 FIND v(dout1_134) AT=1410.05n

.meas tran vdout1_0ck1420 FIND v(dout1_0) AT=1430.05n

.meas tran vdout1_1ck1420 FIND v(dout1_1) AT=1430.05n

.meas tran vdout1_2ck1420 FIND v(dout1_2) AT=1430.05n

.meas tran vdout1_3ck1420 FIND v(dout1_3) AT=1430.05n

.meas tran vdout1_4ck1420 FIND v(dout1_4) AT=1430.05n

.meas tran vdout1_5ck1420 FIND v(dout1_5) AT=1430.05n

.meas tran vdout1_6ck1420 FIND v(dout1_6) AT=1430.05n

.meas tran vdout1_7ck1420 FIND v(dout1_7) AT=1430.05n

.meas tran vdout1_8ck1420 FIND v(dout1_8) AT=1430.05n

.meas tran vdout1_9ck1420 FIND v(dout1_9) AT=1430.05n

.meas tran vdout1_10ck1420 FIND v(dout1_10) AT=1430.05n

.meas tran vdout1_11ck1420 FIND v(dout1_11) AT=1430.05n

.meas tran vdout1_12ck1420 FIND v(dout1_12) AT=1430.05n

.meas tran vdout1_13ck1420 FIND v(dout1_13) AT=1430.05n

.meas tran vdout1_14ck1420 FIND v(dout1_14) AT=1430.05n

.meas tran vdout1_15ck1420 FIND v(dout1_15) AT=1430.05n

.meas tran vdout1_16ck1420 FIND v(dout1_16) AT=1430.05n

.meas tran vdout1_17ck1420 FIND v(dout1_17) AT=1430.05n

.meas tran vdout1_18ck1420 FIND v(dout1_18) AT=1430.05n

.meas tran vdout1_19ck1420 FIND v(dout1_19) AT=1430.05n

.meas tran vdout1_20ck1420 FIND v(dout1_20) AT=1430.05n

.meas tran vdout1_21ck1420 FIND v(dout1_21) AT=1430.05n

.meas tran vdout1_22ck1420 FIND v(dout1_22) AT=1430.05n

.meas tran vdout1_23ck1420 FIND v(dout1_23) AT=1430.05n

.meas tran vdout1_24ck1420 FIND v(dout1_24) AT=1430.05n

.meas tran vdout1_25ck1420 FIND v(dout1_25) AT=1430.05n

.meas tran vdout1_26ck1420 FIND v(dout1_26) AT=1430.05n

.meas tran vdout1_27ck1420 FIND v(dout1_27) AT=1430.05n

.meas tran vdout1_28ck1420 FIND v(dout1_28) AT=1430.05n

.meas tran vdout1_29ck1420 FIND v(dout1_29) AT=1430.05n

.meas tran vdout1_30ck1420 FIND v(dout1_30) AT=1430.05n

.meas tran vdout1_31ck1420 FIND v(dout1_31) AT=1430.05n

.meas tran vdout1_32ck1420 FIND v(dout1_32) AT=1430.05n

.meas tran vdout1_33ck1420 FIND v(dout1_33) AT=1430.05n

.meas tran vdout1_34ck1420 FIND v(dout1_34) AT=1430.05n

.meas tran vdout1_35ck1420 FIND v(dout1_35) AT=1430.05n

.meas tran vdout1_36ck1420 FIND v(dout1_36) AT=1430.05n

.meas tran vdout1_37ck1420 FIND v(dout1_37) AT=1430.05n

.meas tran vdout1_38ck1420 FIND v(dout1_38) AT=1430.05n

.meas tran vdout1_39ck1420 FIND v(dout1_39) AT=1430.05n

.meas tran vdout1_40ck1420 FIND v(dout1_40) AT=1430.05n

.meas tran vdout1_41ck1420 FIND v(dout1_41) AT=1430.05n

.meas tran vdout1_42ck1420 FIND v(dout1_42) AT=1430.05n

.meas tran vdout1_43ck1420 FIND v(dout1_43) AT=1430.05n

.meas tran vdout1_44ck1420 FIND v(dout1_44) AT=1430.05n

.meas tran vdout1_45ck1420 FIND v(dout1_45) AT=1430.05n

.meas tran vdout1_46ck1420 FIND v(dout1_46) AT=1430.05n

.meas tran vdout1_47ck1420 FIND v(dout1_47) AT=1430.05n

.meas tran vdout1_48ck1420 FIND v(dout1_48) AT=1430.05n

.meas tran vdout1_49ck1420 FIND v(dout1_49) AT=1430.05n

.meas tran vdout1_50ck1420 FIND v(dout1_50) AT=1430.05n

.meas tran vdout1_51ck1420 FIND v(dout1_51) AT=1430.05n

.meas tran vdout1_52ck1420 FIND v(dout1_52) AT=1430.05n

.meas tran vdout1_53ck1420 FIND v(dout1_53) AT=1430.05n

.meas tran vdout1_54ck1420 FIND v(dout1_54) AT=1430.05n

.meas tran vdout1_55ck1420 FIND v(dout1_55) AT=1430.05n

.meas tran vdout1_56ck1420 FIND v(dout1_56) AT=1430.05n

.meas tran vdout1_57ck1420 FIND v(dout1_57) AT=1430.05n

.meas tran vdout1_58ck1420 FIND v(dout1_58) AT=1430.05n

.meas tran vdout1_59ck1420 FIND v(dout1_59) AT=1430.05n

.meas tran vdout1_60ck1420 FIND v(dout1_60) AT=1430.05n

.meas tran vdout1_61ck1420 FIND v(dout1_61) AT=1430.05n

.meas tran vdout1_62ck1420 FIND v(dout1_62) AT=1430.05n

.meas tran vdout1_63ck1420 FIND v(dout1_63) AT=1430.05n

.meas tran vdout1_64ck1420 FIND v(dout1_64) AT=1430.05n

.meas tran vdout1_65ck1420 FIND v(dout1_65) AT=1430.05n

.meas tran vdout1_66ck1420 FIND v(dout1_66) AT=1430.05n

.meas tran vdout1_67ck1420 FIND v(dout1_67) AT=1430.05n

.meas tran vdout1_68ck1420 FIND v(dout1_68) AT=1430.05n

.meas tran vdout1_69ck1420 FIND v(dout1_69) AT=1430.05n

.meas tran vdout1_70ck1420 FIND v(dout1_70) AT=1430.05n

.meas tran vdout1_71ck1420 FIND v(dout1_71) AT=1430.05n

.meas tran vdout1_72ck1420 FIND v(dout1_72) AT=1430.05n

.meas tran vdout1_73ck1420 FIND v(dout1_73) AT=1430.05n

.meas tran vdout1_74ck1420 FIND v(dout1_74) AT=1430.05n

.meas tran vdout1_75ck1420 FIND v(dout1_75) AT=1430.05n

.meas tran vdout1_76ck1420 FIND v(dout1_76) AT=1430.05n

.meas tran vdout1_77ck1420 FIND v(dout1_77) AT=1430.05n

.meas tran vdout1_78ck1420 FIND v(dout1_78) AT=1430.05n

.meas tran vdout1_79ck1420 FIND v(dout1_79) AT=1430.05n

.meas tran vdout1_80ck1420 FIND v(dout1_80) AT=1430.05n

.meas tran vdout1_81ck1420 FIND v(dout1_81) AT=1430.05n

.meas tran vdout1_82ck1420 FIND v(dout1_82) AT=1430.05n

.meas tran vdout1_83ck1420 FIND v(dout1_83) AT=1430.05n

.meas tran vdout1_84ck1420 FIND v(dout1_84) AT=1430.05n

.meas tran vdout1_85ck1420 FIND v(dout1_85) AT=1430.05n

.meas tran vdout1_86ck1420 FIND v(dout1_86) AT=1430.05n

.meas tran vdout1_87ck1420 FIND v(dout1_87) AT=1430.05n

.meas tran vdout1_88ck1420 FIND v(dout1_88) AT=1430.05n

.meas tran vdout1_89ck1420 FIND v(dout1_89) AT=1430.05n

.meas tran vdout1_90ck1420 FIND v(dout1_90) AT=1430.05n

.meas tran vdout1_91ck1420 FIND v(dout1_91) AT=1430.05n

.meas tran vdout1_92ck1420 FIND v(dout1_92) AT=1430.05n

.meas tran vdout1_93ck1420 FIND v(dout1_93) AT=1430.05n

.meas tran vdout1_94ck1420 FIND v(dout1_94) AT=1430.05n

.meas tran vdout1_95ck1420 FIND v(dout1_95) AT=1430.05n

.meas tran vdout1_96ck1420 FIND v(dout1_96) AT=1430.05n

.meas tran vdout1_97ck1420 FIND v(dout1_97) AT=1430.05n

.meas tran vdout1_98ck1420 FIND v(dout1_98) AT=1430.05n

.meas tran vdout1_99ck1420 FIND v(dout1_99) AT=1430.05n

.meas tran vdout1_100ck1420 FIND v(dout1_100) AT=1430.05n

.meas tran vdout1_101ck1420 FIND v(dout1_101) AT=1430.05n

.meas tran vdout1_102ck1420 FIND v(dout1_102) AT=1430.05n

.meas tran vdout1_103ck1420 FIND v(dout1_103) AT=1430.05n

.meas tran vdout1_104ck1420 FIND v(dout1_104) AT=1430.05n

.meas tran vdout1_105ck1420 FIND v(dout1_105) AT=1430.05n

.meas tran vdout1_106ck1420 FIND v(dout1_106) AT=1430.05n

.meas tran vdout1_107ck1420 FIND v(dout1_107) AT=1430.05n

.meas tran vdout1_108ck1420 FIND v(dout1_108) AT=1430.05n

.meas tran vdout1_109ck1420 FIND v(dout1_109) AT=1430.05n

.meas tran vdout1_110ck1420 FIND v(dout1_110) AT=1430.05n

.meas tran vdout1_111ck1420 FIND v(dout1_111) AT=1430.05n

.meas tran vdout1_112ck1420 FIND v(dout1_112) AT=1430.05n

.meas tran vdout1_113ck1420 FIND v(dout1_113) AT=1430.05n

.meas tran vdout1_114ck1420 FIND v(dout1_114) AT=1430.05n

.meas tran vdout1_115ck1420 FIND v(dout1_115) AT=1430.05n

.meas tran vdout1_116ck1420 FIND v(dout1_116) AT=1430.05n

.meas tran vdout1_117ck1420 FIND v(dout1_117) AT=1430.05n

.meas tran vdout1_118ck1420 FIND v(dout1_118) AT=1430.05n

.meas tran vdout1_119ck1420 FIND v(dout1_119) AT=1430.05n

.meas tran vdout1_120ck1420 FIND v(dout1_120) AT=1430.05n

.meas tran vdout1_121ck1420 FIND v(dout1_121) AT=1430.05n

.meas tran vdout1_122ck1420 FIND v(dout1_122) AT=1430.05n

.meas tran vdout1_123ck1420 FIND v(dout1_123) AT=1430.05n

.meas tran vdout1_124ck1420 FIND v(dout1_124) AT=1430.05n

.meas tran vdout1_125ck1420 FIND v(dout1_125) AT=1430.05n

.meas tran vdout1_126ck1420 FIND v(dout1_126) AT=1430.05n

.meas tran vdout1_127ck1420 FIND v(dout1_127) AT=1430.05n

.meas tran vdout1_128ck1420 FIND v(dout1_128) AT=1430.05n

.meas tran vdout1_129ck1420 FIND v(dout1_129) AT=1430.05n

.meas tran vdout1_130ck1420 FIND v(dout1_130) AT=1430.05n

.meas tran vdout1_131ck1420 FIND v(dout1_131) AT=1430.05n

.meas tran vdout1_132ck1420 FIND v(dout1_132) AT=1430.05n

.meas tran vdout1_133ck1420 FIND v(dout1_133) AT=1430.05n

.meas tran vdout1_134ck1420 FIND v(dout1_134) AT=1430.05n

.meas tran vdout1_0ck1430 FIND v(dout1_0) AT=1440.05n

.meas tran vdout1_1ck1430 FIND v(dout1_1) AT=1440.05n

.meas tran vdout1_2ck1430 FIND v(dout1_2) AT=1440.05n

.meas tran vdout1_3ck1430 FIND v(dout1_3) AT=1440.05n

.meas tran vdout1_4ck1430 FIND v(dout1_4) AT=1440.05n

.meas tran vdout1_5ck1430 FIND v(dout1_5) AT=1440.05n

.meas tran vdout1_6ck1430 FIND v(dout1_6) AT=1440.05n

.meas tran vdout1_7ck1430 FIND v(dout1_7) AT=1440.05n

.meas tran vdout1_8ck1430 FIND v(dout1_8) AT=1440.05n

.meas tran vdout1_9ck1430 FIND v(dout1_9) AT=1440.05n

.meas tran vdout1_10ck1430 FIND v(dout1_10) AT=1440.05n

.meas tran vdout1_11ck1430 FIND v(dout1_11) AT=1440.05n

.meas tran vdout1_12ck1430 FIND v(dout1_12) AT=1440.05n

.meas tran vdout1_13ck1430 FIND v(dout1_13) AT=1440.05n

.meas tran vdout1_14ck1430 FIND v(dout1_14) AT=1440.05n

.meas tran vdout1_15ck1430 FIND v(dout1_15) AT=1440.05n

.meas tran vdout1_16ck1430 FIND v(dout1_16) AT=1440.05n

.meas tran vdout1_17ck1430 FIND v(dout1_17) AT=1440.05n

.meas tran vdout1_18ck1430 FIND v(dout1_18) AT=1440.05n

.meas tran vdout1_19ck1430 FIND v(dout1_19) AT=1440.05n

.meas tran vdout1_20ck1430 FIND v(dout1_20) AT=1440.05n

.meas tran vdout1_21ck1430 FIND v(dout1_21) AT=1440.05n

.meas tran vdout1_22ck1430 FIND v(dout1_22) AT=1440.05n

.meas tran vdout1_23ck1430 FIND v(dout1_23) AT=1440.05n

.meas tran vdout1_24ck1430 FIND v(dout1_24) AT=1440.05n

.meas tran vdout1_25ck1430 FIND v(dout1_25) AT=1440.05n

.meas tran vdout1_26ck1430 FIND v(dout1_26) AT=1440.05n

.meas tran vdout1_27ck1430 FIND v(dout1_27) AT=1440.05n

.meas tran vdout1_28ck1430 FIND v(dout1_28) AT=1440.05n

.meas tran vdout1_29ck1430 FIND v(dout1_29) AT=1440.05n

.meas tran vdout1_30ck1430 FIND v(dout1_30) AT=1440.05n

.meas tran vdout1_31ck1430 FIND v(dout1_31) AT=1440.05n

.meas tran vdout1_32ck1430 FIND v(dout1_32) AT=1440.05n

.meas tran vdout1_33ck1430 FIND v(dout1_33) AT=1440.05n

.meas tran vdout1_34ck1430 FIND v(dout1_34) AT=1440.05n

.meas tran vdout1_35ck1430 FIND v(dout1_35) AT=1440.05n

.meas tran vdout1_36ck1430 FIND v(dout1_36) AT=1440.05n

.meas tran vdout1_37ck1430 FIND v(dout1_37) AT=1440.05n

.meas tran vdout1_38ck1430 FIND v(dout1_38) AT=1440.05n

.meas tran vdout1_39ck1430 FIND v(dout1_39) AT=1440.05n

.meas tran vdout1_40ck1430 FIND v(dout1_40) AT=1440.05n

.meas tran vdout1_41ck1430 FIND v(dout1_41) AT=1440.05n

.meas tran vdout1_42ck1430 FIND v(dout1_42) AT=1440.05n

.meas tran vdout1_43ck1430 FIND v(dout1_43) AT=1440.05n

.meas tran vdout1_44ck1430 FIND v(dout1_44) AT=1440.05n

.meas tran vdout1_45ck1430 FIND v(dout1_45) AT=1440.05n

.meas tran vdout1_46ck1430 FIND v(dout1_46) AT=1440.05n

.meas tran vdout1_47ck1430 FIND v(dout1_47) AT=1440.05n

.meas tran vdout1_48ck1430 FIND v(dout1_48) AT=1440.05n

.meas tran vdout1_49ck1430 FIND v(dout1_49) AT=1440.05n

.meas tran vdout1_50ck1430 FIND v(dout1_50) AT=1440.05n

.meas tran vdout1_51ck1430 FIND v(dout1_51) AT=1440.05n

.meas tran vdout1_52ck1430 FIND v(dout1_52) AT=1440.05n

.meas tran vdout1_53ck1430 FIND v(dout1_53) AT=1440.05n

.meas tran vdout1_54ck1430 FIND v(dout1_54) AT=1440.05n

.meas tran vdout1_55ck1430 FIND v(dout1_55) AT=1440.05n

.meas tran vdout1_56ck1430 FIND v(dout1_56) AT=1440.05n

.meas tran vdout1_57ck1430 FIND v(dout1_57) AT=1440.05n

.meas tran vdout1_58ck1430 FIND v(dout1_58) AT=1440.05n

.meas tran vdout1_59ck1430 FIND v(dout1_59) AT=1440.05n

.meas tran vdout1_60ck1430 FIND v(dout1_60) AT=1440.05n

.meas tran vdout1_61ck1430 FIND v(dout1_61) AT=1440.05n

.meas tran vdout1_62ck1430 FIND v(dout1_62) AT=1440.05n

.meas tran vdout1_63ck1430 FIND v(dout1_63) AT=1440.05n

.meas tran vdout1_64ck1430 FIND v(dout1_64) AT=1440.05n

.meas tran vdout1_65ck1430 FIND v(dout1_65) AT=1440.05n

.meas tran vdout1_66ck1430 FIND v(dout1_66) AT=1440.05n

.meas tran vdout1_67ck1430 FIND v(dout1_67) AT=1440.05n

.meas tran vdout1_68ck1430 FIND v(dout1_68) AT=1440.05n

.meas tran vdout1_69ck1430 FIND v(dout1_69) AT=1440.05n

.meas tran vdout1_70ck1430 FIND v(dout1_70) AT=1440.05n

.meas tran vdout1_71ck1430 FIND v(dout1_71) AT=1440.05n

.meas tran vdout1_72ck1430 FIND v(dout1_72) AT=1440.05n

.meas tran vdout1_73ck1430 FIND v(dout1_73) AT=1440.05n

.meas tran vdout1_74ck1430 FIND v(dout1_74) AT=1440.05n

.meas tran vdout1_75ck1430 FIND v(dout1_75) AT=1440.05n

.meas tran vdout1_76ck1430 FIND v(dout1_76) AT=1440.05n

.meas tran vdout1_77ck1430 FIND v(dout1_77) AT=1440.05n

.meas tran vdout1_78ck1430 FIND v(dout1_78) AT=1440.05n

.meas tran vdout1_79ck1430 FIND v(dout1_79) AT=1440.05n

.meas tran vdout1_80ck1430 FIND v(dout1_80) AT=1440.05n

.meas tran vdout1_81ck1430 FIND v(dout1_81) AT=1440.05n

.meas tran vdout1_82ck1430 FIND v(dout1_82) AT=1440.05n

.meas tran vdout1_83ck1430 FIND v(dout1_83) AT=1440.05n

.meas tran vdout1_84ck1430 FIND v(dout1_84) AT=1440.05n

.meas tran vdout1_85ck1430 FIND v(dout1_85) AT=1440.05n

.meas tran vdout1_86ck1430 FIND v(dout1_86) AT=1440.05n

.meas tran vdout1_87ck1430 FIND v(dout1_87) AT=1440.05n

.meas tran vdout1_88ck1430 FIND v(dout1_88) AT=1440.05n

.meas tran vdout1_89ck1430 FIND v(dout1_89) AT=1440.05n

.meas tran vdout1_90ck1430 FIND v(dout1_90) AT=1440.05n

.meas tran vdout1_91ck1430 FIND v(dout1_91) AT=1440.05n

.meas tran vdout1_92ck1430 FIND v(dout1_92) AT=1440.05n

.meas tran vdout1_93ck1430 FIND v(dout1_93) AT=1440.05n

.meas tran vdout1_94ck1430 FIND v(dout1_94) AT=1440.05n

.meas tran vdout1_95ck1430 FIND v(dout1_95) AT=1440.05n

.meas tran vdout1_96ck1430 FIND v(dout1_96) AT=1440.05n

.meas tran vdout1_97ck1430 FIND v(dout1_97) AT=1440.05n

.meas tran vdout1_98ck1430 FIND v(dout1_98) AT=1440.05n

.meas tran vdout1_99ck1430 FIND v(dout1_99) AT=1440.05n

.meas tran vdout1_100ck1430 FIND v(dout1_100) AT=1440.05n

.meas tran vdout1_101ck1430 FIND v(dout1_101) AT=1440.05n

.meas tran vdout1_102ck1430 FIND v(dout1_102) AT=1440.05n

.meas tran vdout1_103ck1430 FIND v(dout1_103) AT=1440.05n

.meas tran vdout1_104ck1430 FIND v(dout1_104) AT=1440.05n

.meas tran vdout1_105ck1430 FIND v(dout1_105) AT=1440.05n

.meas tran vdout1_106ck1430 FIND v(dout1_106) AT=1440.05n

.meas tran vdout1_107ck1430 FIND v(dout1_107) AT=1440.05n

.meas tran vdout1_108ck1430 FIND v(dout1_108) AT=1440.05n

.meas tran vdout1_109ck1430 FIND v(dout1_109) AT=1440.05n

.meas tran vdout1_110ck1430 FIND v(dout1_110) AT=1440.05n

.meas tran vdout1_111ck1430 FIND v(dout1_111) AT=1440.05n

.meas tran vdout1_112ck1430 FIND v(dout1_112) AT=1440.05n

.meas tran vdout1_113ck1430 FIND v(dout1_113) AT=1440.05n

.meas tran vdout1_114ck1430 FIND v(dout1_114) AT=1440.05n

.meas tran vdout1_115ck1430 FIND v(dout1_115) AT=1440.05n

.meas tran vdout1_116ck1430 FIND v(dout1_116) AT=1440.05n

.meas tran vdout1_117ck1430 FIND v(dout1_117) AT=1440.05n

.meas tran vdout1_118ck1430 FIND v(dout1_118) AT=1440.05n

.meas tran vdout1_119ck1430 FIND v(dout1_119) AT=1440.05n

.meas tran vdout1_120ck1430 FIND v(dout1_120) AT=1440.05n

.meas tran vdout1_121ck1430 FIND v(dout1_121) AT=1440.05n

.meas tran vdout1_122ck1430 FIND v(dout1_122) AT=1440.05n

.meas tran vdout1_123ck1430 FIND v(dout1_123) AT=1440.05n

.meas tran vdout1_124ck1430 FIND v(dout1_124) AT=1440.05n

.meas tran vdout1_125ck1430 FIND v(dout1_125) AT=1440.05n

.meas tran vdout1_126ck1430 FIND v(dout1_126) AT=1440.05n

.meas tran vdout1_127ck1430 FIND v(dout1_127) AT=1440.05n

.meas tran vdout1_128ck1430 FIND v(dout1_128) AT=1440.05n

.meas tran vdout1_129ck1430 FIND v(dout1_129) AT=1440.05n

.meas tran vdout1_130ck1430 FIND v(dout1_130) AT=1440.05n

.meas tran vdout1_131ck1430 FIND v(dout1_131) AT=1440.05n

.meas tran vdout1_132ck1430 FIND v(dout1_132) AT=1440.05n

.meas tran vdout1_133ck1430 FIND v(dout1_133) AT=1440.05n

.meas tran vdout1_134ck1430 FIND v(dout1_134) AT=1440.05n

.meas tran vdout1_0ck1460 FIND v(dout1_0) AT=1470.05n

.meas tran vdout1_1ck1460 FIND v(dout1_1) AT=1470.05n

.meas tran vdout1_2ck1460 FIND v(dout1_2) AT=1470.05n

.meas tran vdout1_3ck1460 FIND v(dout1_3) AT=1470.05n

.meas tran vdout1_4ck1460 FIND v(dout1_4) AT=1470.05n

.meas tran vdout1_5ck1460 FIND v(dout1_5) AT=1470.05n

.meas tran vdout1_6ck1460 FIND v(dout1_6) AT=1470.05n

.meas tran vdout1_7ck1460 FIND v(dout1_7) AT=1470.05n

.meas tran vdout1_8ck1460 FIND v(dout1_8) AT=1470.05n

.meas tran vdout1_9ck1460 FIND v(dout1_9) AT=1470.05n

.meas tran vdout1_10ck1460 FIND v(dout1_10) AT=1470.05n

.meas tran vdout1_11ck1460 FIND v(dout1_11) AT=1470.05n

.meas tran vdout1_12ck1460 FIND v(dout1_12) AT=1470.05n

.meas tran vdout1_13ck1460 FIND v(dout1_13) AT=1470.05n

.meas tran vdout1_14ck1460 FIND v(dout1_14) AT=1470.05n

.meas tran vdout1_15ck1460 FIND v(dout1_15) AT=1470.05n

.meas tran vdout1_16ck1460 FIND v(dout1_16) AT=1470.05n

.meas tran vdout1_17ck1460 FIND v(dout1_17) AT=1470.05n

.meas tran vdout1_18ck1460 FIND v(dout1_18) AT=1470.05n

.meas tran vdout1_19ck1460 FIND v(dout1_19) AT=1470.05n

.meas tran vdout1_20ck1460 FIND v(dout1_20) AT=1470.05n

.meas tran vdout1_21ck1460 FIND v(dout1_21) AT=1470.05n

.meas tran vdout1_22ck1460 FIND v(dout1_22) AT=1470.05n

.meas tran vdout1_23ck1460 FIND v(dout1_23) AT=1470.05n

.meas tran vdout1_24ck1460 FIND v(dout1_24) AT=1470.05n

.meas tran vdout1_25ck1460 FIND v(dout1_25) AT=1470.05n

.meas tran vdout1_26ck1460 FIND v(dout1_26) AT=1470.05n

.meas tran vdout1_27ck1460 FIND v(dout1_27) AT=1470.05n

.meas tran vdout1_28ck1460 FIND v(dout1_28) AT=1470.05n

.meas tran vdout1_29ck1460 FIND v(dout1_29) AT=1470.05n

.meas tran vdout1_30ck1460 FIND v(dout1_30) AT=1470.05n

.meas tran vdout1_31ck1460 FIND v(dout1_31) AT=1470.05n

.meas tran vdout1_32ck1460 FIND v(dout1_32) AT=1470.05n

.meas tran vdout1_33ck1460 FIND v(dout1_33) AT=1470.05n

.meas tran vdout1_34ck1460 FIND v(dout1_34) AT=1470.05n

.meas tran vdout1_35ck1460 FIND v(dout1_35) AT=1470.05n

.meas tran vdout1_36ck1460 FIND v(dout1_36) AT=1470.05n

.meas tran vdout1_37ck1460 FIND v(dout1_37) AT=1470.05n

.meas tran vdout1_38ck1460 FIND v(dout1_38) AT=1470.05n

.meas tran vdout1_39ck1460 FIND v(dout1_39) AT=1470.05n

.meas tran vdout1_40ck1460 FIND v(dout1_40) AT=1470.05n

.meas tran vdout1_41ck1460 FIND v(dout1_41) AT=1470.05n

.meas tran vdout1_42ck1460 FIND v(dout1_42) AT=1470.05n

.meas tran vdout1_43ck1460 FIND v(dout1_43) AT=1470.05n

.meas tran vdout1_44ck1460 FIND v(dout1_44) AT=1470.05n

.meas tran vdout1_45ck1460 FIND v(dout1_45) AT=1470.05n

.meas tran vdout1_46ck1460 FIND v(dout1_46) AT=1470.05n

.meas tran vdout1_47ck1460 FIND v(dout1_47) AT=1470.05n

.meas tran vdout1_48ck1460 FIND v(dout1_48) AT=1470.05n

.meas tran vdout1_49ck1460 FIND v(dout1_49) AT=1470.05n

.meas tran vdout1_50ck1460 FIND v(dout1_50) AT=1470.05n

.meas tran vdout1_51ck1460 FIND v(dout1_51) AT=1470.05n

.meas tran vdout1_52ck1460 FIND v(dout1_52) AT=1470.05n

.meas tran vdout1_53ck1460 FIND v(dout1_53) AT=1470.05n

.meas tran vdout1_54ck1460 FIND v(dout1_54) AT=1470.05n

.meas tran vdout1_55ck1460 FIND v(dout1_55) AT=1470.05n

.meas tran vdout1_56ck1460 FIND v(dout1_56) AT=1470.05n

.meas tran vdout1_57ck1460 FIND v(dout1_57) AT=1470.05n

.meas tran vdout1_58ck1460 FIND v(dout1_58) AT=1470.05n

.meas tran vdout1_59ck1460 FIND v(dout1_59) AT=1470.05n

.meas tran vdout1_60ck1460 FIND v(dout1_60) AT=1470.05n

.meas tran vdout1_61ck1460 FIND v(dout1_61) AT=1470.05n

.meas tran vdout1_62ck1460 FIND v(dout1_62) AT=1470.05n

.meas tran vdout1_63ck1460 FIND v(dout1_63) AT=1470.05n

.meas tran vdout1_64ck1460 FIND v(dout1_64) AT=1470.05n

.meas tran vdout1_65ck1460 FIND v(dout1_65) AT=1470.05n

.meas tran vdout1_66ck1460 FIND v(dout1_66) AT=1470.05n

.meas tran vdout1_67ck1460 FIND v(dout1_67) AT=1470.05n

.meas tran vdout1_68ck1460 FIND v(dout1_68) AT=1470.05n

.meas tran vdout1_69ck1460 FIND v(dout1_69) AT=1470.05n

.meas tran vdout1_70ck1460 FIND v(dout1_70) AT=1470.05n

.meas tran vdout1_71ck1460 FIND v(dout1_71) AT=1470.05n

.meas tran vdout1_72ck1460 FIND v(dout1_72) AT=1470.05n

.meas tran vdout1_73ck1460 FIND v(dout1_73) AT=1470.05n

.meas tran vdout1_74ck1460 FIND v(dout1_74) AT=1470.05n

.meas tran vdout1_75ck1460 FIND v(dout1_75) AT=1470.05n

.meas tran vdout1_76ck1460 FIND v(dout1_76) AT=1470.05n

.meas tran vdout1_77ck1460 FIND v(dout1_77) AT=1470.05n

.meas tran vdout1_78ck1460 FIND v(dout1_78) AT=1470.05n

.meas tran vdout1_79ck1460 FIND v(dout1_79) AT=1470.05n

.meas tran vdout1_80ck1460 FIND v(dout1_80) AT=1470.05n

.meas tran vdout1_81ck1460 FIND v(dout1_81) AT=1470.05n

.meas tran vdout1_82ck1460 FIND v(dout1_82) AT=1470.05n

.meas tran vdout1_83ck1460 FIND v(dout1_83) AT=1470.05n

.meas tran vdout1_84ck1460 FIND v(dout1_84) AT=1470.05n

.meas tran vdout1_85ck1460 FIND v(dout1_85) AT=1470.05n

.meas tran vdout1_86ck1460 FIND v(dout1_86) AT=1470.05n

.meas tran vdout1_87ck1460 FIND v(dout1_87) AT=1470.05n

.meas tran vdout1_88ck1460 FIND v(dout1_88) AT=1470.05n

.meas tran vdout1_89ck1460 FIND v(dout1_89) AT=1470.05n

.meas tran vdout1_90ck1460 FIND v(dout1_90) AT=1470.05n

.meas tran vdout1_91ck1460 FIND v(dout1_91) AT=1470.05n

.meas tran vdout1_92ck1460 FIND v(dout1_92) AT=1470.05n

.meas tran vdout1_93ck1460 FIND v(dout1_93) AT=1470.05n

.meas tran vdout1_94ck1460 FIND v(dout1_94) AT=1470.05n

.meas tran vdout1_95ck1460 FIND v(dout1_95) AT=1470.05n

.meas tran vdout1_96ck1460 FIND v(dout1_96) AT=1470.05n

.meas tran vdout1_97ck1460 FIND v(dout1_97) AT=1470.05n

.meas tran vdout1_98ck1460 FIND v(dout1_98) AT=1470.05n

.meas tran vdout1_99ck1460 FIND v(dout1_99) AT=1470.05n

.meas tran vdout1_100ck1460 FIND v(dout1_100) AT=1470.05n

.meas tran vdout1_101ck1460 FIND v(dout1_101) AT=1470.05n

.meas tran vdout1_102ck1460 FIND v(dout1_102) AT=1470.05n

.meas tran vdout1_103ck1460 FIND v(dout1_103) AT=1470.05n

.meas tran vdout1_104ck1460 FIND v(dout1_104) AT=1470.05n

.meas tran vdout1_105ck1460 FIND v(dout1_105) AT=1470.05n

.meas tran vdout1_106ck1460 FIND v(dout1_106) AT=1470.05n

.meas tran vdout1_107ck1460 FIND v(dout1_107) AT=1470.05n

.meas tran vdout1_108ck1460 FIND v(dout1_108) AT=1470.05n

.meas tran vdout1_109ck1460 FIND v(dout1_109) AT=1470.05n

.meas tran vdout1_110ck1460 FIND v(dout1_110) AT=1470.05n

.meas tran vdout1_111ck1460 FIND v(dout1_111) AT=1470.05n

.meas tran vdout1_112ck1460 FIND v(dout1_112) AT=1470.05n

.meas tran vdout1_113ck1460 FIND v(dout1_113) AT=1470.05n

.meas tran vdout1_114ck1460 FIND v(dout1_114) AT=1470.05n

.meas tran vdout1_115ck1460 FIND v(dout1_115) AT=1470.05n

.meas tran vdout1_116ck1460 FIND v(dout1_116) AT=1470.05n

.meas tran vdout1_117ck1460 FIND v(dout1_117) AT=1470.05n

.meas tran vdout1_118ck1460 FIND v(dout1_118) AT=1470.05n

.meas tran vdout1_119ck1460 FIND v(dout1_119) AT=1470.05n

.meas tran vdout1_120ck1460 FIND v(dout1_120) AT=1470.05n

.meas tran vdout1_121ck1460 FIND v(dout1_121) AT=1470.05n

.meas tran vdout1_122ck1460 FIND v(dout1_122) AT=1470.05n

.meas tran vdout1_123ck1460 FIND v(dout1_123) AT=1470.05n

.meas tran vdout1_124ck1460 FIND v(dout1_124) AT=1470.05n

.meas tran vdout1_125ck1460 FIND v(dout1_125) AT=1470.05n

.meas tran vdout1_126ck1460 FIND v(dout1_126) AT=1470.05n

.meas tran vdout1_127ck1460 FIND v(dout1_127) AT=1470.05n

.meas tran vdout1_128ck1460 FIND v(dout1_128) AT=1470.05n

.meas tran vdout1_129ck1460 FIND v(dout1_129) AT=1470.05n

.meas tran vdout1_130ck1460 FIND v(dout1_130) AT=1470.05n

.meas tran vdout1_131ck1460 FIND v(dout1_131) AT=1470.05n

.meas tran vdout1_132ck1460 FIND v(dout1_132) AT=1470.05n

.meas tran vdout1_133ck1460 FIND v(dout1_133) AT=1470.05n

.meas tran vdout1_134ck1460 FIND v(dout1_134) AT=1470.05n

.meas tran vdout1_0ck1470 FIND v(dout1_0) AT=1480.05n

.meas tran vdout1_1ck1470 FIND v(dout1_1) AT=1480.05n

.meas tran vdout1_2ck1470 FIND v(dout1_2) AT=1480.05n

.meas tran vdout1_3ck1470 FIND v(dout1_3) AT=1480.05n

.meas tran vdout1_4ck1470 FIND v(dout1_4) AT=1480.05n

.meas tran vdout1_5ck1470 FIND v(dout1_5) AT=1480.05n

.meas tran vdout1_6ck1470 FIND v(dout1_6) AT=1480.05n

.meas tran vdout1_7ck1470 FIND v(dout1_7) AT=1480.05n

.meas tran vdout1_8ck1470 FIND v(dout1_8) AT=1480.05n

.meas tran vdout1_9ck1470 FIND v(dout1_9) AT=1480.05n

.meas tran vdout1_10ck1470 FIND v(dout1_10) AT=1480.05n

.meas tran vdout1_11ck1470 FIND v(dout1_11) AT=1480.05n

.meas tran vdout1_12ck1470 FIND v(dout1_12) AT=1480.05n

.meas tran vdout1_13ck1470 FIND v(dout1_13) AT=1480.05n

.meas tran vdout1_14ck1470 FIND v(dout1_14) AT=1480.05n

.meas tran vdout1_15ck1470 FIND v(dout1_15) AT=1480.05n

.meas tran vdout1_16ck1470 FIND v(dout1_16) AT=1480.05n

.meas tran vdout1_17ck1470 FIND v(dout1_17) AT=1480.05n

.meas tran vdout1_18ck1470 FIND v(dout1_18) AT=1480.05n

.meas tran vdout1_19ck1470 FIND v(dout1_19) AT=1480.05n

.meas tran vdout1_20ck1470 FIND v(dout1_20) AT=1480.05n

.meas tran vdout1_21ck1470 FIND v(dout1_21) AT=1480.05n

.meas tran vdout1_22ck1470 FIND v(dout1_22) AT=1480.05n

.meas tran vdout1_23ck1470 FIND v(dout1_23) AT=1480.05n

.meas tran vdout1_24ck1470 FIND v(dout1_24) AT=1480.05n

.meas tran vdout1_25ck1470 FIND v(dout1_25) AT=1480.05n

.meas tran vdout1_26ck1470 FIND v(dout1_26) AT=1480.05n

.meas tran vdout1_27ck1470 FIND v(dout1_27) AT=1480.05n

.meas tran vdout1_28ck1470 FIND v(dout1_28) AT=1480.05n

.meas tran vdout1_29ck1470 FIND v(dout1_29) AT=1480.05n

.meas tran vdout1_30ck1470 FIND v(dout1_30) AT=1480.05n

.meas tran vdout1_31ck1470 FIND v(dout1_31) AT=1480.05n

.meas tran vdout1_32ck1470 FIND v(dout1_32) AT=1480.05n

.meas tran vdout1_33ck1470 FIND v(dout1_33) AT=1480.05n

.meas tran vdout1_34ck1470 FIND v(dout1_34) AT=1480.05n

.meas tran vdout1_35ck1470 FIND v(dout1_35) AT=1480.05n

.meas tran vdout1_36ck1470 FIND v(dout1_36) AT=1480.05n

.meas tran vdout1_37ck1470 FIND v(dout1_37) AT=1480.05n

.meas tran vdout1_38ck1470 FIND v(dout1_38) AT=1480.05n

.meas tran vdout1_39ck1470 FIND v(dout1_39) AT=1480.05n

.meas tran vdout1_40ck1470 FIND v(dout1_40) AT=1480.05n

.meas tran vdout1_41ck1470 FIND v(dout1_41) AT=1480.05n

.meas tran vdout1_42ck1470 FIND v(dout1_42) AT=1480.05n

.meas tran vdout1_43ck1470 FIND v(dout1_43) AT=1480.05n

.meas tran vdout1_44ck1470 FIND v(dout1_44) AT=1480.05n

.meas tran vdout1_45ck1470 FIND v(dout1_45) AT=1480.05n

.meas tran vdout1_46ck1470 FIND v(dout1_46) AT=1480.05n

.meas tran vdout1_47ck1470 FIND v(dout1_47) AT=1480.05n

.meas tran vdout1_48ck1470 FIND v(dout1_48) AT=1480.05n

.meas tran vdout1_49ck1470 FIND v(dout1_49) AT=1480.05n

.meas tran vdout1_50ck1470 FIND v(dout1_50) AT=1480.05n

.meas tran vdout1_51ck1470 FIND v(dout1_51) AT=1480.05n

.meas tran vdout1_52ck1470 FIND v(dout1_52) AT=1480.05n

.meas tran vdout1_53ck1470 FIND v(dout1_53) AT=1480.05n

.meas tran vdout1_54ck1470 FIND v(dout1_54) AT=1480.05n

.meas tran vdout1_55ck1470 FIND v(dout1_55) AT=1480.05n

.meas tran vdout1_56ck1470 FIND v(dout1_56) AT=1480.05n

.meas tran vdout1_57ck1470 FIND v(dout1_57) AT=1480.05n

.meas tran vdout1_58ck1470 FIND v(dout1_58) AT=1480.05n

.meas tran vdout1_59ck1470 FIND v(dout1_59) AT=1480.05n

.meas tran vdout1_60ck1470 FIND v(dout1_60) AT=1480.05n

.meas tran vdout1_61ck1470 FIND v(dout1_61) AT=1480.05n

.meas tran vdout1_62ck1470 FIND v(dout1_62) AT=1480.05n

.meas tran vdout1_63ck1470 FIND v(dout1_63) AT=1480.05n

.meas tran vdout1_64ck1470 FIND v(dout1_64) AT=1480.05n

.meas tran vdout1_65ck1470 FIND v(dout1_65) AT=1480.05n

.meas tran vdout1_66ck1470 FIND v(dout1_66) AT=1480.05n

.meas tran vdout1_67ck1470 FIND v(dout1_67) AT=1480.05n

.meas tran vdout1_68ck1470 FIND v(dout1_68) AT=1480.05n

.meas tran vdout1_69ck1470 FIND v(dout1_69) AT=1480.05n

.meas tran vdout1_70ck1470 FIND v(dout1_70) AT=1480.05n

.meas tran vdout1_71ck1470 FIND v(dout1_71) AT=1480.05n

.meas tran vdout1_72ck1470 FIND v(dout1_72) AT=1480.05n

.meas tran vdout1_73ck1470 FIND v(dout1_73) AT=1480.05n

.meas tran vdout1_74ck1470 FIND v(dout1_74) AT=1480.05n

.meas tran vdout1_75ck1470 FIND v(dout1_75) AT=1480.05n

.meas tran vdout1_76ck1470 FIND v(dout1_76) AT=1480.05n

.meas tran vdout1_77ck1470 FIND v(dout1_77) AT=1480.05n

.meas tran vdout1_78ck1470 FIND v(dout1_78) AT=1480.05n

.meas tran vdout1_79ck1470 FIND v(dout1_79) AT=1480.05n

.meas tran vdout1_80ck1470 FIND v(dout1_80) AT=1480.05n

.meas tran vdout1_81ck1470 FIND v(dout1_81) AT=1480.05n

.meas tran vdout1_82ck1470 FIND v(dout1_82) AT=1480.05n

.meas tran vdout1_83ck1470 FIND v(dout1_83) AT=1480.05n

.meas tran vdout1_84ck1470 FIND v(dout1_84) AT=1480.05n

.meas tran vdout1_85ck1470 FIND v(dout1_85) AT=1480.05n

.meas tran vdout1_86ck1470 FIND v(dout1_86) AT=1480.05n

.meas tran vdout1_87ck1470 FIND v(dout1_87) AT=1480.05n

.meas tran vdout1_88ck1470 FIND v(dout1_88) AT=1480.05n

.meas tran vdout1_89ck1470 FIND v(dout1_89) AT=1480.05n

.meas tran vdout1_90ck1470 FIND v(dout1_90) AT=1480.05n

.meas tran vdout1_91ck1470 FIND v(dout1_91) AT=1480.05n

.meas tran vdout1_92ck1470 FIND v(dout1_92) AT=1480.05n

.meas tran vdout1_93ck1470 FIND v(dout1_93) AT=1480.05n

.meas tran vdout1_94ck1470 FIND v(dout1_94) AT=1480.05n

.meas tran vdout1_95ck1470 FIND v(dout1_95) AT=1480.05n

.meas tran vdout1_96ck1470 FIND v(dout1_96) AT=1480.05n

.meas tran vdout1_97ck1470 FIND v(dout1_97) AT=1480.05n

.meas tran vdout1_98ck1470 FIND v(dout1_98) AT=1480.05n

.meas tran vdout1_99ck1470 FIND v(dout1_99) AT=1480.05n

.meas tran vdout1_100ck1470 FIND v(dout1_100) AT=1480.05n

.meas tran vdout1_101ck1470 FIND v(dout1_101) AT=1480.05n

.meas tran vdout1_102ck1470 FIND v(dout1_102) AT=1480.05n

.meas tran vdout1_103ck1470 FIND v(dout1_103) AT=1480.05n

.meas tran vdout1_104ck1470 FIND v(dout1_104) AT=1480.05n

.meas tran vdout1_105ck1470 FIND v(dout1_105) AT=1480.05n

.meas tran vdout1_106ck1470 FIND v(dout1_106) AT=1480.05n

.meas tran vdout1_107ck1470 FIND v(dout1_107) AT=1480.05n

.meas tran vdout1_108ck1470 FIND v(dout1_108) AT=1480.05n

.meas tran vdout1_109ck1470 FIND v(dout1_109) AT=1480.05n

.meas tran vdout1_110ck1470 FIND v(dout1_110) AT=1480.05n

.meas tran vdout1_111ck1470 FIND v(dout1_111) AT=1480.05n

.meas tran vdout1_112ck1470 FIND v(dout1_112) AT=1480.05n

.meas tran vdout1_113ck1470 FIND v(dout1_113) AT=1480.05n

.meas tran vdout1_114ck1470 FIND v(dout1_114) AT=1480.05n

.meas tran vdout1_115ck1470 FIND v(dout1_115) AT=1480.05n

.meas tran vdout1_116ck1470 FIND v(dout1_116) AT=1480.05n

.meas tran vdout1_117ck1470 FIND v(dout1_117) AT=1480.05n

.meas tran vdout1_118ck1470 FIND v(dout1_118) AT=1480.05n

.meas tran vdout1_119ck1470 FIND v(dout1_119) AT=1480.05n

.meas tran vdout1_120ck1470 FIND v(dout1_120) AT=1480.05n

.meas tran vdout1_121ck1470 FIND v(dout1_121) AT=1480.05n

.meas tran vdout1_122ck1470 FIND v(dout1_122) AT=1480.05n

.meas tran vdout1_123ck1470 FIND v(dout1_123) AT=1480.05n

.meas tran vdout1_124ck1470 FIND v(dout1_124) AT=1480.05n

.meas tran vdout1_125ck1470 FIND v(dout1_125) AT=1480.05n

.meas tran vdout1_126ck1470 FIND v(dout1_126) AT=1480.05n

.meas tran vdout1_127ck1470 FIND v(dout1_127) AT=1480.05n

.meas tran vdout1_128ck1470 FIND v(dout1_128) AT=1480.05n

.meas tran vdout1_129ck1470 FIND v(dout1_129) AT=1480.05n

.meas tran vdout1_130ck1470 FIND v(dout1_130) AT=1480.05n

.meas tran vdout1_131ck1470 FIND v(dout1_131) AT=1480.05n

.meas tran vdout1_132ck1470 FIND v(dout1_132) AT=1480.05n

.meas tran vdout1_133ck1470 FIND v(dout1_133) AT=1480.05n

.meas tran vdout1_134ck1470 FIND v(dout1_134) AT=1480.05n

.meas tran vdout1_0ck1480 FIND v(dout1_0) AT=1490.05n

.meas tran vdout1_1ck1480 FIND v(dout1_1) AT=1490.05n

.meas tran vdout1_2ck1480 FIND v(dout1_2) AT=1490.05n

.meas tran vdout1_3ck1480 FIND v(dout1_3) AT=1490.05n

.meas tran vdout1_4ck1480 FIND v(dout1_4) AT=1490.05n

.meas tran vdout1_5ck1480 FIND v(dout1_5) AT=1490.05n

.meas tran vdout1_6ck1480 FIND v(dout1_6) AT=1490.05n

.meas tran vdout1_7ck1480 FIND v(dout1_7) AT=1490.05n

.meas tran vdout1_8ck1480 FIND v(dout1_8) AT=1490.05n

.meas tran vdout1_9ck1480 FIND v(dout1_9) AT=1490.05n

.meas tran vdout1_10ck1480 FIND v(dout1_10) AT=1490.05n

.meas tran vdout1_11ck1480 FIND v(dout1_11) AT=1490.05n

.meas tran vdout1_12ck1480 FIND v(dout1_12) AT=1490.05n

.meas tran vdout1_13ck1480 FIND v(dout1_13) AT=1490.05n

.meas tran vdout1_14ck1480 FIND v(dout1_14) AT=1490.05n

.meas tran vdout1_15ck1480 FIND v(dout1_15) AT=1490.05n

.meas tran vdout1_16ck1480 FIND v(dout1_16) AT=1490.05n

.meas tran vdout1_17ck1480 FIND v(dout1_17) AT=1490.05n

.meas tran vdout1_18ck1480 FIND v(dout1_18) AT=1490.05n

.meas tran vdout1_19ck1480 FIND v(dout1_19) AT=1490.05n

.meas tran vdout1_20ck1480 FIND v(dout1_20) AT=1490.05n

.meas tran vdout1_21ck1480 FIND v(dout1_21) AT=1490.05n

.meas tran vdout1_22ck1480 FIND v(dout1_22) AT=1490.05n

.meas tran vdout1_23ck1480 FIND v(dout1_23) AT=1490.05n

.meas tran vdout1_24ck1480 FIND v(dout1_24) AT=1490.05n

.meas tran vdout1_25ck1480 FIND v(dout1_25) AT=1490.05n

.meas tran vdout1_26ck1480 FIND v(dout1_26) AT=1490.05n

.meas tran vdout1_27ck1480 FIND v(dout1_27) AT=1490.05n

.meas tran vdout1_28ck1480 FIND v(dout1_28) AT=1490.05n

.meas tran vdout1_29ck1480 FIND v(dout1_29) AT=1490.05n

.meas tran vdout1_30ck1480 FIND v(dout1_30) AT=1490.05n

.meas tran vdout1_31ck1480 FIND v(dout1_31) AT=1490.05n

.meas tran vdout1_32ck1480 FIND v(dout1_32) AT=1490.05n

.meas tran vdout1_33ck1480 FIND v(dout1_33) AT=1490.05n

.meas tran vdout1_34ck1480 FIND v(dout1_34) AT=1490.05n

.meas tran vdout1_35ck1480 FIND v(dout1_35) AT=1490.05n

.meas tran vdout1_36ck1480 FIND v(dout1_36) AT=1490.05n

.meas tran vdout1_37ck1480 FIND v(dout1_37) AT=1490.05n

.meas tran vdout1_38ck1480 FIND v(dout1_38) AT=1490.05n

.meas tran vdout1_39ck1480 FIND v(dout1_39) AT=1490.05n

.meas tran vdout1_40ck1480 FIND v(dout1_40) AT=1490.05n

.meas tran vdout1_41ck1480 FIND v(dout1_41) AT=1490.05n

.meas tran vdout1_42ck1480 FIND v(dout1_42) AT=1490.05n

.meas tran vdout1_43ck1480 FIND v(dout1_43) AT=1490.05n

.meas tran vdout1_44ck1480 FIND v(dout1_44) AT=1490.05n

.meas tran vdout1_45ck1480 FIND v(dout1_45) AT=1490.05n

.meas tran vdout1_46ck1480 FIND v(dout1_46) AT=1490.05n

.meas tran vdout1_47ck1480 FIND v(dout1_47) AT=1490.05n

.meas tran vdout1_48ck1480 FIND v(dout1_48) AT=1490.05n

.meas tran vdout1_49ck1480 FIND v(dout1_49) AT=1490.05n

.meas tran vdout1_50ck1480 FIND v(dout1_50) AT=1490.05n

.meas tran vdout1_51ck1480 FIND v(dout1_51) AT=1490.05n

.meas tran vdout1_52ck1480 FIND v(dout1_52) AT=1490.05n

.meas tran vdout1_53ck1480 FIND v(dout1_53) AT=1490.05n

.meas tran vdout1_54ck1480 FIND v(dout1_54) AT=1490.05n

.meas tran vdout1_55ck1480 FIND v(dout1_55) AT=1490.05n

.meas tran vdout1_56ck1480 FIND v(dout1_56) AT=1490.05n

.meas tran vdout1_57ck1480 FIND v(dout1_57) AT=1490.05n

.meas tran vdout1_58ck1480 FIND v(dout1_58) AT=1490.05n

.meas tran vdout1_59ck1480 FIND v(dout1_59) AT=1490.05n

.meas tran vdout1_60ck1480 FIND v(dout1_60) AT=1490.05n

.meas tran vdout1_61ck1480 FIND v(dout1_61) AT=1490.05n

.meas tran vdout1_62ck1480 FIND v(dout1_62) AT=1490.05n

.meas tran vdout1_63ck1480 FIND v(dout1_63) AT=1490.05n

.meas tran vdout1_64ck1480 FIND v(dout1_64) AT=1490.05n

.meas tran vdout1_65ck1480 FIND v(dout1_65) AT=1490.05n

.meas tran vdout1_66ck1480 FIND v(dout1_66) AT=1490.05n

.meas tran vdout1_67ck1480 FIND v(dout1_67) AT=1490.05n

.meas tran vdout1_68ck1480 FIND v(dout1_68) AT=1490.05n

.meas tran vdout1_69ck1480 FIND v(dout1_69) AT=1490.05n

.meas tran vdout1_70ck1480 FIND v(dout1_70) AT=1490.05n

.meas tran vdout1_71ck1480 FIND v(dout1_71) AT=1490.05n

.meas tran vdout1_72ck1480 FIND v(dout1_72) AT=1490.05n

.meas tran vdout1_73ck1480 FIND v(dout1_73) AT=1490.05n

.meas tran vdout1_74ck1480 FIND v(dout1_74) AT=1490.05n

.meas tran vdout1_75ck1480 FIND v(dout1_75) AT=1490.05n

.meas tran vdout1_76ck1480 FIND v(dout1_76) AT=1490.05n

.meas tran vdout1_77ck1480 FIND v(dout1_77) AT=1490.05n

.meas tran vdout1_78ck1480 FIND v(dout1_78) AT=1490.05n

.meas tran vdout1_79ck1480 FIND v(dout1_79) AT=1490.05n

.meas tran vdout1_80ck1480 FIND v(dout1_80) AT=1490.05n

.meas tran vdout1_81ck1480 FIND v(dout1_81) AT=1490.05n

.meas tran vdout1_82ck1480 FIND v(dout1_82) AT=1490.05n

.meas tran vdout1_83ck1480 FIND v(dout1_83) AT=1490.05n

.meas tran vdout1_84ck1480 FIND v(dout1_84) AT=1490.05n

.meas tran vdout1_85ck1480 FIND v(dout1_85) AT=1490.05n

.meas tran vdout1_86ck1480 FIND v(dout1_86) AT=1490.05n

.meas tran vdout1_87ck1480 FIND v(dout1_87) AT=1490.05n

.meas tran vdout1_88ck1480 FIND v(dout1_88) AT=1490.05n

.meas tran vdout1_89ck1480 FIND v(dout1_89) AT=1490.05n

.meas tran vdout1_90ck1480 FIND v(dout1_90) AT=1490.05n

.meas tran vdout1_91ck1480 FIND v(dout1_91) AT=1490.05n

.meas tran vdout1_92ck1480 FIND v(dout1_92) AT=1490.05n

.meas tran vdout1_93ck1480 FIND v(dout1_93) AT=1490.05n

.meas tran vdout1_94ck1480 FIND v(dout1_94) AT=1490.05n

.meas tran vdout1_95ck1480 FIND v(dout1_95) AT=1490.05n

.meas tran vdout1_96ck1480 FIND v(dout1_96) AT=1490.05n

.meas tran vdout1_97ck1480 FIND v(dout1_97) AT=1490.05n

.meas tran vdout1_98ck1480 FIND v(dout1_98) AT=1490.05n

.meas tran vdout1_99ck1480 FIND v(dout1_99) AT=1490.05n

.meas tran vdout1_100ck1480 FIND v(dout1_100) AT=1490.05n

.meas tran vdout1_101ck1480 FIND v(dout1_101) AT=1490.05n

.meas tran vdout1_102ck1480 FIND v(dout1_102) AT=1490.05n

.meas tran vdout1_103ck1480 FIND v(dout1_103) AT=1490.05n

.meas tran vdout1_104ck1480 FIND v(dout1_104) AT=1490.05n

.meas tran vdout1_105ck1480 FIND v(dout1_105) AT=1490.05n

.meas tran vdout1_106ck1480 FIND v(dout1_106) AT=1490.05n

.meas tran vdout1_107ck1480 FIND v(dout1_107) AT=1490.05n

.meas tran vdout1_108ck1480 FIND v(dout1_108) AT=1490.05n

.meas tran vdout1_109ck1480 FIND v(dout1_109) AT=1490.05n

.meas tran vdout1_110ck1480 FIND v(dout1_110) AT=1490.05n

.meas tran vdout1_111ck1480 FIND v(dout1_111) AT=1490.05n

.meas tran vdout1_112ck1480 FIND v(dout1_112) AT=1490.05n

.meas tran vdout1_113ck1480 FIND v(dout1_113) AT=1490.05n

.meas tran vdout1_114ck1480 FIND v(dout1_114) AT=1490.05n

.meas tran vdout1_115ck1480 FIND v(dout1_115) AT=1490.05n

.meas tran vdout1_116ck1480 FIND v(dout1_116) AT=1490.05n

.meas tran vdout1_117ck1480 FIND v(dout1_117) AT=1490.05n

.meas tran vdout1_118ck1480 FIND v(dout1_118) AT=1490.05n

.meas tran vdout1_119ck1480 FIND v(dout1_119) AT=1490.05n

.meas tran vdout1_120ck1480 FIND v(dout1_120) AT=1490.05n

.meas tran vdout1_121ck1480 FIND v(dout1_121) AT=1490.05n

.meas tran vdout1_122ck1480 FIND v(dout1_122) AT=1490.05n

.meas tran vdout1_123ck1480 FIND v(dout1_123) AT=1490.05n

.meas tran vdout1_124ck1480 FIND v(dout1_124) AT=1490.05n

.meas tran vdout1_125ck1480 FIND v(dout1_125) AT=1490.05n

.meas tran vdout1_126ck1480 FIND v(dout1_126) AT=1490.05n

.meas tran vdout1_127ck1480 FIND v(dout1_127) AT=1490.05n

.meas tran vdout1_128ck1480 FIND v(dout1_128) AT=1490.05n

.meas tran vdout1_129ck1480 FIND v(dout1_129) AT=1490.05n

.meas tran vdout1_130ck1480 FIND v(dout1_130) AT=1490.05n

.meas tran vdout1_131ck1480 FIND v(dout1_131) AT=1490.05n

.meas tran vdout1_132ck1480 FIND v(dout1_132) AT=1490.05n

.meas tran vdout1_133ck1480 FIND v(dout1_133) AT=1490.05n

.meas tran vdout1_134ck1480 FIND v(dout1_134) AT=1490.05n

.meas tran vdout1_0ck1580 FIND v(dout1_0) AT=1590.05n

.meas tran vdout1_1ck1580 FIND v(dout1_1) AT=1590.05n

.meas tran vdout1_2ck1580 FIND v(dout1_2) AT=1590.05n

.meas tran vdout1_3ck1580 FIND v(dout1_3) AT=1590.05n

.meas tran vdout1_4ck1580 FIND v(dout1_4) AT=1590.05n

.meas tran vdout1_5ck1580 FIND v(dout1_5) AT=1590.05n

.meas tran vdout1_6ck1580 FIND v(dout1_6) AT=1590.05n

.meas tran vdout1_7ck1580 FIND v(dout1_7) AT=1590.05n

.meas tran vdout1_8ck1580 FIND v(dout1_8) AT=1590.05n

.meas tran vdout1_9ck1580 FIND v(dout1_9) AT=1590.05n

.meas tran vdout1_10ck1580 FIND v(dout1_10) AT=1590.05n

.meas tran vdout1_11ck1580 FIND v(dout1_11) AT=1590.05n

.meas tran vdout1_12ck1580 FIND v(dout1_12) AT=1590.05n

.meas tran vdout1_13ck1580 FIND v(dout1_13) AT=1590.05n

.meas tran vdout1_14ck1580 FIND v(dout1_14) AT=1590.05n

.meas tran vdout1_15ck1580 FIND v(dout1_15) AT=1590.05n

.meas tran vdout1_16ck1580 FIND v(dout1_16) AT=1590.05n

.meas tran vdout1_17ck1580 FIND v(dout1_17) AT=1590.05n

.meas tran vdout1_18ck1580 FIND v(dout1_18) AT=1590.05n

.meas tran vdout1_19ck1580 FIND v(dout1_19) AT=1590.05n

.meas tran vdout1_20ck1580 FIND v(dout1_20) AT=1590.05n

.meas tran vdout1_21ck1580 FIND v(dout1_21) AT=1590.05n

.meas tran vdout1_22ck1580 FIND v(dout1_22) AT=1590.05n

.meas tran vdout1_23ck1580 FIND v(dout1_23) AT=1590.05n

.meas tran vdout1_24ck1580 FIND v(dout1_24) AT=1590.05n

.meas tran vdout1_25ck1580 FIND v(dout1_25) AT=1590.05n

.meas tran vdout1_26ck1580 FIND v(dout1_26) AT=1590.05n

.meas tran vdout1_27ck1580 FIND v(dout1_27) AT=1590.05n

.meas tran vdout1_28ck1580 FIND v(dout1_28) AT=1590.05n

.meas tran vdout1_29ck1580 FIND v(dout1_29) AT=1590.05n

.meas tran vdout1_30ck1580 FIND v(dout1_30) AT=1590.05n

.meas tran vdout1_31ck1580 FIND v(dout1_31) AT=1590.05n

.meas tran vdout1_32ck1580 FIND v(dout1_32) AT=1590.05n

.meas tran vdout1_33ck1580 FIND v(dout1_33) AT=1590.05n

.meas tran vdout1_34ck1580 FIND v(dout1_34) AT=1590.05n

.meas tran vdout1_35ck1580 FIND v(dout1_35) AT=1590.05n

.meas tran vdout1_36ck1580 FIND v(dout1_36) AT=1590.05n

.meas tran vdout1_37ck1580 FIND v(dout1_37) AT=1590.05n

.meas tran vdout1_38ck1580 FIND v(dout1_38) AT=1590.05n

.meas tran vdout1_39ck1580 FIND v(dout1_39) AT=1590.05n

.meas tran vdout1_40ck1580 FIND v(dout1_40) AT=1590.05n

.meas tran vdout1_41ck1580 FIND v(dout1_41) AT=1590.05n

.meas tran vdout1_42ck1580 FIND v(dout1_42) AT=1590.05n

.meas tran vdout1_43ck1580 FIND v(dout1_43) AT=1590.05n

.meas tran vdout1_44ck1580 FIND v(dout1_44) AT=1590.05n

.meas tran vdout1_45ck1580 FIND v(dout1_45) AT=1590.05n

.meas tran vdout1_46ck1580 FIND v(dout1_46) AT=1590.05n

.meas tran vdout1_47ck1580 FIND v(dout1_47) AT=1590.05n

.meas tran vdout1_48ck1580 FIND v(dout1_48) AT=1590.05n

.meas tran vdout1_49ck1580 FIND v(dout1_49) AT=1590.05n

.meas tran vdout1_50ck1580 FIND v(dout1_50) AT=1590.05n

.meas tran vdout1_51ck1580 FIND v(dout1_51) AT=1590.05n

.meas tran vdout1_52ck1580 FIND v(dout1_52) AT=1590.05n

.meas tran vdout1_53ck1580 FIND v(dout1_53) AT=1590.05n

.meas tran vdout1_54ck1580 FIND v(dout1_54) AT=1590.05n

.meas tran vdout1_55ck1580 FIND v(dout1_55) AT=1590.05n

.meas tran vdout1_56ck1580 FIND v(dout1_56) AT=1590.05n

.meas tran vdout1_57ck1580 FIND v(dout1_57) AT=1590.05n

.meas tran vdout1_58ck1580 FIND v(dout1_58) AT=1590.05n

.meas tran vdout1_59ck1580 FIND v(dout1_59) AT=1590.05n

.meas tran vdout1_60ck1580 FIND v(dout1_60) AT=1590.05n

.meas tran vdout1_61ck1580 FIND v(dout1_61) AT=1590.05n

.meas tran vdout1_62ck1580 FIND v(dout1_62) AT=1590.05n

.meas tran vdout1_63ck1580 FIND v(dout1_63) AT=1590.05n

.meas tran vdout1_64ck1580 FIND v(dout1_64) AT=1590.05n

.meas tran vdout1_65ck1580 FIND v(dout1_65) AT=1590.05n

.meas tran vdout1_66ck1580 FIND v(dout1_66) AT=1590.05n

.meas tran vdout1_67ck1580 FIND v(dout1_67) AT=1590.05n

.meas tran vdout1_68ck1580 FIND v(dout1_68) AT=1590.05n

.meas tran vdout1_69ck1580 FIND v(dout1_69) AT=1590.05n

.meas tran vdout1_70ck1580 FIND v(dout1_70) AT=1590.05n

.meas tran vdout1_71ck1580 FIND v(dout1_71) AT=1590.05n

.meas tran vdout1_72ck1580 FIND v(dout1_72) AT=1590.05n

.meas tran vdout1_73ck1580 FIND v(dout1_73) AT=1590.05n

.meas tran vdout1_74ck1580 FIND v(dout1_74) AT=1590.05n

.meas tran vdout1_75ck1580 FIND v(dout1_75) AT=1590.05n

.meas tran vdout1_76ck1580 FIND v(dout1_76) AT=1590.05n

.meas tran vdout1_77ck1580 FIND v(dout1_77) AT=1590.05n

.meas tran vdout1_78ck1580 FIND v(dout1_78) AT=1590.05n

.meas tran vdout1_79ck1580 FIND v(dout1_79) AT=1590.05n

.meas tran vdout1_80ck1580 FIND v(dout1_80) AT=1590.05n

.meas tran vdout1_81ck1580 FIND v(dout1_81) AT=1590.05n

.meas tran vdout1_82ck1580 FIND v(dout1_82) AT=1590.05n

.meas tran vdout1_83ck1580 FIND v(dout1_83) AT=1590.05n

.meas tran vdout1_84ck1580 FIND v(dout1_84) AT=1590.05n

.meas tran vdout1_85ck1580 FIND v(dout1_85) AT=1590.05n

.meas tran vdout1_86ck1580 FIND v(dout1_86) AT=1590.05n

.meas tran vdout1_87ck1580 FIND v(dout1_87) AT=1590.05n

.meas tran vdout1_88ck1580 FIND v(dout1_88) AT=1590.05n

.meas tran vdout1_89ck1580 FIND v(dout1_89) AT=1590.05n

.meas tran vdout1_90ck1580 FIND v(dout1_90) AT=1590.05n

.meas tran vdout1_91ck1580 FIND v(dout1_91) AT=1590.05n

.meas tran vdout1_92ck1580 FIND v(dout1_92) AT=1590.05n

.meas tran vdout1_93ck1580 FIND v(dout1_93) AT=1590.05n

.meas tran vdout1_94ck1580 FIND v(dout1_94) AT=1590.05n

.meas tran vdout1_95ck1580 FIND v(dout1_95) AT=1590.05n

.meas tran vdout1_96ck1580 FIND v(dout1_96) AT=1590.05n

.meas tran vdout1_97ck1580 FIND v(dout1_97) AT=1590.05n

.meas tran vdout1_98ck1580 FIND v(dout1_98) AT=1590.05n

.meas tran vdout1_99ck1580 FIND v(dout1_99) AT=1590.05n

.meas tran vdout1_100ck1580 FIND v(dout1_100) AT=1590.05n

.meas tran vdout1_101ck1580 FIND v(dout1_101) AT=1590.05n

.meas tran vdout1_102ck1580 FIND v(dout1_102) AT=1590.05n

.meas tran vdout1_103ck1580 FIND v(dout1_103) AT=1590.05n

.meas tran vdout1_104ck1580 FIND v(dout1_104) AT=1590.05n

.meas tran vdout1_105ck1580 FIND v(dout1_105) AT=1590.05n

.meas tran vdout1_106ck1580 FIND v(dout1_106) AT=1590.05n

.meas tran vdout1_107ck1580 FIND v(dout1_107) AT=1590.05n

.meas tran vdout1_108ck1580 FIND v(dout1_108) AT=1590.05n

.meas tran vdout1_109ck1580 FIND v(dout1_109) AT=1590.05n

.meas tran vdout1_110ck1580 FIND v(dout1_110) AT=1590.05n

.meas tran vdout1_111ck1580 FIND v(dout1_111) AT=1590.05n

.meas tran vdout1_112ck1580 FIND v(dout1_112) AT=1590.05n

.meas tran vdout1_113ck1580 FIND v(dout1_113) AT=1590.05n

.meas tran vdout1_114ck1580 FIND v(dout1_114) AT=1590.05n

.meas tran vdout1_115ck1580 FIND v(dout1_115) AT=1590.05n

.meas tran vdout1_116ck1580 FIND v(dout1_116) AT=1590.05n

.meas tran vdout1_117ck1580 FIND v(dout1_117) AT=1590.05n

.meas tran vdout1_118ck1580 FIND v(dout1_118) AT=1590.05n

.meas tran vdout1_119ck1580 FIND v(dout1_119) AT=1590.05n

.meas tran vdout1_120ck1580 FIND v(dout1_120) AT=1590.05n

.meas tran vdout1_121ck1580 FIND v(dout1_121) AT=1590.05n

.meas tran vdout1_122ck1580 FIND v(dout1_122) AT=1590.05n

.meas tran vdout1_123ck1580 FIND v(dout1_123) AT=1590.05n

.meas tran vdout1_124ck1580 FIND v(dout1_124) AT=1590.05n

.meas tran vdout1_125ck1580 FIND v(dout1_125) AT=1590.05n

.meas tran vdout1_126ck1580 FIND v(dout1_126) AT=1590.05n

.meas tran vdout1_127ck1580 FIND v(dout1_127) AT=1590.05n

.meas tran vdout1_128ck1580 FIND v(dout1_128) AT=1590.05n

.meas tran vdout1_129ck1580 FIND v(dout1_129) AT=1590.05n

.meas tran vdout1_130ck1580 FIND v(dout1_130) AT=1590.05n

.meas tran vdout1_131ck1580 FIND v(dout1_131) AT=1590.05n

.meas tran vdout1_132ck1580 FIND v(dout1_132) AT=1590.05n

.meas tran vdout1_133ck1580 FIND v(dout1_133) AT=1590.05n

.meas tran vdout1_134ck1580 FIND v(dout1_134) AT=1590.05n

.meas tran vdout1_0ck1590 FIND v(dout1_0) AT=1600.05n

.meas tran vdout1_1ck1590 FIND v(dout1_1) AT=1600.05n

.meas tran vdout1_2ck1590 FIND v(dout1_2) AT=1600.05n

.meas tran vdout1_3ck1590 FIND v(dout1_3) AT=1600.05n

.meas tran vdout1_4ck1590 FIND v(dout1_4) AT=1600.05n

.meas tran vdout1_5ck1590 FIND v(dout1_5) AT=1600.05n

.meas tran vdout1_6ck1590 FIND v(dout1_6) AT=1600.05n

.meas tran vdout1_7ck1590 FIND v(dout1_7) AT=1600.05n

.meas tran vdout1_8ck1590 FIND v(dout1_8) AT=1600.05n

.meas tran vdout1_9ck1590 FIND v(dout1_9) AT=1600.05n

.meas tran vdout1_10ck1590 FIND v(dout1_10) AT=1600.05n

.meas tran vdout1_11ck1590 FIND v(dout1_11) AT=1600.05n

.meas tran vdout1_12ck1590 FIND v(dout1_12) AT=1600.05n

.meas tran vdout1_13ck1590 FIND v(dout1_13) AT=1600.05n

.meas tran vdout1_14ck1590 FIND v(dout1_14) AT=1600.05n

.meas tran vdout1_15ck1590 FIND v(dout1_15) AT=1600.05n

.meas tran vdout1_16ck1590 FIND v(dout1_16) AT=1600.05n

.meas tran vdout1_17ck1590 FIND v(dout1_17) AT=1600.05n

.meas tran vdout1_18ck1590 FIND v(dout1_18) AT=1600.05n

.meas tran vdout1_19ck1590 FIND v(dout1_19) AT=1600.05n

.meas tran vdout1_20ck1590 FIND v(dout1_20) AT=1600.05n

.meas tran vdout1_21ck1590 FIND v(dout1_21) AT=1600.05n

.meas tran vdout1_22ck1590 FIND v(dout1_22) AT=1600.05n

.meas tran vdout1_23ck1590 FIND v(dout1_23) AT=1600.05n

.meas tran vdout1_24ck1590 FIND v(dout1_24) AT=1600.05n

.meas tran vdout1_25ck1590 FIND v(dout1_25) AT=1600.05n

.meas tran vdout1_26ck1590 FIND v(dout1_26) AT=1600.05n

.meas tran vdout1_27ck1590 FIND v(dout1_27) AT=1600.05n

.meas tran vdout1_28ck1590 FIND v(dout1_28) AT=1600.05n

.meas tran vdout1_29ck1590 FIND v(dout1_29) AT=1600.05n

.meas tran vdout1_30ck1590 FIND v(dout1_30) AT=1600.05n

.meas tran vdout1_31ck1590 FIND v(dout1_31) AT=1600.05n

.meas tran vdout1_32ck1590 FIND v(dout1_32) AT=1600.05n

.meas tran vdout1_33ck1590 FIND v(dout1_33) AT=1600.05n

.meas tran vdout1_34ck1590 FIND v(dout1_34) AT=1600.05n

.meas tran vdout1_35ck1590 FIND v(dout1_35) AT=1600.05n

.meas tran vdout1_36ck1590 FIND v(dout1_36) AT=1600.05n

.meas tran vdout1_37ck1590 FIND v(dout1_37) AT=1600.05n

.meas tran vdout1_38ck1590 FIND v(dout1_38) AT=1600.05n

.meas tran vdout1_39ck1590 FIND v(dout1_39) AT=1600.05n

.meas tran vdout1_40ck1590 FIND v(dout1_40) AT=1600.05n

.meas tran vdout1_41ck1590 FIND v(dout1_41) AT=1600.05n

.meas tran vdout1_42ck1590 FIND v(dout1_42) AT=1600.05n

.meas tran vdout1_43ck1590 FIND v(dout1_43) AT=1600.05n

.meas tran vdout1_44ck1590 FIND v(dout1_44) AT=1600.05n

.meas tran vdout1_45ck1590 FIND v(dout1_45) AT=1600.05n

.meas tran vdout1_46ck1590 FIND v(dout1_46) AT=1600.05n

.meas tran vdout1_47ck1590 FIND v(dout1_47) AT=1600.05n

.meas tran vdout1_48ck1590 FIND v(dout1_48) AT=1600.05n

.meas tran vdout1_49ck1590 FIND v(dout1_49) AT=1600.05n

.meas tran vdout1_50ck1590 FIND v(dout1_50) AT=1600.05n

.meas tran vdout1_51ck1590 FIND v(dout1_51) AT=1600.05n

.meas tran vdout1_52ck1590 FIND v(dout1_52) AT=1600.05n

.meas tran vdout1_53ck1590 FIND v(dout1_53) AT=1600.05n

.meas tran vdout1_54ck1590 FIND v(dout1_54) AT=1600.05n

.meas tran vdout1_55ck1590 FIND v(dout1_55) AT=1600.05n

.meas tran vdout1_56ck1590 FIND v(dout1_56) AT=1600.05n

.meas tran vdout1_57ck1590 FIND v(dout1_57) AT=1600.05n

.meas tran vdout1_58ck1590 FIND v(dout1_58) AT=1600.05n

.meas tran vdout1_59ck1590 FIND v(dout1_59) AT=1600.05n

.meas tran vdout1_60ck1590 FIND v(dout1_60) AT=1600.05n

.meas tran vdout1_61ck1590 FIND v(dout1_61) AT=1600.05n

.meas tran vdout1_62ck1590 FIND v(dout1_62) AT=1600.05n

.meas tran vdout1_63ck1590 FIND v(dout1_63) AT=1600.05n

.meas tran vdout1_64ck1590 FIND v(dout1_64) AT=1600.05n

.meas tran vdout1_65ck1590 FIND v(dout1_65) AT=1600.05n

.meas tran vdout1_66ck1590 FIND v(dout1_66) AT=1600.05n

.meas tran vdout1_67ck1590 FIND v(dout1_67) AT=1600.05n

.meas tran vdout1_68ck1590 FIND v(dout1_68) AT=1600.05n

.meas tran vdout1_69ck1590 FIND v(dout1_69) AT=1600.05n

.meas tran vdout1_70ck1590 FIND v(dout1_70) AT=1600.05n

.meas tran vdout1_71ck1590 FIND v(dout1_71) AT=1600.05n

.meas tran vdout1_72ck1590 FIND v(dout1_72) AT=1600.05n

.meas tran vdout1_73ck1590 FIND v(dout1_73) AT=1600.05n

.meas tran vdout1_74ck1590 FIND v(dout1_74) AT=1600.05n

.meas tran vdout1_75ck1590 FIND v(dout1_75) AT=1600.05n

.meas tran vdout1_76ck1590 FIND v(dout1_76) AT=1600.05n

.meas tran vdout1_77ck1590 FIND v(dout1_77) AT=1600.05n

.meas tran vdout1_78ck1590 FIND v(dout1_78) AT=1600.05n

.meas tran vdout1_79ck1590 FIND v(dout1_79) AT=1600.05n

.meas tran vdout1_80ck1590 FIND v(dout1_80) AT=1600.05n

.meas tran vdout1_81ck1590 FIND v(dout1_81) AT=1600.05n

.meas tran vdout1_82ck1590 FIND v(dout1_82) AT=1600.05n

.meas tran vdout1_83ck1590 FIND v(dout1_83) AT=1600.05n

.meas tran vdout1_84ck1590 FIND v(dout1_84) AT=1600.05n

.meas tran vdout1_85ck1590 FIND v(dout1_85) AT=1600.05n

.meas tran vdout1_86ck1590 FIND v(dout1_86) AT=1600.05n

.meas tran vdout1_87ck1590 FIND v(dout1_87) AT=1600.05n

.meas tran vdout1_88ck1590 FIND v(dout1_88) AT=1600.05n

.meas tran vdout1_89ck1590 FIND v(dout1_89) AT=1600.05n

.meas tran vdout1_90ck1590 FIND v(dout1_90) AT=1600.05n

.meas tran vdout1_91ck1590 FIND v(dout1_91) AT=1600.05n

.meas tran vdout1_92ck1590 FIND v(dout1_92) AT=1600.05n

.meas tran vdout1_93ck1590 FIND v(dout1_93) AT=1600.05n

.meas tran vdout1_94ck1590 FIND v(dout1_94) AT=1600.05n

.meas tran vdout1_95ck1590 FIND v(dout1_95) AT=1600.05n

.meas tran vdout1_96ck1590 FIND v(dout1_96) AT=1600.05n

.meas tran vdout1_97ck1590 FIND v(dout1_97) AT=1600.05n

.meas tran vdout1_98ck1590 FIND v(dout1_98) AT=1600.05n

.meas tran vdout1_99ck1590 FIND v(dout1_99) AT=1600.05n

.meas tran vdout1_100ck1590 FIND v(dout1_100) AT=1600.05n

.meas tran vdout1_101ck1590 FIND v(dout1_101) AT=1600.05n

.meas tran vdout1_102ck1590 FIND v(dout1_102) AT=1600.05n

.meas tran vdout1_103ck1590 FIND v(dout1_103) AT=1600.05n

.meas tran vdout1_104ck1590 FIND v(dout1_104) AT=1600.05n

.meas tran vdout1_105ck1590 FIND v(dout1_105) AT=1600.05n

.meas tran vdout1_106ck1590 FIND v(dout1_106) AT=1600.05n

.meas tran vdout1_107ck1590 FIND v(dout1_107) AT=1600.05n

.meas tran vdout1_108ck1590 FIND v(dout1_108) AT=1600.05n

.meas tran vdout1_109ck1590 FIND v(dout1_109) AT=1600.05n

.meas tran vdout1_110ck1590 FIND v(dout1_110) AT=1600.05n

.meas tran vdout1_111ck1590 FIND v(dout1_111) AT=1600.05n

.meas tran vdout1_112ck1590 FIND v(dout1_112) AT=1600.05n

.meas tran vdout1_113ck1590 FIND v(dout1_113) AT=1600.05n

.meas tran vdout1_114ck1590 FIND v(dout1_114) AT=1600.05n

.meas tran vdout1_115ck1590 FIND v(dout1_115) AT=1600.05n

.meas tran vdout1_116ck1590 FIND v(dout1_116) AT=1600.05n

.meas tran vdout1_117ck1590 FIND v(dout1_117) AT=1600.05n

.meas tran vdout1_118ck1590 FIND v(dout1_118) AT=1600.05n

.meas tran vdout1_119ck1590 FIND v(dout1_119) AT=1600.05n

.meas tran vdout1_120ck1590 FIND v(dout1_120) AT=1600.05n

.meas tran vdout1_121ck1590 FIND v(dout1_121) AT=1600.05n

.meas tran vdout1_122ck1590 FIND v(dout1_122) AT=1600.05n

.meas tran vdout1_123ck1590 FIND v(dout1_123) AT=1600.05n

.meas tran vdout1_124ck1590 FIND v(dout1_124) AT=1600.05n

.meas tran vdout1_125ck1590 FIND v(dout1_125) AT=1600.05n

.meas tran vdout1_126ck1590 FIND v(dout1_126) AT=1600.05n

.meas tran vdout1_127ck1590 FIND v(dout1_127) AT=1600.05n

.meas tran vdout1_128ck1590 FIND v(dout1_128) AT=1600.05n

.meas tran vdout1_129ck1590 FIND v(dout1_129) AT=1600.05n

.meas tran vdout1_130ck1590 FIND v(dout1_130) AT=1600.05n

.meas tran vdout1_131ck1590 FIND v(dout1_131) AT=1600.05n

.meas tran vdout1_132ck1590 FIND v(dout1_132) AT=1600.05n

.meas tran vdout1_133ck1590 FIND v(dout1_133) AT=1600.05n

.meas tran vdout1_134ck1590 FIND v(dout1_134) AT=1600.05n

.meas tran vdout1_0ck1600 FIND v(dout1_0) AT=1610.05n

.meas tran vdout1_1ck1600 FIND v(dout1_1) AT=1610.05n

.meas tran vdout1_2ck1600 FIND v(dout1_2) AT=1610.05n

.meas tran vdout1_3ck1600 FIND v(dout1_3) AT=1610.05n

.meas tran vdout1_4ck1600 FIND v(dout1_4) AT=1610.05n

.meas tran vdout1_5ck1600 FIND v(dout1_5) AT=1610.05n

.meas tran vdout1_6ck1600 FIND v(dout1_6) AT=1610.05n

.meas tran vdout1_7ck1600 FIND v(dout1_7) AT=1610.05n

.meas tran vdout1_8ck1600 FIND v(dout1_8) AT=1610.05n

.meas tran vdout1_9ck1600 FIND v(dout1_9) AT=1610.05n

.meas tran vdout1_10ck1600 FIND v(dout1_10) AT=1610.05n

.meas tran vdout1_11ck1600 FIND v(dout1_11) AT=1610.05n

.meas tran vdout1_12ck1600 FIND v(dout1_12) AT=1610.05n

.meas tran vdout1_13ck1600 FIND v(dout1_13) AT=1610.05n

.meas tran vdout1_14ck1600 FIND v(dout1_14) AT=1610.05n

.meas tran vdout1_15ck1600 FIND v(dout1_15) AT=1610.05n

.meas tran vdout1_16ck1600 FIND v(dout1_16) AT=1610.05n

.meas tran vdout1_17ck1600 FIND v(dout1_17) AT=1610.05n

.meas tran vdout1_18ck1600 FIND v(dout1_18) AT=1610.05n

.meas tran vdout1_19ck1600 FIND v(dout1_19) AT=1610.05n

.meas tran vdout1_20ck1600 FIND v(dout1_20) AT=1610.05n

.meas tran vdout1_21ck1600 FIND v(dout1_21) AT=1610.05n

.meas tran vdout1_22ck1600 FIND v(dout1_22) AT=1610.05n

.meas tran vdout1_23ck1600 FIND v(dout1_23) AT=1610.05n

.meas tran vdout1_24ck1600 FIND v(dout1_24) AT=1610.05n

.meas tran vdout1_25ck1600 FIND v(dout1_25) AT=1610.05n

.meas tran vdout1_26ck1600 FIND v(dout1_26) AT=1610.05n

.meas tran vdout1_27ck1600 FIND v(dout1_27) AT=1610.05n

.meas tran vdout1_28ck1600 FIND v(dout1_28) AT=1610.05n

.meas tran vdout1_29ck1600 FIND v(dout1_29) AT=1610.05n

.meas tran vdout1_30ck1600 FIND v(dout1_30) AT=1610.05n

.meas tran vdout1_31ck1600 FIND v(dout1_31) AT=1610.05n

.meas tran vdout1_32ck1600 FIND v(dout1_32) AT=1610.05n

.meas tran vdout1_33ck1600 FIND v(dout1_33) AT=1610.05n

.meas tran vdout1_34ck1600 FIND v(dout1_34) AT=1610.05n

.meas tran vdout1_35ck1600 FIND v(dout1_35) AT=1610.05n

.meas tran vdout1_36ck1600 FIND v(dout1_36) AT=1610.05n

.meas tran vdout1_37ck1600 FIND v(dout1_37) AT=1610.05n

.meas tran vdout1_38ck1600 FIND v(dout1_38) AT=1610.05n

.meas tran vdout1_39ck1600 FIND v(dout1_39) AT=1610.05n

.meas tran vdout1_40ck1600 FIND v(dout1_40) AT=1610.05n

.meas tran vdout1_41ck1600 FIND v(dout1_41) AT=1610.05n

.meas tran vdout1_42ck1600 FIND v(dout1_42) AT=1610.05n

.meas tran vdout1_43ck1600 FIND v(dout1_43) AT=1610.05n

.meas tran vdout1_44ck1600 FIND v(dout1_44) AT=1610.05n

.meas tran vdout1_45ck1600 FIND v(dout1_45) AT=1610.05n

.meas tran vdout1_46ck1600 FIND v(dout1_46) AT=1610.05n

.meas tran vdout1_47ck1600 FIND v(dout1_47) AT=1610.05n

.meas tran vdout1_48ck1600 FIND v(dout1_48) AT=1610.05n

.meas tran vdout1_49ck1600 FIND v(dout1_49) AT=1610.05n

.meas tran vdout1_50ck1600 FIND v(dout1_50) AT=1610.05n

.meas tran vdout1_51ck1600 FIND v(dout1_51) AT=1610.05n

.meas tran vdout1_52ck1600 FIND v(dout1_52) AT=1610.05n

.meas tran vdout1_53ck1600 FIND v(dout1_53) AT=1610.05n

.meas tran vdout1_54ck1600 FIND v(dout1_54) AT=1610.05n

.meas tran vdout1_55ck1600 FIND v(dout1_55) AT=1610.05n

.meas tran vdout1_56ck1600 FIND v(dout1_56) AT=1610.05n

.meas tran vdout1_57ck1600 FIND v(dout1_57) AT=1610.05n

.meas tran vdout1_58ck1600 FIND v(dout1_58) AT=1610.05n

.meas tran vdout1_59ck1600 FIND v(dout1_59) AT=1610.05n

.meas tran vdout1_60ck1600 FIND v(dout1_60) AT=1610.05n

.meas tran vdout1_61ck1600 FIND v(dout1_61) AT=1610.05n

.meas tran vdout1_62ck1600 FIND v(dout1_62) AT=1610.05n

.meas tran vdout1_63ck1600 FIND v(dout1_63) AT=1610.05n

.meas tran vdout1_64ck1600 FIND v(dout1_64) AT=1610.05n

.meas tran vdout1_65ck1600 FIND v(dout1_65) AT=1610.05n

.meas tran vdout1_66ck1600 FIND v(dout1_66) AT=1610.05n

.meas tran vdout1_67ck1600 FIND v(dout1_67) AT=1610.05n

.meas tran vdout1_68ck1600 FIND v(dout1_68) AT=1610.05n

.meas tran vdout1_69ck1600 FIND v(dout1_69) AT=1610.05n

.meas tran vdout1_70ck1600 FIND v(dout1_70) AT=1610.05n

.meas tran vdout1_71ck1600 FIND v(dout1_71) AT=1610.05n

.meas tran vdout1_72ck1600 FIND v(dout1_72) AT=1610.05n

.meas tran vdout1_73ck1600 FIND v(dout1_73) AT=1610.05n

.meas tran vdout1_74ck1600 FIND v(dout1_74) AT=1610.05n

.meas tran vdout1_75ck1600 FIND v(dout1_75) AT=1610.05n

.meas tran vdout1_76ck1600 FIND v(dout1_76) AT=1610.05n

.meas tran vdout1_77ck1600 FIND v(dout1_77) AT=1610.05n

.meas tran vdout1_78ck1600 FIND v(dout1_78) AT=1610.05n

.meas tran vdout1_79ck1600 FIND v(dout1_79) AT=1610.05n

.meas tran vdout1_80ck1600 FIND v(dout1_80) AT=1610.05n

.meas tran vdout1_81ck1600 FIND v(dout1_81) AT=1610.05n

.meas tran vdout1_82ck1600 FIND v(dout1_82) AT=1610.05n

.meas tran vdout1_83ck1600 FIND v(dout1_83) AT=1610.05n

.meas tran vdout1_84ck1600 FIND v(dout1_84) AT=1610.05n

.meas tran vdout1_85ck1600 FIND v(dout1_85) AT=1610.05n

.meas tran vdout1_86ck1600 FIND v(dout1_86) AT=1610.05n

.meas tran vdout1_87ck1600 FIND v(dout1_87) AT=1610.05n

.meas tran vdout1_88ck1600 FIND v(dout1_88) AT=1610.05n

.meas tran vdout1_89ck1600 FIND v(dout1_89) AT=1610.05n

.meas tran vdout1_90ck1600 FIND v(dout1_90) AT=1610.05n

.meas tran vdout1_91ck1600 FIND v(dout1_91) AT=1610.05n

.meas tran vdout1_92ck1600 FIND v(dout1_92) AT=1610.05n

.meas tran vdout1_93ck1600 FIND v(dout1_93) AT=1610.05n

.meas tran vdout1_94ck1600 FIND v(dout1_94) AT=1610.05n

.meas tran vdout1_95ck1600 FIND v(dout1_95) AT=1610.05n

.meas tran vdout1_96ck1600 FIND v(dout1_96) AT=1610.05n

.meas tran vdout1_97ck1600 FIND v(dout1_97) AT=1610.05n

.meas tran vdout1_98ck1600 FIND v(dout1_98) AT=1610.05n

.meas tran vdout1_99ck1600 FIND v(dout1_99) AT=1610.05n

.meas tran vdout1_100ck1600 FIND v(dout1_100) AT=1610.05n

.meas tran vdout1_101ck1600 FIND v(dout1_101) AT=1610.05n

.meas tran vdout1_102ck1600 FIND v(dout1_102) AT=1610.05n

.meas tran vdout1_103ck1600 FIND v(dout1_103) AT=1610.05n

.meas tran vdout1_104ck1600 FIND v(dout1_104) AT=1610.05n

.meas tran vdout1_105ck1600 FIND v(dout1_105) AT=1610.05n

.meas tran vdout1_106ck1600 FIND v(dout1_106) AT=1610.05n

.meas tran vdout1_107ck1600 FIND v(dout1_107) AT=1610.05n

.meas tran vdout1_108ck1600 FIND v(dout1_108) AT=1610.05n

.meas tran vdout1_109ck1600 FIND v(dout1_109) AT=1610.05n

.meas tran vdout1_110ck1600 FIND v(dout1_110) AT=1610.05n

.meas tran vdout1_111ck1600 FIND v(dout1_111) AT=1610.05n

.meas tran vdout1_112ck1600 FIND v(dout1_112) AT=1610.05n

.meas tran vdout1_113ck1600 FIND v(dout1_113) AT=1610.05n

.meas tran vdout1_114ck1600 FIND v(dout1_114) AT=1610.05n

.meas tran vdout1_115ck1600 FIND v(dout1_115) AT=1610.05n

.meas tran vdout1_116ck1600 FIND v(dout1_116) AT=1610.05n

.meas tran vdout1_117ck1600 FIND v(dout1_117) AT=1610.05n

.meas tran vdout1_118ck1600 FIND v(dout1_118) AT=1610.05n

.meas tran vdout1_119ck1600 FIND v(dout1_119) AT=1610.05n

.meas tran vdout1_120ck1600 FIND v(dout1_120) AT=1610.05n

.meas tran vdout1_121ck1600 FIND v(dout1_121) AT=1610.05n

.meas tran vdout1_122ck1600 FIND v(dout1_122) AT=1610.05n

.meas tran vdout1_123ck1600 FIND v(dout1_123) AT=1610.05n

.meas tran vdout1_124ck1600 FIND v(dout1_124) AT=1610.05n

.meas tran vdout1_125ck1600 FIND v(dout1_125) AT=1610.05n

.meas tran vdout1_126ck1600 FIND v(dout1_126) AT=1610.05n

.meas tran vdout1_127ck1600 FIND v(dout1_127) AT=1610.05n

.meas tran vdout1_128ck1600 FIND v(dout1_128) AT=1610.05n

.meas tran vdout1_129ck1600 FIND v(dout1_129) AT=1610.05n

.meas tran vdout1_130ck1600 FIND v(dout1_130) AT=1610.05n

.meas tran vdout1_131ck1600 FIND v(dout1_131) AT=1610.05n

.meas tran vdout1_132ck1600 FIND v(dout1_132) AT=1610.05n

.meas tran vdout1_133ck1600 FIND v(dout1_133) AT=1610.05n

.meas tran vdout1_134ck1600 FIND v(dout1_134) AT=1610.05n

.meas tran vdout1_0ck1630 FIND v(dout1_0) AT=1640.05n

.meas tran vdout1_1ck1630 FIND v(dout1_1) AT=1640.05n

.meas tran vdout1_2ck1630 FIND v(dout1_2) AT=1640.05n

.meas tran vdout1_3ck1630 FIND v(dout1_3) AT=1640.05n

.meas tran vdout1_4ck1630 FIND v(dout1_4) AT=1640.05n

.meas tran vdout1_5ck1630 FIND v(dout1_5) AT=1640.05n

.meas tran vdout1_6ck1630 FIND v(dout1_6) AT=1640.05n

.meas tran vdout1_7ck1630 FIND v(dout1_7) AT=1640.05n

.meas tran vdout1_8ck1630 FIND v(dout1_8) AT=1640.05n

.meas tran vdout1_9ck1630 FIND v(dout1_9) AT=1640.05n

.meas tran vdout1_10ck1630 FIND v(dout1_10) AT=1640.05n

.meas tran vdout1_11ck1630 FIND v(dout1_11) AT=1640.05n

.meas tran vdout1_12ck1630 FIND v(dout1_12) AT=1640.05n

.meas tran vdout1_13ck1630 FIND v(dout1_13) AT=1640.05n

.meas tran vdout1_14ck1630 FIND v(dout1_14) AT=1640.05n

.meas tran vdout1_15ck1630 FIND v(dout1_15) AT=1640.05n

.meas tran vdout1_16ck1630 FIND v(dout1_16) AT=1640.05n

.meas tran vdout1_17ck1630 FIND v(dout1_17) AT=1640.05n

.meas tran vdout1_18ck1630 FIND v(dout1_18) AT=1640.05n

.meas tran vdout1_19ck1630 FIND v(dout1_19) AT=1640.05n

.meas tran vdout1_20ck1630 FIND v(dout1_20) AT=1640.05n

.meas tran vdout1_21ck1630 FIND v(dout1_21) AT=1640.05n

.meas tran vdout1_22ck1630 FIND v(dout1_22) AT=1640.05n

.meas tran vdout1_23ck1630 FIND v(dout1_23) AT=1640.05n

.meas tran vdout1_24ck1630 FIND v(dout1_24) AT=1640.05n

.meas tran vdout1_25ck1630 FIND v(dout1_25) AT=1640.05n

.meas tran vdout1_26ck1630 FIND v(dout1_26) AT=1640.05n

.meas tran vdout1_27ck1630 FIND v(dout1_27) AT=1640.05n

.meas tran vdout1_28ck1630 FIND v(dout1_28) AT=1640.05n

.meas tran vdout1_29ck1630 FIND v(dout1_29) AT=1640.05n

.meas tran vdout1_30ck1630 FIND v(dout1_30) AT=1640.05n

.meas tran vdout1_31ck1630 FIND v(dout1_31) AT=1640.05n

.meas tran vdout1_32ck1630 FIND v(dout1_32) AT=1640.05n

.meas tran vdout1_33ck1630 FIND v(dout1_33) AT=1640.05n

.meas tran vdout1_34ck1630 FIND v(dout1_34) AT=1640.05n

.meas tran vdout1_35ck1630 FIND v(dout1_35) AT=1640.05n

.meas tran vdout1_36ck1630 FIND v(dout1_36) AT=1640.05n

.meas tran vdout1_37ck1630 FIND v(dout1_37) AT=1640.05n

.meas tran vdout1_38ck1630 FIND v(dout1_38) AT=1640.05n

.meas tran vdout1_39ck1630 FIND v(dout1_39) AT=1640.05n

.meas tran vdout1_40ck1630 FIND v(dout1_40) AT=1640.05n

.meas tran vdout1_41ck1630 FIND v(dout1_41) AT=1640.05n

.meas tran vdout1_42ck1630 FIND v(dout1_42) AT=1640.05n

.meas tran vdout1_43ck1630 FIND v(dout1_43) AT=1640.05n

.meas tran vdout1_44ck1630 FIND v(dout1_44) AT=1640.05n

.meas tran vdout1_45ck1630 FIND v(dout1_45) AT=1640.05n

.meas tran vdout1_46ck1630 FIND v(dout1_46) AT=1640.05n

.meas tran vdout1_47ck1630 FIND v(dout1_47) AT=1640.05n

.meas tran vdout1_48ck1630 FIND v(dout1_48) AT=1640.05n

.meas tran vdout1_49ck1630 FIND v(dout1_49) AT=1640.05n

.meas tran vdout1_50ck1630 FIND v(dout1_50) AT=1640.05n

.meas tran vdout1_51ck1630 FIND v(dout1_51) AT=1640.05n

.meas tran vdout1_52ck1630 FIND v(dout1_52) AT=1640.05n

.meas tran vdout1_53ck1630 FIND v(dout1_53) AT=1640.05n

.meas tran vdout1_54ck1630 FIND v(dout1_54) AT=1640.05n

.meas tran vdout1_55ck1630 FIND v(dout1_55) AT=1640.05n

.meas tran vdout1_56ck1630 FIND v(dout1_56) AT=1640.05n

.meas tran vdout1_57ck1630 FIND v(dout1_57) AT=1640.05n

.meas tran vdout1_58ck1630 FIND v(dout1_58) AT=1640.05n

.meas tran vdout1_59ck1630 FIND v(dout1_59) AT=1640.05n

.meas tran vdout1_60ck1630 FIND v(dout1_60) AT=1640.05n

.meas tran vdout1_61ck1630 FIND v(dout1_61) AT=1640.05n

.meas tran vdout1_62ck1630 FIND v(dout1_62) AT=1640.05n

.meas tran vdout1_63ck1630 FIND v(dout1_63) AT=1640.05n

.meas tran vdout1_64ck1630 FIND v(dout1_64) AT=1640.05n

.meas tran vdout1_65ck1630 FIND v(dout1_65) AT=1640.05n

.meas tran vdout1_66ck1630 FIND v(dout1_66) AT=1640.05n

.meas tran vdout1_67ck1630 FIND v(dout1_67) AT=1640.05n

.meas tran vdout1_68ck1630 FIND v(dout1_68) AT=1640.05n

.meas tran vdout1_69ck1630 FIND v(dout1_69) AT=1640.05n

.meas tran vdout1_70ck1630 FIND v(dout1_70) AT=1640.05n

.meas tran vdout1_71ck1630 FIND v(dout1_71) AT=1640.05n

.meas tran vdout1_72ck1630 FIND v(dout1_72) AT=1640.05n

.meas tran vdout1_73ck1630 FIND v(dout1_73) AT=1640.05n

.meas tran vdout1_74ck1630 FIND v(dout1_74) AT=1640.05n

.meas tran vdout1_75ck1630 FIND v(dout1_75) AT=1640.05n

.meas tran vdout1_76ck1630 FIND v(dout1_76) AT=1640.05n

.meas tran vdout1_77ck1630 FIND v(dout1_77) AT=1640.05n

.meas tran vdout1_78ck1630 FIND v(dout1_78) AT=1640.05n

.meas tran vdout1_79ck1630 FIND v(dout1_79) AT=1640.05n

.meas tran vdout1_80ck1630 FIND v(dout1_80) AT=1640.05n

.meas tran vdout1_81ck1630 FIND v(dout1_81) AT=1640.05n

.meas tran vdout1_82ck1630 FIND v(dout1_82) AT=1640.05n

.meas tran vdout1_83ck1630 FIND v(dout1_83) AT=1640.05n

.meas tran vdout1_84ck1630 FIND v(dout1_84) AT=1640.05n

.meas tran vdout1_85ck1630 FIND v(dout1_85) AT=1640.05n

.meas tran vdout1_86ck1630 FIND v(dout1_86) AT=1640.05n

.meas tran vdout1_87ck1630 FIND v(dout1_87) AT=1640.05n

.meas tran vdout1_88ck1630 FIND v(dout1_88) AT=1640.05n

.meas tran vdout1_89ck1630 FIND v(dout1_89) AT=1640.05n

.meas tran vdout1_90ck1630 FIND v(dout1_90) AT=1640.05n

.meas tran vdout1_91ck1630 FIND v(dout1_91) AT=1640.05n

.meas tran vdout1_92ck1630 FIND v(dout1_92) AT=1640.05n

.meas tran vdout1_93ck1630 FIND v(dout1_93) AT=1640.05n

.meas tran vdout1_94ck1630 FIND v(dout1_94) AT=1640.05n

.meas tran vdout1_95ck1630 FIND v(dout1_95) AT=1640.05n

.meas tran vdout1_96ck1630 FIND v(dout1_96) AT=1640.05n

.meas tran vdout1_97ck1630 FIND v(dout1_97) AT=1640.05n

.meas tran vdout1_98ck1630 FIND v(dout1_98) AT=1640.05n

.meas tran vdout1_99ck1630 FIND v(dout1_99) AT=1640.05n

.meas tran vdout1_100ck1630 FIND v(dout1_100) AT=1640.05n

.meas tran vdout1_101ck1630 FIND v(dout1_101) AT=1640.05n

.meas tran vdout1_102ck1630 FIND v(dout1_102) AT=1640.05n

.meas tran vdout1_103ck1630 FIND v(dout1_103) AT=1640.05n

.meas tran vdout1_104ck1630 FIND v(dout1_104) AT=1640.05n

.meas tran vdout1_105ck1630 FIND v(dout1_105) AT=1640.05n

.meas tran vdout1_106ck1630 FIND v(dout1_106) AT=1640.05n

.meas tran vdout1_107ck1630 FIND v(dout1_107) AT=1640.05n

.meas tran vdout1_108ck1630 FIND v(dout1_108) AT=1640.05n

.meas tran vdout1_109ck1630 FIND v(dout1_109) AT=1640.05n

.meas tran vdout1_110ck1630 FIND v(dout1_110) AT=1640.05n

.meas tran vdout1_111ck1630 FIND v(dout1_111) AT=1640.05n

.meas tran vdout1_112ck1630 FIND v(dout1_112) AT=1640.05n

.meas tran vdout1_113ck1630 FIND v(dout1_113) AT=1640.05n

.meas tran vdout1_114ck1630 FIND v(dout1_114) AT=1640.05n

.meas tran vdout1_115ck1630 FIND v(dout1_115) AT=1640.05n

.meas tran vdout1_116ck1630 FIND v(dout1_116) AT=1640.05n

.meas tran vdout1_117ck1630 FIND v(dout1_117) AT=1640.05n

.meas tran vdout1_118ck1630 FIND v(dout1_118) AT=1640.05n

.meas tran vdout1_119ck1630 FIND v(dout1_119) AT=1640.05n

.meas tran vdout1_120ck1630 FIND v(dout1_120) AT=1640.05n

.meas tran vdout1_121ck1630 FIND v(dout1_121) AT=1640.05n

.meas tran vdout1_122ck1630 FIND v(dout1_122) AT=1640.05n

.meas tran vdout1_123ck1630 FIND v(dout1_123) AT=1640.05n

.meas tran vdout1_124ck1630 FIND v(dout1_124) AT=1640.05n

.meas tran vdout1_125ck1630 FIND v(dout1_125) AT=1640.05n

.meas tran vdout1_126ck1630 FIND v(dout1_126) AT=1640.05n

.meas tran vdout1_127ck1630 FIND v(dout1_127) AT=1640.05n

.meas tran vdout1_128ck1630 FIND v(dout1_128) AT=1640.05n

.meas tran vdout1_129ck1630 FIND v(dout1_129) AT=1640.05n

.meas tran vdout1_130ck1630 FIND v(dout1_130) AT=1640.05n

.meas tran vdout1_131ck1630 FIND v(dout1_131) AT=1640.05n

.meas tran vdout1_132ck1630 FIND v(dout1_132) AT=1640.05n

.meas tran vdout1_133ck1630 FIND v(dout1_133) AT=1640.05n

.meas tran vdout1_134ck1630 FIND v(dout1_134) AT=1640.05n

.meas tran vdout1_0ck1640 FIND v(dout1_0) AT=1650.05n

.meas tran vdout1_1ck1640 FIND v(dout1_1) AT=1650.05n

.meas tran vdout1_2ck1640 FIND v(dout1_2) AT=1650.05n

.meas tran vdout1_3ck1640 FIND v(dout1_3) AT=1650.05n

.meas tran vdout1_4ck1640 FIND v(dout1_4) AT=1650.05n

.meas tran vdout1_5ck1640 FIND v(dout1_5) AT=1650.05n

.meas tran vdout1_6ck1640 FIND v(dout1_6) AT=1650.05n

.meas tran vdout1_7ck1640 FIND v(dout1_7) AT=1650.05n

.meas tran vdout1_8ck1640 FIND v(dout1_8) AT=1650.05n

.meas tran vdout1_9ck1640 FIND v(dout1_9) AT=1650.05n

.meas tran vdout1_10ck1640 FIND v(dout1_10) AT=1650.05n

.meas tran vdout1_11ck1640 FIND v(dout1_11) AT=1650.05n

.meas tran vdout1_12ck1640 FIND v(dout1_12) AT=1650.05n

.meas tran vdout1_13ck1640 FIND v(dout1_13) AT=1650.05n

.meas tran vdout1_14ck1640 FIND v(dout1_14) AT=1650.05n

.meas tran vdout1_15ck1640 FIND v(dout1_15) AT=1650.05n

.meas tran vdout1_16ck1640 FIND v(dout1_16) AT=1650.05n

.meas tran vdout1_17ck1640 FIND v(dout1_17) AT=1650.05n

.meas tran vdout1_18ck1640 FIND v(dout1_18) AT=1650.05n

.meas tran vdout1_19ck1640 FIND v(dout1_19) AT=1650.05n

.meas tran vdout1_20ck1640 FIND v(dout1_20) AT=1650.05n

.meas tran vdout1_21ck1640 FIND v(dout1_21) AT=1650.05n

.meas tran vdout1_22ck1640 FIND v(dout1_22) AT=1650.05n

.meas tran vdout1_23ck1640 FIND v(dout1_23) AT=1650.05n

.meas tran vdout1_24ck1640 FIND v(dout1_24) AT=1650.05n

.meas tran vdout1_25ck1640 FIND v(dout1_25) AT=1650.05n

.meas tran vdout1_26ck1640 FIND v(dout1_26) AT=1650.05n

.meas tran vdout1_27ck1640 FIND v(dout1_27) AT=1650.05n

.meas tran vdout1_28ck1640 FIND v(dout1_28) AT=1650.05n

.meas tran vdout1_29ck1640 FIND v(dout1_29) AT=1650.05n

.meas tran vdout1_30ck1640 FIND v(dout1_30) AT=1650.05n

.meas tran vdout1_31ck1640 FIND v(dout1_31) AT=1650.05n

.meas tran vdout1_32ck1640 FIND v(dout1_32) AT=1650.05n

.meas tran vdout1_33ck1640 FIND v(dout1_33) AT=1650.05n

.meas tran vdout1_34ck1640 FIND v(dout1_34) AT=1650.05n

.meas tran vdout1_35ck1640 FIND v(dout1_35) AT=1650.05n

.meas tran vdout1_36ck1640 FIND v(dout1_36) AT=1650.05n

.meas tran vdout1_37ck1640 FIND v(dout1_37) AT=1650.05n

.meas tran vdout1_38ck1640 FIND v(dout1_38) AT=1650.05n

.meas tran vdout1_39ck1640 FIND v(dout1_39) AT=1650.05n

.meas tran vdout1_40ck1640 FIND v(dout1_40) AT=1650.05n

.meas tran vdout1_41ck1640 FIND v(dout1_41) AT=1650.05n

.meas tran vdout1_42ck1640 FIND v(dout1_42) AT=1650.05n

.meas tran vdout1_43ck1640 FIND v(dout1_43) AT=1650.05n

.meas tran vdout1_44ck1640 FIND v(dout1_44) AT=1650.05n

.meas tran vdout1_45ck1640 FIND v(dout1_45) AT=1650.05n

.meas tran vdout1_46ck1640 FIND v(dout1_46) AT=1650.05n

.meas tran vdout1_47ck1640 FIND v(dout1_47) AT=1650.05n

.meas tran vdout1_48ck1640 FIND v(dout1_48) AT=1650.05n

.meas tran vdout1_49ck1640 FIND v(dout1_49) AT=1650.05n

.meas tran vdout1_50ck1640 FIND v(dout1_50) AT=1650.05n

.meas tran vdout1_51ck1640 FIND v(dout1_51) AT=1650.05n

.meas tran vdout1_52ck1640 FIND v(dout1_52) AT=1650.05n

.meas tran vdout1_53ck1640 FIND v(dout1_53) AT=1650.05n

.meas tran vdout1_54ck1640 FIND v(dout1_54) AT=1650.05n

.meas tran vdout1_55ck1640 FIND v(dout1_55) AT=1650.05n

.meas tran vdout1_56ck1640 FIND v(dout1_56) AT=1650.05n

.meas tran vdout1_57ck1640 FIND v(dout1_57) AT=1650.05n

.meas tran vdout1_58ck1640 FIND v(dout1_58) AT=1650.05n

.meas tran vdout1_59ck1640 FIND v(dout1_59) AT=1650.05n

.meas tran vdout1_60ck1640 FIND v(dout1_60) AT=1650.05n

.meas tran vdout1_61ck1640 FIND v(dout1_61) AT=1650.05n

.meas tran vdout1_62ck1640 FIND v(dout1_62) AT=1650.05n

.meas tran vdout1_63ck1640 FIND v(dout1_63) AT=1650.05n

.meas tran vdout1_64ck1640 FIND v(dout1_64) AT=1650.05n

.meas tran vdout1_65ck1640 FIND v(dout1_65) AT=1650.05n

.meas tran vdout1_66ck1640 FIND v(dout1_66) AT=1650.05n

.meas tran vdout1_67ck1640 FIND v(dout1_67) AT=1650.05n

.meas tran vdout1_68ck1640 FIND v(dout1_68) AT=1650.05n

.meas tran vdout1_69ck1640 FIND v(dout1_69) AT=1650.05n

.meas tran vdout1_70ck1640 FIND v(dout1_70) AT=1650.05n

.meas tran vdout1_71ck1640 FIND v(dout1_71) AT=1650.05n

.meas tran vdout1_72ck1640 FIND v(dout1_72) AT=1650.05n

.meas tran vdout1_73ck1640 FIND v(dout1_73) AT=1650.05n

.meas tran vdout1_74ck1640 FIND v(dout1_74) AT=1650.05n

.meas tran vdout1_75ck1640 FIND v(dout1_75) AT=1650.05n

.meas tran vdout1_76ck1640 FIND v(dout1_76) AT=1650.05n

.meas tran vdout1_77ck1640 FIND v(dout1_77) AT=1650.05n

.meas tran vdout1_78ck1640 FIND v(dout1_78) AT=1650.05n

.meas tran vdout1_79ck1640 FIND v(dout1_79) AT=1650.05n

.meas tran vdout1_80ck1640 FIND v(dout1_80) AT=1650.05n

.meas tran vdout1_81ck1640 FIND v(dout1_81) AT=1650.05n

.meas tran vdout1_82ck1640 FIND v(dout1_82) AT=1650.05n

.meas tran vdout1_83ck1640 FIND v(dout1_83) AT=1650.05n

.meas tran vdout1_84ck1640 FIND v(dout1_84) AT=1650.05n

.meas tran vdout1_85ck1640 FIND v(dout1_85) AT=1650.05n

.meas tran vdout1_86ck1640 FIND v(dout1_86) AT=1650.05n

.meas tran vdout1_87ck1640 FIND v(dout1_87) AT=1650.05n

.meas tran vdout1_88ck1640 FIND v(dout1_88) AT=1650.05n

.meas tran vdout1_89ck1640 FIND v(dout1_89) AT=1650.05n

.meas tran vdout1_90ck1640 FIND v(dout1_90) AT=1650.05n

.meas tran vdout1_91ck1640 FIND v(dout1_91) AT=1650.05n

.meas tran vdout1_92ck1640 FIND v(dout1_92) AT=1650.05n

.meas tran vdout1_93ck1640 FIND v(dout1_93) AT=1650.05n

.meas tran vdout1_94ck1640 FIND v(dout1_94) AT=1650.05n

.meas tran vdout1_95ck1640 FIND v(dout1_95) AT=1650.05n

.meas tran vdout1_96ck1640 FIND v(dout1_96) AT=1650.05n

.meas tran vdout1_97ck1640 FIND v(dout1_97) AT=1650.05n

.meas tran vdout1_98ck1640 FIND v(dout1_98) AT=1650.05n

.meas tran vdout1_99ck1640 FIND v(dout1_99) AT=1650.05n

.meas tran vdout1_100ck1640 FIND v(dout1_100) AT=1650.05n

.meas tran vdout1_101ck1640 FIND v(dout1_101) AT=1650.05n

.meas tran vdout1_102ck1640 FIND v(dout1_102) AT=1650.05n

.meas tran vdout1_103ck1640 FIND v(dout1_103) AT=1650.05n

.meas tran vdout1_104ck1640 FIND v(dout1_104) AT=1650.05n

.meas tran vdout1_105ck1640 FIND v(dout1_105) AT=1650.05n

.meas tran vdout1_106ck1640 FIND v(dout1_106) AT=1650.05n

.meas tran vdout1_107ck1640 FIND v(dout1_107) AT=1650.05n

.meas tran vdout1_108ck1640 FIND v(dout1_108) AT=1650.05n

.meas tran vdout1_109ck1640 FIND v(dout1_109) AT=1650.05n

.meas tran vdout1_110ck1640 FIND v(dout1_110) AT=1650.05n

.meas tran vdout1_111ck1640 FIND v(dout1_111) AT=1650.05n

.meas tran vdout1_112ck1640 FIND v(dout1_112) AT=1650.05n

.meas tran vdout1_113ck1640 FIND v(dout1_113) AT=1650.05n

.meas tran vdout1_114ck1640 FIND v(dout1_114) AT=1650.05n

.meas tran vdout1_115ck1640 FIND v(dout1_115) AT=1650.05n

.meas tran vdout1_116ck1640 FIND v(dout1_116) AT=1650.05n

.meas tran vdout1_117ck1640 FIND v(dout1_117) AT=1650.05n

.meas tran vdout1_118ck1640 FIND v(dout1_118) AT=1650.05n

.meas tran vdout1_119ck1640 FIND v(dout1_119) AT=1650.05n

.meas tran vdout1_120ck1640 FIND v(dout1_120) AT=1650.05n

.meas tran vdout1_121ck1640 FIND v(dout1_121) AT=1650.05n

.meas tran vdout1_122ck1640 FIND v(dout1_122) AT=1650.05n

.meas tran vdout1_123ck1640 FIND v(dout1_123) AT=1650.05n

.meas tran vdout1_124ck1640 FIND v(dout1_124) AT=1650.05n

.meas tran vdout1_125ck1640 FIND v(dout1_125) AT=1650.05n

.meas tran vdout1_126ck1640 FIND v(dout1_126) AT=1650.05n

.meas tran vdout1_127ck1640 FIND v(dout1_127) AT=1650.05n

.meas tran vdout1_128ck1640 FIND v(dout1_128) AT=1650.05n

.meas tran vdout1_129ck1640 FIND v(dout1_129) AT=1650.05n

.meas tran vdout1_130ck1640 FIND v(dout1_130) AT=1650.05n

.meas tran vdout1_131ck1640 FIND v(dout1_131) AT=1650.05n

.meas tran vdout1_132ck1640 FIND v(dout1_132) AT=1650.05n

.meas tran vdout1_133ck1640 FIND v(dout1_133) AT=1650.05n

.meas tran vdout1_134ck1640 FIND v(dout1_134) AT=1650.05n

.meas tran vdout1_0ck1660 FIND v(dout1_0) AT=1670.05n

.meas tran vdout1_1ck1660 FIND v(dout1_1) AT=1670.05n

.meas tran vdout1_2ck1660 FIND v(dout1_2) AT=1670.05n

.meas tran vdout1_3ck1660 FIND v(dout1_3) AT=1670.05n

.meas tran vdout1_4ck1660 FIND v(dout1_4) AT=1670.05n

.meas tran vdout1_5ck1660 FIND v(dout1_5) AT=1670.05n

.meas tran vdout1_6ck1660 FIND v(dout1_6) AT=1670.05n

.meas tran vdout1_7ck1660 FIND v(dout1_7) AT=1670.05n

.meas tran vdout1_8ck1660 FIND v(dout1_8) AT=1670.05n

.meas tran vdout1_9ck1660 FIND v(dout1_9) AT=1670.05n

.meas tran vdout1_10ck1660 FIND v(dout1_10) AT=1670.05n

.meas tran vdout1_11ck1660 FIND v(dout1_11) AT=1670.05n

.meas tran vdout1_12ck1660 FIND v(dout1_12) AT=1670.05n

.meas tran vdout1_13ck1660 FIND v(dout1_13) AT=1670.05n

.meas tran vdout1_14ck1660 FIND v(dout1_14) AT=1670.05n

.meas tran vdout1_15ck1660 FIND v(dout1_15) AT=1670.05n

.meas tran vdout1_16ck1660 FIND v(dout1_16) AT=1670.05n

.meas tran vdout1_17ck1660 FIND v(dout1_17) AT=1670.05n

.meas tran vdout1_18ck1660 FIND v(dout1_18) AT=1670.05n

.meas tran vdout1_19ck1660 FIND v(dout1_19) AT=1670.05n

.meas tran vdout1_20ck1660 FIND v(dout1_20) AT=1670.05n

.meas tran vdout1_21ck1660 FIND v(dout1_21) AT=1670.05n

.meas tran vdout1_22ck1660 FIND v(dout1_22) AT=1670.05n

.meas tran vdout1_23ck1660 FIND v(dout1_23) AT=1670.05n

.meas tran vdout1_24ck1660 FIND v(dout1_24) AT=1670.05n

.meas tran vdout1_25ck1660 FIND v(dout1_25) AT=1670.05n

.meas tran vdout1_26ck1660 FIND v(dout1_26) AT=1670.05n

.meas tran vdout1_27ck1660 FIND v(dout1_27) AT=1670.05n

.meas tran vdout1_28ck1660 FIND v(dout1_28) AT=1670.05n

.meas tran vdout1_29ck1660 FIND v(dout1_29) AT=1670.05n

.meas tran vdout1_30ck1660 FIND v(dout1_30) AT=1670.05n

.meas tran vdout1_31ck1660 FIND v(dout1_31) AT=1670.05n

.meas tran vdout1_32ck1660 FIND v(dout1_32) AT=1670.05n

.meas tran vdout1_33ck1660 FIND v(dout1_33) AT=1670.05n

.meas tran vdout1_34ck1660 FIND v(dout1_34) AT=1670.05n

.meas tran vdout1_35ck1660 FIND v(dout1_35) AT=1670.05n

.meas tran vdout1_36ck1660 FIND v(dout1_36) AT=1670.05n

.meas tran vdout1_37ck1660 FIND v(dout1_37) AT=1670.05n

.meas tran vdout1_38ck1660 FIND v(dout1_38) AT=1670.05n

.meas tran vdout1_39ck1660 FIND v(dout1_39) AT=1670.05n

.meas tran vdout1_40ck1660 FIND v(dout1_40) AT=1670.05n

.meas tran vdout1_41ck1660 FIND v(dout1_41) AT=1670.05n

.meas tran vdout1_42ck1660 FIND v(dout1_42) AT=1670.05n

.meas tran vdout1_43ck1660 FIND v(dout1_43) AT=1670.05n

.meas tran vdout1_44ck1660 FIND v(dout1_44) AT=1670.05n

.meas tran vdout1_45ck1660 FIND v(dout1_45) AT=1670.05n

.meas tran vdout1_46ck1660 FIND v(dout1_46) AT=1670.05n

.meas tran vdout1_47ck1660 FIND v(dout1_47) AT=1670.05n

.meas tran vdout1_48ck1660 FIND v(dout1_48) AT=1670.05n

.meas tran vdout1_49ck1660 FIND v(dout1_49) AT=1670.05n

.meas tran vdout1_50ck1660 FIND v(dout1_50) AT=1670.05n

.meas tran vdout1_51ck1660 FIND v(dout1_51) AT=1670.05n

.meas tran vdout1_52ck1660 FIND v(dout1_52) AT=1670.05n

.meas tran vdout1_53ck1660 FIND v(dout1_53) AT=1670.05n

.meas tran vdout1_54ck1660 FIND v(dout1_54) AT=1670.05n

.meas tran vdout1_55ck1660 FIND v(dout1_55) AT=1670.05n

.meas tran vdout1_56ck1660 FIND v(dout1_56) AT=1670.05n

.meas tran vdout1_57ck1660 FIND v(dout1_57) AT=1670.05n

.meas tran vdout1_58ck1660 FIND v(dout1_58) AT=1670.05n

.meas tran vdout1_59ck1660 FIND v(dout1_59) AT=1670.05n

.meas tran vdout1_60ck1660 FIND v(dout1_60) AT=1670.05n

.meas tran vdout1_61ck1660 FIND v(dout1_61) AT=1670.05n

.meas tran vdout1_62ck1660 FIND v(dout1_62) AT=1670.05n

.meas tran vdout1_63ck1660 FIND v(dout1_63) AT=1670.05n

.meas tran vdout1_64ck1660 FIND v(dout1_64) AT=1670.05n

.meas tran vdout1_65ck1660 FIND v(dout1_65) AT=1670.05n

.meas tran vdout1_66ck1660 FIND v(dout1_66) AT=1670.05n

.meas tran vdout1_67ck1660 FIND v(dout1_67) AT=1670.05n

.meas tran vdout1_68ck1660 FIND v(dout1_68) AT=1670.05n

.meas tran vdout1_69ck1660 FIND v(dout1_69) AT=1670.05n

.meas tran vdout1_70ck1660 FIND v(dout1_70) AT=1670.05n

.meas tran vdout1_71ck1660 FIND v(dout1_71) AT=1670.05n

.meas tran vdout1_72ck1660 FIND v(dout1_72) AT=1670.05n

.meas tran vdout1_73ck1660 FIND v(dout1_73) AT=1670.05n

.meas tran vdout1_74ck1660 FIND v(dout1_74) AT=1670.05n

.meas tran vdout1_75ck1660 FIND v(dout1_75) AT=1670.05n

.meas tran vdout1_76ck1660 FIND v(dout1_76) AT=1670.05n

.meas tran vdout1_77ck1660 FIND v(dout1_77) AT=1670.05n

.meas tran vdout1_78ck1660 FIND v(dout1_78) AT=1670.05n

.meas tran vdout1_79ck1660 FIND v(dout1_79) AT=1670.05n

.meas tran vdout1_80ck1660 FIND v(dout1_80) AT=1670.05n

.meas tran vdout1_81ck1660 FIND v(dout1_81) AT=1670.05n

.meas tran vdout1_82ck1660 FIND v(dout1_82) AT=1670.05n

.meas tran vdout1_83ck1660 FIND v(dout1_83) AT=1670.05n

.meas tran vdout1_84ck1660 FIND v(dout1_84) AT=1670.05n

.meas tran vdout1_85ck1660 FIND v(dout1_85) AT=1670.05n

.meas tran vdout1_86ck1660 FIND v(dout1_86) AT=1670.05n

.meas tran vdout1_87ck1660 FIND v(dout1_87) AT=1670.05n

.meas tran vdout1_88ck1660 FIND v(dout1_88) AT=1670.05n

.meas tran vdout1_89ck1660 FIND v(dout1_89) AT=1670.05n

.meas tran vdout1_90ck1660 FIND v(dout1_90) AT=1670.05n

.meas tran vdout1_91ck1660 FIND v(dout1_91) AT=1670.05n

.meas tran vdout1_92ck1660 FIND v(dout1_92) AT=1670.05n

.meas tran vdout1_93ck1660 FIND v(dout1_93) AT=1670.05n

.meas tran vdout1_94ck1660 FIND v(dout1_94) AT=1670.05n

.meas tran vdout1_95ck1660 FIND v(dout1_95) AT=1670.05n

.meas tran vdout1_96ck1660 FIND v(dout1_96) AT=1670.05n

.meas tran vdout1_97ck1660 FIND v(dout1_97) AT=1670.05n

.meas tran vdout1_98ck1660 FIND v(dout1_98) AT=1670.05n

.meas tran vdout1_99ck1660 FIND v(dout1_99) AT=1670.05n

.meas tran vdout1_100ck1660 FIND v(dout1_100) AT=1670.05n

.meas tran vdout1_101ck1660 FIND v(dout1_101) AT=1670.05n

.meas tran vdout1_102ck1660 FIND v(dout1_102) AT=1670.05n

.meas tran vdout1_103ck1660 FIND v(dout1_103) AT=1670.05n

.meas tran vdout1_104ck1660 FIND v(dout1_104) AT=1670.05n

.meas tran vdout1_105ck1660 FIND v(dout1_105) AT=1670.05n

.meas tran vdout1_106ck1660 FIND v(dout1_106) AT=1670.05n

.meas tran vdout1_107ck1660 FIND v(dout1_107) AT=1670.05n

.meas tran vdout1_108ck1660 FIND v(dout1_108) AT=1670.05n

.meas tran vdout1_109ck1660 FIND v(dout1_109) AT=1670.05n

.meas tran vdout1_110ck1660 FIND v(dout1_110) AT=1670.05n

.meas tran vdout1_111ck1660 FIND v(dout1_111) AT=1670.05n

.meas tran vdout1_112ck1660 FIND v(dout1_112) AT=1670.05n

.meas tran vdout1_113ck1660 FIND v(dout1_113) AT=1670.05n

.meas tran vdout1_114ck1660 FIND v(dout1_114) AT=1670.05n

.meas tran vdout1_115ck1660 FIND v(dout1_115) AT=1670.05n

.meas tran vdout1_116ck1660 FIND v(dout1_116) AT=1670.05n

.meas tran vdout1_117ck1660 FIND v(dout1_117) AT=1670.05n

.meas tran vdout1_118ck1660 FIND v(dout1_118) AT=1670.05n

.meas tran vdout1_119ck1660 FIND v(dout1_119) AT=1670.05n

.meas tran vdout1_120ck1660 FIND v(dout1_120) AT=1670.05n

.meas tran vdout1_121ck1660 FIND v(dout1_121) AT=1670.05n

.meas tran vdout1_122ck1660 FIND v(dout1_122) AT=1670.05n

.meas tran vdout1_123ck1660 FIND v(dout1_123) AT=1670.05n

.meas tran vdout1_124ck1660 FIND v(dout1_124) AT=1670.05n

.meas tran vdout1_125ck1660 FIND v(dout1_125) AT=1670.05n

.meas tran vdout1_126ck1660 FIND v(dout1_126) AT=1670.05n

.meas tran vdout1_127ck1660 FIND v(dout1_127) AT=1670.05n

.meas tran vdout1_128ck1660 FIND v(dout1_128) AT=1670.05n

.meas tran vdout1_129ck1660 FIND v(dout1_129) AT=1670.05n

.meas tran vdout1_130ck1660 FIND v(dout1_130) AT=1670.05n

.meas tran vdout1_131ck1660 FIND v(dout1_131) AT=1670.05n

.meas tran vdout1_132ck1660 FIND v(dout1_132) AT=1670.05n

.meas tran vdout1_133ck1660 FIND v(dout1_133) AT=1670.05n

.meas tran vdout1_134ck1660 FIND v(dout1_134) AT=1670.05n

.meas tran vdout1_0ck1680 FIND v(dout1_0) AT=1690.05n

.meas tran vdout1_1ck1680 FIND v(dout1_1) AT=1690.05n

.meas tran vdout1_2ck1680 FIND v(dout1_2) AT=1690.05n

.meas tran vdout1_3ck1680 FIND v(dout1_3) AT=1690.05n

.meas tran vdout1_4ck1680 FIND v(dout1_4) AT=1690.05n

.meas tran vdout1_5ck1680 FIND v(dout1_5) AT=1690.05n

.meas tran vdout1_6ck1680 FIND v(dout1_6) AT=1690.05n

.meas tran vdout1_7ck1680 FIND v(dout1_7) AT=1690.05n

.meas tran vdout1_8ck1680 FIND v(dout1_8) AT=1690.05n

.meas tran vdout1_9ck1680 FIND v(dout1_9) AT=1690.05n

.meas tran vdout1_10ck1680 FIND v(dout1_10) AT=1690.05n

.meas tran vdout1_11ck1680 FIND v(dout1_11) AT=1690.05n

.meas tran vdout1_12ck1680 FIND v(dout1_12) AT=1690.05n

.meas tran vdout1_13ck1680 FIND v(dout1_13) AT=1690.05n

.meas tran vdout1_14ck1680 FIND v(dout1_14) AT=1690.05n

.meas tran vdout1_15ck1680 FIND v(dout1_15) AT=1690.05n

.meas tran vdout1_16ck1680 FIND v(dout1_16) AT=1690.05n

.meas tran vdout1_17ck1680 FIND v(dout1_17) AT=1690.05n

.meas tran vdout1_18ck1680 FIND v(dout1_18) AT=1690.05n

.meas tran vdout1_19ck1680 FIND v(dout1_19) AT=1690.05n

.meas tran vdout1_20ck1680 FIND v(dout1_20) AT=1690.05n

.meas tran vdout1_21ck1680 FIND v(dout1_21) AT=1690.05n

.meas tran vdout1_22ck1680 FIND v(dout1_22) AT=1690.05n

.meas tran vdout1_23ck1680 FIND v(dout1_23) AT=1690.05n

.meas tran vdout1_24ck1680 FIND v(dout1_24) AT=1690.05n

.meas tran vdout1_25ck1680 FIND v(dout1_25) AT=1690.05n

.meas tran vdout1_26ck1680 FIND v(dout1_26) AT=1690.05n

.meas tran vdout1_27ck1680 FIND v(dout1_27) AT=1690.05n

.meas tran vdout1_28ck1680 FIND v(dout1_28) AT=1690.05n

.meas tran vdout1_29ck1680 FIND v(dout1_29) AT=1690.05n

.meas tran vdout1_30ck1680 FIND v(dout1_30) AT=1690.05n

.meas tran vdout1_31ck1680 FIND v(dout1_31) AT=1690.05n

.meas tran vdout1_32ck1680 FIND v(dout1_32) AT=1690.05n

.meas tran vdout1_33ck1680 FIND v(dout1_33) AT=1690.05n

.meas tran vdout1_34ck1680 FIND v(dout1_34) AT=1690.05n

.meas tran vdout1_35ck1680 FIND v(dout1_35) AT=1690.05n

.meas tran vdout1_36ck1680 FIND v(dout1_36) AT=1690.05n

.meas tran vdout1_37ck1680 FIND v(dout1_37) AT=1690.05n

.meas tran vdout1_38ck1680 FIND v(dout1_38) AT=1690.05n

.meas tran vdout1_39ck1680 FIND v(dout1_39) AT=1690.05n

.meas tran vdout1_40ck1680 FIND v(dout1_40) AT=1690.05n

.meas tran vdout1_41ck1680 FIND v(dout1_41) AT=1690.05n

.meas tran vdout1_42ck1680 FIND v(dout1_42) AT=1690.05n

.meas tran vdout1_43ck1680 FIND v(dout1_43) AT=1690.05n

.meas tran vdout1_44ck1680 FIND v(dout1_44) AT=1690.05n

.meas tran vdout1_45ck1680 FIND v(dout1_45) AT=1690.05n

.meas tran vdout1_46ck1680 FIND v(dout1_46) AT=1690.05n

.meas tran vdout1_47ck1680 FIND v(dout1_47) AT=1690.05n

.meas tran vdout1_48ck1680 FIND v(dout1_48) AT=1690.05n

.meas tran vdout1_49ck1680 FIND v(dout1_49) AT=1690.05n

.meas tran vdout1_50ck1680 FIND v(dout1_50) AT=1690.05n

.meas tran vdout1_51ck1680 FIND v(dout1_51) AT=1690.05n

.meas tran vdout1_52ck1680 FIND v(dout1_52) AT=1690.05n

.meas tran vdout1_53ck1680 FIND v(dout1_53) AT=1690.05n

.meas tran vdout1_54ck1680 FIND v(dout1_54) AT=1690.05n

.meas tran vdout1_55ck1680 FIND v(dout1_55) AT=1690.05n

.meas tran vdout1_56ck1680 FIND v(dout1_56) AT=1690.05n

.meas tran vdout1_57ck1680 FIND v(dout1_57) AT=1690.05n

.meas tran vdout1_58ck1680 FIND v(dout1_58) AT=1690.05n

.meas tran vdout1_59ck1680 FIND v(dout1_59) AT=1690.05n

.meas tran vdout1_60ck1680 FIND v(dout1_60) AT=1690.05n

.meas tran vdout1_61ck1680 FIND v(dout1_61) AT=1690.05n

.meas tran vdout1_62ck1680 FIND v(dout1_62) AT=1690.05n

.meas tran vdout1_63ck1680 FIND v(dout1_63) AT=1690.05n

.meas tran vdout1_64ck1680 FIND v(dout1_64) AT=1690.05n

.meas tran vdout1_65ck1680 FIND v(dout1_65) AT=1690.05n

.meas tran vdout1_66ck1680 FIND v(dout1_66) AT=1690.05n

.meas tran vdout1_67ck1680 FIND v(dout1_67) AT=1690.05n

.meas tran vdout1_68ck1680 FIND v(dout1_68) AT=1690.05n

.meas tran vdout1_69ck1680 FIND v(dout1_69) AT=1690.05n

.meas tran vdout1_70ck1680 FIND v(dout1_70) AT=1690.05n

.meas tran vdout1_71ck1680 FIND v(dout1_71) AT=1690.05n

.meas tran vdout1_72ck1680 FIND v(dout1_72) AT=1690.05n

.meas tran vdout1_73ck1680 FIND v(dout1_73) AT=1690.05n

.meas tran vdout1_74ck1680 FIND v(dout1_74) AT=1690.05n

.meas tran vdout1_75ck1680 FIND v(dout1_75) AT=1690.05n

.meas tran vdout1_76ck1680 FIND v(dout1_76) AT=1690.05n

.meas tran vdout1_77ck1680 FIND v(dout1_77) AT=1690.05n

.meas tran vdout1_78ck1680 FIND v(dout1_78) AT=1690.05n

.meas tran vdout1_79ck1680 FIND v(dout1_79) AT=1690.05n

.meas tran vdout1_80ck1680 FIND v(dout1_80) AT=1690.05n

.meas tran vdout1_81ck1680 FIND v(dout1_81) AT=1690.05n

.meas tran vdout1_82ck1680 FIND v(dout1_82) AT=1690.05n

.meas tran vdout1_83ck1680 FIND v(dout1_83) AT=1690.05n

.meas tran vdout1_84ck1680 FIND v(dout1_84) AT=1690.05n

.meas tran vdout1_85ck1680 FIND v(dout1_85) AT=1690.05n

.meas tran vdout1_86ck1680 FIND v(dout1_86) AT=1690.05n

.meas tran vdout1_87ck1680 FIND v(dout1_87) AT=1690.05n

.meas tran vdout1_88ck1680 FIND v(dout1_88) AT=1690.05n

.meas tran vdout1_89ck1680 FIND v(dout1_89) AT=1690.05n

.meas tran vdout1_90ck1680 FIND v(dout1_90) AT=1690.05n

.meas tran vdout1_91ck1680 FIND v(dout1_91) AT=1690.05n

.meas tran vdout1_92ck1680 FIND v(dout1_92) AT=1690.05n

.meas tran vdout1_93ck1680 FIND v(dout1_93) AT=1690.05n

.meas tran vdout1_94ck1680 FIND v(dout1_94) AT=1690.05n

.meas tran vdout1_95ck1680 FIND v(dout1_95) AT=1690.05n

.meas tran vdout1_96ck1680 FIND v(dout1_96) AT=1690.05n

.meas tran vdout1_97ck1680 FIND v(dout1_97) AT=1690.05n

.meas tran vdout1_98ck1680 FIND v(dout1_98) AT=1690.05n

.meas tran vdout1_99ck1680 FIND v(dout1_99) AT=1690.05n

.meas tran vdout1_100ck1680 FIND v(dout1_100) AT=1690.05n

.meas tran vdout1_101ck1680 FIND v(dout1_101) AT=1690.05n

.meas tran vdout1_102ck1680 FIND v(dout1_102) AT=1690.05n

.meas tran vdout1_103ck1680 FIND v(dout1_103) AT=1690.05n

.meas tran vdout1_104ck1680 FIND v(dout1_104) AT=1690.05n

.meas tran vdout1_105ck1680 FIND v(dout1_105) AT=1690.05n

.meas tran vdout1_106ck1680 FIND v(dout1_106) AT=1690.05n

.meas tran vdout1_107ck1680 FIND v(dout1_107) AT=1690.05n

.meas tran vdout1_108ck1680 FIND v(dout1_108) AT=1690.05n

.meas tran vdout1_109ck1680 FIND v(dout1_109) AT=1690.05n

.meas tran vdout1_110ck1680 FIND v(dout1_110) AT=1690.05n

.meas tran vdout1_111ck1680 FIND v(dout1_111) AT=1690.05n

.meas tran vdout1_112ck1680 FIND v(dout1_112) AT=1690.05n

.meas tran vdout1_113ck1680 FIND v(dout1_113) AT=1690.05n

.meas tran vdout1_114ck1680 FIND v(dout1_114) AT=1690.05n

.meas tran vdout1_115ck1680 FIND v(dout1_115) AT=1690.05n

.meas tran vdout1_116ck1680 FIND v(dout1_116) AT=1690.05n

.meas tran vdout1_117ck1680 FIND v(dout1_117) AT=1690.05n

.meas tran vdout1_118ck1680 FIND v(dout1_118) AT=1690.05n

.meas tran vdout1_119ck1680 FIND v(dout1_119) AT=1690.05n

.meas tran vdout1_120ck1680 FIND v(dout1_120) AT=1690.05n

.meas tran vdout1_121ck1680 FIND v(dout1_121) AT=1690.05n

.meas tran vdout1_122ck1680 FIND v(dout1_122) AT=1690.05n

.meas tran vdout1_123ck1680 FIND v(dout1_123) AT=1690.05n

.meas tran vdout1_124ck1680 FIND v(dout1_124) AT=1690.05n

.meas tran vdout1_125ck1680 FIND v(dout1_125) AT=1690.05n

.meas tran vdout1_126ck1680 FIND v(dout1_126) AT=1690.05n

.meas tran vdout1_127ck1680 FIND v(dout1_127) AT=1690.05n

.meas tran vdout1_128ck1680 FIND v(dout1_128) AT=1690.05n

.meas tran vdout1_129ck1680 FIND v(dout1_129) AT=1690.05n

.meas tran vdout1_130ck1680 FIND v(dout1_130) AT=1690.05n

.meas tran vdout1_131ck1680 FIND v(dout1_131) AT=1690.05n

.meas tran vdout1_132ck1680 FIND v(dout1_132) AT=1690.05n

.meas tran vdout1_133ck1680 FIND v(dout1_133) AT=1690.05n

.meas tran vdout1_134ck1680 FIND v(dout1_134) AT=1690.05n

.meas tran vdout1_0ck1700 FIND v(dout1_0) AT=1710.05n

.meas tran vdout1_1ck1700 FIND v(dout1_1) AT=1710.05n

.meas tran vdout1_2ck1700 FIND v(dout1_2) AT=1710.05n

.meas tran vdout1_3ck1700 FIND v(dout1_3) AT=1710.05n

.meas tran vdout1_4ck1700 FIND v(dout1_4) AT=1710.05n

.meas tran vdout1_5ck1700 FIND v(dout1_5) AT=1710.05n

.meas tran vdout1_6ck1700 FIND v(dout1_6) AT=1710.05n

.meas tran vdout1_7ck1700 FIND v(dout1_7) AT=1710.05n

.meas tran vdout1_8ck1700 FIND v(dout1_8) AT=1710.05n

.meas tran vdout1_9ck1700 FIND v(dout1_9) AT=1710.05n

.meas tran vdout1_10ck1700 FIND v(dout1_10) AT=1710.05n

.meas tran vdout1_11ck1700 FIND v(dout1_11) AT=1710.05n

.meas tran vdout1_12ck1700 FIND v(dout1_12) AT=1710.05n

.meas tran vdout1_13ck1700 FIND v(dout1_13) AT=1710.05n

.meas tran vdout1_14ck1700 FIND v(dout1_14) AT=1710.05n

.meas tran vdout1_15ck1700 FIND v(dout1_15) AT=1710.05n

.meas tran vdout1_16ck1700 FIND v(dout1_16) AT=1710.05n

.meas tran vdout1_17ck1700 FIND v(dout1_17) AT=1710.05n

.meas tran vdout1_18ck1700 FIND v(dout1_18) AT=1710.05n

.meas tran vdout1_19ck1700 FIND v(dout1_19) AT=1710.05n

.meas tran vdout1_20ck1700 FIND v(dout1_20) AT=1710.05n

.meas tran vdout1_21ck1700 FIND v(dout1_21) AT=1710.05n

.meas tran vdout1_22ck1700 FIND v(dout1_22) AT=1710.05n

.meas tran vdout1_23ck1700 FIND v(dout1_23) AT=1710.05n

.meas tran vdout1_24ck1700 FIND v(dout1_24) AT=1710.05n

.meas tran vdout1_25ck1700 FIND v(dout1_25) AT=1710.05n

.meas tran vdout1_26ck1700 FIND v(dout1_26) AT=1710.05n

.meas tran vdout1_27ck1700 FIND v(dout1_27) AT=1710.05n

.meas tran vdout1_28ck1700 FIND v(dout1_28) AT=1710.05n

.meas tran vdout1_29ck1700 FIND v(dout1_29) AT=1710.05n

.meas tran vdout1_30ck1700 FIND v(dout1_30) AT=1710.05n

.meas tran vdout1_31ck1700 FIND v(dout1_31) AT=1710.05n

.meas tran vdout1_32ck1700 FIND v(dout1_32) AT=1710.05n

.meas tran vdout1_33ck1700 FIND v(dout1_33) AT=1710.05n

.meas tran vdout1_34ck1700 FIND v(dout1_34) AT=1710.05n

.meas tran vdout1_35ck1700 FIND v(dout1_35) AT=1710.05n

.meas tran vdout1_36ck1700 FIND v(dout1_36) AT=1710.05n

.meas tran vdout1_37ck1700 FIND v(dout1_37) AT=1710.05n

.meas tran vdout1_38ck1700 FIND v(dout1_38) AT=1710.05n

.meas tran vdout1_39ck1700 FIND v(dout1_39) AT=1710.05n

.meas tran vdout1_40ck1700 FIND v(dout1_40) AT=1710.05n

.meas tran vdout1_41ck1700 FIND v(dout1_41) AT=1710.05n

.meas tran vdout1_42ck1700 FIND v(dout1_42) AT=1710.05n

.meas tran vdout1_43ck1700 FIND v(dout1_43) AT=1710.05n

.meas tran vdout1_44ck1700 FIND v(dout1_44) AT=1710.05n

.meas tran vdout1_45ck1700 FIND v(dout1_45) AT=1710.05n

.meas tran vdout1_46ck1700 FIND v(dout1_46) AT=1710.05n

.meas tran vdout1_47ck1700 FIND v(dout1_47) AT=1710.05n

.meas tran vdout1_48ck1700 FIND v(dout1_48) AT=1710.05n

.meas tran vdout1_49ck1700 FIND v(dout1_49) AT=1710.05n

.meas tran vdout1_50ck1700 FIND v(dout1_50) AT=1710.05n

.meas tran vdout1_51ck1700 FIND v(dout1_51) AT=1710.05n

.meas tran vdout1_52ck1700 FIND v(dout1_52) AT=1710.05n

.meas tran vdout1_53ck1700 FIND v(dout1_53) AT=1710.05n

.meas tran vdout1_54ck1700 FIND v(dout1_54) AT=1710.05n

.meas tran vdout1_55ck1700 FIND v(dout1_55) AT=1710.05n

.meas tran vdout1_56ck1700 FIND v(dout1_56) AT=1710.05n

.meas tran vdout1_57ck1700 FIND v(dout1_57) AT=1710.05n

.meas tran vdout1_58ck1700 FIND v(dout1_58) AT=1710.05n

.meas tran vdout1_59ck1700 FIND v(dout1_59) AT=1710.05n

.meas tran vdout1_60ck1700 FIND v(dout1_60) AT=1710.05n

.meas tran vdout1_61ck1700 FIND v(dout1_61) AT=1710.05n

.meas tran vdout1_62ck1700 FIND v(dout1_62) AT=1710.05n

.meas tran vdout1_63ck1700 FIND v(dout1_63) AT=1710.05n

.meas tran vdout1_64ck1700 FIND v(dout1_64) AT=1710.05n

.meas tran vdout1_65ck1700 FIND v(dout1_65) AT=1710.05n

.meas tran vdout1_66ck1700 FIND v(dout1_66) AT=1710.05n

.meas tran vdout1_67ck1700 FIND v(dout1_67) AT=1710.05n

.meas tran vdout1_68ck1700 FIND v(dout1_68) AT=1710.05n

.meas tran vdout1_69ck1700 FIND v(dout1_69) AT=1710.05n

.meas tran vdout1_70ck1700 FIND v(dout1_70) AT=1710.05n

.meas tran vdout1_71ck1700 FIND v(dout1_71) AT=1710.05n

.meas tran vdout1_72ck1700 FIND v(dout1_72) AT=1710.05n

.meas tran vdout1_73ck1700 FIND v(dout1_73) AT=1710.05n

.meas tran vdout1_74ck1700 FIND v(dout1_74) AT=1710.05n

.meas tran vdout1_75ck1700 FIND v(dout1_75) AT=1710.05n

.meas tran vdout1_76ck1700 FIND v(dout1_76) AT=1710.05n

.meas tran vdout1_77ck1700 FIND v(dout1_77) AT=1710.05n

.meas tran vdout1_78ck1700 FIND v(dout1_78) AT=1710.05n

.meas tran vdout1_79ck1700 FIND v(dout1_79) AT=1710.05n

.meas tran vdout1_80ck1700 FIND v(dout1_80) AT=1710.05n

.meas tran vdout1_81ck1700 FIND v(dout1_81) AT=1710.05n

.meas tran vdout1_82ck1700 FIND v(dout1_82) AT=1710.05n

.meas tran vdout1_83ck1700 FIND v(dout1_83) AT=1710.05n

.meas tran vdout1_84ck1700 FIND v(dout1_84) AT=1710.05n

.meas tran vdout1_85ck1700 FIND v(dout1_85) AT=1710.05n

.meas tran vdout1_86ck1700 FIND v(dout1_86) AT=1710.05n

.meas tran vdout1_87ck1700 FIND v(dout1_87) AT=1710.05n

.meas tran vdout1_88ck1700 FIND v(dout1_88) AT=1710.05n

.meas tran vdout1_89ck1700 FIND v(dout1_89) AT=1710.05n

.meas tran vdout1_90ck1700 FIND v(dout1_90) AT=1710.05n

.meas tran vdout1_91ck1700 FIND v(dout1_91) AT=1710.05n

.meas tran vdout1_92ck1700 FIND v(dout1_92) AT=1710.05n

.meas tran vdout1_93ck1700 FIND v(dout1_93) AT=1710.05n

.meas tran vdout1_94ck1700 FIND v(dout1_94) AT=1710.05n

.meas tran vdout1_95ck1700 FIND v(dout1_95) AT=1710.05n

.meas tran vdout1_96ck1700 FIND v(dout1_96) AT=1710.05n

.meas tran vdout1_97ck1700 FIND v(dout1_97) AT=1710.05n

.meas tran vdout1_98ck1700 FIND v(dout1_98) AT=1710.05n

.meas tran vdout1_99ck1700 FIND v(dout1_99) AT=1710.05n

.meas tran vdout1_100ck1700 FIND v(dout1_100) AT=1710.05n

.meas tran vdout1_101ck1700 FIND v(dout1_101) AT=1710.05n

.meas tran vdout1_102ck1700 FIND v(dout1_102) AT=1710.05n

.meas tran vdout1_103ck1700 FIND v(dout1_103) AT=1710.05n

.meas tran vdout1_104ck1700 FIND v(dout1_104) AT=1710.05n

.meas tran vdout1_105ck1700 FIND v(dout1_105) AT=1710.05n

.meas tran vdout1_106ck1700 FIND v(dout1_106) AT=1710.05n

.meas tran vdout1_107ck1700 FIND v(dout1_107) AT=1710.05n

.meas tran vdout1_108ck1700 FIND v(dout1_108) AT=1710.05n

.meas tran vdout1_109ck1700 FIND v(dout1_109) AT=1710.05n

.meas tran vdout1_110ck1700 FIND v(dout1_110) AT=1710.05n

.meas tran vdout1_111ck1700 FIND v(dout1_111) AT=1710.05n

.meas tran vdout1_112ck1700 FIND v(dout1_112) AT=1710.05n

.meas tran vdout1_113ck1700 FIND v(dout1_113) AT=1710.05n

.meas tran vdout1_114ck1700 FIND v(dout1_114) AT=1710.05n

.meas tran vdout1_115ck1700 FIND v(dout1_115) AT=1710.05n

.meas tran vdout1_116ck1700 FIND v(dout1_116) AT=1710.05n

.meas tran vdout1_117ck1700 FIND v(dout1_117) AT=1710.05n

.meas tran vdout1_118ck1700 FIND v(dout1_118) AT=1710.05n

.meas tran vdout1_119ck1700 FIND v(dout1_119) AT=1710.05n

.meas tran vdout1_120ck1700 FIND v(dout1_120) AT=1710.05n

.meas tran vdout1_121ck1700 FIND v(dout1_121) AT=1710.05n

.meas tran vdout1_122ck1700 FIND v(dout1_122) AT=1710.05n

.meas tran vdout1_123ck1700 FIND v(dout1_123) AT=1710.05n

.meas tran vdout1_124ck1700 FIND v(dout1_124) AT=1710.05n

.meas tran vdout1_125ck1700 FIND v(dout1_125) AT=1710.05n

.meas tran vdout1_126ck1700 FIND v(dout1_126) AT=1710.05n

.meas tran vdout1_127ck1700 FIND v(dout1_127) AT=1710.05n

.meas tran vdout1_128ck1700 FIND v(dout1_128) AT=1710.05n

.meas tran vdout1_129ck1700 FIND v(dout1_129) AT=1710.05n

.meas tran vdout1_130ck1700 FIND v(dout1_130) AT=1710.05n

.meas tran vdout1_131ck1700 FIND v(dout1_131) AT=1710.05n

.meas tran vdout1_132ck1700 FIND v(dout1_132) AT=1710.05n

.meas tran vdout1_133ck1700 FIND v(dout1_133) AT=1710.05n

.meas tran vdout1_134ck1700 FIND v(dout1_134) AT=1710.05n

.meas tran vdout1_0ck1720 FIND v(dout1_0) AT=1730.05n

.meas tran vdout1_1ck1720 FIND v(dout1_1) AT=1730.05n

.meas tran vdout1_2ck1720 FIND v(dout1_2) AT=1730.05n

.meas tran vdout1_3ck1720 FIND v(dout1_3) AT=1730.05n

.meas tran vdout1_4ck1720 FIND v(dout1_4) AT=1730.05n

.meas tran vdout1_5ck1720 FIND v(dout1_5) AT=1730.05n

.meas tran vdout1_6ck1720 FIND v(dout1_6) AT=1730.05n

.meas tran vdout1_7ck1720 FIND v(dout1_7) AT=1730.05n

.meas tran vdout1_8ck1720 FIND v(dout1_8) AT=1730.05n

.meas tran vdout1_9ck1720 FIND v(dout1_9) AT=1730.05n

.meas tran vdout1_10ck1720 FIND v(dout1_10) AT=1730.05n

.meas tran vdout1_11ck1720 FIND v(dout1_11) AT=1730.05n

.meas tran vdout1_12ck1720 FIND v(dout1_12) AT=1730.05n

.meas tran vdout1_13ck1720 FIND v(dout1_13) AT=1730.05n

.meas tran vdout1_14ck1720 FIND v(dout1_14) AT=1730.05n

.meas tran vdout1_15ck1720 FIND v(dout1_15) AT=1730.05n

.meas tran vdout1_16ck1720 FIND v(dout1_16) AT=1730.05n

.meas tran vdout1_17ck1720 FIND v(dout1_17) AT=1730.05n

.meas tran vdout1_18ck1720 FIND v(dout1_18) AT=1730.05n

.meas tran vdout1_19ck1720 FIND v(dout1_19) AT=1730.05n

.meas tran vdout1_20ck1720 FIND v(dout1_20) AT=1730.05n

.meas tran vdout1_21ck1720 FIND v(dout1_21) AT=1730.05n

.meas tran vdout1_22ck1720 FIND v(dout1_22) AT=1730.05n

.meas tran vdout1_23ck1720 FIND v(dout1_23) AT=1730.05n

.meas tran vdout1_24ck1720 FIND v(dout1_24) AT=1730.05n

.meas tran vdout1_25ck1720 FIND v(dout1_25) AT=1730.05n

.meas tran vdout1_26ck1720 FIND v(dout1_26) AT=1730.05n

.meas tran vdout1_27ck1720 FIND v(dout1_27) AT=1730.05n

.meas tran vdout1_28ck1720 FIND v(dout1_28) AT=1730.05n

.meas tran vdout1_29ck1720 FIND v(dout1_29) AT=1730.05n

.meas tran vdout1_30ck1720 FIND v(dout1_30) AT=1730.05n

.meas tran vdout1_31ck1720 FIND v(dout1_31) AT=1730.05n

.meas tran vdout1_32ck1720 FIND v(dout1_32) AT=1730.05n

.meas tran vdout1_33ck1720 FIND v(dout1_33) AT=1730.05n

.meas tran vdout1_34ck1720 FIND v(dout1_34) AT=1730.05n

.meas tran vdout1_35ck1720 FIND v(dout1_35) AT=1730.05n

.meas tran vdout1_36ck1720 FIND v(dout1_36) AT=1730.05n

.meas tran vdout1_37ck1720 FIND v(dout1_37) AT=1730.05n

.meas tran vdout1_38ck1720 FIND v(dout1_38) AT=1730.05n

.meas tran vdout1_39ck1720 FIND v(dout1_39) AT=1730.05n

.meas tran vdout1_40ck1720 FIND v(dout1_40) AT=1730.05n

.meas tran vdout1_41ck1720 FIND v(dout1_41) AT=1730.05n

.meas tran vdout1_42ck1720 FIND v(dout1_42) AT=1730.05n

.meas tran vdout1_43ck1720 FIND v(dout1_43) AT=1730.05n

.meas tran vdout1_44ck1720 FIND v(dout1_44) AT=1730.05n

.meas tran vdout1_45ck1720 FIND v(dout1_45) AT=1730.05n

.meas tran vdout1_46ck1720 FIND v(dout1_46) AT=1730.05n

.meas tran vdout1_47ck1720 FIND v(dout1_47) AT=1730.05n

.meas tran vdout1_48ck1720 FIND v(dout1_48) AT=1730.05n

.meas tran vdout1_49ck1720 FIND v(dout1_49) AT=1730.05n

.meas tran vdout1_50ck1720 FIND v(dout1_50) AT=1730.05n

.meas tran vdout1_51ck1720 FIND v(dout1_51) AT=1730.05n

.meas tran vdout1_52ck1720 FIND v(dout1_52) AT=1730.05n

.meas tran vdout1_53ck1720 FIND v(dout1_53) AT=1730.05n

.meas tran vdout1_54ck1720 FIND v(dout1_54) AT=1730.05n

.meas tran vdout1_55ck1720 FIND v(dout1_55) AT=1730.05n

.meas tran vdout1_56ck1720 FIND v(dout1_56) AT=1730.05n

.meas tran vdout1_57ck1720 FIND v(dout1_57) AT=1730.05n

.meas tran vdout1_58ck1720 FIND v(dout1_58) AT=1730.05n

.meas tran vdout1_59ck1720 FIND v(dout1_59) AT=1730.05n

.meas tran vdout1_60ck1720 FIND v(dout1_60) AT=1730.05n

.meas tran vdout1_61ck1720 FIND v(dout1_61) AT=1730.05n

.meas tran vdout1_62ck1720 FIND v(dout1_62) AT=1730.05n

.meas tran vdout1_63ck1720 FIND v(dout1_63) AT=1730.05n

.meas tran vdout1_64ck1720 FIND v(dout1_64) AT=1730.05n

.meas tran vdout1_65ck1720 FIND v(dout1_65) AT=1730.05n

.meas tran vdout1_66ck1720 FIND v(dout1_66) AT=1730.05n

.meas tran vdout1_67ck1720 FIND v(dout1_67) AT=1730.05n

.meas tran vdout1_68ck1720 FIND v(dout1_68) AT=1730.05n

.meas tran vdout1_69ck1720 FIND v(dout1_69) AT=1730.05n

.meas tran vdout1_70ck1720 FIND v(dout1_70) AT=1730.05n

.meas tran vdout1_71ck1720 FIND v(dout1_71) AT=1730.05n

.meas tran vdout1_72ck1720 FIND v(dout1_72) AT=1730.05n

.meas tran vdout1_73ck1720 FIND v(dout1_73) AT=1730.05n

.meas tran vdout1_74ck1720 FIND v(dout1_74) AT=1730.05n

.meas tran vdout1_75ck1720 FIND v(dout1_75) AT=1730.05n

.meas tran vdout1_76ck1720 FIND v(dout1_76) AT=1730.05n

.meas tran vdout1_77ck1720 FIND v(dout1_77) AT=1730.05n

.meas tran vdout1_78ck1720 FIND v(dout1_78) AT=1730.05n

.meas tran vdout1_79ck1720 FIND v(dout1_79) AT=1730.05n

.meas tran vdout1_80ck1720 FIND v(dout1_80) AT=1730.05n

.meas tran vdout1_81ck1720 FIND v(dout1_81) AT=1730.05n

.meas tran vdout1_82ck1720 FIND v(dout1_82) AT=1730.05n

.meas tran vdout1_83ck1720 FIND v(dout1_83) AT=1730.05n

.meas tran vdout1_84ck1720 FIND v(dout1_84) AT=1730.05n

.meas tran vdout1_85ck1720 FIND v(dout1_85) AT=1730.05n

.meas tran vdout1_86ck1720 FIND v(dout1_86) AT=1730.05n

.meas tran vdout1_87ck1720 FIND v(dout1_87) AT=1730.05n

.meas tran vdout1_88ck1720 FIND v(dout1_88) AT=1730.05n

.meas tran vdout1_89ck1720 FIND v(dout1_89) AT=1730.05n

.meas tran vdout1_90ck1720 FIND v(dout1_90) AT=1730.05n

.meas tran vdout1_91ck1720 FIND v(dout1_91) AT=1730.05n

.meas tran vdout1_92ck1720 FIND v(dout1_92) AT=1730.05n

.meas tran vdout1_93ck1720 FIND v(dout1_93) AT=1730.05n

.meas tran vdout1_94ck1720 FIND v(dout1_94) AT=1730.05n

.meas tran vdout1_95ck1720 FIND v(dout1_95) AT=1730.05n

.meas tran vdout1_96ck1720 FIND v(dout1_96) AT=1730.05n

.meas tran vdout1_97ck1720 FIND v(dout1_97) AT=1730.05n

.meas tran vdout1_98ck1720 FIND v(dout1_98) AT=1730.05n

.meas tran vdout1_99ck1720 FIND v(dout1_99) AT=1730.05n

.meas tran vdout1_100ck1720 FIND v(dout1_100) AT=1730.05n

.meas tran vdout1_101ck1720 FIND v(dout1_101) AT=1730.05n

.meas tran vdout1_102ck1720 FIND v(dout1_102) AT=1730.05n

.meas tran vdout1_103ck1720 FIND v(dout1_103) AT=1730.05n

.meas tran vdout1_104ck1720 FIND v(dout1_104) AT=1730.05n

.meas tran vdout1_105ck1720 FIND v(dout1_105) AT=1730.05n

.meas tran vdout1_106ck1720 FIND v(dout1_106) AT=1730.05n

.meas tran vdout1_107ck1720 FIND v(dout1_107) AT=1730.05n

.meas tran vdout1_108ck1720 FIND v(dout1_108) AT=1730.05n

.meas tran vdout1_109ck1720 FIND v(dout1_109) AT=1730.05n

.meas tran vdout1_110ck1720 FIND v(dout1_110) AT=1730.05n

.meas tran vdout1_111ck1720 FIND v(dout1_111) AT=1730.05n

.meas tran vdout1_112ck1720 FIND v(dout1_112) AT=1730.05n

.meas tran vdout1_113ck1720 FIND v(dout1_113) AT=1730.05n

.meas tran vdout1_114ck1720 FIND v(dout1_114) AT=1730.05n

.meas tran vdout1_115ck1720 FIND v(dout1_115) AT=1730.05n

.meas tran vdout1_116ck1720 FIND v(dout1_116) AT=1730.05n

.meas tran vdout1_117ck1720 FIND v(dout1_117) AT=1730.05n

.meas tran vdout1_118ck1720 FIND v(dout1_118) AT=1730.05n

.meas tran vdout1_119ck1720 FIND v(dout1_119) AT=1730.05n

.meas tran vdout1_120ck1720 FIND v(dout1_120) AT=1730.05n

.meas tran vdout1_121ck1720 FIND v(dout1_121) AT=1730.05n

.meas tran vdout1_122ck1720 FIND v(dout1_122) AT=1730.05n

.meas tran vdout1_123ck1720 FIND v(dout1_123) AT=1730.05n

.meas tran vdout1_124ck1720 FIND v(dout1_124) AT=1730.05n

.meas tran vdout1_125ck1720 FIND v(dout1_125) AT=1730.05n

.meas tran vdout1_126ck1720 FIND v(dout1_126) AT=1730.05n

.meas tran vdout1_127ck1720 FIND v(dout1_127) AT=1730.05n

.meas tran vdout1_128ck1720 FIND v(dout1_128) AT=1730.05n

.meas tran vdout1_129ck1720 FIND v(dout1_129) AT=1730.05n

.meas tran vdout1_130ck1720 FIND v(dout1_130) AT=1730.05n

.meas tran vdout1_131ck1720 FIND v(dout1_131) AT=1730.05n

.meas tran vdout1_132ck1720 FIND v(dout1_132) AT=1730.05n

.meas tran vdout1_133ck1720 FIND v(dout1_133) AT=1730.05n

.meas tran vdout1_134ck1720 FIND v(dout1_134) AT=1730.05n

.meas tran vdout1_0ck1740 FIND v(dout1_0) AT=1750.05n

.meas tran vdout1_1ck1740 FIND v(dout1_1) AT=1750.05n

.meas tran vdout1_2ck1740 FIND v(dout1_2) AT=1750.05n

.meas tran vdout1_3ck1740 FIND v(dout1_3) AT=1750.05n

.meas tran vdout1_4ck1740 FIND v(dout1_4) AT=1750.05n

.meas tran vdout1_5ck1740 FIND v(dout1_5) AT=1750.05n

.meas tran vdout1_6ck1740 FIND v(dout1_6) AT=1750.05n

.meas tran vdout1_7ck1740 FIND v(dout1_7) AT=1750.05n

.meas tran vdout1_8ck1740 FIND v(dout1_8) AT=1750.05n

.meas tran vdout1_9ck1740 FIND v(dout1_9) AT=1750.05n

.meas tran vdout1_10ck1740 FIND v(dout1_10) AT=1750.05n

.meas tran vdout1_11ck1740 FIND v(dout1_11) AT=1750.05n

.meas tran vdout1_12ck1740 FIND v(dout1_12) AT=1750.05n

.meas tran vdout1_13ck1740 FIND v(dout1_13) AT=1750.05n

.meas tran vdout1_14ck1740 FIND v(dout1_14) AT=1750.05n

.meas tran vdout1_15ck1740 FIND v(dout1_15) AT=1750.05n

.meas tran vdout1_16ck1740 FIND v(dout1_16) AT=1750.05n

.meas tran vdout1_17ck1740 FIND v(dout1_17) AT=1750.05n

.meas tran vdout1_18ck1740 FIND v(dout1_18) AT=1750.05n

.meas tran vdout1_19ck1740 FIND v(dout1_19) AT=1750.05n

.meas tran vdout1_20ck1740 FIND v(dout1_20) AT=1750.05n

.meas tran vdout1_21ck1740 FIND v(dout1_21) AT=1750.05n

.meas tran vdout1_22ck1740 FIND v(dout1_22) AT=1750.05n

.meas tran vdout1_23ck1740 FIND v(dout1_23) AT=1750.05n

.meas tran vdout1_24ck1740 FIND v(dout1_24) AT=1750.05n

.meas tran vdout1_25ck1740 FIND v(dout1_25) AT=1750.05n

.meas tran vdout1_26ck1740 FIND v(dout1_26) AT=1750.05n

.meas tran vdout1_27ck1740 FIND v(dout1_27) AT=1750.05n

.meas tran vdout1_28ck1740 FIND v(dout1_28) AT=1750.05n

.meas tran vdout1_29ck1740 FIND v(dout1_29) AT=1750.05n

.meas tran vdout1_30ck1740 FIND v(dout1_30) AT=1750.05n

.meas tran vdout1_31ck1740 FIND v(dout1_31) AT=1750.05n

.meas tran vdout1_32ck1740 FIND v(dout1_32) AT=1750.05n

.meas tran vdout1_33ck1740 FIND v(dout1_33) AT=1750.05n

.meas tran vdout1_34ck1740 FIND v(dout1_34) AT=1750.05n

.meas tran vdout1_35ck1740 FIND v(dout1_35) AT=1750.05n

.meas tran vdout1_36ck1740 FIND v(dout1_36) AT=1750.05n

.meas tran vdout1_37ck1740 FIND v(dout1_37) AT=1750.05n

.meas tran vdout1_38ck1740 FIND v(dout1_38) AT=1750.05n

.meas tran vdout1_39ck1740 FIND v(dout1_39) AT=1750.05n

.meas tran vdout1_40ck1740 FIND v(dout1_40) AT=1750.05n

.meas tran vdout1_41ck1740 FIND v(dout1_41) AT=1750.05n

.meas tran vdout1_42ck1740 FIND v(dout1_42) AT=1750.05n

.meas tran vdout1_43ck1740 FIND v(dout1_43) AT=1750.05n

.meas tran vdout1_44ck1740 FIND v(dout1_44) AT=1750.05n

.meas tran vdout1_45ck1740 FIND v(dout1_45) AT=1750.05n

.meas tran vdout1_46ck1740 FIND v(dout1_46) AT=1750.05n

.meas tran vdout1_47ck1740 FIND v(dout1_47) AT=1750.05n

.meas tran vdout1_48ck1740 FIND v(dout1_48) AT=1750.05n

.meas tran vdout1_49ck1740 FIND v(dout1_49) AT=1750.05n

.meas tran vdout1_50ck1740 FIND v(dout1_50) AT=1750.05n

.meas tran vdout1_51ck1740 FIND v(dout1_51) AT=1750.05n

.meas tran vdout1_52ck1740 FIND v(dout1_52) AT=1750.05n

.meas tran vdout1_53ck1740 FIND v(dout1_53) AT=1750.05n

.meas tran vdout1_54ck1740 FIND v(dout1_54) AT=1750.05n

.meas tran vdout1_55ck1740 FIND v(dout1_55) AT=1750.05n

.meas tran vdout1_56ck1740 FIND v(dout1_56) AT=1750.05n

.meas tran vdout1_57ck1740 FIND v(dout1_57) AT=1750.05n

.meas tran vdout1_58ck1740 FIND v(dout1_58) AT=1750.05n

.meas tran vdout1_59ck1740 FIND v(dout1_59) AT=1750.05n

.meas tran vdout1_60ck1740 FIND v(dout1_60) AT=1750.05n

.meas tran vdout1_61ck1740 FIND v(dout1_61) AT=1750.05n

.meas tran vdout1_62ck1740 FIND v(dout1_62) AT=1750.05n

.meas tran vdout1_63ck1740 FIND v(dout1_63) AT=1750.05n

.meas tran vdout1_64ck1740 FIND v(dout1_64) AT=1750.05n

.meas tran vdout1_65ck1740 FIND v(dout1_65) AT=1750.05n

.meas tran vdout1_66ck1740 FIND v(dout1_66) AT=1750.05n

.meas tran vdout1_67ck1740 FIND v(dout1_67) AT=1750.05n

.meas tran vdout1_68ck1740 FIND v(dout1_68) AT=1750.05n

.meas tran vdout1_69ck1740 FIND v(dout1_69) AT=1750.05n

.meas tran vdout1_70ck1740 FIND v(dout1_70) AT=1750.05n

.meas tran vdout1_71ck1740 FIND v(dout1_71) AT=1750.05n

.meas tran vdout1_72ck1740 FIND v(dout1_72) AT=1750.05n

.meas tran vdout1_73ck1740 FIND v(dout1_73) AT=1750.05n

.meas tran vdout1_74ck1740 FIND v(dout1_74) AT=1750.05n

.meas tran vdout1_75ck1740 FIND v(dout1_75) AT=1750.05n

.meas tran vdout1_76ck1740 FIND v(dout1_76) AT=1750.05n

.meas tran vdout1_77ck1740 FIND v(dout1_77) AT=1750.05n

.meas tran vdout1_78ck1740 FIND v(dout1_78) AT=1750.05n

.meas tran vdout1_79ck1740 FIND v(dout1_79) AT=1750.05n

.meas tran vdout1_80ck1740 FIND v(dout1_80) AT=1750.05n

.meas tran vdout1_81ck1740 FIND v(dout1_81) AT=1750.05n

.meas tran vdout1_82ck1740 FIND v(dout1_82) AT=1750.05n

.meas tran vdout1_83ck1740 FIND v(dout1_83) AT=1750.05n

.meas tran vdout1_84ck1740 FIND v(dout1_84) AT=1750.05n

.meas tran vdout1_85ck1740 FIND v(dout1_85) AT=1750.05n

.meas tran vdout1_86ck1740 FIND v(dout1_86) AT=1750.05n

.meas tran vdout1_87ck1740 FIND v(dout1_87) AT=1750.05n

.meas tran vdout1_88ck1740 FIND v(dout1_88) AT=1750.05n

.meas tran vdout1_89ck1740 FIND v(dout1_89) AT=1750.05n

.meas tran vdout1_90ck1740 FIND v(dout1_90) AT=1750.05n

.meas tran vdout1_91ck1740 FIND v(dout1_91) AT=1750.05n

.meas tran vdout1_92ck1740 FIND v(dout1_92) AT=1750.05n

.meas tran vdout1_93ck1740 FIND v(dout1_93) AT=1750.05n

.meas tran vdout1_94ck1740 FIND v(dout1_94) AT=1750.05n

.meas tran vdout1_95ck1740 FIND v(dout1_95) AT=1750.05n

.meas tran vdout1_96ck1740 FIND v(dout1_96) AT=1750.05n

.meas tran vdout1_97ck1740 FIND v(dout1_97) AT=1750.05n

.meas tran vdout1_98ck1740 FIND v(dout1_98) AT=1750.05n

.meas tran vdout1_99ck1740 FIND v(dout1_99) AT=1750.05n

.meas tran vdout1_100ck1740 FIND v(dout1_100) AT=1750.05n

.meas tran vdout1_101ck1740 FIND v(dout1_101) AT=1750.05n

.meas tran vdout1_102ck1740 FIND v(dout1_102) AT=1750.05n

.meas tran vdout1_103ck1740 FIND v(dout1_103) AT=1750.05n

.meas tran vdout1_104ck1740 FIND v(dout1_104) AT=1750.05n

.meas tran vdout1_105ck1740 FIND v(dout1_105) AT=1750.05n

.meas tran vdout1_106ck1740 FIND v(dout1_106) AT=1750.05n

.meas tran vdout1_107ck1740 FIND v(dout1_107) AT=1750.05n

.meas tran vdout1_108ck1740 FIND v(dout1_108) AT=1750.05n

.meas tran vdout1_109ck1740 FIND v(dout1_109) AT=1750.05n

.meas tran vdout1_110ck1740 FIND v(dout1_110) AT=1750.05n

.meas tran vdout1_111ck1740 FIND v(dout1_111) AT=1750.05n

.meas tran vdout1_112ck1740 FIND v(dout1_112) AT=1750.05n

.meas tran vdout1_113ck1740 FIND v(dout1_113) AT=1750.05n

.meas tran vdout1_114ck1740 FIND v(dout1_114) AT=1750.05n

.meas tran vdout1_115ck1740 FIND v(dout1_115) AT=1750.05n

.meas tran vdout1_116ck1740 FIND v(dout1_116) AT=1750.05n

.meas tran vdout1_117ck1740 FIND v(dout1_117) AT=1750.05n

.meas tran vdout1_118ck1740 FIND v(dout1_118) AT=1750.05n

.meas tran vdout1_119ck1740 FIND v(dout1_119) AT=1750.05n

.meas tran vdout1_120ck1740 FIND v(dout1_120) AT=1750.05n

.meas tran vdout1_121ck1740 FIND v(dout1_121) AT=1750.05n

.meas tran vdout1_122ck1740 FIND v(dout1_122) AT=1750.05n

.meas tran vdout1_123ck1740 FIND v(dout1_123) AT=1750.05n

.meas tran vdout1_124ck1740 FIND v(dout1_124) AT=1750.05n

.meas tran vdout1_125ck1740 FIND v(dout1_125) AT=1750.05n

.meas tran vdout1_126ck1740 FIND v(dout1_126) AT=1750.05n

.meas tran vdout1_127ck1740 FIND v(dout1_127) AT=1750.05n

.meas tran vdout1_128ck1740 FIND v(dout1_128) AT=1750.05n

.meas tran vdout1_129ck1740 FIND v(dout1_129) AT=1750.05n

.meas tran vdout1_130ck1740 FIND v(dout1_130) AT=1750.05n

.meas tran vdout1_131ck1740 FIND v(dout1_131) AT=1750.05n

.meas tran vdout1_132ck1740 FIND v(dout1_132) AT=1750.05n

.meas tran vdout1_133ck1740 FIND v(dout1_133) AT=1750.05n

.meas tran vdout1_134ck1740 FIND v(dout1_134) AT=1750.05n

.meas tran vdout1_0ck1750 FIND v(dout1_0) AT=1760.05n

.meas tran vdout1_1ck1750 FIND v(dout1_1) AT=1760.05n

.meas tran vdout1_2ck1750 FIND v(dout1_2) AT=1760.05n

.meas tran vdout1_3ck1750 FIND v(dout1_3) AT=1760.05n

.meas tran vdout1_4ck1750 FIND v(dout1_4) AT=1760.05n

.meas tran vdout1_5ck1750 FIND v(dout1_5) AT=1760.05n

.meas tran vdout1_6ck1750 FIND v(dout1_6) AT=1760.05n

.meas tran vdout1_7ck1750 FIND v(dout1_7) AT=1760.05n

.meas tran vdout1_8ck1750 FIND v(dout1_8) AT=1760.05n

.meas tran vdout1_9ck1750 FIND v(dout1_9) AT=1760.05n

.meas tran vdout1_10ck1750 FIND v(dout1_10) AT=1760.05n

.meas tran vdout1_11ck1750 FIND v(dout1_11) AT=1760.05n

.meas tran vdout1_12ck1750 FIND v(dout1_12) AT=1760.05n

.meas tran vdout1_13ck1750 FIND v(dout1_13) AT=1760.05n

.meas tran vdout1_14ck1750 FIND v(dout1_14) AT=1760.05n

.meas tran vdout1_15ck1750 FIND v(dout1_15) AT=1760.05n

.meas tran vdout1_16ck1750 FIND v(dout1_16) AT=1760.05n

.meas tran vdout1_17ck1750 FIND v(dout1_17) AT=1760.05n

.meas tran vdout1_18ck1750 FIND v(dout1_18) AT=1760.05n

.meas tran vdout1_19ck1750 FIND v(dout1_19) AT=1760.05n

.meas tran vdout1_20ck1750 FIND v(dout1_20) AT=1760.05n

.meas tran vdout1_21ck1750 FIND v(dout1_21) AT=1760.05n

.meas tran vdout1_22ck1750 FIND v(dout1_22) AT=1760.05n

.meas tran vdout1_23ck1750 FIND v(dout1_23) AT=1760.05n

.meas tran vdout1_24ck1750 FIND v(dout1_24) AT=1760.05n

.meas tran vdout1_25ck1750 FIND v(dout1_25) AT=1760.05n

.meas tran vdout1_26ck1750 FIND v(dout1_26) AT=1760.05n

.meas tran vdout1_27ck1750 FIND v(dout1_27) AT=1760.05n

.meas tran vdout1_28ck1750 FIND v(dout1_28) AT=1760.05n

.meas tran vdout1_29ck1750 FIND v(dout1_29) AT=1760.05n

.meas tran vdout1_30ck1750 FIND v(dout1_30) AT=1760.05n

.meas tran vdout1_31ck1750 FIND v(dout1_31) AT=1760.05n

.meas tran vdout1_32ck1750 FIND v(dout1_32) AT=1760.05n

.meas tran vdout1_33ck1750 FIND v(dout1_33) AT=1760.05n

.meas tran vdout1_34ck1750 FIND v(dout1_34) AT=1760.05n

.meas tran vdout1_35ck1750 FIND v(dout1_35) AT=1760.05n

.meas tran vdout1_36ck1750 FIND v(dout1_36) AT=1760.05n

.meas tran vdout1_37ck1750 FIND v(dout1_37) AT=1760.05n

.meas tran vdout1_38ck1750 FIND v(dout1_38) AT=1760.05n

.meas tran vdout1_39ck1750 FIND v(dout1_39) AT=1760.05n

.meas tran vdout1_40ck1750 FIND v(dout1_40) AT=1760.05n

.meas tran vdout1_41ck1750 FIND v(dout1_41) AT=1760.05n

.meas tran vdout1_42ck1750 FIND v(dout1_42) AT=1760.05n

.meas tran vdout1_43ck1750 FIND v(dout1_43) AT=1760.05n

.meas tran vdout1_44ck1750 FIND v(dout1_44) AT=1760.05n

.meas tran vdout1_45ck1750 FIND v(dout1_45) AT=1760.05n

.meas tran vdout1_46ck1750 FIND v(dout1_46) AT=1760.05n

.meas tran vdout1_47ck1750 FIND v(dout1_47) AT=1760.05n

.meas tran vdout1_48ck1750 FIND v(dout1_48) AT=1760.05n

.meas tran vdout1_49ck1750 FIND v(dout1_49) AT=1760.05n

.meas tran vdout1_50ck1750 FIND v(dout1_50) AT=1760.05n

.meas tran vdout1_51ck1750 FIND v(dout1_51) AT=1760.05n

.meas tran vdout1_52ck1750 FIND v(dout1_52) AT=1760.05n

.meas tran vdout1_53ck1750 FIND v(dout1_53) AT=1760.05n

.meas tran vdout1_54ck1750 FIND v(dout1_54) AT=1760.05n

.meas tran vdout1_55ck1750 FIND v(dout1_55) AT=1760.05n

.meas tran vdout1_56ck1750 FIND v(dout1_56) AT=1760.05n

.meas tran vdout1_57ck1750 FIND v(dout1_57) AT=1760.05n

.meas tran vdout1_58ck1750 FIND v(dout1_58) AT=1760.05n

.meas tran vdout1_59ck1750 FIND v(dout1_59) AT=1760.05n

.meas tran vdout1_60ck1750 FIND v(dout1_60) AT=1760.05n

.meas tran vdout1_61ck1750 FIND v(dout1_61) AT=1760.05n

.meas tran vdout1_62ck1750 FIND v(dout1_62) AT=1760.05n

.meas tran vdout1_63ck1750 FIND v(dout1_63) AT=1760.05n

.meas tran vdout1_64ck1750 FIND v(dout1_64) AT=1760.05n

.meas tran vdout1_65ck1750 FIND v(dout1_65) AT=1760.05n

.meas tran vdout1_66ck1750 FIND v(dout1_66) AT=1760.05n

.meas tran vdout1_67ck1750 FIND v(dout1_67) AT=1760.05n

.meas tran vdout1_68ck1750 FIND v(dout1_68) AT=1760.05n

.meas tran vdout1_69ck1750 FIND v(dout1_69) AT=1760.05n

.meas tran vdout1_70ck1750 FIND v(dout1_70) AT=1760.05n

.meas tran vdout1_71ck1750 FIND v(dout1_71) AT=1760.05n

.meas tran vdout1_72ck1750 FIND v(dout1_72) AT=1760.05n

.meas tran vdout1_73ck1750 FIND v(dout1_73) AT=1760.05n

.meas tran vdout1_74ck1750 FIND v(dout1_74) AT=1760.05n

.meas tran vdout1_75ck1750 FIND v(dout1_75) AT=1760.05n

.meas tran vdout1_76ck1750 FIND v(dout1_76) AT=1760.05n

.meas tran vdout1_77ck1750 FIND v(dout1_77) AT=1760.05n

.meas tran vdout1_78ck1750 FIND v(dout1_78) AT=1760.05n

.meas tran vdout1_79ck1750 FIND v(dout1_79) AT=1760.05n

.meas tran vdout1_80ck1750 FIND v(dout1_80) AT=1760.05n

.meas tran vdout1_81ck1750 FIND v(dout1_81) AT=1760.05n

.meas tran vdout1_82ck1750 FIND v(dout1_82) AT=1760.05n

.meas tran vdout1_83ck1750 FIND v(dout1_83) AT=1760.05n

.meas tran vdout1_84ck1750 FIND v(dout1_84) AT=1760.05n

.meas tran vdout1_85ck1750 FIND v(dout1_85) AT=1760.05n

.meas tran vdout1_86ck1750 FIND v(dout1_86) AT=1760.05n

.meas tran vdout1_87ck1750 FIND v(dout1_87) AT=1760.05n

.meas tran vdout1_88ck1750 FIND v(dout1_88) AT=1760.05n

.meas tran vdout1_89ck1750 FIND v(dout1_89) AT=1760.05n

.meas tran vdout1_90ck1750 FIND v(dout1_90) AT=1760.05n

.meas tran vdout1_91ck1750 FIND v(dout1_91) AT=1760.05n

.meas tran vdout1_92ck1750 FIND v(dout1_92) AT=1760.05n

.meas tran vdout1_93ck1750 FIND v(dout1_93) AT=1760.05n

.meas tran vdout1_94ck1750 FIND v(dout1_94) AT=1760.05n

.meas tran vdout1_95ck1750 FIND v(dout1_95) AT=1760.05n

.meas tran vdout1_96ck1750 FIND v(dout1_96) AT=1760.05n

.meas tran vdout1_97ck1750 FIND v(dout1_97) AT=1760.05n

.meas tran vdout1_98ck1750 FIND v(dout1_98) AT=1760.05n

.meas tran vdout1_99ck1750 FIND v(dout1_99) AT=1760.05n

.meas tran vdout1_100ck1750 FIND v(dout1_100) AT=1760.05n

.meas tran vdout1_101ck1750 FIND v(dout1_101) AT=1760.05n

.meas tran vdout1_102ck1750 FIND v(dout1_102) AT=1760.05n

.meas tran vdout1_103ck1750 FIND v(dout1_103) AT=1760.05n

.meas tran vdout1_104ck1750 FIND v(dout1_104) AT=1760.05n

.meas tran vdout1_105ck1750 FIND v(dout1_105) AT=1760.05n

.meas tran vdout1_106ck1750 FIND v(dout1_106) AT=1760.05n

.meas tran vdout1_107ck1750 FIND v(dout1_107) AT=1760.05n

.meas tran vdout1_108ck1750 FIND v(dout1_108) AT=1760.05n

.meas tran vdout1_109ck1750 FIND v(dout1_109) AT=1760.05n

.meas tran vdout1_110ck1750 FIND v(dout1_110) AT=1760.05n

.meas tran vdout1_111ck1750 FIND v(dout1_111) AT=1760.05n

.meas tran vdout1_112ck1750 FIND v(dout1_112) AT=1760.05n

.meas tran vdout1_113ck1750 FIND v(dout1_113) AT=1760.05n

.meas tran vdout1_114ck1750 FIND v(dout1_114) AT=1760.05n

.meas tran vdout1_115ck1750 FIND v(dout1_115) AT=1760.05n

.meas tran vdout1_116ck1750 FIND v(dout1_116) AT=1760.05n

.meas tran vdout1_117ck1750 FIND v(dout1_117) AT=1760.05n

.meas tran vdout1_118ck1750 FIND v(dout1_118) AT=1760.05n

.meas tran vdout1_119ck1750 FIND v(dout1_119) AT=1760.05n

.meas tran vdout1_120ck1750 FIND v(dout1_120) AT=1760.05n

.meas tran vdout1_121ck1750 FIND v(dout1_121) AT=1760.05n

.meas tran vdout1_122ck1750 FIND v(dout1_122) AT=1760.05n

.meas tran vdout1_123ck1750 FIND v(dout1_123) AT=1760.05n

.meas tran vdout1_124ck1750 FIND v(dout1_124) AT=1760.05n

.meas tran vdout1_125ck1750 FIND v(dout1_125) AT=1760.05n

.meas tran vdout1_126ck1750 FIND v(dout1_126) AT=1760.05n

.meas tran vdout1_127ck1750 FIND v(dout1_127) AT=1760.05n

.meas tran vdout1_128ck1750 FIND v(dout1_128) AT=1760.05n

.meas tran vdout1_129ck1750 FIND v(dout1_129) AT=1760.05n

.meas tran vdout1_130ck1750 FIND v(dout1_130) AT=1760.05n

.meas tran vdout1_131ck1750 FIND v(dout1_131) AT=1760.05n

.meas tran vdout1_132ck1750 FIND v(dout1_132) AT=1760.05n

.meas tran vdout1_133ck1750 FIND v(dout1_133) AT=1760.05n

.meas tran vdout1_134ck1750 FIND v(dout1_134) AT=1760.05n

.meas tran vdout1_0ck1760 FIND v(dout1_0) AT=1770.05n

.meas tran vdout1_1ck1760 FIND v(dout1_1) AT=1770.05n

.meas tran vdout1_2ck1760 FIND v(dout1_2) AT=1770.05n

.meas tran vdout1_3ck1760 FIND v(dout1_3) AT=1770.05n

.meas tran vdout1_4ck1760 FIND v(dout1_4) AT=1770.05n

.meas tran vdout1_5ck1760 FIND v(dout1_5) AT=1770.05n

.meas tran vdout1_6ck1760 FIND v(dout1_6) AT=1770.05n

.meas tran vdout1_7ck1760 FIND v(dout1_7) AT=1770.05n

.meas tran vdout1_8ck1760 FIND v(dout1_8) AT=1770.05n

.meas tran vdout1_9ck1760 FIND v(dout1_9) AT=1770.05n

.meas tran vdout1_10ck1760 FIND v(dout1_10) AT=1770.05n

.meas tran vdout1_11ck1760 FIND v(dout1_11) AT=1770.05n

.meas tran vdout1_12ck1760 FIND v(dout1_12) AT=1770.05n

.meas tran vdout1_13ck1760 FIND v(dout1_13) AT=1770.05n

.meas tran vdout1_14ck1760 FIND v(dout1_14) AT=1770.05n

.meas tran vdout1_15ck1760 FIND v(dout1_15) AT=1770.05n

.meas tran vdout1_16ck1760 FIND v(dout1_16) AT=1770.05n

.meas tran vdout1_17ck1760 FIND v(dout1_17) AT=1770.05n

.meas tran vdout1_18ck1760 FIND v(dout1_18) AT=1770.05n

.meas tran vdout1_19ck1760 FIND v(dout1_19) AT=1770.05n

.meas tran vdout1_20ck1760 FIND v(dout1_20) AT=1770.05n

.meas tran vdout1_21ck1760 FIND v(dout1_21) AT=1770.05n

.meas tran vdout1_22ck1760 FIND v(dout1_22) AT=1770.05n

.meas tran vdout1_23ck1760 FIND v(dout1_23) AT=1770.05n

.meas tran vdout1_24ck1760 FIND v(dout1_24) AT=1770.05n

.meas tran vdout1_25ck1760 FIND v(dout1_25) AT=1770.05n

.meas tran vdout1_26ck1760 FIND v(dout1_26) AT=1770.05n

.meas tran vdout1_27ck1760 FIND v(dout1_27) AT=1770.05n

.meas tran vdout1_28ck1760 FIND v(dout1_28) AT=1770.05n

.meas tran vdout1_29ck1760 FIND v(dout1_29) AT=1770.05n

.meas tran vdout1_30ck1760 FIND v(dout1_30) AT=1770.05n

.meas tran vdout1_31ck1760 FIND v(dout1_31) AT=1770.05n

.meas tran vdout1_32ck1760 FIND v(dout1_32) AT=1770.05n

.meas tran vdout1_33ck1760 FIND v(dout1_33) AT=1770.05n

.meas tran vdout1_34ck1760 FIND v(dout1_34) AT=1770.05n

.meas tran vdout1_35ck1760 FIND v(dout1_35) AT=1770.05n

.meas tran vdout1_36ck1760 FIND v(dout1_36) AT=1770.05n

.meas tran vdout1_37ck1760 FIND v(dout1_37) AT=1770.05n

.meas tran vdout1_38ck1760 FIND v(dout1_38) AT=1770.05n

.meas tran vdout1_39ck1760 FIND v(dout1_39) AT=1770.05n

.meas tran vdout1_40ck1760 FIND v(dout1_40) AT=1770.05n

.meas tran vdout1_41ck1760 FIND v(dout1_41) AT=1770.05n

.meas tran vdout1_42ck1760 FIND v(dout1_42) AT=1770.05n

.meas tran vdout1_43ck1760 FIND v(dout1_43) AT=1770.05n

.meas tran vdout1_44ck1760 FIND v(dout1_44) AT=1770.05n

.meas tran vdout1_45ck1760 FIND v(dout1_45) AT=1770.05n

.meas tran vdout1_46ck1760 FIND v(dout1_46) AT=1770.05n

.meas tran vdout1_47ck1760 FIND v(dout1_47) AT=1770.05n

.meas tran vdout1_48ck1760 FIND v(dout1_48) AT=1770.05n

.meas tran vdout1_49ck1760 FIND v(dout1_49) AT=1770.05n

.meas tran vdout1_50ck1760 FIND v(dout1_50) AT=1770.05n

.meas tran vdout1_51ck1760 FIND v(dout1_51) AT=1770.05n

.meas tran vdout1_52ck1760 FIND v(dout1_52) AT=1770.05n

.meas tran vdout1_53ck1760 FIND v(dout1_53) AT=1770.05n

.meas tran vdout1_54ck1760 FIND v(dout1_54) AT=1770.05n

.meas tran vdout1_55ck1760 FIND v(dout1_55) AT=1770.05n

.meas tran vdout1_56ck1760 FIND v(dout1_56) AT=1770.05n

.meas tran vdout1_57ck1760 FIND v(dout1_57) AT=1770.05n

.meas tran vdout1_58ck1760 FIND v(dout1_58) AT=1770.05n

.meas tran vdout1_59ck1760 FIND v(dout1_59) AT=1770.05n

.meas tran vdout1_60ck1760 FIND v(dout1_60) AT=1770.05n

.meas tran vdout1_61ck1760 FIND v(dout1_61) AT=1770.05n

.meas tran vdout1_62ck1760 FIND v(dout1_62) AT=1770.05n

.meas tran vdout1_63ck1760 FIND v(dout1_63) AT=1770.05n

.meas tran vdout1_64ck1760 FIND v(dout1_64) AT=1770.05n

.meas tran vdout1_65ck1760 FIND v(dout1_65) AT=1770.05n

.meas tran vdout1_66ck1760 FIND v(dout1_66) AT=1770.05n

.meas tran vdout1_67ck1760 FIND v(dout1_67) AT=1770.05n

.meas tran vdout1_68ck1760 FIND v(dout1_68) AT=1770.05n

.meas tran vdout1_69ck1760 FIND v(dout1_69) AT=1770.05n

.meas tran vdout1_70ck1760 FIND v(dout1_70) AT=1770.05n

.meas tran vdout1_71ck1760 FIND v(dout1_71) AT=1770.05n

.meas tran vdout1_72ck1760 FIND v(dout1_72) AT=1770.05n

.meas tran vdout1_73ck1760 FIND v(dout1_73) AT=1770.05n

.meas tran vdout1_74ck1760 FIND v(dout1_74) AT=1770.05n

.meas tran vdout1_75ck1760 FIND v(dout1_75) AT=1770.05n

.meas tran vdout1_76ck1760 FIND v(dout1_76) AT=1770.05n

.meas tran vdout1_77ck1760 FIND v(dout1_77) AT=1770.05n

.meas tran vdout1_78ck1760 FIND v(dout1_78) AT=1770.05n

.meas tran vdout1_79ck1760 FIND v(dout1_79) AT=1770.05n

.meas tran vdout1_80ck1760 FIND v(dout1_80) AT=1770.05n

.meas tran vdout1_81ck1760 FIND v(dout1_81) AT=1770.05n

.meas tran vdout1_82ck1760 FIND v(dout1_82) AT=1770.05n

.meas tran vdout1_83ck1760 FIND v(dout1_83) AT=1770.05n

.meas tran vdout1_84ck1760 FIND v(dout1_84) AT=1770.05n

.meas tran vdout1_85ck1760 FIND v(dout1_85) AT=1770.05n

.meas tran vdout1_86ck1760 FIND v(dout1_86) AT=1770.05n

.meas tran vdout1_87ck1760 FIND v(dout1_87) AT=1770.05n

.meas tran vdout1_88ck1760 FIND v(dout1_88) AT=1770.05n

.meas tran vdout1_89ck1760 FIND v(dout1_89) AT=1770.05n

.meas tran vdout1_90ck1760 FIND v(dout1_90) AT=1770.05n

.meas tran vdout1_91ck1760 FIND v(dout1_91) AT=1770.05n

.meas tran vdout1_92ck1760 FIND v(dout1_92) AT=1770.05n

.meas tran vdout1_93ck1760 FIND v(dout1_93) AT=1770.05n

.meas tran vdout1_94ck1760 FIND v(dout1_94) AT=1770.05n

.meas tran vdout1_95ck1760 FIND v(dout1_95) AT=1770.05n

.meas tran vdout1_96ck1760 FIND v(dout1_96) AT=1770.05n

.meas tran vdout1_97ck1760 FIND v(dout1_97) AT=1770.05n

.meas tran vdout1_98ck1760 FIND v(dout1_98) AT=1770.05n

.meas tran vdout1_99ck1760 FIND v(dout1_99) AT=1770.05n

.meas tran vdout1_100ck1760 FIND v(dout1_100) AT=1770.05n

.meas tran vdout1_101ck1760 FIND v(dout1_101) AT=1770.05n

.meas tran vdout1_102ck1760 FIND v(dout1_102) AT=1770.05n

.meas tran vdout1_103ck1760 FIND v(dout1_103) AT=1770.05n

.meas tran vdout1_104ck1760 FIND v(dout1_104) AT=1770.05n

.meas tran vdout1_105ck1760 FIND v(dout1_105) AT=1770.05n

.meas tran vdout1_106ck1760 FIND v(dout1_106) AT=1770.05n

.meas tran vdout1_107ck1760 FIND v(dout1_107) AT=1770.05n

.meas tran vdout1_108ck1760 FIND v(dout1_108) AT=1770.05n

.meas tran vdout1_109ck1760 FIND v(dout1_109) AT=1770.05n

.meas tran vdout1_110ck1760 FIND v(dout1_110) AT=1770.05n

.meas tran vdout1_111ck1760 FIND v(dout1_111) AT=1770.05n

.meas tran vdout1_112ck1760 FIND v(dout1_112) AT=1770.05n

.meas tran vdout1_113ck1760 FIND v(dout1_113) AT=1770.05n

.meas tran vdout1_114ck1760 FIND v(dout1_114) AT=1770.05n

.meas tran vdout1_115ck1760 FIND v(dout1_115) AT=1770.05n

.meas tran vdout1_116ck1760 FIND v(dout1_116) AT=1770.05n

.meas tran vdout1_117ck1760 FIND v(dout1_117) AT=1770.05n

.meas tran vdout1_118ck1760 FIND v(dout1_118) AT=1770.05n

.meas tran vdout1_119ck1760 FIND v(dout1_119) AT=1770.05n

.meas tran vdout1_120ck1760 FIND v(dout1_120) AT=1770.05n

.meas tran vdout1_121ck1760 FIND v(dout1_121) AT=1770.05n

.meas tran vdout1_122ck1760 FIND v(dout1_122) AT=1770.05n

.meas tran vdout1_123ck1760 FIND v(dout1_123) AT=1770.05n

.meas tran vdout1_124ck1760 FIND v(dout1_124) AT=1770.05n

.meas tran vdout1_125ck1760 FIND v(dout1_125) AT=1770.05n

.meas tran vdout1_126ck1760 FIND v(dout1_126) AT=1770.05n

.meas tran vdout1_127ck1760 FIND v(dout1_127) AT=1770.05n

.meas tran vdout1_128ck1760 FIND v(dout1_128) AT=1770.05n

.meas tran vdout1_129ck1760 FIND v(dout1_129) AT=1770.05n

.meas tran vdout1_130ck1760 FIND v(dout1_130) AT=1770.05n

.meas tran vdout1_131ck1760 FIND v(dout1_131) AT=1770.05n

.meas tran vdout1_132ck1760 FIND v(dout1_132) AT=1770.05n

.meas tran vdout1_133ck1760 FIND v(dout1_133) AT=1770.05n

.meas tran vdout1_134ck1760 FIND v(dout1_134) AT=1770.05n

.meas tran vdout1_0ck1770 FIND v(dout1_0) AT=1780.05n

.meas tran vdout1_1ck1770 FIND v(dout1_1) AT=1780.05n

.meas tran vdout1_2ck1770 FIND v(dout1_2) AT=1780.05n

.meas tran vdout1_3ck1770 FIND v(dout1_3) AT=1780.05n

.meas tran vdout1_4ck1770 FIND v(dout1_4) AT=1780.05n

.meas tran vdout1_5ck1770 FIND v(dout1_5) AT=1780.05n

.meas tran vdout1_6ck1770 FIND v(dout1_6) AT=1780.05n

.meas tran vdout1_7ck1770 FIND v(dout1_7) AT=1780.05n

.meas tran vdout1_8ck1770 FIND v(dout1_8) AT=1780.05n

.meas tran vdout1_9ck1770 FIND v(dout1_9) AT=1780.05n

.meas tran vdout1_10ck1770 FIND v(dout1_10) AT=1780.05n

.meas tran vdout1_11ck1770 FIND v(dout1_11) AT=1780.05n

.meas tran vdout1_12ck1770 FIND v(dout1_12) AT=1780.05n

.meas tran vdout1_13ck1770 FIND v(dout1_13) AT=1780.05n

.meas tran vdout1_14ck1770 FIND v(dout1_14) AT=1780.05n

.meas tran vdout1_15ck1770 FIND v(dout1_15) AT=1780.05n

.meas tran vdout1_16ck1770 FIND v(dout1_16) AT=1780.05n

.meas tran vdout1_17ck1770 FIND v(dout1_17) AT=1780.05n

.meas tran vdout1_18ck1770 FIND v(dout1_18) AT=1780.05n

.meas tran vdout1_19ck1770 FIND v(dout1_19) AT=1780.05n

.meas tran vdout1_20ck1770 FIND v(dout1_20) AT=1780.05n

.meas tran vdout1_21ck1770 FIND v(dout1_21) AT=1780.05n

.meas tran vdout1_22ck1770 FIND v(dout1_22) AT=1780.05n

.meas tran vdout1_23ck1770 FIND v(dout1_23) AT=1780.05n

.meas tran vdout1_24ck1770 FIND v(dout1_24) AT=1780.05n

.meas tran vdout1_25ck1770 FIND v(dout1_25) AT=1780.05n

.meas tran vdout1_26ck1770 FIND v(dout1_26) AT=1780.05n

.meas tran vdout1_27ck1770 FIND v(dout1_27) AT=1780.05n

.meas tran vdout1_28ck1770 FIND v(dout1_28) AT=1780.05n

.meas tran vdout1_29ck1770 FIND v(dout1_29) AT=1780.05n

.meas tran vdout1_30ck1770 FIND v(dout1_30) AT=1780.05n

.meas tran vdout1_31ck1770 FIND v(dout1_31) AT=1780.05n

.meas tran vdout1_32ck1770 FIND v(dout1_32) AT=1780.05n

.meas tran vdout1_33ck1770 FIND v(dout1_33) AT=1780.05n

.meas tran vdout1_34ck1770 FIND v(dout1_34) AT=1780.05n

.meas tran vdout1_35ck1770 FIND v(dout1_35) AT=1780.05n

.meas tran vdout1_36ck1770 FIND v(dout1_36) AT=1780.05n

.meas tran vdout1_37ck1770 FIND v(dout1_37) AT=1780.05n

.meas tran vdout1_38ck1770 FIND v(dout1_38) AT=1780.05n

.meas tran vdout1_39ck1770 FIND v(dout1_39) AT=1780.05n

.meas tran vdout1_40ck1770 FIND v(dout1_40) AT=1780.05n

.meas tran vdout1_41ck1770 FIND v(dout1_41) AT=1780.05n

.meas tran vdout1_42ck1770 FIND v(dout1_42) AT=1780.05n

.meas tran vdout1_43ck1770 FIND v(dout1_43) AT=1780.05n

.meas tran vdout1_44ck1770 FIND v(dout1_44) AT=1780.05n

.meas tran vdout1_45ck1770 FIND v(dout1_45) AT=1780.05n

.meas tran vdout1_46ck1770 FIND v(dout1_46) AT=1780.05n

.meas tran vdout1_47ck1770 FIND v(dout1_47) AT=1780.05n

.meas tran vdout1_48ck1770 FIND v(dout1_48) AT=1780.05n

.meas tran vdout1_49ck1770 FIND v(dout1_49) AT=1780.05n

.meas tran vdout1_50ck1770 FIND v(dout1_50) AT=1780.05n

.meas tran vdout1_51ck1770 FIND v(dout1_51) AT=1780.05n

.meas tran vdout1_52ck1770 FIND v(dout1_52) AT=1780.05n

.meas tran vdout1_53ck1770 FIND v(dout1_53) AT=1780.05n

.meas tran vdout1_54ck1770 FIND v(dout1_54) AT=1780.05n

.meas tran vdout1_55ck1770 FIND v(dout1_55) AT=1780.05n

.meas tran vdout1_56ck1770 FIND v(dout1_56) AT=1780.05n

.meas tran vdout1_57ck1770 FIND v(dout1_57) AT=1780.05n

.meas tran vdout1_58ck1770 FIND v(dout1_58) AT=1780.05n

.meas tran vdout1_59ck1770 FIND v(dout1_59) AT=1780.05n

.meas tran vdout1_60ck1770 FIND v(dout1_60) AT=1780.05n

.meas tran vdout1_61ck1770 FIND v(dout1_61) AT=1780.05n

.meas tran vdout1_62ck1770 FIND v(dout1_62) AT=1780.05n

.meas tran vdout1_63ck1770 FIND v(dout1_63) AT=1780.05n

.meas tran vdout1_64ck1770 FIND v(dout1_64) AT=1780.05n

.meas tran vdout1_65ck1770 FIND v(dout1_65) AT=1780.05n

.meas tran vdout1_66ck1770 FIND v(dout1_66) AT=1780.05n

.meas tran vdout1_67ck1770 FIND v(dout1_67) AT=1780.05n

.meas tran vdout1_68ck1770 FIND v(dout1_68) AT=1780.05n

.meas tran vdout1_69ck1770 FIND v(dout1_69) AT=1780.05n

.meas tran vdout1_70ck1770 FIND v(dout1_70) AT=1780.05n

.meas tran vdout1_71ck1770 FIND v(dout1_71) AT=1780.05n

.meas tran vdout1_72ck1770 FIND v(dout1_72) AT=1780.05n

.meas tran vdout1_73ck1770 FIND v(dout1_73) AT=1780.05n

.meas tran vdout1_74ck1770 FIND v(dout1_74) AT=1780.05n

.meas tran vdout1_75ck1770 FIND v(dout1_75) AT=1780.05n

.meas tran vdout1_76ck1770 FIND v(dout1_76) AT=1780.05n

.meas tran vdout1_77ck1770 FIND v(dout1_77) AT=1780.05n

.meas tran vdout1_78ck1770 FIND v(dout1_78) AT=1780.05n

.meas tran vdout1_79ck1770 FIND v(dout1_79) AT=1780.05n

.meas tran vdout1_80ck1770 FIND v(dout1_80) AT=1780.05n

.meas tran vdout1_81ck1770 FIND v(dout1_81) AT=1780.05n

.meas tran vdout1_82ck1770 FIND v(dout1_82) AT=1780.05n

.meas tran vdout1_83ck1770 FIND v(dout1_83) AT=1780.05n

.meas tran vdout1_84ck1770 FIND v(dout1_84) AT=1780.05n

.meas tran vdout1_85ck1770 FIND v(dout1_85) AT=1780.05n

.meas tran vdout1_86ck1770 FIND v(dout1_86) AT=1780.05n

.meas tran vdout1_87ck1770 FIND v(dout1_87) AT=1780.05n

.meas tran vdout1_88ck1770 FIND v(dout1_88) AT=1780.05n

.meas tran vdout1_89ck1770 FIND v(dout1_89) AT=1780.05n

.meas tran vdout1_90ck1770 FIND v(dout1_90) AT=1780.05n

.meas tran vdout1_91ck1770 FIND v(dout1_91) AT=1780.05n

.meas tran vdout1_92ck1770 FIND v(dout1_92) AT=1780.05n

.meas tran vdout1_93ck1770 FIND v(dout1_93) AT=1780.05n

.meas tran vdout1_94ck1770 FIND v(dout1_94) AT=1780.05n

.meas tran vdout1_95ck1770 FIND v(dout1_95) AT=1780.05n

.meas tran vdout1_96ck1770 FIND v(dout1_96) AT=1780.05n

.meas tran vdout1_97ck1770 FIND v(dout1_97) AT=1780.05n

.meas tran vdout1_98ck1770 FIND v(dout1_98) AT=1780.05n

.meas tran vdout1_99ck1770 FIND v(dout1_99) AT=1780.05n

.meas tran vdout1_100ck1770 FIND v(dout1_100) AT=1780.05n

.meas tran vdout1_101ck1770 FIND v(dout1_101) AT=1780.05n

.meas tran vdout1_102ck1770 FIND v(dout1_102) AT=1780.05n

.meas tran vdout1_103ck1770 FIND v(dout1_103) AT=1780.05n

.meas tran vdout1_104ck1770 FIND v(dout1_104) AT=1780.05n

.meas tran vdout1_105ck1770 FIND v(dout1_105) AT=1780.05n

.meas tran vdout1_106ck1770 FIND v(dout1_106) AT=1780.05n

.meas tran vdout1_107ck1770 FIND v(dout1_107) AT=1780.05n

.meas tran vdout1_108ck1770 FIND v(dout1_108) AT=1780.05n

.meas tran vdout1_109ck1770 FIND v(dout1_109) AT=1780.05n

.meas tran vdout1_110ck1770 FIND v(dout1_110) AT=1780.05n

.meas tran vdout1_111ck1770 FIND v(dout1_111) AT=1780.05n

.meas tran vdout1_112ck1770 FIND v(dout1_112) AT=1780.05n

.meas tran vdout1_113ck1770 FIND v(dout1_113) AT=1780.05n

.meas tran vdout1_114ck1770 FIND v(dout1_114) AT=1780.05n

.meas tran vdout1_115ck1770 FIND v(dout1_115) AT=1780.05n

.meas tran vdout1_116ck1770 FIND v(dout1_116) AT=1780.05n

.meas tran vdout1_117ck1770 FIND v(dout1_117) AT=1780.05n

.meas tran vdout1_118ck1770 FIND v(dout1_118) AT=1780.05n

.meas tran vdout1_119ck1770 FIND v(dout1_119) AT=1780.05n

.meas tran vdout1_120ck1770 FIND v(dout1_120) AT=1780.05n

.meas tran vdout1_121ck1770 FIND v(dout1_121) AT=1780.05n

.meas tran vdout1_122ck1770 FIND v(dout1_122) AT=1780.05n

.meas tran vdout1_123ck1770 FIND v(dout1_123) AT=1780.05n

.meas tran vdout1_124ck1770 FIND v(dout1_124) AT=1780.05n

.meas tran vdout1_125ck1770 FIND v(dout1_125) AT=1780.05n

.meas tran vdout1_126ck1770 FIND v(dout1_126) AT=1780.05n

.meas tran vdout1_127ck1770 FIND v(dout1_127) AT=1780.05n

.meas tran vdout1_128ck1770 FIND v(dout1_128) AT=1780.05n

.meas tran vdout1_129ck1770 FIND v(dout1_129) AT=1780.05n

.meas tran vdout1_130ck1770 FIND v(dout1_130) AT=1780.05n

.meas tran vdout1_131ck1770 FIND v(dout1_131) AT=1780.05n

.meas tran vdout1_132ck1770 FIND v(dout1_132) AT=1780.05n

.meas tran vdout1_133ck1770 FIND v(dout1_133) AT=1780.05n

.meas tran vdout1_134ck1770 FIND v(dout1_134) AT=1780.05n

.meas tran vdout1_0ck1780 FIND v(dout1_0) AT=1790.05n

.meas tran vdout1_1ck1780 FIND v(dout1_1) AT=1790.05n

.meas tran vdout1_2ck1780 FIND v(dout1_2) AT=1790.05n

.meas tran vdout1_3ck1780 FIND v(dout1_3) AT=1790.05n

.meas tran vdout1_4ck1780 FIND v(dout1_4) AT=1790.05n

.meas tran vdout1_5ck1780 FIND v(dout1_5) AT=1790.05n

.meas tran vdout1_6ck1780 FIND v(dout1_6) AT=1790.05n

.meas tran vdout1_7ck1780 FIND v(dout1_7) AT=1790.05n

.meas tran vdout1_8ck1780 FIND v(dout1_8) AT=1790.05n

.meas tran vdout1_9ck1780 FIND v(dout1_9) AT=1790.05n

.meas tran vdout1_10ck1780 FIND v(dout1_10) AT=1790.05n

.meas tran vdout1_11ck1780 FIND v(dout1_11) AT=1790.05n

.meas tran vdout1_12ck1780 FIND v(dout1_12) AT=1790.05n

.meas tran vdout1_13ck1780 FIND v(dout1_13) AT=1790.05n

.meas tran vdout1_14ck1780 FIND v(dout1_14) AT=1790.05n

.meas tran vdout1_15ck1780 FIND v(dout1_15) AT=1790.05n

.meas tran vdout1_16ck1780 FIND v(dout1_16) AT=1790.05n

.meas tran vdout1_17ck1780 FIND v(dout1_17) AT=1790.05n

.meas tran vdout1_18ck1780 FIND v(dout1_18) AT=1790.05n

.meas tran vdout1_19ck1780 FIND v(dout1_19) AT=1790.05n

.meas tran vdout1_20ck1780 FIND v(dout1_20) AT=1790.05n

.meas tran vdout1_21ck1780 FIND v(dout1_21) AT=1790.05n

.meas tran vdout1_22ck1780 FIND v(dout1_22) AT=1790.05n

.meas tran vdout1_23ck1780 FIND v(dout1_23) AT=1790.05n

.meas tran vdout1_24ck1780 FIND v(dout1_24) AT=1790.05n

.meas tran vdout1_25ck1780 FIND v(dout1_25) AT=1790.05n

.meas tran vdout1_26ck1780 FIND v(dout1_26) AT=1790.05n

.meas tran vdout1_27ck1780 FIND v(dout1_27) AT=1790.05n

.meas tran vdout1_28ck1780 FIND v(dout1_28) AT=1790.05n

.meas tran vdout1_29ck1780 FIND v(dout1_29) AT=1790.05n

.meas tran vdout1_30ck1780 FIND v(dout1_30) AT=1790.05n

.meas tran vdout1_31ck1780 FIND v(dout1_31) AT=1790.05n

.meas tran vdout1_32ck1780 FIND v(dout1_32) AT=1790.05n

.meas tran vdout1_33ck1780 FIND v(dout1_33) AT=1790.05n

.meas tran vdout1_34ck1780 FIND v(dout1_34) AT=1790.05n

.meas tran vdout1_35ck1780 FIND v(dout1_35) AT=1790.05n

.meas tran vdout1_36ck1780 FIND v(dout1_36) AT=1790.05n

.meas tran vdout1_37ck1780 FIND v(dout1_37) AT=1790.05n

.meas tran vdout1_38ck1780 FIND v(dout1_38) AT=1790.05n

.meas tran vdout1_39ck1780 FIND v(dout1_39) AT=1790.05n

.meas tran vdout1_40ck1780 FIND v(dout1_40) AT=1790.05n

.meas tran vdout1_41ck1780 FIND v(dout1_41) AT=1790.05n

.meas tran vdout1_42ck1780 FIND v(dout1_42) AT=1790.05n

.meas tran vdout1_43ck1780 FIND v(dout1_43) AT=1790.05n

.meas tran vdout1_44ck1780 FIND v(dout1_44) AT=1790.05n

.meas tran vdout1_45ck1780 FIND v(dout1_45) AT=1790.05n

.meas tran vdout1_46ck1780 FIND v(dout1_46) AT=1790.05n

.meas tran vdout1_47ck1780 FIND v(dout1_47) AT=1790.05n

.meas tran vdout1_48ck1780 FIND v(dout1_48) AT=1790.05n

.meas tran vdout1_49ck1780 FIND v(dout1_49) AT=1790.05n

.meas tran vdout1_50ck1780 FIND v(dout1_50) AT=1790.05n

.meas tran vdout1_51ck1780 FIND v(dout1_51) AT=1790.05n

.meas tran vdout1_52ck1780 FIND v(dout1_52) AT=1790.05n

.meas tran vdout1_53ck1780 FIND v(dout1_53) AT=1790.05n

.meas tran vdout1_54ck1780 FIND v(dout1_54) AT=1790.05n

.meas tran vdout1_55ck1780 FIND v(dout1_55) AT=1790.05n

.meas tran vdout1_56ck1780 FIND v(dout1_56) AT=1790.05n

.meas tran vdout1_57ck1780 FIND v(dout1_57) AT=1790.05n

.meas tran vdout1_58ck1780 FIND v(dout1_58) AT=1790.05n

.meas tran vdout1_59ck1780 FIND v(dout1_59) AT=1790.05n

.meas tran vdout1_60ck1780 FIND v(dout1_60) AT=1790.05n

.meas tran vdout1_61ck1780 FIND v(dout1_61) AT=1790.05n

.meas tran vdout1_62ck1780 FIND v(dout1_62) AT=1790.05n

.meas tran vdout1_63ck1780 FIND v(dout1_63) AT=1790.05n

.meas tran vdout1_64ck1780 FIND v(dout1_64) AT=1790.05n

.meas tran vdout1_65ck1780 FIND v(dout1_65) AT=1790.05n

.meas tran vdout1_66ck1780 FIND v(dout1_66) AT=1790.05n

.meas tran vdout1_67ck1780 FIND v(dout1_67) AT=1790.05n

.meas tran vdout1_68ck1780 FIND v(dout1_68) AT=1790.05n

.meas tran vdout1_69ck1780 FIND v(dout1_69) AT=1790.05n

.meas tran vdout1_70ck1780 FIND v(dout1_70) AT=1790.05n

.meas tran vdout1_71ck1780 FIND v(dout1_71) AT=1790.05n

.meas tran vdout1_72ck1780 FIND v(dout1_72) AT=1790.05n

.meas tran vdout1_73ck1780 FIND v(dout1_73) AT=1790.05n

.meas tran vdout1_74ck1780 FIND v(dout1_74) AT=1790.05n

.meas tran vdout1_75ck1780 FIND v(dout1_75) AT=1790.05n

.meas tran vdout1_76ck1780 FIND v(dout1_76) AT=1790.05n

.meas tran vdout1_77ck1780 FIND v(dout1_77) AT=1790.05n

.meas tran vdout1_78ck1780 FIND v(dout1_78) AT=1790.05n

.meas tran vdout1_79ck1780 FIND v(dout1_79) AT=1790.05n

.meas tran vdout1_80ck1780 FIND v(dout1_80) AT=1790.05n

.meas tran vdout1_81ck1780 FIND v(dout1_81) AT=1790.05n

.meas tran vdout1_82ck1780 FIND v(dout1_82) AT=1790.05n

.meas tran vdout1_83ck1780 FIND v(dout1_83) AT=1790.05n

.meas tran vdout1_84ck1780 FIND v(dout1_84) AT=1790.05n

.meas tran vdout1_85ck1780 FIND v(dout1_85) AT=1790.05n

.meas tran vdout1_86ck1780 FIND v(dout1_86) AT=1790.05n

.meas tran vdout1_87ck1780 FIND v(dout1_87) AT=1790.05n

.meas tran vdout1_88ck1780 FIND v(dout1_88) AT=1790.05n

.meas tran vdout1_89ck1780 FIND v(dout1_89) AT=1790.05n

.meas tran vdout1_90ck1780 FIND v(dout1_90) AT=1790.05n

.meas tran vdout1_91ck1780 FIND v(dout1_91) AT=1790.05n

.meas tran vdout1_92ck1780 FIND v(dout1_92) AT=1790.05n

.meas tran vdout1_93ck1780 FIND v(dout1_93) AT=1790.05n

.meas tran vdout1_94ck1780 FIND v(dout1_94) AT=1790.05n

.meas tran vdout1_95ck1780 FIND v(dout1_95) AT=1790.05n

.meas tran vdout1_96ck1780 FIND v(dout1_96) AT=1790.05n

.meas tran vdout1_97ck1780 FIND v(dout1_97) AT=1790.05n

.meas tran vdout1_98ck1780 FIND v(dout1_98) AT=1790.05n

.meas tran vdout1_99ck1780 FIND v(dout1_99) AT=1790.05n

.meas tran vdout1_100ck1780 FIND v(dout1_100) AT=1790.05n

.meas tran vdout1_101ck1780 FIND v(dout1_101) AT=1790.05n

.meas tran vdout1_102ck1780 FIND v(dout1_102) AT=1790.05n

.meas tran vdout1_103ck1780 FIND v(dout1_103) AT=1790.05n

.meas tran vdout1_104ck1780 FIND v(dout1_104) AT=1790.05n

.meas tran vdout1_105ck1780 FIND v(dout1_105) AT=1790.05n

.meas tran vdout1_106ck1780 FIND v(dout1_106) AT=1790.05n

.meas tran vdout1_107ck1780 FIND v(dout1_107) AT=1790.05n

.meas tran vdout1_108ck1780 FIND v(dout1_108) AT=1790.05n

.meas tran vdout1_109ck1780 FIND v(dout1_109) AT=1790.05n

.meas tran vdout1_110ck1780 FIND v(dout1_110) AT=1790.05n

.meas tran vdout1_111ck1780 FIND v(dout1_111) AT=1790.05n

.meas tran vdout1_112ck1780 FIND v(dout1_112) AT=1790.05n

.meas tran vdout1_113ck1780 FIND v(dout1_113) AT=1790.05n

.meas tran vdout1_114ck1780 FIND v(dout1_114) AT=1790.05n

.meas tran vdout1_115ck1780 FIND v(dout1_115) AT=1790.05n

.meas tran vdout1_116ck1780 FIND v(dout1_116) AT=1790.05n

.meas tran vdout1_117ck1780 FIND v(dout1_117) AT=1790.05n

.meas tran vdout1_118ck1780 FIND v(dout1_118) AT=1790.05n

.meas tran vdout1_119ck1780 FIND v(dout1_119) AT=1790.05n

.meas tran vdout1_120ck1780 FIND v(dout1_120) AT=1790.05n

.meas tran vdout1_121ck1780 FIND v(dout1_121) AT=1790.05n

.meas tran vdout1_122ck1780 FIND v(dout1_122) AT=1790.05n

.meas tran vdout1_123ck1780 FIND v(dout1_123) AT=1790.05n

.meas tran vdout1_124ck1780 FIND v(dout1_124) AT=1790.05n

.meas tran vdout1_125ck1780 FIND v(dout1_125) AT=1790.05n

.meas tran vdout1_126ck1780 FIND v(dout1_126) AT=1790.05n

.meas tran vdout1_127ck1780 FIND v(dout1_127) AT=1790.05n

.meas tran vdout1_128ck1780 FIND v(dout1_128) AT=1790.05n

.meas tran vdout1_129ck1780 FIND v(dout1_129) AT=1790.05n

.meas tran vdout1_130ck1780 FIND v(dout1_130) AT=1790.05n

.meas tran vdout1_131ck1780 FIND v(dout1_131) AT=1790.05n

.meas tran vdout1_132ck1780 FIND v(dout1_132) AT=1790.05n

.meas tran vdout1_133ck1780 FIND v(dout1_133) AT=1790.05n

.meas tran vdout1_134ck1780 FIND v(dout1_134) AT=1790.05n

.meas tran vdout1_0ck1790 FIND v(dout1_0) AT=1800.05n

.meas tran vdout1_1ck1790 FIND v(dout1_1) AT=1800.05n

.meas tran vdout1_2ck1790 FIND v(dout1_2) AT=1800.05n

.meas tran vdout1_3ck1790 FIND v(dout1_3) AT=1800.05n

.meas tran vdout1_4ck1790 FIND v(dout1_4) AT=1800.05n

.meas tran vdout1_5ck1790 FIND v(dout1_5) AT=1800.05n

.meas tran vdout1_6ck1790 FIND v(dout1_6) AT=1800.05n

.meas tran vdout1_7ck1790 FIND v(dout1_7) AT=1800.05n

.meas tran vdout1_8ck1790 FIND v(dout1_8) AT=1800.05n

.meas tran vdout1_9ck1790 FIND v(dout1_9) AT=1800.05n

.meas tran vdout1_10ck1790 FIND v(dout1_10) AT=1800.05n

.meas tran vdout1_11ck1790 FIND v(dout1_11) AT=1800.05n

.meas tran vdout1_12ck1790 FIND v(dout1_12) AT=1800.05n

.meas tran vdout1_13ck1790 FIND v(dout1_13) AT=1800.05n

.meas tran vdout1_14ck1790 FIND v(dout1_14) AT=1800.05n

.meas tran vdout1_15ck1790 FIND v(dout1_15) AT=1800.05n

.meas tran vdout1_16ck1790 FIND v(dout1_16) AT=1800.05n

.meas tran vdout1_17ck1790 FIND v(dout1_17) AT=1800.05n

.meas tran vdout1_18ck1790 FIND v(dout1_18) AT=1800.05n

.meas tran vdout1_19ck1790 FIND v(dout1_19) AT=1800.05n

.meas tran vdout1_20ck1790 FIND v(dout1_20) AT=1800.05n

.meas tran vdout1_21ck1790 FIND v(dout1_21) AT=1800.05n

.meas tran vdout1_22ck1790 FIND v(dout1_22) AT=1800.05n

.meas tran vdout1_23ck1790 FIND v(dout1_23) AT=1800.05n

.meas tran vdout1_24ck1790 FIND v(dout1_24) AT=1800.05n

.meas tran vdout1_25ck1790 FIND v(dout1_25) AT=1800.05n

.meas tran vdout1_26ck1790 FIND v(dout1_26) AT=1800.05n

.meas tran vdout1_27ck1790 FIND v(dout1_27) AT=1800.05n

.meas tran vdout1_28ck1790 FIND v(dout1_28) AT=1800.05n

.meas tran vdout1_29ck1790 FIND v(dout1_29) AT=1800.05n

.meas tran vdout1_30ck1790 FIND v(dout1_30) AT=1800.05n

.meas tran vdout1_31ck1790 FIND v(dout1_31) AT=1800.05n

.meas tran vdout1_32ck1790 FIND v(dout1_32) AT=1800.05n

.meas tran vdout1_33ck1790 FIND v(dout1_33) AT=1800.05n

.meas tran vdout1_34ck1790 FIND v(dout1_34) AT=1800.05n

.meas tran vdout1_35ck1790 FIND v(dout1_35) AT=1800.05n

.meas tran vdout1_36ck1790 FIND v(dout1_36) AT=1800.05n

.meas tran vdout1_37ck1790 FIND v(dout1_37) AT=1800.05n

.meas tran vdout1_38ck1790 FIND v(dout1_38) AT=1800.05n

.meas tran vdout1_39ck1790 FIND v(dout1_39) AT=1800.05n

.meas tran vdout1_40ck1790 FIND v(dout1_40) AT=1800.05n

.meas tran vdout1_41ck1790 FIND v(dout1_41) AT=1800.05n

.meas tran vdout1_42ck1790 FIND v(dout1_42) AT=1800.05n

.meas tran vdout1_43ck1790 FIND v(dout1_43) AT=1800.05n

.meas tran vdout1_44ck1790 FIND v(dout1_44) AT=1800.05n

.meas tran vdout1_45ck1790 FIND v(dout1_45) AT=1800.05n

.meas tran vdout1_46ck1790 FIND v(dout1_46) AT=1800.05n

.meas tran vdout1_47ck1790 FIND v(dout1_47) AT=1800.05n

.meas tran vdout1_48ck1790 FIND v(dout1_48) AT=1800.05n

.meas tran vdout1_49ck1790 FIND v(dout1_49) AT=1800.05n

.meas tran vdout1_50ck1790 FIND v(dout1_50) AT=1800.05n

.meas tran vdout1_51ck1790 FIND v(dout1_51) AT=1800.05n

.meas tran vdout1_52ck1790 FIND v(dout1_52) AT=1800.05n

.meas tran vdout1_53ck1790 FIND v(dout1_53) AT=1800.05n

.meas tran vdout1_54ck1790 FIND v(dout1_54) AT=1800.05n

.meas tran vdout1_55ck1790 FIND v(dout1_55) AT=1800.05n

.meas tran vdout1_56ck1790 FIND v(dout1_56) AT=1800.05n

.meas tran vdout1_57ck1790 FIND v(dout1_57) AT=1800.05n

.meas tran vdout1_58ck1790 FIND v(dout1_58) AT=1800.05n

.meas tran vdout1_59ck1790 FIND v(dout1_59) AT=1800.05n

.meas tran vdout1_60ck1790 FIND v(dout1_60) AT=1800.05n

.meas tran vdout1_61ck1790 FIND v(dout1_61) AT=1800.05n

.meas tran vdout1_62ck1790 FIND v(dout1_62) AT=1800.05n

.meas tran vdout1_63ck1790 FIND v(dout1_63) AT=1800.05n

.meas tran vdout1_64ck1790 FIND v(dout1_64) AT=1800.05n

.meas tran vdout1_65ck1790 FIND v(dout1_65) AT=1800.05n

.meas tran vdout1_66ck1790 FIND v(dout1_66) AT=1800.05n

.meas tran vdout1_67ck1790 FIND v(dout1_67) AT=1800.05n

.meas tran vdout1_68ck1790 FIND v(dout1_68) AT=1800.05n

.meas tran vdout1_69ck1790 FIND v(dout1_69) AT=1800.05n

.meas tran vdout1_70ck1790 FIND v(dout1_70) AT=1800.05n

.meas tran vdout1_71ck1790 FIND v(dout1_71) AT=1800.05n

.meas tran vdout1_72ck1790 FIND v(dout1_72) AT=1800.05n

.meas tran vdout1_73ck1790 FIND v(dout1_73) AT=1800.05n

.meas tran vdout1_74ck1790 FIND v(dout1_74) AT=1800.05n

.meas tran vdout1_75ck1790 FIND v(dout1_75) AT=1800.05n

.meas tran vdout1_76ck1790 FIND v(dout1_76) AT=1800.05n

.meas tran vdout1_77ck1790 FIND v(dout1_77) AT=1800.05n

.meas tran vdout1_78ck1790 FIND v(dout1_78) AT=1800.05n

.meas tran vdout1_79ck1790 FIND v(dout1_79) AT=1800.05n

.meas tran vdout1_80ck1790 FIND v(dout1_80) AT=1800.05n

.meas tran vdout1_81ck1790 FIND v(dout1_81) AT=1800.05n

.meas tran vdout1_82ck1790 FIND v(dout1_82) AT=1800.05n

.meas tran vdout1_83ck1790 FIND v(dout1_83) AT=1800.05n

.meas tran vdout1_84ck1790 FIND v(dout1_84) AT=1800.05n

.meas tran vdout1_85ck1790 FIND v(dout1_85) AT=1800.05n

.meas tran vdout1_86ck1790 FIND v(dout1_86) AT=1800.05n

.meas tran vdout1_87ck1790 FIND v(dout1_87) AT=1800.05n

.meas tran vdout1_88ck1790 FIND v(dout1_88) AT=1800.05n

.meas tran vdout1_89ck1790 FIND v(dout1_89) AT=1800.05n

.meas tran vdout1_90ck1790 FIND v(dout1_90) AT=1800.05n

.meas tran vdout1_91ck1790 FIND v(dout1_91) AT=1800.05n

.meas tran vdout1_92ck1790 FIND v(dout1_92) AT=1800.05n

.meas tran vdout1_93ck1790 FIND v(dout1_93) AT=1800.05n

.meas tran vdout1_94ck1790 FIND v(dout1_94) AT=1800.05n

.meas tran vdout1_95ck1790 FIND v(dout1_95) AT=1800.05n

.meas tran vdout1_96ck1790 FIND v(dout1_96) AT=1800.05n

.meas tran vdout1_97ck1790 FIND v(dout1_97) AT=1800.05n

.meas tran vdout1_98ck1790 FIND v(dout1_98) AT=1800.05n

.meas tran vdout1_99ck1790 FIND v(dout1_99) AT=1800.05n

.meas tran vdout1_100ck1790 FIND v(dout1_100) AT=1800.05n

.meas tran vdout1_101ck1790 FIND v(dout1_101) AT=1800.05n

.meas tran vdout1_102ck1790 FIND v(dout1_102) AT=1800.05n

.meas tran vdout1_103ck1790 FIND v(dout1_103) AT=1800.05n

.meas tran vdout1_104ck1790 FIND v(dout1_104) AT=1800.05n

.meas tran vdout1_105ck1790 FIND v(dout1_105) AT=1800.05n

.meas tran vdout1_106ck1790 FIND v(dout1_106) AT=1800.05n

.meas tran vdout1_107ck1790 FIND v(dout1_107) AT=1800.05n

.meas tran vdout1_108ck1790 FIND v(dout1_108) AT=1800.05n

.meas tran vdout1_109ck1790 FIND v(dout1_109) AT=1800.05n

.meas tran vdout1_110ck1790 FIND v(dout1_110) AT=1800.05n

.meas tran vdout1_111ck1790 FIND v(dout1_111) AT=1800.05n

.meas tran vdout1_112ck1790 FIND v(dout1_112) AT=1800.05n

.meas tran vdout1_113ck1790 FIND v(dout1_113) AT=1800.05n

.meas tran vdout1_114ck1790 FIND v(dout1_114) AT=1800.05n

.meas tran vdout1_115ck1790 FIND v(dout1_115) AT=1800.05n

.meas tran vdout1_116ck1790 FIND v(dout1_116) AT=1800.05n

.meas tran vdout1_117ck1790 FIND v(dout1_117) AT=1800.05n

.meas tran vdout1_118ck1790 FIND v(dout1_118) AT=1800.05n

.meas tran vdout1_119ck1790 FIND v(dout1_119) AT=1800.05n

.meas tran vdout1_120ck1790 FIND v(dout1_120) AT=1800.05n

.meas tran vdout1_121ck1790 FIND v(dout1_121) AT=1800.05n

.meas tran vdout1_122ck1790 FIND v(dout1_122) AT=1800.05n

.meas tran vdout1_123ck1790 FIND v(dout1_123) AT=1800.05n

.meas tran vdout1_124ck1790 FIND v(dout1_124) AT=1800.05n

.meas tran vdout1_125ck1790 FIND v(dout1_125) AT=1800.05n

.meas tran vdout1_126ck1790 FIND v(dout1_126) AT=1800.05n

.meas tran vdout1_127ck1790 FIND v(dout1_127) AT=1800.05n

.meas tran vdout1_128ck1790 FIND v(dout1_128) AT=1800.05n

.meas tran vdout1_129ck1790 FIND v(dout1_129) AT=1800.05n

.meas tran vdout1_130ck1790 FIND v(dout1_130) AT=1800.05n

.meas tran vdout1_131ck1790 FIND v(dout1_131) AT=1800.05n

.meas tran vdout1_132ck1790 FIND v(dout1_132) AT=1800.05n

.meas tran vdout1_133ck1790 FIND v(dout1_133) AT=1800.05n

.meas tran vdout1_134ck1790 FIND v(dout1_134) AT=1800.05n

.meas tran vdout1_0ck1800 FIND v(dout1_0) AT=1810.05n

.meas tran vdout1_1ck1800 FIND v(dout1_1) AT=1810.05n

.meas tran vdout1_2ck1800 FIND v(dout1_2) AT=1810.05n

.meas tran vdout1_3ck1800 FIND v(dout1_3) AT=1810.05n

.meas tran vdout1_4ck1800 FIND v(dout1_4) AT=1810.05n

.meas tran vdout1_5ck1800 FIND v(dout1_5) AT=1810.05n

.meas tran vdout1_6ck1800 FIND v(dout1_6) AT=1810.05n

.meas tran vdout1_7ck1800 FIND v(dout1_7) AT=1810.05n

.meas tran vdout1_8ck1800 FIND v(dout1_8) AT=1810.05n

.meas tran vdout1_9ck1800 FIND v(dout1_9) AT=1810.05n

.meas tran vdout1_10ck1800 FIND v(dout1_10) AT=1810.05n

.meas tran vdout1_11ck1800 FIND v(dout1_11) AT=1810.05n

.meas tran vdout1_12ck1800 FIND v(dout1_12) AT=1810.05n

.meas tran vdout1_13ck1800 FIND v(dout1_13) AT=1810.05n

.meas tran vdout1_14ck1800 FIND v(dout1_14) AT=1810.05n

.meas tran vdout1_15ck1800 FIND v(dout1_15) AT=1810.05n

.meas tran vdout1_16ck1800 FIND v(dout1_16) AT=1810.05n

.meas tran vdout1_17ck1800 FIND v(dout1_17) AT=1810.05n

.meas tran vdout1_18ck1800 FIND v(dout1_18) AT=1810.05n

.meas tran vdout1_19ck1800 FIND v(dout1_19) AT=1810.05n

.meas tran vdout1_20ck1800 FIND v(dout1_20) AT=1810.05n

.meas tran vdout1_21ck1800 FIND v(dout1_21) AT=1810.05n

.meas tran vdout1_22ck1800 FIND v(dout1_22) AT=1810.05n

.meas tran vdout1_23ck1800 FIND v(dout1_23) AT=1810.05n

.meas tran vdout1_24ck1800 FIND v(dout1_24) AT=1810.05n

.meas tran vdout1_25ck1800 FIND v(dout1_25) AT=1810.05n

.meas tran vdout1_26ck1800 FIND v(dout1_26) AT=1810.05n

.meas tran vdout1_27ck1800 FIND v(dout1_27) AT=1810.05n

.meas tran vdout1_28ck1800 FIND v(dout1_28) AT=1810.05n

.meas tran vdout1_29ck1800 FIND v(dout1_29) AT=1810.05n

.meas tran vdout1_30ck1800 FIND v(dout1_30) AT=1810.05n

.meas tran vdout1_31ck1800 FIND v(dout1_31) AT=1810.05n

.meas tran vdout1_32ck1800 FIND v(dout1_32) AT=1810.05n

.meas tran vdout1_33ck1800 FIND v(dout1_33) AT=1810.05n

.meas tran vdout1_34ck1800 FIND v(dout1_34) AT=1810.05n

.meas tran vdout1_35ck1800 FIND v(dout1_35) AT=1810.05n

.meas tran vdout1_36ck1800 FIND v(dout1_36) AT=1810.05n

.meas tran vdout1_37ck1800 FIND v(dout1_37) AT=1810.05n

.meas tran vdout1_38ck1800 FIND v(dout1_38) AT=1810.05n

.meas tran vdout1_39ck1800 FIND v(dout1_39) AT=1810.05n

.meas tran vdout1_40ck1800 FIND v(dout1_40) AT=1810.05n

.meas tran vdout1_41ck1800 FIND v(dout1_41) AT=1810.05n

.meas tran vdout1_42ck1800 FIND v(dout1_42) AT=1810.05n

.meas tran vdout1_43ck1800 FIND v(dout1_43) AT=1810.05n

.meas tran vdout1_44ck1800 FIND v(dout1_44) AT=1810.05n

.meas tran vdout1_45ck1800 FIND v(dout1_45) AT=1810.05n

.meas tran vdout1_46ck1800 FIND v(dout1_46) AT=1810.05n

.meas tran vdout1_47ck1800 FIND v(dout1_47) AT=1810.05n

.meas tran vdout1_48ck1800 FIND v(dout1_48) AT=1810.05n

.meas tran vdout1_49ck1800 FIND v(dout1_49) AT=1810.05n

.meas tran vdout1_50ck1800 FIND v(dout1_50) AT=1810.05n

.meas tran vdout1_51ck1800 FIND v(dout1_51) AT=1810.05n

.meas tran vdout1_52ck1800 FIND v(dout1_52) AT=1810.05n

.meas tran vdout1_53ck1800 FIND v(dout1_53) AT=1810.05n

.meas tran vdout1_54ck1800 FIND v(dout1_54) AT=1810.05n

.meas tran vdout1_55ck1800 FIND v(dout1_55) AT=1810.05n

.meas tran vdout1_56ck1800 FIND v(dout1_56) AT=1810.05n

.meas tran vdout1_57ck1800 FIND v(dout1_57) AT=1810.05n

.meas tran vdout1_58ck1800 FIND v(dout1_58) AT=1810.05n

.meas tran vdout1_59ck1800 FIND v(dout1_59) AT=1810.05n

.meas tran vdout1_60ck1800 FIND v(dout1_60) AT=1810.05n

.meas tran vdout1_61ck1800 FIND v(dout1_61) AT=1810.05n

.meas tran vdout1_62ck1800 FIND v(dout1_62) AT=1810.05n

.meas tran vdout1_63ck1800 FIND v(dout1_63) AT=1810.05n

.meas tran vdout1_64ck1800 FIND v(dout1_64) AT=1810.05n

.meas tran vdout1_65ck1800 FIND v(dout1_65) AT=1810.05n

.meas tran vdout1_66ck1800 FIND v(dout1_66) AT=1810.05n

.meas tran vdout1_67ck1800 FIND v(dout1_67) AT=1810.05n

.meas tran vdout1_68ck1800 FIND v(dout1_68) AT=1810.05n

.meas tran vdout1_69ck1800 FIND v(dout1_69) AT=1810.05n

.meas tran vdout1_70ck1800 FIND v(dout1_70) AT=1810.05n

.meas tran vdout1_71ck1800 FIND v(dout1_71) AT=1810.05n

.meas tran vdout1_72ck1800 FIND v(dout1_72) AT=1810.05n

.meas tran vdout1_73ck1800 FIND v(dout1_73) AT=1810.05n

.meas tran vdout1_74ck1800 FIND v(dout1_74) AT=1810.05n

.meas tran vdout1_75ck1800 FIND v(dout1_75) AT=1810.05n

.meas tran vdout1_76ck1800 FIND v(dout1_76) AT=1810.05n

.meas tran vdout1_77ck1800 FIND v(dout1_77) AT=1810.05n

.meas tran vdout1_78ck1800 FIND v(dout1_78) AT=1810.05n

.meas tran vdout1_79ck1800 FIND v(dout1_79) AT=1810.05n

.meas tran vdout1_80ck1800 FIND v(dout1_80) AT=1810.05n

.meas tran vdout1_81ck1800 FIND v(dout1_81) AT=1810.05n

.meas tran vdout1_82ck1800 FIND v(dout1_82) AT=1810.05n

.meas tran vdout1_83ck1800 FIND v(dout1_83) AT=1810.05n

.meas tran vdout1_84ck1800 FIND v(dout1_84) AT=1810.05n

.meas tran vdout1_85ck1800 FIND v(dout1_85) AT=1810.05n

.meas tran vdout1_86ck1800 FIND v(dout1_86) AT=1810.05n

.meas tran vdout1_87ck1800 FIND v(dout1_87) AT=1810.05n

.meas tran vdout1_88ck1800 FIND v(dout1_88) AT=1810.05n

.meas tran vdout1_89ck1800 FIND v(dout1_89) AT=1810.05n

.meas tran vdout1_90ck1800 FIND v(dout1_90) AT=1810.05n

.meas tran vdout1_91ck1800 FIND v(dout1_91) AT=1810.05n

.meas tran vdout1_92ck1800 FIND v(dout1_92) AT=1810.05n

.meas tran vdout1_93ck1800 FIND v(dout1_93) AT=1810.05n

.meas tran vdout1_94ck1800 FIND v(dout1_94) AT=1810.05n

.meas tran vdout1_95ck1800 FIND v(dout1_95) AT=1810.05n

.meas tran vdout1_96ck1800 FIND v(dout1_96) AT=1810.05n

.meas tran vdout1_97ck1800 FIND v(dout1_97) AT=1810.05n

.meas tran vdout1_98ck1800 FIND v(dout1_98) AT=1810.05n

.meas tran vdout1_99ck1800 FIND v(dout1_99) AT=1810.05n

.meas tran vdout1_100ck1800 FIND v(dout1_100) AT=1810.05n

.meas tran vdout1_101ck1800 FIND v(dout1_101) AT=1810.05n

.meas tran vdout1_102ck1800 FIND v(dout1_102) AT=1810.05n

.meas tran vdout1_103ck1800 FIND v(dout1_103) AT=1810.05n

.meas tran vdout1_104ck1800 FIND v(dout1_104) AT=1810.05n

.meas tran vdout1_105ck1800 FIND v(dout1_105) AT=1810.05n

.meas tran vdout1_106ck1800 FIND v(dout1_106) AT=1810.05n

.meas tran vdout1_107ck1800 FIND v(dout1_107) AT=1810.05n

.meas tran vdout1_108ck1800 FIND v(dout1_108) AT=1810.05n

.meas tran vdout1_109ck1800 FIND v(dout1_109) AT=1810.05n

.meas tran vdout1_110ck1800 FIND v(dout1_110) AT=1810.05n

.meas tran vdout1_111ck1800 FIND v(dout1_111) AT=1810.05n

.meas tran vdout1_112ck1800 FIND v(dout1_112) AT=1810.05n

.meas tran vdout1_113ck1800 FIND v(dout1_113) AT=1810.05n

.meas tran vdout1_114ck1800 FIND v(dout1_114) AT=1810.05n

.meas tran vdout1_115ck1800 FIND v(dout1_115) AT=1810.05n

.meas tran vdout1_116ck1800 FIND v(dout1_116) AT=1810.05n

.meas tran vdout1_117ck1800 FIND v(dout1_117) AT=1810.05n

.meas tran vdout1_118ck1800 FIND v(dout1_118) AT=1810.05n

.meas tran vdout1_119ck1800 FIND v(dout1_119) AT=1810.05n

.meas tran vdout1_120ck1800 FIND v(dout1_120) AT=1810.05n

.meas tran vdout1_121ck1800 FIND v(dout1_121) AT=1810.05n

.meas tran vdout1_122ck1800 FIND v(dout1_122) AT=1810.05n

.meas tran vdout1_123ck1800 FIND v(dout1_123) AT=1810.05n

.meas tran vdout1_124ck1800 FIND v(dout1_124) AT=1810.05n

.meas tran vdout1_125ck1800 FIND v(dout1_125) AT=1810.05n

.meas tran vdout1_126ck1800 FIND v(dout1_126) AT=1810.05n

.meas tran vdout1_127ck1800 FIND v(dout1_127) AT=1810.05n

.meas tran vdout1_128ck1800 FIND v(dout1_128) AT=1810.05n

.meas tran vdout1_129ck1800 FIND v(dout1_129) AT=1810.05n

.meas tran vdout1_130ck1800 FIND v(dout1_130) AT=1810.05n

.meas tran vdout1_131ck1800 FIND v(dout1_131) AT=1810.05n

.meas tran vdout1_132ck1800 FIND v(dout1_132) AT=1810.05n

.meas tran vdout1_133ck1800 FIND v(dout1_133) AT=1810.05n

.meas tran vdout1_134ck1800 FIND v(dout1_134) AT=1810.05n

.meas tran vdout1_0ck1880 FIND v(dout1_0) AT=1890.05n

.meas tran vdout1_1ck1880 FIND v(dout1_1) AT=1890.05n

.meas tran vdout1_2ck1880 FIND v(dout1_2) AT=1890.05n

.meas tran vdout1_3ck1880 FIND v(dout1_3) AT=1890.05n

.meas tran vdout1_4ck1880 FIND v(dout1_4) AT=1890.05n

.meas tran vdout1_5ck1880 FIND v(dout1_5) AT=1890.05n

.meas tran vdout1_6ck1880 FIND v(dout1_6) AT=1890.05n

.meas tran vdout1_7ck1880 FIND v(dout1_7) AT=1890.05n

.meas tran vdout1_8ck1880 FIND v(dout1_8) AT=1890.05n

.meas tran vdout1_9ck1880 FIND v(dout1_9) AT=1890.05n

.meas tran vdout1_10ck1880 FIND v(dout1_10) AT=1890.05n

.meas tran vdout1_11ck1880 FIND v(dout1_11) AT=1890.05n

.meas tran vdout1_12ck1880 FIND v(dout1_12) AT=1890.05n

.meas tran vdout1_13ck1880 FIND v(dout1_13) AT=1890.05n

.meas tran vdout1_14ck1880 FIND v(dout1_14) AT=1890.05n

.meas tran vdout1_15ck1880 FIND v(dout1_15) AT=1890.05n

.meas tran vdout1_16ck1880 FIND v(dout1_16) AT=1890.05n

.meas tran vdout1_17ck1880 FIND v(dout1_17) AT=1890.05n

.meas tran vdout1_18ck1880 FIND v(dout1_18) AT=1890.05n

.meas tran vdout1_19ck1880 FIND v(dout1_19) AT=1890.05n

.meas tran vdout1_20ck1880 FIND v(dout1_20) AT=1890.05n

.meas tran vdout1_21ck1880 FIND v(dout1_21) AT=1890.05n

.meas tran vdout1_22ck1880 FIND v(dout1_22) AT=1890.05n

.meas tran vdout1_23ck1880 FIND v(dout1_23) AT=1890.05n

.meas tran vdout1_24ck1880 FIND v(dout1_24) AT=1890.05n

.meas tran vdout1_25ck1880 FIND v(dout1_25) AT=1890.05n

.meas tran vdout1_26ck1880 FIND v(dout1_26) AT=1890.05n

.meas tran vdout1_27ck1880 FIND v(dout1_27) AT=1890.05n

.meas tran vdout1_28ck1880 FIND v(dout1_28) AT=1890.05n

.meas tran vdout1_29ck1880 FIND v(dout1_29) AT=1890.05n

.meas tran vdout1_30ck1880 FIND v(dout1_30) AT=1890.05n

.meas tran vdout1_31ck1880 FIND v(dout1_31) AT=1890.05n

.meas tran vdout1_32ck1880 FIND v(dout1_32) AT=1890.05n

.meas tran vdout1_33ck1880 FIND v(dout1_33) AT=1890.05n

.meas tran vdout1_34ck1880 FIND v(dout1_34) AT=1890.05n

.meas tran vdout1_35ck1880 FIND v(dout1_35) AT=1890.05n

.meas tran vdout1_36ck1880 FIND v(dout1_36) AT=1890.05n

.meas tran vdout1_37ck1880 FIND v(dout1_37) AT=1890.05n

.meas tran vdout1_38ck1880 FIND v(dout1_38) AT=1890.05n

.meas tran vdout1_39ck1880 FIND v(dout1_39) AT=1890.05n

.meas tran vdout1_40ck1880 FIND v(dout1_40) AT=1890.05n

.meas tran vdout1_41ck1880 FIND v(dout1_41) AT=1890.05n

.meas tran vdout1_42ck1880 FIND v(dout1_42) AT=1890.05n

.meas tran vdout1_43ck1880 FIND v(dout1_43) AT=1890.05n

.meas tran vdout1_44ck1880 FIND v(dout1_44) AT=1890.05n

.meas tran vdout1_45ck1880 FIND v(dout1_45) AT=1890.05n

.meas tran vdout1_46ck1880 FIND v(dout1_46) AT=1890.05n

.meas tran vdout1_47ck1880 FIND v(dout1_47) AT=1890.05n

.meas tran vdout1_48ck1880 FIND v(dout1_48) AT=1890.05n

.meas tran vdout1_49ck1880 FIND v(dout1_49) AT=1890.05n

.meas tran vdout1_50ck1880 FIND v(dout1_50) AT=1890.05n

.meas tran vdout1_51ck1880 FIND v(dout1_51) AT=1890.05n

.meas tran vdout1_52ck1880 FIND v(dout1_52) AT=1890.05n

.meas tran vdout1_53ck1880 FIND v(dout1_53) AT=1890.05n

.meas tran vdout1_54ck1880 FIND v(dout1_54) AT=1890.05n

.meas tran vdout1_55ck1880 FIND v(dout1_55) AT=1890.05n

.meas tran vdout1_56ck1880 FIND v(dout1_56) AT=1890.05n

.meas tran vdout1_57ck1880 FIND v(dout1_57) AT=1890.05n

.meas tran vdout1_58ck1880 FIND v(dout1_58) AT=1890.05n

.meas tran vdout1_59ck1880 FIND v(dout1_59) AT=1890.05n

.meas tran vdout1_60ck1880 FIND v(dout1_60) AT=1890.05n

.meas tran vdout1_61ck1880 FIND v(dout1_61) AT=1890.05n

.meas tran vdout1_62ck1880 FIND v(dout1_62) AT=1890.05n

.meas tran vdout1_63ck1880 FIND v(dout1_63) AT=1890.05n

.meas tran vdout1_64ck1880 FIND v(dout1_64) AT=1890.05n

.meas tran vdout1_65ck1880 FIND v(dout1_65) AT=1890.05n

.meas tran vdout1_66ck1880 FIND v(dout1_66) AT=1890.05n

.meas tran vdout1_67ck1880 FIND v(dout1_67) AT=1890.05n

.meas tran vdout1_68ck1880 FIND v(dout1_68) AT=1890.05n

.meas tran vdout1_69ck1880 FIND v(dout1_69) AT=1890.05n

.meas tran vdout1_70ck1880 FIND v(dout1_70) AT=1890.05n

.meas tran vdout1_71ck1880 FIND v(dout1_71) AT=1890.05n

.meas tran vdout1_72ck1880 FIND v(dout1_72) AT=1890.05n

.meas tran vdout1_73ck1880 FIND v(dout1_73) AT=1890.05n

.meas tran vdout1_74ck1880 FIND v(dout1_74) AT=1890.05n

.meas tran vdout1_75ck1880 FIND v(dout1_75) AT=1890.05n

.meas tran vdout1_76ck1880 FIND v(dout1_76) AT=1890.05n

.meas tran vdout1_77ck1880 FIND v(dout1_77) AT=1890.05n

.meas tran vdout1_78ck1880 FIND v(dout1_78) AT=1890.05n

.meas tran vdout1_79ck1880 FIND v(dout1_79) AT=1890.05n

.meas tran vdout1_80ck1880 FIND v(dout1_80) AT=1890.05n

.meas tran vdout1_81ck1880 FIND v(dout1_81) AT=1890.05n

.meas tran vdout1_82ck1880 FIND v(dout1_82) AT=1890.05n

.meas tran vdout1_83ck1880 FIND v(dout1_83) AT=1890.05n

.meas tran vdout1_84ck1880 FIND v(dout1_84) AT=1890.05n

.meas tran vdout1_85ck1880 FIND v(dout1_85) AT=1890.05n

.meas tran vdout1_86ck1880 FIND v(dout1_86) AT=1890.05n

.meas tran vdout1_87ck1880 FIND v(dout1_87) AT=1890.05n

.meas tran vdout1_88ck1880 FIND v(dout1_88) AT=1890.05n

.meas tran vdout1_89ck1880 FIND v(dout1_89) AT=1890.05n

.meas tran vdout1_90ck1880 FIND v(dout1_90) AT=1890.05n

.meas tran vdout1_91ck1880 FIND v(dout1_91) AT=1890.05n

.meas tran vdout1_92ck1880 FIND v(dout1_92) AT=1890.05n

.meas tran vdout1_93ck1880 FIND v(dout1_93) AT=1890.05n

.meas tran vdout1_94ck1880 FIND v(dout1_94) AT=1890.05n

.meas tran vdout1_95ck1880 FIND v(dout1_95) AT=1890.05n

.meas tran vdout1_96ck1880 FIND v(dout1_96) AT=1890.05n

.meas tran vdout1_97ck1880 FIND v(dout1_97) AT=1890.05n

.meas tran vdout1_98ck1880 FIND v(dout1_98) AT=1890.05n

.meas tran vdout1_99ck1880 FIND v(dout1_99) AT=1890.05n

.meas tran vdout1_100ck1880 FIND v(dout1_100) AT=1890.05n

.meas tran vdout1_101ck1880 FIND v(dout1_101) AT=1890.05n

.meas tran vdout1_102ck1880 FIND v(dout1_102) AT=1890.05n

.meas tran vdout1_103ck1880 FIND v(dout1_103) AT=1890.05n

.meas tran vdout1_104ck1880 FIND v(dout1_104) AT=1890.05n

.meas tran vdout1_105ck1880 FIND v(dout1_105) AT=1890.05n

.meas tran vdout1_106ck1880 FIND v(dout1_106) AT=1890.05n

.meas tran vdout1_107ck1880 FIND v(dout1_107) AT=1890.05n

.meas tran vdout1_108ck1880 FIND v(dout1_108) AT=1890.05n

.meas tran vdout1_109ck1880 FIND v(dout1_109) AT=1890.05n

.meas tran vdout1_110ck1880 FIND v(dout1_110) AT=1890.05n

.meas tran vdout1_111ck1880 FIND v(dout1_111) AT=1890.05n

.meas tran vdout1_112ck1880 FIND v(dout1_112) AT=1890.05n

.meas tran vdout1_113ck1880 FIND v(dout1_113) AT=1890.05n

.meas tran vdout1_114ck1880 FIND v(dout1_114) AT=1890.05n

.meas tran vdout1_115ck1880 FIND v(dout1_115) AT=1890.05n

.meas tran vdout1_116ck1880 FIND v(dout1_116) AT=1890.05n

.meas tran vdout1_117ck1880 FIND v(dout1_117) AT=1890.05n

.meas tran vdout1_118ck1880 FIND v(dout1_118) AT=1890.05n

.meas tran vdout1_119ck1880 FIND v(dout1_119) AT=1890.05n

.meas tran vdout1_120ck1880 FIND v(dout1_120) AT=1890.05n

.meas tran vdout1_121ck1880 FIND v(dout1_121) AT=1890.05n

.meas tran vdout1_122ck1880 FIND v(dout1_122) AT=1890.05n

.meas tran vdout1_123ck1880 FIND v(dout1_123) AT=1890.05n

.meas tran vdout1_124ck1880 FIND v(dout1_124) AT=1890.05n

.meas tran vdout1_125ck1880 FIND v(dout1_125) AT=1890.05n

.meas tran vdout1_126ck1880 FIND v(dout1_126) AT=1890.05n

.meas tran vdout1_127ck1880 FIND v(dout1_127) AT=1890.05n

.meas tran vdout1_128ck1880 FIND v(dout1_128) AT=1890.05n

.meas tran vdout1_129ck1880 FIND v(dout1_129) AT=1890.05n

.meas tran vdout1_130ck1880 FIND v(dout1_130) AT=1890.05n

.meas tran vdout1_131ck1880 FIND v(dout1_131) AT=1890.05n

.meas tran vdout1_132ck1880 FIND v(dout1_132) AT=1890.05n

.meas tran vdout1_133ck1880 FIND v(dout1_133) AT=1890.05n

.meas tran vdout1_134ck1880 FIND v(dout1_134) AT=1890.05n

.meas tran vdout1_0ck1890 FIND v(dout1_0) AT=1900.05n

.meas tran vdout1_1ck1890 FIND v(dout1_1) AT=1900.05n

.meas tran vdout1_2ck1890 FIND v(dout1_2) AT=1900.05n

.meas tran vdout1_3ck1890 FIND v(dout1_3) AT=1900.05n

.meas tran vdout1_4ck1890 FIND v(dout1_4) AT=1900.05n

.meas tran vdout1_5ck1890 FIND v(dout1_5) AT=1900.05n

.meas tran vdout1_6ck1890 FIND v(dout1_6) AT=1900.05n

.meas tran vdout1_7ck1890 FIND v(dout1_7) AT=1900.05n

.meas tran vdout1_8ck1890 FIND v(dout1_8) AT=1900.05n

.meas tran vdout1_9ck1890 FIND v(dout1_9) AT=1900.05n

.meas tran vdout1_10ck1890 FIND v(dout1_10) AT=1900.05n

.meas tran vdout1_11ck1890 FIND v(dout1_11) AT=1900.05n

.meas tran vdout1_12ck1890 FIND v(dout1_12) AT=1900.05n

.meas tran vdout1_13ck1890 FIND v(dout1_13) AT=1900.05n

.meas tran vdout1_14ck1890 FIND v(dout1_14) AT=1900.05n

.meas tran vdout1_15ck1890 FIND v(dout1_15) AT=1900.05n

.meas tran vdout1_16ck1890 FIND v(dout1_16) AT=1900.05n

.meas tran vdout1_17ck1890 FIND v(dout1_17) AT=1900.05n

.meas tran vdout1_18ck1890 FIND v(dout1_18) AT=1900.05n

.meas tran vdout1_19ck1890 FIND v(dout1_19) AT=1900.05n

.meas tran vdout1_20ck1890 FIND v(dout1_20) AT=1900.05n

.meas tran vdout1_21ck1890 FIND v(dout1_21) AT=1900.05n

.meas tran vdout1_22ck1890 FIND v(dout1_22) AT=1900.05n

.meas tran vdout1_23ck1890 FIND v(dout1_23) AT=1900.05n

.meas tran vdout1_24ck1890 FIND v(dout1_24) AT=1900.05n

.meas tran vdout1_25ck1890 FIND v(dout1_25) AT=1900.05n

.meas tran vdout1_26ck1890 FIND v(dout1_26) AT=1900.05n

.meas tran vdout1_27ck1890 FIND v(dout1_27) AT=1900.05n

.meas tran vdout1_28ck1890 FIND v(dout1_28) AT=1900.05n

.meas tran vdout1_29ck1890 FIND v(dout1_29) AT=1900.05n

.meas tran vdout1_30ck1890 FIND v(dout1_30) AT=1900.05n

.meas tran vdout1_31ck1890 FIND v(dout1_31) AT=1900.05n

.meas tran vdout1_32ck1890 FIND v(dout1_32) AT=1900.05n

.meas tran vdout1_33ck1890 FIND v(dout1_33) AT=1900.05n

.meas tran vdout1_34ck1890 FIND v(dout1_34) AT=1900.05n

.meas tran vdout1_35ck1890 FIND v(dout1_35) AT=1900.05n

.meas tran vdout1_36ck1890 FIND v(dout1_36) AT=1900.05n

.meas tran vdout1_37ck1890 FIND v(dout1_37) AT=1900.05n

.meas tran vdout1_38ck1890 FIND v(dout1_38) AT=1900.05n

.meas tran vdout1_39ck1890 FIND v(dout1_39) AT=1900.05n

.meas tran vdout1_40ck1890 FIND v(dout1_40) AT=1900.05n

.meas tran vdout1_41ck1890 FIND v(dout1_41) AT=1900.05n

.meas tran vdout1_42ck1890 FIND v(dout1_42) AT=1900.05n

.meas tran vdout1_43ck1890 FIND v(dout1_43) AT=1900.05n

.meas tran vdout1_44ck1890 FIND v(dout1_44) AT=1900.05n

.meas tran vdout1_45ck1890 FIND v(dout1_45) AT=1900.05n

.meas tran vdout1_46ck1890 FIND v(dout1_46) AT=1900.05n

.meas tran vdout1_47ck1890 FIND v(dout1_47) AT=1900.05n

.meas tran vdout1_48ck1890 FIND v(dout1_48) AT=1900.05n

.meas tran vdout1_49ck1890 FIND v(dout1_49) AT=1900.05n

.meas tran vdout1_50ck1890 FIND v(dout1_50) AT=1900.05n

.meas tran vdout1_51ck1890 FIND v(dout1_51) AT=1900.05n

.meas tran vdout1_52ck1890 FIND v(dout1_52) AT=1900.05n

.meas tran vdout1_53ck1890 FIND v(dout1_53) AT=1900.05n

.meas tran vdout1_54ck1890 FIND v(dout1_54) AT=1900.05n

.meas tran vdout1_55ck1890 FIND v(dout1_55) AT=1900.05n

.meas tran vdout1_56ck1890 FIND v(dout1_56) AT=1900.05n

.meas tran vdout1_57ck1890 FIND v(dout1_57) AT=1900.05n

.meas tran vdout1_58ck1890 FIND v(dout1_58) AT=1900.05n

.meas tran vdout1_59ck1890 FIND v(dout1_59) AT=1900.05n

.meas tran vdout1_60ck1890 FIND v(dout1_60) AT=1900.05n

.meas tran vdout1_61ck1890 FIND v(dout1_61) AT=1900.05n

.meas tran vdout1_62ck1890 FIND v(dout1_62) AT=1900.05n

.meas tran vdout1_63ck1890 FIND v(dout1_63) AT=1900.05n

.meas tran vdout1_64ck1890 FIND v(dout1_64) AT=1900.05n

.meas tran vdout1_65ck1890 FIND v(dout1_65) AT=1900.05n

.meas tran vdout1_66ck1890 FIND v(dout1_66) AT=1900.05n

.meas tran vdout1_67ck1890 FIND v(dout1_67) AT=1900.05n

.meas tran vdout1_68ck1890 FIND v(dout1_68) AT=1900.05n

.meas tran vdout1_69ck1890 FIND v(dout1_69) AT=1900.05n

.meas tran vdout1_70ck1890 FIND v(dout1_70) AT=1900.05n

.meas tran vdout1_71ck1890 FIND v(dout1_71) AT=1900.05n

.meas tran vdout1_72ck1890 FIND v(dout1_72) AT=1900.05n

.meas tran vdout1_73ck1890 FIND v(dout1_73) AT=1900.05n

.meas tran vdout1_74ck1890 FIND v(dout1_74) AT=1900.05n

.meas tran vdout1_75ck1890 FIND v(dout1_75) AT=1900.05n

.meas tran vdout1_76ck1890 FIND v(dout1_76) AT=1900.05n

.meas tran vdout1_77ck1890 FIND v(dout1_77) AT=1900.05n

.meas tran vdout1_78ck1890 FIND v(dout1_78) AT=1900.05n

.meas tran vdout1_79ck1890 FIND v(dout1_79) AT=1900.05n

.meas tran vdout1_80ck1890 FIND v(dout1_80) AT=1900.05n

.meas tran vdout1_81ck1890 FIND v(dout1_81) AT=1900.05n

.meas tran vdout1_82ck1890 FIND v(dout1_82) AT=1900.05n

.meas tran vdout1_83ck1890 FIND v(dout1_83) AT=1900.05n

.meas tran vdout1_84ck1890 FIND v(dout1_84) AT=1900.05n

.meas tran vdout1_85ck1890 FIND v(dout1_85) AT=1900.05n

.meas tran vdout1_86ck1890 FIND v(dout1_86) AT=1900.05n

.meas tran vdout1_87ck1890 FIND v(dout1_87) AT=1900.05n

.meas tran vdout1_88ck1890 FIND v(dout1_88) AT=1900.05n

.meas tran vdout1_89ck1890 FIND v(dout1_89) AT=1900.05n

.meas tran vdout1_90ck1890 FIND v(dout1_90) AT=1900.05n

.meas tran vdout1_91ck1890 FIND v(dout1_91) AT=1900.05n

.meas tran vdout1_92ck1890 FIND v(dout1_92) AT=1900.05n

.meas tran vdout1_93ck1890 FIND v(dout1_93) AT=1900.05n

.meas tran vdout1_94ck1890 FIND v(dout1_94) AT=1900.05n

.meas tran vdout1_95ck1890 FIND v(dout1_95) AT=1900.05n

.meas tran vdout1_96ck1890 FIND v(dout1_96) AT=1900.05n

.meas tran vdout1_97ck1890 FIND v(dout1_97) AT=1900.05n

.meas tran vdout1_98ck1890 FIND v(dout1_98) AT=1900.05n

.meas tran vdout1_99ck1890 FIND v(dout1_99) AT=1900.05n

.meas tran vdout1_100ck1890 FIND v(dout1_100) AT=1900.05n

.meas tran vdout1_101ck1890 FIND v(dout1_101) AT=1900.05n

.meas tran vdout1_102ck1890 FIND v(dout1_102) AT=1900.05n

.meas tran vdout1_103ck1890 FIND v(dout1_103) AT=1900.05n

.meas tran vdout1_104ck1890 FIND v(dout1_104) AT=1900.05n

.meas tran vdout1_105ck1890 FIND v(dout1_105) AT=1900.05n

.meas tran vdout1_106ck1890 FIND v(dout1_106) AT=1900.05n

.meas tran vdout1_107ck1890 FIND v(dout1_107) AT=1900.05n

.meas tran vdout1_108ck1890 FIND v(dout1_108) AT=1900.05n

.meas tran vdout1_109ck1890 FIND v(dout1_109) AT=1900.05n

.meas tran vdout1_110ck1890 FIND v(dout1_110) AT=1900.05n

.meas tran vdout1_111ck1890 FIND v(dout1_111) AT=1900.05n

.meas tran vdout1_112ck1890 FIND v(dout1_112) AT=1900.05n

.meas tran vdout1_113ck1890 FIND v(dout1_113) AT=1900.05n

.meas tran vdout1_114ck1890 FIND v(dout1_114) AT=1900.05n

.meas tran vdout1_115ck1890 FIND v(dout1_115) AT=1900.05n

.meas tran vdout1_116ck1890 FIND v(dout1_116) AT=1900.05n

.meas tran vdout1_117ck1890 FIND v(dout1_117) AT=1900.05n

.meas tran vdout1_118ck1890 FIND v(dout1_118) AT=1900.05n

.meas tran vdout1_119ck1890 FIND v(dout1_119) AT=1900.05n

.meas tran vdout1_120ck1890 FIND v(dout1_120) AT=1900.05n

.meas tran vdout1_121ck1890 FIND v(dout1_121) AT=1900.05n

.meas tran vdout1_122ck1890 FIND v(dout1_122) AT=1900.05n

.meas tran vdout1_123ck1890 FIND v(dout1_123) AT=1900.05n

.meas tran vdout1_124ck1890 FIND v(dout1_124) AT=1900.05n

.meas tran vdout1_125ck1890 FIND v(dout1_125) AT=1900.05n

.meas tran vdout1_126ck1890 FIND v(dout1_126) AT=1900.05n

.meas tran vdout1_127ck1890 FIND v(dout1_127) AT=1900.05n

.meas tran vdout1_128ck1890 FIND v(dout1_128) AT=1900.05n

.meas tran vdout1_129ck1890 FIND v(dout1_129) AT=1900.05n

.meas tran vdout1_130ck1890 FIND v(dout1_130) AT=1900.05n

.meas tran vdout1_131ck1890 FIND v(dout1_131) AT=1900.05n

.meas tran vdout1_132ck1890 FIND v(dout1_132) AT=1900.05n

.meas tran vdout1_133ck1890 FIND v(dout1_133) AT=1900.05n

.meas tran vdout1_134ck1890 FIND v(dout1_134) AT=1900.05n

.meas tran vdout1_0ck1980 FIND v(dout1_0) AT=1990.05n

.meas tran vdout1_1ck1980 FIND v(dout1_1) AT=1990.05n

.meas tran vdout1_2ck1980 FIND v(dout1_2) AT=1990.05n

.meas tran vdout1_3ck1980 FIND v(dout1_3) AT=1990.05n

.meas tran vdout1_4ck1980 FIND v(dout1_4) AT=1990.05n

.meas tran vdout1_5ck1980 FIND v(dout1_5) AT=1990.05n

.meas tran vdout1_6ck1980 FIND v(dout1_6) AT=1990.05n

.meas tran vdout1_7ck1980 FIND v(dout1_7) AT=1990.05n

.meas tran vdout1_8ck1980 FIND v(dout1_8) AT=1990.05n

.meas tran vdout1_9ck1980 FIND v(dout1_9) AT=1990.05n

.meas tran vdout1_10ck1980 FIND v(dout1_10) AT=1990.05n

.meas tran vdout1_11ck1980 FIND v(dout1_11) AT=1990.05n

.meas tran vdout1_12ck1980 FIND v(dout1_12) AT=1990.05n

.meas tran vdout1_13ck1980 FIND v(dout1_13) AT=1990.05n

.meas tran vdout1_14ck1980 FIND v(dout1_14) AT=1990.05n

.meas tran vdout1_15ck1980 FIND v(dout1_15) AT=1990.05n

.meas tran vdout1_16ck1980 FIND v(dout1_16) AT=1990.05n

.meas tran vdout1_17ck1980 FIND v(dout1_17) AT=1990.05n

.meas tran vdout1_18ck1980 FIND v(dout1_18) AT=1990.05n

.meas tran vdout1_19ck1980 FIND v(dout1_19) AT=1990.05n

.meas tran vdout1_20ck1980 FIND v(dout1_20) AT=1990.05n

.meas tran vdout1_21ck1980 FIND v(dout1_21) AT=1990.05n

.meas tran vdout1_22ck1980 FIND v(dout1_22) AT=1990.05n

.meas tran vdout1_23ck1980 FIND v(dout1_23) AT=1990.05n

.meas tran vdout1_24ck1980 FIND v(dout1_24) AT=1990.05n

.meas tran vdout1_25ck1980 FIND v(dout1_25) AT=1990.05n

.meas tran vdout1_26ck1980 FIND v(dout1_26) AT=1990.05n

.meas tran vdout1_27ck1980 FIND v(dout1_27) AT=1990.05n

.meas tran vdout1_28ck1980 FIND v(dout1_28) AT=1990.05n

.meas tran vdout1_29ck1980 FIND v(dout1_29) AT=1990.05n

.meas tran vdout1_30ck1980 FIND v(dout1_30) AT=1990.05n

.meas tran vdout1_31ck1980 FIND v(dout1_31) AT=1990.05n

.meas tran vdout1_32ck1980 FIND v(dout1_32) AT=1990.05n

.meas tran vdout1_33ck1980 FIND v(dout1_33) AT=1990.05n

.meas tran vdout1_34ck1980 FIND v(dout1_34) AT=1990.05n

.meas tran vdout1_35ck1980 FIND v(dout1_35) AT=1990.05n

.meas tran vdout1_36ck1980 FIND v(dout1_36) AT=1990.05n

.meas tran vdout1_37ck1980 FIND v(dout1_37) AT=1990.05n

.meas tran vdout1_38ck1980 FIND v(dout1_38) AT=1990.05n

.meas tran vdout1_39ck1980 FIND v(dout1_39) AT=1990.05n

.meas tran vdout1_40ck1980 FIND v(dout1_40) AT=1990.05n

.meas tran vdout1_41ck1980 FIND v(dout1_41) AT=1990.05n

.meas tran vdout1_42ck1980 FIND v(dout1_42) AT=1990.05n

.meas tran vdout1_43ck1980 FIND v(dout1_43) AT=1990.05n

.meas tran vdout1_44ck1980 FIND v(dout1_44) AT=1990.05n

.meas tran vdout1_45ck1980 FIND v(dout1_45) AT=1990.05n

.meas tran vdout1_46ck1980 FIND v(dout1_46) AT=1990.05n

.meas tran vdout1_47ck1980 FIND v(dout1_47) AT=1990.05n

.meas tran vdout1_48ck1980 FIND v(dout1_48) AT=1990.05n

.meas tran vdout1_49ck1980 FIND v(dout1_49) AT=1990.05n

.meas tran vdout1_50ck1980 FIND v(dout1_50) AT=1990.05n

.meas tran vdout1_51ck1980 FIND v(dout1_51) AT=1990.05n

.meas tran vdout1_52ck1980 FIND v(dout1_52) AT=1990.05n

.meas tran vdout1_53ck1980 FIND v(dout1_53) AT=1990.05n

.meas tran vdout1_54ck1980 FIND v(dout1_54) AT=1990.05n

.meas tran vdout1_55ck1980 FIND v(dout1_55) AT=1990.05n

.meas tran vdout1_56ck1980 FIND v(dout1_56) AT=1990.05n

.meas tran vdout1_57ck1980 FIND v(dout1_57) AT=1990.05n

.meas tran vdout1_58ck1980 FIND v(dout1_58) AT=1990.05n

.meas tran vdout1_59ck1980 FIND v(dout1_59) AT=1990.05n

.meas tran vdout1_60ck1980 FIND v(dout1_60) AT=1990.05n

.meas tran vdout1_61ck1980 FIND v(dout1_61) AT=1990.05n

.meas tran vdout1_62ck1980 FIND v(dout1_62) AT=1990.05n

.meas tran vdout1_63ck1980 FIND v(dout1_63) AT=1990.05n

.meas tran vdout1_64ck1980 FIND v(dout1_64) AT=1990.05n

.meas tran vdout1_65ck1980 FIND v(dout1_65) AT=1990.05n

.meas tran vdout1_66ck1980 FIND v(dout1_66) AT=1990.05n

.meas tran vdout1_67ck1980 FIND v(dout1_67) AT=1990.05n

.meas tran vdout1_68ck1980 FIND v(dout1_68) AT=1990.05n

.meas tran vdout1_69ck1980 FIND v(dout1_69) AT=1990.05n

.meas tran vdout1_70ck1980 FIND v(dout1_70) AT=1990.05n

.meas tran vdout1_71ck1980 FIND v(dout1_71) AT=1990.05n

.meas tran vdout1_72ck1980 FIND v(dout1_72) AT=1990.05n

.meas tran vdout1_73ck1980 FIND v(dout1_73) AT=1990.05n

.meas tran vdout1_74ck1980 FIND v(dout1_74) AT=1990.05n

.meas tran vdout1_75ck1980 FIND v(dout1_75) AT=1990.05n

.meas tran vdout1_76ck1980 FIND v(dout1_76) AT=1990.05n

.meas tran vdout1_77ck1980 FIND v(dout1_77) AT=1990.05n

.meas tran vdout1_78ck1980 FIND v(dout1_78) AT=1990.05n

.meas tran vdout1_79ck1980 FIND v(dout1_79) AT=1990.05n

.meas tran vdout1_80ck1980 FIND v(dout1_80) AT=1990.05n

.meas tran vdout1_81ck1980 FIND v(dout1_81) AT=1990.05n

.meas tran vdout1_82ck1980 FIND v(dout1_82) AT=1990.05n

.meas tran vdout1_83ck1980 FIND v(dout1_83) AT=1990.05n

.meas tran vdout1_84ck1980 FIND v(dout1_84) AT=1990.05n

.meas tran vdout1_85ck1980 FIND v(dout1_85) AT=1990.05n

.meas tran vdout1_86ck1980 FIND v(dout1_86) AT=1990.05n

.meas tran vdout1_87ck1980 FIND v(dout1_87) AT=1990.05n

.meas tran vdout1_88ck1980 FIND v(dout1_88) AT=1990.05n

.meas tran vdout1_89ck1980 FIND v(dout1_89) AT=1990.05n

.meas tran vdout1_90ck1980 FIND v(dout1_90) AT=1990.05n

.meas tran vdout1_91ck1980 FIND v(dout1_91) AT=1990.05n

.meas tran vdout1_92ck1980 FIND v(dout1_92) AT=1990.05n

.meas tran vdout1_93ck1980 FIND v(dout1_93) AT=1990.05n

.meas tran vdout1_94ck1980 FIND v(dout1_94) AT=1990.05n

.meas tran vdout1_95ck1980 FIND v(dout1_95) AT=1990.05n

.meas tran vdout1_96ck1980 FIND v(dout1_96) AT=1990.05n

.meas tran vdout1_97ck1980 FIND v(dout1_97) AT=1990.05n

.meas tran vdout1_98ck1980 FIND v(dout1_98) AT=1990.05n

.meas tran vdout1_99ck1980 FIND v(dout1_99) AT=1990.05n

.meas tran vdout1_100ck1980 FIND v(dout1_100) AT=1990.05n

.meas tran vdout1_101ck1980 FIND v(dout1_101) AT=1990.05n

.meas tran vdout1_102ck1980 FIND v(dout1_102) AT=1990.05n

.meas tran vdout1_103ck1980 FIND v(dout1_103) AT=1990.05n

.meas tran vdout1_104ck1980 FIND v(dout1_104) AT=1990.05n

.meas tran vdout1_105ck1980 FIND v(dout1_105) AT=1990.05n

.meas tran vdout1_106ck1980 FIND v(dout1_106) AT=1990.05n

.meas tran vdout1_107ck1980 FIND v(dout1_107) AT=1990.05n

.meas tran vdout1_108ck1980 FIND v(dout1_108) AT=1990.05n

.meas tran vdout1_109ck1980 FIND v(dout1_109) AT=1990.05n

.meas tran vdout1_110ck1980 FIND v(dout1_110) AT=1990.05n

.meas tran vdout1_111ck1980 FIND v(dout1_111) AT=1990.05n

.meas tran vdout1_112ck1980 FIND v(dout1_112) AT=1990.05n

.meas tran vdout1_113ck1980 FIND v(dout1_113) AT=1990.05n

.meas tran vdout1_114ck1980 FIND v(dout1_114) AT=1990.05n

.meas tran vdout1_115ck1980 FIND v(dout1_115) AT=1990.05n

.meas tran vdout1_116ck1980 FIND v(dout1_116) AT=1990.05n

.meas tran vdout1_117ck1980 FIND v(dout1_117) AT=1990.05n

.meas tran vdout1_118ck1980 FIND v(dout1_118) AT=1990.05n

.meas tran vdout1_119ck1980 FIND v(dout1_119) AT=1990.05n

.meas tran vdout1_120ck1980 FIND v(dout1_120) AT=1990.05n

.meas tran vdout1_121ck1980 FIND v(dout1_121) AT=1990.05n

.meas tran vdout1_122ck1980 FIND v(dout1_122) AT=1990.05n

.meas tran vdout1_123ck1980 FIND v(dout1_123) AT=1990.05n

.meas tran vdout1_124ck1980 FIND v(dout1_124) AT=1990.05n

.meas tran vdout1_125ck1980 FIND v(dout1_125) AT=1990.05n

.meas tran vdout1_126ck1980 FIND v(dout1_126) AT=1990.05n

.meas tran vdout1_127ck1980 FIND v(dout1_127) AT=1990.05n

.meas tran vdout1_128ck1980 FIND v(dout1_128) AT=1990.05n

.meas tran vdout1_129ck1980 FIND v(dout1_129) AT=1990.05n

.meas tran vdout1_130ck1980 FIND v(dout1_130) AT=1990.05n

.meas tran vdout1_131ck1980 FIND v(dout1_131) AT=1990.05n

.meas tran vdout1_132ck1980 FIND v(dout1_132) AT=1990.05n

.meas tran vdout1_133ck1980 FIND v(dout1_133) AT=1990.05n

.meas tran vdout1_134ck1980 FIND v(dout1_134) AT=1990.05n

.meas tran vdout1_0ck1990 FIND v(dout1_0) AT=2000.05n

.meas tran vdout1_1ck1990 FIND v(dout1_1) AT=2000.05n

.meas tran vdout1_2ck1990 FIND v(dout1_2) AT=2000.05n

.meas tran vdout1_3ck1990 FIND v(dout1_3) AT=2000.05n

.meas tran vdout1_4ck1990 FIND v(dout1_4) AT=2000.05n

.meas tran vdout1_5ck1990 FIND v(dout1_5) AT=2000.05n

.meas tran vdout1_6ck1990 FIND v(dout1_6) AT=2000.05n

.meas tran vdout1_7ck1990 FIND v(dout1_7) AT=2000.05n

.meas tran vdout1_8ck1990 FIND v(dout1_8) AT=2000.05n

.meas tran vdout1_9ck1990 FIND v(dout1_9) AT=2000.05n

.meas tran vdout1_10ck1990 FIND v(dout1_10) AT=2000.05n

.meas tran vdout1_11ck1990 FIND v(dout1_11) AT=2000.05n

.meas tran vdout1_12ck1990 FIND v(dout1_12) AT=2000.05n

.meas tran vdout1_13ck1990 FIND v(dout1_13) AT=2000.05n

.meas tran vdout1_14ck1990 FIND v(dout1_14) AT=2000.05n

.meas tran vdout1_15ck1990 FIND v(dout1_15) AT=2000.05n

.meas tran vdout1_16ck1990 FIND v(dout1_16) AT=2000.05n

.meas tran vdout1_17ck1990 FIND v(dout1_17) AT=2000.05n

.meas tran vdout1_18ck1990 FIND v(dout1_18) AT=2000.05n

.meas tran vdout1_19ck1990 FIND v(dout1_19) AT=2000.05n

.meas tran vdout1_20ck1990 FIND v(dout1_20) AT=2000.05n

.meas tran vdout1_21ck1990 FIND v(dout1_21) AT=2000.05n

.meas tran vdout1_22ck1990 FIND v(dout1_22) AT=2000.05n

.meas tran vdout1_23ck1990 FIND v(dout1_23) AT=2000.05n

.meas tran vdout1_24ck1990 FIND v(dout1_24) AT=2000.05n

.meas tran vdout1_25ck1990 FIND v(dout1_25) AT=2000.05n

.meas tran vdout1_26ck1990 FIND v(dout1_26) AT=2000.05n

.meas tran vdout1_27ck1990 FIND v(dout1_27) AT=2000.05n

.meas tran vdout1_28ck1990 FIND v(dout1_28) AT=2000.05n

.meas tran vdout1_29ck1990 FIND v(dout1_29) AT=2000.05n

.meas tran vdout1_30ck1990 FIND v(dout1_30) AT=2000.05n

.meas tran vdout1_31ck1990 FIND v(dout1_31) AT=2000.05n

.meas tran vdout1_32ck1990 FIND v(dout1_32) AT=2000.05n

.meas tran vdout1_33ck1990 FIND v(dout1_33) AT=2000.05n

.meas tran vdout1_34ck1990 FIND v(dout1_34) AT=2000.05n

.meas tran vdout1_35ck1990 FIND v(dout1_35) AT=2000.05n

.meas tran vdout1_36ck1990 FIND v(dout1_36) AT=2000.05n

.meas tran vdout1_37ck1990 FIND v(dout1_37) AT=2000.05n

.meas tran vdout1_38ck1990 FIND v(dout1_38) AT=2000.05n

.meas tran vdout1_39ck1990 FIND v(dout1_39) AT=2000.05n

.meas tran vdout1_40ck1990 FIND v(dout1_40) AT=2000.05n

.meas tran vdout1_41ck1990 FIND v(dout1_41) AT=2000.05n

.meas tran vdout1_42ck1990 FIND v(dout1_42) AT=2000.05n

.meas tran vdout1_43ck1990 FIND v(dout1_43) AT=2000.05n

.meas tran vdout1_44ck1990 FIND v(dout1_44) AT=2000.05n

.meas tran vdout1_45ck1990 FIND v(dout1_45) AT=2000.05n

.meas tran vdout1_46ck1990 FIND v(dout1_46) AT=2000.05n

.meas tran vdout1_47ck1990 FIND v(dout1_47) AT=2000.05n

.meas tran vdout1_48ck1990 FIND v(dout1_48) AT=2000.05n

.meas tran vdout1_49ck1990 FIND v(dout1_49) AT=2000.05n

.meas tran vdout1_50ck1990 FIND v(dout1_50) AT=2000.05n

.meas tran vdout1_51ck1990 FIND v(dout1_51) AT=2000.05n

.meas tran vdout1_52ck1990 FIND v(dout1_52) AT=2000.05n

.meas tran vdout1_53ck1990 FIND v(dout1_53) AT=2000.05n

.meas tran vdout1_54ck1990 FIND v(dout1_54) AT=2000.05n

.meas tran vdout1_55ck1990 FIND v(dout1_55) AT=2000.05n

.meas tran vdout1_56ck1990 FIND v(dout1_56) AT=2000.05n

.meas tran vdout1_57ck1990 FIND v(dout1_57) AT=2000.05n

.meas tran vdout1_58ck1990 FIND v(dout1_58) AT=2000.05n

.meas tran vdout1_59ck1990 FIND v(dout1_59) AT=2000.05n

.meas tran vdout1_60ck1990 FIND v(dout1_60) AT=2000.05n

.meas tran vdout1_61ck1990 FIND v(dout1_61) AT=2000.05n

.meas tran vdout1_62ck1990 FIND v(dout1_62) AT=2000.05n

.meas tran vdout1_63ck1990 FIND v(dout1_63) AT=2000.05n

.meas tran vdout1_64ck1990 FIND v(dout1_64) AT=2000.05n

.meas tran vdout1_65ck1990 FIND v(dout1_65) AT=2000.05n

.meas tran vdout1_66ck1990 FIND v(dout1_66) AT=2000.05n

.meas tran vdout1_67ck1990 FIND v(dout1_67) AT=2000.05n

.meas tran vdout1_68ck1990 FIND v(dout1_68) AT=2000.05n

.meas tran vdout1_69ck1990 FIND v(dout1_69) AT=2000.05n

.meas tran vdout1_70ck1990 FIND v(dout1_70) AT=2000.05n

.meas tran vdout1_71ck1990 FIND v(dout1_71) AT=2000.05n

.meas tran vdout1_72ck1990 FIND v(dout1_72) AT=2000.05n

.meas tran vdout1_73ck1990 FIND v(dout1_73) AT=2000.05n

.meas tran vdout1_74ck1990 FIND v(dout1_74) AT=2000.05n

.meas tran vdout1_75ck1990 FIND v(dout1_75) AT=2000.05n

.meas tran vdout1_76ck1990 FIND v(dout1_76) AT=2000.05n

.meas tran vdout1_77ck1990 FIND v(dout1_77) AT=2000.05n

.meas tran vdout1_78ck1990 FIND v(dout1_78) AT=2000.05n

.meas tran vdout1_79ck1990 FIND v(dout1_79) AT=2000.05n

.meas tran vdout1_80ck1990 FIND v(dout1_80) AT=2000.05n

.meas tran vdout1_81ck1990 FIND v(dout1_81) AT=2000.05n

.meas tran vdout1_82ck1990 FIND v(dout1_82) AT=2000.05n

.meas tran vdout1_83ck1990 FIND v(dout1_83) AT=2000.05n

.meas tran vdout1_84ck1990 FIND v(dout1_84) AT=2000.05n

.meas tran vdout1_85ck1990 FIND v(dout1_85) AT=2000.05n

.meas tran vdout1_86ck1990 FIND v(dout1_86) AT=2000.05n

.meas tran vdout1_87ck1990 FIND v(dout1_87) AT=2000.05n

.meas tran vdout1_88ck1990 FIND v(dout1_88) AT=2000.05n

.meas tran vdout1_89ck1990 FIND v(dout1_89) AT=2000.05n

.meas tran vdout1_90ck1990 FIND v(dout1_90) AT=2000.05n

.meas tran vdout1_91ck1990 FIND v(dout1_91) AT=2000.05n

.meas tran vdout1_92ck1990 FIND v(dout1_92) AT=2000.05n

.meas tran vdout1_93ck1990 FIND v(dout1_93) AT=2000.05n

.meas tran vdout1_94ck1990 FIND v(dout1_94) AT=2000.05n

.meas tran vdout1_95ck1990 FIND v(dout1_95) AT=2000.05n

.meas tran vdout1_96ck1990 FIND v(dout1_96) AT=2000.05n

.meas tran vdout1_97ck1990 FIND v(dout1_97) AT=2000.05n

.meas tran vdout1_98ck1990 FIND v(dout1_98) AT=2000.05n

.meas tran vdout1_99ck1990 FIND v(dout1_99) AT=2000.05n

.meas tran vdout1_100ck1990 FIND v(dout1_100) AT=2000.05n

.meas tran vdout1_101ck1990 FIND v(dout1_101) AT=2000.05n

.meas tran vdout1_102ck1990 FIND v(dout1_102) AT=2000.05n

.meas tran vdout1_103ck1990 FIND v(dout1_103) AT=2000.05n

.meas tran vdout1_104ck1990 FIND v(dout1_104) AT=2000.05n

.meas tran vdout1_105ck1990 FIND v(dout1_105) AT=2000.05n

.meas tran vdout1_106ck1990 FIND v(dout1_106) AT=2000.05n

.meas tran vdout1_107ck1990 FIND v(dout1_107) AT=2000.05n

.meas tran vdout1_108ck1990 FIND v(dout1_108) AT=2000.05n

.meas tran vdout1_109ck1990 FIND v(dout1_109) AT=2000.05n

.meas tran vdout1_110ck1990 FIND v(dout1_110) AT=2000.05n

.meas tran vdout1_111ck1990 FIND v(dout1_111) AT=2000.05n

.meas tran vdout1_112ck1990 FIND v(dout1_112) AT=2000.05n

.meas tran vdout1_113ck1990 FIND v(dout1_113) AT=2000.05n

.meas tran vdout1_114ck1990 FIND v(dout1_114) AT=2000.05n

.meas tran vdout1_115ck1990 FIND v(dout1_115) AT=2000.05n

.meas tran vdout1_116ck1990 FIND v(dout1_116) AT=2000.05n

.meas tran vdout1_117ck1990 FIND v(dout1_117) AT=2000.05n

.meas tran vdout1_118ck1990 FIND v(dout1_118) AT=2000.05n

.meas tran vdout1_119ck1990 FIND v(dout1_119) AT=2000.05n

.meas tran vdout1_120ck1990 FIND v(dout1_120) AT=2000.05n

.meas tran vdout1_121ck1990 FIND v(dout1_121) AT=2000.05n

.meas tran vdout1_122ck1990 FIND v(dout1_122) AT=2000.05n

.meas tran vdout1_123ck1990 FIND v(dout1_123) AT=2000.05n

.meas tran vdout1_124ck1990 FIND v(dout1_124) AT=2000.05n

.meas tran vdout1_125ck1990 FIND v(dout1_125) AT=2000.05n

.meas tran vdout1_126ck1990 FIND v(dout1_126) AT=2000.05n

.meas tran vdout1_127ck1990 FIND v(dout1_127) AT=2000.05n

.meas tran vdout1_128ck1990 FIND v(dout1_128) AT=2000.05n

.meas tran vdout1_129ck1990 FIND v(dout1_129) AT=2000.05n

.meas tran vdout1_130ck1990 FIND v(dout1_130) AT=2000.05n

.meas tran vdout1_131ck1990 FIND v(dout1_131) AT=2000.05n

.meas tran vdout1_132ck1990 FIND v(dout1_132) AT=2000.05n

.meas tran vdout1_133ck1990 FIND v(dout1_133) AT=2000.05n

.meas tran vdout1_134ck1990 FIND v(dout1_134) AT=2000.05n
