.meas tran vdout1_0ck40 FIND v(dout1_0) AT=50.05n

.meas tran vdout1_1ck40 FIND v(dout1_1) AT=50.05n

.meas tran vdout1_2ck40 FIND v(dout1_2) AT=50.05n

.meas tran vdout1_3ck40 FIND v(dout1_3) AT=50.05n

.meas tran vdout1_4ck40 FIND v(dout1_4) AT=50.05n

.meas tran vdout1_5ck40 FIND v(dout1_5) AT=50.05n

.meas tran vdout1_6ck40 FIND v(dout1_6) AT=50.05n

.meas tran vdout1_7ck40 FIND v(dout1_7) AT=50.05n

.meas tran vdout1_8ck40 FIND v(dout1_8) AT=50.05n

.meas tran vdout1_9ck40 FIND v(dout1_9) AT=50.05n

.meas tran vdout1_10ck40 FIND v(dout1_10) AT=50.05n

.meas tran vdout1_11ck40 FIND v(dout1_11) AT=50.05n

.meas tran vdout1_12ck40 FIND v(dout1_12) AT=50.05n

.meas tran vdout1_13ck40 FIND v(dout1_13) AT=50.05n

.meas tran vdout1_14ck40 FIND v(dout1_14) AT=50.05n

.meas tran vdout1_15ck40 FIND v(dout1_15) AT=50.05n

.meas tran vdout1_16ck40 FIND v(dout1_16) AT=50.05n

.meas tran vdout1_17ck40 FIND v(dout1_17) AT=50.05n

.meas tran vdout1_18ck40 FIND v(dout1_18) AT=50.05n

.meas tran vdout1_19ck40 FIND v(dout1_19) AT=50.05n

.meas tran vdout1_20ck40 FIND v(dout1_20) AT=50.05n

.meas tran vdout1_21ck40 FIND v(dout1_21) AT=50.05n

.meas tran vdout1_22ck40 FIND v(dout1_22) AT=50.05n

.meas tran vdout1_23ck40 FIND v(dout1_23) AT=50.05n

.meas tran vdout1_24ck40 FIND v(dout1_24) AT=50.05n

.meas tran vdout1_25ck40 FIND v(dout1_25) AT=50.05n

.meas tran vdout1_26ck40 FIND v(dout1_26) AT=50.05n

.meas tran vdout1_27ck40 FIND v(dout1_27) AT=50.05n

.meas tran vdout1_28ck40 FIND v(dout1_28) AT=50.05n

.meas tran vdout1_29ck40 FIND v(dout1_29) AT=50.05n

.meas tran vdout1_30ck40 FIND v(dout1_30) AT=50.05n

.meas tran vdout1_31ck40 FIND v(dout1_31) AT=50.05n

.meas tran vdout1_32ck40 FIND v(dout1_32) AT=50.05n

.meas tran vdout1_33ck40 FIND v(dout1_33) AT=50.05n

.meas tran vdout1_34ck40 FIND v(dout1_34) AT=50.05n

.meas tran vdout1_35ck40 FIND v(dout1_35) AT=50.05n

.meas tran vdout1_36ck40 FIND v(dout1_36) AT=50.05n

.meas tran vdout1_37ck40 FIND v(dout1_37) AT=50.05n

.meas tran vdout1_38ck40 FIND v(dout1_38) AT=50.05n

.meas tran vdout1_39ck40 FIND v(dout1_39) AT=50.05n

.meas tran vdout1_40ck40 FIND v(dout1_40) AT=50.05n

.meas tran vdout1_41ck40 FIND v(dout1_41) AT=50.05n

.meas tran vdout1_42ck40 FIND v(dout1_42) AT=50.05n

.meas tran vdout1_43ck40 FIND v(dout1_43) AT=50.05n

.meas tran vdout1_44ck40 FIND v(dout1_44) AT=50.05n

.meas tran vdout1_45ck40 FIND v(dout1_45) AT=50.05n

.meas tran vdout1_46ck40 FIND v(dout1_46) AT=50.05n

.meas tran vdout1_47ck40 FIND v(dout1_47) AT=50.05n

.meas tran vdout1_48ck40 FIND v(dout1_48) AT=50.05n

.meas tran vdout1_49ck40 FIND v(dout1_49) AT=50.05n

.meas tran vdout1_50ck40 FIND v(dout1_50) AT=50.05n

.meas tran vdout1_51ck40 FIND v(dout1_51) AT=50.05n

.meas tran vdout1_52ck40 FIND v(dout1_52) AT=50.05n

.meas tran vdout1_53ck40 FIND v(dout1_53) AT=50.05n

.meas tran vdout1_54ck40 FIND v(dout1_54) AT=50.05n

.meas tran vdout1_55ck40 FIND v(dout1_55) AT=50.05n

.meas tran vdout1_56ck40 FIND v(dout1_56) AT=50.05n

.meas tran vdout1_57ck40 FIND v(dout1_57) AT=50.05n

.meas tran vdout1_58ck40 FIND v(dout1_58) AT=50.05n

.meas tran vdout1_59ck40 FIND v(dout1_59) AT=50.05n

.meas tran vdout1_60ck40 FIND v(dout1_60) AT=50.05n

.meas tran vdout1_61ck40 FIND v(dout1_61) AT=50.05n

.meas tran vdout1_62ck40 FIND v(dout1_62) AT=50.05n

.meas tran vdout1_63ck40 FIND v(dout1_63) AT=50.05n

.meas tran vdout1_64ck40 FIND v(dout1_64) AT=50.05n

.meas tran vdout1_65ck40 FIND v(dout1_65) AT=50.05n

.meas tran vdout1_66ck40 FIND v(dout1_66) AT=50.05n

.meas tran vdout1_67ck40 FIND v(dout1_67) AT=50.05n

.meas tran vdout1_68ck40 FIND v(dout1_68) AT=50.05n

.meas tran vdout1_69ck40 FIND v(dout1_69) AT=50.05n

.meas tran vdout1_70ck40 FIND v(dout1_70) AT=50.05n

.meas tran vdout1_71ck40 FIND v(dout1_71) AT=50.05n

.meas tran vdout1_72ck40 FIND v(dout1_72) AT=50.05n

.meas tran vdout1_73ck40 FIND v(dout1_73) AT=50.05n

.meas tran vdout1_74ck40 FIND v(dout1_74) AT=50.05n

.meas tran vdout1_75ck40 FIND v(dout1_75) AT=50.05n

.meas tran vdout1_76ck40 FIND v(dout1_76) AT=50.05n

.meas tran vdout1_77ck40 FIND v(dout1_77) AT=50.05n

.meas tran vdout1_78ck40 FIND v(dout1_78) AT=50.05n

.meas tran vdout1_79ck40 FIND v(dout1_79) AT=50.05n

.meas tran vdout1_80ck40 FIND v(dout1_80) AT=50.05n

.meas tran vdout1_81ck40 FIND v(dout1_81) AT=50.05n

.meas tran vdout1_82ck40 FIND v(dout1_82) AT=50.05n

.meas tran vdout1_83ck40 FIND v(dout1_83) AT=50.05n

.meas tran vdout1_84ck40 FIND v(dout1_84) AT=50.05n

.meas tran vdout1_85ck40 FIND v(dout1_85) AT=50.05n

.meas tran vdout1_86ck40 FIND v(dout1_86) AT=50.05n

.meas tran vdout1_87ck40 FIND v(dout1_87) AT=50.05n

.meas tran vdout1_88ck40 FIND v(dout1_88) AT=50.05n

.meas tran vdout1_89ck40 FIND v(dout1_89) AT=50.05n

.meas tran vdout1_90ck40 FIND v(dout1_90) AT=50.05n

.meas tran vdout1_91ck40 FIND v(dout1_91) AT=50.05n

.meas tran vdout1_92ck40 FIND v(dout1_92) AT=50.05n

.meas tran vdout1_93ck40 FIND v(dout1_93) AT=50.05n

.meas tran vdout1_94ck40 FIND v(dout1_94) AT=50.05n

.meas tran vdout1_95ck40 FIND v(dout1_95) AT=50.05n

.meas tran vdout1_96ck40 FIND v(dout1_96) AT=50.05n

.meas tran vdout1_97ck40 FIND v(dout1_97) AT=50.05n

.meas tran vdout1_98ck40 FIND v(dout1_98) AT=50.05n

.meas tran vdout1_99ck40 FIND v(dout1_99) AT=50.05n

.meas tran vdout1_100ck40 FIND v(dout1_100) AT=50.05n

.meas tran vdout1_101ck40 FIND v(dout1_101) AT=50.05n

.meas tran vdout1_102ck40 FIND v(dout1_102) AT=50.05n

.meas tran vdout1_103ck40 FIND v(dout1_103) AT=50.05n

.meas tran vdout1_104ck40 FIND v(dout1_104) AT=50.05n

.meas tran vdout1_105ck40 FIND v(dout1_105) AT=50.05n

.meas tran vdout1_106ck40 FIND v(dout1_106) AT=50.05n

.meas tran vdout1_107ck40 FIND v(dout1_107) AT=50.05n

.meas tran vdout1_108ck40 FIND v(dout1_108) AT=50.05n

.meas tran vdout1_109ck40 FIND v(dout1_109) AT=50.05n

.meas tran vdout1_110ck40 FIND v(dout1_110) AT=50.05n

.meas tran vdout1_111ck40 FIND v(dout1_111) AT=50.05n

.meas tran vdout1_112ck40 FIND v(dout1_112) AT=50.05n

.meas tran vdout1_113ck40 FIND v(dout1_113) AT=50.05n

.meas tran vdout1_114ck40 FIND v(dout1_114) AT=50.05n

.meas tran vdout1_115ck40 FIND v(dout1_115) AT=50.05n

.meas tran vdout1_116ck40 FIND v(dout1_116) AT=50.05n

.meas tran vdout1_117ck40 FIND v(dout1_117) AT=50.05n

.meas tran vdout1_118ck40 FIND v(dout1_118) AT=50.05n

.meas tran vdout1_119ck40 FIND v(dout1_119) AT=50.05n

.meas tran vdout1_120ck40 FIND v(dout1_120) AT=50.05n

.meas tran vdout1_121ck40 FIND v(dout1_121) AT=50.05n

.meas tran vdout1_122ck40 FIND v(dout1_122) AT=50.05n

.meas tran vdout1_123ck40 FIND v(dout1_123) AT=50.05n

.meas tran vdout1_124ck40 FIND v(dout1_124) AT=50.05n

.meas tran vdout1_125ck40 FIND v(dout1_125) AT=50.05n

.meas tran vdout1_126ck40 FIND v(dout1_126) AT=50.05n

.meas tran vdout1_127ck40 FIND v(dout1_127) AT=50.05n

.meas tran vdout1_128ck40 FIND v(dout1_128) AT=50.05n

.meas tran vdout1_129ck40 FIND v(dout1_129) AT=50.05n

.meas tran vdout1_130ck40 FIND v(dout1_130) AT=50.05n

.meas tran vdout1_131ck40 FIND v(dout1_131) AT=50.05n

.meas tran vdout1_132ck40 FIND v(dout1_132) AT=50.05n

.meas tran vdout1_133ck40 FIND v(dout1_133) AT=50.05n

.meas tran vdout1_134ck40 FIND v(dout1_134) AT=50.05n

.meas tran vdout1_135ck40 FIND v(dout1_135) AT=50.05n

.meas tran vdout1_136ck40 FIND v(dout1_136) AT=50.05n

.meas tran vdout1_137ck40 FIND v(dout1_137) AT=50.05n

.meas tran vdout1_138ck40 FIND v(dout1_138) AT=50.05n

.meas tran vdout1_139ck40 FIND v(dout1_139) AT=50.05n

.meas tran vdout1_140ck40 FIND v(dout1_140) AT=50.05n

.meas tran vdout1_141ck40 FIND v(dout1_141) AT=50.05n

.meas tran vdout1_142ck40 FIND v(dout1_142) AT=50.05n

.meas tran vdout1_143ck40 FIND v(dout1_143) AT=50.05n

.meas tran vdout1_144ck40 FIND v(dout1_144) AT=50.05n

.meas tran vdout1_145ck40 FIND v(dout1_145) AT=50.05n

.meas tran vdout1_146ck40 FIND v(dout1_146) AT=50.05n

.meas tran vdout1_147ck40 FIND v(dout1_147) AT=50.05n

.meas tran vdout1_148ck40 FIND v(dout1_148) AT=50.05n

.meas tran vdout1_149ck40 FIND v(dout1_149) AT=50.05n

.meas tran vdout1_150ck40 FIND v(dout1_150) AT=50.05n

.meas tran vdout1_151ck40 FIND v(dout1_151) AT=50.05n

.meas tran vdout1_152ck40 FIND v(dout1_152) AT=50.05n

.meas tran vdout1_153ck40 FIND v(dout1_153) AT=50.05n

.meas tran vdout1_154ck40 FIND v(dout1_154) AT=50.05n

.meas tran vdout1_155ck40 FIND v(dout1_155) AT=50.05n

.meas tran vdout1_156ck40 FIND v(dout1_156) AT=50.05n

.meas tran vdout1_157ck40 FIND v(dout1_157) AT=50.05n

.meas tran vdout1_158ck40 FIND v(dout1_158) AT=50.05n

.meas tran vdout1_159ck40 FIND v(dout1_159) AT=50.05n

.meas tran vdout1_160ck40 FIND v(dout1_160) AT=50.05n

.meas tran vdout1_161ck40 FIND v(dout1_161) AT=50.05n

.meas tran vdout1_162ck40 FIND v(dout1_162) AT=50.05n

.meas tran vdout1_163ck40 FIND v(dout1_163) AT=50.05n

.meas tran vdout1_164ck40 FIND v(dout1_164) AT=50.05n

.meas tran vdout1_165ck40 FIND v(dout1_165) AT=50.05n

.meas tran vdout1_166ck40 FIND v(dout1_166) AT=50.05n

.meas tran vdout1_167ck40 FIND v(dout1_167) AT=50.05n

.meas tran vdout1_168ck40 FIND v(dout1_168) AT=50.05n

.meas tran vdout1_169ck40 FIND v(dout1_169) AT=50.05n

.meas tran vdout1_170ck40 FIND v(dout1_170) AT=50.05n

.meas tran vdout1_171ck40 FIND v(dout1_171) AT=50.05n

.meas tran vdout1_172ck40 FIND v(dout1_172) AT=50.05n

.meas tran vdout1_173ck40 FIND v(dout1_173) AT=50.05n

.meas tran vdout1_174ck40 FIND v(dout1_174) AT=50.05n

.meas tran vdout1_175ck40 FIND v(dout1_175) AT=50.05n

.meas tran vdout1_176ck40 FIND v(dout1_176) AT=50.05n

.meas tran vdout1_177ck40 FIND v(dout1_177) AT=50.05n

.meas tran vdout1_178ck40 FIND v(dout1_178) AT=50.05n

.meas tran vdout1_179ck40 FIND v(dout1_179) AT=50.05n

.meas tran vdout1_180ck40 FIND v(dout1_180) AT=50.05n

.meas tran vdout1_181ck40 FIND v(dout1_181) AT=50.05n

.meas tran vdout1_182ck40 FIND v(dout1_182) AT=50.05n

.meas tran vdout1_183ck40 FIND v(dout1_183) AT=50.05n

.meas tran vdout1_184ck40 FIND v(dout1_184) AT=50.05n

.meas tran vdout1_185ck40 FIND v(dout1_185) AT=50.05n

.meas tran vdout1_186ck40 FIND v(dout1_186) AT=50.05n

.meas tran vdout1_187ck40 FIND v(dout1_187) AT=50.05n

.meas tran vdout1_188ck40 FIND v(dout1_188) AT=50.05n

.meas tran vdout1_189ck40 FIND v(dout1_189) AT=50.05n

.meas tran vdout1_190ck40 FIND v(dout1_190) AT=50.05n

.meas tran vdout1_191ck40 FIND v(dout1_191) AT=50.05n

.meas tran vdout1_192ck40 FIND v(dout1_192) AT=50.05n

.meas tran vdout1_193ck40 FIND v(dout1_193) AT=50.05n

.meas tran vdout1_194ck40 FIND v(dout1_194) AT=50.05n

.meas tran vdout1_195ck40 FIND v(dout1_195) AT=50.05n

.meas tran vdout1_196ck40 FIND v(dout1_196) AT=50.05n

.meas tran vdout1_197ck40 FIND v(dout1_197) AT=50.05n

.meas tran vdout1_198ck40 FIND v(dout1_198) AT=50.05n

.meas tran vdout1_199ck40 FIND v(dout1_199) AT=50.05n

.meas tran vdout1_200ck40 FIND v(dout1_200) AT=50.05n

.meas tran vdout1_201ck40 FIND v(dout1_201) AT=50.05n

.meas tran vdout1_202ck40 FIND v(dout1_202) AT=50.05n

.meas tran vdout1_203ck40 FIND v(dout1_203) AT=50.05n

.meas tran vdout1_204ck40 FIND v(dout1_204) AT=50.05n

.meas tran vdout1_205ck40 FIND v(dout1_205) AT=50.05n

.meas tran vdout1_206ck40 FIND v(dout1_206) AT=50.05n

.meas tran vdout1_207ck40 FIND v(dout1_207) AT=50.05n

.meas tran vdout1_208ck40 FIND v(dout1_208) AT=50.05n

.meas tran vdout1_209ck40 FIND v(dout1_209) AT=50.05n

.meas tran vdout1_210ck40 FIND v(dout1_210) AT=50.05n

.meas tran vdout1_211ck40 FIND v(dout1_211) AT=50.05n

.meas tran vdout1_212ck40 FIND v(dout1_212) AT=50.05n

.meas tran vdout1_213ck40 FIND v(dout1_213) AT=50.05n

.meas tran vdout1_214ck40 FIND v(dout1_214) AT=50.05n

.meas tran vdout1_215ck40 FIND v(dout1_215) AT=50.05n

.meas tran vdout1_216ck40 FIND v(dout1_216) AT=50.05n

.meas tran vdout1_217ck40 FIND v(dout1_217) AT=50.05n

.meas tran vdout1_218ck40 FIND v(dout1_218) AT=50.05n

.meas tran vdout1_219ck40 FIND v(dout1_219) AT=50.05n

.meas tran vdout1_220ck40 FIND v(dout1_220) AT=50.05n

.meas tran vdout1_221ck40 FIND v(dout1_221) AT=50.05n

.meas tran vdout1_222ck40 FIND v(dout1_222) AT=50.05n

.meas tran vdout1_223ck40 FIND v(dout1_223) AT=50.05n

.meas tran vdout1_224ck40 FIND v(dout1_224) AT=50.05n

.meas tran vdout1_225ck40 FIND v(dout1_225) AT=50.05n

.meas tran vdout1_226ck40 FIND v(dout1_226) AT=50.05n

.meas tran vdout1_227ck40 FIND v(dout1_227) AT=50.05n

.meas tran vdout1_228ck40 FIND v(dout1_228) AT=50.05n

.meas tran vdout1_229ck40 FIND v(dout1_229) AT=50.05n

.meas tran vdout1_230ck40 FIND v(dout1_230) AT=50.05n

.meas tran vdout1_231ck40 FIND v(dout1_231) AT=50.05n

.meas tran vdout1_232ck40 FIND v(dout1_232) AT=50.05n

.meas tran vdout1_233ck40 FIND v(dout1_233) AT=50.05n

.meas tran vdout1_234ck40 FIND v(dout1_234) AT=50.05n

.meas tran vdout1_235ck40 FIND v(dout1_235) AT=50.05n

.meas tran vdout1_236ck40 FIND v(dout1_236) AT=50.05n

.meas tran vdout1_237ck40 FIND v(dout1_237) AT=50.05n

.meas tran vdout1_238ck40 FIND v(dout1_238) AT=50.05n

.meas tran vdout1_239ck40 FIND v(dout1_239) AT=50.05n

.meas tran vdout1_240ck40 FIND v(dout1_240) AT=50.05n

.meas tran vdout1_241ck40 FIND v(dout1_241) AT=50.05n

.meas tran vdout1_242ck40 FIND v(dout1_242) AT=50.05n

.meas tran vdout1_243ck40 FIND v(dout1_243) AT=50.05n

.meas tran vdout1_244ck40 FIND v(dout1_244) AT=50.05n

.meas tran vdout1_245ck40 FIND v(dout1_245) AT=50.05n

.meas tran vdout1_246ck40 FIND v(dout1_246) AT=50.05n

.meas tran vdout1_247ck40 FIND v(dout1_247) AT=50.05n

.meas tran vdout1_248ck40 FIND v(dout1_248) AT=50.05n

.meas tran vdout1_249ck40 FIND v(dout1_249) AT=50.05n

.meas tran vdout1_250ck40 FIND v(dout1_250) AT=50.05n

.meas tran vdout1_251ck40 FIND v(dout1_251) AT=50.05n

.meas tran vdout1_252ck40 FIND v(dout1_252) AT=50.05n

.meas tran vdout1_253ck40 FIND v(dout1_253) AT=50.05n

.meas tran vdout1_254ck40 FIND v(dout1_254) AT=50.05n

.meas tran vdout1_255ck40 FIND v(dout1_255) AT=50.05n

.meas tran vdout1_256ck40 FIND v(dout1_256) AT=50.05n

.meas tran vdout1_0ck80 FIND v(dout1_0) AT=90.05n

.meas tran vdout1_1ck80 FIND v(dout1_1) AT=90.05n

.meas tran vdout1_2ck80 FIND v(dout1_2) AT=90.05n

.meas tran vdout1_3ck80 FIND v(dout1_3) AT=90.05n

.meas tran vdout1_4ck80 FIND v(dout1_4) AT=90.05n

.meas tran vdout1_5ck80 FIND v(dout1_5) AT=90.05n

.meas tran vdout1_6ck80 FIND v(dout1_6) AT=90.05n

.meas tran vdout1_7ck80 FIND v(dout1_7) AT=90.05n

.meas tran vdout1_8ck80 FIND v(dout1_8) AT=90.05n

.meas tran vdout1_9ck80 FIND v(dout1_9) AT=90.05n

.meas tran vdout1_10ck80 FIND v(dout1_10) AT=90.05n

.meas tran vdout1_11ck80 FIND v(dout1_11) AT=90.05n

.meas tran vdout1_12ck80 FIND v(dout1_12) AT=90.05n

.meas tran vdout1_13ck80 FIND v(dout1_13) AT=90.05n

.meas tran vdout1_14ck80 FIND v(dout1_14) AT=90.05n

.meas tran vdout1_15ck80 FIND v(dout1_15) AT=90.05n

.meas tran vdout1_16ck80 FIND v(dout1_16) AT=90.05n

.meas tran vdout1_17ck80 FIND v(dout1_17) AT=90.05n

.meas tran vdout1_18ck80 FIND v(dout1_18) AT=90.05n

.meas tran vdout1_19ck80 FIND v(dout1_19) AT=90.05n

.meas tran vdout1_20ck80 FIND v(dout1_20) AT=90.05n

.meas tran vdout1_21ck80 FIND v(dout1_21) AT=90.05n

.meas tran vdout1_22ck80 FIND v(dout1_22) AT=90.05n

.meas tran vdout1_23ck80 FIND v(dout1_23) AT=90.05n

.meas tran vdout1_24ck80 FIND v(dout1_24) AT=90.05n

.meas tran vdout1_25ck80 FIND v(dout1_25) AT=90.05n

.meas tran vdout1_26ck80 FIND v(dout1_26) AT=90.05n

.meas tran vdout1_27ck80 FIND v(dout1_27) AT=90.05n

.meas tran vdout1_28ck80 FIND v(dout1_28) AT=90.05n

.meas tran vdout1_29ck80 FIND v(dout1_29) AT=90.05n

.meas tran vdout1_30ck80 FIND v(dout1_30) AT=90.05n

.meas tran vdout1_31ck80 FIND v(dout1_31) AT=90.05n

.meas tran vdout1_32ck80 FIND v(dout1_32) AT=90.05n

.meas tran vdout1_33ck80 FIND v(dout1_33) AT=90.05n

.meas tran vdout1_34ck80 FIND v(dout1_34) AT=90.05n

.meas tran vdout1_35ck80 FIND v(dout1_35) AT=90.05n

.meas tran vdout1_36ck80 FIND v(dout1_36) AT=90.05n

.meas tran vdout1_37ck80 FIND v(dout1_37) AT=90.05n

.meas tran vdout1_38ck80 FIND v(dout1_38) AT=90.05n

.meas tran vdout1_39ck80 FIND v(dout1_39) AT=90.05n

.meas tran vdout1_40ck80 FIND v(dout1_40) AT=90.05n

.meas tran vdout1_41ck80 FIND v(dout1_41) AT=90.05n

.meas tran vdout1_42ck80 FIND v(dout1_42) AT=90.05n

.meas tran vdout1_43ck80 FIND v(dout1_43) AT=90.05n

.meas tran vdout1_44ck80 FIND v(dout1_44) AT=90.05n

.meas tran vdout1_45ck80 FIND v(dout1_45) AT=90.05n

.meas tran vdout1_46ck80 FIND v(dout1_46) AT=90.05n

.meas tran vdout1_47ck80 FIND v(dout1_47) AT=90.05n

.meas tran vdout1_48ck80 FIND v(dout1_48) AT=90.05n

.meas tran vdout1_49ck80 FIND v(dout1_49) AT=90.05n

.meas tran vdout1_50ck80 FIND v(dout1_50) AT=90.05n

.meas tran vdout1_51ck80 FIND v(dout1_51) AT=90.05n

.meas tran vdout1_52ck80 FIND v(dout1_52) AT=90.05n

.meas tran vdout1_53ck80 FIND v(dout1_53) AT=90.05n

.meas tran vdout1_54ck80 FIND v(dout1_54) AT=90.05n

.meas tran vdout1_55ck80 FIND v(dout1_55) AT=90.05n

.meas tran vdout1_56ck80 FIND v(dout1_56) AT=90.05n

.meas tran vdout1_57ck80 FIND v(dout1_57) AT=90.05n

.meas tran vdout1_58ck80 FIND v(dout1_58) AT=90.05n

.meas tran vdout1_59ck80 FIND v(dout1_59) AT=90.05n

.meas tran vdout1_60ck80 FIND v(dout1_60) AT=90.05n

.meas tran vdout1_61ck80 FIND v(dout1_61) AT=90.05n

.meas tran vdout1_62ck80 FIND v(dout1_62) AT=90.05n

.meas tran vdout1_63ck80 FIND v(dout1_63) AT=90.05n

.meas tran vdout1_64ck80 FIND v(dout1_64) AT=90.05n

.meas tran vdout1_65ck80 FIND v(dout1_65) AT=90.05n

.meas tran vdout1_66ck80 FIND v(dout1_66) AT=90.05n

.meas tran vdout1_67ck80 FIND v(dout1_67) AT=90.05n

.meas tran vdout1_68ck80 FIND v(dout1_68) AT=90.05n

.meas tran vdout1_69ck80 FIND v(dout1_69) AT=90.05n

.meas tran vdout1_70ck80 FIND v(dout1_70) AT=90.05n

.meas tran vdout1_71ck80 FIND v(dout1_71) AT=90.05n

.meas tran vdout1_72ck80 FIND v(dout1_72) AT=90.05n

.meas tran vdout1_73ck80 FIND v(dout1_73) AT=90.05n

.meas tran vdout1_74ck80 FIND v(dout1_74) AT=90.05n

.meas tran vdout1_75ck80 FIND v(dout1_75) AT=90.05n

.meas tran vdout1_76ck80 FIND v(dout1_76) AT=90.05n

.meas tran vdout1_77ck80 FIND v(dout1_77) AT=90.05n

.meas tran vdout1_78ck80 FIND v(dout1_78) AT=90.05n

.meas tran vdout1_79ck80 FIND v(dout1_79) AT=90.05n

.meas tran vdout1_80ck80 FIND v(dout1_80) AT=90.05n

.meas tran vdout1_81ck80 FIND v(dout1_81) AT=90.05n

.meas tran vdout1_82ck80 FIND v(dout1_82) AT=90.05n

.meas tran vdout1_83ck80 FIND v(dout1_83) AT=90.05n

.meas tran vdout1_84ck80 FIND v(dout1_84) AT=90.05n

.meas tran vdout1_85ck80 FIND v(dout1_85) AT=90.05n

.meas tran vdout1_86ck80 FIND v(dout1_86) AT=90.05n

.meas tran vdout1_87ck80 FIND v(dout1_87) AT=90.05n

.meas tran vdout1_88ck80 FIND v(dout1_88) AT=90.05n

.meas tran vdout1_89ck80 FIND v(dout1_89) AT=90.05n

.meas tran vdout1_90ck80 FIND v(dout1_90) AT=90.05n

.meas tran vdout1_91ck80 FIND v(dout1_91) AT=90.05n

.meas tran vdout1_92ck80 FIND v(dout1_92) AT=90.05n

.meas tran vdout1_93ck80 FIND v(dout1_93) AT=90.05n

.meas tran vdout1_94ck80 FIND v(dout1_94) AT=90.05n

.meas tran vdout1_95ck80 FIND v(dout1_95) AT=90.05n

.meas tran vdout1_96ck80 FIND v(dout1_96) AT=90.05n

.meas tran vdout1_97ck80 FIND v(dout1_97) AT=90.05n

.meas tran vdout1_98ck80 FIND v(dout1_98) AT=90.05n

.meas tran vdout1_99ck80 FIND v(dout1_99) AT=90.05n

.meas tran vdout1_100ck80 FIND v(dout1_100) AT=90.05n

.meas tran vdout1_101ck80 FIND v(dout1_101) AT=90.05n

.meas tran vdout1_102ck80 FIND v(dout1_102) AT=90.05n

.meas tran vdout1_103ck80 FIND v(dout1_103) AT=90.05n

.meas tran vdout1_104ck80 FIND v(dout1_104) AT=90.05n

.meas tran vdout1_105ck80 FIND v(dout1_105) AT=90.05n

.meas tran vdout1_106ck80 FIND v(dout1_106) AT=90.05n

.meas tran vdout1_107ck80 FIND v(dout1_107) AT=90.05n

.meas tran vdout1_108ck80 FIND v(dout1_108) AT=90.05n

.meas tran vdout1_109ck80 FIND v(dout1_109) AT=90.05n

.meas tran vdout1_110ck80 FIND v(dout1_110) AT=90.05n

.meas tran vdout1_111ck80 FIND v(dout1_111) AT=90.05n

.meas tran vdout1_112ck80 FIND v(dout1_112) AT=90.05n

.meas tran vdout1_113ck80 FIND v(dout1_113) AT=90.05n

.meas tran vdout1_114ck80 FIND v(dout1_114) AT=90.05n

.meas tran vdout1_115ck80 FIND v(dout1_115) AT=90.05n

.meas tran vdout1_116ck80 FIND v(dout1_116) AT=90.05n

.meas tran vdout1_117ck80 FIND v(dout1_117) AT=90.05n

.meas tran vdout1_118ck80 FIND v(dout1_118) AT=90.05n

.meas tran vdout1_119ck80 FIND v(dout1_119) AT=90.05n

.meas tran vdout1_120ck80 FIND v(dout1_120) AT=90.05n

.meas tran vdout1_121ck80 FIND v(dout1_121) AT=90.05n

.meas tran vdout1_122ck80 FIND v(dout1_122) AT=90.05n

.meas tran vdout1_123ck80 FIND v(dout1_123) AT=90.05n

.meas tran vdout1_124ck80 FIND v(dout1_124) AT=90.05n

.meas tran vdout1_125ck80 FIND v(dout1_125) AT=90.05n

.meas tran vdout1_126ck80 FIND v(dout1_126) AT=90.05n

.meas tran vdout1_127ck80 FIND v(dout1_127) AT=90.05n

.meas tran vdout1_128ck80 FIND v(dout1_128) AT=90.05n

.meas tran vdout1_129ck80 FIND v(dout1_129) AT=90.05n

.meas tran vdout1_130ck80 FIND v(dout1_130) AT=90.05n

.meas tran vdout1_131ck80 FIND v(dout1_131) AT=90.05n

.meas tran vdout1_132ck80 FIND v(dout1_132) AT=90.05n

.meas tran vdout1_133ck80 FIND v(dout1_133) AT=90.05n

.meas tran vdout1_134ck80 FIND v(dout1_134) AT=90.05n

.meas tran vdout1_135ck80 FIND v(dout1_135) AT=90.05n

.meas tran vdout1_136ck80 FIND v(dout1_136) AT=90.05n

.meas tran vdout1_137ck80 FIND v(dout1_137) AT=90.05n

.meas tran vdout1_138ck80 FIND v(dout1_138) AT=90.05n

.meas tran vdout1_139ck80 FIND v(dout1_139) AT=90.05n

.meas tran vdout1_140ck80 FIND v(dout1_140) AT=90.05n

.meas tran vdout1_141ck80 FIND v(dout1_141) AT=90.05n

.meas tran vdout1_142ck80 FIND v(dout1_142) AT=90.05n

.meas tran vdout1_143ck80 FIND v(dout1_143) AT=90.05n

.meas tran vdout1_144ck80 FIND v(dout1_144) AT=90.05n

.meas tran vdout1_145ck80 FIND v(dout1_145) AT=90.05n

.meas tran vdout1_146ck80 FIND v(dout1_146) AT=90.05n

.meas tran vdout1_147ck80 FIND v(dout1_147) AT=90.05n

.meas tran vdout1_148ck80 FIND v(dout1_148) AT=90.05n

.meas tran vdout1_149ck80 FIND v(dout1_149) AT=90.05n

.meas tran vdout1_150ck80 FIND v(dout1_150) AT=90.05n

.meas tran vdout1_151ck80 FIND v(dout1_151) AT=90.05n

.meas tran vdout1_152ck80 FIND v(dout1_152) AT=90.05n

.meas tran vdout1_153ck80 FIND v(dout1_153) AT=90.05n

.meas tran vdout1_154ck80 FIND v(dout1_154) AT=90.05n

.meas tran vdout1_155ck80 FIND v(dout1_155) AT=90.05n

.meas tran vdout1_156ck80 FIND v(dout1_156) AT=90.05n

.meas tran vdout1_157ck80 FIND v(dout1_157) AT=90.05n

.meas tran vdout1_158ck80 FIND v(dout1_158) AT=90.05n

.meas tran vdout1_159ck80 FIND v(dout1_159) AT=90.05n

.meas tran vdout1_160ck80 FIND v(dout1_160) AT=90.05n

.meas tran vdout1_161ck80 FIND v(dout1_161) AT=90.05n

.meas tran vdout1_162ck80 FIND v(dout1_162) AT=90.05n

.meas tran vdout1_163ck80 FIND v(dout1_163) AT=90.05n

.meas tran vdout1_164ck80 FIND v(dout1_164) AT=90.05n

.meas tran vdout1_165ck80 FIND v(dout1_165) AT=90.05n

.meas tran vdout1_166ck80 FIND v(dout1_166) AT=90.05n

.meas tran vdout1_167ck80 FIND v(dout1_167) AT=90.05n

.meas tran vdout1_168ck80 FIND v(dout1_168) AT=90.05n

.meas tran vdout1_169ck80 FIND v(dout1_169) AT=90.05n

.meas tran vdout1_170ck80 FIND v(dout1_170) AT=90.05n

.meas tran vdout1_171ck80 FIND v(dout1_171) AT=90.05n

.meas tran vdout1_172ck80 FIND v(dout1_172) AT=90.05n

.meas tran vdout1_173ck80 FIND v(dout1_173) AT=90.05n

.meas tran vdout1_174ck80 FIND v(dout1_174) AT=90.05n

.meas tran vdout1_175ck80 FIND v(dout1_175) AT=90.05n

.meas tran vdout1_176ck80 FIND v(dout1_176) AT=90.05n

.meas tran vdout1_177ck80 FIND v(dout1_177) AT=90.05n

.meas tran vdout1_178ck80 FIND v(dout1_178) AT=90.05n

.meas tran vdout1_179ck80 FIND v(dout1_179) AT=90.05n

.meas tran vdout1_180ck80 FIND v(dout1_180) AT=90.05n

.meas tran vdout1_181ck80 FIND v(dout1_181) AT=90.05n

.meas tran vdout1_182ck80 FIND v(dout1_182) AT=90.05n

.meas tran vdout1_183ck80 FIND v(dout1_183) AT=90.05n

.meas tran vdout1_184ck80 FIND v(dout1_184) AT=90.05n

.meas tran vdout1_185ck80 FIND v(dout1_185) AT=90.05n

.meas tran vdout1_186ck80 FIND v(dout1_186) AT=90.05n

.meas tran vdout1_187ck80 FIND v(dout1_187) AT=90.05n

.meas tran vdout1_188ck80 FIND v(dout1_188) AT=90.05n

.meas tran vdout1_189ck80 FIND v(dout1_189) AT=90.05n

.meas tran vdout1_190ck80 FIND v(dout1_190) AT=90.05n

.meas tran vdout1_191ck80 FIND v(dout1_191) AT=90.05n

.meas tran vdout1_192ck80 FIND v(dout1_192) AT=90.05n

.meas tran vdout1_193ck80 FIND v(dout1_193) AT=90.05n

.meas tran vdout1_194ck80 FIND v(dout1_194) AT=90.05n

.meas tran vdout1_195ck80 FIND v(dout1_195) AT=90.05n

.meas tran vdout1_196ck80 FIND v(dout1_196) AT=90.05n

.meas tran vdout1_197ck80 FIND v(dout1_197) AT=90.05n

.meas tran vdout1_198ck80 FIND v(dout1_198) AT=90.05n

.meas tran vdout1_199ck80 FIND v(dout1_199) AT=90.05n

.meas tran vdout1_200ck80 FIND v(dout1_200) AT=90.05n

.meas tran vdout1_201ck80 FIND v(dout1_201) AT=90.05n

.meas tran vdout1_202ck80 FIND v(dout1_202) AT=90.05n

.meas tran vdout1_203ck80 FIND v(dout1_203) AT=90.05n

.meas tran vdout1_204ck80 FIND v(dout1_204) AT=90.05n

.meas tran vdout1_205ck80 FIND v(dout1_205) AT=90.05n

.meas tran vdout1_206ck80 FIND v(dout1_206) AT=90.05n

.meas tran vdout1_207ck80 FIND v(dout1_207) AT=90.05n

.meas tran vdout1_208ck80 FIND v(dout1_208) AT=90.05n

.meas tran vdout1_209ck80 FIND v(dout1_209) AT=90.05n

.meas tran vdout1_210ck80 FIND v(dout1_210) AT=90.05n

.meas tran vdout1_211ck80 FIND v(dout1_211) AT=90.05n

.meas tran vdout1_212ck80 FIND v(dout1_212) AT=90.05n

.meas tran vdout1_213ck80 FIND v(dout1_213) AT=90.05n

.meas tran vdout1_214ck80 FIND v(dout1_214) AT=90.05n

.meas tran vdout1_215ck80 FIND v(dout1_215) AT=90.05n

.meas tran vdout1_216ck80 FIND v(dout1_216) AT=90.05n

.meas tran vdout1_217ck80 FIND v(dout1_217) AT=90.05n

.meas tran vdout1_218ck80 FIND v(dout1_218) AT=90.05n

.meas tran vdout1_219ck80 FIND v(dout1_219) AT=90.05n

.meas tran vdout1_220ck80 FIND v(dout1_220) AT=90.05n

.meas tran vdout1_221ck80 FIND v(dout1_221) AT=90.05n

.meas tran vdout1_222ck80 FIND v(dout1_222) AT=90.05n

.meas tran vdout1_223ck80 FIND v(dout1_223) AT=90.05n

.meas tran vdout1_224ck80 FIND v(dout1_224) AT=90.05n

.meas tran vdout1_225ck80 FIND v(dout1_225) AT=90.05n

.meas tran vdout1_226ck80 FIND v(dout1_226) AT=90.05n

.meas tran vdout1_227ck80 FIND v(dout1_227) AT=90.05n

.meas tran vdout1_228ck80 FIND v(dout1_228) AT=90.05n

.meas tran vdout1_229ck80 FIND v(dout1_229) AT=90.05n

.meas tran vdout1_230ck80 FIND v(dout1_230) AT=90.05n

.meas tran vdout1_231ck80 FIND v(dout1_231) AT=90.05n

.meas tran vdout1_232ck80 FIND v(dout1_232) AT=90.05n

.meas tran vdout1_233ck80 FIND v(dout1_233) AT=90.05n

.meas tran vdout1_234ck80 FIND v(dout1_234) AT=90.05n

.meas tran vdout1_235ck80 FIND v(dout1_235) AT=90.05n

.meas tran vdout1_236ck80 FIND v(dout1_236) AT=90.05n

.meas tran vdout1_237ck80 FIND v(dout1_237) AT=90.05n

.meas tran vdout1_238ck80 FIND v(dout1_238) AT=90.05n

.meas tran vdout1_239ck80 FIND v(dout1_239) AT=90.05n

.meas tran vdout1_240ck80 FIND v(dout1_240) AT=90.05n

.meas tran vdout1_241ck80 FIND v(dout1_241) AT=90.05n

.meas tran vdout1_242ck80 FIND v(dout1_242) AT=90.05n

.meas tran vdout1_243ck80 FIND v(dout1_243) AT=90.05n

.meas tran vdout1_244ck80 FIND v(dout1_244) AT=90.05n

.meas tran vdout1_245ck80 FIND v(dout1_245) AT=90.05n

.meas tran vdout1_246ck80 FIND v(dout1_246) AT=90.05n

.meas tran vdout1_247ck80 FIND v(dout1_247) AT=90.05n

.meas tran vdout1_248ck80 FIND v(dout1_248) AT=90.05n

.meas tran vdout1_249ck80 FIND v(dout1_249) AT=90.05n

.meas tran vdout1_250ck80 FIND v(dout1_250) AT=90.05n

.meas tran vdout1_251ck80 FIND v(dout1_251) AT=90.05n

.meas tran vdout1_252ck80 FIND v(dout1_252) AT=90.05n

.meas tran vdout1_253ck80 FIND v(dout1_253) AT=90.05n

.meas tran vdout1_254ck80 FIND v(dout1_254) AT=90.05n

.meas tran vdout1_255ck80 FIND v(dout1_255) AT=90.05n

.meas tran vdout1_256ck80 FIND v(dout1_256) AT=90.05n

.meas tran vdout1_0ck100 FIND v(dout1_0) AT=110.05n

.meas tran vdout1_1ck100 FIND v(dout1_1) AT=110.05n

.meas tran vdout1_2ck100 FIND v(dout1_2) AT=110.05n

.meas tran vdout1_3ck100 FIND v(dout1_3) AT=110.05n

.meas tran vdout1_4ck100 FIND v(dout1_4) AT=110.05n

.meas tran vdout1_5ck100 FIND v(dout1_5) AT=110.05n

.meas tran vdout1_6ck100 FIND v(dout1_6) AT=110.05n

.meas tran vdout1_7ck100 FIND v(dout1_7) AT=110.05n

.meas tran vdout1_8ck100 FIND v(dout1_8) AT=110.05n

.meas tran vdout1_9ck100 FIND v(dout1_9) AT=110.05n

.meas tran vdout1_10ck100 FIND v(dout1_10) AT=110.05n

.meas tran vdout1_11ck100 FIND v(dout1_11) AT=110.05n

.meas tran vdout1_12ck100 FIND v(dout1_12) AT=110.05n

.meas tran vdout1_13ck100 FIND v(dout1_13) AT=110.05n

.meas tran vdout1_14ck100 FIND v(dout1_14) AT=110.05n

.meas tran vdout1_15ck100 FIND v(dout1_15) AT=110.05n

.meas tran vdout1_16ck100 FIND v(dout1_16) AT=110.05n

.meas tran vdout1_17ck100 FIND v(dout1_17) AT=110.05n

.meas tran vdout1_18ck100 FIND v(dout1_18) AT=110.05n

.meas tran vdout1_19ck100 FIND v(dout1_19) AT=110.05n

.meas tran vdout1_20ck100 FIND v(dout1_20) AT=110.05n

.meas tran vdout1_21ck100 FIND v(dout1_21) AT=110.05n

.meas tran vdout1_22ck100 FIND v(dout1_22) AT=110.05n

.meas tran vdout1_23ck100 FIND v(dout1_23) AT=110.05n

.meas tran vdout1_24ck100 FIND v(dout1_24) AT=110.05n

.meas tran vdout1_25ck100 FIND v(dout1_25) AT=110.05n

.meas tran vdout1_26ck100 FIND v(dout1_26) AT=110.05n

.meas tran vdout1_27ck100 FIND v(dout1_27) AT=110.05n

.meas tran vdout1_28ck100 FIND v(dout1_28) AT=110.05n

.meas tran vdout1_29ck100 FIND v(dout1_29) AT=110.05n

.meas tran vdout1_30ck100 FIND v(dout1_30) AT=110.05n

.meas tran vdout1_31ck100 FIND v(dout1_31) AT=110.05n

.meas tran vdout1_32ck100 FIND v(dout1_32) AT=110.05n

.meas tran vdout1_33ck100 FIND v(dout1_33) AT=110.05n

.meas tran vdout1_34ck100 FIND v(dout1_34) AT=110.05n

.meas tran vdout1_35ck100 FIND v(dout1_35) AT=110.05n

.meas tran vdout1_36ck100 FIND v(dout1_36) AT=110.05n

.meas tran vdout1_37ck100 FIND v(dout1_37) AT=110.05n

.meas tran vdout1_38ck100 FIND v(dout1_38) AT=110.05n

.meas tran vdout1_39ck100 FIND v(dout1_39) AT=110.05n

.meas tran vdout1_40ck100 FIND v(dout1_40) AT=110.05n

.meas tran vdout1_41ck100 FIND v(dout1_41) AT=110.05n

.meas tran vdout1_42ck100 FIND v(dout1_42) AT=110.05n

.meas tran vdout1_43ck100 FIND v(dout1_43) AT=110.05n

.meas tran vdout1_44ck100 FIND v(dout1_44) AT=110.05n

.meas tran vdout1_45ck100 FIND v(dout1_45) AT=110.05n

.meas tran vdout1_46ck100 FIND v(dout1_46) AT=110.05n

.meas tran vdout1_47ck100 FIND v(dout1_47) AT=110.05n

.meas tran vdout1_48ck100 FIND v(dout1_48) AT=110.05n

.meas tran vdout1_49ck100 FIND v(dout1_49) AT=110.05n

.meas tran vdout1_50ck100 FIND v(dout1_50) AT=110.05n

.meas tran vdout1_51ck100 FIND v(dout1_51) AT=110.05n

.meas tran vdout1_52ck100 FIND v(dout1_52) AT=110.05n

.meas tran vdout1_53ck100 FIND v(dout1_53) AT=110.05n

.meas tran vdout1_54ck100 FIND v(dout1_54) AT=110.05n

.meas tran vdout1_55ck100 FIND v(dout1_55) AT=110.05n

.meas tran vdout1_56ck100 FIND v(dout1_56) AT=110.05n

.meas tran vdout1_57ck100 FIND v(dout1_57) AT=110.05n

.meas tran vdout1_58ck100 FIND v(dout1_58) AT=110.05n

.meas tran vdout1_59ck100 FIND v(dout1_59) AT=110.05n

.meas tran vdout1_60ck100 FIND v(dout1_60) AT=110.05n

.meas tran vdout1_61ck100 FIND v(dout1_61) AT=110.05n

.meas tran vdout1_62ck100 FIND v(dout1_62) AT=110.05n

.meas tran vdout1_63ck100 FIND v(dout1_63) AT=110.05n

.meas tran vdout1_64ck100 FIND v(dout1_64) AT=110.05n

.meas tran vdout1_65ck100 FIND v(dout1_65) AT=110.05n

.meas tran vdout1_66ck100 FIND v(dout1_66) AT=110.05n

.meas tran vdout1_67ck100 FIND v(dout1_67) AT=110.05n

.meas tran vdout1_68ck100 FIND v(dout1_68) AT=110.05n

.meas tran vdout1_69ck100 FIND v(dout1_69) AT=110.05n

.meas tran vdout1_70ck100 FIND v(dout1_70) AT=110.05n

.meas tran vdout1_71ck100 FIND v(dout1_71) AT=110.05n

.meas tran vdout1_72ck100 FIND v(dout1_72) AT=110.05n

.meas tran vdout1_73ck100 FIND v(dout1_73) AT=110.05n

.meas tran vdout1_74ck100 FIND v(dout1_74) AT=110.05n

.meas tran vdout1_75ck100 FIND v(dout1_75) AT=110.05n

.meas tran vdout1_76ck100 FIND v(dout1_76) AT=110.05n

.meas tran vdout1_77ck100 FIND v(dout1_77) AT=110.05n

.meas tran vdout1_78ck100 FIND v(dout1_78) AT=110.05n

.meas tran vdout1_79ck100 FIND v(dout1_79) AT=110.05n

.meas tran vdout1_80ck100 FIND v(dout1_80) AT=110.05n

.meas tran vdout1_81ck100 FIND v(dout1_81) AT=110.05n

.meas tran vdout1_82ck100 FIND v(dout1_82) AT=110.05n

.meas tran vdout1_83ck100 FIND v(dout1_83) AT=110.05n

.meas tran vdout1_84ck100 FIND v(dout1_84) AT=110.05n

.meas tran vdout1_85ck100 FIND v(dout1_85) AT=110.05n

.meas tran vdout1_86ck100 FIND v(dout1_86) AT=110.05n

.meas tran vdout1_87ck100 FIND v(dout1_87) AT=110.05n

.meas tran vdout1_88ck100 FIND v(dout1_88) AT=110.05n

.meas tran vdout1_89ck100 FIND v(dout1_89) AT=110.05n

.meas tran vdout1_90ck100 FIND v(dout1_90) AT=110.05n

.meas tran vdout1_91ck100 FIND v(dout1_91) AT=110.05n

.meas tran vdout1_92ck100 FIND v(dout1_92) AT=110.05n

.meas tran vdout1_93ck100 FIND v(dout1_93) AT=110.05n

.meas tran vdout1_94ck100 FIND v(dout1_94) AT=110.05n

.meas tran vdout1_95ck100 FIND v(dout1_95) AT=110.05n

.meas tran vdout1_96ck100 FIND v(dout1_96) AT=110.05n

.meas tran vdout1_97ck100 FIND v(dout1_97) AT=110.05n

.meas tran vdout1_98ck100 FIND v(dout1_98) AT=110.05n

.meas tran vdout1_99ck100 FIND v(dout1_99) AT=110.05n

.meas tran vdout1_100ck100 FIND v(dout1_100) AT=110.05n

.meas tran vdout1_101ck100 FIND v(dout1_101) AT=110.05n

.meas tran vdout1_102ck100 FIND v(dout1_102) AT=110.05n

.meas tran vdout1_103ck100 FIND v(dout1_103) AT=110.05n

.meas tran vdout1_104ck100 FIND v(dout1_104) AT=110.05n

.meas tran vdout1_105ck100 FIND v(dout1_105) AT=110.05n

.meas tran vdout1_106ck100 FIND v(dout1_106) AT=110.05n

.meas tran vdout1_107ck100 FIND v(dout1_107) AT=110.05n

.meas tran vdout1_108ck100 FIND v(dout1_108) AT=110.05n

.meas tran vdout1_109ck100 FIND v(dout1_109) AT=110.05n

.meas tran vdout1_110ck100 FIND v(dout1_110) AT=110.05n

.meas tran vdout1_111ck100 FIND v(dout1_111) AT=110.05n

.meas tran vdout1_112ck100 FIND v(dout1_112) AT=110.05n

.meas tran vdout1_113ck100 FIND v(dout1_113) AT=110.05n

.meas tran vdout1_114ck100 FIND v(dout1_114) AT=110.05n

.meas tran vdout1_115ck100 FIND v(dout1_115) AT=110.05n

.meas tran vdout1_116ck100 FIND v(dout1_116) AT=110.05n

.meas tran vdout1_117ck100 FIND v(dout1_117) AT=110.05n

.meas tran vdout1_118ck100 FIND v(dout1_118) AT=110.05n

.meas tran vdout1_119ck100 FIND v(dout1_119) AT=110.05n

.meas tran vdout1_120ck100 FIND v(dout1_120) AT=110.05n

.meas tran vdout1_121ck100 FIND v(dout1_121) AT=110.05n

.meas tran vdout1_122ck100 FIND v(dout1_122) AT=110.05n

.meas tran vdout1_123ck100 FIND v(dout1_123) AT=110.05n

.meas tran vdout1_124ck100 FIND v(dout1_124) AT=110.05n

.meas tran vdout1_125ck100 FIND v(dout1_125) AT=110.05n

.meas tran vdout1_126ck100 FIND v(dout1_126) AT=110.05n

.meas tran vdout1_127ck100 FIND v(dout1_127) AT=110.05n

.meas tran vdout1_128ck100 FIND v(dout1_128) AT=110.05n

.meas tran vdout1_129ck100 FIND v(dout1_129) AT=110.05n

.meas tran vdout1_130ck100 FIND v(dout1_130) AT=110.05n

.meas tran vdout1_131ck100 FIND v(dout1_131) AT=110.05n

.meas tran vdout1_132ck100 FIND v(dout1_132) AT=110.05n

.meas tran vdout1_133ck100 FIND v(dout1_133) AT=110.05n

.meas tran vdout1_134ck100 FIND v(dout1_134) AT=110.05n

.meas tran vdout1_135ck100 FIND v(dout1_135) AT=110.05n

.meas tran vdout1_136ck100 FIND v(dout1_136) AT=110.05n

.meas tran vdout1_137ck100 FIND v(dout1_137) AT=110.05n

.meas tran vdout1_138ck100 FIND v(dout1_138) AT=110.05n

.meas tran vdout1_139ck100 FIND v(dout1_139) AT=110.05n

.meas tran vdout1_140ck100 FIND v(dout1_140) AT=110.05n

.meas tran vdout1_141ck100 FIND v(dout1_141) AT=110.05n

.meas tran vdout1_142ck100 FIND v(dout1_142) AT=110.05n

.meas tran vdout1_143ck100 FIND v(dout1_143) AT=110.05n

.meas tran vdout1_144ck100 FIND v(dout1_144) AT=110.05n

.meas tran vdout1_145ck100 FIND v(dout1_145) AT=110.05n

.meas tran vdout1_146ck100 FIND v(dout1_146) AT=110.05n

.meas tran vdout1_147ck100 FIND v(dout1_147) AT=110.05n

.meas tran vdout1_148ck100 FIND v(dout1_148) AT=110.05n

.meas tran vdout1_149ck100 FIND v(dout1_149) AT=110.05n

.meas tran vdout1_150ck100 FIND v(dout1_150) AT=110.05n

.meas tran vdout1_151ck100 FIND v(dout1_151) AT=110.05n

.meas tran vdout1_152ck100 FIND v(dout1_152) AT=110.05n

.meas tran vdout1_153ck100 FIND v(dout1_153) AT=110.05n

.meas tran vdout1_154ck100 FIND v(dout1_154) AT=110.05n

.meas tran vdout1_155ck100 FIND v(dout1_155) AT=110.05n

.meas tran vdout1_156ck100 FIND v(dout1_156) AT=110.05n

.meas tran vdout1_157ck100 FIND v(dout1_157) AT=110.05n

.meas tran vdout1_158ck100 FIND v(dout1_158) AT=110.05n

.meas tran vdout1_159ck100 FIND v(dout1_159) AT=110.05n

.meas tran vdout1_160ck100 FIND v(dout1_160) AT=110.05n

.meas tran vdout1_161ck100 FIND v(dout1_161) AT=110.05n

.meas tran vdout1_162ck100 FIND v(dout1_162) AT=110.05n

.meas tran vdout1_163ck100 FIND v(dout1_163) AT=110.05n

.meas tran vdout1_164ck100 FIND v(dout1_164) AT=110.05n

.meas tran vdout1_165ck100 FIND v(dout1_165) AT=110.05n

.meas tran vdout1_166ck100 FIND v(dout1_166) AT=110.05n

.meas tran vdout1_167ck100 FIND v(dout1_167) AT=110.05n

.meas tran vdout1_168ck100 FIND v(dout1_168) AT=110.05n

.meas tran vdout1_169ck100 FIND v(dout1_169) AT=110.05n

.meas tran vdout1_170ck100 FIND v(dout1_170) AT=110.05n

.meas tran vdout1_171ck100 FIND v(dout1_171) AT=110.05n

.meas tran vdout1_172ck100 FIND v(dout1_172) AT=110.05n

.meas tran vdout1_173ck100 FIND v(dout1_173) AT=110.05n

.meas tran vdout1_174ck100 FIND v(dout1_174) AT=110.05n

.meas tran vdout1_175ck100 FIND v(dout1_175) AT=110.05n

.meas tran vdout1_176ck100 FIND v(dout1_176) AT=110.05n

.meas tran vdout1_177ck100 FIND v(dout1_177) AT=110.05n

.meas tran vdout1_178ck100 FIND v(dout1_178) AT=110.05n

.meas tran vdout1_179ck100 FIND v(dout1_179) AT=110.05n

.meas tran vdout1_180ck100 FIND v(dout1_180) AT=110.05n

.meas tran vdout1_181ck100 FIND v(dout1_181) AT=110.05n

.meas tran vdout1_182ck100 FIND v(dout1_182) AT=110.05n

.meas tran vdout1_183ck100 FIND v(dout1_183) AT=110.05n

.meas tran vdout1_184ck100 FIND v(dout1_184) AT=110.05n

.meas tran vdout1_185ck100 FIND v(dout1_185) AT=110.05n

.meas tran vdout1_186ck100 FIND v(dout1_186) AT=110.05n

.meas tran vdout1_187ck100 FIND v(dout1_187) AT=110.05n

.meas tran vdout1_188ck100 FIND v(dout1_188) AT=110.05n

.meas tran vdout1_189ck100 FIND v(dout1_189) AT=110.05n

.meas tran vdout1_190ck100 FIND v(dout1_190) AT=110.05n

.meas tran vdout1_191ck100 FIND v(dout1_191) AT=110.05n

.meas tran vdout1_192ck100 FIND v(dout1_192) AT=110.05n

.meas tran vdout1_193ck100 FIND v(dout1_193) AT=110.05n

.meas tran vdout1_194ck100 FIND v(dout1_194) AT=110.05n

.meas tran vdout1_195ck100 FIND v(dout1_195) AT=110.05n

.meas tran vdout1_196ck100 FIND v(dout1_196) AT=110.05n

.meas tran vdout1_197ck100 FIND v(dout1_197) AT=110.05n

.meas tran vdout1_198ck100 FIND v(dout1_198) AT=110.05n

.meas tran vdout1_199ck100 FIND v(dout1_199) AT=110.05n

.meas tran vdout1_200ck100 FIND v(dout1_200) AT=110.05n

.meas tran vdout1_201ck100 FIND v(dout1_201) AT=110.05n

.meas tran vdout1_202ck100 FIND v(dout1_202) AT=110.05n

.meas tran vdout1_203ck100 FIND v(dout1_203) AT=110.05n

.meas tran vdout1_204ck100 FIND v(dout1_204) AT=110.05n

.meas tran vdout1_205ck100 FIND v(dout1_205) AT=110.05n

.meas tran vdout1_206ck100 FIND v(dout1_206) AT=110.05n

.meas tran vdout1_207ck100 FIND v(dout1_207) AT=110.05n

.meas tran vdout1_208ck100 FIND v(dout1_208) AT=110.05n

.meas tran vdout1_209ck100 FIND v(dout1_209) AT=110.05n

.meas tran vdout1_210ck100 FIND v(dout1_210) AT=110.05n

.meas tran vdout1_211ck100 FIND v(dout1_211) AT=110.05n

.meas tran vdout1_212ck100 FIND v(dout1_212) AT=110.05n

.meas tran vdout1_213ck100 FIND v(dout1_213) AT=110.05n

.meas tran vdout1_214ck100 FIND v(dout1_214) AT=110.05n

.meas tran vdout1_215ck100 FIND v(dout1_215) AT=110.05n

.meas tran vdout1_216ck100 FIND v(dout1_216) AT=110.05n

.meas tran vdout1_217ck100 FIND v(dout1_217) AT=110.05n

.meas tran vdout1_218ck100 FIND v(dout1_218) AT=110.05n

.meas tran vdout1_219ck100 FIND v(dout1_219) AT=110.05n

.meas tran vdout1_220ck100 FIND v(dout1_220) AT=110.05n

.meas tran vdout1_221ck100 FIND v(dout1_221) AT=110.05n

.meas tran vdout1_222ck100 FIND v(dout1_222) AT=110.05n

.meas tran vdout1_223ck100 FIND v(dout1_223) AT=110.05n

.meas tran vdout1_224ck100 FIND v(dout1_224) AT=110.05n

.meas tran vdout1_225ck100 FIND v(dout1_225) AT=110.05n

.meas tran vdout1_226ck100 FIND v(dout1_226) AT=110.05n

.meas tran vdout1_227ck100 FIND v(dout1_227) AT=110.05n

.meas tran vdout1_228ck100 FIND v(dout1_228) AT=110.05n

.meas tran vdout1_229ck100 FIND v(dout1_229) AT=110.05n

.meas tran vdout1_230ck100 FIND v(dout1_230) AT=110.05n

.meas tran vdout1_231ck100 FIND v(dout1_231) AT=110.05n

.meas tran vdout1_232ck100 FIND v(dout1_232) AT=110.05n

.meas tran vdout1_233ck100 FIND v(dout1_233) AT=110.05n

.meas tran vdout1_234ck100 FIND v(dout1_234) AT=110.05n

.meas tran vdout1_235ck100 FIND v(dout1_235) AT=110.05n

.meas tran vdout1_236ck100 FIND v(dout1_236) AT=110.05n

.meas tran vdout1_237ck100 FIND v(dout1_237) AT=110.05n

.meas tran vdout1_238ck100 FIND v(dout1_238) AT=110.05n

.meas tran vdout1_239ck100 FIND v(dout1_239) AT=110.05n

.meas tran vdout1_240ck100 FIND v(dout1_240) AT=110.05n

.meas tran vdout1_241ck100 FIND v(dout1_241) AT=110.05n

.meas tran vdout1_242ck100 FIND v(dout1_242) AT=110.05n

.meas tran vdout1_243ck100 FIND v(dout1_243) AT=110.05n

.meas tran vdout1_244ck100 FIND v(dout1_244) AT=110.05n

.meas tran vdout1_245ck100 FIND v(dout1_245) AT=110.05n

.meas tran vdout1_246ck100 FIND v(dout1_246) AT=110.05n

.meas tran vdout1_247ck100 FIND v(dout1_247) AT=110.05n

.meas tran vdout1_248ck100 FIND v(dout1_248) AT=110.05n

.meas tran vdout1_249ck100 FIND v(dout1_249) AT=110.05n

.meas tran vdout1_250ck100 FIND v(dout1_250) AT=110.05n

.meas tran vdout1_251ck100 FIND v(dout1_251) AT=110.05n

.meas tran vdout1_252ck100 FIND v(dout1_252) AT=110.05n

.meas tran vdout1_253ck100 FIND v(dout1_253) AT=110.05n

.meas tran vdout1_254ck100 FIND v(dout1_254) AT=110.05n

.meas tran vdout1_255ck100 FIND v(dout1_255) AT=110.05n

.meas tran vdout1_256ck100 FIND v(dout1_256) AT=110.05n

.meas tran vdout1_0ck130 FIND v(dout1_0) AT=140.05n

.meas tran vdout1_1ck130 FIND v(dout1_1) AT=140.05n

.meas tran vdout1_2ck130 FIND v(dout1_2) AT=140.05n

.meas tran vdout1_3ck130 FIND v(dout1_3) AT=140.05n

.meas tran vdout1_4ck130 FIND v(dout1_4) AT=140.05n

.meas tran vdout1_5ck130 FIND v(dout1_5) AT=140.05n

.meas tran vdout1_6ck130 FIND v(dout1_6) AT=140.05n

.meas tran vdout1_7ck130 FIND v(dout1_7) AT=140.05n

.meas tran vdout1_8ck130 FIND v(dout1_8) AT=140.05n

.meas tran vdout1_9ck130 FIND v(dout1_9) AT=140.05n

.meas tran vdout1_10ck130 FIND v(dout1_10) AT=140.05n

.meas tran vdout1_11ck130 FIND v(dout1_11) AT=140.05n

.meas tran vdout1_12ck130 FIND v(dout1_12) AT=140.05n

.meas tran vdout1_13ck130 FIND v(dout1_13) AT=140.05n

.meas tran vdout1_14ck130 FIND v(dout1_14) AT=140.05n

.meas tran vdout1_15ck130 FIND v(dout1_15) AT=140.05n

.meas tran vdout1_16ck130 FIND v(dout1_16) AT=140.05n

.meas tran vdout1_17ck130 FIND v(dout1_17) AT=140.05n

.meas tran vdout1_18ck130 FIND v(dout1_18) AT=140.05n

.meas tran vdout1_19ck130 FIND v(dout1_19) AT=140.05n

.meas tran vdout1_20ck130 FIND v(dout1_20) AT=140.05n

.meas tran vdout1_21ck130 FIND v(dout1_21) AT=140.05n

.meas tran vdout1_22ck130 FIND v(dout1_22) AT=140.05n

.meas tran vdout1_23ck130 FIND v(dout1_23) AT=140.05n

.meas tran vdout1_24ck130 FIND v(dout1_24) AT=140.05n

.meas tran vdout1_25ck130 FIND v(dout1_25) AT=140.05n

.meas tran vdout1_26ck130 FIND v(dout1_26) AT=140.05n

.meas tran vdout1_27ck130 FIND v(dout1_27) AT=140.05n

.meas tran vdout1_28ck130 FIND v(dout1_28) AT=140.05n

.meas tran vdout1_29ck130 FIND v(dout1_29) AT=140.05n

.meas tran vdout1_30ck130 FIND v(dout1_30) AT=140.05n

.meas tran vdout1_31ck130 FIND v(dout1_31) AT=140.05n

.meas tran vdout1_32ck130 FIND v(dout1_32) AT=140.05n

.meas tran vdout1_33ck130 FIND v(dout1_33) AT=140.05n

.meas tran vdout1_34ck130 FIND v(dout1_34) AT=140.05n

.meas tran vdout1_35ck130 FIND v(dout1_35) AT=140.05n

.meas tran vdout1_36ck130 FIND v(dout1_36) AT=140.05n

.meas tran vdout1_37ck130 FIND v(dout1_37) AT=140.05n

.meas tran vdout1_38ck130 FIND v(dout1_38) AT=140.05n

.meas tran vdout1_39ck130 FIND v(dout1_39) AT=140.05n

.meas tran vdout1_40ck130 FIND v(dout1_40) AT=140.05n

.meas tran vdout1_41ck130 FIND v(dout1_41) AT=140.05n

.meas tran vdout1_42ck130 FIND v(dout1_42) AT=140.05n

.meas tran vdout1_43ck130 FIND v(dout1_43) AT=140.05n

.meas tran vdout1_44ck130 FIND v(dout1_44) AT=140.05n

.meas tran vdout1_45ck130 FIND v(dout1_45) AT=140.05n

.meas tran vdout1_46ck130 FIND v(dout1_46) AT=140.05n

.meas tran vdout1_47ck130 FIND v(dout1_47) AT=140.05n

.meas tran vdout1_48ck130 FIND v(dout1_48) AT=140.05n

.meas tran vdout1_49ck130 FIND v(dout1_49) AT=140.05n

.meas tran vdout1_50ck130 FIND v(dout1_50) AT=140.05n

.meas tran vdout1_51ck130 FIND v(dout1_51) AT=140.05n

.meas tran vdout1_52ck130 FIND v(dout1_52) AT=140.05n

.meas tran vdout1_53ck130 FIND v(dout1_53) AT=140.05n

.meas tran vdout1_54ck130 FIND v(dout1_54) AT=140.05n

.meas tran vdout1_55ck130 FIND v(dout1_55) AT=140.05n

.meas tran vdout1_56ck130 FIND v(dout1_56) AT=140.05n

.meas tran vdout1_57ck130 FIND v(dout1_57) AT=140.05n

.meas tran vdout1_58ck130 FIND v(dout1_58) AT=140.05n

.meas tran vdout1_59ck130 FIND v(dout1_59) AT=140.05n

.meas tran vdout1_60ck130 FIND v(dout1_60) AT=140.05n

.meas tran vdout1_61ck130 FIND v(dout1_61) AT=140.05n

.meas tran vdout1_62ck130 FIND v(dout1_62) AT=140.05n

.meas tran vdout1_63ck130 FIND v(dout1_63) AT=140.05n

.meas tran vdout1_64ck130 FIND v(dout1_64) AT=140.05n

.meas tran vdout1_65ck130 FIND v(dout1_65) AT=140.05n

.meas tran vdout1_66ck130 FIND v(dout1_66) AT=140.05n

.meas tran vdout1_67ck130 FIND v(dout1_67) AT=140.05n

.meas tran vdout1_68ck130 FIND v(dout1_68) AT=140.05n

.meas tran vdout1_69ck130 FIND v(dout1_69) AT=140.05n

.meas tran vdout1_70ck130 FIND v(dout1_70) AT=140.05n

.meas tran vdout1_71ck130 FIND v(dout1_71) AT=140.05n

.meas tran vdout1_72ck130 FIND v(dout1_72) AT=140.05n

.meas tran vdout1_73ck130 FIND v(dout1_73) AT=140.05n

.meas tran vdout1_74ck130 FIND v(dout1_74) AT=140.05n

.meas tran vdout1_75ck130 FIND v(dout1_75) AT=140.05n

.meas tran vdout1_76ck130 FIND v(dout1_76) AT=140.05n

.meas tran vdout1_77ck130 FIND v(dout1_77) AT=140.05n

.meas tran vdout1_78ck130 FIND v(dout1_78) AT=140.05n

.meas tran vdout1_79ck130 FIND v(dout1_79) AT=140.05n

.meas tran vdout1_80ck130 FIND v(dout1_80) AT=140.05n

.meas tran vdout1_81ck130 FIND v(dout1_81) AT=140.05n

.meas tran vdout1_82ck130 FIND v(dout1_82) AT=140.05n

.meas tran vdout1_83ck130 FIND v(dout1_83) AT=140.05n

.meas tran vdout1_84ck130 FIND v(dout1_84) AT=140.05n

.meas tran vdout1_85ck130 FIND v(dout1_85) AT=140.05n

.meas tran vdout1_86ck130 FIND v(dout1_86) AT=140.05n

.meas tran vdout1_87ck130 FIND v(dout1_87) AT=140.05n

.meas tran vdout1_88ck130 FIND v(dout1_88) AT=140.05n

.meas tran vdout1_89ck130 FIND v(dout1_89) AT=140.05n

.meas tran vdout1_90ck130 FIND v(dout1_90) AT=140.05n

.meas tran vdout1_91ck130 FIND v(dout1_91) AT=140.05n

.meas tran vdout1_92ck130 FIND v(dout1_92) AT=140.05n

.meas tran vdout1_93ck130 FIND v(dout1_93) AT=140.05n

.meas tran vdout1_94ck130 FIND v(dout1_94) AT=140.05n

.meas tran vdout1_95ck130 FIND v(dout1_95) AT=140.05n

.meas tran vdout1_96ck130 FIND v(dout1_96) AT=140.05n

.meas tran vdout1_97ck130 FIND v(dout1_97) AT=140.05n

.meas tran vdout1_98ck130 FIND v(dout1_98) AT=140.05n

.meas tran vdout1_99ck130 FIND v(dout1_99) AT=140.05n

.meas tran vdout1_100ck130 FIND v(dout1_100) AT=140.05n

.meas tran vdout1_101ck130 FIND v(dout1_101) AT=140.05n

.meas tran vdout1_102ck130 FIND v(dout1_102) AT=140.05n

.meas tran vdout1_103ck130 FIND v(dout1_103) AT=140.05n

.meas tran vdout1_104ck130 FIND v(dout1_104) AT=140.05n

.meas tran vdout1_105ck130 FIND v(dout1_105) AT=140.05n

.meas tran vdout1_106ck130 FIND v(dout1_106) AT=140.05n

.meas tran vdout1_107ck130 FIND v(dout1_107) AT=140.05n

.meas tran vdout1_108ck130 FIND v(dout1_108) AT=140.05n

.meas tran vdout1_109ck130 FIND v(dout1_109) AT=140.05n

.meas tran vdout1_110ck130 FIND v(dout1_110) AT=140.05n

.meas tran vdout1_111ck130 FIND v(dout1_111) AT=140.05n

.meas tran vdout1_112ck130 FIND v(dout1_112) AT=140.05n

.meas tran vdout1_113ck130 FIND v(dout1_113) AT=140.05n

.meas tran vdout1_114ck130 FIND v(dout1_114) AT=140.05n

.meas tran vdout1_115ck130 FIND v(dout1_115) AT=140.05n

.meas tran vdout1_116ck130 FIND v(dout1_116) AT=140.05n

.meas tran vdout1_117ck130 FIND v(dout1_117) AT=140.05n

.meas tran vdout1_118ck130 FIND v(dout1_118) AT=140.05n

.meas tran vdout1_119ck130 FIND v(dout1_119) AT=140.05n

.meas tran vdout1_120ck130 FIND v(dout1_120) AT=140.05n

.meas tran vdout1_121ck130 FIND v(dout1_121) AT=140.05n

.meas tran vdout1_122ck130 FIND v(dout1_122) AT=140.05n

.meas tran vdout1_123ck130 FIND v(dout1_123) AT=140.05n

.meas tran vdout1_124ck130 FIND v(dout1_124) AT=140.05n

.meas tran vdout1_125ck130 FIND v(dout1_125) AT=140.05n

.meas tran vdout1_126ck130 FIND v(dout1_126) AT=140.05n

.meas tran vdout1_127ck130 FIND v(dout1_127) AT=140.05n

.meas tran vdout1_128ck130 FIND v(dout1_128) AT=140.05n

.meas tran vdout1_129ck130 FIND v(dout1_129) AT=140.05n

.meas tran vdout1_130ck130 FIND v(dout1_130) AT=140.05n

.meas tran vdout1_131ck130 FIND v(dout1_131) AT=140.05n

.meas tran vdout1_132ck130 FIND v(dout1_132) AT=140.05n

.meas tran vdout1_133ck130 FIND v(dout1_133) AT=140.05n

.meas tran vdout1_134ck130 FIND v(dout1_134) AT=140.05n

.meas tran vdout1_135ck130 FIND v(dout1_135) AT=140.05n

.meas tran vdout1_136ck130 FIND v(dout1_136) AT=140.05n

.meas tran vdout1_137ck130 FIND v(dout1_137) AT=140.05n

.meas tran vdout1_138ck130 FIND v(dout1_138) AT=140.05n

.meas tran vdout1_139ck130 FIND v(dout1_139) AT=140.05n

.meas tran vdout1_140ck130 FIND v(dout1_140) AT=140.05n

.meas tran vdout1_141ck130 FIND v(dout1_141) AT=140.05n

.meas tran vdout1_142ck130 FIND v(dout1_142) AT=140.05n

.meas tran vdout1_143ck130 FIND v(dout1_143) AT=140.05n

.meas tran vdout1_144ck130 FIND v(dout1_144) AT=140.05n

.meas tran vdout1_145ck130 FIND v(dout1_145) AT=140.05n

.meas tran vdout1_146ck130 FIND v(dout1_146) AT=140.05n

.meas tran vdout1_147ck130 FIND v(dout1_147) AT=140.05n

.meas tran vdout1_148ck130 FIND v(dout1_148) AT=140.05n

.meas tran vdout1_149ck130 FIND v(dout1_149) AT=140.05n

.meas tran vdout1_150ck130 FIND v(dout1_150) AT=140.05n

.meas tran vdout1_151ck130 FIND v(dout1_151) AT=140.05n

.meas tran vdout1_152ck130 FIND v(dout1_152) AT=140.05n

.meas tran vdout1_153ck130 FIND v(dout1_153) AT=140.05n

.meas tran vdout1_154ck130 FIND v(dout1_154) AT=140.05n

.meas tran vdout1_155ck130 FIND v(dout1_155) AT=140.05n

.meas tran vdout1_156ck130 FIND v(dout1_156) AT=140.05n

.meas tran vdout1_157ck130 FIND v(dout1_157) AT=140.05n

.meas tran vdout1_158ck130 FIND v(dout1_158) AT=140.05n

.meas tran vdout1_159ck130 FIND v(dout1_159) AT=140.05n

.meas tran vdout1_160ck130 FIND v(dout1_160) AT=140.05n

.meas tran vdout1_161ck130 FIND v(dout1_161) AT=140.05n

.meas tran vdout1_162ck130 FIND v(dout1_162) AT=140.05n

.meas tran vdout1_163ck130 FIND v(dout1_163) AT=140.05n

.meas tran vdout1_164ck130 FIND v(dout1_164) AT=140.05n

.meas tran vdout1_165ck130 FIND v(dout1_165) AT=140.05n

.meas tran vdout1_166ck130 FIND v(dout1_166) AT=140.05n

.meas tran vdout1_167ck130 FIND v(dout1_167) AT=140.05n

.meas tran vdout1_168ck130 FIND v(dout1_168) AT=140.05n

.meas tran vdout1_169ck130 FIND v(dout1_169) AT=140.05n

.meas tran vdout1_170ck130 FIND v(dout1_170) AT=140.05n

.meas tran vdout1_171ck130 FIND v(dout1_171) AT=140.05n

.meas tran vdout1_172ck130 FIND v(dout1_172) AT=140.05n

.meas tran vdout1_173ck130 FIND v(dout1_173) AT=140.05n

.meas tran vdout1_174ck130 FIND v(dout1_174) AT=140.05n

.meas tran vdout1_175ck130 FIND v(dout1_175) AT=140.05n

.meas tran vdout1_176ck130 FIND v(dout1_176) AT=140.05n

.meas tran vdout1_177ck130 FIND v(dout1_177) AT=140.05n

.meas tran vdout1_178ck130 FIND v(dout1_178) AT=140.05n

.meas tran vdout1_179ck130 FIND v(dout1_179) AT=140.05n

.meas tran vdout1_180ck130 FIND v(dout1_180) AT=140.05n

.meas tran vdout1_181ck130 FIND v(dout1_181) AT=140.05n

.meas tran vdout1_182ck130 FIND v(dout1_182) AT=140.05n

.meas tran vdout1_183ck130 FIND v(dout1_183) AT=140.05n

.meas tran vdout1_184ck130 FIND v(dout1_184) AT=140.05n

.meas tran vdout1_185ck130 FIND v(dout1_185) AT=140.05n

.meas tran vdout1_186ck130 FIND v(dout1_186) AT=140.05n

.meas tran vdout1_187ck130 FIND v(dout1_187) AT=140.05n

.meas tran vdout1_188ck130 FIND v(dout1_188) AT=140.05n

.meas tran vdout1_189ck130 FIND v(dout1_189) AT=140.05n

.meas tran vdout1_190ck130 FIND v(dout1_190) AT=140.05n

.meas tran vdout1_191ck130 FIND v(dout1_191) AT=140.05n

.meas tran vdout1_192ck130 FIND v(dout1_192) AT=140.05n

.meas tran vdout1_193ck130 FIND v(dout1_193) AT=140.05n

.meas tran vdout1_194ck130 FIND v(dout1_194) AT=140.05n

.meas tran vdout1_195ck130 FIND v(dout1_195) AT=140.05n

.meas tran vdout1_196ck130 FIND v(dout1_196) AT=140.05n

.meas tran vdout1_197ck130 FIND v(dout1_197) AT=140.05n

.meas tran vdout1_198ck130 FIND v(dout1_198) AT=140.05n

.meas tran vdout1_199ck130 FIND v(dout1_199) AT=140.05n

.meas tran vdout1_200ck130 FIND v(dout1_200) AT=140.05n

.meas tran vdout1_201ck130 FIND v(dout1_201) AT=140.05n

.meas tran vdout1_202ck130 FIND v(dout1_202) AT=140.05n

.meas tran vdout1_203ck130 FIND v(dout1_203) AT=140.05n

.meas tran vdout1_204ck130 FIND v(dout1_204) AT=140.05n

.meas tran vdout1_205ck130 FIND v(dout1_205) AT=140.05n

.meas tran vdout1_206ck130 FIND v(dout1_206) AT=140.05n

.meas tran vdout1_207ck130 FIND v(dout1_207) AT=140.05n

.meas tran vdout1_208ck130 FIND v(dout1_208) AT=140.05n

.meas tran vdout1_209ck130 FIND v(dout1_209) AT=140.05n

.meas tran vdout1_210ck130 FIND v(dout1_210) AT=140.05n

.meas tran vdout1_211ck130 FIND v(dout1_211) AT=140.05n

.meas tran vdout1_212ck130 FIND v(dout1_212) AT=140.05n

.meas tran vdout1_213ck130 FIND v(dout1_213) AT=140.05n

.meas tran vdout1_214ck130 FIND v(dout1_214) AT=140.05n

.meas tran vdout1_215ck130 FIND v(dout1_215) AT=140.05n

.meas tran vdout1_216ck130 FIND v(dout1_216) AT=140.05n

.meas tran vdout1_217ck130 FIND v(dout1_217) AT=140.05n

.meas tran vdout1_218ck130 FIND v(dout1_218) AT=140.05n

.meas tran vdout1_219ck130 FIND v(dout1_219) AT=140.05n

.meas tran vdout1_220ck130 FIND v(dout1_220) AT=140.05n

.meas tran vdout1_221ck130 FIND v(dout1_221) AT=140.05n

.meas tran vdout1_222ck130 FIND v(dout1_222) AT=140.05n

.meas tran vdout1_223ck130 FIND v(dout1_223) AT=140.05n

.meas tran vdout1_224ck130 FIND v(dout1_224) AT=140.05n

.meas tran vdout1_225ck130 FIND v(dout1_225) AT=140.05n

.meas tran vdout1_226ck130 FIND v(dout1_226) AT=140.05n

.meas tran vdout1_227ck130 FIND v(dout1_227) AT=140.05n

.meas tran vdout1_228ck130 FIND v(dout1_228) AT=140.05n

.meas tran vdout1_229ck130 FIND v(dout1_229) AT=140.05n

.meas tran vdout1_230ck130 FIND v(dout1_230) AT=140.05n

.meas tran vdout1_231ck130 FIND v(dout1_231) AT=140.05n

.meas tran vdout1_232ck130 FIND v(dout1_232) AT=140.05n

.meas tran vdout1_233ck130 FIND v(dout1_233) AT=140.05n

.meas tran vdout1_234ck130 FIND v(dout1_234) AT=140.05n

.meas tran vdout1_235ck130 FIND v(dout1_235) AT=140.05n

.meas tran vdout1_236ck130 FIND v(dout1_236) AT=140.05n

.meas tran vdout1_237ck130 FIND v(dout1_237) AT=140.05n

.meas tran vdout1_238ck130 FIND v(dout1_238) AT=140.05n

.meas tran vdout1_239ck130 FIND v(dout1_239) AT=140.05n

.meas tran vdout1_240ck130 FIND v(dout1_240) AT=140.05n

.meas tran vdout1_241ck130 FIND v(dout1_241) AT=140.05n

.meas tran vdout1_242ck130 FIND v(dout1_242) AT=140.05n

.meas tran vdout1_243ck130 FIND v(dout1_243) AT=140.05n

.meas tran vdout1_244ck130 FIND v(dout1_244) AT=140.05n

.meas tran vdout1_245ck130 FIND v(dout1_245) AT=140.05n

.meas tran vdout1_246ck130 FIND v(dout1_246) AT=140.05n

.meas tran vdout1_247ck130 FIND v(dout1_247) AT=140.05n

.meas tran vdout1_248ck130 FIND v(dout1_248) AT=140.05n

.meas tran vdout1_249ck130 FIND v(dout1_249) AT=140.05n

.meas tran vdout1_250ck130 FIND v(dout1_250) AT=140.05n

.meas tran vdout1_251ck130 FIND v(dout1_251) AT=140.05n

.meas tran vdout1_252ck130 FIND v(dout1_252) AT=140.05n

.meas tran vdout1_253ck130 FIND v(dout1_253) AT=140.05n

.meas tran vdout1_254ck130 FIND v(dout1_254) AT=140.05n

.meas tran vdout1_255ck130 FIND v(dout1_255) AT=140.05n

.meas tran vdout1_256ck130 FIND v(dout1_256) AT=140.05n

.meas tran vdout1_0ck150 FIND v(dout1_0) AT=160.05n

.meas tran vdout1_1ck150 FIND v(dout1_1) AT=160.05n

.meas tran vdout1_2ck150 FIND v(dout1_2) AT=160.05n

.meas tran vdout1_3ck150 FIND v(dout1_3) AT=160.05n

.meas tran vdout1_4ck150 FIND v(dout1_4) AT=160.05n

.meas tran vdout1_5ck150 FIND v(dout1_5) AT=160.05n

.meas tran vdout1_6ck150 FIND v(dout1_6) AT=160.05n

.meas tran vdout1_7ck150 FIND v(dout1_7) AT=160.05n

.meas tran vdout1_8ck150 FIND v(dout1_8) AT=160.05n

.meas tran vdout1_9ck150 FIND v(dout1_9) AT=160.05n

.meas tran vdout1_10ck150 FIND v(dout1_10) AT=160.05n

.meas tran vdout1_11ck150 FIND v(dout1_11) AT=160.05n

.meas tran vdout1_12ck150 FIND v(dout1_12) AT=160.05n

.meas tran vdout1_13ck150 FIND v(dout1_13) AT=160.05n

.meas tran vdout1_14ck150 FIND v(dout1_14) AT=160.05n

.meas tran vdout1_15ck150 FIND v(dout1_15) AT=160.05n

.meas tran vdout1_16ck150 FIND v(dout1_16) AT=160.05n

.meas tran vdout1_17ck150 FIND v(dout1_17) AT=160.05n

.meas tran vdout1_18ck150 FIND v(dout1_18) AT=160.05n

.meas tran vdout1_19ck150 FIND v(dout1_19) AT=160.05n

.meas tran vdout1_20ck150 FIND v(dout1_20) AT=160.05n

.meas tran vdout1_21ck150 FIND v(dout1_21) AT=160.05n

.meas tran vdout1_22ck150 FIND v(dout1_22) AT=160.05n

.meas tran vdout1_23ck150 FIND v(dout1_23) AT=160.05n

.meas tran vdout1_24ck150 FIND v(dout1_24) AT=160.05n

.meas tran vdout1_25ck150 FIND v(dout1_25) AT=160.05n

.meas tran vdout1_26ck150 FIND v(dout1_26) AT=160.05n

.meas tran vdout1_27ck150 FIND v(dout1_27) AT=160.05n

.meas tran vdout1_28ck150 FIND v(dout1_28) AT=160.05n

.meas tran vdout1_29ck150 FIND v(dout1_29) AT=160.05n

.meas tran vdout1_30ck150 FIND v(dout1_30) AT=160.05n

.meas tran vdout1_31ck150 FIND v(dout1_31) AT=160.05n

.meas tran vdout1_32ck150 FIND v(dout1_32) AT=160.05n

.meas tran vdout1_33ck150 FIND v(dout1_33) AT=160.05n

.meas tran vdout1_34ck150 FIND v(dout1_34) AT=160.05n

.meas tran vdout1_35ck150 FIND v(dout1_35) AT=160.05n

.meas tran vdout1_36ck150 FIND v(dout1_36) AT=160.05n

.meas tran vdout1_37ck150 FIND v(dout1_37) AT=160.05n

.meas tran vdout1_38ck150 FIND v(dout1_38) AT=160.05n

.meas tran vdout1_39ck150 FIND v(dout1_39) AT=160.05n

.meas tran vdout1_40ck150 FIND v(dout1_40) AT=160.05n

.meas tran vdout1_41ck150 FIND v(dout1_41) AT=160.05n

.meas tran vdout1_42ck150 FIND v(dout1_42) AT=160.05n

.meas tran vdout1_43ck150 FIND v(dout1_43) AT=160.05n

.meas tran vdout1_44ck150 FIND v(dout1_44) AT=160.05n

.meas tran vdout1_45ck150 FIND v(dout1_45) AT=160.05n

.meas tran vdout1_46ck150 FIND v(dout1_46) AT=160.05n

.meas tran vdout1_47ck150 FIND v(dout1_47) AT=160.05n

.meas tran vdout1_48ck150 FIND v(dout1_48) AT=160.05n

.meas tran vdout1_49ck150 FIND v(dout1_49) AT=160.05n

.meas tran vdout1_50ck150 FIND v(dout1_50) AT=160.05n

.meas tran vdout1_51ck150 FIND v(dout1_51) AT=160.05n

.meas tran vdout1_52ck150 FIND v(dout1_52) AT=160.05n

.meas tran vdout1_53ck150 FIND v(dout1_53) AT=160.05n

.meas tran vdout1_54ck150 FIND v(dout1_54) AT=160.05n

.meas tran vdout1_55ck150 FIND v(dout1_55) AT=160.05n

.meas tran vdout1_56ck150 FIND v(dout1_56) AT=160.05n

.meas tran vdout1_57ck150 FIND v(dout1_57) AT=160.05n

.meas tran vdout1_58ck150 FIND v(dout1_58) AT=160.05n

.meas tran vdout1_59ck150 FIND v(dout1_59) AT=160.05n

.meas tran vdout1_60ck150 FIND v(dout1_60) AT=160.05n

.meas tran vdout1_61ck150 FIND v(dout1_61) AT=160.05n

.meas tran vdout1_62ck150 FIND v(dout1_62) AT=160.05n

.meas tran vdout1_63ck150 FIND v(dout1_63) AT=160.05n

.meas tran vdout1_64ck150 FIND v(dout1_64) AT=160.05n

.meas tran vdout1_65ck150 FIND v(dout1_65) AT=160.05n

.meas tran vdout1_66ck150 FIND v(dout1_66) AT=160.05n

.meas tran vdout1_67ck150 FIND v(dout1_67) AT=160.05n

.meas tran vdout1_68ck150 FIND v(dout1_68) AT=160.05n

.meas tran vdout1_69ck150 FIND v(dout1_69) AT=160.05n

.meas tran vdout1_70ck150 FIND v(dout1_70) AT=160.05n

.meas tran vdout1_71ck150 FIND v(dout1_71) AT=160.05n

.meas tran vdout1_72ck150 FIND v(dout1_72) AT=160.05n

.meas tran vdout1_73ck150 FIND v(dout1_73) AT=160.05n

.meas tran vdout1_74ck150 FIND v(dout1_74) AT=160.05n

.meas tran vdout1_75ck150 FIND v(dout1_75) AT=160.05n

.meas tran vdout1_76ck150 FIND v(dout1_76) AT=160.05n

.meas tran vdout1_77ck150 FIND v(dout1_77) AT=160.05n

.meas tran vdout1_78ck150 FIND v(dout1_78) AT=160.05n

.meas tran vdout1_79ck150 FIND v(dout1_79) AT=160.05n

.meas tran vdout1_80ck150 FIND v(dout1_80) AT=160.05n

.meas tran vdout1_81ck150 FIND v(dout1_81) AT=160.05n

.meas tran vdout1_82ck150 FIND v(dout1_82) AT=160.05n

.meas tran vdout1_83ck150 FIND v(dout1_83) AT=160.05n

.meas tran vdout1_84ck150 FIND v(dout1_84) AT=160.05n

.meas tran vdout1_85ck150 FIND v(dout1_85) AT=160.05n

.meas tran vdout1_86ck150 FIND v(dout1_86) AT=160.05n

.meas tran vdout1_87ck150 FIND v(dout1_87) AT=160.05n

.meas tran vdout1_88ck150 FIND v(dout1_88) AT=160.05n

.meas tran vdout1_89ck150 FIND v(dout1_89) AT=160.05n

.meas tran vdout1_90ck150 FIND v(dout1_90) AT=160.05n

.meas tran vdout1_91ck150 FIND v(dout1_91) AT=160.05n

.meas tran vdout1_92ck150 FIND v(dout1_92) AT=160.05n

.meas tran vdout1_93ck150 FIND v(dout1_93) AT=160.05n

.meas tran vdout1_94ck150 FIND v(dout1_94) AT=160.05n

.meas tran vdout1_95ck150 FIND v(dout1_95) AT=160.05n

.meas tran vdout1_96ck150 FIND v(dout1_96) AT=160.05n

.meas tran vdout1_97ck150 FIND v(dout1_97) AT=160.05n

.meas tran vdout1_98ck150 FIND v(dout1_98) AT=160.05n

.meas tran vdout1_99ck150 FIND v(dout1_99) AT=160.05n

.meas tran vdout1_100ck150 FIND v(dout1_100) AT=160.05n

.meas tran vdout1_101ck150 FIND v(dout1_101) AT=160.05n

.meas tran vdout1_102ck150 FIND v(dout1_102) AT=160.05n

.meas tran vdout1_103ck150 FIND v(dout1_103) AT=160.05n

.meas tran vdout1_104ck150 FIND v(dout1_104) AT=160.05n

.meas tran vdout1_105ck150 FIND v(dout1_105) AT=160.05n

.meas tran vdout1_106ck150 FIND v(dout1_106) AT=160.05n

.meas tran vdout1_107ck150 FIND v(dout1_107) AT=160.05n

.meas tran vdout1_108ck150 FIND v(dout1_108) AT=160.05n

.meas tran vdout1_109ck150 FIND v(dout1_109) AT=160.05n

.meas tran vdout1_110ck150 FIND v(dout1_110) AT=160.05n

.meas tran vdout1_111ck150 FIND v(dout1_111) AT=160.05n

.meas tran vdout1_112ck150 FIND v(dout1_112) AT=160.05n

.meas tran vdout1_113ck150 FIND v(dout1_113) AT=160.05n

.meas tran vdout1_114ck150 FIND v(dout1_114) AT=160.05n

.meas tran vdout1_115ck150 FIND v(dout1_115) AT=160.05n

.meas tran vdout1_116ck150 FIND v(dout1_116) AT=160.05n

.meas tran vdout1_117ck150 FIND v(dout1_117) AT=160.05n

.meas tran vdout1_118ck150 FIND v(dout1_118) AT=160.05n

.meas tran vdout1_119ck150 FIND v(dout1_119) AT=160.05n

.meas tran vdout1_120ck150 FIND v(dout1_120) AT=160.05n

.meas tran vdout1_121ck150 FIND v(dout1_121) AT=160.05n

.meas tran vdout1_122ck150 FIND v(dout1_122) AT=160.05n

.meas tran vdout1_123ck150 FIND v(dout1_123) AT=160.05n

.meas tran vdout1_124ck150 FIND v(dout1_124) AT=160.05n

.meas tran vdout1_125ck150 FIND v(dout1_125) AT=160.05n

.meas tran vdout1_126ck150 FIND v(dout1_126) AT=160.05n

.meas tran vdout1_127ck150 FIND v(dout1_127) AT=160.05n

.meas tran vdout1_128ck150 FIND v(dout1_128) AT=160.05n

.meas tran vdout1_129ck150 FIND v(dout1_129) AT=160.05n

.meas tran vdout1_130ck150 FIND v(dout1_130) AT=160.05n

.meas tran vdout1_131ck150 FIND v(dout1_131) AT=160.05n

.meas tran vdout1_132ck150 FIND v(dout1_132) AT=160.05n

.meas tran vdout1_133ck150 FIND v(dout1_133) AT=160.05n

.meas tran vdout1_134ck150 FIND v(dout1_134) AT=160.05n

.meas tran vdout1_135ck150 FIND v(dout1_135) AT=160.05n

.meas tran vdout1_136ck150 FIND v(dout1_136) AT=160.05n

.meas tran vdout1_137ck150 FIND v(dout1_137) AT=160.05n

.meas tran vdout1_138ck150 FIND v(dout1_138) AT=160.05n

.meas tran vdout1_139ck150 FIND v(dout1_139) AT=160.05n

.meas tran vdout1_140ck150 FIND v(dout1_140) AT=160.05n

.meas tran vdout1_141ck150 FIND v(dout1_141) AT=160.05n

.meas tran vdout1_142ck150 FIND v(dout1_142) AT=160.05n

.meas tran vdout1_143ck150 FIND v(dout1_143) AT=160.05n

.meas tran vdout1_144ck150 FIND v(dout1_144) AT=160.05n

.meas tran vdout1_145ck150 FIND v(dout1_145) AT=160.05n

.meas tran vdout1_146ck150 FIND v(dout1_146) AT=160.05n

.meas tran vdout1_147ck150 FIND v(dout1_147) AT=160.05n

.meas tran vdout1_148ck150 FIND v(dout1_148) AT=160.05n

.meas tran vdout1_149ck150 FIND v(dout1_149) AT=160.05n

.meas tran vdout1_150ck150 FIND v(dout1_150) AT=160.05n

.meas tran vdout1_151ck150 FIND v(dout1_151) AT=160.05n

.meas tran vdout1_152ck150 FIND v(dout1_152) AT=160.05n

.meas tran vdout1_153ck150 FIND v(dout1_153) AT=160.05n

.meas tran vdout1_154ck150 FIND v(dout1_154) AT=160.05n

.meas tran vdout1_155ck150 FIND v(dout1_155) AT=160.05n

.meas tran vdout1_156ck150 FIND v(dout1_156) AT=160.05n

.meas tran vdout1_157ck150 FIND v(dout1_157) AT=160.05n

.meas tran vdout1_158ck150 FIND v(dout1_158) AT=160.05n

.meas tran vdout1_159ck150 FIND v(dout1_159) AT=160.05n

.meas tran vdout1_160ck150 FIND v(dout1_160) AT=160.05n

.meas tran vdout1_161ck150 FIND v(dout1_161) AT=160.05n

.meas tran vdout1_162ck150 FIND v(dout1_162) AT=160.05n

.meas tran vdout1_163ck150 FIND v(dout1_163) AT=160.05n

.meas tran vdout1_164ck150 FIND v(dout1_164) AT=160.05n

.meas tran vdout1_165ck150 FIND v(dout1_165) AT=160.05n

.meas tran vdout1_166ck150 FIND v(dout1_166) AT=160.05n

.meas tran vdout1_167ck150 FIND v(dout1_167) AT=160.05n

.meas tran vdout1_168ck150 FIND v(dout1_168) AT=160.05n

.meas tran vdout1_169ck150 FIND v(dout1_169) AT=160.05n

.meas tran vdout1_170ck150 FIND v(dout1_170) AT=160.05n

.meas tran vdout1_171ck150 FIND v(dout1_171) AT=160.05n

.meas tran vdout1_172ck150 FIND v(dout1_172) AT=160.05n

.meas tran vdout1_173ck150 FIND v(dout1_173) AT=160.05n

.meas tran vdout1_174ck150 FIND v(dout1_174) AT=160.05n

.meas tran vdout1_175ck150 FIND v(dout1_175) AT=160.05n

.meas tran vdout1_176ck150 FIND v(dout1_176) AT=160.05n

.meas tran vdout1_177ck150 FIND v(dout1_177) AT=160.05n

.meas tran vdout1_178ck150 FIND v(dout1_178) AT=160.05n

.meas tran vdout1_179ck150 FIND v(dout1_179) AT=160.05n

.meas tran vdout1_180ck150 FIND v(dout1_180) AT=160.05n

.meas tran vdout1_181ck150 FIND v(dout1_181) AT=160.05n

.meas tran vdout1_182ck150 FIND v(dout1_182) AT=160.05n

.meas tran vdout1_183ck150 FIND v(dout1_183) AT=160.05n

.meas tran vdout1_184ck150 FIND v(dout1_184) AT=160.05n

.meas tran vdout1_185ck150 FIND v(dout1_185) AT=160.05n

.meas tran vdout1_186ck150 FIND v(dout1_186) AT=160.05n

.meas tran vdout1_187ck150 FIND v(dout1_187) AT=160.05n

.meas tran vdout1_188ck150 FIND v(dout1_188) AT=160.05n

.meas tran vdout1_189ck150 FIND v(dout1_189) AT=160.05n

.meas tran vdout1_190ck150 FIND v(dout1_190) AT=160.05n

.meas tran vdout1_191ck150 FIND v(dout1_191) AT=160.05n

.meas tran vdout1_192ck150 FIND v(dout1_192) AT=160.05n

.meas tran vdout1_193ck150 FIND v(dout1_193) AT=160.05n

.meas tran vdout1_194ck150 FIND v(dout1_194) AT=160.05n

.meas tran vdout1_195ck150 FIND v(dout1_195) AT=160.05n

.meas tran vdout1_196ck150 FIND v(dout1_196) AT=160.05n

.meas tran vdout1_197ck150 FIND v(dout1_197) AT=160.05n

.meas tran vdout1_198ck150 FIND v(dout1_198) AT=160.05n

.meas tran vdout1_199ck150 FIND v(dout1_199) AT=160.05n

.meas tran vdout1_200ck150 FIND v(dout1_200) AT=160.05n

.meas tran vdout1_201ck150 FIND v(dout1_201) AT=160.05n

.meas tran vdout1_202ck150 FIND v(dout1_202) AT=160.05n

.meas tran vdout1_203ck150 FIND v(dout1_203) AT=160.05n

.meas tran vdout1_204ck150 FIND v(dout1_204) AT=160.05n

.meas tran vdout1_205ck150 FIND v(dout1_205) AT=160.05n

.meas tran vdout1_206ck150 FIND v(dout1_206) AT=160.05n

.meas tran vdout1_207ck150 FIND v(dout1_207) AT=160.05n

.meas tran vdout1_208ck150 FIND v(dout1_208) AT=160.05n

.meas tran vdout1_209ck150 FIND v(dout1_209) AT=160.05n

.meas tran vdout1_210ck150 FIND v(dout1_210) AT=160.05n

.meas tran vdout1_211ck150 FIND v(dout1_211) AT=160.05n

.meas tran vdout1_212ck150 FIND v(dout1_212) AT=160.05n

.meas tran vdout1_213ck150 FIND v(dout1_213) AT=160.05n

.meas tran vdout1_214ck150 FIND v(dout1_214) AT=160.05n

.meas tran vdout1_215ck150 FIND v(dout1_215) AT=160.05n

.meas tran vdout1_216ck150 FIND v(dout1_216) AT=160.05n

.meas tran vdout1_217ck150 FIND v(dout1_217) AT=160.05n

.meas tran vdout1_218ck150 FIND v(dout1_218) AT=160.05n

.meas tran vdout1_219ck150 FIND v(dout1_219) AT=160.05n

.meas tran vdout1_220ck150 FIND v(dout1_220) AT=160.05n

.meas tran vdout1_221ck150 FIND v(dout1_221) AT=160.05n

.meas tran vdout1_222ck150 FIND v(dout1_222) AT=160.05n

.meas tran vdout1_223ck150 FIND v(dout1_223) AT=160.05n

.meas tran vdout1_224ck150 FIND v(dout1_224) AT=160.05n

.meas tran vdout1_225ck150 FIND v(dout1_225) AT=160.05n

.meas tran vdout1_226ck150 FIND v(dout1_226) AT=160.05n

.meas tran vdout1_227ck150 FIND v(dout1_227) AT=160.05n

.meas tran vdout1_228ck150 FIND v(dout1_228) AT=160.05n

.meas tran vdout1_229ck150 FIND v(dout1_229) AT=160.05n

.meas tran vdout1_230ck150 FIND v(dout1_230) AT=160.05n

.meas tran vdout1_231ck150 FIND v(dout1_231) AT=160.05n

.meas tran vdout1_232ck150 FIND v(dout1_232) AT=160.05n

.meas tran vdout1_233ck150 FIND v(dout1_233) AT=160.05n

.meas tran vdout1_234ck150 FIND v(dout1_234) AT=160.05n

.meas tran vdout1_235ck150 FIND v(dout1_235) AT=160.05n

.meas tran vdout1_236ck150 FIND v(dout1_236) AT=160.05n

.meas tran vdout1_237ck150 FIND v(dout1_237) AT=160.05n

.meas tran vdout1_238ck150 FIND v(dout1_238) AT=160.05n

.meas tran vdout1_239ck150 FIND v(dout1_239) AT=160.05n

.meas tran vdout1_240ck150 FIND v(dout1_240) AT=160.05n

.meas tran vdout1_241ck150 FIND v(dout1_241) AT=160.05n

.meas tran vdout1_242ck150 FIND v(dout1_242) AT=160.05n

.meas tran vdout1_243ck150 FIND v(dout1_243) AT=160.05n

.meas tran vdout1_244ck150 FIND v(dout1_244) AT=160.05n

.meas tran vdout1_245ck150 FIND v(dout1_245) AT=160.05n

.meas tran vdout1_246ck150 FIND v(dout1_246) AT=160.05n

.meas tran vdout1_247ck150 FIND v(dout1_247) AT=160.05n

.meas tran vdout1_248ck150 FIND v(dout1_248) AT=160.05n

.meas tran vdout1_249ck150 FIND v(dout1_249) AT=160.05n

.meas tran vdout1_250ck150 FIND v(dout1_250) AT=160.05n

.meas tran vdout1_251ck150 FIND v(dout1_251) AT=160.05n

.meas tran vdout1_252ck150 FIND v(dout1_252) AT=160.05n

.meas tran vdout1_253ck150 FIND v(dout1_253) AT=160.05n

.meas tran vdout1_254ck150 FIND v(dout1_254) AT=160.05n

.meas tran vdout1_255ck150 FIND v(dout1_255) AT=160.05n

.meas tran vdout1_256ck150 FIND v(dout1_256) AT=160.05n

.meas tran vdout1_0ck190 FIND v(dout1_0) AT=200.05n

.meas tran vdout1_1ck190 FIND v(dout1_1) AT=200.05n

.meas tran vdout1_2ck190 FIND v(dout1_2) AT=200.05n

.meas tran vdout1_3ck190 FIND v(dout1_3) AT=200.05n

.meas tran vdout1_4ck190 FIND v(dout1_4) AT=200.05n

.meas tran vdout1_5ck190 FIND v(dout1_5) AT=200.05n

.meas tran vdout1_6ck190 FIND v(dout1_6) AT=200.05n

.meas tran vdout1_7ck190 FIND v(dout1_7) AT=200.05n

.meas tran vdout1_8ck190 FIND v(dout1_8) AT=200.05n

.meas tran vdout1_9ck190 FIND v(dout1_9) AT=200.05n

.meas tran vdout1_10ck190 FIND v(dout1_10) AT=200.05n

.meas tran vdout1_11ck190 FIND v(dout1_11) AT=200.05n

.meas tran vdout1_12ck190 FIND v(dout1_12) AT=200.05n

.meas tran vdout1_13ck190 FIND v(dout1_13) AT=200.05n

.meas tran vdout1_14ck190 FIND v(dout1_14) AT=200.05n

.meas tran vdout1_15ck190 FIND v(dout1_15) AT=200.05n

.meas tran vdout1_16ck190 FIND v(dout1_16) AT=200.05n

.meas tran vdout1_17ck190 FIND v(dout1_17) AT=200.05n

.meas tran vdout1_18ck190 FIND v(dout1_18) AT=200.05n

.meas tran vdout1_19ck190 FIND v(dout1_19) AT=200.05n

.meas tran vdout1_20ck190 FIND v(dout1_20) AT=200.05n

.meas tran vdout1_21ck190 FIND v(dout1_21) AT=200.05n

.meas tran vdout1_22ck190 FIND v(dout1_22) AT=200.05n

.meas tran vdout1_23ck190 FIND v(dout1_23) AT=200.05n

.meas tran vdout1_24ck190 FIND v(dout1_24) AT=200.05n

.meas tran vdout1_25ck190 FIND v(dout1_25) AT=200.05n

.meas tran vdout1_26ck190 FIND v(dout1_26) AT=200.05n

.meas tran vdout1_27ck190 FIND v(dout1_27) AT=200.05n

.meas tran vdout1_28ck190 FIND v(dout1_28) AT=200.05n

.meas tran vdout1_29ck190 FIND v(dout1_29) AT=200.05n

.meas tran vdout1_30ck190 FIND v(dout1_30) AT=200.05n

.meas tran vdout1_31ck190 FIND v(dout1_31) AT=200.05n

.meas tran vdout1_32ck190 FIND v(dout1_32) AT=200.05n

.meas tran vdout1_33ck190 FIND v(dout1_33) AT=200.05n

.meas tran vdout1_34ck190 FIND v(dout1_34) AT=200.05n

.meas tran vdout1_35ck190 FIND v(dout1_35) AT=200.05n

.meas tran vdout1_36ck190 FIND v(dout1_36) AT=200.05n

.meas tran vdout1_37ck190 FIND v(dout1_37) AT=200.05n

.meas tran vdout1_38ck190 FIND v(dout1_38) AT=200.05n

.meas tran vdout1_39ck190 FIND v(dout1_39) AT=200.05n

.meas tran vdout1_40ck190 FIND v(dout1_40) AT=200.05n

.meas tran vdout1_41ck190 FIND v(dout1_41) AT=200.05n

.meas tran vdout1_42ck190 FIND v(dout1_42) AT=200.05n

.meas tran vdout1_43ck190 FIND v(dout1_43) AT=200.05n

.meas tran vdout1_44ck190 FIND v(dout1_44) AT=200.05n

.meas tran vdout1_45ck190 FIND v(dout1_45) AT=200.05n

.meas tran vdout1_46ck190 FIND v(dout1_46) AT=200.05n

.meas tran vdout1_47ck190 FIND v(dout1_47) AT=200.05n

.meas tran vdout1_48ck190 FIND v(dout1_48) AT=200.05n

.meas tran vdout1_49ck190 FIND v(dout1_49) AT=200.05n

.meas tran vdout1_50ck190 FIND v(dout1_50) AT=200.05n

.meas tran vdout1_51ck190 FIND v(dout1_51) AT=200.05n

.meas tran vdout1_52ck190 FIND v(dout1_52) AT=200.05n

.meas tran vdout1_53ck190 FIND v(dout1_53) AT=200.05n

.meas tran vdout1_54ck190 FIND v(dout1_54) AT=200.05n

.meas tran vdout1_55ck190 FIND v(dout1_55) AT=200.05n

.meas tran vdout1_56ck190 FIND v(dout1_56) AT=200.05n

.meas tran vdout1_57ck190 FIND v(dout1_57) AT=200.05n

.meas tran vdout1_58ck190 FIND v(dout1_58) AT=200.05n

.meas tran vdout1_59ck190 FIND v(dout1_59) AT=200.05n

.meas tran vdout1_60ck190 FIND v(dout1_60) AT=200.05n

.meas tran vdout1_61ck190 FIND v(dout1_61) AT=200.05n

.meas tran vdout1_62ck190 FIND v(dout1_62) AT=200.05n

.meas tran vdout1_63ck190 FIND v(dout1_63) AT=200.05n

.meas tran vdout1_64ck190 FIND v(dout1_64) AT=200.05n

.meas tran vdout1_65ck190 FIND v(dout1_65) AT=200.05n

.meas tran vdout1_66ck190 FIND v(dout1_66) AT=200.05n

.meas tran vdout1_67ck190 FIND v(dout1_67) AT=200.05n

.meas tran vdout1_68ck190 FIND v(dout1_68) AT=200.05n

.meas tran vdout1_69ck190 FIND v(dout1_69) AT=200.05n

.meas tran vdout1_70ck190 FIND v(dout1_70) AT=200.05n

.meas tran vdout1_71ck190 FIND v(dout1_71) AT=200.05n

.meas tran vdout1_72ck190 FIND v(dout1_72) AT=200.05n

.meas tran vdout1_73ck190 FIND v(dout1_73) AT=200.05n

.meas tran vdout1_74ck190 FIND v(dout1_74) AT=200.05n

.meas tran vdout1_75ck190 FIND v(dout1_75) AT=200.05n

.meas tran vdout1_76ck190 FIND v(dout1_76) AT=200.05n

.meas tran vdout1_77ck190 FIND v(dout1_77) AT=200.05n

.meas tran vdout1_78ck190 FIND v(dout1_78) AT=200.05n

.meas tran vdout1_79ck190 FIND v(dout1_79) AT=200.05n

.meas tran vdout1_80ck190 FIND v(dout1_80) AT=200.05n

.meas tran vdout1_81ck190 FIND v(dout1_81) AT=200.05n

.meas tran vdout1_82ck190 FIND v(dout1_82) AT=200.05n

.meas tran vdout1_83ck190 FIND v(dout1_83) AT=200.05n

.meas tran vdout1_84ck190 FIND v(dout1_84) AT=200.05n

.meas tran vdout1_85ck190 FIND v(dout1_85) AT=200.05n

.meas tran vdout1_86ck190 FIND v(dout1_86) AT=200.05n

.meas tran vdout1_87ck190 FIND v(dout1_87) AT=200.05n

.meas tran vdout1_88ck190 FIND v(dout1_88) AT=200.05n

.meas tran vdout1_89ck190 FIND v(dout1_89) AT=200.05n

.meas tran vdout1_90ck190 FIND v(dout1_90) AT=200.05n

.meas tran vdout1_91ck190 FIND v(dout1_91) AT=200.05n

.meas tran vdout1_92ck190 FIND v(dout1_92) AT=200.05n

.meas tran vdout1_93ck190 FIND v(dout1_93) AT=200.05n

.meas tran vdout1_94ck190 FIND v(dout1_94) AT=200.05n

.meas tran vdout1_95ck190 FIND v(dout1_95) AT=200.05n

.meas tran vdout1_96ck190 FIND v(dout1_96) AT=200.05n

.meas tran vdout1_97ck190 FIND v(dout1_97) AT=200.05n

.meas tran vdout1_98ck190 FIND v(dout1_98) AT=200.05n

.meas tran vdout1_99ck190 FIND v(dout1_99) AT=200.05n

.meas tran vdout1_100ck190 FIND v(dout1_100) AT=200.05n

.meas tran vdout1_101ck190 FIND v(dout1_101) AT=200.05n

.meas tran vdout1_102ck190 FIND v(dout1_102) AT=200.05n

.meas tran vdout1_103ck190 FIND v(dout1_103) AT=200.05n

.meas tran vdout1_104ck190 FIND v(dout1_104) AT=200.05n

.meas tran vdout1_105ck190 FIND v(dout1_105) AT=200.05n

.meas tran vdout1_106ck190 FIND v(dout1_106) AT=200.05n

.meas tran vdout1_107ck190 FIND v(dout1_107) AT=200.05n

.meas tran vdout1_108ck190 FIND v(dout1_108) AT=200.05n

.meas tran vdout1_109ck190 FIND v(dout1_109) AT=200.05n

.meas tran vdout1_110ck190 FIND v(dout1_110) AT=200.05n

.meas tran vdout1_111ck190 FIND v(dout1_111) AT=200.05n

.meas tran vdout1_112ck190 FIND v(dout1_112) AT=200.05n

.meas tran vdout1_113ck190 FIND v(dout1_113) AT=200.05n

.meas tran vdout1_114ck190 FIND v(dout1_114) AT=200.05n

.meas tran vdout1_115ck190 FIND v(dout1_115) AT=200.05n

.meas tran vdout1_116ck190 FIND v(dout1_116) AT=200.05n

.meas tran vdout1_117ck190 FIND v(dout1_117) AT=200.05n

.meas tran vdout1_118ck190 FIND v(dout1_118) AT=200.05n

.meas tran vdout1_119ck190 FIND v(dout1_119) AT=200.05n

.meas tran vdout1_120ck190 FIND v(dout1_120) AT=200.05n

.meas tran vdout1_121ck190 FIND v(dout1_121) AT=200.05n

.meas tran vdout1_122ck190 FIND v(dout1_122) AT=200.05n

.meas tran vdout1_123ck190 FIND v(dout1_123) AT=200.05n

.meas tran vdout1_124ck190 FIND v(dout1_124) AT=200.05n

.meas tran vdout1_125ck190 FIND v(dout1_125) AT=200.05n

.meas tran vdout1_126ck190 FIND v(dout1_126) AT=200.05n

.meas tran vdout1_127ck190 FIND v(dout1_127) AT=200.05n

.meas tran vdout1_128ck190 FIND v(dout1_128) AT=200.05n

.meas tran vdout1_129ck190 FIND v(dout1_129) AT=200.05n

.meas tran vdout1_130ck190 FIND v(dout1_130) AT=200.05n

.meas tran vdout1_131ck190 FIND v(dout1_131) AT=200.05n

.meas tran vdout1_132ck190 FIND v(dout1_132) AT=200.05n

.meas tran vdout1_133ck190 FIND v(dout1_133) AT=200.05n

.meas tran vdout1_134ck190 FIND v(dout1_134) AT=200.05n

.meas tran vdout1_135ck190 FIND v(dout1_135) AT=200.05n

.meas tran vdout1_136ck190 FIND v(dout1_136) AT=200.05n

.meas tran vdout1_137ck190 FIND v(dout1_137) AT=200.05n

.meas tran vdout1_138ck190 FIND v(dout1_138) AT=200.05n

.meas tran vdout1_139ck190 FIND v(dout1_139) AT=200.05n

.meas tran vdout1_140ck190 FIND v(dout1_140) AT=200.05n

.meas tran vdout1_141ck190 FIND v(dout1_141) AT=200.05n

.meas tran vdout1_142ck190 FIND v(dout1_142) AT=200.05n

.meas tran vdout1_143ck190 FIND v(dout1_143) AT=200.05n

.meas tran vdout1_144ck190 FIND v(dout1_144) AT=200.05n

.meas tran vdout1_145ck190 FIND v(dout1_145) AT=200.05n

.meas tran vdout1_146ck190 FIND v(dout1_146) AT=200.05n

.meas tran vdout1_147ck190 FIND v(dout1_147) AT=200.05n

.meas tran vdout1_148ck190 FIND v(dout1_148) AT=200.05n

.meas tran vdout1_149ck190 FIND v(dout1_149) AT=200.05n

.meas tran vdout1_150ck190 FIND v(dout1_150) AT=200.05n

.meas tran vdout1_151ck190 FIND v(dout1_151) AT=200.05n

.meas tran vdout1_152ck190 FIND v(dout1_152) AT=200.05n

.meas tran vdout1_153ck190 FIND v(dout1_153) AT=200.05n

.meas tran vdout1_154ck190 FIND v(dout1_154) AT=200.05n

.meas tran vdout1_155ck190 FIND v(dout1_155) AT=200.05n

.meas tran vdout1_156ck190 FIND v(dout1_156) AT=200.05n

.meas tran vdout1_157ck190 FIND v(dout1_157) AT=200.05n

.meas tran vdout1_158ck190 FIND v(dout1_158) AT=200.05n

.meas tran vdout1_159ck190 FIND v(dout1_159) AT=200.05n

.meas tran vdout1_160ck190 FIND v(dout1_160) AT=200.05n

.meas tran vdout1_161ck190 FIND v(dout1_161) AT=200.05n

.meas tran vdout1_162ck190 FIND v(dout1_162) AT=200.05n

.meas tran vdout1_163ck190 FIND v(dout1_163) AT=200.05n

.meas tran vdout1_164ck190 FIND v(dout1_164) AT=200.05n

.meas tran vdout1_165ck190 FIND v(dout1_165) AT=200.05n

.meas tran vdout1_166ck190 FIND v(dout1_166) AT=200.05n

.meas tran vdout1_167ck190 FIND v(dout1_167) AT=200.05n

.meas tran vdout1_168ck190 FIND v(dout1_168) AT=200.05n

.meas tran vdout1_169ck190 FIND v(dout1_169) AT=200.05n

.meas tran vdout1_170ck190 FIND v(dout1_170) AT=200.05n

.meas tran vdout1_171ck190 FIND v(dout1_171) AT=200.05n

.meas tran vdout1_172ck190 FIND v(dout1_172) AT=200.05n

.meas tran vdout1_173ck190 FIND v(dout1_173) AT=200.05n

.meas tran vdout1_174ck190 FIND v(dout1_174) AT=200.05n

.meas tran vdout1_175ck190 FIND v(dout1_175) AT=200.05n

.meas tran vdout1_176ck190 FIND v(dout1_176) AT=200.05n

.meas tran vdout1_177ck190 FIND v(dout1_177) AT=200.05n

.meas tran vdout1_178ck190 FIND v(dout1_178) AT=200.05n

.meas tran vdout1_179ck190 FIND v(dout1_179) AT=200.05n

.meas tran vdout1_180ck190 FIND v(dout1_180) AT=200.05n

.meas tran vdout1_181ck190 FIND v(dout1_181) AT=200.05n

.meas tran vdout1_182ck190 FIND v(dout1_182) AT=200.05n

.meas tran vdout1_183ck190 FIND v(dout1_183) AT=200.05n

.meas tran vdout1_184ck190 FIND v(dout1_184) AT=200.05n

.meas tran vdout1_185ck190 FIND v(dout1_185) AT=200.05n

.meas tran vdout1_186ck190 FIND v(dout1_186) AT=200.05n

.meas tran vdout1_187ck190 FIND v(dout1_187) AT=200.05n

.meas tran vdout1_188ck190 FIND v(dout1_188) AT=200.05n

.meas tran vdout1_189ck190 FIND v(dout1_189) AT=200.05n

.meas tran vdout1_190ck190 FIND v(dout1_190) AT=200.05n

.meas tran vdout1_191ck190 FIND v(dout1_191) AT=200.05n

.meas tran vdout1_192ck190 FIND v(dout1_192) AT=200.05n

.meas tran vdout1_193ck190 FIND v(dout1_193) AT=200.05n

.meas tran vdout1_194ck190 FIND v(dout1_194) AT=200.05n

.meas tran vdout1_195ck190 FIND v(dout1_195) AT=200.05n

.meas tran vdout1_196ck190 FIND v(dout1_196) AT=200.05n

.meas tran vdout1_197ck190 FIND v(dout1_197) AT=200.05n

.meas tran vdout1_198ck190 FIND v(dout1_198) AT=200.05n

.meas tran vdout1_199ck190 FIND v(dout1_199) AT=200.05n

.meas tran vdout1_200ck190 FIND v(dout1_200) AT=200.05n

.meas tran vdout1_201ck190 FIND v(dout1_201) AT=200.05n

.meas tran vdout1_202ck190 FIND v(dout1_202) AT=200.05n

.meas tran vdout1_203ck190 FIND v(dout1_203) AT=200.05n

.meas tran vdout1_204ck190 FIND v(dout1_204) AT=200.05n

.meas tran vdout1_205ck190 FIND v(dout1_205) AT=200.05n

.meas tran vdout1_206ck190 FIND v(dout1_206) AT=200.05n

.meas tran vdout1_207ck190 FIND v(dout1_207) AT=200.05n

.meas tran vdout1_208ck190 FIND v(dout1_208) AT=200.05n

.meas tran vdout1_209ck190 FIND v(dout1_209) AT=200.05n

.meas tran vdout1_210ck190 FIND v(dout1_210) AT=200.05n

.meas tran vdout1_211ck190 FIND v(dout1_211) AT=200.05n

.meas tran vdout1_212ck190 FIND v(dout1_212) AT=200.05n

.meas tran vdout1_213ck190 FIND v(dout1_213) AT=200.05n

.meas tran vdout1_214ck190 FIND v(dout1_214) AT=200.05n

.meas tran vdout1_215ck190 FIND v(dout1_215) AT=200.05n

.meas tran vdout1_216ck190 FIND v(dout1_216) AT=200.05n

.meas tran vdout1_217ck190 FIND v(dout1_217) AT=200.05n

.meas tran vdout1_218ck190 FIND v(dout1_218) AT=200.05n

.meas tran vdout1_219ck190 FIND v(dout1_219) AT=200.05n

.meas tran vdout1_220ck190 FIND v(dout1_220) AT=200.05n

.meas tran vdout1_221ck190 FIND v(dout1_221) AT=200.05n

.meas tran vdout1_222ck190 FIND v(dout1_222) AT=200.05n

.meas tran vdout1_223ck190 FIND v(dout1_223) AT=200.05n

.meas tran vdout1_224ck190 FIND v(dout1_224) AT=200.05n

.meas tran vdout1_225ck190 FIND v(dout1_225) AT=200.05n

.meas tran vdout1_226ck190 FIND v(dout1_226) AT=200.05n

.meas tran vdout1_227ck190 FIND v(dout1_227) AT=200.05n

.meas tran vdout1_228ck190 FIND v(dout1_228) AT=200.05n

.meas tran vdout1_229ck190 FIND v(dout1_229) AT=200.05n

.meas tran vdout1_230ck190 FIND v(dout1_230) AT=200.05n

.meas tran vdout1_231ck190 FIND v(dout1_231) AT=200.05n

.meas tran vdout1_232ck190 FIND v(dout1_232) AT=200.05n

.meas tran vdout1_233ck190 FIND v(dout1_233) AT=200.05n

.meas tran vdout1_234ck190 FIND v(dout1_234) AT=200.05n

.meas tran vdout1_235ck190 FIND v(dout1_235) AT=200.05n

.meas tran vdout1_236ck190 FIND v(dout1_236) AT=200.05n

.meas tran vdout1_237ck190 FIND v(dout1_237) AT=200.05n

.meas tran vdout1_238ck190 FIND v(dout1_238) AT=200.05n

.meas tran vdout1_239ck190 FIND v(dout1_239) AT=200.05n

.meas tran vdout1_240ck190 FIND v(dout1_240) AT=200.05n

.meas tran vdout1_241ck190 FIND v(dout1_241) AT=200.05n

.meas tran vdout1_242ck190 FIND v(dout1_242) AT=200.05n

.meas tran vdout1_243ck190 FIND v(dout1_243) AT=200.05n

.meas tran vdout1_244ck190 FIND v(dout1_244) AT=200.05n

.meas tran vdout1_245ck190 FIND v(dout1_245) AT=200.05n

.meas tran vdout1_246ck190 FIND v(dout1_246) AT=200.05n

.meas tran vdout1_247ck190 FIND v(dout1_247) AT=200.05n

.meas tran vdout1_248ck190 FIND v(dout1_248) AT=200.05n

.meas tran vdout1_249ck190 FIND v(dout1_249) AT=200.05n

.meas tran vdout1_250ck190 FIND v(dout1_250) AT=200.05n

.meas tran vdout1_251ck190 FIND v(dout1_251) AT=200.05n

.meas tran vdout1_252ck190 FIND v(dout1_252) AT=200.05n

.meas tran vdout1_253ck190 FIND v(dout1_253) AT=200.05n

.meas tran vdout1_254ck190 FIND v(dout1_254) AT=200.05n

.meas tran vdout1_255ck190 FIND v(dout1_255) AT=200.05n

.meas tran vdout1_256ck190 FIND v(dout1_256) AT=200.05n

.meas tran vdout1_0ck220 FIND v(dout1_0) AT=230.05n

.meas tran vdout1_1ck220 FIND v(dout1_1) AT=230.05n

.meas tran vdout1_2ck220 FIND v(dout1_2) AT=230.05n

.meas tran vdout1_3ck220 FIND v(dout1_3) AT=230.05n

.meas tran vdout1_4ck220 FIND v(dout1_4) AT=230.05n

.meas tran vdout1_5ck220 FIND v(dout1_5) AT=230.05n

.meas tran vdout1_6ck220 FIND v(dout1_6) AT=230.05n

.meas tran vdout1_7ck220 FIND v(dout1_7) AT=230.05n

.meas tran vdout1_8ck220 FIND v(dout1_8) AT=230.05n

.meas tran vdout1_9ck220 FIND v(dout1_9) AT=230.05n

.meas tran vdout1_10ck220 FIND v(dout1_10) AT=230.05n

.meas tran vdout1_11ck220 FIND v(dout1_11) AT=230.05n

.meas tran vdout1_12ck220 FIND v(dout1_12) AT=230.05n

.meas tran vdout1_13ck220 FIND v(dout1_13) AT=230.05n

.meas tran vdout1_14ck220 FIND v(dout1_14) AT=230.05n

.meas tran vdout1_15ck220 FIND v(dout1_15) AT=230.05n

.meas tran vdout1_16ck220 FIND v(dout1_16) AT=230.05n

.meas tran vdout1_17ck220 FIND v(dout1_17) AT=230.05n

.meas tran vdout1_18ck220 FIND v(dout1_18) AT=230.05n

.meas tran vdout1_19ck220 FIND v(dout1_19) AT=230.05n

.meas tran vdout1_20ck220 FIND v(dout1_20) AT=230.05n

.meas tran vdout1_21ck220 FIND v(dout1_21) AT=230.05n

.meas tran vdout1_22ck220 FIND v(dout1_22) AT=230.05n

.meas tran vdout1_23ck220 FIND v(dout1_23) AT=230.05n

.meas tran vdout1_24ck220 FIND v(dout1_24) AT=230.05n

.meas tran vdout1_25ck220 FIND v(dout1_25) AT=230.05n

.meas tran vdout1_26ck220 FIND v(dout1_26) AT=230.05n

.meas tran vdout1_27ck220 FIND v(dout1_27) AT=230.05n

.meas tran vdout1_28ck220 FIND v(dout1_28) AT=230.05n

.meas tran vdout1_29ck220 FIND v(dout1_29) AT=230.05n

.meas tran vdout1_30ck220 FIND v(dout1_30) AT=230.05n

.meas tran vdout1_31ck220 FIND v(dout1_31) AT=230.05n

.meas tran vdout1_32ck220 FIND v(dout1_32) AT=230.05n

.meas tran vdout1_33ck220 FIND v(dout1_33) AT=230.05n

.meas tran vdout1_34ck220 FIND v(dout1_34) AT=230.05n

.meas tran vdout1_35ck220 FIND v(dout1_35) AT=230.05n

.meas tran vdout1_36ck220 FIND v(dout1_36) AT=230.05n

.meas tran vdout1_37ck220 FIND v(dout1_37) AT=230.05n

.meas tran vdout1_38ck220 FIND v(dout1_38) AT=230.05n

.meas tran vdout1_39ck220 FIND v(dout1_39) AT=230.05n

.meas tran vdout1_40ck220 FIND v(dout1_40) AT=230.05n

.meas tran vdout1_41ck220 FIND v(dout1_41) AT=230.05n

.meas tran vdout1_42ck220 FIND v(dout1_42) AT=230.05n

.meas tran vdout1_43ck220 FIND v(dout1_43) AT=230.05n

.meas tran vdout1_44ck220 FIND v(dout1_44) AT=230.05n

.meas tran vdout1_45ck220 FIND v(dout1_45) AT=230.05n

.meas tran vdout1_46ck220 FIND v(dout1_46) AT=230.05n

.meas tran vdout1_47ck220 FIND v(dout1_47) AT=230.05n

.meas tran vdout1_48ck220 FIND v(dout1_48) AT=230.05n

.meas tran vdout1_49ck220 FIND v(dout1_49) AT=230.05n

.meas tran vdout1_50ck220 FIND v(dout1_50) AT=230.05n

.meas tran vdout1_51ck220 FIND v(dout1_51) AT=230.05n

.meas tran vdout1_52ck220 FIND v(dout1_52) AT=230.05n

.meas tran vdout1_53ck220 FIND v(dout1_53) AT=230.05n

.meas tran vdout1_54ck220 FIND v(dout1_54) AT=230.05n

.meas tran vdout1_55ck220 FIND v(dout1_55) AT=230.05n

.meas tran vdout1_56ck220 FIND v(dout1_56) AT=230.05n

.meas tran vdout1_57ck220 FIND v(dout1_57) AT=230.05n

.meas tran vdout1_58ck220 FIND v(dout1_58) AT=230.05n

.meas tran vdout1_59ck220 FIND v(dout1_59) AT=230.05n

.meas tran vdout1_60ck220 FIND v(dout1_60) AT=230.05n

.meas tran vdout1_61ck220 FIND v(dout1_61) AT=230.05n

.meas tran vdout1_62ck220 FIND v(dout1_62) AT=230.05n

.meas tran vdout1_63ck220 FIND v(dout1_63) AT=230.05n

.meas tran vdout1_64ck220 FIND v(dout1_64) AT=230.05n

.meas tran vdout1_65ck220 FIND v(dout1_65) AT=230.05n

.meas tran vdout1_66ck220 FIND v(dout1_66) AT=230.05n

.meas tran vdout1_67ck220 FIND v(dout1_67) AT=230.05n

.meas tran vdout1_68ck220 FIND v(dout1_68) AT=230.05n

.meas tran vdout1_69ck220 FIND v(dout1_69) AT=230.05n

.meas tran vdout1_70ck220 FIND v(dout1_70) AT=230.05n

.meas tran vdout1_71ck220 FIND v(dout1_71) AT=230.05n

.meas tran vdout1_72ck220 FIND v(dout1_72) AT=230.05n

.meas tran vdout1_73ck220 FIND v(dout1_73) AT=230.05n

.meas tran vdout1_74ck220 FIND v(dout1_74) AT=230.05n

.meas tran vdout1_75ck220 FIND v(dout1_75) AT=230.05n

.meas tran vdout1_76ck220 FIND v(dout1_76) AT=230.05n

.meas tran vdout1_77ck220 FIND v(dout1_77) AT=230.05n

.meas tran vdout1_78ck220 FIND v(dout1_78) AT=230.05n

.meas tran vdout1_79ck220 FIND v(dout1_79) AT=230.05n

.meas tran vdout1_80ck220 FIND v(dout1_80) AT=230.05n

.meas tran vdout1_81ck220 FIND v(dout1_81) AT=230.05n

.meas tran vdout1_82ck220 FIND v(dout1_82) AT=230.05n

.meas tran vdout1_83ck220 FIND v(dout1_83) AT=230.05n

.meas tran vdout1_84ck220 FIND v(dout1_84) AT=230.05n

.meas tran vdout1_85ck220 FIND v(dout1_85) AT=230.05n

.meas tran vdout1_86ck220 FIND v(dout1_86) AT=230.05n

.meas tran vdout1_87ck220 FIND v(dout1_87) AT=230.05n

.meas tran vdout1_88ck220 FIND v(dout1_88) AT=230.05n

.meas tran vdout1_89ck220 FIND v(dout1_89) AT=230.05n

.meas tran vdout1_90ck220 FIND v(dout1_90) AT=230.05n

.meas tran vdout1_91ck220 FIND v(dout1_91) AT=230.05n

.meas tran vdout1_92ck220 FIND v(dout1_92) AT=230.05n

.meas tran vdout1_93ck220 FIND v(dout1_93) AT=230.05n

.meas tran vdout1_94ck220 FIND v(dout1_94) AT=230.05n

.meas tran vdout1_95ck220 FIND v(dout1_95) AT=230.05n

.meas tran vdout1_96ck220 FIND v(dout1_96) AT=230.05n

.meas tran vdout1_97ck220 FIND v(dout1_97) AT=230.05n

.meas tran vdout1_98ck220 FIND v(dout1_98) AT=230.05n

.meas tran vdout1_99ck220 FIND v(dout1_99) AT=230.05n

.meas tran vdout1_100ck220 FIND v(dout1_100) AT=230.05n

.meas tran vdout1_101ck220 FIND v(dout1_101) AT=230.05n

.meas tran vdout1_102ck220 FIND v(dout1_102) AT=230.05n

.meas tran vdout1_103ck220 FIND v(dout1_103) AT=230.05n

.meas tran vdout1_104ck220 FIND v(dout1_104) AT=230.05n

.meas tran vdout1_105ck220 FIND v(dout1_105) AT=230.05n

.meas tran vdout1_106ck220 FIND v(dout1_106) AT=230.05n

.meas tran vdout1_107ck220 FIND v(dout1_107) AT=230.05n

.meas tran vdout1_108ck220 FIND v(dout1_108) AT=230.05n

.meas tran vdout1_109ck220 FIND v(dout1_109) AT=230.05n

.meas tran vdout1_110ck220 FIND v(dout1_110) AT=230.05n

.meas tran vdout1_111ck220 FIND v(dout1_111) AT=230.05n

.meas tran vdout1_112ck220 FIND v(dout1_112) AT=230.05n

.meas tran vdout1_113ck220 FIND v(dout1_113) AT=230.05n

.meas tran vdout1_114ck220 FIND v(dout1_114) AT=230.05n

.meas tran vdout1_115ck220 FIND v(dout1_115) AT=230.05n

.meas tran vdout1_116ck220 FIND v(dout1_116) AT=230.05n

.meas tran vdout1_117ck220 FIND v(dout1_117) AT=230.05n

.meas tran vdout1_118ck220 FIND v(dout1_118) AT=230.05n

.meas tran vdout1_119ck220 FIND v(dout1_119) AT=230.05n

.meas tran vdout1_120ck220 FIND v(dout1_120) AT=230.05n

.meas tran vdout1_121ck220 FIND v(dout1_121) AT=230.05n

.meas tran vdout1_122ck220 FIND v(dout1_122) AT=230.05n

.meas tran vdout1_123ck220 FIND v(dout1_123) AT=230.05n

.meas tran vdout1_124ck220 FIND v(dout1_124) AT=230.05n

.meas tran vdout1_125ck220 FIND v(dout1_125) AT=230.05n

.meas tran vdout1_126ck220 FIND v(dout1_126) AT=230.05n

.meas tran vdout1_127ck220 FIND v(dout1_127) AT=230.05n

.meas tran vdout1_128ck220 FIND v(dout1_128) AT=230.05n

.meas tran vdout1_129ck220 FIND v(dout1_129) AT=230.05n

.meas tran vdout1_130ck220 FIND v(dout1_130) AT=230.05n

.meas tran vdout1_131ck220 FIND v(dout1_131) AT=230.05n

.meas tran vdout1_132ck220 FIND v(dout1_132) AT=230.05n

.meas tran vdout1_133ck220 FIND v(dout1_133) AT=230.05n

.meas tran vdout1_134ck220 FIND v(dout1_134) AT=230.05n

.meas tran vdout1_135ck220 FIND v(dout1_135) AT=230.05n

.meas tran vdout1_136ck220 FIND v(dout1_136) AT=230.05n

.meas tran vdout1_137ck220 FIND v(dout1_137) AT=230.05n

.meas tran vdout1_138ck220 FIND v(dout1_138) AT=230.05n

.meas tran vdout1_139ck220 FIND v(dout1_139) AT=230.05n

.meas tran vdout1_140ck220 FIND v(dout1_140) AT=230.05n

.meas tran vdout1_141ck220 FIND v(dout1_141) AT=230.05n

.meas tran vdout1_142ck220 FIND v(dout1_142) AT=230.05n

.meas tran vdout1_143ck220 FIND v(dout1_143) AT=230.05n

.meas tran vdout1_144ck220 FIND v(dout1_144) AT=230.05n

.meas tran vdout1_145ck220 FIND v(dout1_145) AT=230.05n

.meas tran vdout1_146ck220 FIND v(dout1_146) AT=230.05n

.meas tran vdout1_147ck220 FIND v(dout1_147) AT=230.05n

.meas tran vdout1_148ck220 FIND v(dout1_148) AT=230.05n

.meas tran vdout1_149ck220 FIND v(dout1_149) AT=230.05n

.meas tran vdout1_150ck220 FIND v(dout1_150) AT=230.05n

.meas tran vdout1_151ck220 FIND v(dout1_151) AT=230.05n

.meas tran vdout1_152ck220 FIND v(dout1_152) AT=230.05n

.meas tran vdout1_153ck220 FIND v(dout1_153) AT=230.05n

.meas tran vdout1_154ck220 FIND v(dout1_154) AT=230.05n

.meas tran vdout1_155ck220 FIND v(dout1_155) AT=230.05n

.meas tran vdout1_156ck220 FIND v(dout1_156) AT=230.05n

.meas tran vdout1_157ck220 FIND v(dout1_157) AT=230.05n

.meas tran vdout1_158ck220 FIND v(dout1_158) AT=230.05n

.meas tran vdout1_159ck220 FIND v(dout1_159) AT=230.05n

.meas tran vdout1_160ck220 FIND v(dout1_160) AT=230.05n

.meas tran vdout1_161ck220 FIND v(dout1_161) AT=230.05n

.meas tran vdout1_162ck220 FIND v(dout1_162) AT=230.05n

.meas tran vdout1_163ck220 FIND v(dout1_163) AT=230.05n

.meas tran vdout1_164ck220 FIND v(dout1_164) AT=230.05n

.meas tran vdout1_165ck220 FIND v(dout1_165) AT=230.05n

.meas tran vdout1_166ck220 FIND v(dout1_166) AT=230.05n

.meas tran vdout1_167ck220 FIND v(dout1_167) AT=230.05n

.meas tran vdout1_168ck220 FIND v(dout1_168) AT=230.05n

.meas tran vdout1_169ck220 FIND v(dout1_169) AT=230.05n

.meas tran vdout1_170ck220 FIND v(dout1_170) AT=230.05n

.meas tran vdout1_171ck220 FIND v(dout1_171) AT=230.05n

.meas tran vdout1_172ck220 FIND v(dout1_172) AT=230.05n

.meas tran vdout1_173ck220 FIND v(dout1_173) AT=230.05n

.meas tran vdout1_174ck220 FIND v(dout1_174) AT=230.05n

.meas tran vdout1_175ck220 FIND v(dout1_175) AT=230.05n

.meas tran vdout1_176ck220 FIND v(dout1_176) AT=230.05n

.meas tran vdout1_177ck220 FIND v(dout1_177) AT=230.05n

.meas tran vdout1_178ck220 FIND v(dout1_178) AT=230.05n

.meas tran vdout1_179ck220 FIND v(dout1_179) AT=230.05n

.meas tran vdout1_180ck220 FIND v(dout1_180) AT=230.05n

.meas tran vdout1_181ck220 FIND v(dout1_181) AT=230.05n

.meas tran vdout1_182ck220 FIND v(dout1_182) AT=230.05n

.meas tran vdout1_183ck220 FIND v(dout1_183) AT=230.05n

.meas tran vdout1_184ck220 FIND v(dout1_184) AT=230.05n

.meas tran vdout1_185ck220 FIND v(dout1_185) AT=230.05n

.meas tran vdout1_186ck220 FIND v(dout1_186) AT=230.05n

.meas tran vdout1_187ck220 FIND v(dout1_187) AT=230.05n

.meas tran vdout1_188ck220 FIND v(dout1_188) AT=230.05n

.meas tran vdout1_189ck220 FIND v(dout1_189) AT=230.05n

.meas tran vdout1_190ck220 FIND v(dout1_190) AT=230.05n

.meas tran vdout1_191ck220 FIND v(dout1_191) AT=230.05n

.meas tran vdout1_192ck220 FIND v(dout1_192) AT=230.05n

.meas tran vdout1_193ck220 FIND v(dout1_193) AT=230.05n

.meas tran vdout1_194ck220 FIND v(dout1_194) AT=230.05n

.meas tran vdout1_195ck220 FIND v(dout1_195) AT=230.05n

.meas tran vdout1_196ck220 FIND v(dout1_196) AT=230.05n

.meas tran vdout1_197ck220 FIND v(dout1_197) AT=230.05n

.meas tran vdout1_198ck220 FIND v(dout1_198) AT=230.05n

.meas tran vdout1_199ck220 FIND v(dout1_199) AT=230.05n

.meas tran vdout1_200ck220 FIND v(dout1_200) AT=230.05n

.meas tran vdout1_201ck220 FIND v(dout1_201) AT=230.05n

.meas tran vdout1_202ck220 FIND v(dout1_202) AT=230.05n

.meas tran vdout1_203ck220 FIND v(dout1_203) AT=230.05n

.meas tran vdout1_204ck220 FIND v(dout1_204) AT=230.05n

.meas tran vdout1_205ck220 FIND v(dout1_205) AT=230.05n

.meas tran vdout1_206ck220 FIND v(dout1_206) AT=230.05n

.meas tran vdout1_207ck220 FIND v(dout1_207) AT=230.05n

.meas tran vdout1_208ck220 FIND v(dout1_208) AT=230.05n

.meas tran vdout1_209ck220 FIND v(dout1_209) AT=230.05n

.meas tran vdout1_210ck220 FIND v(dout1_210) AT=230.05n

.meas tran vdout1_211ck220 FIND v(dout1_211) AT=230.05n

.meas tran vdout1_212ck220 FIND v(dout1_212) AT=230.05n

.meas tran vdout1_213ck220 FIND v(dout1_213) AT=230.05n

.meas tran vdout1_214ck220 FIND v(dout1_214) AT=230.05n

.meas tran vdout1_215ck220 FIND v(dout1_215) AT=230.05n

.meas tran vdout1_216ck220 FIND v(dout1_216) AT=230.05n

.meas tran vdout1_217ck220 FIND v(dout1_217) AT=230.05n

.meas tran vdout1_218ck220 FIND v(dout1_218) AT=230.05n

.meas tran vdout1_219ck220 FIND v(dout1_219) AT=230.05n

.meas tran vdout1_220ck220 FIND v(dout1_220) AT=230.05n

.meas tran vdout1_221ck220 FIND v(dout1_221) AT=230.05n

.meas tran vdout1_222ck220 FIND v(dout1_222) AT=230.05n

.meas tran vdout1_223ck220 FIND v(dout1_223) AT=230.05n

.meas tran vdout1_224ck220 FIND v(dout1_224) AT=230.05n

.meas tran vdout1_225ck220 FIND v(dout1_225) AT=230.05n

.meas tran vdout1_226ck220 FIND v(dout1_226) AT=230.05n

.meas tran vdout1_227ck220 FIND v(dout1_227) AT=230.05n

.meas tran vdout1_228ck220 FIND v(dout1_228) AT=230.05n

.meas tran vdout1_229ck220 FIND v(dout1_229) AT=230.05n

.meas tran vdout1_230ck220 FIND v(dout1_230) AT=230.05n

.meas tran vdout1_231ck220 FIND v(dout1_231) AT=230.05n

.meas tran vdout1_232ck220 FIND v(dout1_232) AT=230.05n

.meas tran vdout1_233ck220 FIND v(dout1_233) AT=230.05n

.meas tran vdout1_234ck220 FIND v(dout1_234) AT=230.05n

.meas tran vdout1_235ck220 FIND v(dout1_235) AT=230.05n

.meas tran vdout1_236ck220 FIND v(dout1_236) AT=230.05n

.meas tran vdout1_237ck220 FIND v(dout1_237) AT=230.05n

.meas tran vdout1_238ck220 FIND v(dout1_238) AT=230.05n

.meas tran vdout1_239ck220 FIND v(dout1_239) AT=230.05n

.meas tran vdout1_240ck220 FIND v(dout1_240) AT=230.05n

.meas tran vdout1_241ck220 FIND v(dout1_241) AT=230.05n

.meas tran vdout1_242ck220 FIND v(dout1_242) AT=230.05n

.meas tran vdout1_243ck220 FIND v(dout1_243) AT=230.05n

.meas tran vdout1_244ck220 FIND v(dout1_244) AT=230.05n

.meas tran vdout1_245ck220 FIND v(dout1_245) AT=230.05n

.meas tran vdout1_246ck220 FIND v(dout1_246) AT=230.05n

.meas tran vdout1_247ck220 FIND v(dout1_247) AT=230.05n

.meas tran vdout1_248ck220 FIND v(dout1_248) AT=230.05n

.meas tran vdout1_249ck220 FIND v(dout1_249) AT=230.05n

.meas tran vdout1_250ck220 FIND v(dout1_250) AT=230.05n

.meas tran vdout1_251ck220 FIND v(dout1_251) AT=230.05n

.meas tran vdout1_252ck220 FIND v(dout1_252) AT=230.05n

.meas tran vdout1_253ck220 FIND v(dout1_253) AT=230.05n

.meas tran vdout1_254ck220 FIND v(dout1_254) AT=230.05n

.meas tran vdout1_255ck220 FIND v(dout1_255) AT=230.05n

.meas tran vdout1_256ck220 FIND v(dout1_256) AT=230.05n

.meas tran vdout1_0ck240 FIND v(dout1_0) AT=250.05n

.meas tran vdout1_1ck240 FIND v(dout1_1) AT=250.05n

.meas tran vdout1_2ck240 FIND v(dout1_2) AT=250.05n

.meas tran vdout1_3ck240 FIND v(dout1_3) AT=250.05n

.meas tran vdout1_4ck240 FIND v(dout1_4) AT=250.05n

.meas tran vdout1_5ck240 FIND v(dout1_5) AT=250.05n

.meas tran vdout1_6ck240 FIND v(dout1_6) AT=250.05n

.meas tran vdout1_7ck240 FIND v(dout1_7) AT=250.05n

.meas tran vdout1_8ck240 FIND v(dout1_8) AT=250.05n

.meas tran vdout1_9ck240 FIND v(dout1_9) AT=250.05n

.meas tran vdout1_10ck240 FIND v(dout1_10) AT=250.05n

.meas tran vdout1_11ck240 FIND v(dout1_11) AT=250.05n

.meas tran vdout1_12ck240 FIND v(dout1_12) AT=250.05n

.meas tran vdout1_13ck240 FIND v(dout1_13) AT=250.05n

.meas tran vdout1_14ck240 FIND v(dout1_14) AT=250.05n

.meas tran vdout1_15ck240 FIND v(dout1_15) AT=250.05n

.meas tran vdout1_16ck240 FIND v(dout1_16) AT=250.05n

.meas tran vdout1_17ck240 FIND v(dout1_17) AT=250.05n

.meas tran vdout1_18ck240 FIND v(dout1_18) AT=250.05n

.meas tran vdout1_19ck240 FIND v(dout1_19) AT=250.05n

.meas tran vdout1_20ck240 FIND v(dout1_20) AT=250.05n

.meas tran vdout1_21ck240 FIND v(dout1_21) AT=250.05n

.meas tran vdout1_22ck240 FIND v(dout1_22) AT=250.05n

.meas tran vdout1_23ck240 FIND v(dout1_23) AT=250.05n

.meas tran vdout1_24ck240 FIND v(dout1_24) AT=250.05n

.meas tran vdout1_25ck240 FIND v(dout1_25) AT=250.05n

.meas tran vdout1_26ck240 FIND v(dout1_26) AT=250.05n

.meas tran vdout1_27ck240 FIND v(dout1_27) AT=250.05n

.meas tran vdout1_28ck240 FIND v(dout1_28) AT=250.05n

.meas tran vdout1_29ck240 FIND v(dout1_29) AT=250.05n

.meas tran vdout1_30ck240 FIND v(dout1_30) AT=250.05n

.meas tran vdout1_31ck240 FIND v(dout1_31) AT=250.05n

.meas tran vdout1_32ck240 FIND v(dout1_32) AT=250.05n

.meas tran vdout1_33ck240 FIND v(dout1_33) AT=250.05n

.meas tran vdout1_34ck240 FIND v(dout1_34) AT=250.05n

.meas tran vdout1_35ck240 FIND v(dout1_35) AT=250.05n

.meas tran vdout1_36ck240 FIND v(dout1_36) AT=250.05n

.meas tran vdout1_37ck240 FIND v(dout1_37) AT=250.05n

.meas tran vdout1_38ck240 FIND v(dout1_38) AT=250.05n

.meas tran vdout1_39ck240 FIND v(dout1_39) AT=250.05n

.meas tran vdout1_40ck240 FIND v(dout1_40) AT=250.05n

.meas tran vdout1_41ck240 FIND v(dout1_41) AT=250.05n

.meas tran vdout1_42ck240 FIND v(dout1_42) AT=250.05n

.meas tran vdout1_43ck240 FIND v(dout1_43) AT=250.05n

.meas tran vdout1_44ck240 FIND v(dout1_44) AT=250.05n

.meas tran vdout1_45ck240 FIND v(dout1_45) AT=250.05n

.meas tran vdout1_46ck240 FIND v(dout1_46) AT=250.05n

.meas tran vdout1_47ck240 FIND v(dout1_47) AT=250.05n

.meas tran vdout1_48ck240 FIND v(dout1_48) AT=250.05n

.meas tran vdout1_49ck240 FIND v(dout1_49) AT=250.05n

.meas tran vdout1_50ck240 FIND v(dout1_50) AT=250.05n

.meas tran vdout1_51ck240 FIND v(dout1_51) AT=250.05n

.meas tran vdout1_52ck240 FIND v(dout1_52) AT=250.05n

.meas tran vdout1_53ck240 FIND v(dout1_53) AT=250.05n

.meas tran vdout1_54ck240 FIND v(dout1_54) AT=250.05n

.meas tran vdout1_55ck240 FIND v(dout1_55) AT=250.05n

.meas tran vdout1_56ck240 FIND v(dout1_56) AT=250.05n

.meas tran vdout1_57ck240 FIND v(dout1_57) AT=250.05n

.meas tran vdout1_58ck240 FIND v(dout1_58) AT=250.05n

.meas tran vdout1_59ck240 FIND v(dout1_59) AT=250.05n

.meas tran vdout1_60ck240 FIND v(dout1_60) AT=250.05n

.meas tran vdout1_61ck240 FIND v(dout1_61) AT=250.05n

.meas tran vdout1_62ck240 FIND v(dout1_62) AT=250.05n

.meas tran vdout1_63ck240 FIND v(dout1_63) AT=250.05n

.meas tran vdout1_64ck240 FIND v(dout1_64) AT=250.05n

.meas tran vdout1_65ck240 FIND v(dout1_65) AT=250.05n

.meas tran vdout1_66ck240 FIND v(dout1_66) AT=250.05n

.meas tran vdout1_67ck240 FIND v(dout1_67) AT=250.05n

.meas tran vdout1_68ck240 FIND v(dout1_68) AT=250.05n

.meas tran vdout1_69ck240 FIND v(dout1_69) AT=250.05n

.meas tran vdout1_70ck240 FIND v(dout1_70) AT=250.05n

.meas tran vdout1_71ck240 FIND v(dout1_71) AT=250.05n

.meas tran vdout1_72ck240 FIND v(dout1_72) AT=250.05n

.meas tran vdout1_73ck240 FIND v(dout1_73) AT=250.05n

.meas tran vdout1_74ck240 FIND v(dout1_74) AT=250.05n

.meas tran vdout1_75ck240 FIND v(dout1_75) AT=250.05n

.meas tran vdout1_76ck240 FIND v(dout1_76) AT=250.05n

.meas tran vdout1_77ck240 FIND v(dout1_77) AT=250.05n

.meas tran vdout1_78ck240 FIND v(dout1_78) AT=250.05n

.meas tran vdout1_79ck240 FIND v(dout1_79) AT=250.05n

.meas tran vdout1_80ck240 FIND v(dout1_80) AT=250.05n

.meas tran vdout1_81ck240 FIND v(dout1_81) AT=250.05n

.meas tran vdout1_82ck240 FIND v(dout1_82) AT=250.05n

.meas tran vdout1_83ck240 FIND v(dout1_83) AT=250.05n

.meas tran vdout1_84ck240 FIND v(dout1_84) AT=250.05n

.meas tran vdout1_85ck240 FIND v(dout1_85) AT=250.05n

.meas tran vdout1_86ck240 FIND v(dout1_86) AT=250.05n

.meas tran vdout1_87ck240 FIND v(dout1_87) AT=250.05n

.meas tran vdout1_88ck240 FIND v(dout1_88) AT=250.05n

.meas tran vdout1_89ck240 FIND v(dout1_89) AT=250.05n

.meas tran vdout1_90ck240 FIND v(dout1_90) AT=250.05n

.meas tran vdout1_91ck240 FIND v(dout1_91) AT=250.05n

.meas tran vdout1_92ck240 FIND v(dout1_92) AT=250.05n

.meas tran vdout1_93ck240 FIND v(dout1_93) AT=250.05n

.meas tran vdout1_94ck240 FIND v(dout1_94) AT=250.05n

.meas tran vdout1_95ck240 FIND v(dout1_95) AT=250.05n

.meas tran vdout1_96ck240 FIND v(dout1_96) AT=250.05n

.meas tran vdout1_97ck240 FIND v(dout1_97) AT=250.05n

.meas tran vdout1_98ck240 FIND v(dout1_98) AT=250.05n

.meas tran vdout1_99ck240 FIND v(dout1_99) AT=250.05n

.meas tran vdout1_100ck240 FIND v(dout1_100) AT=250.05n

.meas tran vdout1_101ck240 FIND v(dout1_101) AT=250.05n

.meas tran vdout1_102ck240 FIND v(dout1_102) AT=250.05n

.meas tran vdout1_103ck240 FIND v(dout1_103) AT=250.05n

.meas tran vdout1_104ck240 FIND v(dout1_104) AT=250.05n

.meas tran vdout1_105ck240 FIND v(dout1_105) AT=250.05n

.meas tran vdout1_106ck240 FIND v(dout1_106) AT=250.05n

.meas tran vdout1_107ck240 FIND v(dout1_107) AT=250.05n

.meas tran vdout1_108ck240 FIND v(dout1_108) AT=250.05n

.meas tran vdout1_109ck240 FIND v(dout1_109) AT=250.05n

.meas tran vdout1_110ck240 FIND v(dout1_110) AT=250.05n

.meas tran vdout1_111ck240 FIND v(dout1_111) AT=250.05n

.meas tran vdout1_112ck240 FIND v(dout1_112) AT=250.05n

.meas tran vdout1_113ck240 FIND v(dout1_113) AT=250.05n

.meas tran vdout1_114ck240 FIND v(dout1_114) AT=250.05n

.meas tran vdout1_115ck240 FIND v(dout1_115) AT=250.05n

.meas tran vdout1_116ck240 FIND v(dout1_116) AT=250.05n

.meas tran vdout1_117ck240 FIND v(dout1_117) AT=250.05n

.meas tran vdout1_118ck240 FIND v(dout1_118) AT=250.05n

.meas tran vdout1_119ck240 FIND v(dout1_119) AT=250.05n

.meas tran vdout1_120ck240 FIND v(dout1_120) AT=250.05n

.meas tran vdout1_121ck240 FIND v(dout1_121) AT=250.05n

.meas tran vdout1_122ck240 FIND v(dout1_122) AT=250.05n

.meas tran vdout1_123ck240 FIND v(dout1_123) AT=250.05n

.meas tran vdout1_124ck240 FIND v(dout1_124) AT=250.05n

.meas tran vdout1_125ck240 FIND v(dout1_125) AT=250.05n

.meas tran vdout1_126ck240 FIND v(dout1_126) AT=250.05n

.meas tran vdout1_127ck240 FIND v(dout1_127) AT=250.05n

.meas tran vdout1_128ck240 FIND v(dout1_128) AT=250.05n

.meas tran vdout1_129ck240 FIND v(dout1_129) AT=250.05n

.meas tran vdout1_130ck240 FIND v(dout1_130) AT=250.05n

.meas tran vdout1_131ck240 FIND v(dout1_131) AT=250.05n

.meas tran vdout1_132ck240 FIND v(dout1_132) AT=250.05n

.meas tran vdout1_133ck240 FIND v(dout1_133) AT=250.05n

.meas tran vdout1_134ck240 FIND v(dout1_134) AT=250.05n

.meas tran vdout1_135ck240 FIND v(dout1_135) AT=250.05n

.meas tran vdout1_136ck240 FIND v(dout1_136) AT=250.05n

.meas tran vdout1_137ck240 FIND v(dout1_137) AT=250.05n

.meas tran vdout1_138ck240 FIND v(dout1_138) AT=250.05n

.meas tran vdout1_139ck240 FIND v(dout1_139) AT=250.05n

.meas tran vdout1_140ck240 FIND v(dout1_140) AT=250.05n

.meas tran vdout1_141ck240 FIND v(dout1_141) AT=250.05n

.meas tran vdout1_142ck240 FIND v(dout1_142) AT=250.05n

.meas tran vdout1_143ck240 FIND v(dout1_143) AT=250.05n

.meas tran vdout1_144ck240 FIND v(dout1_144) AT=250.05n

.meas tran vdout1_145ck240 FIND v(dout1_145) AT=250.05n

.meas tran vdout1_146ck240 FIND v(dout1_146) AT=250.05n

.meas tran vdout1_147ck240 FIND v(dout1_147) AT=250.05n

.meas tran vdout1_148ck240 FIND v(dout1_148) AT=250.05n

.meas tran vdout1_149ck240 FIND v(dout1_149) AT=250.05n

.meas tran vdout1_150ck240 FIND v(dout1_150) AT=250.05n

.meas tran vdout1_151ck240 FIND v(dout1_151) AT=250.05n

.meas tran vdout1_152ck240 FIND v(dout1_152) AT=250.05n

.meas tran vdout1_153ck240 FIND v(dout1_153) AT=250.05n

.meas tran vdout1_154ck240 FIND v(dout1_154) AT=250.05n

.meas tran vdout1_155ck240 FIND v(dout1_155) AT=250.05n

.meas tran vdout1_156ck240 FIND v(dout1_156) AT=250.05n

.meas tran vdout1_157ck240 FIND v(dout1_157) AT=250.05n

.meas tran vdout1_158ck240 FIND v(dout1_158) AT=250.05n

.meas tran vdout1_159ck240 FIND v(dout1_159) AT=250.05n

.meas tran vdout1_160ck240 FIND v(dout1_160) AT=250.05n

.meas tran vdout1_161ck240 FIND v(dout1_161) AT=250.05n

.meas tran vdout1_162ck240 FIND v(dout1_162) AT=250.05n

.meas tran vdout1_163ck240 FIND v(dout1_163) AT=250.05n

.meas tran vdout1_164ck240 FIND v(dout1_164) AT=250.05n

.meas tran vdout1_165ck240 FIND v(dout1_165) AT=250.05n

.meas tran vdout1_166ck240 FIND v(dout1_166) AT=250.05n

.meas tran vdout1_167ck240 FIND v(dout1_167) AT=250.05n

.meas tran vdout1_168ck240 FIND v(dout1_168) AT=250.05n

.meas tran vdout1_169ck240 FIND v(dout1_169) AT=250.05n

.meas tran vdout1_170ck240 FIND v(dout1_170) AT=250.05n

.meas tran vdout1_171ck240 FIND v(dout1_171) AT=250.05n

.meas tran vdout1_172ck240 FIND v(dout1_172) AT=250.05n

.meas tran vdout1_173ck240 FIND v(dout1_173) AT=250.05n

.meas tran vdout1_174ck240 FIND v(dout1_174) AT=250.05n

.meas tran vdout1_175ck240 FIND v(dout1_175) AT=250.05n

.meas tran vdout1_176ck240 FIND v(dout1_176) AT=250.05n

.meas tran vdout1_177ck240 FIND v(dout1_177) AT=250.05n

.meas tran vdout1_178ck240 FIND v(dout1_178) AT=250.05n

.meas tran vdout1_179ck240 FIND v(dout1_179) AT=250.05n

.meas tran vdout1_180ck240 FIND v(dout1_180) AT=250.05n

.meas tran vdout1_181ck240 FIND v(dout1_181) AT=250.05n

.meas tran vdout1_182ck240 FIND v(dout1_182) AT=250.05n

.meas tran vdout1_183ck240 FIND v(dout1_183) AT=250.05n

.meas tran vdout1_184ck240 FIND v(dout1_184) AT=250.05n

.meas tran vdout1_185ck240 FIND v(dout1_185) AT=250.05n

.meas tran vdout1_186ck240 FIND v(dout1_186) AT=250.05n

.meas tran vdout1_187ck240 FIND v(dout1_187) AT=250.05n

.meas tran vdout1_188ck240 FIND v(dout1_188) AT=250.05n

.meas tran vdout1_189ck240 FIND v(dout1_189) AT=250.05n

.meas tran vdout1_190ck240 FIND v(dout1_190) AT=250.05n

.meas tran vdout1_191ck240 FIND v(dout1_191) AT=250.05n

.meas tran vdout1_192ck240 FIND v(dout1_192) AT=250.05n

.meas tran vdout1_193ck240 FIND v(dout1_193) AT=250.05n

.meas tran vdout1_194ck240 FIND v(dout1_194) AT=250.05n

.meas tran vdout1_195ck240 FIND v(dout1_195) AT=250.05n

.meas tran vdout1_196ck240 FIND v(dout1_196) AT=250.05n

.meas tran vdout1_197ck240 FIND v(dout1_197) AT=250.05n

.meas tran vdout1_198ck240 FIND v(dout1_198) AT=250.05n

.meas tran vdout1_199ck240 FIND v(dout1_199) AT=250.05n

.meas tran vdout1_200ck240 FIND v(dout1_200) AT=250.05n

.meas tran vdout1_201ck240 FIND v(dout1_201) AT=250.05n

.meas tran vdout1_202ck240 FIND v(dout1_202) AT=250.05n

.meas tran vdout1_203ck240 FIND v(dout1_203) AT=250.05n

.meas tran vdout1_204ck240 FIND v(dout1_204) AT=250.05n

.meas tran vdout1_205ck240 FIND v(dout1_205) AT=250.05n

.meas tran vdout1_206ck240 FIND v(dout1_206) AT=250.05n

.meas tran vdout1_207ck240 FIND v(dout1_207) AT=250.05n

.meas tran vdout1_208ck240 FIND v(dout1_208) AT=250.05n

.meas tran vdout1_209ck240 FIND v(dout1_209) AT=250.05n

.meas tran vdout1_210ck240 FIND v(dout1_210) AT=250.05n

.meas tran vdout1_211ck240 FIND v(dout1_211) AT=250.05n

.meas tran vdout1_212ck240 FIND v(dout1_212) AT=250.05n

.meas tran vdout1_213ck240 FIND v(dout1_213) AT=250.05n

.meas tran vdout1_214ck240 FIND v(dout1_214) AT=250.05n

.meas tran vdout1_215ck240 FIND v(dout1_215) AT=250.05n

.meas tran vdout1_216ck240 FIND v(dout1_216) AT=250.05n

.meas tran vdout1_217ck240 FIND v(dout1_217) AT=250.05n

.meas tran vdout1_218ck240 FIND v(dout1_218) AT=250.05n

.meas tran vdout1_219ck240 FIND v(dout1_219) AT=250.05n

.meas tran vdout1_220ck240 FIND v(dout1_220) AT=250.05n

.meas tran vdout1_221ck240 FIND v(dout1_221) AT=250.05n

.meas tran vdout1_222ck240 FIND v(dout1_222) AT=250.05n

.meas tran vdout1_223ck240 FIND v(dout1_223) AT=250.05n

.meas tran vdout1_224ck240 FIND v(dout1_224) AT=250.05n

.meas tran vdout1_225ck240 FIND v(dout1_225) AT=250.05n

.meas tran vdout1_226ck240 FIND v(dout1_226) AT=250.05n

.meas tran vdout1_227ck240 FIND v(dout1_227) AT=250.05n

.meas tran vdout1_228ck240 FIND v(dout1_228) AT=250.05n

.meas tran vdout1_229ck240 FIND v(dout1_229) AT=250.05n

.meas tran vdout1_230ck240 FIND v(dout1_230) AT=250.05n

.meas tran vdout1_231ck240 FIND v(dout1_231) AT=250.05n

.meas tran vdout1_232ck240 FIND v(dout1_232) AT=250.05n

.meas tran vdout1_233ck240 FIND v(dout1_233) AT=250.05n

.meas tran vdout1_234ck240 FIND v(dout1_234) AT=250.05n

.meas tran vdout1_235ck240 FIND v(dout1_235) AT=250.05n

.meas tran vdout1_236ck240 FIND v(dout1_236) AT=250.05n

.meas tran vdout1_237ck240 FIND v(dout1_237) AT=250.05n

.meas tran vdout1_238ck240 FIND v(dout1_238) AT=250.05n

.meas tran vdout1_239ck240 FIND v(dout1_239) AT=250.05n

.meas tran vdout1_240ck240 FIND v(dout1_240) AT=250.05n

.meas tran vdout1_241ck240 FIND v(dout1_241) AT=250.05n

.meas tran vdout1_242ck240 FIND v(dout1_242) AT=250.05n

.meas tran vdout1_243ck240 FIND v(dout1_243) AT=250.05n

.meas tran vdout1_244ck240 FIND v(dout1_244) AT=250.05n

.meas tran vdout1_245ck240 FIND v(dout1_245) AT=250.05n

.meas tran vdout1_246ck240 FIND v(dout1_246) AT=250.05n

.meas tran vdout1_247ck240 FIND v(dout1_247) AT=250.05n

.meas tran vdout1_248ck240 FIND v(dout1_248) AT=250.05n

.meas tran vdout1_249ck240 FIND v(dout1_249) AT=250.05n

.meas tran vdout1_250ck240 FIND v(dout1_250) AT=250.05n

.meas tran vdout1_251ck240 FIND v(dout1_251) AT=250.05n

.meas tran vdout1_252ck240 FIND v(dout1_252) AT=250.05n

.meas tran vdout1_253ck240 FIND v(dout1_253) AT=250.05n

.meas tran vdout1_254ck240 FIND v(dout1_254) AT=250.05n

.meas tran vdout1_255ck240 FIND v(dout1_255) AT=250.05n

.meas tran vdout1_256ck240 FIND v(dout1_256) AT=250.05n

.meas tran vdout1_0ck250 FIND v(dout1_0) AT=260.05n

.meas tran vdout1_1ck250 FIND v(dout1_1) AT=260.05n

.meas tran vdout1_2ck250 FIND v(dout1_2) AT=260.05n

.meas tran vdout1_3ck250 FIND v(dout1_3) AT=260.05n

.meas tran vdout1_4ck250 FIND v(dout1_4) AT=260.05n

.meas tran vdout1_5ck250 FIND v(dout1_5) AT=260.05n

.meas tran vdout1_6ck250 FIND v(dout1_6) AT=260.05n

.meas tran vdout1_7ck250 FIND v(dout1_7) AT=260.05n

.meas tran vdout1_8ck250 FIND v(dout1_8) AT=260.05n

.meas tran vdout1_9ck250 FIND v(dout1_9) AT=260.05n

.meas tran vdout1_10ck250 FIND v(dout1_10) AT=260.05n

.meas tran vdout1_11ck250 FIND v(dout1_11) AT=260.05n

.meas tran vdout1_12ck250 FIND v(dout1_12) AT=260.05n

.meas tran vdout1_13ck250 FIND v(dout1_13) AT=260.05n

.meas tran vdout1_14ck250 FIND v(dout1_14) AT=260.05n

.meas tran vdout1_15ck250 FIND v(dout1_15) AT=260.05n

.meas tran vdout1_16ck250 FIND v(dout1_16) AT=260.05n

.meas tran vdout1_17ck250 FIND v(dout1_17) AT=260.05n

.meas tran vdout1_18ck250 FIND v(dout1_18) AT=260.05n

.meas tran vdout1_19ck250 FIND v(dout1_19) AT=260.05n

.meas tran vdout1_20ck250 FIND v(dout1_20) AT=260.05n

.meas tran vdout1_21ck250 FIND v(dout1_21) AT=260.05n

.meas tran vdout1_22ck250 FIND v(dout1_22) AT=260.05n

.meas tran vdout1_23ck250 FIND v(dout1_23) AT=260.05n

.meas tran vdout1_24ck250 FIND v(dout1_24) AT=260.05n

.meas tran vdout1_25ck250 FIND v(dout1_25) AT=260.05n

.meas tran vdout1_26ck250 FIND v(dout1_26) AT=260.05n

.meas tran vdout1_27ck250 FIND v(dout1_27) AT=260.05n

.meas tran vdout1_28ck250 FIND v(dout1_28) AT=260.05n

.meas tran vdout1_29ck250 FIND v(dout1_29) AT=260.05n

.meas tran vdout1_30ck250 FIND v(dout1_30) AT=260.05n

.meas tran vdout1_31ck250 FIND v(dout1_31) AT=260.05n

.meas tran vdout1_32ck250 FIND v(dout1_32) AT=260.05n

.meas tran vdout1_33ck250 FIND v(dout1_33) AT=260.05n

.meas tran vdout1_34ck250 FIND v(dout1_34) AT=260.05n

.meas tran vdout1_35ck250 FIND v(dout1_35) AT=260.05n

.meas tran vdout1_36ck250 FIND v(dout1_36) AT=260.05n

.meas tran vdout1_37ck250 FIND v(dout1_37) AT=260.05n

.meas tran vdout1_38ck250 FIND v(dout1_38) AT=260.05n

.meas tran vdout1_39ck250 FIND v(dout1_39) AT=260.05n

.meas tran vdout1_40ck250 FIND v(dout1_40) AT=260.05n

.meas tran vdout1_41ck250 FIND v(dout1_41) AT=260.05n

.meas tran vdout1_42ck250 FIND v(dout1_42) AT=260.05n

.meas tran vdout1_43ck250 FIND v(dout1_43) AT=260.05n

.meas tran vdout1_44ck250 FIND v(dout1_44) AT=260.05n

.meas tran vdout1_45ck250 FIND v(dout1_45) AT=260.05n

.meas tran vdout1_46ck250 FIND v(dout1_46) AT=260.05n

.meas tran vdout1_47ck250 FIND v(dout1_47) AT=260.05n

.meas tran vdout1_48ck250 FIND v(dout1_48) AT=260.05n

.meas tran vdout1_49ck250 FIND v(dout1_49) AT=260.05n

.meas tran vdout1_50ck250 FIND v(dout1_50) AT=260.05n

.meas tran vdout1_51ck250 FIND v(dout1_51) AT=260.05n

.meas tran vdout1_52ck250 FIND v(dout1_52) AT=260.05n

.meas tran vdout1_53ck250 FIND v(dout1_53) AT=260.05n

.meas tran vdout1_54ck250 FIND v(dout1_54) AT=260.05n

.meas tran vdout1_55ck250 FIND v(dout1_55) AT=260.05n

.meas tran vdout1_56ck250 FIND v(dout1_56) AT=260.05n

.meas tran vdout1_57ck250 FIND v(dout1_57) AT=260.05n

.meas tran vdout1_58ck250 FIND v(dout1_58) AT=260.05n

.meas tran vdout1_59ck250 FIND v(dout1_59) AT=260.05n

.meas tran vdout1_60ck250 FIND v(dout1_60) AT=260.05n

.meas tran vdout1_61ck250 FIND v(dout1_61) AT=260.05n

.meas tran vdout1_62ck250 FIND v(dout1_62) AT=260.05n

.meas tran vdout1_63ck250 FIND v(dout1_63) AT=260.05n

.meas tran vdout1_64ck250 FIND v(dout1_64) AT=260.05n

.meas tran vdout1_65ck250 FIND v(dout1_65) AT=260.05n

.meas tran vdout1_66ck250 FIND v(dout1_66) AT=260.05n

.meas tran vdout1_67ck250 FIND v(dout1_67) AT=260.05n

.meas tran vdout1_68ck250 FIND v(dout1_68) AT=260.05n

.meas tran vdout1_69ck250 FIND v(dout1_69) AT=260.05n

.meas tran vdout1_70ck250 FIND v(dout1_70) AT=260.05n

.meas tran vdout1_71ck250 FIND v(dout1_71) AT=260.05n

.meas tran vdout1_72ck250 FIND v(dout1_72) AT=260.05n

.meas tran vdout1_73ck250 FIND v(dout1_73) AT=260.05n

.meas tran vdout1_74ck250 FIND v(dout1_74) AT=260.05n

.meas tran vdout1_75ck250 FIND v(dout1_75) AT=260.05n

.meas tran vdout1_76ck250 FIND v(dout1_76) AT=260.05n

.meas tran vdout1_77ck250 FIND v(dout1_77) AT=260.05n

.meas tran vdout1_78ck250 FIND v(dout1_78) AT=260.05n

.meas tran vdout1_79ck250 FIND v(dout1_79) AT=260.05n

.meas tran vdout1_80ck250 FIND v(dout1_80) AT=260.05n

.meas tran vdout1_81ck250 FIND v(dout1_81) AT=260.05n

.meas tran vdout1_82ck250 FIND v(dout1_82) AT=260.05n

.meas tran vdout1_83ck250 FIND v(dout1_83) AT=260.05n

.meas tran vdout1_84ck250 FIND v(dout1_84) AT=260.05n

.meas tran vdout1_85ck250 FIND v(dout1_85) AT=260.05n

.meas tran vdout1_86ck250 FIND v(dout1_86) AT=260.05n

.meas tran vdout1_87ck250 FIND v(dout1_87) AT=260.05n

.meas tran vdout1_88ck250 FIND v(dout1_88) AT=260.05n

.meas tran vdout1_89ck250 FIND v(dout1_89) AT=260.05n

.meas tran vdout1_90ck250 FIND v(dout1_90) AT=260.05n

.meas tran vdout1_91ck250 FIND v(dout1_91) AT=260.05n

.meas tran vdout1_92ck250 FIND v(dout1_92) AT=260.05n

.meas tran vdout1_93ck250 FIND v(dout1_93) AT=260.05n

.meas tran vdout1_94ck250 FIND v(dout1_94) AT=260.05n

.meas tran vdout1_95ck250 FIND v(dout1_95) AT=260.05n

.meas tran vdout1_96ck250 FIND v(dout1_96) AT=260.05n

.meas tran vdout1_97ck250 FIND v(dout1_97) AT=260.05n

.meas tran vdout1_98ck250 FIND v(dout1_98) AT=260.05n

.meas tran vdout1_99ck250 FIND v(dout1_99) AT=260.05n

.meas tran vdout1_100ck250 FIND v(dout1_100) AT=260.05n

.meas tran vdout1_101ck250 FIND v(dout1_101) AT=260.05n

.meas tran vdout1_102ck250 FIND v(dout1_102) AT=260.05n

.meas tran vdout1_103ck250 FIND v(dout1_103) AT=260.05n

.meas tran vdout1_104ck250 FIND v(dout1_104) AT=260.05n

.meas tran vdout1_105ck250 FIND v(dout1_105) AT=260.05n

.meas tran vdout1_106ck250 FIND v(dout1_106) AT=260.05n

.meas tran vdout1_107ck250 FIND v(dout1_107) AT=260.05n

.meas tran vdout1_108ck250 FIND v(dout1_108) AT=260.05n

.meas tran vdout1_109ck250 FIND v(dout1_109) AT=260.05n

.meas tran vdout1_110ck250 FIND v(dout1_110) AT=260.05n

.meas tran vdout1_111ck250 FIND v(dout1_111) AT=260.05n

.meas tran vdout1_112ck250 FIND v(dout1_112) AT=260.05n

.meas tran vdout1_113ck250 FIND v(dout1_113) AT=260.05n

.meas tran vdout1_114ck250 FIND v(dout1_114) AT=260.05n

.meas tran vdout1_115ck250 FIND v(dout1_115) AT=260.05n

.meas tran vdout1_116ck250 FIND v(dout1_116) AT=260.05n

.meas tran vdout1_117ck250 FIND v(dout1_117) AT=260.05n

.meas tran vdout1_118ck250 FIND v(dout1_118) AT=260.05n

.meas tran vdout1_119ck250 FIND v(dout1_119) AT=260.05n

.meas tran vdout1_120ck250 FIND v(dout1_120) AT=260.05n

.meas tran vdout1_121ck250 FIND v(dout1_121) AT=260.05n

.meas tran vdout1_122ck250 FIND v(dout1_122) AT=260.05n

.meas tran vdout1_123ck250 FIND v(dout1_123) AT=260.05n

.meas tran vdout1_124ck250 FIND v(dout1_124) AT=260.05n

.meas tran vdout1_125ck250 FIND v(dout1_125) AT=260.05n

.meas tran vdout1_126ck250 FIND v(dout1_126) AT=260.05n

.meas tran vdout1_127ck250 FIND v(dout1_127) AT=260.05n

.meas tran vdout1_128ck250 FIND v(dout1_128) AT=260.05n

.meas tran vdout1_129ck250 FIND v(dout1_129) AT=260.05n

.meas tran vdout1_130ck250 FIND v(dout1_130) AT=260.05n

.meas tran vdout1_131ck250 FIND v(dout1_131) AT=260.05n

.meas tran vdout1_132ck250 FIND v(dout1_132) AT=260.05n

.meas tran vdout1_133ck250 FIND v(dout1_133) AT=260.05n

.meas tran vdout1_134ck250 FIND v(dout1_134) AT=260.05n

.meas tran vdout1_135ck250 FIND v(dout1_135) AT=260.05n

.meas tran vdout1_136ck250 FIND v(dout1_136) AT=260.05n

.meas tran vdout1_137ck250 FIND v(dout1_137) AT=260.05n

.meas tran vdout1_138ck250 FIND v(dout1_138) AT=260.05n

.meas tran vdout1_139ck250 FIND v(dout1_139) AT=260.05n

.meas tran vdout1_140ck250 FIND v(dout1_140) AT=260.05n

.meas tran vdout1_141ck250 FIND v(dout1_141) AT=260.05n

.meas tran vdout1_142ck250 FIND v(dout1_142) AT=260.05n

.meas tran vdout1_143ck250 FIND v(dout1_143) AT=260.05n

.meas tran vdout1_144ck250 FIND v(dout1_144) AT=260.05n

.meas tran vdout1_145ck250 FIND v(dout1_145) AT=260.05n

.meas tran vdout1_146ck250 FIND v(dout1_146) AT=260.05n

.meas tran vdout1_147ck250 FIND v(dout1_147) AT=260.05n

.meas tran vdout1_148ck250 FIND v(dout1_148) AT=260.05n

.meas tran vdout1_149ck250 FIND v(dout1_149) AT=260.05n

.meas tran vdout1_150ck250 FIND v(dout1_150) AT=260.05n

.meas tran vdout1_151ck250 FIND v(dout1_151) AT=260.05n

.meas tran vdout1_152ck250 FIND v(dout1_152) AT=260.05n

.meas tran vdout1_153ck250 FIND v(dout1_153) AT=260.05n

.meas tran vdout1_154ck250 FIND v(dout1_154) AT=260.05n

.meas tran vdout1_155ck250 FIND v(dout1_155) AT=260.05n

.meas tran vdout1_156ck250 FIND v(dout1_156) AT=260.05n

.meas tran vdout1_157ck250 FIND v(dout1_157) AT=260.05n

.meas tran vdout1_158ck250 FIND v(dout1_158) AT=260.05n

.meas tran vdout1_159ck250 FIND v(dout1_159) AT=260.05n

.meas tran vdout1_160ck250 FIND v(dout1_160) AT=260.05n

.meas tran vdout1_161ck250 FIND v(dout1_161) AT=260.05n

.meas tran vdout1_162ck250 FIND v(dout1_162) AT=260.05n

.meas tran vdout1_163ck250 FIND v(dout1_163) AT=260.05n

.meas tran vdout1_164ck250 FIND v(dout1_164) AT=260.05n

.meas tran vdout1_165ck250 FIND v(dout1_165) AT=260.05n

.meas tran vdout1_166ck250 FIND v(dout1_166) AT=260.05n

.meas tran vdout1_167ck250 FIND v(dout1_167) AT=260.05n

.meas tran vdout1_168ck250 FIND v(dout1_168) AT=260.05n

.meas tran vdout1_169ck250 FIND v(dout1_169) AT=260.05n

.meas tran vdout1_170ck250 FIND v(dout1_170) AT=260.05n

.meas tran vdout1_171ck250 FIND v(dout1_171) AT=260.05n

.meas tran vdout1_172ck250 FIND v(dout1_172) AT=260.05n

.meas tran vdout1_173ck250 FIND v(dout1_173) AT=260.05n

.meas tran vdout1_174ck250 FIND v(dout1_174) AT=260.05n

.meas tran vdout1_175ck250 FIND v(dout1_175) AT=260.05n

.meas tran vdout1_176ck250 FIND v(dout1_176) AT=260.05n

.meas tran vdout1_177ck250 FIND v(dout1_177) AT=260.05n

.meas tran vdout1_178ck250 FIND v(dout1_178) AT=260.05n

.meas tran vdout1_179ck250 FIND v(dout1_179) AT=260.05n

.meas tran vdout1_180ck250 FIND v(dout1_180) AT=260.05n

.meas tran vdout1_181ck250 FIND v(dout1_181) AT=260.05n

.meas tran vdout1_182ck250 FIND v(dout1_182) AT=260.05n

.meas tran vdout1_183ck250 FIND v(dout1_183) AT=260.05n

.meas tran vdout1_184ck250 FIND v(dout1_184) AT=260.05n

.meas tran vdout1_185ck250 FIND v(dout1_185) AT=260.05n

.meas tran vdout1_186ck250 FIND v(dout1_186) AT=260.05n

.meas tran vdout1_187ck250 FIND v(dout1_187) AT=260.05n

.meas tran vdout1_188ck250 FIND v(dout1_188) AT=260.05n

.meas tran vdout1_189ck250 FIND v(dout1_189) AT=260.05n

.meas tran vdout1_190ck250 FIND v(dout1_190) AT=260.05n

.meas tran vdout1_191ck250 FIND v(dout1_191) AT=260.05n

.meas tran vdout1_192ck250 FIND v(dout1_192) AT=260.05n

.meas tran vdout1_193ck250 FIND v(dout1_193) AT=260.05n

.meas tran vdout1_194ck250 FIND v(dout1_194) AT=260.05n

.meas tran vdout1_195ck250 FIND v(dout1_195) AT=260.05n

.meas tran vdout1_196ck250 FIND v(dout1_196) AT=260.05n

.meas tran vdout1_197ck250 FIND v(dout1_197) AT=260.05n

.meas tran vdout1_198ck250 FIND v(dout1_198) AT=260.05n

.meas tran vdout1_199ck250 FIND v(dout1_199) AT=260.05n

.meas tran vdout1_200ck250 FIND v(dout1_200) AT=260.05n

.meas tran vdout1_201ck250 FIND v(dout1_201) AT=260.05n

.meas tran vdout1_202ck250 FIND v(dout1_202) AT=260.05n

.meas tran vdout1_203ck250 FIND v(dout1_203) AT=260.05n

.meas tran vdout1_204ck250 FIND v(dout1_204) AT=260.05n

.meas tran vdout1_205ck250 FIND v(dout1_205) AT=260.05n

.meas tran vdout1_206ck250 FIND v(dout1_206) AT=260.05n

.meas tran vdout1_207ck250 FIND v(dout1_207) AT=260.05n

.meas tran vdout1_208ck250 FIND v(dout1_208) AT=260.05n

.meas tran vdout1_209ck250 FIND v(dout1_209) AT=260.05n

.meas tran vdout1_210ck250 FIND v(dout1_210) AT=260.05n

.meas tran vdout1_211ck250 FIND v(dout1_211) AT=260.05n

.meas tran vdout1_212ck250 FIND v(dout1_212) AT=260.05n

.meas tran vdout1_213ck250 FIND v(dout1_213) AT=260.05n

.meas tran vdout1_214ck250 FIND v(dout1_214) AT=260.05n

.meas tran vdout1_215ck250 FIND v(dout1_215) AT=260.05n

.meas tran vdout1_216ck250 FIND v(dout1_216) AT=260.05n

.meas tran vdout1_217ck250 FIND v(dout1_217) AT=260.05n

.meas tran vdout1_218ck250 FIND v(dout1_218) AT=260.05n

.meas tran vdout1_219ck250 FIND v(dout1_219) AT=260.05n

.meas tran vdout1_220ck250 FIND v(dout1_220) AT=260.05n

.meas tran vdout1_221ck250 FIND v(dout1_221) AT=260.05n

.meas tran vdout1_222ck250 FIND v(dout1_222) AT=260.05n

.meas tran vdout1_223ck250 FIND v(dout1_223) AT=260.05n

.meas tran vdout1_224ck250 FIND v(dout1_224) AT=260.05n

.meas tran vdout1_225ck250 FIND v(dout1_225) AT=260.05n

.meas tran vdout1_226ck250 FIND v(dout1_226) AT=260.05n

.meas tran vdout1_227ck250 FIND v(dout1_227) AT=260.05n

.meas tran vdout1_228ck250 FIND v(dout1_228) AT=260.05n

.meas tran vdout1_229ck250 FIND v(dout1_229) AT=260.05n

.meas tran vdout1_230ck250 FIND v(dout1_230) AT=260.05n

.meas tran vdout1_231ck250 FIND v(dout1_231) AT=260.05n

.meas tran vdout1_232ck250 FIND v(dout1_232) AT=260.05n

.meas tran vdout1_233ck250 FIND v(dout1_233) AT=260.05n

.meas tran vdout1_234ck250 FIND v(dout1_234) AT=260.05n

.meas tran vdout1_235ck250 FIND v(dout1_235) AT=260.05n

.meas tran vdout1_236ck250 FIND v(dout1_236) AT=260.05n

.meas tran vdout1_237ck250 FIND v(dout1_237) AT=260.05n

.meas tran vdout1_238ck250 FIND v(dout1_238) AT=260.05n

.meas tran vdout1_239ck250 FIND v(dout1_239) AT=260.05n

.meas tran vdout1_240ck250 FIND v(dout1_240) AT=260.05n

.meas tran vdout1_241ck250 FIND v(dout1_241) AT=260.05n

.meas tran vdout1_242ck250 FIND v(dout1_242) AT=260.05n

.meas tran vdout1_243ck250 FIND v(dout1_243) AT=260.05n

.meas tran vdout1_244ck250 FIND v(dout1_244) AT=260.05n

.meas tran vdout1_245ck250 FIND v(dout1_245) AT=260.05n

.meas tran vdout1_246ck250 FIND v(dout1_246) AT=260.05n

.meas tran vdout1_247ck250 FIND v(dout1_247) AT=260.05n

.meas tran vdout1_248ck250 FIND v(dout1_248) AT=260.05n

.meas tran vdout1_249ck250 FIND v(dout1_249) AT=260.05n

.meas tran vdout1_250ck250 FIND v(dout1_250) AT=260.05n

.meas tran vdout1_251ck250 FIND v(dout1_251) AT=260.05n

.meas tran vdout1_252ck250 FIND v(dout1_252) AT=260.05n

.meas tran vdout1_253ck250 FIND v(dout1_253) AT=260.05n

.meas tran vdout1_254ck250 FIND v(dout1_254) AT=260.05n

.meas tran vdout1_255ck250 FIND v(dout1_255) AT=260.05n

.meas tran vdout1_256ck250 FIND v(dout1_256) AT=260.05n

.meas tran vdout1_0ck270 FIND v(dout1_0) AT=280.05n

.meas tran vdout1_1ck270 FIND v(dout1_1) AT=280.05n

.meas tran vdout1_2ck270 FIND v(dout1_2) AT=280.05n

.meas tran vdout1_3ck270 FIND v(dout1_3) AT=280.05n

.meas tran vdout1_4ck270 FIND v(dout1_4) AT=280.05n

.meas tran vdout1_5ck270 FIND v(dout1_5) AT=280.05n

.meas tran vdout1_6ck270 FIND v(dout1_6) AT=280.05n

.meas tran vdout1_7ck270 FIND v(dout1_7) AT=280.05n

.meas tran vdout1_8ck270 FIND v(dout1_8) AT=280.05n

.meas tran vdout1_9ck270 FIND v(dout1_9) AT=280.05n

.meas tran vdout1_10ck270 FIND v(dout1_10) AT=280.05n

.meas tran vdout1_11ck270 FIND v(dout1_11) AT=280.05n

.meas tran vdout1_12ck270 FIND v(dout1_12) AT=280.05n

.meas tran vdout1_13ck270 FIND v(dout1_13) AT=280.05n

.meas tran vdout1_14ck270 FIND v(dout1_14) AT=280.05n

.meas tran vdout1_15ck270 FIND v(dout1_15) AT=280.05n

.meas tran vdout1_16ck270 FIND v(dout1_16) AT=280.05n

.meas tran vdout1_17ck270 FIND v(dout1_17) AT=280.05n

.meas tran vdout1_18ck270 FIND v(dout1_18) AT=280.05n

.meas tran vdout1_19ck270 FIND v(dout1_19) AT=280.05n

.meas tran vdout1_20ck270 FIND v(dout1_20) AT=280.05n

.meas tran vdout1_21ck270 FIND v(dout1_21) AT=280.05n

.meas tran vdout1_22ck270 FIND v(dout1_22) AT=280.05n

.meas tran vdout1_23ck270 FIND v(dout1_23) AT=280.05n

.meas tran vdout1_24ck270 FIND v(dout1_24) AT=280.05n

.meas tran vdout1_25ck270 FIND v(dout1_25) AT=280.05n

.meas tran vdout1_26ck270 FIND v(dout1_26) AT=280.05n

.meas tran vdout1_27ck270 FIND v(dout1_27) AT=280.05n

.meas tran vdout1_28ck270 FIND v(dout1_28) AT=280.05n

.meas tran vdout1_29ck270 FIND v(dout1_29) AT=280.05n

.meas tran vdout1_30ck270 FIND v(dout1_30) AT=280.05n

.meas tran vdout1_31ck270 FIND v(dout1_31) AT=280.05n

.meas tran vdout1_32ck270 FIND v(dout1_32) AT=280.05n

.meas tran vdout1_33ck270 FIND v(dout1_33) AT=280.05n

.meas tran vdout1_34ck270 FIND v(dout1_34) AT=280.05n

.meas tran vdout1_35ck270 FIND v(dout1_35) AT=280.05n

.meas tran vdout1_36ck270 FIND v(dout1_36) AT=280.05n

.meas tran vdout1_37ck270 FIND v(dout1_37) AT=280.05n

.meas tran vdout1_38ck270 FIND v(dout1_38) AT=280.05n

.meas tran vdout1_39ck270 FIND v(dout1_39) AT=280.05n

.meas tran vdout1_40ck270 FIND v(dout1_40) AT=280.05n

.meas tran vdout1_41ck270 FIND v(dout1_41) AT=280.05n

.meas tran vdout1_42ck270 FIND v(dout1_42) AT=280.05n

.meas tran vdout1_43ck270 FIND v(dout1_43) AT=280.05n

.meas tran vdout1_44ck270 FIND v(dout1_44) AT=280.05n

.meas tran vdout1_45ck270 FIND v(dout1_45) AT=280.05n

.meas tran vdout1_46ck270 FIND v(dout1_46) AT=280.05n

.meas tran vdout1_47ck270 FIND v(dout1_47) AT=280.05n

.meas tran vdout1_48ck270 FIND v(dout1_48) AT=280.05n

.meas tran vdout1_49ck270 FIND v(dout1_49) AT=280.05n

.meas tran vdout1_50ck270 FIND v(dout1_50) AT=280.05n

.meas tran vdout1_51ck270 FIND v(dout1_51) AT=280.05n

.meas tran vdout1_52ck270 FIND v(dout1_52) AT=280.05n

.meas tran vdout1_53ck270 FIND v(dout1_53) AT=280.05n

.meas tran vdout1_54ck270 FIND v(dout1_54) AT=280.05n

.meas tran vdout1_55ck270 FIND v(dout1_55) AT=280.05n

.meas tran vdout1_56ck270 FIND v(dout1_56) AT=280.05n

.meas tran vdout1_57ck270 FIND v(dout1_57) AT=280.05n

.meas tran vdout1_58ck270 FIND v(dout1_58) AT=280.05n

.meas tran vdout1_59ck270 FIND v(dout1_59) AT=280.05n

.meas tran vdout1_60ck270 FIND v(dout1_60) AT=280.05n

.meas tran vdout1_61ck270 FIND v(dout1_61) AT=280.05n

.meas tran vdout1_62ck270 FIND v(dout1_62) AT=280.05n

.meas tran vdout1_63ck270 FIND v(dout1_63) AT=280.05n

.meas tran vdout1_64ck270 FIND v(dout1_64) AT=280.05n

.meas tran vdout1_65ck270 FIND v(dout1_65) AT=280.05n

.meas tran vdout1_66ck270 FIND v(dout1_66) AT=280.05n

.meas tran vdout1_67ck270 FIND v(dout1_67) AT=280.05n

.meas tran vdout1_68ck270 FIND v(dout1_68) AT=280.05n

.meas tran vdout1_69ck270 FIND v(dout1_69) AT=280.05n

.meas tran vdout1_70ck270 FIND v(dout1_70) AT=280.05n

.meas tran vdout1_71ck270 FIND v(dout1_71) AT=280.05n

.meas tran vdout1_72ck270 FIND v(dout1_72) AT=280.05n

.meas tran vdout1_73ck270 FIND v(dout1_73) AT=280.05n

.meas tran vdout1_74ck270 FIND v(dout1_74) AT=280.05n

.meas tran vdout1_75ck270 FIND v(dout1_75) AT=280.05n

.meas tran vdout1_76ck270 FIND v(dout1_76) AT=280.05n

.meas tran vdout1_77ck270 FIND v(dout1_77) AT=280.05n

.meas tran vdout1_78ck270 FIND v(dout1_78) AT=280.05n

.meas tran vdout1_79ck270 FIND v(dout1_79) AT=280.05n

.meas tran vdout1_80ck270 FIND v(dout1_80) AT=280.05n

.meas tran vdout1_81ck270 FIND v(dout1_81) AT=280.05n

.meas tran vdout1_82ck270 FIND v(dout1_82) AT=280.05n

.meas tran vdout1_83ck270 FIND v(dout1_83) AT=280.05n

.meas tran vdout1_84ck270 FIND v(dout1_84) AT=280.05n

.meas tran vdout1_85ck270 FIND v(dout1_85) AT=280.05n

.meas tran vdout1_86ck270 FIND v(dout1_86) AT=280.05n

.meas tran vdout1_87ck270 FIND v(dout1_87) AT=280.05n

.meas tran vdout1_88ck270 FIND v(dout1_88) AT=280.05n

.meas tran vdout1_89ck270 FIND v(dout1_89) AT=280.05n

.meas tran vdout1_90ck270 FIND v(dout1_90) AT=280.05n

.meas tran vdout1_91ck270 FIND v(dout1_91) AT=280.05n

.meas tran vdout1_92ck270 FIND v(dout1_92) AT=280.05n

.meas tran vdout1_93ck270 FIND v(dout1_93) AT=280.05n

.meas tran vdout1_94ck270 FIND v(dout1_94) AT=280.05n

.meas tran vdout1_95ck270 FIND v(dout1_95) AT=280.05n

.meas tran vdout1_96ck270 FIND v(dout1_96) AT=280.05n

.meas tran vdout1_97ck270 FIND v(dout1_97) AT=280.05n

.meas tran vdout1_98ck270 FIND v(dout1_98) AT=280.05n

.meas tran vdout1_99ck270 FIND v(dout1_99) AT=280.05n

.meas tran vdout1_100ck270 FIND v(dout1_100) AT=280.05n

.meas tran vdout1_101ck270 FIND v(dout1_101) AT=280.05n

.meas tran vdout1_102ck270 FIND v(dout1_102) AT=280.05n

.meas tran vdout1_103ck270 FIND v(dout1_103) AT=280.05n

.meas tran vdout1_104ck270 FIND v(dout1_104) AT=280.05n

.meas tran vdout1_105ck270 FIND v(dout1_105) AT=280.05n

.meas tran vdout1_106ck270 FIND v(dout1_106) AT=280.05n

.meas tran vdout1_107ck270 FIND v(dout1_107) AT=280.05n

.meas tran vdout1_108ck270 FIND v(dout1_108) AT=280.05n

.meas tran vdout1_109ck270 FIND v(dout1_109) AT=280.05n

.meas tran vdout1_110ck270 FIND v(dout1_110) AT=280.05n

.meas tran vdout1_111ck270 FIND v(dout1_111) AT=280.05n

.meas tran vdout1_112ck270 FIND v(dout1_112) AT=280.05n

.meas tran vdout1_113ck270 FIND v(dout1_113) AT=280.05n

.meas tran vdout1_114ck270 FIND v(dout1_114) AT=280.05n

.meas tran vdout1_115ck270 FIND v(dout1_115) AT=280.05n

.meas tran vdout1_116ck270 FIND v(dout1_116) AT=280.05n

.meas tran vdout1_117ck270 FIND v(dout1_117) AT=280.05n

.meas tran vdout1_118ck270 FIND v(dout1_118) AT=280.05n

.meas tran vdout1_119ck270 FIND v(dout1_119) AT=280.05n

.meas tran vdout1_120ck270 FIND v(dout1_120) AT=280.05n

.meas tran vdout1_121ck270 FIND v(dout1_121) AT=280.05n

.meas tran vdout1_122ck270 FIND v(dout1_122) AT=280.05n

.meas tran vdout1_123ck270 FIND v(dout1_123) AT=280.05n

.meas tran vdout1_124ck270 FIND v(dout1_124) AT=280.05n

.meas tran vdout1_125ck270 FIND v(dout1_125) AT=280.05n

.meas tran vdout1_126ck270 FIND v(dout1_126) AT=280.05n

.meas tran vdout1_127ck270 FIND v(dout1_127) AT=280.05n

.meas tran vdout1_128ck270 FIND v(dout1_128) AT=280.05n

.meas tran vdout1_129ck270 FIND v(dout1_129) AT=280.05n

.meas tran vdout1_130ck270 FIND v(dout1_130) AT=280.05n

.meas tran vdout1_131ck270 FIND v(dout1_131) AT=280.05n

.meas tran vdout1_132ck270 FIND v(dout1_132) AT=280.05n

.meas tran vdout1_133ck270 FIND v(dout1_133) AT=280.05n

.meas tran vdout1_134ck270 FIND v(dout1_134) AT=280.05n

.meas tran vdout1_135ck270 FIND v(dout1_135) AT=280.05n

.meas tran vdout1_136ck270 FIND v(dout1_136) AT=280.05n

.meas tran vdout1_137ck270 FIND v(dout1_137) AT=280.05n

.meas tran vdout1_138ck270 FIND v(dout1_138) AT=280.05n

.meas tran vdout1_139ck270 FIND v(dout1_139) AT=280.05n

.meas tran vdout1_140ck270 FIND v(dout1_140) AT=280.05n

.meas tran vdout1_141ck270 FIND v(dout1_141) AT=280.05n

.meas tran vdout1_142ck270 FIND v(dout1_142) AT=280.05n

.meas tran vdout1_143ck270 FIND v(dout1_143) AT=280.05n

.meas tran vdout1_144ck270 FIND v(dout1_144) AT=280.05n

.meas tran vdout1_145ck270 FIND v(dout1_145) AT=280.05n

.meas tran vdout1_146ck270 FIND v(dout1_146) AT=280.05n

.meas tran vdout1_147ck270 FIND v(dout1_147) AT=280.05n

.meas tran vdout1_148ck270 FIND v(dout1_148) AT=280.05n

.meas tran vdout1_149ck270 FIND v(dout1_149) AT=280.05n

.meas tran vdout1_150ck270 FIND v(dout1_150) AT=280.05n

.meas tran vdout1_151ck270 FIND v(dout1_151) AT=280.05n

.meas tran vdout1_152ck270 FIND v(dout1_152) AT=280.05n

.meas tran vdout1_153ck270 FIND v(dout1_153) AT=280.05n

.meas tran vdout1_154ck270 FIND v(dout1_154) AT=280.05n

.meas tran vdout1_155ck270 FIND v(dout1_155) AT=280.05n

.meas tran vdout1_156ck270 FIND v(dout1_156) AT=280.05n

.meas tran vdout1_157ck270 FIND v(dout1_157) AT=280.05n

.meas tran vdout1_158ck270 FIND v(dout1_158) AT=280.05n

.meas tran vdout1_159ck270 FIND v(dout1_159) AT=280.05n

.meas tran vdout1_160ck270 FIND v(dout1_160) AT=280.05n

.meas tran vdout1_161ck270 FIND v(dout1_161) AT=280.05n

.meas tran vdout1_162ck270 FIND v(dout1_162) AT=280.05n

.meas tran vdout1_163ck270 FIND v(dout1_163) AT=280.05n

.meas tran vdout1_164ck270 FIND v(dout1_164) AT=280.05n

.meas tran vdout1_165ck270 FIND v(dout1_165) AT=280.05n

.meas tran vdout1_166ck270 FIND v(dout1_166) AT=280.05n

.meas tran vdout1_167ck270 FIND v(dout1_167) AT=280.05n

.meas tran vdout1_168ck270 FIND v(dout1_168) AT=280.05n

.meas tran vdout1_169ck270 FIND v(dout1_169) AT=280.05n

.meas tran vdout1_170ck270 FIND v(dout1_170) AT=280.05n

.meas tran vdout1_171ck270 FIND v(dout1_171) AT=280.05n

.meas tran vdout1_172ck270 FIND v(dout1_172) AT=280.05n

.meas tran vdout1_173ck270 FIND v(dout1_173) AT=280.05n

.meas tran vdout1_174ck270 FIND v(dout1_174) AT=280.05n

.meas tran vdout1_175ck270 FIND v(dout1_175) AT=280.05n

.meas tran vdout1_176ck270 FIND v(dout1_176) AT=280.05n

.meas tran vdout1_177ck270 FIND v(dout1_177) AT=280.05n

.meas tran vdout1_178ck270 FIND v(dout1_178) AT=280.05n

.meas tran vdout1_179ck270 FIND v(dout1_179) AT=280.05n

.meas tran vdout1_180ck270 FIND v(dout1_180) AT=280.05n

.meas tran vdout1_181ck270 FIND v(dout1_181) AT=280.05n

.meas tran vdout1_182ck270 FIND v(dout1_182) AT=280.05n

.meas tran vdout1_183ck270 FIND v(dout1_183) AT=280.05n

.meas tran vdout1_184ck270 FIND v(dout1_184) AT=280.05n

.meas tran vdout1_185ck270 FIND v(dout1_185) AT=280.05n

.meas tran vdout1_186ck270 FIND v(dout1_186) AT=280.05n

.meas tran vdout1_187ck270 FIND v(dout1_187) AT=280.05n

.meas tran vdout1_188ck270 FIND v(dout1_188) AT=280.05n

.meas tran vdout1_189ck270 FIND v(dout1_189) AT=280.05n

.meas tran vdout1_190ck270 FIND v(dout1_190) AT=280.05n

.meas tran vdout1_191ck270 FIND v(dout1_191) AT=280.05n

.meas tran vdout1_192ck270 FIND v(dout1_192) AT=280.05n

.meas tran vdout1_193ck270 FIND v(dout1_193) AT=280.05n

.meas tran vdout1_194ck270 FIND v(dout1_194) AT=280.05n

.meas tran vdout1_195ck270 FIND v(dout1_195) AT=280.05n

.meas tran vdout1_196ck270 FIND v(dout1_196) AT=280.05n

.meas tran vdout1_197ck270 FIND v(dout1_197) AT=280.05n

.meas tran vdout1_198ck270 FIND v(dout1_198) AT=280.05n

.meas tran vdout1_199ck270 FIND v(dout1_199) AT=280.05n

.meas tran vdout1_200ck270 FIND v(dout1_200) AT=280.05n

.meas tran vdout1_201ck270 FIND v(dout1_201) AT=280.05n

.meas tran vdout1_202ck270 FIND v(dout1_202) AT=280.05n

.meas tran vdout1_203ck270 FIND v(dout1_203) AT=280.05n

.meas tran vdout1_204ck270 FIND v(dout1_204) AT=280.05n

.meas tran vdout1_205ck270 FIND v(dout1_205) AT=280.05n

.meas tran vdout1_206ck270 FIND v(dout1_206) AT=280.05n

.meas tran vdout1_207ck270 FIND v(dout1_207) AT=280.05n

.meas tran vdout1_208ck270 FIND v(dout1_208) AT=280.05n

.meas tran vdout1_209ck270 FIND v(dout1_209) AT=280.05n

.meas tran vdout1_210ck270 FIND v(dout1_210) AT=280.05n

.meas tran vdout1_211ck270 FIND v(dout1_211) AT=280.05n

.meas tran vdout1_212ck270 FIND v(dout1_212) AT=280.05n

.meas tran vdout1_213ck270 FIND v(dout1_213) AT=280.05n

.meas tran vdout1_214ck270 FIND v(dout1_214) AT=280.05n

.meas tran vdout1_215ck270 FIND v(dout1_215) AT=280.05n

.meas tran vdout1_216ck270 FIND v(dout1_216) AT=280.05n

.meas tran vdout1_217ck270 FIND v(dout1_217) AT=280.05n

.meas tran vdout1_218ck270 FIND v(dout1_218) AT=280.05n

.meas tran vdout1_219ck270 FIND v(dout1_219) AT=280.05n

.meas tran vdout1_220ck270 FIND v(dout1_220) AT=280.05n

.meas tran vdout1_221ck270 FIND v(dout1_221) AT=280.05n

.meas tran vdout1_222ck270 FIND v(dout1_222) AT=280.05n

.meas tran vdout1_223ck270 FIND v(dout1_223) AT=280.05n

.meas tran vdout1_224ck270 FIND v(dout1_224) AT=280.05n

.meas tran vdout1_225ck270 FIND v(dout1_225) AT=280.05n

.meas tran vdout1_226ck270 FIND v(dout1_226) AT=280.05n

.meas tran vdout1_227ck270 FIND v(dout1_227) AT=280.05n

.meas tran vdout1_228ck270 FIND v(dout1_228) AT=280.05n

.meas tran vdout1_229ck270 FIND v(dout1_229) AT=280.05n

.meas tran vdout1_230ck270 FIND v(dout1_230) AT=280.05n

.meas tran vdout1_231ck270 FIND v(dout1_231) AT=280.05n

.meas tran vdout1_232ck270 FIND v(dout1_232) AT=280.05n

.meas tran vdout1_233ck270 FIND v(dout1_233) AT=280.05n

.meas tran vdout1_234ck270 FIND v(dout1_234) AT=280.05n

.meas tran vdout1_235ck270 FIND v(dout1_235) AT=280.05n

.meas tran vdout1_236ck270 FIND v(dout1_236) AT=280.05n

.meas tran vdout1_237ck270 FIND v(dout1_237) AT=280.05n

.meas tran vdout1_238ck270 FIND v(dout1_238) AT=280.05n

.meas tran vdout1_239ck270 FIND v(dout1_239) AT=280.05n

.meas tran vdout1_240ck270 FIND v(dout1_240) AT=280.05n

.meas tran vdout1_241ck270 FIND v(dout1_241) AT=280.05n

.meas tran vdout1_242ck270 FIND v(dout1_242) AT=280.05n

.meas tran vdout1_243ck270 FIND v(dout1_243) AT=280.05n

.meas tran vdout1_244ck270 FIND v(dout1_244) AT=280.05n

.meas tran vdout1_245ck270 FIND v(dout1_245) AT=280.05n

.meas tran vdout1_246ck270 FIND v(dout1_246) AT=280.05n

.meas tran vdout1_247ck270 FIND v(dout1_247) AT=280.05n

.meas tran vdout1_248ck270 FIND v(dout1_248) AT=280.05n

.meas tran vdout1_249ck270 FIND v(dout1_249) AT=280.05n

.meas tran vdout1_250ck270 FIND v(dout1_250) AT=280.05n

.meas tran vdout1_251ck270 FIND v(dout1_251) AT=280.05n

.meas tran vdout1_252ck270 FIND v(dout1_252) AT=280.05n

.meas tran vdout1_253ck270 FIND v(dout1_253) AT=280.05n

.meas tran vdout1_254ck270 FIND v(dout1_254) AT=280.05n

.meas tran vdout1_255ck270 FIND v(dout1_255) AT=280.05n

.meas tran vdout1_256ck270 FIND v(dout1_256) AT=280.05n

.meas tran vdout1_0ck300 FIND v(dout1_0) AT=310.05n

.meas tran vdout1_1ck300 FIND v(dout1_1) AT=310.05n

.meas tran vdout1_2ck300 FIND v(dout1_2) AT=310.05n

.meas tran vdout1_3ck300 FIND v(dout1_3) AT=310.05n

.meas tran vdout1_4ck300 FIND v(dout1_4) AT=310.05n

.meas tran vdout1_5ck300 FIND v(dout1_5) AT=310.05n

.meas tran vdout1_6ck300 FIND v(dout1_6) AT=310.05n

.meas tran vdout1_7ck300 FIND v(dout1_7) AT=310.05n

.meas tran vdout1_8ck300 FIND v(dout1_8) AT=310.05n

.meas tran vdout1_9ck300 FIND v(dout1_9) AT=310.05n

.meas tran vdout1_10ck300 FIND v(dout1_10) AT=310.05n

.meas tran vdout1_11ck300 FIND v(dout1_11) AT=310.05n

.meas tran vdout1_12ck300 FIND v(dout1_12) AT=310.05n

.meas tran vdout1_13ck300 FIND v(dout1_13) AT=310.05n

.meas tran vdout1_14ck300 FIND v(dout1_14) AT=310.05n

.meas tran vdout1_15ck300 FIND v(dout1_15) AT=310.05n

.meas tran vdout1_16ck300 FIND v(dout1_16) AT=310.05n

.meas tran vdout1_17ck300 FIND v(dout1_17) AT=310.05n

.meas tran vdout1_18ck300 FIND v(dout1_18) AT=310.05n

.meas tran vdout1_19ck300 FIND v(dout1_19) AT=310.05n

.meas tran vdout1_20ck300 FIND v(dout1_20) AT=310.05n

.meas tran vdout1_21ck300 FIND v(dout1_21) AT=310.05n

.meas tran vdout1_22ck300 FIND v(dout1_22) AT=310.05n

.meas tran vdout1_23ck300 FIND v(dout1_23) AT=310.05n

.meas tran vdout1_24ck300 FIND v(dout1_24) AT=310.05n

.meas tran vdout1_25ck300 FIND v(dout1_25) AT=310.05n

.meas tran vdout1_26ck300 FIND v(dout1_26) AT=310.05n

.meas tran vdout1_27ck300 FIND v(dout1_27) AT=310.05n

.meas tran vdout1_28ck300 FIND v(dout1_28) AT=310.05n

.meas tran vdout1_29ck300 FIND v(dout1_29) AT=310.05n

.meas tran vdout1_30ck300 FIND v(dout1_30) AT=310.05n

.meas tran vdout1_31ck300 FIND v(dout1_31) AT=310.05n

.meas tran vdout1_32ck300 FIND v(dout1_32) AT=310.05n

.meas tran vdout1_33ck300 FIND v(dout1_33) AT=310.05n

.meas tran vdout1_34ck300 FIND v(dout1_34) AT=310.05n

.meas tran vdout1_35ck300 FIND v(dout1_35) AT=310.05n

.meas tran vdout1_36ck300 FIND v(dout1_36) AT=310.05n

.meas tran vdout1_37ck300 FIND v(dout1_37) AT=310.05n

.meas tran vdout1_38ck300 FIND v(dout1_38) AT=310.05n

.meas tran vdout1_39ck300 FIND v(dout1_39) AT=310.05n

.meas tran vdout1_40ck300 FIND v(dout1_40) AT=310.05n

.meas tran vdout1_41ck300 FIND v(dout1_41) AT=310.05n

.meas tran vdout1_42ck300 FIND v(dout1_42) AT=310.05n

.meas tran vdout1_43ck300 FIND v(dout1_43) AT=310.05n

.meas tran vdout1_44ck300 FIND v(dout1_44) AT=310.05n

.meas tran vdout1_45ck300 FIND v(dout1_45) AT=310.05n

.meas tran vdout1_46ck300 FIND v(dout1_46) AT=310.05n

.meas tran vdout1_47ck300 FIND v(dout1_47) AT=310.05n

.meas tran vdout1_48ck300 FIND v(dout1_48) AT=310.05n

.meas tran vdout1_49ck300 FIND v(dout1_49) AT=310.05n

.meas tran vdout1_50ck300 FIND v(dout1_50) AT=310.05n

.meas tran vdout1_51ck300 FIND v(dout1_51) AT=310.05n

.meas tran vdout1_52ck300 FIND v(dout1_52) AT=310.05n

.meas tran vdout1_53ck300 FIND v(dout1_53) AT=310.05n

.meas tran vdout1_54ck300 FIND v(dout1_54) AT=310.05n

.meas tran vdout1_55ck300 FIND v(dout1_55) AT=310.05n

.meas tran vdout1_56ck300 FIND v(dout1_56) AT=310.05n

.meas tran vdout1_57ck300 FIND v(dout1_57) AT=310.05n

.meas tran vdout1_58ck300 FIND v(dout1_58) AT=310.05n

.meas tran vdout1_59ck300 FIND v(dout1_59) AT=310.05n

.meas tran vdout1_60ck300 FIND v(dout1_60) AT=310.05n

.meas tran vdout1_61ck300 FIND v(dout1_61) AT=310.05n

.meas tran vdout1_62ck300 FIND v(dout1_62) AT=310.05n

.meas tran vdout1_63ck300 FIND v(dout1_63) AT=310.05n

.meas tran vdout1_64ck300 FIND v(dout1_64) AT=310.05n

.meas tran vdout1_65ck300 FIND v(dout1_65) AT=310.05n

.meas tran vdout1_66ck300 FIND v(dout1_66) AT=310.05n

.meas tran vdout1_67ck300 FIND v(dout1_67) AT=310.05n

.meas tran vdout1_68ck300 FIND v(dout1_68) AT=310.05n

.meas tran vdout1_69ck300 FIND v(dout1_69) AT=310.05n

.meas tran vdout1_70ck300 FIND v(dout1_70) AT=310.05n

.meas tran vdout1_71ck300 FIND v(dout1_71) AT=310.05n

.meas tran vdout1_72ck300 FIND v(dout1_72) AT=310.05n

.meas tran vdout1_73ck300 FIND v(dout1_73) AT=310.05n

.meas tran vdout1_74ck300 FIND v(dout1_74) AT=310.05n

.meas tran vdout1_75ck300 FIND v(dout1_75) AT=310.05n

.meas tran vdout1_76ck300 FIND v(dout1_76) AT=310.05n

.meas tran vdout1_77ck300 FIND v(dout1_77) AT=310.05n

.meas tran vdout1_78ck300 FIND v(dout1_78) AT=310.05n

.meas tran vdout1_79ck300 FIND v(dout1_79) AT=310.05n

.meas tran vdout1_80ck300 FIND v(dout1_80) AT=310.05n

.meas tran vdout1_81ck300 FIND v(dout1_81) AT=310.05n

.meas tran vdout1_82ck300 FIND v(dout1_82) AT=310.05n

.meas tran vdout1_83ck300 FIND v(dout1_83) AT=310.05n

.meas tran vdout1_84ck300 FIND v(dout1_84) AT=310.05n

.meas tran vdout1_85ck300 FIND v(dout1_85) AT=310.05n

.meas tran vdout1_86ck300 FIND v(dout1_86) AT=310.05n

.meas tran vdout1_87ck300 FIND v(dout1_87) AT=310.05n

.meas tran vdout1_88ck300 FIND v(dout1_88) AT=310.05n

.meas tran vdout1_89ck300 FIND v(dout1_89) AT=310.05n

.meas tran vdout1_90ck300 FIND v(dout1_90) AT=310.05n

.meas tran vdout1_91ck300 FIND v(dout1_91) AT=310.05n

.meas tran vdout1_92ck300 FIND v(dout1_92) AT=310.05n

.meas tran vdout1_93ck300 FIND v(dout1_93) AT=310.05n

.meas tran vdout1_94ck300 FIND v(dout1_94) AT=310.05n

.meas tran vdout1_95ck300 FIND v(dout1_95) AT=310.05n

.meas tran vdout1_96ck300 FIND v(dout1_96) AT=310.05n

.meas tran vdout1_97ck300 FIND v(dout1_97) AT=310.05n

.meas tran vdout1_98ck300 FIND v(dout1_98) AT=310.05n

.meas tran vdout1_99ck300 FIND v(dout1_99) AT=310.05n

.meas tran vdout1_100ck300 FIND v(dout1_100) AT=310.05n

.meas tran vdout1_101ck300 FIND v(dout1_101) AT=310.05n

.meas tran vdout1_102ck300 FIND v(dout1_102) AT=310.05n

.meas tran vdout1_103ck300 FIND v(dout1_103) AT=310.05n

.meas tran vdout1_104ck300 FIND v(dout1_104) AT=310.05n

.meas tran vdout1_105ck300 FIND v(dout1_105) AT=310.05n

.meas tran vdout1_106ck300 FIND v(dout1_106) AT=310.05n

.meas tran vdout1_107ck300 FIND v(dout1_107) AT=310.05n

.meas tran vdout1_108ck300 FIND v(dout1_108) AT=310.05n

.meas tran vdout1_109ck300 FIND v(dout1_109) AT=310.05n

.meas tran vdout1_110ck300 FIND v(dout1_110) AT=310.05n

.meas tran vdout1_111ck300 FIND v(dout1_111) AT=310.05n

.meas tran vdout1_112ck300 FIND v(dout1_112) AT=310.05n

.meas tran vdout1_113ck300 FIND v(dout1_113) AT=310.05n

.meas tran vdout1_114ck300 FIND v(dout1_114) AT=310.05n

.meas tran vdout1_115ck300 FIND v(dout1_115) AT=310.05n

.meas tran vdout1_116ck300 FIND v(dout1_116) AT=310.05n

.meas tran vdout1_117ck300 FIND v(dout1_117) AT=310.05n

.meas tran vdout1_118ck300 FIND v(dout1_118) AT=310.05n

.meas tran vdout1_119ck300 FIND v(dout1_119) AT=310.05n

.meas tran vdout1_120ck300 FIND v(dout1_120) AT=310.05n

.meas tran vdout1_121ck300 FIND v(dout1_121) AT=310.05n

.meas tran vdout1_122ck300 FIND v(dout1_122) AT=310.05n

.meas tran vdout1_123ck300 FIND v(dout1_123) AT=310.05n

.meas tran vdout1_124ck300 FIND v(dout1_124) AT=310.05n

.meas tran vdout1_125ck300 FIND v(dout1_125) AT=310.05n

.meas tran vdout1_126ck300 FIND v(dout1_126) AT=310.05n

.meas tran vdout1_127ck300 FIND v(dout1_127) AT=310.05n

.meas tran vdout1_128ck300 FIND v(dout1_128) AT=310.05n

.meas tran vdout1_129ck300 FIND v(dout1_129) AT=310.05n

.meas tran vdout1_130ck300 FIND v(dout1_130) AT=310.05n

.meas tran vdout1_131ck300 FIND v(dout1_131) AT=310.05n

.meas tran vdout1_132ck300 FIND v(dout1_132) AT=310.05n

.meas tran vdout1_133ck300 FIND v(dout1_133) AT=310.05n

.meas tran vdout1_134ck300 FIND v(dout1_134) AT=310.05n

.meas tran vdout1_135ck300 FIND v(dout1_135) AT=310.05n

.meas tran vdout1_136ck300 FIND v(dout1_136) AT=310.05n

.meas tran vdout1_137ck300 FIND v(dout1_137) AT=310.05n

.meas tran vdout1_138ck300 FIND v(dout1_138) AT=310.05n

.meas tran vdout1_139ck300 FIND v(dout1_139) AT=310.05n

.meas tran vdout1_140ck300 FIND v(dout1_140) AT=310.05n

.meas tran vdout1_141ck300 FIND v(dout1_141) AT=310.05n

.meas tran vdout1_142ck300 FIND v(dout1_142) AT=310.05n

.meas tran vdout1_143ck300 FIND v(dout1_143) AT=310.05n

.meas tran vdout1_144ck300 FIND v(dout1_144) AT=310.05n

.meas tran vdout1_145ck300 FIND v(dout1_145) AT=310.05n

.meas tran vdout1_146ck300 FIND v(dout1_146) AT=310.05n

.meas tran vdout1_147ck300 FIND v(dout1_147) AT=310.05n

.meas tran vdout1_148ck300 FIND v(dout1_148) AT=310.05n

.meas tran vdout1_149ck300 FIND v(dout1_149) AT=310.05n

.meas tran vdout1_150ck300 FIND v(dout1_150) AT=310.05n

.meas tran vdout1_151ck300 FIND v(dout1_151) AT=310.05n

.meas tran vdout1_152ck300 FIND v(dout1_152) AT=310.05n

.meas tran vdout1_153ck300 FIND v(dout1_153) AT=310.05n

.meas tran vdout1_154ck300 FIND v(dout1_154) AT=310.05n

.meas tran vdout1_155ck300 FIND v(dout1_155) AT=310.05n

.meas tran vdout1_156ck300 FIND v(dout1_156) AT=310.05n

.meas tran vdout1_157ck300 FIND v(dout1_157) AT=310.05n

.meas tran vdout1_158ck300 FIND v(dout1_158) AT=310.05n

.meas tran vdout1_159ck300 FIND v(dout1_159) AT=310.05n

.meas tran vdout1_160ck300 FIND v(dout1_160) AT=310.05n

.meas tran vdout1_161ck300 FIND v(dout1_161) AT=310.05n

.meas tran vdout1_162ck300 FIND v(dout1_162) AT=310.05n

.meas tran vdout1_163ck300 FIND v(dout1_163) AT=310.05n

.meas tran vdout1_164ck300 FIND v(dout1_164) AT=310.05n

.meas tran vdout1_165ck300 FIND v(dout1_165) AT=310.05n

.meas tran vdout1_166ck300 FIND v(dout1_166) AT=310.05n

.meas tran vdout1_167ck300 FIND v(dout1_167) AT=310.05n

.meas tran vdout1_168ck300 FIND v(dout1_168) AT=310.05n

.meas tran vdout1_169ck300 FIND v(dout1_169) AT=310.05n

.meas tran vdout1_170ck300 FIND v(dout1_170) AT=310.05n

.meas tran vdout1_171ck300 FIND v(dout1_171) AT=310.05n

.meas tran vdout1_172ck300 FIND v(dout1_172) AT=310.05n

.meas tran vdout1_173ck300 FIND v(dout1_173) AT=310.05n

.meas tran vdout1_174ck300 FIND v(dout1_174) AT=310.05n

.meas tran vdout1_175ck300 FIND v(dout1_175) AT=310.05n

.meas tran vdout1_176ck300 FIND v(dout1_176) AT=310.05n

.meas tran vdout1_177ck300 FIND v(dout1_177) AT=310.05n

.meas tran vdout1_178ck300 FIND v(dout1_178) AT=310.05n

.meas tran vdout1_179ck300 FIND v(dout1_179) AT=310.05n

.meas tran vdout1_180ck300 FIND v(dout1_180) AT=310.05n

.meas tran vdout1_181ck300 FIND v(dout1_181) AT=310.05n

.meas tran vdout1_182ck300 FIND v(dout1_182) AT=310.05n

.meas tran vdout1_183ck300 FIND v(dout1_183) AT=310.05n

.meas tran vdout1_184ck300 FIND v(dout1_184) AT=310.05n

.meas tran vdout1_185ck300 FIND v(dout1_185) AT=310.05n

.meas tran vdout1_186ck300 FIND v(dout1_186) AT=310.05n

.meas tran vdout1_187ck300 FIND v(dout1_187) AT=310.05n

.meas tran vdout1_188ck300 FIND v(dout1_188) AT=310.05n

.meas tran vdout1_189ck300 FIND v(dout1_189) AT=310.05n

.meas tran vdout1_190ck300 FIND v(dout1_190) AT=310.05n

.meas tran vdout1_191ck300 FIND v(dout1_191) AT=310.05n

.meas tran vdout1_192ck300 FIND v(dout1_192) AT=310.05n

.meas tran vdout1_193ck300 FIND v(dout1_193) AT=310.05n

.meas tran vdout1_194ck300 FIND v(dout1_194) AT=310.05n

.meas tran vdout1_195ck300 FIND v(dout1_195) AT=310.05n

.meas tran vdout1_196ck300 FIND v(dout1_196) AT=310.05n

.meas tran vdout1_197ck300 FIND v(dout1_197) AT=310.05n

.meas tran vdout1_198ck300 FIND v(dout1_198) AT=310.05n

.meas tran vdout1_199ck300 FIND v(dout1_199) AT=310.05n

.meas tran vdout1_200ck300 FIND v(dout1_200) AT=310.05n

.meas tran vdout1_201ck300 FIND v(dout1_201) AT=310.05n

.meas tran vdout1_202ck300 FIND v(dout1_202) AT=310.05n

.meas tran vdout1_203ck300 FIND v(dout1_203) AT=310.05n

.meas tran vdout1_204ck300 FIND v(dout1_204) AT=310.05n

.meas tran vdout1_205ck300 FIND v(dout1_205) AT=310.05n

.meas tran vdout1_206ck300 FIND v(dout1_206) AT=310.05n

.meas tran vdout1_207ck300 FIND v(dout1_207) AT=310.05n

.meas tran vdout1_208ck300 FIND v(dout1_208) AT=310.05n

.meas tran vdout1_209ck300 FIND v(dout1_209) AT=310.05n

.meas tran vdout1_210ck300 FIND v(dout1_210) AT=310.05n

.meas tran vdout1_211ck300 FIND v(dout1_211) AT=310.05n

.meas tran vdout1_212ck300 FIND v(dout1_212) AT=310.05n

.meas tran vdout1_213ck300 FIND v(dout1_213) AT=310.05n

.meas tran vdout1_214ck300 FIND v(dout1_214) AT=310.05n

.meas tran vdout1_215ck300 FIND v(dout1_215) AT=310.05n

.meas tran vdout1_216ck300 FIND v(dout1_216) AT=310.05n

.meas tran vdout1_217ck300 FIND v(dout1_217) AT=310.05n

.meas tran vdout1_218ck300 FIND v(dout1_218) AT=310.05n

.meas tran vdout1_219ck300 FIND v(dout1_219) AT=310.05n

.meas tran vdout1_220ck300 FIND v(dout1_220) AT=310.05n

.meas tran vdout1_221ck300 FIND v(dout1_221) AT=310.05n

.meas tran vdout1_222ck300 FIND v(dout1_222) AT=310.05n

.meas tran vdout1_223ck300 FIND v(dout1_223) AT=310.05n

.meas tran vdout1_224ck300 FIND v(dout1_224) AT=310.05n

.meas tran vdout1_225ck300 FIND v(dout1_225) AT=310.05n

.meas tran vdout1_226ck300 FIND v(dout1_226) AT=310.05n

.meas tran vdout1_227ck300 FIND v(dout1_227) AT=310.05n

.meas tran vdout1_228ck300 FIND v(dout1_228) AT=310.05n

.meas tran vdout1_229ck300 FIND v(dout1_229) AT=310.05n

.meas tran vdout1_230ck300 FIND v(dout1_230) AT=310.05n

.meas tran vdout1_231ck300 FIND v(dout1_231) AT=310.05n

.meas tran vdout1_232ck300 FIND v(dout1_232) AT=310.05n

.meas tran vdout1_233ck300 FIND v(dout1_233) AT=310.05n

.meas tran vdout1_234ck300 FIND v(dout1_234) AT=310.05n

.meas tran vdout1_235ck300 FIND v(dout1_235) AT=310.05n

.meas tran vdout1_236ck300 FIND v(dout1_236) AT=310.05n

.meas tran vdout1_237ck300 FIND v(dout1_237) AT=310.05n

.meas tran vdout1_238ck300 FIND v(dout1_238) AT=310.05n

.meas tran vdout1_239ck300 FIND v(dout1_239) AT=310.05n

.meas tran vdout1_240ck300 FIND v(dout1_240) AT=310.05n

.meas tran vdout1_241ck300 FIND v(dout1_241) AT=310.05n

.meas tran vdout1_242ck300 FIND v(dout1_242) AT=310.05n

.meas tran vdout1_243ck300 FIND v(dout1_243) AT=310.05n

.meas tran vdout1_244ck300 FIND v(dout1_244) AT=310.05n

.meas tran vdout1_245ck300 FIND v(dout1_245) AT=310.05n

.meas tran vdout1_246ck300 FIND v(dout1_246) AT=310.05n

.meas tran vdout1_247ck300 FIND v(dout1_247) AT=310.05n

.meas tran vdout1_248ck300 FIND v(dout1_248) AT=310.05n

.meas tran vdout1_249ck300 FIND v(dout1_249) AT=310.05n

.meas tran vdout1_250ck300 FIND v(dout1_250) AT=310.05n

.meas tran vdout1_251ck300 FIND v(dout1_251) AT=310.05n

.meas tran vdout1_252ck300 FIND v(dout1_252) AT=310.05n

.meas tran vdout1_253ck300 FIND v(dout1_253) AT=310.05n

.meas tran vdout1_254ck300 FIND v(dout1_254) AT=310.05n

.meas tran vdout1_255ck300 FIND v(dout1_255) AT=310.05n

.meas tran vdout1_256ck300 FIND v(dout1_256) AT=310.05n

.meas tran vdout1_0ck350 FIND v(dout1_0) AT=360.05n

.meas tran vdout1_1ck350 FIND v(dout1_1) AT=360.05n

.meas tran vdout1_2ck350 FIND v(dout1_2) AT=360.05n

.meas tran vdout1_3ck350 FIND v(dout1_3) AT=360.05n

.meas tran vdout1_4ck350 FIND v(dout1_4) AT=360.05n

.meas tran vdout1_5ck350 FIND v(dout1_5) AT=360.05n

.meas tran vdout1_6ck350 FIND v(dout1_6) AT=360.05n

.meas tran vdout1_7ck350 FIND v(dout1_7) AT=360.05n

.meas tran vdout1_8ck350 FIND v(dout1_8) AT=360.05n

.meas tran vdout1_9ck350 FIND v(dout1_9) AT=360.05n

.meas tran vdout1_10ck350 FIND v(dout1_10) AT=360.05n

.meas tran vdout1_11ck350 FIND v(dout1_11) AT=360.05n

.meas tran vdout1_12ck350 FIND v(dout1_12) AT=360.05n

.meas tran vdout1_13ck350 FIND v(dout1_13) AT=360.05n

.meas tran vdout1_14ck350 FIND v(dout1_14) AT=360.05n

.meas tran vdout1_15ck350 FIND v(dout1_15) AT=360.05n

.meas tran vdout1_16ck350 FIND v(dout1_16) AT=360.05n

.meas tran vdout1_17ck350 FIND v(dout1_17) AT=360.05n

.meas tran vdout1_18ck350 FIND v(dout1_18) AT=360.05n

.meas tran vdout1_19ck350 FIND v(dout1_19) AT=360.05n

.meas tran vdout1_20ck350 FIND v(dout1_20) AT=360.05n

.meas tran vdout1_21ck350 FIND v(dout1_21) AT=360.05n

.meas tran vdout1_22ck350 FIND v(dout1_22) AT=360.05n

.meas tran vdout1_23ck350 FIND v(dout1_23) AT=360.05n

.meas tran vdout1_24ck350 FIND v(dout1_24) AT=360.05n

.meas tran vdout1_25ck350 FIND v(dout1_25) AT=360.05n

.meas tran vdout1_26ck350 FIND v(dout1_26) AT=360.05n

.meas tran vdout1_27ck350 FIND v(dout1_27) AT=360.05n

.meas tran vdout1_28ck350 FIND v(dout1_28) AT=360.05n

.meas tran vdout1_29ck350 FIND v(dout1_29) AT=360.05n

.meas tran vdout1_30ck350 FIND v(dout1_30) AT=360.05n

.meas tran vdout1_31ck350 FIND v(dout1_31) AT=360.05n

.meas tran vdout1_32ck350 FIND v(dout1_32) AT=360.05n

.meas tran vdout1_33ck350 FIND v(dout1_33) AT=360.05n

.meas tran vdout1_34ck350 FIND v(dout1_34) AT=360.05n

.meas tran vdout1_35ck350 FIND v(dout1_35) AT=360.05n

.meas tran vdout1_36ck350 FIND v(dout1_36) AT=360.05n

.meas tran vdout1_37ck350 FIND v(dout1_37) AT=360.05n

.meas tran vdout1_38ck350 FIND v(dout1_38) AT=360.05n

.meas tran vdout1_39ck350 FIND v(dout1_39) AT=360.05n

.meas tran vdout1_40ck350 FIND v(dout1_40) AT=360.05n

.meas tran vdout1_41ck350 FIND v(dout1_41) AT=360.05n

.meas tran vdout1_42ck350 FIND v(dout1_42) AT=360.05n

.meas tran vdout1_43ck350 FIND v(dout1_43) AT=360.05n

.meas tran vdout1_44ck350 FIND v(dout1_44) AT=360.05n

.meas tran vdout1_45ck350 FIND v(dout1_45) AT=360.05n

.meas tran vdout1_46ck350 FIND v(dout1_46) AT=360.05n

.meas tran vdout1_47ck350 FIND v(dout1_47) AT=360.05n

.meas tran vdout1_48ck350 FIND v(dout1_48) AT=360.05n

.meas tran vdout1_49ck350 FIND v(dout1_49) AT=360.05n

.meas tran vdout1_50ck350 FIND v(dout1_50) AT=360.05n

.meas tran vdout1_51ck350 FIND v(dout1_51) AT=360.05n

.meas tran vdout1_52ck350 FIND v(dout1_52) AT=360.05n

.meas tran vdout1_53ck350 FIND v(dout1_53) AT=360.05n

.meas tran vdout1_54ck350 FIND v(dout1_54) AT=360.05n

.meas tran vdout1_55ck350 FIND v(dout1_55) AT=360.05n

.meas tran vdout1_56ck350 FIND v(dout1_56) AT=360.05n

.meas tran vdout1_57ck350 FIND v(dout1_57) AT=360.05n

.meas tran vdout1_58ck350 FIND v(dout1_58) AT=360.05n

.meas tran vdout1_59ck350 FIND v(dout1_59) AT=360.05n

.meas tran vdout1_60ck350 FIND v(dout1_60) AT=360.05n

.meas tran vdout1_61ck350 FIND v(dout1_61) AT=360.05n

.meas tran vdout1_62ck350 FIND v(dout1_62) AT=360.05n

.meas tran vdout1_63ck350 FIND v(dout1_63) AT=360.05n

.meas tran vdout1_64ck350 FIND v(dout1_64) AT=360.05n

.meas tran vdout1_65ck350 FIND v(dout1_65) AT=360.05n

.meas tran vdout1_66ck350 FIND v(dout1_66) AT=360.05n

.meas tran vdout1_67ck350 FIND v(dout1_67) AT=360.05n

.meas tran vdout1_68ck350 FIND v(dout1_68) AT=360.05n

.meas tran vdout1_69ck350 FIND v(dout1_69) AT=360.05n

.meas tran vdout1_70ck350 FIND v(dout1_70) AT=360.05n

.meas tran vdout1_71ck350 FIND v(dout1_71) AT=360.05n

.meas tran vdout1_72ck350 FIND v(dout1_72) AT=360.05n

.meas tran vdout1_73ck350 FIND v(dout1_73) AT=360.05n

.meas tran vdout1_74ck350 FIND v(dout1_74) AT=360.05n

.meas tran vdout1_75ck350 FIND v(dout1_75) AT=360.05n

.meas tran vdout1_76ck350 FIND v(dout1_76) AT=360.05n

.meas tran vdout1_77ck350 FIND v(dout1_77) AT=360.05n

.meas tran vdout1_78ck350 FIND v(dout1_78) AT=360.05n

.meas tran vdout1_79ck350 FIND v(dout1_79) AT=360.05n

.meas tran vdout1_80ck350 FIND v(dout1_80) AT=360.05n

.meas tran vdout1_81ck350 FIND v(dout1_81) AT=360.05n

.meas tran vdout1_82ck350 FIND v(dout1_82) AT=360.05n

.meas tran vdout1_83ck350 FIND v(dout1_83) AT=360.05n

.meas tran vdout1_84ck350 FIND v(dout1_84) AT=360.05n

.meas tran vdout1_85ck350 FIND v(dout1_85) AT=360.05n

.meas tran vdout1_86ck350 FIND v(dout1_86) AT=360.05n

.meas tran vdout1_87ck350 FIND v(dout1_87) AT=360.05n

.meas tran vdout1_88ck350 FIND v(dout1_88) AT=360.05n

.meas tran vdout1_89ck350 FIND v(dout1_89) AT=360.05n

.meas tran vdout1_90ck350 FIND v(dout1_90) AT=360.05n

.meas tran vdout1_91ck350 FIND v(dout1_91) AT=360.05n

.meas tran vdout1_92ck350 FIND v(dout1_92) AT=360.05n

.meas tran vdout1_93ck350 FIND v(dout1_93) AT=360.05n

.meas tran vdout1_94ck350 FIND v(dout1_94) AT=360.05n

.meas tran vdout1_95ck350 FIND v(dout1_95) AT=360.05n

.meas tran vdout1_96ck350 FIND v(dout1_96) AT=360.05n

.meas tran vdout1_97ck350 FIND v(dout1_97) AT=360.05n

.meas tran vdout1_98ck350 FIND v(dout1_98) AT=360.05n

.meas tran vdout1_99ck350 FIND v(dout1_99) AT=360.05n

.meas tran vdout1_100ck350 FIND v(dout1_100) AT=360.05n

.meas tran vdout1_101ck350 FIND v(dout1_101) AT=360.05n

.meas tran vdout1_102ck350 FIND v(dout1_102) AT=360.05n

.meas tran vdout1_103ck350 FIND v(dout1_103) AT=360.05n

.meas tran vdout1_104ck350 FIND v(dout1_104) AT=360.05n

.meas tran vdout1_105ck350 FIND v(dout1_105) AT=360.05n

.meas tran vdout1_106ck350 FIND v(dout1_106) AT=360.05n

.meas tran vdout1_107ck350 FIND v(dout1_107) AT=360.05n

.meas tran vdout1_108ck350 FIND v(dout1_108) AT=360.05n

.meas tran vdout1_109ck350 FIND v(dout1_109) AT=360.05n

.meas tran vdout1_110ck350 FIND v(dout1_110) AT=360.05n

.meas tran vdout1_111ck350 FIND v(dout1_111) AT=360.05n

.meas tran vdout1_112ck350 FIND v(dout1_112) AT=360.05n

.meas tran vdout1_113ck350 FIND v(dout1_113) AT=360.05n

.meas tran vdout1_114ck350 FIND v(dout1_114) AT=360.05n

.meas tran vdout1_115ck350 FIND v(dout1_115) AT=360.05n

.meas tran vdout1_116ck350 FIND v(dout1_116) AT=360.05n

.meas tran vdout1_117ck350 FIND v(dout1_117) AT=360.05n

.meas tran vdout1_118ck350 FIND v(dout1_118) AT=360.05n

.meas tran vdout1_119ck350 FIND v(dout1_119) AT=360.05n

.meas tran vdout1_120ck350 FIND v(dout1_120) AT=360.05n

.meas tran vdout1_121ck350 FIND v(dout1_121) AT=360.05n

.meas tran vdout1_122ck350 FIND v(dout1_122) AT=360.05n

.meas tran vdout1_123ck350 FIND v(dout1_123) AT=360.05n

.meas tran vdout1_124ck350 FIND v(dout1_124) AT=360.05n

.meas tran vdout1_125ck350 FIND v(dout1_125) AT=360.05n

.meas tran vdout1_126ck350 FIND v(dout1_126) AT=360.05n

.meas tran vdout1_127ck350 FIND v(dout1_127) AT=360.05n

.meas tran vdout1_128ck350 FIND v(dout1_128) AT=360.05n

.meas tran vdout1_129ck350 FIND v(dout1_129) AT=360.05n

.meas tran vdout1_130ck350 FIND v(dout1_130) AT=360.05n

.meas tran vdout1_131ck350 FIND v(dout1_131) AT=360.05n

.meas tran vdout1_132ck350 FIND v(dout1_132) AT=360.05n

.meas tran vdout1_133ck350 FIND v(dout1_133) AT=360.05n

.meas tran vdout1_134ck350 FIND v(dout1_134) AT=360.05n

.meas tran vdout1_135ck350 FIND v(dout1_135) AT=360.05n

.meas tran vdout1_136ck350 FIND v(dout1_136) AT=360.05n

.meas tran vdout1_137ck350 FIND v(dout1_137) AT=360.05n

.meas tran vdout1_138ck350 FIND v(dout1_138) AT=360.05n

.meas tran vdout1_139ck350 FIND v(dout1_139) AT=360.05n

.meas tran vdout1_140ck350 FIND v(dout1_140) AT=360.05n

.meas tran vdout1_141ck350 FIND v(dout1_141) AT=360.05n

.meas tran vdout1_142ck350 FIND v(dout1_142) AT=360.05n

.meas tran vdout1_143ck350 FIND v(dout1_143) AT=360.05n

.meas tran vdout1_144ck350 FIND v(dout1_144) AT=360.05n

.meas tran vdout1_145ck350 FIND v(dout1_145) AT=360.05n

.meas tran vdout1_146ck350 FIND v(dout1_146) AT=360.05n

.meas tran vdout1_147ck350 FIND v(dout1_147) AT=360.05n

.meas tran vdout1_148ck350 FIND v(dout1_148) AT=360.05n

.meas tran vdout1_149ck350 FIND v(dout1_149) AT=360.05n

.meas tran vdout1_150ck350 FIND v(dout1_150) AT=360.05n

.meas tran vdout1_151ck350 FIND v(dout1_151) AT=360.05n

.meas tran vdout1_152ck350 FIND v(dout1_152) AT=360.05n

.meas tran vdout1_153ck350 FIND v(dout1_153) AT=360.05n

.meas tran vdout1_154ck350 FIND v(dout1_154) AT=360.05n

.meas tran vdout1_155ck350 FIND v(dout1_155) AT=360.05n

.meas tran vdout1_156ck350 FIND v(dout1_156) AT=360.05n

.meas tran vdout1_157ck350 FIND v(dout1_157) AT=360.05n

.meas tran vdout1_158ck350 FIND v(dout1_158) AT=360.05n

.meas tran vdout1_159ck350 FIND v(dout1_159) AT=360.05n

.meas tran vdout1_160ck350 FIND v(dout1_160) AT=360.05n

.meas tran vdout1_161ck350 FIND v(dout1_161) AT=360.05n

.meas tran vdout1_162ck350 FIND v(dout1_162) AT=360.05n

.meas tran vdout1_163ck350 FIND v(dout1_163) AT=360.05n

.meas tran vdout1_164ck350 FIND v(dout1_164) AT=360.05n

.meas tran vdout1_165ck350 FIND v(dout1_165) AT=360.05n

.meas tran vdout1_166ck350 FIND v(dout1_166) AT=360.05n

.meas tran vdout1_167ck350 FIND v(dout1_167) AT=360.05n

.meas tran vdout1_168ck350 FIND v(dout1_168) AT=360.05n

.meas tran vdout1_169ck350 FIND v(dout1_169) AT=360.05n

.meas tran vdout1_170ck350 FIND v(dout1_170) AT=360.05n

.meas tran vdout1_171ck350 FIND v(dout1_171) AT=360.05n

.meas tran vdout1_172ck350 FIND v(dout1_172) AT=360.05n

.meas tran vdout1_173ck350 FIND v(dout1_173) AT=360.05n

.meas tran vdout1_174ck350 FIND v(dout1_174) AT=360.05n

.meas tran vdout1_175ck350 FIND v(dout1_175) AT=360.05n

.meas tran vdout1_176ck350 FIND v(dout1_176) AT=360.05n

.meas tran vdout1_177ck350 FIND v(dout1_177) AT=360.05n

.meas tran vdout1_178ck350 FIND v(dout1_178) AT=360.05n

.meas tran vdout1_179ck350 FIND v(dout1_179) AT=360.05n

.meas tran vdout1_180ck350 FIND v(dout1_180) AT=360.05n

.meas tran vdout1_181ck350 FIND v(dout1_181) AT=360.05n

.meas tran vdout1_182ck350 FIND v(dout1_182) AT=360.05n

.meas tran vdout1_183ck350 FIND v(dout1_183) AT=360.05n

.meas tran vdout1_184ck350 FIND v(dout1_184) AT=360.05n

.meas tran vdout1_185ck350 FIND v(dout1_185) AT=360.05n

.meas tran vdout1_186ck350 FIND v(dout1_186) AT=360.05n

.meas tran vdout1_187ck350 FIND v(dout1_187) AT=360.05n

.meas tran vdout1_188ck350 FIND v(dout1_188) AT=360.05n

.meas tran vdout1_189ck350 FIND v(dout1_189) AT=360.05n

.meas tran vdout1_190ck350 FIND v(dout1_190) AT=360.05n

.meas tran vdout1_191ck350 FIND v(dout1_191) AT=360.05n

.meas tran vdout1_192ck350 FIND v(dout1_192) AT=360.05n

.meas tran vdout1_193ck350 FIND v(dout1_193) AT=360.05n

.meas tran vdout1_194ck350 FIND v(dout1_194) AT=360.05n

.meas tran vdout1_195ck350 FIND v(dout1_195) AT=360.05n

.meas tran vdout1_196ck350 FIND v(dout1_196) AT=360.05n

.meas tran vdout1_197ck350 FIND v(dout1_197) AT=360.05n

.meas tran vdout1_198ck350 FIND v(dout1_198) AT=360.05n

.meas tran vdout1_199ck350 FIND v(dout1_199) AT=360.05n

.meas tran vdout1_200ck350 FIND v(dout1_200) AT=360.05n

.meas tran vdout1_201ck350 FIND v(dout1_201) AT=360.05n

.meas tran vdout1_202ck350 FIND v(dout1_202) AT=360.05n

.meas tran vdout1_203ck350 FIND v(dout1_203) AT=360.05n

.meas tran vdout1_204ck350 FIND v(dout1_204) AT=360.05n

.meas tran vdout1_205ck350 FIND v(dout1_205) AT=360.05n

.meas tran vdout1_206ck350 FIND v(dout1_206) AT=360.05n

.meas tran vdout1_207ck350 FIND v(dout1_207) AT=360.05n

.meas tran vdout1_208ck350 FIND v(dout1_208) AT=360.05n

.meas tran vdout1_209ck350 FIND v(dout1_209) AT=360.05n

.meas tran vdout1_210ck350 FIND v(dout1_210) AT=360.05n

.meas tran vdout1_211ck350 FIND v(dout1_211) AT=360.05n

.meas tran vdout1_212ck350 FIND v(dout1_212) AT=360.05n

.meas tran vdout1_213ck350 FIND v(dout1_213) AT=360.05n

.meas tran vdout1_214ck350 FIND v(dout1_214) AT=360.05n

.meas tran vdout1_215ck350 FIND v(dout1_215) AT=360.05n

.meas tran vdout1_216ck350 FIND v(dout1_216) AT=360.05n

.meas tran vdout1_217ck350 FIND v(dout1_217) AT=360.05n

.meas tran vdout1_218ck350 FIND v(dout1_218) AT=360.05n

.meas tran vdout1_219ck350 FIND v(dout1_219) AT=360.05n

.meas tran vdout1_220ck350 FIND v(dout1_220) AT=360.05n

.meas tran vdout1_221ck350 FIND v(dout1_221) AT=360.05n

.meas tran vdout1_222ck350 FIND v(dout1_222) AT=360.05n

.meas tran vdout1_223ck350 FIND v(dout1_223) AT=360.05n

.meas tran vdout1_224ck350 FIND v(dout1_224) AT=360.05n

.meas tran vdout1_225ck350 FIND v(dout1_225) AT=360.05n

.meas tran vdout1_226ck350 FIND v(dout1_226) AT=360.05n

.meas tran vdout1_227ck350 FIND v(dout1_227) AT=360.05n

.meas tran vdout1_228ck350 FIND v(dout1_228) AT=360.05n

.meas tran vdout1_229ck350 FIND v(dout1_229) AT=360.05n

.meas tran vdout1_230ck350 FIND v(dout1_230) AT=360.05n

.meas tran vdout1_231ck350 FIND v(dout1_231) AT=360.05n

.meas tran vdout1_232ck350 FIND v(dout1_232) AT=360.05n

.meas tran vdout1_233ck350 FIND v(dout1_233) AT=360.05n

.meas tran vdout1_234ck350 FIND v(dout1_234) AT=360.05n

.meas tran vdout1_235ck350 FIND v(dout1_235) AT=360.05n

.meas tran vdout1_236ck350 FIND v(dout1_236) AT=360.05n

.meas tran vdout1_237ck350 FIND v(dout1_237) AT=360.05n

.meas tran vdout1_238ck350 FIND v(dout1_238) AT=360.05n

.meas tran vdout1_239ck350 FIND v(dout1_239) AT=360.05n

.meas tran vdout1_240ck350 FIND v(dout1_240) AT=360.05n

.meas tran vdout1_241ck350 FIND v(dout1_241) AT=360.05n

.meas tran vdout1_242ck350 FIND v(dout1_242) AT=360.05n

.meas tran vdout1_243ck350 FIND v(dout1_243) AT=360.05n

.meas tran vdout1_244ck350 FIND v(dout1_244) AT=360.05n

.meas tran vdout1_245ck350 FIND v(dout1_245) AT=360.05n

.meas tran vdout1_246ck350 FIND v(dout1_246) AT=360.05n

.meas tran vdout1_247ck350 FIND v(dout1_247) AT=360.05n

.meas tran vdout1_248ck350 FIND v(dout1_248) AT=360.05n

.meas tran vdout1_249ck350 FIND v(dout1_249) AT=360.05n

.meas tran vdout1_250ck350 FIND v(dout1_250) AT=360.05n

.meas tran vdout1_251ck350 FIND v(dout1_251) AT=360.05n

.meas tran vdout1_252ck350 FIND v(dout1_252) AT=360.05n

.meas tran vdout1_253ck350 FIND v(dout1_253) AT=360.05n

.meas tran vdout1_254ck350 FIND v(dout1_254) AT=360.05n

.meas tran vdout1_255ck350 FIND v(dout1_255) AT=360.05n

.meas tran vdout1_256ck350 FIND v(dout1_256) AT=360.05n

.meas tran vdout1_0ck390 FIND v(dout1_0) AT=400.05n

.meas tran vdout1_1ck390 FIND v(dout1_1) AT=400.05n

.meas tran vdout1_2ck390 FIND v(dout1_2) AT=400.05n

.meas tran vdout1_3ck390 FIND v(dout1_3) AT=400.05n

.meas tran vdout1_4ck390 FIND v(dout1_4) AT=400.05n

.meas tran vdout1_5ck390 FIND v(dout1_5) AT=400.05n

.meas tran vdout1_6ck390 FIND v(dout1_6) AT=400.05n

.meas tran vdout1_7ck390 FIND v(dout1_7) AT=400.05n

.meas tran vdout1_8ck390 FIND v(dout1_8) AT=400.05n

.meas tran vdout1_9ck390 FIND v(dout1_9) AT=400.05n

.meas tran vdout1_10ck390 FIND v(dout1_10) AT=400.05n

.meas tran vdout1_11ck390 FIND v(dout1_11) AT=400.05n

.meas tran vdout1_12ck390 FIND v(dout1_12) AT=400.05n

.meas tran vdout1_13ck390 FIND v(dout1_13) AT=400.05n

.meas tran vdout1_14ck390 FIND v(dout1_14) AT=400.05n

.meas tran vdout1_15ck390 FIND v(dout1_15) AT=400.05n

.meas tran vdout1_16ck390 FIND v(dout1_16) AT=400.05n

.meas tran vdout1_17ck390 FIND v(dout1_17) AT=400.05n

.meas tran vdout1_18ck390 FIND v(dout1_18) AT=400.05n

.meas tran vdout1_19ck390 FIND v(dout1_19) AT=400.05n

.meas tran vdout1_20ck390 FIND v(dout1_20) AT=400.05n

.meas tran vdout1_21ck390 FIND v(dout1_21) AT=400.05n

.meas tran vdout1_22ck390 FIND v(dout1_22) AT=400.05n

.meas tran vdout1_23ck390 FIND v(dout1_23) AT=400.05n

.meas tran vdout1_24ck390 FIND v(dout1_24) AT=400.05n

.meas tran vdout1_25ck390 FIND v(dout1_25) AT=400.05n

.meas tran vdout1_26ck390 FIND v(dout1_26) AT=400.05n

.meas tran vdout1_27ck390 FIND v(dout1_27) AT=400.05n

.meas tran vdout1_28ck390 FIND v(dout1_28) AT=400.05n

.meas tran vdout1_29ck390 FIND v(dout1_29) AT=400.05n

.meas tran vdout1_30ck390 FIND v(dout1_30) AT=400.05n

.meas tran vdout1_31ck390 FIND v(dout1_31) AT=400.05n

.meas tran vdout1_32ck390 FIND v(dout1_32) AT=400.05n

.meas tran vdout1_33ck390 FIND v(dout1_33) AT=400.05n

.meas tran vdout1_34ck390 FIND v(dout1_34) AT=400.05n

.meas tran vdout1_35ck390 FIND v(dout1_35) AT=400.05n

.meas tran vdout1_36ck390 FIND v(dout1_36) AT=400.05n

.meas tran vdout1_37ck390 FIND v(dout1_37) AT=400.05n

.meas tran vdout1_38ck390 FIND v(dout1_38) AT=400.05n

.meas tran vdout1_39ck390 FIND v(dout1_39) AT=400.05n

.meas tran vdout1_40ck390 FIND v(dout1_40) AT=400.05n

.meas tran vdout1_41ck390 FIND v(dout1_41) AT=400.05n

.meas tran vdout1_42ck390 FIND v(dout1_42) AT=400.05n

.meas tran vdout1_43ck390 FIND v(dout1_43) AT=400.05n

.meas tran vdout1_44ck390 FIND v(dout1_44) AT=400.05n

.meas tran vdout1_45ck390 FIND v(dout1_45) AT=400.05n

.meas tran vdout1_46ck390 FIND v(dout1_46) AT=400.05n

.meas tran vdout1_47ck390 FIND v(dout1_47) AT=400.05n

.meas tran vdout1_48ck390 FIND v(dout1_48) AT=400.05n

.meas tran vdout1_49ck390 FIND v(dout1_49) AT=400.05n

.meas tran vdout1_50ck390 FIND v(dout1_50) AT=400.05n

.meas tran vdout1_51ck390 FIND v(dout1_51) AT=400.05n

.meas tran vdout1_52ck390 FIND v(dout1_52) AT=400.05n

.meas tran vdout1_53ck390 FIND v(dout1_53) AT=400.05n

.meas tran vdout1_54ck390 FIND v(dout1_54) AT=400.05n

.meas tran vdout1_55ck390 FIND v(dout1_55) AT=400.05n

.meas tran vdout1_56ck390 FIND v(dout1_56) AT=400.05n

.meas tran vdout1_57ck390 FIND v(dout1_57) AT=400.05n

.meas tran vdout1_58ck390 FIND v(dout1_58) AT=400.05n

.meas tran vdout1_59ck390 FIND v(dout1_59) AT=400.05n

.meas tran vdout1_60ck390 FIND v(dout1_60) AT=400.05n

.meas tran vdout1_61ck390 FIND v(dout1_61) AT=400.05n

.meas tran vdout1_62ck390 FIND v(dout1_62) AT=400.05n

.meas tran vdout1_63ck390 FIND v(dout1_63) AT=400.05n

.meas tran vdout1_64ck390 FIND v(dout1_64) AT=400.05n

.meas tran vdout1_65ck390 FIND v(dout1_65) AT=400.05n

.meas tran vdout1_66ck390 FIND v(dout1_66) AT=400.05n

.meas tran vdout1_67ck390 FIND v(dout1_67) AT=400.05n

.meas tran vdout1_68ck390 FIND v(dout1_68) AT=400.05n

.meas tran vdout1_69ck390 FIND v(dout1_69) AT=400.05n

.meas tran vdout1_70ck390 FIND v(dout1_70) AT=400.05n

.meas tran vdout1_71ck390 FIND v(dout1_71) AT=400.05n

.meas tran vdout1_72ck390 FIND v(dout1_72) AT=400.05n

.meas tran vdout1_73ck390 FIND v(dout1_73) AT=400.05n

.meas tran vdout1_74ck390 FIND v(dout1_74) AT=400.05n

.meas tran vdout1_75ck390 FIND v(dout1_75) AT=400.05n

.meas tran vdout1_76ck390 FIND v(dout1_76) AT=400.05n

.meas tran vdout1_77ck390 FIND v(dout1_77) AT=400.05n

.meas tran vdout1_78ck390 FIND v(dout1_78) AT=400.05n

.meas tran vdout1_79ck390 FIND v(dout1_79) AT=400.05n

.meas tran vdout1_80ck390 FIND v(dout1_80) AT=400.05n

.meas tran vdout1_81ck390 FIND v(dout1_81) AT=400.05n

.meas tran vdout1_82ck390 FIND v(dout1_82) AT=400.05n

.meas tran vdout1_83ck390 FIND v(dout1_83) AT=400.05n

.meas tran vdout1_84ck390 FIND v(dout1_84) AT=400.05n

.meas tran vdout1_85ck390 FIND v(dout1_85) AT=400.05n

.meas tran vdout1_86ck390 FIND v(dout1_86) AT=400.05n

.meas tran vdout1_87ck390 FIND v(dout1_87) AT=400.05n

.meas tran vdout1_88ck390 FIND v(dout1_88) AT=400.05n

.meas tran vdout1_89ck390 FIND v(dout1_89) AT=400.05n

.meas tran vdout1_90ck390 FIND v(dout1_90) AT=400.05n

.meas tran vdout1_91ck390 FIND v(dout1_91) AT=400.05n

.meas tran vdout1_92ck390 FIND v(dout1_92) AT=400.05n

.meas tran vdout1_93ck390 FIND v(dout1_93) AT=400.05n

.meas tran vdout1_94ck390 FIND v(dout1_94) AT=400.05n

.meas tran vdout1_95ck390 FIND v(dout1_95) AT=400.05n

.meas tran vdout1_96ck390 FIND v(dout1_96) AT=400.05n

.meas tran vdout1_97ck390 FIND v(dout1_97) AT=400.05n

.meas tran vdout1_98ck390 FIND v(dout1_98) AT=400.05n

.meas tran vdout1_99ck390 FIND v(dout1_99) AT=400.05n

.meas tran vdout1_100ck390 FIND v(dout1_100) AT=400.05n

.meas tran vdout1_101ck390 FIND v(dout1_101) AT=400.05n

.meas tran vdout1_102ck390 FIND v(dout1_102) AT=400.05n

.meas tran vdout1_103ck390 FIND v(dout1_103) AT=400.05n

.meas tran vdout1_104ck390 FIND v(dout1_104) AT=400.05n

.meas tran vdout1_105ck390 FIND v(dout1_105) AT=400.05n

.meas tran vdout1_106ck390 FIND v(dout1_106) AT=400.05n

.meas tran vdout1_107ck390 FIND v(dout1_107) AT=400.05n

.meas tran vdout1_108ck390 FIND v(dout1_108) AT=400.05n

.meas tran vdout1_109ck390 FIND v(dout1_109) AT=400.05n

.meas tran vdout1_110ck390 FIND v(dout1_110) AT=400.05n

.meas tran vdout1_111ck390 FIND v(dout1_111) AT=400.05n

.meas tran vdout1_112ck390 FIND v(dout1_112) AT=400.05n

.meas tran vdout1_113ck390 FIND v(dout1_113) AT=400.05n

.meas tran vdout1_114ck390 FIND v(dout1_114) AT=400.05n

.meas tran vdout1_115ck390 FIND v(dout1_115) AT=400.05n

.meas tran vdout1_116ck390 FIND v(dout1_116) AT=400.05n

.meas tran vdout1_117ck390 FIND v(dout1_117) AT=400.05n

.meas tran vdout1_118ck390 FIND v(dout1_118) AT=400.05n

.meas tran vdout1_119ck390 FIND v(dout1_119) AT=400.05n

.meas tran vdout1_120ck390 FIND v(dout1_120) AT=400.05n

.meas tran vdout1_121ck390 FIND v(dout1_121) AT=400.05n

.meas tran vdout1_122ck390 FIND v(dout1_122) AT=400.05n

.meas tran vdout1_123ck390 FIND v(dout1_123) AT=400.05n

.meas tran vdout1_124ck390 FIND v(dout1_124) AT=400.05n

.meas tran vdout1_125ck390 FIND v(dout1_125) AT=400.05n

.meas tran vdout1_126ck390 FIND v(dout1_126) AT=400.05n

.meas tran vdout1_127ck390 FIND v(dout1_127) AT=400.05n

.meas tran vdout1_128ck390 FIND v(dout1_128) AT=400.05n

.meas tran vdout1_129ck390 FIND v(dout1_129) AT=400.05n

.meas tran vdout1_130ck390 FIND v(dout1_130) AT=400.05n

.meas tran vdout1_131ck390 FIND v(dout1_131) AT=400.05n

.meas tran vdout1_132ck390 FIND v(dout1_132) AT=400.05n

.meas tran vdout1_133ck390 FIND v(dout1_133) AT=400.05n

.meas tran vdout1_134ck390 FIND v(dout1_134) AT=400.05n

.meas tran vdout1_135ck390 FIND v(dout1_135) AT=400.05n

.meas tran vdout1_136ck390 FIND v(dout1_136) AT=400.05n

.meas tran vdout1_137ck390 FIND v(dout1_137) AT=400.05n

.meas tran vdout1_138ck390 FIND v(dout1_138) AT=400.05n

.meas tran vdout1_139ck390 FIND v(dout1_139) AT=400.05n

.meas tran vdout1_140ck390 FIND v(dout1_140) AT=400.05n

.meas tran vdout1_141ck390 FIND v(dout1_141) AT=400.05n

.meas tran vdout1_142ck390 FIND v(dout1_142) AT=400.05n

.meas tran vdout1_143ck390 FIND v(dout1_143) AT=400.05n

.meas tran vdout1_144ck390 FIND v(dout1_144) AT=400.05n

.meas tran vdout1_145ck390 FIND v(dout1_145) AT=400.05n

.meas tran vdout1_146ck390 FIND v(dout1_146) AT=400.05n

.meas tran vdout1_147ck390 FIND v(dout1_147) AT=400.05n

.meas tran vdout1_148ck390 FIND v(dout1_148) AT=400.05n

.meas tran vdout1_149ck390 FIND v(dout1_149) AT=400.05n

.meas tran vdout1_150ck390 FIND v(dout1_150) AT=400.05n

.meas tran vdout1_151ck390 FIND v(dout1_151) AT=400.05n

.meas tran vdout1_152ck390 FIND v(dout1_152) AT=400.05n

.meas tran vdout1_153ck390 FIND v(dout1_153) AT=400.05n

.meas tran vdout1_154ck390 FIND v(dout1_154) AT=400.05n

.meas tran vdout1_155ck390 FIND v(dout1_155) AT=400.05n

.meas tran vdout1_156ck390 FIND v(dout1_156) AT=400.05n

.meas tran vdout1_157ck390 FIND v(dout1_157) AT=400.05n

.meas tran vdout1_158ck390 FIND v(dout1_158) AT=400.05n

.meas tran vdout1_159ck390 FIND v(dout1_159) AT=400.05n

.meas tran vdout1_160ck390 FIND v(dout1_160) AT=400.05n

.meas tran vdout1_161ck390 FIND v(dout1_161) AT=400.05n

.meas tran vdout1_162ck390 FIND v(dout1_162) AT=400.05n

.meas tran vdout1_163ck390 FIND v(dout1_163) AT=400.05n

.meas tran vdout1_164ck390 FIND v(dout1_164) AT=400.05n

.meas tran vdout1_165ck390 FIND v(dout1_165) AT=400.05n

.meas tran vdout1_166ck390 FIND v(dout1_166) AT=400.05n

.meas tran vdout1_167ck390 FIND v(dout1_167) AT=400.05n

.meas tran vdout1_168ck390 FIND v(dout1_168) AT=400.05n

.meas tran vdout1_169ck390 FIND v(dout1_169) AT=400.05n

.meas tran vdout1_170ck390 FIND v(dout1_170) AT=400.05n

.meas tran vdout1_171ck390 FIND v(dout1_171) AT=400.05n

.meas tran vdout1_172ck390 FIND v(dout1_172) AT=400.05n

.meas tran vdout1_173ck390 FIND v(dout1_173) AT=400.05n

.meas tran vdout1_174ck390 FIND v(dout1_174) AT=400.05n

.meas tran vdout1_175ck390 FIND v(dout1_175) AT=400.05n

.meas tran vdout1_176ck390 FIND v(dout1_176) AT=400.05n

.meas tran vdout1_177ck390 FIND v(dout1_177) AT=400.05n

.meas tran vdout1_178ck390 FIND v(dout1_178) AT=400.05n

.meas tran vdout1_179ck390 FIND v(dout1_179) AT=400.05n

.meas tran vdout1_180ck390 FIND v(dout1_180) AT=400.05n

.meas tran vdout1_181ck390 FIND v(dout1_181) AT=400.05n

.meas tran vdout1_182ck390 FIND v(dout1_182) AT=400.05n

.meas tran vdout1_183ck390 FIND v(dout1_183) AT=400.05n

.meas tran vdout1_184ck390 FIND v(dout1_184) AT=400.05n

.meas tran vdout1_185ck390 FIND v(dout1_185) AT=400.05n

.meas tran vdout1_186ck390 FIND v(dout1_186) AT=400.05n

.meas tran vdout1_187ck390 FIND v(dout1_187) AT=400.05n

.meas tran vdout1_188ck390 FIND v(dout1_188) AT=400.05n

.meas tran vdout1_189ck390 FIND v(dout1_189) AT=400.05n

.meas tran vdout1_190ck390 FIND v(dout1_190) AT=400.05n

.meas tran vdout1_191ck390 FIND v(dout1_191) AT=400.05n

.meas tran vdout1_192ck390 FIND v(dout1_192) AT=400.05n

.meas tran vdout1_193ck390 FIND v(dout1_193) AT=400.05n

.meas tran vdout1_194ck390 FIND v(dout1_194) AT=400.05n

.meas tran vdout1_195ck390 FIND v(dout1_195) AT=400.05n

.meas tran vdout1_196ck390 FIND v(dout1_196) AT=400.05n

.meas tran vdout1_197ck390 FIND v(dout1_197) AT=400.05n

.meas tran vdout1_198ck390 FIND v(dout1_198) AT=400.05n

.meas tran vdout1_199ck390 FIND v(dout1_199) AT=400.05n

.meas tran vdout1_200ck390 FIND v(dout1_200) AT=400.05n

.meas tran vdout1_201ck390 FIND v(dout1_201) AT=400.05n

.meas tran vdout1_202ck390 FIND v(dout1_202) AT=400.05n

.meas tran vdout1_203ck390 FIND v(dout1_203) AT=400.05n

.meas tran vdout1_204ck390 FIND v(dout1_204) AT=400.05n

.meas tran vdout1_205ck390 FIND v(dout1_205) AT=400.05n

.meas tran vdout1_206ck390 FIND v(dout1_206) AT=400.05n

.meas tran vdout1_207ck390 FIND v(dout1_207) AT=400.05n

.meas tran vdout1_208ck390 FIND v(dout1_208) AT=400.05n

.meas tran vdout1_209ck390 FIND v(dout1_209) AT=400.05n

.meas tran vdout1_210ck390 FIND v(dout1_210) AT=400.05n

.meas tran vdout1_211ck390 FIND v(dout1_211) AT=400.05n

.meas tran vdout1_212ck390 FIND v(dout1_212) AT=400.05n

.meas tran vdout1_213ck390 FIND v(dout1_213) AT=400.05n

.meas tran vdout1_214ck390 FIND v(dout1_214) AT=400.05n

.meas tran vdout1_215ck390 FIND v(dout1_215) AT=400.05n

.meas tran vdout1_216ck390 FIND v(dout1_216) AT=400.05n

.meas tran vdout1_217ck390 FIND v(dout1_217) AT=400.05n

.meas tran vdout1_218ck390 FIND v(dout1_218) AT=400.05n

.meas tran vdout1_219ck390 FIND v(dout1_219) AT=400.05n

.meas tran vdout1_220ck390 FIND v(dout1_220) AT=400.05n

.meas tran vdout1_221ck390 FIND v(dout1_221) AT=400.05n

.meas tran vdout1_222ck390 FIND v(dout1_222) AT=400.05n

.meas tran vdout1_223ck390 FIND v(dout1_223) AT=400.05n

.meas tran vdout1_224ck390 FIND v(dout1_224) AT=400.05n

.meas tran vdout1_225ck390 FIND v(dout1_225) AT=400.05n

.meas tran vdout1_226ck390 FIND v(dout1_226) AT=400.05n

.meas tran vdout1_227ck390 FIND v(dout1_227) AT=400.05n

.meas tran vdout1_228ck390 FIND v(dout1_228) AT=400.05n

.meas tran vdout1_229ck390 FIND v(dout1_229) AT=400.05n

.meas tran vdout1_230ck390 FIND v(dout1_230) AT=400.05n

.meas tran vdout1_231ck390 FIND v(dout1_231) AT=400.05n

.meas tran vdout1_232ck390 FIND v(dout1_232) AT=400.05n

.meas tran vdout1_233ck390 FIND v(dout1_233) AT=400.05n

.meas tran vdout1_234ck390 FIND v(dout1_234) AT=400.05n

.meas tran vdout1_235ck390 FIND v(dout1_235) AT=400.05n

.meas tran vdout1_236ck390 FIND v(dout1_236) AT=400.05n

.meas tran vdout1_237ck390 FIND v(dout1_237) AT=400.05n

.meas tran vdout1_238ck390 FIND v(dout1_238) AT=400.05n

.meas tran vdout1_239ck390 FIND v(dout1_239) AT=400.05n

.meas tran vdout1_240ck390 FIND v(dout1_240) AT=400.05n

.meas tran vdout1_241ck390 FIND v(dout1_241) AT=400.05n

.meas tran vdout1_242ck390 FIND v(dout1_242) AT=400.05n

.meas tran vdout1_243ck390 FIND v(dout1_243) AT=400.05n

.meas tran vdout1_244ck390 FIND v(dout1_244) AT=400.05n

.meas tran vdout1_245ck390 FIND v(dout1_245) AT=400.05n

.meas tran vdout1_246ck390 FIND v(dout1_246) AT=400.05n

.meas tran vdout1_247ck390 FIND v(dout1_247) AT=400.05n

.meas tran vdout1_248ck390 FIND v(dout1_248) AT=400.05n

.meas tran vdout1_249ck390 FIND v(dout1_249) AT=400.05n

.meas tran vdout1_250ck390 FIND v(dout1_250) AT=400.05n

.meas tran vdout1_251ck390 FIND v(dout1_251) AT=400.05n

.meas tran vdout1_252ck390 FIND v(dout1_252) AT=400.05n

.meas tran vdout1_253ck390 FIND v(dout1_253) AT=400.05n

.meas tran vdout1_254ck390 FIND v(dout1_254) AT=400.05n

.meas tran vdout1_255ck390 FIND v(dout1_255) AT=400.05n

.meas tran vdout1_256ck390 FIND v(dout1_256) AT=400.05n

.meas tran vdout1_0ck410 FIND v(dout1_0) AT=420.05n

.meas tran vdout1_1ck410 FIND v(dout1_1) AT=420.05n

.meas tran vdout1_2ck410 FIND v(dout1_2) AT=420.05n

.meas tran vdout1_3ck410 FIND v(dout1_3) AT=420.05n

.meas tran vdout1_4ck410 FIND v(dout1_4) AT=420.05n

.meas tran vdout1_5ck410 FIND v(dout1_5) AT=420.05n

.meas tran vdout1_6ck410 FIND v(dout1_6) AT=420.05n

.meas tran vdout1_7ck410 FIND v(dout1_7) AT=420.05n

.meas tran vdout1_8ck410 FIND v(dout1_8) AT=420.05n

.meas tran vdout1_9ck410 FIND v(dout1_9) AT=420.05n

.meas tran vdout1_10ck410 FIND v(dout1_10) AT=420.05n

.meas tran vdout1_11ck410 FIND v(dout1_11) AT=420.05n

.meas tran vdout1_12ck410 FIND v(dout1_12) AT=420.05n

.meas tran vdout1_13ck410 FIND v(dout1_13) AT=420.05n

.meas tran vdout1_14ck410 FIND v(dout1_14) AT=420.05n

.meas tran vdout1_15ck410 FIND v(dout1_15) AT=420.05n

.meas tran vdout1_16ck410 FIND v(dout1_16) AT=420.05n

.meas tran vdout1_17ck410 FIND v(dout1_17) AT=420.05n

.meas tran vdout1_18ck410 FIND v(dout1_18) AT=420.05n

.meas tran vdout1_19ck410 FIND v(dout1_19) AT=420.05n

.meas tran vdout1_20ck410 FIND v(dout1_20) AT=420.05n

.meas tran vdout1_21ck410 FIND v(dout1_21) AT=420.05n

.meas tran vdout1_22ck410 FIND v(dout1_22) AT=420.05n

.meas tran vdout1_23ck410 FIND v(dout1_23) AT=420.05n

.meas tran vdout1_24ck410 FIND v(dout1_24) AT=420.05n

.meas tran vdout1_25ck410 FIND v(dout1_25) AT=420.05n

.meas tran vdout1_26ck410 FIND v(dout1_26) AT=420.05n

.meas tran vdout1_27ck410 FIND v(dout1_27) AT=420.05n

.meas tran vdout1_28ck410 FIND v(dout1_28) AT=420.05n

.meas tran vdout1_29ck410 FIND v(dout1_29) AT=420.05n

.meas tran vdout1_30ck410 FIND v(dout1_30) AT=420.05n

.meas tran vdout1_31ck410 FIND v(dout1_31) AT=420.05n

.meas tran vdout1_32ck410 FIND v(dout1_32) AT=420.05n

.meas tran vdout1_33ck410 FIND v(dout1_33) AT=420.05n

.meas tran vdout1_34ck410 FIND v(dout1_34) AT=420.05n

.meas tran vdout1_35ck410 FIND v(dout1_35) AT=420.05n

.meas tran vdout1_36ck410 FIND v(dout1_36) AT=420.05n

.meas tran vdout1_37ck410 FIND v(dout1_37) AT=420.05n

.meas tran vdout1_38ck410 FIND v(dout1_38) AT=420.05n

.meas tran vdout1_39ck410 FIND v(dout1_39) AT=420.05n

.meas tran vdout1_40ck410 FIND v(dout1_40) AT=420.05n

.meas tran vdout1_41ck410 FIND v(dout1_41) AT=420.05n

.meas tran vdout1_42ck410 FIND v(dout1_42) AT=420.05n

.meas tran vdout1_43ck410 FIND v(dout1_43) AT=420.05n

.meas tran vdout1_44ck410 FIND v(dout1_44) AT=420.05n

.meas tran vdout1_45ck410 FIND v(dout1_45) AT=420.05n

.meas tran vdout1_46ck410 FIND v(dout1_46) AT=420.05n

.meas tran vdout1_47ck410 FIND v(dout1_47) AT=420.05n

.meas tran vdout1_48ck410 FIND v(dout1_48) AT=420.05n

.meas tran vdout1_49ck410 FIND v(dout1_49) AT=420.05n

.meas tran vdout1_50ck410 FIND v(dout1_50) AT=420.05n

.meas tran vdout1_51ck410 FIND v(dout1_51) AT=420.05n

.meas tran vdout1_52ck410 FIND v(dout1_52) AT=420.05n

.meas tran vdout1_53ck410 FIND v(dout1_53) AT=420.05n

.meas tran vdout1_54ck410 FIND v(dout1_54) AT=420.05n

.meas tran vdout1_55ck410 FIND v(dout1_55) AT=420.05n

.meas tran vdout1_56ck410 FIND v(dout1_56) AT=420.05n

.meas tran vdout1_57ck410 FIND v(dout1_57) AT=420.05n

.meas tran vdout1_58ck410 FIND v(dout1_58) AT=420.05n

.meas tran vdout1_59ck410 FIND v(dout1_59) AT=420.05n

.meas tran vdout1_60ck410 FIND v(dout1_60) AT=420.05n

.meas tran vdout1_61ck410 FIND v(dout1_61) AT=420.05n

.meas tran vdout1_62ck410 FIND v(dout1_62) AT=420.05n

.meas tran vdout1_63ck410 FIND v(dout1_63) AT=420.05n

.meas tran vdout1_64ck410 FIND v(dout1_64) AT=420.05n

.meas tran vdout1_65ck410 FIND v(dout1_65) AT=420.05n

.meas tran vdout1_66ck410 FIND v(dout1_66) AT=420.05n

.meas tran vdout1_67ck410 FIND v(dout1_67) AT=420.05n

.meas tran vdout1_68ck410 FIND v(dout1_68) AT=420.05n

.meas tran vdout1_69ck410 FIND v(dout1_69) AT=420.05n

.meas tran vdout1_70ck410 FIND v(dout1_70) AT=420.05n

.meas tran vdout1_71ck410 FIND v(dout1_71) AT=420.05n

.meas tran vdout1_72ck410 FIND v(dout1_72) AT=420.05n

.meas tran vdout1_73ck410 FIND v(dout1_73) AT=420.05n

.meas tran vdout1_74ck410 FIND v(dout1_74) AT=420.05n

.meas tran vdout1_75ck410 FIND v(dout1_75) AT=420.05n

.meas tran vdout1_76ck410 FIND v(dout1_76) AT=420.05n

.meas tran vdout1_77ck410 FIND v(dout1_77) AT=420.05n

.meas tran vdout1_78ck410 FIND v(dout1_78) AT=420.05n

.meas tran vdout1_79ck410 FIND v(dout1_79) AT=420.05n

.meas tran vdout1_80ck410 FIND v(dout1_80) AT=420.05n

.meas tran vdout1_81ck410 FIND v(dout1_81) AT=420.05n

.meas tran vdout1_82ck410 FIND v(dout1_82) AT=420.05n

.meas tran vdout1_83ck410 FIND v(dout1_83) AT=420.05n

.meas tran vdout1_84ck410 FIND v(dout1_84) AT=420.05n

.meas tran vdout1_85ck410 FIND v(dout1_85) AT=420.05n

.meas tran vdout1_86ck410 FIND v(dout1_86) AT=420.05n

.meas tran vdout1_87ck410 FIND v(dout1_87) AT=420.05n

.meas tran vdout1_88ck410 FIND v(dout1_88) AT=420.05n

.meas tran vdout1_89ck410 FIND v(dout1_89) AT=420.05n

.meas tran vdout1_90ck410 FIND v(dout1_90) AT=420.05n

.meas tran vdout1_91ck410 FIND v(dout1_91) AT=420.05n

.meas tran vdout1_92ck410 FIND v(dout1_92) AT=420.05n

.meas tran vdout1_93ck410 FIND v(dout1_93) AT=420.05n

.meas tran vdout1_94ck410 FIND v(dout1_94) AT=420.05n

.meas tran vdout1_95ck410 FIND v(dout1_95) AT=420.05n

.meas tran vdout1_96ck410 FIND v(dout1_96) AT=420.05n

.meas tran vdout1_97ck410 FIND v(dout1_97) AT=420.05n

.meas tran vdout1_98ck410 FIND v(dout1_98) AT=420.05n

.meas tran vdout1_99ck410 FIND v(dout1_99) AT=420.05n

.meas tran vdout1_100ck410 FIND v(dout1_100) AT=420.05n

.meas tran vdout1_101ck410 FIND v(dout1_101) AT=420.05n

.meas tran vdout1_102ck410 FIND v(dout1_102) AT=420.05n

.meas tran vdout1_103ck410 FIND v(dout1_103) AT=420.05n

.meas tran vdout1_104ck410 FIND v(dout1_104) AT=420.05n

.meas tran vdout1_105ck410 FIND v(dout1_105) AT=420.05n

.meas tran vdout1_106ck410 FIND v(dout1_106) AT=420.05n

.meas tran vdout1_107ck410 FIND v(dout1_107) AT=420.05n

.meas tran vdout1_108ck410 FIND v(dout1_108) AT=420.05n

.meas tran vdout1_109ck410 FIND v(dout1_109) AT=420.05n

.meas tran vdout1_110ck410 FIND v(dout1_110) AT=420.05n

.meas tran vdout1_111ck410 FIND v(dout1_111) AT=420.05n

.meas tran vdout1_112ck410 FIND v(dout1_112) AT=420.05n

.meas tran vdout1_113ck410 FIND v(dout1_113) AT=420.05n

.meas tran vdout1_114ck410 FIND v(dout1_114) AT=420.05n

.meas tran vdout1_115ck410 FIND v(dout1_115) AT=420.05n

.meas tran vdout1_116ck410 FIND v(dout1_116) AT=420.05n

.meas tran vdout1_117ck410 FIND v(dout1_117) AT=420.05n

.meas tran vdout1_118ck410 FIND v(dout1_118) AT=420.05n

.meas tran vdout1_119ck410 FIND v(dout1_119) AT=420.05n

.meas tran vdout1_120ck410 FIND v(dout1_120) AT=420.05n

.meas tran vdout1_121ck410 FIND v(dout1_121) AT=420.05n

.meas tran vdout1_122ck410 FIND v(dout1_122) AT=420.05n

.meas tran vdout1_123ck410 FIND v(dout1_123) AT=420.05n

.meas tran vdout1_124ck410 FIND v(dout1_124) AT=420.05n

.meas tran vdout1_125ck410 FIND v(dout1_125) AT=420.05n

.meas tran vdout1_126ck410 FIND v(dout1_126) AT=420.05n

.meas tran vdout1_127ck410 FIND v(dout1_127) AT=420.05n

.meas tran vdout1_128ck410 FIND v(dout1_128) AT=420.05n

.meas tran vdout1_129ck410 FIND v(dout1_129) AT=420.05n

.meas tran vdout1_130ck410 FIND v(dout1_130) AT=420.05n

.meas tran vdout1_131ck410 FIND v(dout1_131) AT=420.05n

.meas tran vdout1_132ck410 FIND v(dout1_132) AT=420.05n

.meas tran vdout1_133ck410 FIND v(dout1_133) AT=420.05n

.meas tran vdout1_134ck410 FIND v(dout1_134) AT=420.05n

.meas tran vdout1_135ck410 FIND v(dout1_135) AT=420.05n

.meas tran vdout1_136ck410 FIND v(dout1_136) AT=420.05n

.meas tran vdout1_137ck410 FIND v(dout1_137) AT=420.05n

.meas tran vdout1_138ck410 FIND v(dout1_138) AT=420.05n

.meas tran vdout1_139ck410 FIND v(dout1_139) AT=420.05n

.meas tran vdout1_140ck410 FIND v(dout1_140) AT=420.05n

.meas tran vdout1_141ck410 FIND v(dout1_141) AT=420.05n

.meas tran vdout1_142ck410 FIND v(dout1_142) AT=420.05n

.meas tran vdout1_143ck410 FIND v(dout1_143) AT=420.05n

.meas tran vdout1_144ck410 FIND v(dout1_144) AT=420.05n

.meas tran vdout1_145ck410 FIND v(dout1_145) AT=420.05n

.meas tran vdout1_146ck410 FIND v(dout1_146) AT=420.05n

.meas tran vdout1_147ck410 FIND v(dout1_147) AT=420.05n

.meas tran vdout1_148ck410 FIND v(dout1_148) AT=420.05n

.meas tran vdout1_149ck410 FIND v(dout1_149) AT=420.05n

.meas tran vdout1_150ck410 FIND v(dout1_150) AT=420.05n

.meas tran vdout1_151ck410 FIND v(dout1_151) AT=420.05n

.meas tran vdout1_152ck410 FIND v(dout1_152) AT=420.05n

.meas tran vdout1_153ck410 FIND v(dout1_153) AT=420.05n

.meas tran vdout1_154ck410 FIND v(dout1_154) AT=420.05n

.meas tran vdout1_155ck410 FIND v(dout1_155) AT=420.05n

.meas tran vdout1_156ck410 FIND v(dout1_156) AT=420.05n

.meas tran vdout1_157ck410 FIND v(dout1_157) AT=420.05n

.meas tran vdout1_158ck410 FIND v(dout1_158) AT=420.05n

.meas tran vdout1_159ck410 FIND v(dout1_159) AT=420.05n

.meas tran vdout1_160ck410 FIND v(dout1_160) AT=420.05n

.meas tran vdout1_161ck410 FIND v(dout1_161) AT=420.05n

.meas tran vdout1_162ck410 FIND v(dout1_162) AT=420.05n

.meas tran vdout1_163ck410 FIND v(dout1_163) AT=420.05n

.meas tran vdout1_164ck410 FIND v(dout1_164) AT=420.05n

.meas tran vdout1_165ck410 FIND v(dout1_165) AT=420.05n

.meas tran vdout1_166ck410 FIND v(dout1_166) AT=420.05n

.meas tran vdout1_167ck410 FIND v(dout1_167) AT=420.05n

.meas tran vdout1_168ck410 FIND v(dout1_168) AT=420.05n

.meas tran vdout1_169ck410 FIND v(dout1_169) AT=420.05n

.meas tran vdout1_170ck410 FIND v(dout1_170) AT=420.05n

.meas tran vdout1_171ck410 FIND v(dout1_171) AT=420.05n

.meas tran vdout1_172ck410 FIND v(dout1_172) AT=420.05n

.meas tran vdout1_173ck410 FIND v(dout1_173) AT=420.05n

.meas tran vdout1_174ck410 FIND v(dout1_174) AT=420.05n

.meas tran vdout1_175ck410 FIND v(dout1_175) AT=420.05n

.meas tran vdout1_176ck410 FIND v(dout1_176) AT=420.05n

.meas tran vdout1_177ck410 FIND v(dout1_177) AT=420.05n

.meas tran vdout1_178ck410 FIND v(dout1_178) AT=420.05n

.meas tran vdout1_179ck410 FIND v(dout1_179) AT=420.05n

.meas tran vdout1_180ck410 FIND v(dout1_180) AT=420.05n

.meas tran vdout1_181ck410 FIND v(dout1_181) AT=420.05n

.meas tran vdout1_182ck410 FIND v(dout1_182) AT=420.05n

.meas tran vdout1_183ck410 FIND v(dout1_183) AT=420.05n

.meas tran vdout1_184ck410 FIND v(dout1_184) AT=420.05n

.meas tran vdout1_185ck410 FIND v(dout1_185) AT=420.05n

.meas tran vdout1_186ck410 FIND v(dout1_186) AT=420.05n

.meas tran vdout1_187ck410 FIND v(dout1_187) AT=420.05n

.meas tran vdout1_188ck410 FIND v(dout1_188) AT=420.05n

.meas tran vdout1_189ck410 FIND v(dout1_189) AT=420.05n

.meas tran vdout1_190ck410 FIND v(dout1_190) AT=420.05n

.meas tran vdout1_191ck410 FIND v(dout1_191) AT=420.05n

.meas tran vdout1_192ck410 FIND v(dout1_192) AT=420.05n

.meas tran vdout1_193ck410 FIND v(dout1_193) AT=420.05n

.meas tran vdout1_194ck410 FIND v(dout1_194) AT=420.05n

.meas tran vdout1_195ck410 FIND v(dout1_195) AT=420.05n

.meas tran vdout1_196ck410 FIND v(dout1_196) AT=420.05n

.meas tran vdout1_197ck410 FIND v(dout1_197) AT=420.05n

.meas tran vdout1_198ck410 FIND v(dout1_198) AT=420.05n

.meas tran vdout1_199ck410 FIND v(dout1_199) AT=420.05n

.meas tran vdout1_200ck410 FIND v(dout1_200) AT=420.05n

.meas tran vdout1_201ck410 FIND v(dout1_201) AT=420.05n

.meas tran vdout1_202ck410 FIND v(dout1_202) AT=420.05n

.meas tran vdout1_203ck410 FIND v(dout1_203) AT=420.05n

.meas tran vdout1_204ck410 FIND v(dout1_204) AT=420.05n

.meas tran vdout1_205ck410 FIND v(dout1_205) AT=420.05n

.meas tran vdout1_206ck410 FIND v(dout1_206) AT=420.05n

.meas tran vdout1_207ck410 FIND v(dout1_207) AT=420.05n

.meas tran vdout1_208ck410 FIND v(dout1_208) AT=420.05n

.meas tran vdout1_209ck410 FIND v(dout1_209) AT=420.05n

.meas tran vdout1_210ck410 FIND v(dout1_210) AT=420.05n

.meas tran vdout1_211ck410 FIND v(dout1_211) AT=420.05n

.meas tran vdout1_212ck410 FIND v(dout1_212) AT=420.05n

.meas tran vdout1_213ck410 FIND v(dout1_213) AT=420.05n

.meas tran vdout1_214ck410 FIND v(dout1_214) AT=420.05n

.meas tran vdout1_215ck410 FIND v(dout1_215) AT=420.05n

.meas tran vdout1_216ck410 FIND v(dout1_216) AT=420.05n

.meas tran vdout1_217ck410 FIND v(dout1_217) AT=420.05n

.meas tran vdout1_218ck410 FIND v(dout1_218) AT=420.05n

.meas tran vdout1_219ck410 FIND v(dout1_219) AT=420.05n

.meas tran vdout1_220ck410 FIND v(dout1_220) AT=420.05n

.meas tran vdout1_221ck410 FIND v(dout1_221) AT=420.05n

.meas tran vdout1_222ck410 FIND v(dout1_222) AT=420.05n

.meas tran vdout1_223ck410 FIND v(dout1_223) AT=420.05n

.meas tran vdout1_224ck410 FIND v(dout1_224) AT=420.05n

.meas tran vdout1_225ck410 FIND v(dout1_225) AT=420.05n

.meas tran vdout1_226ck410 FIND v(dout1_226) AT=420.05n

.meas tran vdout1_227ck410 FIND v(dout1_227) AT=420.05n

.meas tran vdout1_228ck410 FIND v(dout1_228) AT=420.05n

.meas tran vdout1_229ck410 FIND v(dout1_229) AT=420.05n

.meas tran vdout1_230ck410 FIND v(dout1_230) AT=420.05n

.meas tran vdout1_231ck410 FIND v(dout1_231) AT=420.05n

.meas tran vdout1_232ck410 FIND v(dout1_232) AT=420.05n

.meas tran vdout1_233ck410 FIND v(dout1_233) AT=420.05n

.meas tran vdout1_234ck410 FIND v(dout1_234) AT=420.05n

.meas tran vdout1_235ck410 FIND v(dout1_235) AT=420.05n

.meas tran vdout1_236ck410 FIND v(dout1_236) AT=420.05n

.meas tran vdout1_237ck410 FIND v(dout1_237) AT=420.05n

.meas tran vdout1_238ck410 FIND v(dout1_238) AT=420.05n

.meas tran vdout1_239ck410 FIND v(dout1_239) AT=420.05n

.meas tran vdout1_240ck410 FIND v(dout1_240) AT=420.05n

.meas tran vdout1_241ck410 FIND v(dout1_241) AT=420.05n

.meas tran vdout1_242ck410 FIND v(dout1_242) AT=420.05n

.meas tran vdout1_243ck410 FIND v(dout1_243) AT=420.05n

.meas tran vdout1_244ck410 FIND v(dout1_244) AT=420.05n

.meas tran vdout1_245ck410 FIND v(dout1_245) AT=420.05n

.meas tran vdout1_246ck410 FIND v(dout1_246) AT=420.05n

.meas tran vdout1_247ck410 FIND v(dout1_247) AT=420.05n

.meas tran vdout1_248ck410 FIND v(dout1_248) AT=420.05n

.meas tran vdout1_249ck410 FIND v(dout1_249) AT=420.05n

.meas tran vdout1_250ck410 FIND v(dout1_250) AT=420.05n

.meas tran vdout1_251ck410 FIND v(dout1_251) AT=420.05n

.meas tran vdout1_252ck410 FIND v(dout1_252) AT=420.05n

.meas tran vdout1_253ck410 FIND v(dout1_253) AT=420.05n

.meas tran vdout1_254ck410 FIND v(dout1_254) AT=420.05n

.meas tran vdout1_255ck410 FIND v(dout1_255) AT=420.05n

.meas tran vdout1_256ck410 FIND v(dout1_256) AT=420.05n

.meas tran vdout1_0ck430 FIND v(dout1_0) AT=440.05n

.meas tran vdout1_1ck430 FIND v(dout1_1) AT=440.05n

.meas tran vdout1_2ck430 FIND v(dout1_2) AT=440.05n

.meas tran vdout1_3ck430 FIND v(dout1_3) AT=440.05n

.meas tran vdout1_4ck430 FIND v(dout1_4) AT=440.05n

.meas tran vdout1_5ck430 FIND v(dout1_5) AT=440.05n

.meas tran vdout1_6ck430 FIND v(dout1_6) AT=440.05n

.meas tran vdout1_7ck430 FIND v(dout1_7) AT=440.05n

.meas tran vdout1_8ck430 FIND v(dout1_8) AT=440.05n

.meas tran vdout1_9ck430 FIND v(dout1_9) AT=440.05n

.meas tran vdout1_10ck430 FIND v(dout1_10) AT=440.05n

.meas tran vdout1_11ck430 FIND v(dout1_11) AT=440.05n

.meas tran vdout1_12ck430 FIND v(dout1_12) AT=440.05n

.meas tran vdout1_13ck430 FIND v(dout1_13) AT=440.05n

.meas tran vdout1_14ck430 FIND v(dout1_14) AT=440.05n

.meas tran vdout1_15ck430 FIND v(dout1_15) AT=440.05n

.meas tran vdout1_16ck430 FIND v(dout1_16) AT=440.05n

.meas tran vdout1_17ck430 FIND v(dout1_17) AT=440.05n

.meas tran vdout1_18ck430 FIND v(dout1_18) AT=440.05n

.meas tran vdout1_19ck430 FIND v(dout1_19) AT=440.05n

.meas tran vdout1_20ck430 FIND v(dout1_20) AT=440.05n

.meas tran vdout1_21ck430 FIND v(dout1_21) AT=440.05n

.meas tran vdout1_22ck430 FIND v(dout1_22) AT=440.05n

.meas tran vdout1_23ck430 FIND v(dout1_23) AT=440.05n

.meas tran vdout1_24ck430 FIND v(dout1_24) AT=440.05n

.meas tran vdout1_25ck430 FIND v(dout1_25) AT=440.05n

.meas tran vdout1_26ck430 FIND v(dout1_26) AT=440.05n

.meas tran vdout1_27ck430 FIND v(dout1_27) AT=440.05n

.meas tran vdout1_28ck430 FIND v(dout1_28) AT=440.05n

.meas tran vdout1_29ck430 FIND v(dout1_29) AT=440.05n

.meas tran vdout1_30ck430 FIND v(dout1_30) AT=440.05n

.meas tran vdout1_31ck430 FIND v(dout1_31) AT=440.05n

.meas tran vdout1_32ck430 FIND v(dout1_32) AT=440.05n

.meas tran vdout1_33ck430 FIND v(dout1_33) AT=440.05n

.meas tran vdout1_34ck430 FIND v(dout1_34) AT=440.05n

.meas tran vdout1_35ck430 FIND v(dout1_35) AT=440.05n

.meas tran vdout1_36ck430 FIND v(dout1_36) AT=440.05n

.meas tran vdout1_37ck430 FIND v(dout1_37) AT=440.05n

.meas tran vdout1_38ck430 FIND v(dout1_38) AT=440.05n

.meas tran vdout1_39ck430 FIND v(dout1_39) AT=440.05n

.meas tran vdout1_40ck430 FIND v(dout1_40) AT=440.05n

.meas tran vdout1_41ck430 FIND v(dout1_41) AT=440.05n

.meas tran vdout1_42ck430 FIND v(dout1_42) AT=440.05n

.meas tran vdout1_43ck430 FIND v(dout1_43) AT=440.05n

.meas tran vdout1_44ck430 FIND v(dout1_44) AT=440.05n

.meas tran vdout1_45ck430 FIND v(dout1_45) AT=440.05n

.meas tran vdout1_46ck430 FIND v(dout1_46) AT=440.05n

.meas tran vdout1_47ck430 FIND v(dout1_47) AT=440.05n

.meas tran vdout1_48ck430 FIND v(dout1_48) AT=440.05n

.meas tran vdout1_49ck430 FIND v(dout1_49) AT=440.05n

.meas tran vdout1_50ck430 FIND v(dout1_50) AT=440.05n

.meas tran vdout1_51ck430 FIND v(dout1_51) AT=440.05n

.meas tran vdout1_52ck430 FIND v(dout1_52) AT=440.05n

.meas tran vdout1_53ck430 FIND v(dout1_53) AT=440.05n

.meas tran vdout1_54ck430 FIND v(dout1_54) AT=440.05n

.meas tran vdout1_55ck430 FIND v(dout1_55) AT=440.05n

.meas tran vdout1_56ck430 FIND v(dout1_56) AT=440.05n

.meas tran vdout1_57ck430 FIND v(dout1_57) AT=440.05n

.meas tran vdout1_58ck430 FIND v(dout1_58) AT=440.05n

.meas tran vdout1_59ck430 FIND v(dout1_59) AT=440.05n

.meas tran vdout1_60ck430 FIND v(dout1_60) AT=440.05n

.meas tran vdout1_61ck430 FIND v(dout1_61) AT=440.05n

.meas tran vdout1_62ck430 FIND v(dout1_62) AT=440.05n

.meas tran vdout1_63ck430 FIND v(dout1_63) AT=440.05n

.meas tran vdout1_64ck430 FIND v(dout1_64) AT=440.05n

.meas tran vdout1_65ck430 FIND v(dout1_65) AT=440.05n

.meas tran vdout1_66ck430 FIND v(dout1_66) AT=440.05n

.meas tran vdout1_67ck430 FIND v(dout1_67) AT=440.05n

.meas tran vdout1_68ck430 FIND v(dout1_68) AT=440.05n

.meas tran vdout1_69ck430 FIND v(dout1_69) AT=440.05n

.meas tran vdout1_70ck430 FIND v(dout1_70) AT=440.05n

.meas tran vdout1_71ck430 FIND v(dout1_71) AT=440.05n

.meas tran vdout1_72ck430 FIND v(dout1_72) AT=440.05n

.meas tran vdout1_73ck430 FIND v(dout1_73) AT=440.05n

.meas tran vdout1_74ck430 FIND v(dout1_74) AT=440.05n

.meas tran vdout1_75ck430 FIND v(dout1_75) AT=440.05n

.meas tran vdout1_76ck430 FIND v(dout1_76) AT=440.05n

.meas tran vdout1_77ck430 FIND v(dout1_77) AT=440.05n

.meas tran vdout1_78ck430 FIND v(dout1_78) AT=440.05n

.meas tran vdout1_79ck430 FIND v(dout1_79) AT=440.05n

.meas tran vdout1_80ck430 FIND v(dout1_80) AT=440.05n

.meas tran vdout1_81ck430 FIND v(dout1_81) AT=440.05n

.meas tran vdout1_82ck430 FIND v(dout1_82) AT=440.05n

.meas tran vdout1_83ck430 FIND v(dout1_83) AT=440.05n

.meas tran vdout1_84ck430 FIND v(dout1_84) AT=440.05n

.meas tran vdout1_85ck430 FIND v(dout1_85) AT=440.05n

.meas tran vdout1_86ck430 FIND v(dout1_86) AT=440.05n

.meas tran vdout1_87ck430 FIND v(dout1_87) AT=440.05n

.meas tran vdout1_88ck430 FIND v(dout1_88) AT=440.05n

.meas tran vdout1_89ck430 FIND v(dout1_89) AT=440.05n

.meas tran vdout1_90ck430 FIND v(dout1_90) AT=440.05n

.meas tran vdout1_91ck430 FIND v(dout1_91) AT=440.05n

.meas tran vdout1_92ck430 FIND v(dout1_92) AT=440.05n

.meas tran vdout1_93ck430 FIND v(dout1_93) AT=440.05n

.meas tran vdout1_94ck430 FIND v(dout1_94) AT=440.05n

.meas tran vdout1_95ck430 FIND v(dout1_95) AT=440.05n

.meas tran vdout1_96ck430 FIND v(dout1_96) AT=440.05n

.meas tran vdout1_97ck430 FIND v(dout1_97) AT=440.05n

.meas tran vdout1_98ck430 FIND v(dout1_98) AT=440.05n

.meas tran vdout1_99ck430 FIND v(dout1_99) AT=440.05n

.meas tran vdout1_100ck430 FIND v(dout1_100) AT=440.05n

.meas tran vdout1_101ck430 FIND v(dout1_101) AT=440.05n

.meas tran vdout1_102ck430 FIND v(dout1_102) AT=440.05n

.meas tran vdout1_103ck430 FIND v(dout1_103) AT=440.05n

.meas tran vdout1_104ck430 FIND v(dout1_104) AT=440.05n

.meas tran vdout1_105ck430 FIND v(dout1_105) AT=440.05n

.meas tran vdout1_106ck430 FIND v(dout1_106) AT=440.05n

.meas tran vdout1_107ck430 FIND v(dout1_107) AT=440.05n

.meas tran vdout1_108ck430 FIND v(dout1_108) AT=440.05n

.meas tran vdout1_109ck430 FIND v(dout1_109) AT=440.05n

.meas tran vdout1_110ck430 FIND v(dout1_110) AT=440.05n

.meas tran vdout1_111ck430 FIND v(dout1_111) AT=440.05n

.meas tran vdout1_112ck430 FIND v(dout1_112) AT=440.05n

.meas tran vdout1_113ck430 FIND v(dout1_113) AT=440.05n

.meas tran vdout1_114ck430 FIND v(dout1_114) AT=440.05n

.meas tran vdout1_115ck430 FIND v(dout1_115) AT=440.05n

.meas tran vdout1_116ck430 FIND v(dout1_116) AT=440.05n

.meas tran vdout1_117ck430 FIND v(dout1_117) AT=440.05n

.meas tran vdout1_118ck430 FIND v(dout1_118) AT=440.05n

.meas tran vdout1_119ck430 FIND v(dout1_119) AT=440.05n

.meas tran vdout1_120ck430 FIND v(dout1_120) AT=440.05n

.meas tran vdout1_121ck430 FIND v(dout1_121) AT=440.05n

.meas tran vdout1_122ck430 FIND v(dout1_122) AT=440.05n

.meas tran vdout1_123ck430 FIND v(dout1_123) AT=440.05n

.meas tran vdout1_124ck430 FIND v(dout1_124) AT=440.05n

.meas tran vdout1_125ck430 FIND v(dout1_125) AT=440.05n

.meas tran vdout1_126ck430 FIND v(dout1_126) AT=440.05n

.meas tran vdout1_127ck430 FIND v(dout1_127) AT=440.05n

.meas tran vdout1_128ck430 FIND v(dout1_128) AT=440.05n

.meas tran vdout1_129ck430 FIND v(dout1_129) AT=440.05n

.meas tran vdout1_130ck430 FIND v(dout1_130) AT=440.05n

.meas tran vdout1_131ck430 FIND v(dout1_131) AT=440.05n

.meas tran vdout1_132ck430 FIND v(dout1_132) AT=440.05n

.meas tran vdout1_133ck430 FIND v(dout1_133) AT=440.05n

.meas tran vdout1_134ck430 FIND v(dout1_134) AT=440.05n

.meas tran vdout1_135ck430 FIND v(dout1_135) AT=440.05n

.meas tran vdout1_136ck430 FIND v(dout1_136) AT=440.05n

.meas tran vdout1_137ck430 FIND v(dout1_137) AT=440.05n

.meas tran vdout1_138ck430 FIND v(dout1_138) AT=440.05n

.meas tran vdout1_139ck430 FIND v(dout1_139) AT=440.05n

.meas tran vdout1_140ck430 FIND v(dout1_140) AT=440.05n

.meas tran vdout1_141ck430 FIND v(dout1_141) AT=440.05n

.meas tran vdout1_142ck430 FIND v(dout1_142) AT=440.05n

.meas tran vdout1_143ck430 FIND v(dout1_143) AT=440.05n

.meas tran vdout1_144ck430 FIND v(dout1_144) AT=440.05n

.meas tran vdout1_145ck430 FIND v(dout1_145) AT=440.05n

.meas tran vdout1_146ck430 FIND v(dout1_146) AT=440.05n

.meas tran vdout1_147ck430 FIND v(dout1_147) AT=440.05n

.meas tran vdout1_148ck430 FIND v(dout1_148) AT=440.05n

.meas tran vdout1_149ck430 FIND v(dout1_149) AT=440.05n

.meas tran vdout1_150ck430 FIND v(dout1_150) AT=440.05n

.meas tran vdout1_151ck430 FIND v(dout1_151) AT=440.05n

.meas tran vdout1_152ck430 FIND v(dout1_152) AT=440.05n

.meas tran vdout1_153ck430 FIND v(dout1_153) AT=440.05n

.meas tran vdout1_154ck430 FIND v(dout1_154) AT=440.05n

.meas tran vdout1_155ck430 FIND v(dout1_155) AT=440.05n

.meas tran vdout1_156ck430 FIND v(dout1_156) AT=440.05n

.meas tran vdout1_157ck430 FIND v(dout1_157) AT=440.05n

.meas tran vdout1_158ck430 FIND v(dout1_158) AT=440.05n

.meas tran vdout1_159ck430 FIND v(dout1_159) AT=440.05n

.meas tran vdout1_160ck430 FIND v(dout1_160) AT=440.05n

.meas tran vdout1_161ck430 FIND v(dout1_161) AT=440.05n

.meas tran vdout1_162ck430 FIND v(dout1_162) AT=440.05n

.meas tran vdout1_163ck430 FIND v(dout1_163) AT=440.05n

.meas tran vdout1_164ck430 FIND v(dout1_164) AT=440.05n

.meas tran vdout1_165ck430 FIND v(dout1_165) AT=440.05n

.meas tran vdout1_166ck430 FIND v(dout1_166) AT=440.05n

.meas tran vdout1_167ck430 FIND v(dout1_167) AT=440.05n

.meas tran vdout1_168ck430 FIND v(dout1_168) AT=440.05n

.meas tran vdout1_169ck430 FIND v(dout1_169) AT=440.05n

.meas tran vdout1_170ck430 FIND v(dout1_170) AT=440.05n

.meas tran vdout1_171ck430 FIND v(dout1_171) AT=440.05n

.meas tran vdout1_172ck430 FIND v(dout1_172) AT=440.05n

.meas tran vdout1_173ck430 FIND v(dout1_173) AT=440.05n

.meas tran vdout1_174ck430 FIND v(dout1_174) AT=440.05n

.meas tran vdout1_175ck430 FIND v(dout1_175) AT=440.05n

.meas tran vdout1_176ck430 FIND v(dout1_176) AT=440.05n

.meas tran vdout1_177ck430 FIND v(dout1_177) AT=440.05n

.meas tran vdout1_178ck430 FIND v(dout1_178) AT=440.05n

.meas tran vdout1_179ck430 FIND v(dout1_179) AT=440.05n

.meas tran vdout1_180ck430 FIND v(dout1_180) AT=440.05n

.meas tran vdout1_181ck430 FIND v(dout1_181) AT=440.05n

.meas tran vdout1_182ck430 FIND v(dout1_182) AT=440.05n

.meas tran vdout1_183ck430 FIND v(dout1_183) AT=440.05n

.meas tran vdout1_184ck430 FIND v(dout1_184) AT=440.05n

.meas tran vdout1_185ck430 FIND v(dout1_185) AT=440.05n

.meas tran vdout1_186ck430 FIND v(dout1_186) AT=440.05n

.meas tran vdout1_187ck430 FIND v(dout1_187) AT=440.05n

.meas tran vdout1_188ck430 FIND v(dout1_188) AT=440.05n

.meas tran vdout1_189ck430 FIND v(dout1_189) AT=440.05n

.meas tran vdout1_190ck430 FIND v(dout1_190) AT=440.05n

.meas tran vdout1_191ck430 FIND v(dout1_191) AT=440.05n

.meas tran vdout1_192ck430 FIND v(dout1_192) AT=440.05n

.meas tran vdout1_193ck430 FIND v(dout1_193) AT=440.05n

.meas tran vdout1_194ck430 FIND v(dout1_194) AT=440.05n

.meas tran vdout1_195ck430 FIND v(dout1_195) AT=440.05n

.meas tran vdout1_196ck430 FIND v(dout1_196) AT=440.05n

.meas tran vdout1_197ck430 FIND v(dout1_197) AT=440.05n

.meas tran vdout1_198ck430 FIND v(dout1_198) AT=440.05n

.meas tran vdout1_199ck430 FIND v(dout1_199) AT=440.05n

.meas tran vdout1_200ck430 FIND v(dout1_200) AT=440.05n

.meas tran vdout1_201ck430 FIND v(dout1_201) AT=440.05n

.meas tran vdout1_202ck430 FIND v(dout1_202) AT=440.05n

.meas tran vdout1_203ck430 FIND v(dout1_203) AT=440.05n

.meas tran vdout1_204ck430 FIND v(dout1_204) AT=440.05n

.meas tran vdout1_205ck430 FIND v(dout1_205) AT=440.05n

.meas tran vdout1_206ck430 FIND v(dout1_206) AT=440.05n

.meas tran vdout1_207ck430 FIND v(dout1_207) AT=440.05n

.meas tran vdout1_208ck430 FIND v(dout1_208) AT=440.05n

.meas tran vdout1_209ck430 FIND v(dout1_209) AT=440.05n

.meas tran vdout1_210ck430 FIND v(dout1_210) AT=440.05n

.meas tran vdout1_211ck430 FIND v(dout1_211) AT=440.05n

.meas tran vdout1_212ck430 FIND v(dout1_212) AT=440.05n

.meas tran vdout1_213ck430 FIND v(dout1_213) AT=440.05n

.meas tran vdout1_214ck430 FIND v(dout1_214) AT=440.05n

.meas tran vdout1_215ck430 FIND v(dout1_215) AT=440.05n

.meas tran vdout1_216ck430 FIND v(dout1_216) AT=440.05n

.meas tran vdout1_217ck430 FIND v(dout1_217) AT=440.05n

.meas tran vdout1_218ck430 FIND v(dout1_218) AT=440.05n

.meas tran vdout1_219ck430 FIND v(dout1_219) AT=440.05n

.meas tran vdout1_220ck430 FIND v(dout1_220) AT=440.05n

.meas tran vdout1_221ck430 FIND v(dout1_221) AT=440.05n

.meas tran vdout1_222ck430 FIND v(dout1_222) AT=440.05n

.meas tran vdout1_223ck430 FIND v(dout1_223) AT=440.05n

.meas tran vdout1_224ck430 FIND v(dout1_224) AT=440.05n

.meas tran vdout1_225ck430 FIND v(dout1_225) AT=440.05n

.meas tran vdout1_226ck430 FIND v(dout1_226) AT=440.05n

.meas tran vdout1_227ck430 FIND v(dout1_227) AT=440.05n

.meas tran vdout1_228ck430 FIND v(dout1_228) AT=440.05n

.meas tran vdout1_229ck430 FIND v(dout1_229) AT=440.05n

.meas tran vdout1_230ck430 FIND v(dout1_230) AT=440.05n

.meas tran vdout1_231ck430 FIND v(dout1_231) AT=440.05n

.meas tran vdout1_232ck430 FIND v(dout1_232) AT=440.05n

.meas tran vdout1_233ck430 FIND v(dout1_233) AT=440.05n

.meas tran vdout1_234ck430 FIND v(dout1_234) AT=440.05n

.meas tran vdout1_235ck430 FIND v(dout1_235) AT=440.05n

.meas tran vdout1_236ck430 FIND v(dout1_236) AT=440.05n

.meas tran vdout1_237ck430 FIND v(dout1_237) AT=440.05n

.meas tran vdout1_238ck430 FIND v(dout1_238) AT=440.05n

.meas tran vdout1_239ck430 FIND v(dout1_239) AT=440.05n

.meas tran vdout1_240ck430 FIND v(dout1_240) AT=440.05n

.meas tran vdout1_241ck430 FIND v(dout1_241) AT=440.05n

.meas tran vdout1_242ck430 FIND v(dout1_242) AT=440.05n

.meas tran vdout1_243ck430 FIND v(dout1_243) AT=440.05n

.meas tran vdout1_244ck430 FIND v(dout1_244) AT=440.05n

.meas tran vdout1_245ck430 FIND v(dout1_245) AT=440.05n

.meas tran vdout1_246ck430 FIND v(dout1_246) AT=440.05n

.meas tran vdout1_247ck430 FIND v(dout1_247) AT=440.05n

.meas tran vdout1_248ck430 FIND v(dout1_248) AT=440.05n

.meas tran vdout1_249ck430 FIND v(dout1_249) AT=440.05n

.meas tran vdout1_250ck430 FIND v(dout1_250) AT=440.05n

.meas tran vdout1_251ck430 FIND v(dout1_251) AT=440.05n

.meas tran vdout1_252ck430 FIND v(dout1_252) AT=440.05n

.meas tran vdout1_253ck430 FIND v(dout1_253) AT=440.05n

.meas tran vdout1_254ck430 FIND v(dout1_254) AT=440.05n

.meas tran vdout1_255ck430 FIND v(dout1_255) AT=440.05n

.meas tran vdout1_256ck430 FIND v(dout1_256) AT=440.05n

.meas tran vdout1_0ck450 FIND v(dout1_0) AT=460.05n

.meas tran vdout1_1ck450 FIND v(dout1_1) AT=460.05n

.meas tran vdout1_2ck450 FIND v(dout1_2) AT=460.05n

.meas tran vdout1_3ck450 FIND v(dout1_3) AT=460.05n

.meas tran vdout1_4ck450 FIND v(dout1_4) AT=460.05n

.meas tran vdout1_5ck450 FIND v(dout1_5) AT=460.05n

.meas tran vdout1_6ck450 FIND v(dout1_6) AT=460.05n

.meas tran vdout1_7ck450 FIND v(dout1_7) AT=460.05n

.meas tran vdout1_8ck450 FIND v(dout1_8) AT=460.05n

.meas tran vdout1_9ck450 FIND v(dout1_9) AT=460.05n

.meas tran vdout1_10ck450 FIND v(dout1_10) AT=460.05n

.meas tran vdout1_11ck450 FIND v(dout1_11) AT=460.05n

.meas tran vdout1_12ck450 FIND v(dout1_12) AT=460.05n

.meas tran vdout1_13ck450 FIND v(dout1_13) AT=460.05n

.meas tran vdout1_14ck450 FIND v(dout1_14) AT=460.05n

.meas tran vdout1_15ck450 FIND v(dout1_15) AT=460.05n

.meas tran vdout1_16ck450 FIND v(dout1_16) AT=460.05n

.meas tran vdout1_17ck450 FIND v(dout1_17) AT=460.05n

.meas tran vdout1_18ck450 FIND v(dout1_18) AT=460.05n

.meas tran vdout1_19ck450 FIND v(dout1_19) AT=460.05n

.meas tran vdout1_20ck450 FIND v(dout1_20) AT=460.05n

.meas tran vdout1_21ck450 FIND v(dout1_21) AT=460.05n

.meas tran vdout1_22ck450 FIND v(dout1_22) AT=460.05n

.meas tran vdout1_23ck450 FIND v(dout1_23) AT=460.05n

.meas tran vdout1_24ck450 FIND v(dout1_24) AT=460.05n

.meas tran vdout1_25ck450 FIND v(dout1_25) AT=460.05n

.meas tran vdout1_26ck450 FIND v(dout1_26) AT=460.05n

.meas tran vdout1_27ck450 FIND v(dout1_27) AT=460.05n

.meas tran vdout1_28ck450 FIND v(dout1_28) AT=460.05n

.meas tran vdout1_29ck450 FIND v(dout1_29) AT=460.05n

.meas tran vdout1_30ck450 FIND v(dout1_30) AT=460.05n

.meas tran vdout1_31ck450 FIND v(dout1_31) AT=460.05n

.meas tran vdout1_32ck450 FIND v(dout1_32) AT=460.05n

.meas tran vdout1_33ck450 FIND v(dout1_33) AT=460.05n

.meas tran vdout1_34ck450 FIND v(dout1_34) AT=460.05n

.meas tran vdout1_35ck450 FIND v(dout1_35) AT=460.05n

.meas tran vdout1_36ck450 FIND v(dout1_36) AT=460.05n

.meas tran vdout1_37ck450 FIND v(dout1_37) AT=460.05n

.meas tran vdout1_38ck450 FIND v(dout1_38) AT=460.05n

.meas tran vdout1_39ck450 FIND v(dout1_39) AT=460.05n

.meas tran vdout1_40ck450 FIND v(dout1_40) AT=460.05n

.meas tran vdout1_41ck450 FIND v(dout1_41) AT=460.05n

.meas tran vdout1_42ck450 FIND v(dout1_42) AT=460.05n

.meas tran vdout1_43ck450 FIND v(dout1_43) AT=460.05n

.meas tran vdout1_44ck450 FIND v(dout1_44) AT=460.05n

.meas tran vdout1_45ck450 FIND v(dout1_45) AT=460.05n

.meas tran vdout1_46ck450 FIND v(dout1_46) AT=460.05n

.meas tran vdout1_47ck450 FIND v(dout1_47) AT=460.05n

.meas tran vdout1_48ck450 FIND v(dout1_48) AT=460.05n

.meas tran vdout1_49ck450 FIND v(dout1_49) AT=460.05n

.meas tran vdout1_50ck450 FIND v(dout1_50) AT=460.05n

.meas tran vdout1_51ck450 FIND v(dout1_51) AT=460.05n

.meas tran vdout1_52ck450 FIND v(dout1_52) AT=460.05n

.meas tran vdout1_53ck450 FIND v(dout1_53) AT=460.05n

.meas tran vdout1_54ck450 FIND v(dout1_54) AT=460.05n

.meas tran vdout1_55ck450 FIND v(dout1_55) AT=460.05n

.meas tran vdout1_56ck450 FIND v(dout1_56) AT=460.05n

.meas tran vdout1_57ck450 FIND v(dout1_57) AT=460.05n

.meas tran vdout1_58ck450 FIND v(dout1_58) AT=460.05n

.meas tran vdout1_59ck450 FIND v(dout1_59) AT=460.05n

.meas tran vdout1_60ck450 FIND v(dout1_60) AT=460.05n

.meas tran vdout1_61ck450 FIND v(dout1_61) AT=460.05n

.meas tran vdout1_62ck450 FIND v(dout1_62) AT=460.05n

.meas tran vdout1_63ck450 FIND v(dout1_63) AT=460.05n

.meas tran vdout1_64ck450 FIND v(dout1_64) AT=460.05n

.meas tran vdout1_65ck450 FIND v(dout1_65) AT=460.05n

.meas tran vdout1_66ck450 FIND v(dout1_66) AT=460.05n

.meas tran vdout1_67ck450 FIND v(dout1_67) AT=460.05n

.meas tran vdout1_68ck450 FIND v(dout1_68) AT=460.05n

.meas tran vdout1_69ck450 FIND v(dout1_69) AT=460.05n

.meas tran vdout1_70ck450 FIND v(dout1_70) AT=460.05n

.meas tran vdout1_71ck450 FIND v(dout1_71) AT=460.05n

.meas tran vdout1_72ck450 FIND v(dout1_72) AT=460.05n

.meas tran vdout1_73ck450 FIND v(dout1_73) AT=460.05n

.meas tran vdout1_74ck450 FIND v(dout1_74) AT=460.05n

.meas tran vdout1_75ck450 FIND v(dout1_75) AT=460.05n

.meas tran vdout1_76ck450 FIND v(dout1_76) AT=460.05n

.meas tran vdout1_77ck450 FIND v(dout1_77) AT=460.05n

.meas tran vdout1_78ck450 FIND v(dout1_78) AT=460.05n

.meas tran vdout1_79ck450 FIND v(dout1_79) AT=460.05n

.meas tran vdout1_80ck450 FIND v(dout1_80) AT=460.05n

.meas tran vdout1_81ck450 FIND v(dout1_81) AT=460.05n

.meas tran vdout1_82ck450 FIND v(dout1_82) AT=460.05n

.meas tran vdout1_83ck450 FIND v(dout1_83) AT=460.05n

.meas tran vdout1_84ck450 FIND v(dout1_84) AT=460.05n

.meas tran vdout1_85ck450 FIND v(dout1_85) AT=460.05n

.meas tran vdout1_86ck450 FIND v(dout1_86) AT=460.05n

.meas tran vdout1_87ck450 FIND v(dout1_87) AT=460.05n

.meas tran vdout1_88ck450 FIND v(dout1_88) AT=460.05n

.meas tran vdout1_89ck450 FIND v(dout1_89) AT=460.05n

.meas tran vdout1_90ck450 FIND v(dout1_90) AT=460.05n

.meas tran vdout1_91ck450 FIND v(dout1_91) AT=460.05n

.meas tran vdout1_92ck450 FIND v(dout1_92) AT=460.05n

.meas tran vdout1_93ck450 FIND v(dout1_93) AT=460.05n

.meas tran vdout1_94ck450 FIND v(dout1_94) AT=460.05n

.meas tran vdout1_95ck450 FIND v(dout1_95) AT=460.05n

.meas tran vdout1_96ck450 FIND v(dout1_96) AT=460.05n

.meas tran vdout1_97ck450 FIND v(dout1_97) AT=460.05n

.meas tran vdout1_98ck450 FIND v(dout1_98) AT=460.05n

.meas tran vdout1_99ck450 FIND v(dout1_99) AT=460.05n

.meas tran vdout1_100ck450 FIND v(dout1_100) AT=460.05n

.meas tran vdout1_101ck450 FIND v(dout1_101) AT=460.05n

.meas tran vdout1_102ck450 FIND v(dout1_102) AT=460.05n

.meas tran vdout1_103ck450 FIND v(dout1_103) AT=460.05n

.meas tran vdout1_104ck450 FIND v(dout1_104) AT=460.05n

.meas tran vdout1_105ck450 FIND v(dout1_105) AT=460.05n

.meas tran vdout1_106ck450 FIND v(dout1_106) AT=460.05n

.meas tran vdout1_107ck450 FIND v(dout1_107) AT=460.05n

.meas tran vdout1_108ck450 FIND v(dout1_108) AT=460.05n

.meas tran vdout1_109ck450 FIND v(dout1_109) AT=460.05n

.meas tran vdout1_110ck450 FIND v(dout1_110) AT=460.05n

.meas tran vdout1_111ck450 FIND v(dout1_111) AT=460.05n

.meas tran vdout1_112ck450 FIND v(dout1_112) AT=460.05n

.meas tran vdout1_113ck450 FIND v(dout1_113) AT=460.05n

.meas tran vdout1_114ck450 FIND v(dout1_114) AT=460.05n

.meas tran vdout1_115ck450 FIND v(dout1_115) AT=460.05n

.meas tran vdout1_116ck450 FIND v(dout1_116) AT=460.05n

.meas tran vdout1_117ck450 FIND v(dout1_117) AT=460.05n

.meas tran vdout1_118ck450 FIND v(dout1_118) AT=460.05n

.meas tran vdout1_119ck450 FIND v(dout1_119) AT=460.05n

.meas tran vdout1_120ck450 FIND v(dout1_120) AT=460.05n

.meas tran vdout1_121ck450 FIND v(dout1_121) AT=460.05n

.meas tran vdout1_122ck450 FIND v(dout1_122) AT=460.05n

.meas tran vdout1_123ck450 FIND v(dout1_123) AT=460.05n

.meas tran vdout1_124ck450 FIND v(dout1_124) AT=460.05n

.meas tran vdout1_125ck450 FIND v(dout1_125) AT=460.05n

.meas tran vdout1_126ck450 FIND v(dout1_126) AT=460.05n

.meas tran vdout1_127ck450 FIND v(dout1_127) AT=460.05n

.meas tran vdout1_128ck450 FIND v(dout1_128) AT=460.05n

.meas tran vdout1_129ck450 FIND v(dout1_129) AT=460.05n

.meas tran vdout1_130ck450 FIND v(dout1_130) AT=460.05n

.meas tran vdout1_131ck450 FIND v(dout1_131) AT=460.05n

.meas tran vdout1_132ck450 FIND v(dout1_132) AT=460.05n

.meas tran vdout1_133ck450 FIND v(dout1_133) AT=460.05n

.meas tran vdout1_134ck450 FIND v(dout1_134) AT=460.05n

.meas tran vdout1_135ck450 FIND v(dout1_135) AT=460.05n

.meas tran vdout1_136ck450 FIND v(dout1_136) AT=460.05n

.meas tran vdout1_137ck450 FIND v(dout1_137) AT=460.05n

.meas tran vdout1_138ck450 FIND v(dout1_138) AT=460.05n

.meas tran vdout1_139ck450 FIND v(dout1_139) AT=460.05n

.meas tran vdout1_140ck450 FIND v(dout1_140) AT=460.05n

.meas tran vdout1_141ck450 FIND v(dout1_141) AT=460.05n

.meas tran vdout1_142ck450 FIND v(dout1_142) AT=460.05n

.meas tran vdout1_143ck450 FIND v(dout1_143) AT=460.05n

.meas tran vdout1_144ck450 FIND v(dout1_144) AT=460.05n

.meas tran vdout1_145ck450 FIND v(dout1_145) AT=460.05n

.meas tran vdout1_146ck450 FIND v(dout1_146) AT=460.05n

.meas tran vdout1_147ck450 FIND v(dout1_147) AT=460.05n

.meas tran vdout1_148ck450 FIND v(dout1_148) AT=460.05n

.meas tran vdout1_149ck450 FIND v(dout1_149) AT=460.05n

.meas tran vdout1_150ck450 FIND v(dout1_150) AT=460.05n

.meas tran vdout1_151ck450 FIND v(dout1_151) AT=460.05n

.meas tran vdout1_152ck450 FIND v(dout1_152) AT=460.05n

.meas tran vdout1_153ck450 FIND v(dout1_153) AT=460.05n

.meas tran vdout1_154ck450 FIND v(dout1_154) AT=460.05n

.meas tran vdout1_155ck450 FIND v(dout1_155) AT=460.05n

.meas tran vdout1_156ck450 FIND v(dout1_156) AT=460.05n

.meas tran vdout1_157ck450 FIND v(dout1_157) AT=460.05n

.meas tran vdout1_158ck450 FIND v(dout1_158) AT=460.05n

.meas tran vdout1_159ck450 FIND v(dout1_159) AT=460.05n

.meas tran vdout1_160ck450 FIND v(dout1_160) AT=460.05n

.meas tran vdout1_161ck450 FIND v(dout1_161) AT=460.05n

.meas tran vdout1_162ck450 FIND v(dout1_162) AT=460.05n

.meas tran vdout1_163ck450 FIND v(dout1_163) AT=460.05n

.meas tran vdout1_164ck450 FIND v(dout1_164) AT=460.05n

.meas tran vdout1_165ck450 FIND v(dout1_165) AT=460.05n

.meas tran vdout1_166ck450 FIND v(dout1_166) AT=460.05n

.meas tran vdout1_167ck450 FIND v(dout1_167) AT=460.05n

.meas tran vdout1_168ck450 FIND v(dout1_168) AT=460.05n

.meas tran vdout1_169ck450 FIND v(dout1_169) AT=460.05n

.meas tran vdout1_170ck450 FIND v(dout1_170) AT=460.05n

.meas tran vdout1_171ck450 FIND v(dout1_171) AT=460.05n

.meas tran vdout1_172ck450 FIND v(dout1_172) AT=460.05n

.meas tran vdout1_173ck450 FIND v(dout1_173) AT=460.05n

.meas tran vdout1_174ck450 FIND v(dout1_174) AT=460.05n

.meas tran vdout1_175ck450 FIND v(dout1_175) AT=460.05n

.meas tran vdout1_176ck450 FIND v(dout1_176) AT=460.05n

.meas tran vdout1_177ck450 FIND v(dout1_177) AT=460.05n

.meas tran vdout1_178ck450 FIND v(dout1_178) AT=460.05n

.meas tran vdout1_179ck450 FIND v(dout1_179) AT=460.05n

.meas tran vdout1_180ck450 FIND v(dout1_180) AT=460.05n

.meas tran vdout1_181ck450 FIND v(dout1_181) AT=460.05n

.meas tran vdout1_182ck450 FIND v(dout1_182) AT=460.05n

.meas tran vdout1_183ck450 FIND v(dout1_183) AT=460.05n

.meas tran vdout1_184ck450 FIND v(dout1_184) AT=460.05n

.meas tran vdout1_185ck450 FIND v(dout1_185) AT=460.05n

.meas tran vdout1_186ck450 FIND v(dout1_186) AT=460.05n

.meas tran vdout1_187ck450 FIND v(dout1_187) AT=460.05n

.meas tran vdout1_188ck450 FIND v(dout1_188) AT=460.05n

.meas tran vdout1_189ck450 FIND v(dout1_189) AT=460.05n

.meas tran vdout1_190ck450 FIND v(dout1_190) AT=460.05n

.meas tran vdout1_191ck450 FIND v(dout1_191) AT=460.05n

.meas tran vdout1_192ck450 FIND v(dout1_192) AT=460.05n

.meas tran vdout1_193ck450 FIND v(dout1_193) AT=460.05n

.meas tran vdout1_194ck450 FIND v(dout1_194) AT=460.05n

.meas tran vdout1_195ck450 FIND v(dout1_195) AT=460.05n

.meas tran vdout1_196ck450 FIND v(dout1_196) AT=460.05n

.meas tran vdout1_197ck450 FIND v(dout1_197) AT=460.05n

.meas tran vdout1_198ck450 FIND v(dout1_198) AT=460.05n

.meas tran vdout1_199ck450 FIND v(dout1_199) AT=460.05n

.meas tran vdout1_200ck450 FIND v(dout1_200) AT=460.05n

.meas tran vdout1_201ck450 FIND v(dout1_201) AT=460.05n

.meas tran vdout1_202ck450 FIND v(dout1_202) AT=460.05n

.meas tran vdout1_203ck450 FIND v(dout1_203) AT=460.05n

.meas tran vdout1_204ck450 FIND v(dout1_204) AT=460.05n

.meas tran vdout1_205ck450 FIND v(dout1_205) AT=460.05n

.meas tran vdout1_206ck450 FIND v(dout1_206) AT=460.05n

.meas tran vdout1_207ck450 FIND v(dout1_207) AT=460.05n

.meas tran vdout1_208ck450 FIND v(dout1_208) AT=460.05n

.meas tran vdout1_209ck450 FIND v(dout1_209) AT=460.05n

.meas tran vdout1_210ck450 FIND v(dout1_210) AT=460.05n

.meas tran vdout1_211ck450 FIND v(dout1_211) AT=460.05n

.meas tran vdout1_212ck450 FIND v(dout1_212) AT=460.05n

.meas tran vdout1_213ck450 FIND v(dout1_213) AT=460.05n

.meas tran vdout1_214ck450 FIND v(dout1_214) AT=460.05n

.meas tran vdout1_215ck450 FIND v(dout1_215) AT=460.05n

.meas tran vdout1_216ck450 FIND v(dout1_216) AT=460.05n

.meas tran vdout1_217ck450 FIND v(dout1_217) AT=460.05n

.meas tran vdout1_218ck450 FIND v(dout1_218) AT=460.05n

.meas tran vdout1_219ck450 FIND v(dout1_219) AT=460.05n

.meas tran vdout1_220ck450 FIND v(dout1_220) AT=460.05n

.meas tran vdout1_221ck450 FIND v(dout1_221) AT=460.05n

.meas tran vdout1_222ck450 FIND v(dout1_222) AT=460.05n

.meas tran vdout1_223ck450 FIND v(dout1_223) AT=460.05n

.meas tran vdout1_224ck450 FIND v(dout1_224) AT=460.05n

.meas tran vdout1_225ck450 FIND v(dout1_225) AT=460.05n

.meas tran vdout1_226ck450 FIND v(dout1_226) AT=460.05n

.meas tran vdout1_227ck450 FIND v(dout1_227) AT=460.05n

.meas tran vdout1_228ck450 FIND v(dout1_228) AT=460.05n

.meas tran vdout1_229ck450 FIND v(dout1_229) AT=460.05n

.meas tran vdout1_230ck450 FIND v(dout1_230) AT=460.05n

.meas tran vdout1_231ck450 FIND v(dout1_231) AT=460.05n

.meas tran vdout1_232ck450 FIND v(dout1_232) AT=460.05n

.meas tran vdout1_233ck450 FIND v(dout1_233) AT=460.05n

.meas tran vdout1_234ck450 FIND v(dout1_234) AT=460.05n

.meas tran vdout1_235ck450 FIND v(dout1_235) AT=460.05n

.meas tran vdout1_236ck450 FIND v(dout1_236) AT=460.05n

.meas tran vdout1_237ck450 FIND v(dout1_237) AT=460.05n

.meas tran vdout1_238ck450 FIND v(dout1_238) AT=460.05n

.meas tran vdout1_239ck450 FIND v(dout1_239) AT=460.05n

.meas tran vdout1_240ck450 FIND v(dout1_240) AT=460.05n

.meas tran vdout1_241ck450 FIND v(dout1_241) AT=460.05n

.meas tran vdout1_242ck450 FIND v(dout1_242) AT=460.05n

.meas tran vdout1_243ck450 FIND v(dout1_243) AT=460.05n

.meas tran vdout1_244ck450 FIND v(dout1_244) AT=460.05n

.meas tran vdout1_245ck450 FIND v(dout1_245) AT=460.05n

.meas tran vdout1_246ck450 FIND v(dout1_246) AT=460.05n

.meas tran vdout1_247ck450 FIND v(dout1_247) AT=460.05n

.meas tran vdout1_248ck450 FIND v(dout1_248) AT=460.05n

.meas tran vdout1_249ck450 FIND v(dout1_249) AT=460.05n

.meas tran vdout1_250ck450 FIND v(dout1_250) AT=460.05n

.meas tran vdout1_251ck450 FIND v(dout1_251) AT=460.05n

.meas tran vdout1_252ck450 FIND v(dout1_252) AT=460.05n

.meas tran vdout1_253ck450 FIND v(dout1_253) AT=460.05n

.meas tran vdout1_254ck450 FIND v(dout1_254) AT=460.05n

.meas tran vdout1_255ck450 FIND v(dout1_255) AT=460.05n

.meas tran vdout1_256ck450 FIND v(dout1_256) AT=460.05n

.meas tran vdout1_0ck460 FIND v(dout1_0) AT=470.05n

.meas tran vdout1_1ck460 FIND v(dout1_1) AT=470.05n

.meas tran vdout1_2ck460 FIND v(dout1_2) AT=470.05n

.meas tran vdout1_3ck460 FIND v(dout1_3) AT=470.05n

.meas tran vdout1_4ck460 FIND v(dout1_4) AT=470.05n

.meas tran vdout1_5ck460 FIND v(dout1_5) AT=470.05n

.meas tran vdout1_6ck460 FIND v(dout1_6) AT=470.05n

.meas tran vdout1_7ck460 FIND v(dout1_7) AT=470.05n

.meas tran vdout1_8ck460 FIND v(dout1_8) AT=470.05n

.meas tran vdout1_9ck460 FIND v(dout1_9) AT=470.05n

.meas tran vdout1_10ck460 FIND v(dout1_10) AT=470.05n

.meas tran vdout1_11ck460 FIND v(dout1_11) AT=470.05n

.meas tran vdout1_12ck460 FIND v(dout1_12) AT=470.05n

.meas tran vdout1_13ck460 FIND v(dout1_13) AT=470.05n

.meas tran vdout1_14ck460 FIND v(dout1_14) AT=470.05n

.meas tran vdout1_15ck460 FIND v(dout1_15) AT=470.05n

.meas tran vdout1_16ck460 FIND v(dout1_16) AT=470.05n

.meas tran vdout1_17ck460 FIND v(dout1_17) AT=470.05n

.meas tran vdout1_18ck460 FIND v(dout1_18) AT=470.05n

.meas tran vdout1_19ck460 FIND v(dout1_19) AT=470.05n

.meas tran vdout1_20ck460 FIND v(dout1_20) AT=470.05n

.meas tran vdout1_21ck460 FIND v(dout1_21) AT=470.05n

.meas tran vdout1_22ck460 FIND v(dout1_22) AT=470.05n

.meas tran vdout1_23ck460 FIND v(dout1_23) AT=470.05n

.meas tran vdout1_24ck460 FIND v(dout1_24) AT=470.05n

.meas tran vdout1_25ck460 FIND v(dout1_25) AT=470.05n

.meas tran vdout1_26ck460 FIND v(dout1_26) AT=470.05n

.meas tran vdout1_27ck460 FIND v(dout1_27) AT=470.05n

.meas tran vdout1_28ck460 FIND v(dout1_28) AT=470.05n

.meas tran vdout1_29ck460 FIND v(dout1_29) AT=470.05n

.meas tran vdout1_30ck460 FIND v(dout1_30) AT=470.05n

.meas tran vdout1_31ck460 FIND v(dout1_31) AT=470.05n

.meas tran vdout1_32ck460 FIND v(dout1_32) AT=470.05n

.meas tran vdout1_33ck460 FIND v(dout1_33) AT=470.05n

.meas tran vdout1_34ck460 FIND v(dout1_34) AT=470.05n

.meas tran vdout1_35ck460 FIND v(dout1_35) AT=470.05n

.meas tran vdout1_36ck460 FIND v(dout1_36) AT=470.05n

.meas tran vdout1_37ck460 FIND v(dout1_37) AT=470.05n

.meas tran vdout1_38ck460 FIND v(dout1_38) AT=470.05n

.meas tran vdout1_39ck460 FIND v(dout1_39) AT=470.05n

.meas tran vdout1_40ck460 FIND v(dout1_40) AT=470.05n

.meas tran vdout1_41ck460 FIND v(dout1_41) AT=470.05n

.meas tran vdout1_42ck460 FIND v(dout1_42) AT=470.05n

.meas tran vdout1_43ck460 FIND v(dout1_43) AT=470.05n

.meas tran vdout1_44ck460 FIND v(dout1_44) AT=470.05n

.meas tran vdout1_45ck460 FIND v(dout1_45) AT=470.05n

.meas tran vdout1_46ck460 FIND v(dout1_46) AT=470.05n

.meas tran vdout1_47ck460 FIND v(dout1_47) AT=470.05n

.meas tran vdout1_48ck460 FIND v(dout1_48) AT=470.05n

.meas tran vdout1_49ck460 FIND v(dout1_49) AT=470.05n

.meas tran vdout1_50ck460 FIND v(dout1_50) AT=470.05n

.meas tran vdout1_51ck460 FIND v(dout1_51) AT=470.05n

.meas tran vdout1_52ck460 FIND v(dout1_52) AT=470.05n

.meas tran vdout1_53ck460 FIND v(dout1_53) AT=470.05n

.meas tran vdout1_54ck460 FIND v(dout1_54) AT=470.05n

.meas tran vdout1_55ck460 FIND v(dout1_55) AT=470.05n

.meas tran vdout1_56ck460 FIND v(dout1_56) AT=470.05n

.meas tran vdout1_57ck460 FIND v(dout1_57) AT=470.05n

.meas tran vdout1_58ck460 FIND v(dout1_58) AT=470.05n

.meas tran vdout1_59ck460 FIND v(dout1_59) AT=470.05n

.meas tran vdout1_60ck460 FIND v(dout1_60) AT=470.05n

.meas tran vdout1_61ck460 FIND v(dout1_61) AT=470.05n

.meas tran vdout1_62ck460 FIND v(dout1_62) AT=470.05n

.meas tran vdout1_63ck460 FIND v(dout1_63) AT=470.05n

.meas tran vdout1_64ck460 FIND v(dout1_64) AT=470.05n

.meas tran vdout1_65ck460 FIND v(dout1_65) AT=470.05n

.meas tran vdout1_66ck460 FIND v(dout1_66) AT=470.05n

.meas tran vdout1_67ck460 FIND v(dout1_67) AT=470.05n

.meas tran vdout1_68ck460 FIND v(dout1_68) AT=470.05n

.meas tran vdout1_69ck460 FIND v(dout1_69) AT=470.05n

.meas tran vdout1_70ck460 FIND v(dout1_70) AT=470.05n

.meas tran vdout1_71ck460 FIND v(dout1_71) AT=470.05n

.meas tran vdout1_72ck460 FIND v(dout1_72) AT=470.05n

.meas tran vdout1_73ck460 FIND v(dout1_73) AT=470.05n

.meas tran vdout1_74ck460 FIND v(dout1_74) AT=470.05n

.meas tran vdout1_75ck460 FIND v(dout1_75) AT=470.05n

.meas tran vdout1_76ck460 FIND v(dout1_76) AT=470.05n

.meas tran vdout1_77ck460 FIND v(dout1_77) AT=470.05n

.meas tran vdout1_78ck460 FIND v(dout1_78) AT=470.05n

.meas tran vdout1_79ck460 FIND v(dout1_79) AT=470.05n

.meas tran vdout1_80ck460 FIND v(dout1_80) AT=470.05n

.meas tran vdout1_81ck460 FIND v(dout1_81) AT=470.05n

.meas tran vdout1_82ck460 FIND v(dout1_82) AT=470.05n

.meas tran vdout1_83ck460 FIND v(dout1_83) AT=470.05n

.meas tran vdout1_84ck460 FIND v(dout1_84) AT=470.05n

.meas tran vdout1_85ck460 FIND v(dout1_85) AT=470.05n

.meas tran vdout1_86ck460 FIND v(dout1_86) AT=470.05n

.meas tran vdout1_87ck460 FIND v(dout1_87) AT=470.05n

.meas tran vdout1_88ck460 FIND v(dout1_88) AT=470.05n

.meas tran vdout1_89ck460 FIND v(dout1_89) AT=470.05n

.meas tran vdout1_90ck460 FIND v(dout1_90) AT=470.05n

.meas tran vdout1_91ck460 FIND v(dout1_91) AT=470.05n

.meas tran vdout1_92ck460 FIND v(dout1_92) AT=470.05n

.meas tran vdout1_93ck460 FIND v(dout1_93) AT=470.05n

.meas tran vdout1_94ck460 FIND v(dout1_94) AT=470.05n

.meas tran vdout1_95ck460 FIND v(dout1_95) AT=470.05n

.meas tran vdout1_96ck460 FIND v(dout1_96) AT=470.05n

.meas tran vdout1_97ck460 FIND v(dout1_97) AT=470.05n

.meas tran vdout1_98ck460 FIND v(dout1_98) AT=470.05n

.meas tran vdout1_99ck460 FIND v(dout1_99) AT=470.05n

.meas tran vdout1_100ck460 FIND v(dout1_100) AT=470.05n

.meas tran vdout1_101ck460 FIND v(dout1_101) AT=470.05n

.meas tran vdout1_102ck460 FIND v(dout1_102) AT=470.05n

.meas tran vdout1_103ck460 FIND v(dout1_103) AT=470.05n

.meas tran vdout1_104ck460 FIND v(dout1_104) AT=470.05n

.meas tran vdout1_105ck460 FIND v(dout1_105) AT=470.05n

.meas tran vdout1_106ck460 FIND v(dout1_106) AT=470.05n

.meas tran vdout1_107ck460 FIND v(dout1_107) AT=470.05n

.meas tran vdout1_108ck460 FIND v(dout1_108) AT=470.05n

.meas tran vdout1_109ck460 FIND v(dout1_109) AT=470.05n

.meas tran vdout1_110ck460 FIND v(dout1_110) AT=470.05n

.meas tran vdout1_111ck460 FIND v(dout1_111) AT=470.05n

.meas tran vdout1_112ck460 FIND v(dout1_112) AT=470.05n

.meas tran vdout1_113ck460 FIND v(dout1_113) AT=470.05n

.meas tran vdout1_114ck460 FIND v(dout1_114) AT=470.05n

.meas tran vdout1_115ck460 FIND v(dout1_115) AT=470.05n

.meas tran vdout1_116ck460 FIND v(dout1_116) AT=470.05n

.meas tran vdout1_117ck460 FIND v(dout1_117) AT=470.05n

.meas tran vdout1_118ck460 FIND v(dout1_118) AT=470.05n

.meas tran vdout1_119ck460 FIND v(dout1_119) AT=470.05n

.meas tran vdout1_120ck460 FIND v(dout1_120) AT=470.05n

.meas tran vdout1_121ck460 FIND v(dout1_121) AT=470.05n

.meas tran vdout1_122ck460 FIND v(dout1_122) AT=470.05n

.meas tran vdout1_123ck460 FIND v(dout1_123) AT=470.05n

.meas tran vdout1_124ck460 FIND v(dout1_124) AT=470.05n

.meas tran vdout1_125ck460 FIND v(dout1_125) AT=470.05n

.meas tran vdout1_126ck460 FIND v(dout1_126) AT=470.05n

.meas tran vdout1_127ck460 FIND v(dout1_127) AT=470.05n

.meas tran vdout1_128ck460 FIND v(dout1_128) AT=470.05n

.meas tran vdout1_129ck460 FIND v(dout1_129) AT=470.05n

.meas tran vdout1_130ck460 FIND v(dout1_130) AT=470.05n

.meas tran vdout1_131ck460 FIND v(dout1_131) AT=470.05n

.meas tran vdout1_132ck460 FIND v(dout1_132) AT=470.05n

.meas tran vdout1_133ck460 FIND v(dout1_133) AT=470.05n

.meas tran vdout1_134ck460 FIND v(dout1_134) AT=470.05n

.meas tran vdout1_135ck460 FIND v(dout1_135) AT=470.05n

.meas tran vdout1_136ck460 FIND v(dout1_136) AT=470.05n

.meas tran vdout1_137ck460 FIND v(dout1_137) AT=470.05n

.meas tran vdout1_138ck460 FIND v(dout1_138) AT=470.05n

.meas tran vdout1_139ck460 FIND v(dout1_139) AT=470.05n

.meas tran vdout1_140ck460 FIND v(dout1_140) AT=470.05n

.meas tran vdout1_141ck460 FIND v(dout1_141) AT=470.05n

.meas tran vdout1_142ck460 FIND v(dout1_142) AT=470.05n

.meas tran vdout1_143ck460 FIND v(dout1_143) AT=470.05n

.meas tran vdout1_144ck460 FIND v(dout1_144) AT=470.05n

.meas tran vdout1_145ck460 FIND v(dout1_145) AT=470.05n

.meas tran vdout1_146ck460 FIND v(dout1_146) AT=470.05n

.meas tran vdout1_147ck460 FIND v(dout1_147) AT=470.05n

.meas tran vdout1_148ck460 FIND v(dout1_148) AT=470.05n

.meas tran vdout1_149ck460 FIND v(dout1_149) AT=470.05n

.meas tran vdout1_150ck460 FIND v(dout1_150) AT=470.05n

.meas tran vdout1_151ck460 FIND v(dout1_151) AT=470.05n

.meas tran vdout1_152ck460 FIND v(dout1_152) AT=470.05n

.meas tran vdout1_153ck460 FIND v(dout1_153) AT=470.05n

.meas tran vdout1_154ck460 FIND v(dout1_154) AT=470.05n

.meas tran vdout1_155ck460 FIND v(dout1_155) AT=470.05n

.meas tran vdout1_156ck460 FIND v(dout1_156) AT=470.05n

.meas tran vdout1_157ck460 FIND v(dout1_157) AT=470.05n

.meas tran vdout1_158ck460 FIND v(dout1_158) AT=470.05n

.meas tran vdout1_159ck460 FIND v(dout1_159) AT=470.05n

.meas tran vdout1_160ck460 FIND v(dout1_160) AT=470.05n

.meas tran vdout1_161ck460 FIND v(dout1_161) AT=470.05n

.meas tran vdout1_162ck460 FIND v(dout1_162) AT=470.05n

.meas tran vdout1_163ck460 FIND v(dout1_163) AT=470.05n

.meas tran vdout1_164ck460 FIND v(dout1_164) AT=470.05n

.meas tran vdout1_165ck460 FIND v(dout1_165) AT=470.05n

.meas tran vdout1_166ck460 FIND v(dout1_166) AT=470.05n

.meas tran vdout1_167ck460 FIND v(dout1_167) AT=470.05n

.meas tran vdout1_168ck460 FIND v(dout1_168) AT=470.05n

.meas tran vdout1_169ck460 FIND v(dout1_169) AT=470.05n

.meas tran vdout1_170ck460 FIND v(dout1_170) AT=470.05n

.meas tran vdout1_171ck460 FIND v(dout1_171) AT=470.05n

.meas tran vdout1_172ck460 FIND v(dout1_172) AT=470.05n

.meas tran vdout1_173ck460 FIND v(dout1_173) AT=470.05n

.meas tran vdout1_174ck460 FIND v(dout1_174) AT=470.05n

.meas tran vdout1_175ck460 FIND v(dout1_175) AT=470.05n

.meas tran vdout1_176ck460 FIND v(dout1_176) AT=470.05n

.meas tran vdout1_177ck460 FIND v(dout1_177) AT=470.05n

.meas tran vdout1_178ck460 FIND v(dout1_178) AT=470.05n

.meas tran vdout1_179ck460 FIND v(dout1_179) AT=470.05n

.meas tran vdout1_180ck460 FIND v(dout1_180) AT=470.05n

.meas tran vdout1_181ck460 FIND v(dout1_181) AT=470.05n

.meas tran vdout1_182ck460 FIND v(dout1_182) AT=470.05n

.meas tran vdout1_183ck460 FIND v(dout1_183) AT=470.05n

.meas tran vdout1_184ck460 FIND v(dout1_184) AT=470.05n

.meas tran vdout1_185ck460 FIND v(dout1_185) AT=470.05n

.meas tran vdout1_186ck460 FIND v(dout1_186) AT=470.05n

.meas tran vdout1_187ck460 FIND v(dout1_187) AT=470.05n

.meas tran vdout1_188ck460 FIND v(dout1_188) AT=470.05n

.meas tran vdout1_189ck460 FIND v(dout1_189) AT=470.05n

.meas tran vdout1_190ck460 FIND v(dout1_190) AT=470.05n

.meas tran vdout1_191ck460 FIND v(dout1_191) AT=470.05n

.meas tran vdout1_192ck460 FIND v(dout1_192) AT=470.05n

.meas tran vdout1_193ck460 FIND v(dout1_193) AT=470.05n

.meas tran vdout1_194ck460 FIND v(dout1_194) AT=470.05n

.meas tran vdout1_195ck460 FIND v(dout1_195) AT=470.05n

.meas tran vdout1_196ck460 FIND v(dout1_196) AT=470.05n

.meas tran vdout1_197ck460 FIND v(dout1_197) AT=470.05n

.meas tran vdout1_198ck460 FIND v(dout1_198) AT=470.05n

.meas tran vdout1_199ck460 FIND v(dout1_199) AT=470.05n

.meas tran vdout1_200ck460 FIND v(dout1_200) AT=470.05n

.meas tran vdout1_201ck460 FIND v(dout1_201) AT=470.05n

.meas tran vdout1_202ck460 FIND v(dout1_202) AT=470.05n

.meas tran vdout1_203ck460 FIND v(dout1_203) AT=470.05n

.meas tran vdout1_204ck460 FIND v(dout1_204) AT=470.05n

.meas tran vdout1_205ck460 FIND v(dout1_205) AT=470.05n

.meas tran vdout1_206ck460 FIND v(dout1_206) AT=470.05n

.meas tran vdout1_207ck460 FIND v(dout1_207) AT=470.05n

.meas tran vdout1_208ck460 FIND v(dout1_208) AT=470.05n

.meas tran vdout1_209ck460 FIND v(dout1_209) AT=470.05n

.meas tran vdout1_210ck460 FIND v(dout1_210) AT=470.05n

.meas tran vdout1_211ck460 FIND v(dout1_211) AT=470.05n

.meas tran vdout1_212ck460 FIND v(dout1_212) AT=470.05n

.meas tran vdout1_213ck460 FIND v(dout1_213) AT=470.05n

.meas tran vdout1_214ck460 FIND v(dout1_214) AT=470.05n

.meas tran vdout1_215ck460 FIND v(dout1_215) AT=470.05n

.meas tran vdout1_216ck460 FIND v(dout1_216) AT=470.05n

.meas tran vdout1_217ck460 FIND v(dout1_217) AT=470.05n

.meas tran vdout1_218ck460 FIND v(dout1_218) AT=470.05n

.meas tran vdout1_219ck460 FIND v(dout1_219) AT=470.05n

.meas tran vdout1_220ck460 FIND v(dout1_220) AT=470.05n

.meas tran vdout1_221ck460 FIND v(dout1_221) AT=470.05n

.meas tran vdout1_222ck460 FIND v(dout1_222) AT=470.05n

.meas tran vdout1_223ck460 FIND v(dout1_223) AT=470.05n

.meas tran vdout1_224ck460 FIND v(dout1_224) AT=470.05n

.meas tran vdout1_225ck460 FIND v(dout1_225) AT=470.05n

.meas tran vdout1_226ck460 FIND v(dout1_226) AT=470.05n

.meas tran vdout1_227ck460 FIND v(dout1_227) AT=470.05n

.meas tran vdout1_228ck460 FIND v(dout1_228) AT=470.05n

.meas tran vdout1_229ck460 FIND v(dout1_229) AT=470.05n

.meas tran vdout1_230ck460 FIND v(dout1_230) AT=470.05n

.meas tran vdout1_231ck460 FIND v(dout1_231) AT=470.05n

.meas tran vdout1_232ck460 FIND v(dout1_232) AT=470.05n

.meas tran vdout1_233ck460 FIND v(dout1_233) AT=470.05n

.meas tran vdout1_234ck460 FIND v(dout1_234) AT=470.05n

.meas tran vdout1_235ck460 FIND v(dout1_235) AT=470.05n

.meas tran vdout1_236ck460 FIND v(dout1_236) AT=470.05n

.meas tran vdout1_237ck460 FIND v(dout1_237) AT=470.05n

.meas tran vdout1_238ck460 FIND v(dout1_238) AT=470.05n

.meas tran vdout1_239ck460 FIND v(dout1_239) AT=470.05n

.meas tran vdout1_240ck460 FIND v(dout1_240) AT=470.05n

.meas tran vdout1_241ck460 FIND v(dout1_241) AT=470.05n

.meas tran vdout1_242ck460 FIND v(dout1_242) AT=470.05n

.meas tran vdout1_243ck460 FIND v(dout1_243) AT=470.05n

.meas tran vdout1_244ck460 FIND v(dout1_244) AT=470.05n

.meas tran vdout1_245ck460 FIND v(dout1_245) AT=470.05n

.meas tran vdout1_246ck460 FIND v(dout1_246) AT=470.05n

.meas tran vdout1_247ck460 FIND v(dout1_247) AT=470.05n

.meas tran vdout1_248ck460 FIND v(dout1_248) AT=470.05n

.meas tran vdout1_249ck460 FIND v(dout1_249) AT=470.05n

.meas tran vdout1_250ck460 FIND v(dout1_250) AT=470.05n

.meas tran vdout1_251ck460 FIND v(dout1_251) AT=470.05n

.meas tran vdout1_252ck460 FIND v(dout1_252) AT=470.05n

.meas tran vdout1_253ck460 FIND v(dout1_253) AT=470.05n

.meas tran vdout1_254ck460 FIND v(dout1_254) AT=470.05n

.meas tran vdout1_255ck460 FIND v(dout1_255) AT=470.05n

.meas tran vdout1_256ck460 FIND v(dout1_256) AT=470.05n

.meas tran vdout1_0ck470 FIND v(dout1_0) AT=480.05n

.meas tran vdout1_1ck470 FIND v(dout1_1) AT=480.05n

.meas tran vdout1_2ck470 FIND v(dout1_2) AT=480.05n

.meas tran vdout1_3ck470 FIND v(dout1_3) AT=480.05n

.meas tran vdout1_4ck470 FIND v(dout1_4) AT=480.05n

.meas tran vdout1_5ck470 FIND v(dout1_5) AT=480.05n

.meas tran vdout1_6ck470 FIND v(dout1_6) AT=480.05n

.meas tran vdout1_7ck470 FIND v(dout1_7) AT=480.05n

.meas tran vdout1_8ck470 FIND v(dout1_8) AT=480.05n

.meas tran vdout1_9ck470 FIND v(dout1_9) AT=480.05n

.meas tran vdout1_10ck470 FIND v(dout1_10) AT=480.05n

.meas tran vdout1_11ck470 FIND v(dout1_11) AT=480.05n

.meas tran vdout1_12ck470 FIND v(dout1_12) AT=480.05n

.meas tran vdout1_13ck470 FIND v(dout1_13) AT=480.05n

.meas tran vdout1_14ck470 FIND v(dout1_14) AT=480.05n

.meas tran vdout1_15ck470 FIND v(dout1_15) AT=480.05n

.meas tran vdout1_16ck470 FIND v(dout1_16) AT=480.05n

.meas tran vdout1_17ck470 FIND v(dout1_17) AT=480.05n

.meas tran vdout1_18ck470 FIND v(dout1_18) AT=480.05n

.meas tran vdout1_19ck470 FIND v(dout1_19) AT=480.05n

.meas tran vdout1_20ck470 FIND v(dout1_20) AT=480.05n

.meas tran vdout1_21ck470 FIND v(dout1_21) AT=480.05n

.meas tran vdout1_22ck470 FIND v(dout1_22) AT=480.05n

.meas tran vdout1_23ck470 FIND v(dout1_23) AT=480.05n

.meas tran vdout1_24ck470 FIND v(dout1_24) AT=480.05n

.meas tran vdout1_25ck470 FIND v(dout1_25) AT=480.05n

.meas tran vdout1_26ck470 FIND v(dout1_26) AT=480.05n

.meas tran vdout1_27ck470 FIND v(dout1_27) AT=480.05n

.meas tran vdout1_28ck470 FIND v(dout1_28) AT=480.05n

.meas tran vdout1_29ck470 FIND v(dout1_29) AT=480.05n

.meas tran vdout1_30ck470 FIND v(dout1_30) AT=480.05n

.meas tran vdout1_31ck470 FIND v(dout1_31) AT=480.05n

.meas tran vdout1_32ck470 FIND v(dout1_32) AT=480.05n

.meas tran vdout1_33ck470 FIND v(dout1_33) AT=480.05n

.meas tran vdout1_34ck470 FIND v(dout1_34) AT=480.05n

.meas tran vdout1_35ck470 FIND v(dout1_35) AT=480.05n

.meas tran vdout1_36ck470 FIND v(dout1_36) AT=480.05n

.meas tran vdout1_37ck470 FIND v(dout1_37) AT=480.05n

.meas tran vdout1_38ck470 FIND v(dout1_38) AT=480.05n

.meas tran vdout1_39ck470 FIND v(dout1_39) AT=480.05n

.meas tran vdout1_40ck470 FIND v(dout1_40) AT=480.05n

.meas tran vdout1_41ck470 FIND v(dout1_41) AT=480.05n

.meas tran vdout1_42ck470 FIND v(dout1_42) AT=480.05n

.meas tran vdout1_43ck470 FIND v(dout1_43) AT=480.05n

.meas tran vdout1_44ck470 FIND v(dout1_44) AT=480.05n

.meas tran vdout1_45ck470 FIND v(dout1_45) AT=480.05n

.meas tran vdout1_46ck470 FIND v(dout1_46) AT=480.05n

.meas tran vdout1_47ck470 FIND v(dout1_47) AT=480.05n

.meas tran vdout1_48ck470 FIND v(dout1_48) AT=480.05n

.meas tran vdout1_49ck470 FIND v(dout1_49) AT=480.05n

.meas tran vdout1_50ck470 FIND v(dout1_50) AT=480.05n

.meas tran vdout1_51ck470 FIND v(dout1_51) AT=480.05n

.meas tran vdout1_52ck470 FIND v(dout1_52) AT=480.05n

.meas tran vdout1_53ck470 FIND v(dout1_53) AT=480.05n

.meas tran vdout1_54ck470 FIND v(dout1_54) AT=480.05n

.meas tran vdout1_55ck470 FIND v(dout1_55) AT=480.05n

.meas tran vdout1_56ck470 FIND v(dout1_56) AT=480.05n

.meas tran vdout1_57ck470 FIND v(dout1_57) AT=480.05n

.meas tran vdout1_58ck470 FIND v(dout1_58) AT=480.05n

.meas tran vdout1_59ck470 FIND v(dout1_59) AT=480.05n

.meas tran vdout1_60ck470 FIND v(dout1_60) AT=480.05n

.meas tran vdout1_61ck470 FIND v(dout1_61) AT=480.05n

.meas tran vdout1_62ck470 FIND v(dout1_62) AT=480.05n

.meas tran vdout1_63ck470 FIND v(dout1_63) AT=480.05n

.meas tran vdout1_64ck470 FIND v(dout1_64) AT=480.05n

.meas tran vdout1_65ck470 FIND v(dout1_65) AT=480.05n

.meas tran vdout1_66ck470 FIND v(dout1_66) AT=480.05n

.meas tran vdout1_67ck470 FIND v(dout1_67) AT=480.05n

.meas tran vdout1_68ck470 FIND v(dout1_68) AT=480.05n

.meas tran vdout1_69ck470 FIND v(dout1_69) AT=480.05n

.meas tran vdout1_70ck470 FIND v(dout1_70) AT=480.05n

.meas tran vdout1_71ck470 FIND v(dout1_71) AT=480.05n

.meas tran vdout1_72ck470 FIND v(dout1_72) AT=480.05n

.meas tran vdout1_73ck470 FIND v(dout1_73) AT=480.05n

.meas tran vdout1_74ck470 FIND v(dout1_74) AT=480.05n

.meas tran vdout1_75ck470 FIND v(dout1_75) AT=480.05n

.meas tran vdout1_76ck470 FIND v(dout1_76) AT=480.05n

.meas tran vdout1_77ck470 FIND v(dout1_77) AT=480.05n

.meas tran vdout1_78ck470 FIND v(dout1_78) AT=480.05n

.meas tran vdout1_79ck470 FIND v(dout1_79) AT=480.05n

.meas tran vdout1_80ck470 FIND v(dout1_80) AT=480.05n

.meas tran vdout1_81ck470 FIND v(dout1_81) AT=480.05n

.meas tran vdout1_82ck470 FIND v(dout1_82) AT=480.05n

.meas tran vdout1_83ck470 FIND v(dout1_83) AT=480.05n

.meas tran vdout1_84ck470 FIND v(dout1_84) AT=480.05n

.meas tran vdout1_85ck470 FIND v(dout1_85) AT=480.05n

.meas tran vdout1_86ck470 FIND v(dout1_86) AT=480.05n

.meas tran vdout1_87ck470 FIND v(dout1_87) AT=480.05n

.meas tran vdout1_88ck470 FIND v(dout1_88) AT=480.05n

.meas tran vdout1_89ck470 FIND v(dout1_89) AT=480.05n

.meas tran vdout1_90ck470 FIND v(dout1_90) AT=480.05n

.meas tran vdout1_91ck470 FIND v(dout1_91) AT=480.05n

.meas tran vdout1_92ck470 FIND v(dout1_92) AT=480.05n

.meas tran vdout1_93ck470 FIND v(dout1_93) AT=480.05n

.meas tran vdout1_94ck470 FIND v(dout1_94) AT=480.05n

.meas tran vdout1_95ck470 FIND v(dout1_95) AT=480.05n

.meas tran vdout1_96ck470 FIND v(dout1_96) AT=480.05n

.meas tran vdout1_97ck470 FIND v(dout1_97) AT=480.05n

.meas tran vdout1_98ck470 FIND v(dout1_98) AT=480.05n

.meas tran vdout1_99ck470 FIND v(dout1_99) AT=480.05n

.meas tran vdout1_100ck470 FIND v(dout1_100) AT=480.05n

.meas tran vdout1_101ck470 FIND v(dout1_101) AT=480.05n

.meas tran vdout1_102ck470 FIND v(dout1_102) AT=480.05n

.meas tran vdout1_103ck470 FIND v(dout1_103) AT=480.05n

.meas tran vdout1_104ck470 FIND v(dout1_104) AT=480.05n

.meas tran vdout1_105ck470 FIND v(dout1_105) AT=480.05n

.meas tran vdout1_106ck470 FIND v(dout1_106) AT=480.05n

.meas tran vdout1_107ck470 FIND v(dout1_107) AT=480.05n

.meas tran vdout1_108ck470 FIND v(dout1_108) AT=480.05n

.meas tran vdout1_109ck470 FIND v(dout1_109) AT=480.05n

.meas tran vdout1_110ck470 FIND v(dout1_110) AT=480.05n

.meas tran vdout1_111ck470 FIND v(dout1_111) AT=480.05n

.meas tran vdout1_112ck470 FIND v(dout1_112) AT=480.05n

.meas tran vdout1_113ck470 FIND v(dout1_113) AT=480.05n

.meas tran vdout1_114ck470 FIND v(dout1_114) AT=480.05n

.meas tran vdout1_115ck470 FIND v(dout1_115) AT=480.05n

.meas tran vdout1_116ck470 FIND v(dout1_116) AT=480.05n

.meas tran vdout1_117ck470 FIND v(dout1_117) AT=480.05n

.meas tran vdout1_118ck470 FIND v(dout1_118) AT=480.05n

.meas tran vdout1_119ck470 FIND v(dout1_119) AT=480.05n

.meas tran vdout1_120ck470 FIND v(dout1_120) AT=480.05n

.meas tran vdout1_121ck470 FIND v(dout1_121) AT=480.05n

.meas tran vdout1_122ck470 FIND v(dout1_122) AT=480.05n

.meas tran vdout1_123ck470 FIND v(dout1_123) AT=480.05n

.meas tran vdout1_124ck470 FIND v(dout1_124) AT=480.05n

.meas tran vdout1_125ck470 FIND v(dout1_125) AT=480.05n

.meas tran vdout1_126ck470 FIND v(dout1_126) AT=480.05n

.meas tran vdout1_127ck470 FIND v(dout1_127) AT=480.05n

.meas tran vdout1_128ck470 FIND v(dout1_128) AT=480.05n

.meas tran vdout1_129ck470 FIND v(dout1_129) AT=480.05n

.meas tran vdout1_130ck470 FIND v(dout1_130) AT=480.05n

.meas tran vdout1_131ck470 FIND v(dout1_131) AT=480.05n

.meas tran vdout1_132ck470 FIND v(dout1_132) AT=480.05n

.meas tran vdout1_133ck470 FIND v(dout1_133) AT=480.05n

.meas tran vdout1_134ck470 FIND v(dout1_134) AT=480.05n

.meas tran vdout1_135ck470 FIND v(dout1_135) AT=480.05n

.meas tran vdout1_136ck470 FIND v(dout1_136) AT=480.05n

.meas tran vdout1_137ck470 FIND v(dout1_137) AT=480.05n

.meas tran vdout1_138ck470 FIND v(dout1_138) AT=480.05n

.meas tran vdout1_139ck470 FIND v(dout1_139) AT=480.05n

.meas tran vdout1_140ck470 FIND v(dout1_140) AT=480.05n

.meas tran vdout1_141ck470 FIND v(dout1_141) AT=480.05n

.meas tran vdout1_142ck470 FIND v(dout1_142) AT=480.05n

.meas tran vdout1_143ck470 FIND v(dout1_143) AT=480.05n

.meas tran vdout1_144ck470 FIND v(dout1_144) AT=480.05n

.meas tran vdout1_145ck470 FIND v(dout1_145) AT=480.05n

.meas tran vdout1_146ck470 FIND v(dout1_146) AT=480.05n

.meas tran vdout1_147ck470 FIND v(dout1_147) AT=480.05n

.meas tran vdout1_148ck470 FIND v(dout1_148) AT=480.05n

.meas tran vdout1_149ck470 FIND v(dout1_149) AT=480.05n

.meas tran vdout1_150ck470 FIND v(dout1_150) AT=480.05n

.meas tran vdout1_151ck470 FIND v(dout1_151) AT=480.05n

.meas tran vdout1_152ck470 FIND v(dout1_152) AT=480.05n

.meas tran vdout1_153ck470 FIND v(dout1_153) AT=480.05n

.meas tran vdout1_154ck470 FIND v(dout1_154) AT=480.05n

.meas tran vdout1_155ck470 FIND v(dout1_155) AT=480.05n

.meas tran vdout1_156ck470 FIND v(dout1_156) AT=480.05n

.meas tran vdout1_157ck470 FIND v(dout1_157) AT=480.05n

.meas tran vdout1_158ck470 FIND v(dout1_158) AT=480.05n

.meas tran vdout1_159ck470 FIND v(dout1_159) AT=480.05n

.meas tran vdout1_160ck470 FIND v(dout1_160) AT=480.05n

.meas tran vdout1_161ck470 FIND v(dout1_161) AT=480.05n

.meas tran vdout1_162ck470 FIND v(dout1_162) AT=480.05n

.meas tran vdout1_163ck470 FIND v(dout1_163) AT=480.05n

.meas tran vdout1_164ck470 FIND v(dout1_164) AT=480.05n

.meas tran vdout1_165ck470 FIND v(dout1_165) AT=480.05n

.meas tran vdout1_166ck470 FIND v(dout1_166) AT=480.05n

.meas tran vdout1_167ck470 FIND v(dout1_167) AT=480.05n

.meas tran vdout1_168ck470 FIND v(dout1_168) AT=480.05n

.meas tran vdout1_169ck470 FIND v(dout1_169) AT=480.05n

.meas tran vdout1_170ck470 FIND v(dout1_170) AT=480.05n

.meas tran vdout1_171ck470 FIND v(dout1_171) AT=480.05n

.meas tran vdout1_172ck470 FIND v(dout1_172) AT=480.05n

.meas tran vdout1_173ck470 FIND v(dout1_173) AT=480.05n

.meas tran vdout1_174ck470 FIND v(dout1_174) AT=480.05n

.meas tran vdout1_175ck470 FIND v(dout1_175) AT=480.05n

.meas tran vdout1_176ck470 FIND v(dout1_176) AT=480.05n

.meas tran vdout1_177ck470 FIND v(dout1_177) AT=480.05n

.meas tran vdout1_178ck470 FIND v(dout1_178) AT=480.05n

.meas tran vdout1_179ck470 FIND v(dout1_179) AT=480.05n

.meas tran vdout1_180ck470 FIND v(dout1_180) AT=480.05n

.meas tran vdout1_181ck470 FIND v(dout1_181) AT=480.05n

.meas tran vdout1_182ck470 FIND v(dout1_182) AT=480.05n

.meas tran vdout1_183ck470 FIND v(dout1_183) AT=480.05n

.meas tran vdout1_184ck470 FIND v(dout1_184) AT=480.05n

.meas tran vdout1_185ck470 FIND v(dout1_185) AT=480.05n

.meas tran vdout1_186ck470 FIND v(dout1_186) AT=480.05n

.meas tran vdout1_187ck470 FIND v(dout1_187) AT=480.05n

.meas tran vdout1_188ck470 FIND v(dout1_188) AT=480.05n

.meas tran vdout1_189ck470 FIND v(dout1_189) AT=480.05n

.meas tran vdout1_190ck470 FIND v(dout1_190) AT=480.05n

.meas tran vdout1_191ck470 FIND v(dout1_191) AT=480.05n

.meas tran vdout1_192ck470 FIND v(dout1_192) AT=480.05n

.meas tran vdout1_193ck470 FIND v(dout1_193) AT=480.05n

.meas tran vdout1_194ck470 FIND v(dout1_194) AT=480.05n

.meas tran vdout1_195ck470 FIND v(dout1_195) AT=480.05n

.meas tran vdout1_196ck470 FIND v(dout1_196) AT=480.05n

.meas tran vdout1_197ck470 FIND v(dout1_197) AT=480.05n

.meas tran vdout1_198ck470 FIND v(dout1_198) AT=480.05n

.meas tran vdout1_199ck470 FIND v(dout1_199) AT=480.05n

.meas tran vdout1_200ck470 FIND v(dout1_200) AT=480.05n

.meas tran vdout1_201ck470 FIND v(dout1_201) AT=480.05n

.meas tran vdout1_202ck470 FIND v(dout1_202) AT=480.05n

.meas tran vdout1_203ck470 FIND v(dout1_203) AT=480.05n

.meas tran vdout1_204ck470 FIND v(dout1_204) AT=480.05n

.meas tran vdout1_205ck470 FIND v(dout1_205) AT=480.05n

.meas tran vdout1_206ck470 FIND v(dout1_206) AT=480.05n

.meas tran vdout1_207ck470 FIND v(dout1_207) AT=480.05n

.meas tran vdout1_208ck470 FIND v(dout1_208) AT=480.05n

.meas tran vdout1_209ck470 FIND v(dout1_209) AT=480.05n

.meas tran vdout1_210ck470 FIND v(dout1_210) AT=480.05n

.meas tran vdout1_211ck470 FIND v(dout1_211) AT=480.05n

.meas tran vdout1_212ck470 FIND v(dout1_212) AT=480.05n

.meas tran vdout1_213ck470 FIND v(dout1_213) AT=480.05n

.meas tran vdout1_214ck470 FIND v(dout1_214) AT=480.05n

.meas tran vdout1_215ck470 FIND v(dout1_215) AT=480.05n

.meas tran vdout1_216ck470 FIND v(dout1_216) AT=480.05n

.meas tran vdout1_217ck470 FIND v(dout1_217) AT=480.05n

.meas tran vdout1_218ck470 FIND v(dout1_218) AT=480.05n

.meas tran vdout1_219ck470 FIND v(dout1_219) AT=480.05n

.meas tran vdout1_220ck470 FIND v(dout1_220) AT=480.05n

.meas tran vdout1_221ck470 FIND v(dout1_221) AT=480.05n

.meas tran vdout1_222ck470 FIND v(dout1_222) AT=480.05n

.meas tran vdout1_223ck470 FIND v(dout1_223) AT=480.05n

.meas tran vdout1_224ck470 FIND v(dout1_224) AT=480.05n

.meas tran vdout1_225ck470 FIND v(dout1_225) AT=480.05n

.meas tran vdout1_226ck470 FIND v(dout1_226) AT=480.05n

.meas tran vdout1_227ck470 FIND v(dout1_227) AT=480.05n

.meas tran vdout1_228ck470 FIND v(dout1_228) AT=480.05n

.meas tran vdout1_229ck470 FIND v(dout1_229) AT=480.05n

.meas tran vdout1_230ck470 FIND v(dout1_230) AT=480.05n

.meas tran vdout1_231ck470 FIND v(dout1_231) AT=480.05n

.meas tran vdout1_232ck470 FIND v(dout1_232) AT=480.05n

.meas tran vdout1_233ck470 FIND v(dout1_233) AT=480.05n

.meas tran vdout1_234ck470 FIND v(dout1_234) AT=480.05n

.meas tran vdout1_235ck470 FIND v(dout1_235) AT=480.05n

.meas tran vdout1_236ck470 FIND v(dout1_236) AT=480.05n

.meas tran vdout1_237ck470 FIND v(dout1_237) AT=480.05n

.meas tran vdout1_238ck470 FIND v(dout1_238) AT=480.05n

.meas tran vdout1_239ck470 FIND v(dout1_239) AT=480.05n

.meas tran vdout1_240ck470 FIND v(dout1_240) AT=480.05n

.meas tran vdout1_241ck470 FIND v(dout1_241) AT=480.05n

.meas tran vdout1_242ck470 FIND v(dout1_242) AT=480.05n

.meas tran vdout1_243ck470 FIND v(dout1_243) AT=480.05n

.meas tran vdout1_244ck470 FIND v(dout1_244) AT=480.05n

.meas tran vdout1_245ck470 FIND v(dout1_245) AT=480.05n

.meas tran vdout1_246ck470 FIND v(dout1_246) AT=480.05n

.meas tran vdout1_247ck470 FIND v(dout1_247) AT=480.05n

.meas tran vdout1_248ck470 FIND v(dout1_248) AT=480.05n

.meas tran vdout1_249ck470 FIND v(dout1_249) AT=480.05n

.meas tran vdout1_250ck470 FIND v(dout1_250) AT=480.05n

.meas tran vdout1_251ck470 FIND v(dout1_251) AT=480.05n

.meas tran vdout1_252ck470 FIND v(dout1_252) AT=480.05n

.meas tran vdout1_253ck470 FIND v(dout1_253) AT=480.05n

.meas tran vdout1_254ck470 FIND v(dout1_254) AT=480.05n

.meas tran vdout1_255ck470 FIND v(dout1_255) AT=480.05n

.meas tran vdout1_256ck470 FIND v(dout1_256) AT=480.05n

.meas tran vdout1_0ck510 FIND v(dout1_0) AT=520.05n

.meas tran vdout1_1ck510 FIND v(dout1_1) AT=520.05n

.meas tran vdout1_2ck510 FIND v(dout1_2) AT=520.05n

.meas tran vdout1_3ck510 FIND v(dout1_3) AT=520.05n

.meas tran vdout1_4ck510 FIND v(dout1_4) AT=520.05n

.meas tran vdout1_5ck510 FIND v(dout1_5) AT=520.05n

.meas tran vdout1_6ck510 FIND v(dout1_6) AT=520.05n

.meas tran vdout1_7ck510 FIND v(dout1_7) AT=520.05n

.meas tran vdout1_8ck510 FIND v(dout1_8) AT=520.05n

.meas tran vdout1_9ck510 FIND v(dout1_9) AT=520.05n

.meas tran vdout1_10ck510 FIND v(dout1_10) AT=520.05n

.meas tran vdout1_11ck510 FIND v(dout1_11) AT=520.05n

.meas tran vdout1_12ck510 FIND v(dout1_12) AT=520.05n

.meas tran vdout1_13ck510 FIND v(dout1_13) AT=520.05n

.meas tran vdout1_14ck510 FIND v(dout1_14) AT=520.05n

.meas tran vdout1_15ck510 FIND v(dout1_15) AT=520.05n

.meas tran vdout1_16ck510 FIND v(dout1_16) AT=520.05n

.meas tran vdout1_17ck510 FIND v(dout1_17) AT=520.05n

.meas tran vdout1_18ck510 FIND v(dout1_18) AT=520.05n

.meas tran vdout1_19ck510 FIND v(dout1_19) AT=520.05n

.meas tran vdout1_20ck510 FIND v(dout1_20) AT=520.05n

.meas tran vdout1_21ck510 FIND v(dout1_21) AT=520.05n

.meas tran vdout1_22ck510 FIND v(dout1_22) AT=520.05n

.meas tran vdout1_23ck510 FIND v(dout1_23) AT=520.05n

.meas tran vdout1_24ck510 FIND v(dout1_24) AT=520.05n

.meas tran vdout1_25ck510 FIND v(dout1_25) AT=520.05n

.meas tran vdout1_26ck510 FIND v(dout1_26) AT=520.05n

.meas tran vdout1_27ck510 FIND v(dout1_27) AT=520.05n

.meas tran vdout1_28ck510 FIND v(dout1_28) AT=520.05n

.meas tran vdout1_29ck510 FIND v(dout1_29) AT=520.05n

.meas tran vdout1_30ck510 FIND v(dout1_30) AT=520.05n

.meas tran vdout1_31ck510 FIND v(dout1_31) AT=520.05n

.meas tran vdout1_32ck510 FIND v(dout1_32) AT=520.05n

.meas tran vdout1_33ck510 FIND v(dout1_33) AT=520.05n

.meas tran vdout1_34ck510 FIND v(dout1_34) AT=520.05n

.meas tran vdout1_35ck510 FIND v(dout1_35) AT=520.05n

.meas tran vdout1_36ck510 FIND v(dout1_36) AT=520.05n

.meas tran vdout1_37ck510 FIND v(dout1_37) AT=520.05n

.meas tran vdout1_38ck510 FIND v(dout1_38) AT=520.05n

.meas tran vdout1_39ck510 FIND v(dout1_39) AT=520.05n

.meas tran vdout1_40ck510 FIND v(dout1_40) AT=520.05n

.meas tran vdout1_41ck510 FIND v(dout1_41) AT=520.05n

.meas tran vdout1_42ck510 FIND v(dout1_42) AT=520.05n

.meas tran vdout1_43ck510 FIND v(dout1_43) AT=520.05n

.meas tran vdout1_44ck510 FIND v(dout1_44) AT=520.05n

.meas tran vdout1_45ck510 FIND v(dout1_45) AT=520.05n

.meas tran vdout1_46ck510 FIND v(dout1_46) AT=520.05n

.meas tran vdout1_47ck510 FIND v(dout1_47) AT=520.05n

.meas tran vdout1_48ck510 FIND v(dout1_48) AT=520.05n

.meas tran vdout1_49ck510 FIND v(dout1_49) AT=520.05n

.meas tran vdout1_50ck510 FIND v(dout1_50) AT=520.05n

.meas tran vdout1_51ck510 FIND v(dout1_51) AT=520.05n

.meas tran vdout1_52ck510 FIND v(dout1_52) AT=520.05n

.meas tran vdout1_53ck510 FIND v(dout1_53) AT=520.05n

.meas tran vdout1_54ck510 FIND v(dout1_54) AT=520.05n

.meas tran vdout1_55ck510 FIND v(dout1_55) AT=520.05n

.meas tran vdout1_56ck510 FIND v(dout1_56) AT=520.05n

.meas tran vdout1_57ck510 FIND v(dout1_57) AT=520.05n

.meas tran vdout1_58ck510 FIND v(dout1_58) AT=520.05n

.meas tran vdout1_59ck510 FIND v(dout1_59) AT=520.05n

.meas tran vdout1_60ck510 FIND v(dout1_60) AT=520.05n

.meas tran vdout1_61ck510 FIND v(dout1_61) AT=520.05n

.meas tran vdout1_62ck510 FIND v(dout1_62) AT=520.05n

.meas tran vdout1_63ck510 FIND v(dout1_63) AT=520.05n

.meas tran vdout1_64ck510 FIND v(dout1_64) AT=520.05n

.meas tran vdout1_65ck510 FIND v(dout1_65) AT=520.05n

.meas tran vdout1_66ck510 FIND v(dout1_66) AT=520.05n

.meas tran vdout1_67ck510 FIND v(dout1_67) AT=520.05n

.meas tran vdout1_68ck510 FIND v(dout1_68) AT=520.05n

.meas tran vdout1_69ck510 FIND v(dout1_69) AT=520.05n

.meas tran vdout1_70ck510 FIND v(dout1_70) AT=520.05n

.meas tran vdout1_71ck510 FIND v(dout1_71) AT=520.05n

.meas tran vdout1_72ck510 FIND v(dout1_72) AT=520.05n

.meas tran vdout1_73ck510 FIND v(dout1_73) AT=520.05n

.meas tran vdout1_74ck510 FIND v(dout1_74) AT=520.05n

.meas tran vdout1_75ck510 FIND v(dout1_75) AT=520.05n

.meas tran vdout1_76ck510 FIND v(dout1_76) AT=520.05n

.meas tran vdout1_77ck510 FIND v(dout1_77) AT=520.05n

.meas tran vdout1_78ck510 FIND v(dout1_78) AT=520.05n

.meas tran vdout1_79ck510 FIND v(dout1_79) AT=520.05n

.meas tran vdout1_80ck510 FIND v(dout1_80) AT=520.05n

.meas tran vdout1_81ck510 FIND v(dout1_81) AT=520.05n

.meas tran vdout1_82ck510 FIND v(dout1_82) AT=520.05n

.meas tran vdout1_83ck510 FIND v(dout1_83) AT=520.05n

.meas tran vdout1_84ck510 FIND v(dout1_84) AT=520.05n

.meas tran vdout1_85ck510 FIND v(dout1_85) AT=520.05n

.meas tran vdout1_86ck510 FIND v(dout1_86) AT=520.05n

.meas tran vdout1_87ck510 FIND v(dout1_87) AT=520.05n

.meas tran vdout1_88ck510 FIND v(dout1_88) AT=520.05n

.meas tran vdout1_89ck510 FIND v(dout1_89) AT=520.05n

.meas tran vdout1_90ck510 FIND v(dout1_90) AT=520.05n

.meas tran vdout1_91ck510 FIND v(dout1_91) AT=520.05n

.meas tran vdout1_92ck510 FIND v(dout1_92) AT=520.05n

.meas tran vdout1_93ck510 FIND v(dout1_93) AT=520.05n

.meas tran vdout1_94ck510 FIND v(dout1_94) AT=520.05n

.meas tran vdout1_95ck510 FIND v(dout1_95) AT=520.05n

.meas tran vdout1_96ck510 FIND v(dout1_96) AT=520.05n

.meas tran vdout1_97ck510 FIND v(dout1_97) AT=520.05n

.meas tran vdout1_98ck510 FIND v(dout1_98) AT=520.05n

.meas tran vdout1_99ck510 FIND v(dout1_99) AT=520.05n

.meas tran vdout1_100ck510 FIND v(dout1_100) AT=520.05n

.meas tran vdout1_101ck510 FIND v(dout1_101) AT=520.05n

.meas tran vdout1_102ck510 FIND v(dout1_102) AT=520.05n

.meas tran vdout1_103ck510 FIND v(dout1_103) AT=520.05n

.meas tran vdout1_104ck510 FIND v(dout1_104) AT=520.05n

.meas tran vdout1_105ck510 FIND v(dout1_105) AT=520.05n

.meas tran vdout1_106ck510 FIND v(dout1_106) AT=520.05n

.meas tran vdout1_107ck510 FIND v(dout1_107) AT=520.05n

.meas tran vdout1_108ck510 FIND v(dout1_108) AT=520.05n

.meas tran vdout1_109ck510 FIND v(dout1_109) AT=520.05n

.meas tran vdout1_110ck510 FIND v(dout1_110) AT=520.05n

.meas tran vdout1_111ck510 FIND v(dout1_111) AT=520.05n

.meas tran vdout1_112ck510 FIND v(dout1_112) AT=520.05n

.meas tran vdout1_113ck510 FIND v(dout1_113) AT=520.05n

.meas tran vdout1_114ck510 FIND v(dout1_114) AT=520.05n

.meas tran vdout1_115ck510 FIND v(dout1_115) AT=520.05n

.meas tran vdout1_116ck510 FIND v(dout1_116) AT=520.05n

.meas tran vdout1_117ck510 FIND v(dout1_117) AT=520.05n

.meas tran vdout1_118ck510 FIND v(dout1_118) AT=520.05n

.meas tran vdout1_119ck510 FIND v(dout1_119) AT=520.05n

.meas tran vdout1_120ck510 FIND v(dout1_120) AT=520.05n

.meas tran vdout1_121ck510 FIND v(dout1_121) AT=520.05n

.meas tran vdout1_122ck510 FIND v(dout1_122) AT=520.05n

.meas tran vdout1_123ck510 FIND v(dout1_123) AT=520.05n

.meas tran vdout1_124ck510 FIND v(dout1_124) AT=520.05n

.meas tran vdout1_125ck510 FIND v(dout1_125) AT=520.05n

.meas tran vdout1_126ck510 FIND v(dout1_126) AT=520.05n

.meas tran vdout1_127ck510 FIND v(dout1_127) AT=520.05n

.meas tran vdout1_128ck510 FIND v(dout1_128) AT=520.05n

.meas tran vdout1_129ck510 FIND v(dout1_129) AT=520.05n

.meas tran vdout1_130ck510 FIND v(dout1_130) AT=520.05n

.meas tran vdout1_131ck510 FIND v(dout1_131) AT=520.05n

.meas tran vdout1_132ck510 FIND v(dout1_132) AT=520.05n

.meas tran vdout1_133ck510 FIND v(dout1_133) AT=520.05n

.meas tran vdout1_134ck510 FIND v(dout1_134) AT=520.05n

.meas tran vdout1_135ck510 FIND v(dout1_135) AT=520.05n

.meas tran vdout1_136ck510 FIND v(dout1_136) AT=520.05n

.meas tran vdout1_137ck510 FIND v(dout1_137) AT=520.05n

.meas tran vdout1_138ck510 FIND v(dout1_138) AT=520.05n

.meas tran vdout1_139ck510 FIND v(dout1_139) AT=520.05n

.meas tran vdout1_140ck510 FIND v(dout1_140) AT=520.05n

.meas tran vdout1_141ck510 FIND v(dout1_141) AT=520.05n

.meas tran vdout1_142ck510 FIND v(dout1_142) AT=520.05n

.meas tran vdout1_143ck510 FIND v(dout1_143) AT=520.05n

.meas tran vdout1_144ck510 FIND v(dout1_144) AT=520.05n

.meas tran vdout1_145ck510 FIND v(dout1_145) AT=520.05n

.meas tran vdout1_146ck510 FIND v(dout1_146) AT=520.05n

.meas tran vdout1_147ck510 FIND v(dout1_147) AT=520.05n

.meas tran vdout1_148ck510 FIND v(dout1_148) AT=520.05n

.meas tran vdout1_149ck510 FIND v(dout1_149) AT=520.05n

.meas tran vdout1_150ck510 FIND v(dout1_150) AT=520.05n

.meas tran vdout1_151ck510 FIND v(dout1_151) AT=520.05n

.meas tran vdout1_152ck510 FIND v(dout1_152) AT=520.05n

.meas tran vdout1_153ck510 FIND v(dout1_153) AT=520.05n

.meas tran vdout1_154ck510 FIND v(dout1_154) AT=520.05n

.meas tran vdout1_155ck510 FIND v(dout1_155) AT=520.05n

.meas tran vdout1_156ck510 FIND v(dout1_156) AT=520.05n

.meas tran vdout1_157ck510 FIND v(dout1_157) AT=520.05n

.meas tran vdout1_158ck510 FIND v(dout1_158) AT=520.05n

.meas tran vdout1_159ck510 FIND v(dout1_159) AT=520.05n

.meas tran vdout1_160ck510 FIND v(dout1_160) AT=520.05n

.meas tran vdout1_161ck510 FIND v(dout1_161) AT=520.05n

.meas tran vdout1_162ck510 FIND v(dout1_162) AT=520.05n

.meas tran vdout1_163ck510 FIND v(dout1_163) AT=520.05n

.meas tran vdout1_164ck510 FIND v(dout1_164) AT=520.05n

.meas tran vdout1_165ck510 FIND v(dout1_165) AT=520.05n

.meas tran vdout1_166ck510 FIND v(dout1_166) AT=520.05n

.meas tran vdout1_167ck510 FIND v(dout1_167) AT=520.05n

.meas tran vdout1_168ck510 FIND v(dout1_168) AT=520.05n

.meas tran vdout1_169ck510 FIND v(dout1_169) AT=520.05n

.meas tran vdout1_170ck510 FIND v(dout1_170) AT=520.05n

.meas tran vdout1_171ck510 FIND v(dout1_171) AT=520.05n

.meas tran vdout1_172ck510 FIND v(dout1_172) AT=520.05n

.meas tran vdout1_173ck510 FIND v(dout1_173) AT=520.05n

.meas tran vdout1_174ck510 FIND v(dout1_174) AT=520.05n

.meas tran vdout1_175ck510 FIND v(dout1_175) AT=520.05n

.meas tran vdout1_176ck510 FIND v(dout1_176) AT=520.05n

.meas tran vdout1_177ck510 FIND v(dout1_177) AT=520.05n

.meas tran vdout1_178ck510 FIND v(dout1_178) AT=520.05n

.meas tran vdout1_179ck510 FIND v(dout1_179) AT=520.05n

.meas tran vdout1_180ck510 FIND v(dout1_180) AT=520.05n

.meas tran vdout1_181ck510 FIND v(dout1_181) AT=520.05n

.meas tran vdout1_182ck510 FIND v(dout1_182) AT=520.05n

.meas tran vdout1_183ck510 FIND v(dout1_183) AT=520.05n

.meas tran vdout1_184ck510 FIND v(dout1_184) AT=520.05n

.meas tran vdout1_185ck510 FIND v(dout1_185) AT=520.05n

.meas tran vdout1_186ck510 FIND v(dout1_186) AT=520.05n

.meas tran vdout1_187ck510 FIND v(dout1_187) AT=520.05n

.meas tran vdout1_188ck510 FIND v(dout1_188) AT=520.05n

.meas tran vdout1_189ck510 FIND v(dout1_189) AT=520.05n

.meas tran vdout1_190ck510 FIND v(dout1_190) AT=520.05n

.meas tran vdout1_191ck510 FIND v(dout1_191) AT=520.05n

.meas tran vdout1_192ck510 FIND v(dout1_192) AT=520.05n

.meas tran vdout1_193ck510 FIND v(dout1_193) AT=520.05n

.meas tran vdout1_194ck510 FIND v(dout1_194) AT=520.05n

.meas tran vdout1_195ck510 FIND v(dout1_195) AT=520.05n

.meas tran vdout1_196ck510 FIND v(dout1_196) AT=520.05n

.meas tran vdout1_197ck510 FIND v(dout1_197) AT=520.05n

.meas tran vdout1_198ck510 FIND v(dout1_198) AT=520.05n

.meas tran vdout1_199ck510 FIND v(dout1_199) AT=520.05n

.meas tran vdout1_200ck510 FIND v(dout1_200) AT=520.05n

.meas tran vdout1_201ck510 FIND v(dout1_201) AT=520.05n

.meas tran vdout1_202ck510 FIND v(dout1_202) AT=520.05n

.meas tran vdout1_203ck510 FIND v(dout1_203) AT=520.05n

.meas tran vdout1_204ck510 FIND v(dout1_204) AT=520.05n

.meas tran vdout1_205ck510 FIND v(dout1_205) AT=520.05n

.meas tran vdout1_206ck510 FIND v(dout1_206) AT=520.05n

.meas tran vdout1_207ck510 FIND v(dout1_207) AT=520.05n

.meas tran vdout1_208ck510 FIND v(dout1_208) AT=520.05n

.meas tran vdout1_209ck510 FIND v(dout1_209) AT=520.05n

.meas tran vdout1_210ck510 FIND v(dout1_210) AT=520.05n

.meas tran vdout1_211ck510 FIND v(dout1_211) AT=520.05n

.meas tran vdout1_212ck510 FIND v(dout1_212) AT=520.05n

.meas tran vdout1_213ck510 FIND v(dout1_213) AT=520.05n

.meas tran vdout1_214ck510 FIND v(dout1_214) AT=520.05n

.meas tran vdout1_215ck510 FIND v(dout1_215) AT=520.05n

.meas tran vdout1_216ck510 FIND v(dout1_216) AT=520.05n

.meas tran vdout1_217ck510 FIND v(dout1_217) AT=520.05n

.meas tran vdout1_218ck510 FIND v(dout1_218) AT=520.05n

.meas tran vdout1_219ck510 FIND v(dout1_219) AT=520.05n

.meas tran vdout1_220ck510 FIND v(dout1_220) AT=520.05n

.meas tran vdout1_221ck510 FIND v(dout1_221) AT=520.05n

.meas tran vdout1_222ck510 FIND v(dout1_222) AT=520.05n

.meas tran vdout1_223ck510 FIND v(dout1_223) AT=520.05n

.meas tran vdout1_224ck510 FIND v(dout1_224) AT=520.05n

.meas tran vdout1_225ck510 FIND v(dout1_225) AT=520.05n

.meas tran vdout1_226ck510 FIND v(dout1_226) AT=520.05n

.meas tran vdout1_227ck510 FIND v(dout1_227) AT=520.05n

.meas tran vdout1_228ck510 FIND v(dout1_228) AT=520.05n

.meas tran vdout1_229ck510 FIND v(dout1_229) AT=520.05n

.meas tran vdout1_230ck510 FIND v(dout1_230) AT=520.05n

.meas tran vdout1_231ck510 FIND v(dout1_231) AT=520.05n

.meas tran vdout1_232ck510 FIND v(dout1_232) AT=520.05n

.meas tran vdout1_233ck510 FIND v(dout1_233) AT=520.05n

.meas tran vdout1_234ck510 FIND v(dout1_234) AT=520.05n

.meas tran vdout1_235ck510 FIND v(dout1_235) AT=520.05n

.meas tran vdout1_236ck510 FIND v(dout1_236) AT=520.05n

.meas tran vdout1_237ck510 FIND v(dout1_237) AT=520.05n

.meas tran vdout1_238ck510 FIND v(dout1_238) AT=520.05n

.meas tran vdout1_239ck510 FIND v(dout1_239) AT=520.05n

.meas tran vdout1_240ck510 FIND v(dout1_240) AT=520.05n

.meas tran vdout1_241ck510 FIND v(dout1_241) AT=520.05n

.meas tran vdout1_242ck510 FIND v(dout1_242) AT=520.05n

.meas tran vdout1_243ck510 FIND v(dout1_243) AT=520.05n

.meas tran vdout1_244ck510 FIND v(dout1_244) AT=520.05n

.meas tran vdout1_245ck510 FIND v(dout1_245) AT=520.05n

.meas tran vdout1_246ck510 FIND v(dout1_246) AT=520.05n

.meas tran vdout1_247ck510 FIND v(dout1_247) AT=520.05n

.meas tran vdout1_248ck510 FIND v(dout1_248) AT=520.05n

.meas tran vdout1_249ck510 FIND v(dout1_249) AT=520.05n

.meas tran vdout1_250ck510 FIND v(dout1_250) AT=520.05n

.meas tran vdout1_251ck510 FIND v(dout1_251) AT=520.05n

.meas tran vdout1_252ck510 FIND v(dout1_252) AT=520.05n

.meas tran vdout1_253ck510 FIND v(dout1_253) AT=520.05n

.meas tran vdout1_254ck510 FIND v(dout1_254) AT=520.05n

.meas tran vdout1_255ck510 FIND v(dout1_255) AT=520.05n

.meas tran vdout1_256ck510 FIND v(dout1_256) AT=520.05n

.meas tran vdout1_0ck540 FIND v(dout1_0) AT=550.05n

.meas tran vdout1_1ck540 FIND v(dout1_1) AT=550.05n

.meas tran vdout1_2ck540 FIND v(dout1_2) AT=550.05n

.meas tran vdout1_3ck540 FIND v(dout1_3) AT=550.05n

.meas tran vdout1_4ck540 FIND v(dout1_4) AT=550.05n

.meas tran vdout1_5ck540 FIND v(dout1_5) AT=550.05n

.meas tran vdout1_6ck540 FIND v(dout1_6) AT=550.05n

.meas tran vdout1_7ck540 FIND v(dout1_7) AT=550.05n

.meas tran vdout1_8ck540 FIND v(dout1_8) AT=550.05n

.meas tran vdout1_9ck540 FIND v(dout1_9) AT=550.05n

.meas tran vdout1_10ck540 FIND v(dout1_10) AT=550.05n

.meas tran vdout1_11ck540 FIND v(dout1_11) AT=550.05n

.meas tran vdout1_12ck540 FIND v(dout1_12) AT=550.05n

.meas tran vdout1_13ck540 FIND v(dout1_13) AT=550.05n

.meas tran vdout1_14ck540 FIND v(dout1_14) AT=550.05n

.meas tran vdout1_15ck540 FIND v(dout1_15) AT=550.05n

.meas tran vdout1_16ck540 FIND v(dout1_16) AT=550.05n

.meas tran vdout1_17ck540 FIND v(dout1_17) AT=550.05n

.meas tran vdout1_18ck540 FIND v(dout1_18) AT=550.05n

.meas tran vdout1_19ck540 FIND v(dout1_19) AT=550.05n

.meas tran vdout1_20ck540 FIND v(dout1_20) AT=550.05n

.meas tran vdout1_21ck540 FIND v(dout1_21) AT=550.05n

.meas tran vdout1_22ck540 FIND v(dout1_22) AT=550.05n

.meas tran vdout1_23ck540 FIND v(dout1_23) AT=550.05n

.meas tran vdout1_24ck540 FIND v(dout1_24) AT=550.05n

.meas tran vdout1_25ck540 FIND v(dout1_25) AT=550.05n

.meas tran vdout1_26ck540 FIND v(dout1_26) AT=550.05n

.meas tran vdout1_27ck540 FIND v(dout1_27) AT=550.05n

.meas tran vdout1_28ck540 FIND v(dout1_28) AT=550.05n

.meas tran vdout1_29ck540 FIND v(dout1_29) AT=550.05n

.meas tran vdout1_30ck540 FIND v(dout1_30) AT=550.05n

.meas tran vdout1_31ck540 FIND v(dout1_31) AT=550.05n

.meas tran vdout1_32ck540 FIND v(dout1_32) AT=550.05n

.meas tran vdout1_33ck540 FIND v(dout1_33) AT=550.05n

.meas tran vdout1_34ck540 FIND v(dout1_34) AT=550.05n

.meas tran vdout1_35ck540 FIND v(dout1_35) AT=550.05n

.meas tran vdout1_36ck540 FIND v(dout1_36) AT=550.05n

.meas tran vdout1_37ck540 FIND v(dout1_37) AT=550.05n

.meas tran vdout1_38ck540 FIND v(dout1_38) AT=550.05n

.meas tran vdout1_39ck540 FIND v(dout1_39) AT=550.05n

.meas tran vdout1_40ck540 FIND v(dout1_40) AT=550.05n

.meas tran vdout1_41ck540 FIND v(dout1_41) AT=550.05n

.meas tran vdout1_42ck540 FIND v(dout1_42) AT=550.05n

.meas tran vdout1_43ck540 FIND v(dout1_43) AT=550.05n

.meas tran vdout1_44ck540 FIND v(dout1_44) AT=550.05n

.meas tran vdout1_45ck540 FIND v(dout1_45) AT=550.05n

.meas tran vdout1_46ck540 FIND v(dout1_46) AT=550.05n

.meas tran vdout1_47ck540 FIND v(dout1_47) AT=550.05n

.meas tran vdout1_48ck540 FIND v(dout1_48) AT=550.05n

.meas tran vdout1_49ck540 FIND v(dout1_49) AT=550.05n

.meas tran vdout1_50ck540 FIND v(dout1_50) AT=550.05n

.meas tran vdout1_51ck540 FIND v(dout1_51) AT=550.05n

.meas tran vdout1_52ck540 FIND v(dout1_52) AT=550.05n

.meas tran vdout1_53ck540 FIND v(dout1_53) AT=550.05n

.meas tran vdout1_54ck540 FIND v(dout1_54) AT=550.05n

.meas tran vdout1_55ck540 FIND v(dout1_55) AT=550.05n

.meas tran vdout1_56ck540 FIND v(dout1_56) AT=550.05n

.meas tran vdout1_57ck540 FIND v(dout1_57) AT=550.05n

.meas tran vdout1_58ck540 FIND v(dout1_58) AT=550.05n

.meas tran vdout1_59ck540 FIND v(dout1_59) AT=550.05n

.meas tran vdout1_60ck540 FIND v(dout1_60) AT=550.05n

.meas tran vdout1_61ck540 FIND v(dout1_61) AT=550.05n

.meas tran vdout1_62ck540 FIND v(dout1_62) AT=550.05n

.meas tran vdout1_63ck540 FIND v(dout1_63) AT=550.05n

.meas tran vdout1_64ck540 FIND v(dout1_64) AT=550.05n

.meas tran vdout1_65ck540 FIND v(dout1_65) AT=550.05n

.meas tran vdout1_66ck540 FIND v(dout1_66) AT=550.05n

.meas tran vdout1_67ck540 FIND v(dout1_67) AT=550.05n

.meas tran vdout1_68ck540 FIND v(dout1_68) AT=550.05n

.meas tran vdout1_69ck540 FIND v(dout1_69) AT=550.05n

.meas tran vdout1_70ck540 FIND v(dout1_70) AT=550.05n

.meas tran vdout1_71ck540 FIND v(dout1_71) AT=550.05n

.meas tran vdout1_72ck540 FIND v(dout1_72) AT=550.05n

.meas tran vdout1_73ck540 FIND v(dout1_73) AT=550.05n

.meas tran vdout1_74ck540 FIND v(dout1_74) AT=550.05n

.meas tran vdout1_75ck540 FIND v(dout1_75) AT=550.05n

.meas tran vdout1_76ck540 FIND v(dout1_76) AT=550.05n

.meas tran vdout1_77ck540 FIND v(dout1_77) AT=550.05n

.meas tran vdout1_78ck540 FIND v(dout1_78) AT=550.05n

.meas tran vdout1_79ck540 FIND v(dout1_79) AT=550.05n

.meas tran vdout1_80ck540 FIND v(dout1_80) AT=550.05n

.meas tran vdout1_81ck540 FIND v(dout1_81) AT=550.05n

.meas tran vdout1_82ck540 FIND v(dout1_82) AT=550.05n

.meas tran vdout1_83ck540 FIND v(dout1_83) AT=550.05n

.meas tran vdout1_84ck540 FIND v(dout1_84) AT=550.05n

.meas tran vdout1_85ck540 FIND v(dout1_85) AT=550.05n

.meas tran vdout1_86ck540 FIND v(dout1_86) AT=550.05n

.meas tran vdout1_87ck540 FIND v(dout1_87) AT=550.05n

.meas tran vdout1_88ck540 FIND v(dout1_88) AT=550.05n

.meas tran vdout1_89ck540 FIND v(dout1_89) AT=550.05n

.meas tran vdout1_90ck540 FIND v(dout1_90) AT=550.05n

.meas tran vdout1_91ck540 FIND v(dout1_91) AT=550.05n

.meas tran vdout1_92ck540 FIND v(dout1_92) AT=550.05n

.meas tran vdout1_93ck540 FIND v(dout1_93) AT=550.05n

.meas tran vdout1_94ck540 FIND v(dout1_94) AT=550.05n

.meas tran vdout1_95ck540 FIND v(dout1_95) AT=550.05n

.meas tran vdout1_96ck540 FIND v(dout1_96) AT=550.05n

.meas tran vdout1_97ck540 FIND v(dout1_97) AT=550.05n

.meas tran vdout1_98ck540 FIND v(dout1_98) AT=550.05n

.meas tran vdout1_99ck540 FIND v(dout1_99) AT=550.05n

.meas tran vdout1_100ck540 FIND v(dout1_100) AT=550.05n

.meas tran vdout1_101ck540 FIND v(dout1_101) AT=550.05n

.meas tran vdout1_102ck540 FIND v(dout1_102) AT=550.05n

.meas tran vdout1_103ck540 FIND v(dout1_103) AT=550.05n

.meas tran vdout1_104ck540 FIND v(dout1_104) AT=550.05n

.meas tran vdout1_105ck540 FIND v(dout1_105) AT=550.05n

.meas tran vdout1_106ck540 FIND v(dout1_106) AT=550.05n

.meas tran vdout1_107ck540 FIND v(dout1_107) AT=550.05n

.meas tran vdout1_108ck540 FIND v(dout1_108) AT=550.05n

.meas tran vdout1_109ck540 FIND v(dout1_109) AT=550.05n

.meas tran vdout1_110ck540 FIND v(dout1_110) AT=550.05n

.meas tran vdout1_111ck540 FIND v(dout1_111) AT=550.05n

.meas tran vdout1_112ck540 FIND v(dout1_112) AT=550.05n

.meas tran vdout1_113ck540 FIND v(dout1_113) AT=550.05n

.meas tran vdout1_114ck540 FIND v(dout1_114) AT=550.05n

.meas tran vdout1_115ck540 FIND v(dout1_115) AT=550.05n

.meas tran vdout1_116ck540 FIND v(dout1_116) AT=550.05n

.meas tran vdout1_117ck540 FIND v(dout1_117) AT=550.05n

.meas tran vdout1_118ck540 FIND v(dout1_118) AT=550.05n

.meas tran vdout1_119ck540 FIND v(dout1_119) AT=550.05n

.meas tran vdout1_120ck540 FIND v(dout1_120) AT=550.05n

.meas tran vdout1_121ck540 FIND v(dout1_121) AT=550.05n

.meas tran vdout1_122ck540 FIND v(dout1_122) AT=550.05n

.meas tran vdout1_123ck540 FIND v(dout1_123) AT=550.05n

.meas tran vdout1_124ck540 FIND v(dout1_124) AT=550.05n

.meas tran vdout1_125ck540 FIND v(dout1_125) AT=550.05n

.meas tran vdout1_126ck540 FIND v(dout1_126) AT=550.05n

.meas tran vdout1_127ck540 FIND v(dout1_127) AT=550.05n

.meas tran vdout1_128ck540 FIND v(dout1_128) AT=550.05n

.meas tran vdout1_129ck540 FIND v(dout1_129) AT=550.05n

.meas tran vdout1_130ck540 FIND v(dout1_130) AT=550.05n

.meas tran vdout1_131ck540 FIND v(dout1_131) AT=550.05n

.meas tran vdout1_132ck540 FIND v(dout1_132) AT=550.05n

.meas tran vdout1_133ck540 FIND v(dout1_133) AT=550.05n

.meas tran vdout1_134ck540 FIND v(dout1_134) AT=550.05n

.meas tran vdout1_135ck540 FIND v(dout1_135) AT=550.05n

.meas tran vdout1_136ck540 FIND v(dout1_136) AT=550.05n

.meas tran vdout1_137ck540 FIND v(dout1_137) AT=550.05n

.meas tran vdout1_138ck540 FIND v(dout1_138) AT=550.05n

.meas tran vdout1_139ck540 FIND v(dout1_139) AT=550.05n

.meas tran vdout1_140ck540 FIND v(dout1_140) AT=550.05n

.meas tran vdout1_141ck540 FIND v(dout1_141) AT=550.05n

.meas tran vdout1_142ck540 FIND v(dout1_142) AT=550.05n

.meas tran vdout1_143ck540 FIND v(dout1_143) AT=550.05n

.meas tran vdout1_144ck540 FIND v(dout1_144) AT=550.05n

.meas tran vdout1_145ck540 FIND v(dout1_145) AT=550.05n

.meas tran vdout1_146ck540 FIND v(dout1_146) AT=550.05n

.meas tran vdout1_147ck540 FIND v(dout1_147) AT=550.05n

.meas tran vdout1_148ck540 FIND v(dout1_148) AT=550.05n

.meas tran vdout1_149ck540 FIND v(dout1_149) AT=550.05n

.meas tran vdout1_150ck540 FIND v(dout1_150) AT=550.05n

.meas tran vdout1_151ck540 FIND v(dout1_151) AT=550.05n

.meas tran vdout1_152ck540 FIND v(dout1_152) AT=550.05n

.meas tran vdout1_153ck540 FIND v(dout1_153) AT=550.05n

.meas tran vdout1_154ck540 FIND v(dout1_154) AT=550.05n

.meas tran vdout1_155ck540 FIND v(dout1_155) AT=550.05n

.meas tran vdout1_156ck540 FIND v(dout1_156) AT=550.05n

.meas tran vdout1_157ck540 FIND v(dout1_157) AT=550.05n

.meas tran vdout1_158ck540 FIND v(dout1_158) AT=550.05n

.meas tran vdout1_159ck540 FIND v(dout1_159) AT=550.05n

.meas tran vdout1_160ck540 FIND v(dout1_160) AT=550.05n

.meas tran vdout1_161ck540 FIND v(dout1_161) AT=550.05n

.meas tran vdout1_162ck540 FIND v(dout1_162) AT=550.05n

.meas tran vdout1_163ck540 FIND v(dout1_163) AT=550.05n

.meas tran vdout1_164ck540 FIND v(dout1_164) AT=550.05n

.meas tran vdout1_165ck540 FIND v(dout1_165) AT=550.05n

.meas tran vdout1_166ck540 FIND v(dout1_166) AT=550.05n

.meas tran vdout1_167ck540 FIND v(dout1_167) AT=550.05n

.meas tran vdout1_168ck540 FIND v(dout1_168) AT=550.05n

.meas tran vdout1_169ck540 FIND v(dout1_169) AT=550.05n

.meas tran vdout1_170ck540 FIND v(dout1_170) AT=550.05n

.meas tran vdout1_171ck540 FIND v(dout1_171) AT=550.05n

.meas tran vdout1_172ck540 FIND v(dout1_172) AT=550.05n

.meas tran vdout1_173ck540 FIND v(dout1_173) AT=550.05n

.meas tran vdout1_174ck540 FIND v(dout1_174) AT=550.05n

.meas tran vdout1_175ck540 FIND v(dout1_175) AT=550.05n

.meas tran vdout1_176ck540 FIND v(dout1_176) AT=550.05n

.meas tran vdout1_177ck540 FIND v(dout1_177) AT=550.05n

.meas tran vdout1_178ck540 FIND v(dout1_178) AT=550.05n

.meas tran vdout1_179ck540 FIND v(dout1_179) AT=550.05n

.meas tran vdout1_180ck540 FIND v(dout1_180) AT=550.05n

.meas tran vdout1_181ck540 FIND v(dout1_181) AT=550.05n

.meas tran vdout1_182ck540 FIND v(dout1_182) AT=550.05n

.meas tran vdout1_183ck540 FIND v(dout1_183) AT=550.05n

.meas tran vdout1_184ck540 FIND v(dout1_184) AT=550.05n

.meas tran vdout1_185ck540 FIND v(dout1_185) AT=550.05n

.meas tran vdout1_186ck540 FIND v(dout1_186) AT=550.05n

.meas tran vdout1_187ck540 FIND v(dout1_187) AT=550.05n

.meas tran vdout1_188ck540 FIND v(dout1_188) AT=550.05n

.meas tran vdout1_189ck540 FIND v(dout1_189) AT=550.05n

.meas tran vdout1_190ck540 FIND v(dout1_190) AT=550.05n

.meas tran vdout1_191ck540 FIND v(dout1_191) AT=550.05n

.meas tran vdout1_192ck540 FIND v(dout1_192) AT=550.05n

.meas tran vdout1_193ck540 FIND v(dout1_193) AT=550.05n

.meas tran vdout1_194ck540 FIND v(dout1_194) AT=550.05n

.meas tran vdout1_195ck540 FIND v(dout1_195) AT=550.05n

.meas tran vdout1_196ck540 FIND v(dout1_196) AT=550.05n

.meas tran vdout1_197ck540 FIND v(dout1_197) AT=550.05n

.meas tran vdout1_198ck540 FIND v(dout1_198) AT=550.05n

.meas tran vdout1_199ck540 FIND v(dout1_199) AT=550.05n

.meas tran vdout1_200ck540 FIND v(dout1_200) AT=550.05n

.meas tran vdout1_201ck540 FIND v(dout1_201) AT=550.05n

.meas tran vdout1_202ck540 FIND v(dout1_202) AT=550.05n

.meas tran vdout1_203ck540 FIND v(dout1_203) AT=550.05n

.meas tran vdout1_204ck540 FIND v(dout1_204) AT=550.05n

.meas tran vdout1_205ck540 FIND v(dout1_205) AT=550.05n

.meas tran vdout1_206ck540 FIND v(dout1_206) AT=550.05n

.meas tran vdout1_207ck540 FIND v(dout1_207) AT=550.05n

.meas tran vdout1_208ck540 FIND v(dout1_208) AT=550.05n

.meas tran vdout1_209ck540 FIND v(dout1_209) AT=550.05n

.meas tran vdout1_210ck540 FIND v(dout1_210) AT=550.05n

.meas tran vdout1_211ck540 FIND v(dout1_211) AT=550.05n

.meas tran vdout1_212ck540 FIND v(dout1_212) AT=550.05n

.meas tran vdout1_213ck540 FIND v(dout1_213) AT=550.05n

.meas tran vdout1_214ck540 FIND v(dout1_214) AT=550.05n

.meas tran vdout1_215ck540 FIND v(dout1_215) AT=550.05n

.meas tran vdout1_216ck540 FIND v(dout1_216) AT=550.05n

.meas tran vdout1_217ck540 FIND v(dout1_217) AT=550.05n

.meas tran vdout1_218ck540 FIND v(dout1_218) AT=550.05n

.meas tran vdout1_219ck540 FIND v(dout1_219) AT=550.05n

.meas tran vdout1_220ck540 FIND v(dout1_220) AT=550.05n

.meas tran vdout1_221ck540 FIND v(dout1_221) AT=550.05n

.meas tran vdout1_222ck540 FIND v(dout1_222) AT=550.05n

.meas tran vdout1_223ck540 FIND v(dout1_223) AT=550.05n

.meas tran vdout1_224ck540 FIND v(dout1_224) AT=550.05n

.meas tran vdout1_225ck540 FIND v(dout1_225) AT=550.05n

.meas tran vdout1_226ck540 FIND v(dout1_226) AT=550.05n

.meas tran vdout1_227ck540 FIND v(dout1_227) AT=550.05n

.meas tran vdout1_228ck540 FIND v(dout1_228) AT=550.05n

.meas tran vdout1_229ck540 FIND v(dout1_229) AT=550.05n

.meas tran vdout1_230ck540 FIND v(dout1_230) AT=550.05n

.meas tran vdout1_231ck540 FIND v(dout1_231) AT=550.05n

.meas tran vdout1_232ck540 FIND v(dout1_232) AT=550.05n

.meas tran vdout1_233ck540 FIND v(dout1_233) AT=550.05n

.meas tran vdout1_234ck540 FIND v(dout1_234) AT=550.05n

.meas tran vdout1_235ck540 FIND v(dout1_235) AT=550.05n

.meas tran vdout1_236ck540 FIND v(dout1_236) AT=550.05n

.meas tran vdout1_237ck540 FIND v(dout1_237) AT=550.05n

.meas tran vdout1_238ck540 FIND v(dout1_238) AT=550.05n

.meas tran vdout1_239ck540 FIND v(dout1_239) AT=550.05n

.meas tran vdout1_240ck540 FIND v(dout1_240) AT=550.05n

.meas tran vdout1_241ck540 FIND v(dout1_241) AT=550.05n

.meas tran vdout1_242ck540 FIND v(dout1_242) AT=550.05n

.meas tran vdout1_243ck540 FIND v(dout1_243) AT=550.05n

.meas tran vdout1_244ck540 FIND v(dout1_244) AT=550.05n

.meas tran vdout1_245ck540 FIND v(dout1_245) AT=550.05n

.meas tran vdout1_246ck540 FIND v(dout1_246) AT=550.05n

.meas tran vdout1_247ck540 FIND v(dout1_247) AT=550.05n

.meas tran vdout1_248ck540 FIND v(dout1_248) AT=550.05n

.meas tran vdout1_249ck540 FIND v(dout1_249) AT=550.05n

.meas tran vdout1_250ck540 FIND v(dout1_250) AT=550.05n

.meas tran vdout1_251ck540 FIND v(dout1_251) AT=550.05n

.meas tran vdout1_252ck540 FIND v(dout1_252) AT=550.05n

.meas tran vdout1_253ck540 FIND v(dout1_253) AT=550.05n

.meas tran vdout1_254ck540 FIND v(dout1_254) AT=550.05n

.meas tran vdout1_255ck540 FIND v(dout1_255) AT=550.05n

.meas tran vdout1_256ck540 FIND v(dout1_256) AT=550.05n

.meas tran vdout1_0ck570 FIND v(dout1_0) AT=580.05n

.meas tran vdout1_1ck570 FIND v(dout1_1) AT=580.05n

.meas tran vdout1_2ck570 FIND v(dout1_2) AT=580.05n

.meas tran vdout1_3ck570 FIND v(dout1_3) AT=580.05n

.meas tran vdout1_4ck570 FIND v(dout1_4) AT=580.05n

.meas tran vdout1_5ck570 FIND v(dout1_5) AT=580.05n

.meas tran vdout1_6ck570 FIND v(dout1_6) AT=580.05n

.meas tran vdout1_7ck570 FIND v(dout1_7) AT=580.05n

.meas tran vdout1_8ck570 FIND v(dout1_8) AT=580.05n

.meas tran vdout1_9ck570 FIND v(dout1_9) AT=580.05n

.meas tran vdout1_10ck570 FIND v(dout1_10) AT=580.05n

.meas tran vdout1_11ck570 FIND v(dout1_11) AT=580.05n

.meas tran vdout1_12ck570 FIND v(dout1_12) AT=580.05n

.meas tran vdout1_13ck570 FIND v(dout1_13) AT=580.05n

.meas tran vdout1_14ck570 FIND v(dout1_14) AT=580.05n

.meas tran vdout1_15ck570 FIND v(dout1_15) AT=580.05n

.meas tran vdout1_16ck570 FIND v(dout1_16) AT=580.05n

.meas tran vdout1_17ck570 FIND v(dout1_17) AT=580.05n

.meas tran vdout1_18ck570 FIND v(dout1_18) AT=580.05n

.meas tran vdout1_19ck570 FIND v(dout1_19) AT=580.05n

.meas tran vdout1_20ck570 FIND v(dout1_20) AT=580.05n

.meas tran vdout1_21ck570 FIND v(dout1_21) AT=580.05n

.meas tran vdout1_22ck570 FIND v(dout1_22) AT=580.05n

.meas tran vdout1_23ck570 FIND v(dout1_23) AT=580.05n

.meas tran vdout1_24ck570 FIND v(dout1_24) AT=580.05n

.meas tran vdout1_25ck570 FIND v(dout1_25) AT=580.05n

.meas tran vdout1_26ck570 FIND v(dout1_26) AT=580.05n

.meas tran vdout1_27ck570 FIND v(dout1_27) AT=580.05n

.meas tran vdout1_28ck570 FIND v(dout1_28) AT=580.05n

.meas tran vdout1_29ck570 FIND v(dout1_29) AT=580.05n

.meas tran vdout1_30ck570 FIND v(dout1_30) AT=580.05n

.meas tran vdout1_31ck570 FIND v(dout1_31) AT=580.05n

.meas tran vdout1_32ck570 FIND v(dout1_32) AT=580.05n

.meas tran vdout1_33ck570 FIND v(dout1_33) AT=580.05n

.meas tran vdout1_34ck570 FIND v(dout1_34) AT=580.05n

.meas tran vdout1_35ck570 FIND v(dout1_35) AT=580.05n

.meas tran vdout1_36ck570 FIND v(dout1_36) AT=580.05n

.meas tran vdout1_37ck570 FIND v(dout1_37) AT=580.05n

.meas tran vdout1_38ck570 FIND v(dout1_38) AT=580.05n

.meas tran vdout1_39ck570 FIND v(dout1_39) AT=580.05n

.meas tran vdout1_40ck570 FIND v(dout1_40) AT=580.05n

.meas tran vdout1_41ck570 FIND v(dout1_41) AT=580.05n

.meas tran vdout1_42ck570 FIND v(dout1_42) AT=580.05n

.meas tran vdout1_43ck570 FIND v(dout1_43) AT=580.05n

.meas tran vdout1_44ck570 FIND v(dout1_44) AT=580.05n

.meas tran vdout1_45ck570 FIND v(dout1_45) AT=580.05n

.meas tran vdout1_46ck570 FIND v(dout1_46) AT=580.05n

.meas tran vdout1_47ck570 FIND v(dout1_47) AT=580.05n

.meas tran vdout1_48ck570 FIND v(dout1_48) AT=580.05n

.meas tran vdout1_49ck570 FIND v(dout1_49) AT=580.05n

.meas tran vdout1_50ck570 FIND v(dout1_50) AT=580.05n

.meas tran vdout1_51ck570 FIND v(dout1_51) AT=580.05n

.meas tran vdout1_52ck570 FIND v(dout1_52) AT=580.05n

.meas tran vdout1_53ck570 FIND v(dout1_53) AT=580.05n

.meas tran vdout1_54ck570 FIND v(dout1_54) AT=580.05n

.meas tran vdout1_55ck570 FIND v(dout1_55) AT=580.05n

.meas tran vdout1_56ck570 FIND v(dout1_56) AT=580.05n

.meas tran vdout1_57ck570 FIND v(dout1_57) AT=580.05n

.meas tran vdout1_58ck570 FIND v(dout1_58) AT=580.05n

.meas tran vdout1_59ck570 FIND v(dout1_59) AT=580.05n

.meas tran vdout1_60ck570 FIND v(dout1_60) AT=580.05n

.meas tran vdout1_61ck570 FIND v(dout1_61) AT=580.05n

.meas tran vdout1_62ck570 FIND v(dout1_62) AT=580.05n

.meas tran vdout1_63ck570 FIND v(dout1_63) AT=580.05n

.meas tran vdout1_64ck570 FIND v(dout1_64) AT=580.05n

.meas tran vdout1_65ck570 FIND v(dout1_65) AT=580.05n

.meas tran vdout1_66ck570 FIND v(dout1_66) AT=580.05n

.meas tran vdout1_67ck570 FIND v(dout1_67) AT=580.05n

.meas tran vdout1_68ck570 FIND v(dout1_68) AT=580.05n

.meas tran vdout1_69ck570 FIND v(dout1_69) AT=580.05n

.meas tran vdout1_70ck570 FIND v(dout1_70) AT=580.05n

.meas tran vdout1_71ck570 FIND v(dout1_71) AT=580.05n

.meas tran vdout1_72ck570 FIND v(dout1_72) AT=580.05n

.meas tran vdout1_73ck570 FIND v(dout1_73) AT=580.05n

.meas tran vdout1_74ck570 FIND v(dout1_74) AT=580.05n

.meas tran vdout1_75ck570 FIND v(dout1_75) AT=580.05n

.meas tran vdout1_76ck570 FIND v(dout1_76) AT=580.05n

.meas tran vdout1_77ck570 FIND v(dout1_77) AT=580.05n

.meas tran vdout1_78ck570 FIND v(dout1_78) AT=580.05n

.meas tran vdout1_79ck570 FIND v(dout1_79) AT=580.05n

.meas tran vdout1_80ck570 FIND v(dout1_80) AT=580.05n

.meas tran vdout1_81ck570 FIND v(dout1_81) AT=580.05n

.meas tran vdout1_82ck570 FIND v(dout1_82) AT=580.05n

.meas tran vdout1_83ck570 FIND v(dout1_83) AT=580.05n

.meas tran vdout1_84ck570 FIND v(dout1_84) AT=580.05n

.meas tran vdout1_85ck570 FIND v(dout1_85) AT=580.05n

.meas tran vdout1_86ck570 FIND v(dout1_86) AT=580.05n

.meas tran vdout1_87ck570 FIND v(dout1_87) AT=580.05n

.meas tran vdout1_88ck570 FIND v(dout1_88) AT=580.05n

.meas tran vdout1_89ck570 FIND v(dout1_89) AT=580.05n

.meas tran vdout1_90ck570 FIND v(dout1_90) AT=580.05n

.meas tran vdout1_91ck570 FIND v(dout1_91) AT=580.05n

.meas tran vdout1_92ck570 FIND v(dout1_92) AT=580.05n

.meas tran vdout1_93ck570 FIND v(dout1_93) AT=580.05n

.meas tran vdout1_94ck570 FIND v(dout1_94) AT=580.05n

.meas tran vdout1_95ck570 FIND v(dout1_95) AT=580.05n

.meas tran vdout1_96ck570 FIND v(dout1_96) AT=580.05n

.meas tran vdout1_97ck570 FIND v(dout1_97) AT=580.05n

.meas tran vdout1_98ck570 FIND v(dout1_98) AT=580.05n

.meas tran vdout1_99ck570 FIND v(dout1_99) AT=580.05n

.meas tran vdout1_100ck570 FIND v(dout1_100) AT=580.05n

.meas tran vdout1_101ck570 FIND v(dout1_101) AT=580.05n

.meas tran vdout1_102ck570 FIND v(dout1_102) AT=580.05n

.meas tran vdout1_103ck570 FIND v(dout1_103) AT=580.05n

.meas tran vdout1_104ck570 FIND v(dout1_104) AT=580.05n

.meas tran vdout1_105ck570 FIND v(dout1_105) AT=580.05n

.meas tran vdout1_106ck570 FIND v(dout1_106) AT=580.05n

.meas tran vdout1_107ck570 FIND v(dout1_107) AT=580.05n

.meas tran vdout1_108ck570 FIND v(dout1_108) AT=580.05n

.meas tran vdout1_109ck570 FIND v(dout1_109) AT=580.05n

.meas tran vdout1_110ck570 FIND v(dout1_110) AT=580.05n

.meas tran vdout1_111ck570 FIND v(dout1_111) AT=580.05n

.meas tran vdout1_112ck570 FIND v(dout1_112) AT=580.05n

.meas tran vdout1_113ck570 FIND v(dout1_113) AT=580.05n

.meas tran vdout1_114ck570 FIND v(dout1_114) AT=580.05n

.meas tran vdout1_115ck570 FIND v(dout1_115) AT=580.05n

.meas tran vdout1_116ck570 FIND v(dout1_116) AT=580.05n

.meas tran vdout1_117ck570 FIND v(dout1_117) AT=580.05n

.meas tran vdout1_118ck570 FIND v(dout1_118) AT=580.05n

.meas tran vdout1_119ck570 FIND v(dout1_119) AT=580.05n

.meas tran vdout1_120ck570 FIND v(dout1_120) AT=580.05n

.meas tran vdout1_121ck570 FIND v(dout1_121) AT=580.05n

.meas tran vdout1_122ck570 FIND v(dout1_122) AT=580.05n

.meas tran vdout1_123ck570 FIND v(dout1_123) AT=580.05n

.meas tran vdout1_124ck570 FIND v(dout1_124) AT=580.05n

.meas tran vdout1_125ck570 FIND v(dout1_125) AT=580.05n

.meas tran vdout1_126ck570 FIND v(dout1_126) AT=580.05n

.meas tran vdout1_127ck570 FIND v(dout1_127) AT=580.05n

.meas tran vdout1_128ck570 FIND v(dout1_128) AT=580.05n

.meas tran vdout1_129ck570 FIND v(dout1_129) AT=580.05n

.meas tran vdout1_130ck570 FIND v(dout1_130) AT=580.05n

.meas tran vdout1_131ck570 FIND v(dout1_131) AT=580.05n

.meas tran vdout1_132ck570 FIND v(dout1_132) AT=580.05n

.meas tran vdout1_133ck570 FIND v(dout1_133) AT=580.05n

.meas tran vdout1_134ck570 FIND v(dout1_134) AT=580.05n

.meas tran vdout1_135ck570 FIND v(dout1_135) AT=580.05n

.meas tran vdout1_136ck570 FIND v(dout1_136) AT=580.05n

.meas tran vdout1_137ck570 FIND v(dout1_137) AT=580.05n

.meas tran vdout1_138ck570 FIND v(dout1_138) AT=580.05n

.meas tran vdout1_139ck570 FIND v(dout1_139) AT=580.05n

.meas tran vdout1_140ck570 FIND v(dout1_140) AT=580.05n

.meas tran vdout1_141ck570 FIND v(dout1_141) AT=580.05n

.meas tran vdout1_142ck570 FIND v(dout1_142) AT=580.05n

.meas tran vdout1_143ck570 FIND v(dout1_143) AT=580.05n

.meas tran vdout1_144ck570 FIND v(dout1_144) AT=580.05n

.meas tran vdout1_145ck570 FIND v(dout1_145) AT=580.05n

.meas tran vdout1_146ck570 FIND v(dout1_146) AT=580.05n

.meas tran vdout1_147ck570 FIND v(dout1_147) AT=580.05n

.meas tran vdout1_148ck570 FIND v(dout1_148) AT=580.05n

.meas tran vdout1_149ck570 FIND v(dout1_149) AT=580.05n

.meas tran vdout1_150ck570 FIND v(dout1_150) AT=580.05n

.meas tran vdout1_151ck570 FIND v(dout1_151) AT=580.05n

.meas tran vdout1_152ck570 FIND v(dout1_152) AT=580.05n

.meas tran vdout1_153ck570 FIND v(dout1_153) AT=580.05n

.meas tran vdout1_154ck570 FIND v(dout1_154) AT=580.05n

.meas tran vdout1_155ck570 FIND v(dout1_155) AT=580.05n

.meas tran vdout1_156ck570 FIND v(dout1_156) AT=580.05n

.meas tran vdout1_157ck570 FIND v(dout1_157) AT=580.05n

.meas tran vdout1_158ck570 FIND v(dout1_158) AT=580.05n

.meas tran vdout1_159ck570 FIND v(dout1_159) AT=580.05n

.meas tran vdout1_160ck570 FIND v(dout1_160) AT=580.05n

.meas tran vdout1_161ck570 FIND v(dout1_161) AT=580.05n

.meas tran vdout1_162ck570 FIND v(dout1_162) AT=580.05n

.meas tran vdout1_163ck570 FIND v(dout1_163) AT=580.05n

.meas tran vdout1_164ck570 FIND v(dout1_164) AT=580.05n

.meas tran vdout1_165ck570 FIND v(dout1_165) AT=580.05n

.meas tran vdout1_166ck570 FIND v(dout1_166) AT=580.05n

.meas tran vdout1_167ck570 FIND v(dout1_167) AT=580.05n

.meas tran vdout1_168ck570 FIND v(dout1_168) AT=580.05n

.meas tran vdout1_169ck570 FIND v(dout1_169) AT=580.05n

.meas tran vdout1_170ck570 FIND v(dout1_170) AT=580.05n

.meas tran vdout1_171ck570 FIND v(dout1_171) AT=580.05n

.meas tran vdout1_172ck570 FIND v(dout1_172) AT=580.05n

.meas tran vdout1_173ck570 FIND v(dout1_173) AT=580.05n

.meas tran vdout1_174ck570 FIND v(dout1_174) AT=580.05n

.meas tran vdout1_175ck570 FIND v(dout1_175) AT=580.05n

.meas tran vdout1_176ck570 FIND v(dout1_176) AT=580.05n

.meas tran vdout1_177ck570 FIND v(dout1_177) AT=580.05n

.meas tran vdout1_178ck570 FIND v(dout1_178) AT=580.05n

.meas tran vdout1_179ck570 FIND v(dout1_179) AT=580.05n

.meas tran vdout1_180ck570 FIND v(dout1_180) AT=580.05n

.meas tran vdout1_181ck570 FIND v(dout1_181) AT=580.05n

.meas tran vdout1_182ck570 FIND v(dout1_182) AT=580.05n

.meas tran vdout1_183ck570 FIND v(dout1_183) AT=580.05n

.meas tran vdout1_184ck570 FIND v(dout1_184) AT=580.05n

.meas tran vdout1_185ck570 FIND v(dout1_185) AT=580.05n

.meas tran vdout1_186ck570 FIND v(dout1_186) AT=580.05n

.meas tran vdout1_187ck570 FIND v(dout1_187) AT=580.05n

.meas tran vdout1_188ck570 FIND v(dout1_188) AT=580.05n

.meas tran vdout1_189ck570 FIND v(dout1_189) AT=580.05n

.meas tran vdout1_190ck570 FIND v(dout1_190) AT=580.05n

.meas tran vdout1_191ck570 FIND v(dout1_191) AT=580.05n

.meas tran vdout1_192ck570 FIND v(dout1_192) AT=580.05n

.meas tran vdout1_193ck570 FIND v(dout1_193) AT=580.05n

.meas tran vdout1_194ck570 FIND v(dout1_194) AT=580.05n

.meas tran vdout1_195ck570 FIND v(dout1_195) AT=580.05n

.meas tran vdout1_196ck570 FIND v(dout1_196) AT=580.05n

.meas tran vdout1_197ck570 FIND v(dout1_197) AT=580.05n

.meas tran vdout1_198ck570 FIND v(dout1_198) AT=580.05n

.meas tran vdout1_199ck570 FIND v(dout1_199) AT=580.05n

.meas tran vdout1_200ck570 FIND v(dout1_200) AT=580.05n

.meas tran vdout1_201ck570 FIND v(dout1_201) AT=580.05n

.meas tran vdout1_202ck570 FIND v(dout1_202) AT=580.05n

.meas tran vdout1_203ck570 FIND v(dout1_203) AT=580.05n

.meas tran vdout1_204ck570 FIND v(dout1_204) AT=580.05n

.meas tran vdout1_205ck570 FIND v(dout1_205) AT=580.05n

.meas tran vdout1_206ck570 FIND v(dout1_206) AT=580.05n

.meas tran vdout1_207ck570 FIND v(dout1_207) AT=580.05n

.meas tran vdout1_208ck570 FIND v(dout1_208) AT=580.05n

.meas tran vdout1_209ck570 FIND v(dout1_209) AT=580.05n

.meas tran vdout1_210ck570 FIND v(dout1_210) AT=580.05n

.meas tran vdout1_211ck570 FIND v(dout1_211) AT=580.05n

.meas tran vdout1_212ck570 FIND v(dout1_212) AT=580.05n

.meas tran vdout1_213ck570 FIND v(dout1_213) AT=580.05n

.meas tran vdout1_214ck570 FIND v(dout1_214) AT=580.05n

.meas tran vdout1_215ck570 FIND v(dout1_215) AT=580.05n

.meas tran vdout1_216ck570 FIND v(dout1_216) AT=580.05n

.meas tran vdout1_217ck570 FIND v(dout1_217) AT=580.05n

.meas tran vdout1_218ck570 FIND v(dout1_218) AT=580.05n

.meas tran vdout1_219ck570 FIND v(dout1_219) AT=580.05n

.meas tran vdout1_220ck570 FIND v(dout1_220) AT=580.05n

.meas tran vdout1_221ck570 FIND v(dout1_221) AT=580.05n

.meas tran vdout1_222ck570 FIND v(dout1_222) AT=580.05n

.meas tran vdout1_223ck570 FIND v(dout1_223) AT=580.05n

.meas tran vdout1_224ck570 FIND v(dout1_224) AT=580.05n

.meas tran vdout1_225ck570 FIND v(dout1_225) AT=580.05n

.meas tran vdout1_226ck570 FIND v(dout1_226) AT=580.05n

.meas tran vdout1_227ck570 FIND v(dout1_227) AT=580.05n

.meas tran vdout1_228ck570 FIND v(dout1_228) AT=580.05n

.meas tran vdout1_229ck570 FIND v(dout1_229) AT=580.05n

.meas tran vdout1_230ck570 FIND v(dout1_230) AT=580.05n

.meas tran vdout1_231ck570 FIND v(dout1_231) AT=580.05n

.meas tran vdout1_232ck570 FIND v(dout1_232) AT=580.05n

.meas tran vdout1_233ck570 FIND v(dout1_233) AT=580.05n

.meas tran vdout1_234ck570 FIND v(dout1_234) AT=580.05n

.meas tran vdout1_235ck570 FIND v(dout1_235) AT=580.05n

.meas tran vdout1_236ck570 FIND v(dout1_236) AT=580.05n

.meas tran vdout1_237ck570 FIND v(dout1_237) AT=580.05n

.meas tran vdout1_238ck570 FIND v(dout1_238) AT=580.05n

.meas tran vdout1_239ck570 FIND v(dout1_239) AT=580.05n

.meas tran vdout1_240ck570 FIND v(dout1_240) AT=580.05n

.meas tran vdout1_241ck570 FIND v(dout1_241) AT=580.05n

.meas tran vdout1_242ck570 FIND v(dout1_242) AT=580.05n

.meas tran vdout1_243ck570 FIND v(dout1_243) AT=580.05n

.meas tran vdout1_244ck570 FIND v(dout1_244) AT=580.05n

.meas tran vdout1_245ck570 FIND v(dout1_245) AT=580.05n

.meas tran vdout1_246ck570 FIND v(dout1_246) AT=580.05n

.meas tran vdout1_247ck570 FIND v(dout1_247) AT=580.05n

.meas tran vdout1_248ck570 FIND v(dout1_248) AT=580.05n

.meas tran vdout1_249ck570 FIND v(dout1_249) AT=580.05n

.meas tran vdout1_250ck570 FIND v(dout1_250) AT=580.05n

.meas tran vdout1_251ck570 FIND v(dout1_251) AT=580.05n

.meas tran vdout1_252ck570 FIND v(dout1_252) AT=580.05n

.meas tran vdout1_253ck570 FIND v(dout1_253) AT=580.05n

.meas tran vdout1_254ck570 FIND v(dout1_254) AT=580.05n

.meas tran vdout1_255ck570 FIND v(dout1_255) AT=580.05n

.meas tran vdout1_256ck570 FIND v(dout1_256) AT=580.05n

.meas tran vdout1_0ck610 FIND v(dout1_0) AT=620.05n

.meas tran vdout1_1ck610 FIND v(dout1_1) AT=620.05n

.meas tran vdout1_2ck610 FIND v(dout1_2) AT=620.05n

.meas tran vdout1_3ck610 FIND v(dout1_3) AT=620.05n

.meas tran vdout1_4ck610 FIND v(dout1_4) AT=620.05n

.meas tran vdout1_5ck610 FIND v(dout1_5) AT=620.05n

.meas tran vdout1_6ck610 FIND v(dout1_6) AT=620.05n

.meas tran vdout1_7ck610 FIND v(dout1_7) AT=620.05n

.meas tran vdout1_8ck610 FIND v(dout1_8) AT=620.05n

.meas tran vdout1_9ck610 FIND v(dout1_9) AT=620.05n

.meas tran vdout1_10ck610 FIND v(dout1_10) AT=620.05n

.meas tran vdout1_11ck610 FIND v(dout1_11) AT=620.05n

.meas tran vdout1_12ck610 FIND v(dout1_12) AT=620.05n

.meas tran vdout1_13ck610 FIND v(dout1_13) AT=620.05n

.meas tran vdout1_14ck610 FIND v(dout1_14) AT=620.05n

.meas tran vdout1_15ck610 FIND v(dout1_15) AT=620.05n

.meas tran vdout1_16ck610 FIND v(dout1_16) AT=620.05n

.meas tran vdout1_17ck610 FIND v(dout1_17) AT=620.05n

.meas tran vdout1_18ck610 FIND v(dout1_18) AT=620.05n

.meas tran vdout1_19ck610 FIND v(dout1_19) AT=620.05n

.meas tran vdout1_20ck610 FIND v(dout1_20) AT=620.05n

.meas tran vdout1_21ck610 FIND v(dout1_21) AT=620.05n

.meas tran vdout1_22ck610 FIND v(dout1_22) AT=620.05n

.meas tran vdout1_23ck610 FIND v(dout1_23) AT=620.05n

.meas tran vdout1_24ck610 FIND v(dout1_24) AT=620.05n

.meas tran vdout1_25ck610 FIND v(dout1_25) AT=620.05n

.meas tran vdout1_26ck610 FIND v(dout1_26) AT=620.05n

.meas tran vdout1_27ck610 FIND v(dout1_27) AT=620.05n

.meas tran vdout1_28ck610 FIND v(dout1_28) AT=620.05n

.meas tran vdout1_29ck610 FIND v(dout1_29) AT=620.05n

.meas tran vdout1_30ck610 FIND v(dout1_30) AT=620.05n

.meas tran vdout1_31ck610 FIND v(dout1_31) AT=620.05n

.meas tran vdout1_32ck610 FIND v(dout1_32) AT=620.05n

.meas tran vdout1_33ck610 FIND v(dout1_33) AT=620.05n

.meas tran vdout1_34ck610 FIND v(dout1_34) AT=620.05n

.meas tran vdout1_35ck610 FIND v(dout1_35) AT=620.05n

.meas tran vdout1_36ck610 FIND v(dout1_36) AT=620.05n

.meas tran vdout1_37ck610 FIND v(dout1_37) AT=620.05n

.meas tran vdout1_38ck610 FIND v(dout1_38) AT=620.05n

.meas tran vdout1_39ck610 FIND v(dout1_39) AT=620.05n

.meas tran vdout1_40ck610 FIND v(dout1_40) AT=620.05n

.meas tran vdout1_41ck610 FIND v(dout1_41) AT=620.05n

.meas tran vdout1_42ck610 FIND v(dout1_42) AT=620.05n

.meas tran vdout1_43ck610 FIND v(dout1_43) AT=620.05n

.meas tran vdout1_44ck610 FIND v(dout1_44) AT=620.05n

.meas tran vdout1_45ck610 FIND v(dout1_45) AT=620.05n

.meas tran vdout1_46ck610 FIND v(dout1_46) AT=620.05n

.meas tran vdout1_47ck610 FIND v(dout1_47) AT=620.05n

.meas tran vdout1_48ck610 FIND v(dout1_48) AT=620.05n

.meas tran vdout1_49ck610 FIND v(dout1_49) AT=620.05n

.meas tran vdout1_50ck610 FIND v(dout1_50) AT=620.05n

.meas tran vdout1_51ck610 FIND v(dout1_51) AT=620.05n

.meas tran vdout1_52ck610 FIND v(dout1_52) AT=620.05n

.meas tran vdout1_53ck610 FIND v(dout1_53) AT=620.05n

.meas tran vdout1_54ck610 FIND v(dout1_54) AT=620.05n

.meas tran vdout1_55ck610 FIND v(dout1_55) AT=620.05n

.meas tran vdout1_56ck610 FIND v(dout1_56) AT=620.05n

.meas tran vdout1_57ck610 FIND v(dout1_57) AT=620.05n

.meas tran vdout1_58ck610 FIND v(dout1_58) AT=620.05n

.meas tran vdout1_59ck610 FIND v(dout1_59) AT=620.05n

.meas tran vdout1_60ck610 FIND v(dout1_60) AT=620.05n

.meas tran vdout1_61ck610 FIND v(dout1_61) AT=620.05n

.meas tran vdout1_62ck610 FIND v(dout1_62) AT=620.05n

.meas tran vdout1_63ck610 FIND v(dout1_63) AT=620.05n

.meas tran vdout1_64ck610 FIND v(dout1_64) AT=620.05n

.meas tran vdout1_65ck610 FIND v(dout1_65) AT=620.05n

.meas tran vdout1_66ck610 FIND v(dout1_66) AT=620.05n

.meas tran vdout1_67ck610 FIND v(dout1_67) AT=620.05n

.meas tran vdout1_68ck610 FIND v(dout1_68) AT=620.05n

.meas tran vdout1_69ck610 FIND v(dout1_69) AT=620.05n

.meas tran vdout1_70ck610 FIND v(dout1_70) AT=620.05n

.meas tran vdout1_71ck610 FIND v(dout1_71) AT=620.05n

.meas tran vdout1_72ck610 FIND v(dout1_72) AT=620.05n

.meas tran vdout1_73ck610 FIND v(dout1_73) AT=620.05n

.meas tran vdout1_74ck610 FIND v(dout1_74) AT=620.05n

.meas tran vdout1_75ck610 FIND v(dout1_75) AT=620.05n

.meas tran vdout1_76ck610 FIND v(dout1_76) AT=620.05n

.meas tran vdout1_77ck610 FIND v(dout1_77) AT=620.05n

.meas tran vdout1_78ck610 FIND v(dout1_78) AT=620.05n

.meas tran vdout1_79ck610 FIND v(dout1_79) AT=620.05n

.meas tran vdout1_80ck610 FIND v(dout1_80) AT=620.05n

.meas tran vdout1_81ck610 FIND v(dout1_81) AT=620.05n

.meas tran vdout1_82ck610 FIND v(dout1_82) AT=620.05n

.meas tran vdout1_83ck610 FIND v(dout1_83) AT=620.05n

.meas tran vdout1_84ck610 FIND v(dout1_84) AT=620.05n

.meas tran vdout1_85ck610 FIND v(dout1_85) AT=620.05n

.meas tran vdout1_86ck610 FIND v(dout1_86) AT=620.05n

.meas tran vdout1_87ck610 FIND v(dout1_87) AT=620.05n

.meas tran vdout1_88ck610 FIND v(dout1_88) AT=620.05n

.meas tran vdout1_89ck610 FIND v(dout1_89) AT=620.05n

.meas tran vdout1_90ck610 FIND v(dout1_90) AT=620.05n

.meas tran vdout1_91ck610 FIND v(dout1_91) AT=620.05n

.meas tran vdout1_92ck610 FIND v(dout1_92) AT=620.05n

.meas tran vdout1_93ck610 FIND v(dout1_93) AT=620.05n

.meas tran vdout1_94ck610 FIND v(dout1_94) AT=620.05n

.meas tran vdout1_95ck610 FIND v(dout1_95) AT=620.05n

.meas tran vdout1_96ck610 FIND v(dout1_96) AT=620.05n

.meas tran vdout1_97ck610 FIND v(dout1_97) AT=620.05n

.meas tran vdout1_98ck610 FIND v(dout1_98) AT=620.05n

.meas tran vdout1_99ck610 FIND v(dout1_99) AT=620.05n

.meas tran vdout1_100ck610 FIND v(dout1_100) AT=620.05n

.meas tran vdout1_101ck610 FIND v(dout1_101) AT=620.05n

.meas tran vdout1_102ck610 FIND v(dout1_102) AT=620.05n

.meas tran vdout1_103ck610 FIND v(dout1_103) AT=620.05n

.meas tran vdout1_104ck610 FIND v(dout1_104) AT=620.05n

.meas tran vdout1_105ck610 FIND v(dout1_105) AT=620.05n

.meas tran vdout1_106ck610 FIND v(dout1_106) AT=620.05n

.meas tran vdout1_107ck610 FIND v(dout1_107) AT=620.05n

.meas tran vdout1_108ck610 FIND v(dout1_108) AT=620.05n

.meas tran vdout1_109ck610 FIND v(dout1_109) AT=620.05n

.meas tran vdout1_110ck610 FIND v(dout1_110) AT=620.05n

.meas tran vdout1_111ck610 FIND v(dout1_111) AT=620.05n

.meas tran vdout1_112ck610 FIND v(dout1_112) AT=620.05n

.meas tran vdout1_113ck610 FIND v(dout1_113) AT=620.05n

.meas tran vdout1_114ck610 FIND v(dout1_114) AT=620.05n

.meas tran vdout1_115ck610 FIND v(dout1_115) AT=620.05n

.meas tran vdout1_116ck610 FIND v(dout1_116) AT=620.05n

.meas tran vdout1_117ck610 FIND v(dout1_117) AT=620.05n

.meas tran vdout1_118ck610 FIND v(dout1_118) AT=620.05n

.meas tran vdout1_119ck610 FIND v(dout1_119) AT=620.05n

.meas tran vdout1_120ck610 FIND v(dout1_120) AT=620.05n

.meas tran vdout1_121ck610 FIND v(dout1_121) AT=620.05n

.meas tran vdout1_122ck610 FIND v(dout1_122) AT=620.05n

.meas tran vdout1_123ck610 FIND v(dout1_123) AT=620.05n

.meas tran vdout1_124ck610 FIND v(dout1_124) AT=620.05n

.meas tran vdout1_125ck610 FIND v(dout1_125) AT=620.05n

.meas tran vdout1_126ck610 FIND v(dout1_126) AT=620.05n

.meas tran vdout1_127ck610 FIND v(dout1_127) AT=620.05n

.meas tran vdout1_128ck610 FIND v(dout1_128) AT=620.05n

.meas tran vdout1_129ck610 FIND v(dout1_129) AT=620.05n

.meas tran vdout1_130ck610 FIND v(dout1_130) AT=620.05n

.meas tran vdout1_131ck610 FIND v(dout1_131) AT=620.05n

.meas tran vdout1_132ck610 FIND v(dout1_132) AT=620.05n

.meas tran vdout1_133ck610 FIND v(dout1_133) AT=620.05n

.meas tran vdout1_134ck610 FIND v(dout1_134) AT=620.05n

.meas tran vdout1_135ck610 FIND v(dout1_135) AT=620.05n

.meas tran vdout1_136ck610 FIND v(dout1_136) AT=620.05n

.meas tran vdout1_137ck610 FIND v(dout1_137) AT=620.05n

.meas tran vdout1_138ck610 FIND v(dout1_138) AT=620.05n

.meas tran vdout1_139ck610 FIND v(dout1_139) AT=620.05n

.meas tran vdout1_140ck610 FIND v(dout1_140) AT=620.05n

.meas tran vdout1_141ck610 FIND v(dout1_141) AT=620.05n

.meas tran vdout1_142ck610 FIND v(dout1_142) AT=620.05n

.meas tran vdout1_143ck610 FIND v(dout1_143) AT=620.05n

.meas tran vdout1_144ck610 FIND v(dout1_144) AT=620.05n

.meas tran vdout1_145ck610 FIND v(dout1_145) AT=620.05n

.meas tran vdout1_146ck610 FIND v(dout1_146) AT=620.05n

.meas tran vdout1_147ck610 FIND v(dout1_147) AT=620.05n

.meas tran vdout1_148ck610 FIND v(dout1_148) AT=620.05n

.meas tran vdout1_149ck610 FIND v(dout1_149) AT=620.05n

.meas tran vdout1_150ck610 FIND v(dout1_150) AT=620.05n

.meas tran vdout1_151ck610 FIND v(dout1_151) AT=620.05n

.meas tran vdout1_152ck610 FIND v(dout1_152) AT=620.05n

.meas tran vdout1_153ck610 FIND v(dout1_153) AT=620.05n

.meas tran vdout1_154ck610 FIND v(dout1_154) AT=620.05n

.meas tran vdout1_155ck610 FIND v(dout1_155) AT=620.05n

.meas tran vdout1_156ck610 FIND v(dout1_156) AT=620.05n

.meas tran vdout1_157ck610 FIND v(dout1_157) AT=620.05n

.meas tran vdout1_158ck610 FIND v(dout1_158) AT=620.05n

.meas tran vdout1_159ck610 FIND v(dout1_159) AT=620.05n

.meas tran vdout1_160ck610 FIND v(dout1_160) AT=620.05n

.meas tran vdout1_161ck610 FIND v(dout1_161) AT=620.05n

.meas tran vdout1_162ck610 FIND v(dout1_162) AT=620.05n

.meas tran vdout1_163ck610 FIND v(dout1_163) AT=620.05n

.meas tran vdout1_164ck610 FIND v(dout1_164) AT=620.05n

.meas tran vdout1_165ck610 FIND v(dout1_165) AT=620.05n

.meas tran vdout1_166ck610 FIND v(dout1_166) AT=620.05n

.meas tran vdout1_167ck610 FIND v(dout1_167) AT=620.05n

.meas tran vdout1_168ck610 FIND v(dout1_168) AT=620.05n

.meas tran vdout1_169ck610 FIND v(dout1_169) AT=620.05n

.meas tran vdout1_170ck610 FIND v(dout1_170) AT=620.05n

.meas tran vdout1_171ck610 FIND v(dout1_171) AT=620.05n

.meas tran vdout1_172ck610 FIND v(dout1_172) AT=620.05n

.meas tran vdout1_173ck610 FIND v(dout1_173) AT=620.05n

.meas tran vdout1_174ck610 FIND v(dout1_174) AT=620.05n

.meas tran vdout1_175ck610 FIND v(dout1_175) AT=620.05n

.meas tran vdout1_176ck610 FIND v(dout1_176) AT=620.05n

.meas tran vdout1_177ck610 FIND v(dout1_177) AT=620.05n

.meas tran vdout1_178ck610 FIND v(dout1_178) AT=620.05n

.meas tran vdout1_179ck610 FIND v(dout1_179) AT=620.05n

.meas tran vdout1_180ck610 FIND v(dout1_180) AT=620.05n

.meas tran vdout1_181ck610 FIND v(dout1_181) AT=620.05n

.meas tran vdout1_182ck610 FIND v(dout1_182) AT=620.05n

.meas tran vdout1_183ck610 FIND v(dout1_183) AT=620.05n

.meas tran vdout1_184ck610 FIND v(dout1_184) AT=620.05n

.meas tran vdout1_185ck610 FIND v(dout1_185) AT=620.05n

.meas tran vdout1_186ck610 FIND v(dout1_186) AT=620.05n

.meas tran vdout1_187ck610 FIND v(dout1_187) AT=620.05n

.meas tran vdout1_188ck610 FIND v(dout1_188) AT=620.05n

.meas tran vdout1_189ck610 FIND v(dout1_189) AT=620.05n

.meas tran vdout1_190ck610 FIND v(dout1_190) AT=620.05n

.meas tran vdout1_191ck610 FIND v(dout1_191) AT=620.05n

.meas tran vdout1_192ck610 FIND v(dout1_192) AT=620.05n

.meas tran vdout1_193ck610 FIND v(dout1_193) AT=620.05n

.meas tran vdout1_194ck610 FIND v(dout1_194) AT=620.05n

.meas tran vdout1_195ck610 FIND v(dout1_195) AT=620.05n

.meas tran vdout1_196ck610 FIND v(dout1_196) AT=620.05n

.meas tran vdout1_197ck610 FIND v(dout1_197) AT=620.05n

.meas tran vdout1_198ck610 FIND v(dout1_198) AT=620.05n

.meas tran vdout1_199ck610 FIND v(dout1_199) AT=620.05n

.meas tran vdout1_200ck610 FIND v(dout1_200) AT=620.05n

.meas tran vdout1_201ck610 FIND v(dout1_201) AT=620.05n

.meas tran vdout1_202ck610 FIND v(dout1_202) AT=620.05n

.meas tran vdout1_203ck610 FIND v(dout1_203) AT=620.05n

.meas tran vdout1_204ck610 FIND v(dout1_204) AT=620.05n

.meas tran vdout1_205ck610 FIND v(dout1_205) AT=620.05n

.meas tran vdout1_206ck610 FIND v(dout1_206) AT=620.05n

.meas tran vdout1_207ck610 FIND v(dout1_207) AT=620.05n

.meas tran vdout1_208ck610 FIND v(dout1_208) AT=620.05n

.meas tran vdout1_209ck610 FIND v(dout1_209) AT=620.05n

.meas tran vdout1_210ck610 FIND v(dout1_210) AT=620.05n

.meas tran vdout1_211ck610 FIND v(dout1_211) AT=620.05n

.meas tran vdout1_212ck610 FIND v(dout1_212) AT=620.05n

.meas tran vdout1_213ck610 FIND v(dout1_213) AT=620.05n

.meas tran vdout1_214ck610 FIND v(dout1_214) AT=620.05n

.meas tran vdout1_215ck610 FIND v(dout1_215) AT=620.05n

.meas tran vdout1_216ck610 FIND v(dout1_216) AT=620.05n

.meas tran vdout1_217ck610 FIND v(dout1_217) AT=620.05n

.meas tran vdout1_218ck610 FIND v(dout1_218) AT=620.05n

.meas tran vdout1_219ck610 FIND v(dout1_219) AT=620.05n

.meas tran vdout1_220ck610 FIND v(dout1_220) AT=620.05n

.meas tran vdout1_221ck610 FIND v(dout1_221) AT=620.05n

.meas tran vdout1_222ck610 FIND v(dout1_222) AT=620.05n

.meas tran vdout1_223ck610 FIND v(dout1_223) AT=620.05n

.meas tran vdout1_224ck610 FIND v(dout1_224) AT=620.05n

.meas tran vdout1_225ck610 FIND v(dout1_225) AT=620.05n

.meas tran vdout1_226ck610 FIND v(dout1_226) AT=620.05n

.meas tran vdout1_227ck610 FIND v(dout1_227) AT=620.05n

.meas tran vdout1_228ck610 FIND v(dout1_228) AT=620.05n

.meas tran vdout1_229ck610 FIND v(dout1_229) AT=620.05n

.meas tran vdout1_230ck610 FIND v(dout1_230) AT=620.05n

.meas tran vdout1_231ck610 FIND v(dout1_231) AT=620.05n

.meas tran vdout1_232ck610 FIND v(dout1_232) AT=620.05n

.meas tran vdout1_233ck610 FIND v(dout1_233) AT=620.05n

.meas tran vdout1_234ck610 FIND v(dout1_234) AT=620.05n

.meas tran vdout1_235ck610 FIND v(dout1_235) AT=620.05n

.meas tran vdout1_236ck610 FIND v(dout1_236) AT=620.05n

.meas tran vdout1_237ck610 FIND v(dout1_237) AT=620.05n

.meas tran vdout1_238ck610 FIND v(dout1_238) AT=620.05n

.meas tran vdout1_239ck610 FIND v(dout1_239) AT=620.05n

.meas tran vdout1_240ck610 FIND v(dout1_240) AT=620.05n

.meas tran vdout1_241ck610 FIND v(dout1_241) AT=620.05n

.meas tran vdout1_242ck610 FIND v(dout1_242) AT=620.05n

.meas tran vdout1_243ck610 FIND v(dout1_243) AT=620.05n

.meas tran vdout1_244ck610 FIND v(dout1_244) AT=620.05n

.meas tran vdout1_245ck610 FIND v(dout1_245) AT=620.05n

.meas tran vdout1_246ck610 FIND v(dout1_246) AT=620.05n

.meas tran vdout1_247ck610 FIND v(dout1_247) AT=620.05n

.meas tran vdout1_248ck610 FIND v(dout1_248) AT=620.05n

.meas tran vdout1_249ck610 FIND v(dout1_249) AT=620.05n

.meas tran vdout1_250ck610 FIND v(dout1_250) AT=620.05n

.meas tran vdout1_251ck610 FIND v(dout1_251) AT=620.05n

.meas tran vdout1_252ck610 FIND v(dout1_252) AT=620.05n

.meas tran vdout1_253ck610 FIND v(dout1_253) AT=620.05n

.meas tran vdout1_254ck610 FIND v(dout1_254) AT=620.05n

.meas tran vdout1_255ck610 FIND v(dout1_255) AT=620.05n

.meas tran vdout1_256ck610 FIND v(dout1_256) AT=620.05n

.meas tran vdout1_0ck650 FIND v(dout1_0) AT=660.05n

.meas tran vdout1_1ck650 FIND v(dout1_1) AT=660.05n

.meas tran vdout1_2ck650 FIND v(dout1_2) AT=660.05n

.meas tran vdout1_3ck650 FIND v(dout1_3) AT=660.05n

.meas tran vdout1_4ck650 FIND v(dout1_4) AT=660.05n

.meas tran vdout1_5ck650 FIND v(dout1_5) AT=660.05n

.meas tran vdout1_6ck650 FIND v(dout1_6) AT=660.05n

.meas tran vdout1_7ck650 FIND v(dout1_7) AT=660.05n

.meas tran vdout1_8ck650 FIND v(dout1_8) AT=660.05n

.meas tran vdout1_9ck650 FIND v(dout1_9) AT=660.05n

.meas tran vdout1_10ck650 FIND v(dout1_10) AT=660.05n

.meas tran vdout1_11ck650 FIND v(dout1_11) AT=660.05n

.meas tran vdout1_12ck650 FIND v(dout1_12) AT=660.05n

.meas tran vdout1_13ck650 FIND v(dout1_13) AT=660.05n

.meas tran vdout1_14ck650 FIND v(dout1_14) AT=660.05n

.meas tran vdout1_15ck650 FIND v(dout1_15) AT=660.05n

.meas tran vdout1_16ck650 FIND v(dout1_16) AT=660.05n

.meas tran vdout1_17ck650 FIND v(dout1_17) AT=660.05n

.meas tran vdout1_18ck650 FIND v(dout1_18) AT=660.05n

.meas tran vdout1_19ck650 FIND v(dout1_19) AT=660.05n

.meas tran vdout1_20ck650 FIND v(dout1_20) AT=660.05n

.meas tran vdout1_21ck650 FIND v(dout1_21) AT=660.05n

.meas tran vdout1_22ck650 FIND v(dout1_22) AT=660.05n

.meas tran vdout1_23ck650 FIND v(dout1_23) AT=660.05n

.meas tran vdout1_24ck650 FIND v(dout1_24) AT=660.05n

.meas tran vdout1_25ck650 FIND v(dout1_25) AT=660.05n

.meas tran vdout1_26ck650 FIND v(dout1_26) AT=660.05n

.meas tran vdout1_27ck650 FIND v(dout1_27) AT=660.05n

.meas tran vdout1_28ck650 FIND v(dout1_28) AT=660.05n

.meas tran vdout1_29ck650 FIND v(dout1_29) AT=660.05n

.meas tran vdout1_30ck650 FIND v(dout1_30) AT=660.05n

.meas tran vdout1_31ck650 FIND v(dout1_31) AT=660.05n

.meas tran vdout1_32ck650 FIND v(dout1_32) AT=660.05n

.meas tran vdout1_33ck650 FIND v(dout1_33) AT=660.05n

.meas tran vdout1_34ck650 FIND v(dout1_34) AT=660.05n

.meas tran vdout1_35ck650 FIND v(dout1_35) AT=660.05n

.meas tran vdout1_36ck650 FIND v(dout1_36) AT=660.05n

.meas tran vdout1_37ck650 FIND v(dout1_37) AT=660.05n

.meas tran vdout1_38ck650 FIND v(dout1_38) AT=660.05n

.meas tran vdout1_39ck650 FIND v(dout1_39) AT=660.05n

.meas tran vdout1_40ck650 FIND v(dout1_40) AT=660.05n

.meas tran vdout1_41ck650 FIND v(dout1_41) AT=660.05n

.meas tran vdout1_42ck650 FIND v(dout1_42) AT=660.05n

.meas tran vdout1_43ck650 FIND v(dout1_43) AT=660.05n

.meas tran vdout1_44ck650 FIND v(dout1_44) AT=660.05n

.meas tran vdout1_45ck650 FIND v(dout1_45) AT=660.05n

.meas tran vdout1_46ck650 FIND v(dout1_46) AT=660.05n

.meas tran vdout1_47ck650 FIND v(dout1_47) AT=660.05n

.meas tran vdout1_48ck650 FIND v(dout1_48) AT=660.05n

.meas tran vdout1_49ck650 FIND v(dout1_49) AT=660.05n

.meas tran vdout1_50ck650 FIND v(dout1_50) AT=660.05n

.meas tran vdout1_51ck650 FIND v(dout1_51) AT=660.05n

.meas tran vdout1_52ck650 FIND v(dout1_52) AT=660.05n

.meas tran vdout1_53ck650 FIND v(dout1_53) AT=660.05n

.meas tran vdout1_54ck650 FIND v(dout1_54) AT=660.05n

.meas tran vdout1_55ck650 FIND v(dout1_55) AT=660.05n

.meas tran vdout1_56ck650 FIND v(dout1_56) AT=660.05n

.meas tran vdout1_57ck650 FIND v(dout1_57) AT=660.05n

.meas tran vdout1_58ck650 FIND v(dout1_58) AT=660.05n

.meas tran vdout1_59ck650 FIND v(dout1_59) AT=660.05n

.meas tran vdout1_60ck650 FIND v(dout1_60) AT=660.05n

.meas tran vdout1_61ck650 FIND v(dout1_61) AT=660.05n

.meas tran vdout1_62ck650 FIND v(dout1_62) AT=660.05n

.meas tran vdout1_63ck650 FIND v(dout1_63) AT=660.05n

.meas tran vdout1_64ck650 FIND v(dout1_64) AT=660.05n

.meas tran vdout1_65ck650 FIND v(dout1_65) AT=660.05n

.meas tran vdout1_66ck650 FIND v(dout1_66) AT=660.05n

.meas tran vdout1_67ck650 FIND v(dout1_67) AT=660.05n

.meas tran vdout1_68ck650 FIND v(dout1_68) AT=660.05n

.meas tran vdout1_69ck650 FIND v(dout1_69) AT=660.05n

.meas tran vdout1_70ck650 FIND v(dout1_70) AT=660.05n

.meas tran vdout1_71ck650 FIND v(dout1_71) AT=660.05n

.meas tran vdout1_72ck650 FIND v(dout1_72) AT=660.05n

.meas tran vdout1_73ck650 FIND v(dout1_73) AT=660.05n

.meas tran vdout1_74ck650 FIND v(dout1_74) AT=660.05n

.meas tran vdout1_75ck650 FIND v(dout1_75) AT=660.05n

.meas tran vdout1_76ck650 FIND v(dout1_76) AT=660.05n

.meas tran vdout1_77ck650 FIND v(dout1_77) AT=660.05n

.meas tran vdout1_78ck650 FIND v(dout1_78) AT=660.05n

.meas tran vdout1_79ck650 FIND v(dout1_79) AT=660.05n

.meas tran vdout1_80ck650 FIND v(dout1_80) AT=660.05n

.meas tran vdout1_81ck650 FIND v(dout1_81) AT=660.05n

.meas tran vdout1_82ck650 FIND v(dout1_82) AT=660.05n

.meas tran vdout1_83ck650 FIND v(dout1_83) AT=660.05n

.meas tran vdout1_84ck650 FIND v(dout1_84) AT=660.05n

.meas tran vdout1_85ck650 FIND v(dout1_85) AT=660.05n

.meas tran vdout1_86ck650 FIND v(dout1_86) AT=660.05n

.meas tran vdout1_87ck650 FIND v(dout1_87) AT=660.05n

.meas tran vdout1_88ck650 FIND v(dout1_88) AT=660.05n

.meas tran vdout1_89ck650 FIND v(dout1_89) AT=660.05n

.meas tran vdout1_90ck650 FIND v(dout1_90) AT=660.05n

.meas tran vdout1_91ck650 FIND v(dout1_91) AT=660.05n

.meas tran vdout1_92ck650 FIND v(dout1_92) AT=660.05n

.meas tran vdout1_93ck650 FIND v(dout1_93) AT=660.05n

.meas tran vdout1_94ck650 FIND v(dout1_94) AT=660.05n

.meas tran vdout1_95ck650 FIND v(dout1_95) AT=660.05n

.meas tran vdout1_96ck650 FIND v(dout1_96) AT=660.05n

.meas tran vdout1_97ck650 FIND v(dout1_97) AT=660.05n

.meas tran vdout1_98ck650 FIND v(dout1_98) AT=660.05n

.meas tran vdout1_99ck650 FIND v(dout1_99) AT=660.05n

.meas tran vdout1_100ck650 FIND v(dout1_100) AT=660.05n

.meas tran vdout1_101ck650 FIND v(dout1_101) AT=660.05n

.meas tran vdout1_102ck650 FIND v(dout1_102) AT=660.05n

.meas tran vdout1_103ck650 FIND v(dout1_103) AT=660.05n

.meas tran vdout1_104ck650 FIND v(dout1_104) AT=660.05n

.meas tran vdout1_105ck650 FIND v(dout1_105) AT=660.05n

.meas tran vdout1_106ck650 FIND v(dout1_106) AT=660.05n

.meas tran vdout1_107ck650 FIND v(dout1_107) AT=660.05n

.meas tran vdout1_108ck650 FIND v(dout1_108) AT=660.05n

.meas tran vdout1_109ck650 FIND v(dout1_109) AT=660.05n

.meas tran vdout1_110ck650 FIND v(dout1_110) AT=660.05n

.meas tran vdout1_111ck650 FIND v(dout1_111) AT=660.05n

.meas tran vdout1_112ck650 FIND v(dout1_112) AT=660.05n

.meas tran vdout1_113ck650 FIND v(dout1_113) AT=660.05n

.meas tran vdout1_114ck650 FIND v(dout1_114) AT=660.05n

.meas tran vdout1_115ck650 FIND v(dout1_115) AT=660.05n

.meas tran vdout1_116ck650 FIND v(dout1_116) AT=660.05n

.meas tran vdout1_117ck650 FIND v(dout1_117) AT=660.05n

.meas tran vdout1_118ck650 FIND v(dout1_118) AT=660.05n

.meas tran vdout1_119ck650 FIND v(dout1_119) AT=660.05n

.meas tran vdout1_120ck650 FIND v(dout1_120) AT=660.05n

.meas tran vdout1_121ck650 FIND v(dout1_121) AT=660.05n

.meas tran vdout1_122ck650 FIND v(dout1_122) AT=660.05n

.meas tran vdout1_123ck650 FIND v(dout1_123) AT=660.05n

.meas tran vdout1_124ck650 FIND v(dout1_124) AT=660.05n

.meas tran vdout1_125ck650 FIND v(dout1_125) AT=660.05n

.meas tran vdout1_126ck650 FIND v(dout1_126) AT=660.05n

.meas tran vdout1_127ck650 FIND v(dout1_127) AT=660.05n

.meas tran vdout1_128ck650 FIND v(dout1_128) AT=660.05n

.meas tran vdout1_129ck650 FIND v(dout1_129) AT=660.05n

.meas tran vdout1_130ck650 FIND v(dout1_130) AT=660.05n

.meas tran vdout1_131ck650 FIND v(dout1_131) AT=660.05n

.meas tran vdout1_132ck650 FIND v(dout1_132) AT=660.05n

.meas tran vdout1_133ck650 FIND v(dout1_133) AT=660.05n

.meas tran vdout1_134ck650 FIND v(dout1_134) AT=660.05n

.meas tran vdout1_135ck650 FIND v(dout1_135) AT=660.05n

.meas tran vdout1_136ck650 FIND v(dout1_136) AT=660.05n

.meas tran vdout1_137ck650 FIND v(dout1_137) AT=660.05n

.meas tran vdout1_138ck650 FIND v(dout1_138) AT=660.05n

.meas tran vdout1_139ck650 FIND v(dout1_139) AT=660.05n

.meas tran vdout1_140ck650 FIND v(dout1_140) AT=660.05n

.meas tran vdout1_141ck650 FIND v(dout1_141) AT=660.05n

.meas tran vdout1_142ck650 FIND v(dout1_142) AT=660.05n

.meas tran vdout1_143ck650 FIND v(dout1_143) AT=660.05n

.meas tran vdout1_144ck650 FIND v(dout1_144) AT=660.05n

.meas tran vdout1_145ck650 FIND v(dout1_145) AT=660.05n

.meas tran vdout1_146ck650 FIND v(dout1_146) AT=660.05n

.meas tran vdout1_147ck650 FIND v(dout1_147) AT=660.05n

.meas tran vdout1_148ck650 FIND v(dout1_148) AT=660.05n

.meas tran vdout1_149ck650 FIND v(dout1_149) AT=660.05n

.meas tran vdout1_150ck650 FIND v(dout1_150) AT=660.05n

.meas tran vdout1_151ck650 FIND v(dout1_151) AT=660.05n

.meas tran vdout1_152ck650 FIND v(dout1_152) AT=660.05n

.meas tran vdout1_153ck650 FIND v(dout1_153) AT=660.05n

.meas tran vdout1_154ck650 FIND v(dout1_154) AT=660.05n

.meas tran vdout1_155ck650 FIND v(dout1_155) AT=660.05n

.meas tran vdout1_156ck650 FIND v(dout1_156) AT=660.05n

.meas tran vdout1_157ck650 FIND v(dout1_157) AT=660.05n

.meas tran vdout1_158ck650 FIND v(dout1_158) AT=660.05n

.meas tran vdout1_159ck650 FIND v(dout1_159) AT=660.05n

.meas tran vdout1_160ck650 FIND v(dout1_160) AT=660.05n

.meas tran vdout1_161ck650 FIND v(dout1_161) AT=660.05n

.meas tran vdout1_162ck650 FIND v(dout1_162) AT=660.05n

.meas tran vdout1_163ck650 FIND v(dout1_163) AT=660.05n

.meas tran vdout1_164ck650 FIND v(dout1_164) AT=660.05n

.meas tran vdout1_165ck650 FIND v(dout1_165) AT=660.05n

.meas tran vdout1_166ck650 FIND v(dout1_166) AT=660.05n

.meas tran vdout1_167ck650 FIND v(dout1_167) AT=660.05n

.meas tran vdout1_168ck650 FIND v(dout1_168) AT=660.05n

.meas tran vdout1_169ck650 FIND v(dout1_169) AT=660.05n

.meas tran vdout1_170ck650 FIND v(dout1_170) AT=660.05n

.meas tran vdout1_171ck650 FIND v(dout1_171) AT=660.05n

.meas tran vdout1_172ck650 FIND v(dout1_172) AT=660.05n

.meas tran vdout1_173ck650 FIND v(dout1_173) AT=660.05n

.meas tran vdout1_174ck650 FIND v(dout1_174) AT=660.05n

.meas tran vdout1_175ck650 FIND v(dout1_175) AT=660.05n

.meas tran vdout1_176ck650 FIND v(dout1_176) AT=660.05n

.meas tran vdout1_177ck650 FIND v(dout1_177) AT=660.05n

.meas tran vdout1_178ck650 FIND v(dout1_178) AT=660.05n

.meas tran vdout1_179ck650 FIND v(dout1_179) AT=660.05n

.meas tran vdout1_180ck650 FIND v(dout1_180) AT=660.05n

.meas tran vdout1_181ck650 FIND v(dout1_181) AT=660.05n

.meas tran vdout1_182ck650 FIND v(dout1_182) AT=660.05n

.meas tran vdout1_183ck650 FIND v(dout1_183) AT=660.05n

.meas tran vdout1_184ck650 FIND v(dout1_184) AT=660.05n

.meas tran vdout1_185ck650 FIND v(dout1_185) AT=660.05n

.meas tran vdout1_186ck650 FIND v(dout1_186) AT=660.05n

.meas tran vdout1_187ck650 FIND v(dout1_187) AT=660.05n

.meas tran vdout1_188ck650 FIND v(dout1_188) AT=660.05n

.meas tran vdout1_189ck650 FIND v(dout1_189) AT=660.05n

.meas tran vdout1_190ck650 FIND v(dout1_190) AT=660.05n

.meas tran vdout1_191ck650 FIND v(dout1_191) AT=660.05n

.meas tran vdout1_192ck650 FIND v(dout1_192) AT=660.05n

.meas tran vdout1_193ck650 FIND v(dout1_193) AT=660.05n

.meas tran vdout1_194ck650 FIND v(dout1_194) AT=660.05n

.meas tran vdout1_195ck650 FIND v(dout1_195) AT=660.05n

.meas tran vdout1_196ck650 FIND v(dout1_196) AT=660.05n

.meas tran vdout1_197ck650 FIND v(dout1_197) AT=660.05n

.meas tran vdout1_198ck650 FIND v(dout1_198) AT=660.05n

.meas tran vdout1_199ck650 FIND v(dout1_199) AT=660.05n

.meas tran vdout1_200ck650 FIND v(dout1_200) AT=660.05n

.meas tran vdout1_201ck650 FIND v(dout1_201) AT=660.05n

.meas tran vdout1_202ck650 FIND v(dout1_202) AT=660.05n

.meas tran vdout1_203ck650 FIND v(dout1_203) AT=660.05n

.meas tran vdout1_204ck650 FIND v(dout1_204) AT=660.05n

.meas tran vdout1_205ck650 FIND v(dout1_205) AT=660.05n

.meas tran vdout1_206ck650 FIND v(dout1_206) AT=660.05n

.meas tran vdout1_207ck650 FIND v(dout1_207) AT=660.05n

.meas tran vdout1_208ck650 FIND v(dout1_208) AT=660.05n

.meas tran vdout1_209ck650 FIND v(dout1_209) AT=660.05n

.meas tran vdout1_210ck650 FIND v(dout1_210) AT=660.05n

.meas tran vdout1_211ck650 FIND v(dout1_211) AT=660.05n

.meas tran vdout1_212ck650 FIND v(dout1_212) AT=660.05n

.meas tran vdout1_213ck650 FIND v(dout1_213) AT=660.05n

.meas tran vdout1_214ck650 FIND v(dout1_214) AT=660.05n

.meas tran vdout1_215ck650 FIND v(dout1_215) AT=660.05n

.meas tran vdout1_216ck650 FIND v(dout1_216) AT=660.05n

.meas tran vdout1_217ck650 FIND v(dout1_217) AT=660.05n

.meas tran vdout1_218ck650 FIND v(dout1_218) AT=660.05n

.meas tran vdout1_219ck650 FIND v(dout1_219) AT=660.05n

.meas tran vdout1_220ck650 FIND v(dout1_220) AT=660.05n

.meas tran vdout1_221ck650 FIND v(dout1_221) AT=660.05n

.meas tran vdout1_222ck650 FIND v(dout1_222) AT=660.05n

.meas tran vdout1_223ck650 FIND v(dout1_223) AT=660.05n

.meas tran vdout1_224ck650 FIND v(dout1_224) AT=660.05n

.meas tran vdout1_225ck650 FIND v(dout1_225) AT=660.05n

.meas tran vdout1_226ck650 FIND v(dout1_226) AT=660.05n

.meas tran vdout1_227ck650 FIND v(dout1_227) AT=660.05n

.meas tran vdout1_228ck650 FIND v(dout1_228) AT=660.05n

.meas tran vdout1_229ck650 FIND v(dout1_229) AT=660.05n

.meas tran vdout1_230ck650 FIND v(dout1_230) AT=660.05n

.meas tran vdout1_231ck650 FIND v(dout1_231) AT=660.05n

.meas tran vdout1_232ck650 FIND v(dout1_232) AT=660.05n

.meas tran vdout1_233ck650 FIND v(dout1_233) AT=660.05n

.meas tran vdout1_234ck650 FIND v(dout1_234) AT=660.05n

.meas tran vdout1_235ck650 FIND v(dout1_235) AT=660.05n

.meas tran vdout1_236ck650 FIND v(dout1_236) AT=660.05n

.meas tran vdout1_237ck650 FIND v(dout1_237) AT=660.05n

.meas tran vdout1_238ck650 FIND v(dout1_238) AT=660.05n

.meas tran vdout1_239ck650 FIND v(dout1_239) AT=660.05n

.meas tran vdout1_240ck650 FIND v(dout1_240) AT=660.05n

.meas tran vdout1_241ck650 FIND v(dout1_241) AT=660.05n

.meas tran vdout1_242ck650 FIND v(dout1_242) AT=660.05n

.meas tran vdout1_243ck650 FIND v(dout1_243) AT=660.05n

.meas tran vdout1_244ck650 FIND v(dout1_244) AT=660.05n

.meas tran vdout1_245ck650 FIND v(dout1_245) AT=660.05n

.meas tran vdout1_246ck650 FIND v(dout1_246) AT=660.05n

.meas tran vdout1_247ck650 FIND v(dout1_247) AT=660.05n

.meas tran vdout1_248ck650 FIND v(dout1_248) AT=660.05n

.meas tran vdout1_249ck650 FIND v(dout1_249) AT=660.05n

.meas tran vdout1_250ck650 FIND v(dout1_250) AT=660.05n

.meas tran vdout1_251ck650 FIND v(dout1_251) AT=660.05n

.meas tran vdout1_252ck650 FIND v(dout1_252) AT=660.05n

.meas tran vdout1_253ck650 FIND v(dout1_253) AT=660.05n

.meas tran vdout1_254ck650 FIND v(dout1_254) AT=660.05n

.meas tran vdout1_255ck650 FIND v(dout1_255) AT=660.05n

.meas tran vdout1_256ck650 FIND v(dout1_256) AT=660.05n

.meas tran vdout1_0ck680 FIND v(dout1_0) AT=690.05n

.meas tran vdout1_1ck680 FIND v(dout1_1) AT=690.05n

.meas tran vdout1_2ck680 FIND v(dout1_2) AT=690.05n

.meas tran vdout1_3ck680 FIND v(dout1_3) AT=690.05n

.meas tran vdout1_4ck680 FIND v(dout1_4) AT=690.05n

.meas tran vdout1_5ck680 FIND v(dout1_5) AT=690.05n

.meas tran vdout1_6ck680 FIND v(dout1_6) AT=690.05n

.meas tran vdout1_7ck680 FIND v(dout1_7) AT=690.05n

.meas tran vdout1_8ck680 FIND v(dout1_8) AT=690.05n

.meas tran vdout1_9ck680 FIND v(dout1_9) AT=690.05n

.meas tran vdout1_10ck680 FIND v(dout1_10) AT=690.05n

.meas tran vdout1_11ck680 FIND v(dout1_11) AT=690.05n

.meas tran vdout1_12ck680 FIND v(dout1_12) AT=690.05n

.meas tran vdout1_13ck680 FIND v(dout1_13) AT=690.05n

.meas tran vdout1_14ck680 FIND v(dout1_14) AT=690.05n

.meas tran vdout1_15ck680 FIND v(dout1_15) AT=690.05n

.meas tran vdout1_16ck680 FIND v(dout1_16) AT=690.05n

.meas tran vdout1_17ck680 FIND v(dout1_17) AT=690.05n

.meas tran vdout1_18ck680 FIND v(dout1_18) AT=690.05n

.meas tran vdout1_19ck680 FIND v(dout1_19) AT=690.05n

.meas tran vdout1_20ck680 FIND v(dout1_20) AT=690.05n

.meas tran vdout1_21ck680 FIND v(dout1_21) AT=690.05n

.meas tran vdout1_22ck680 FIND v(dout1_22) AT=690.05n

.meas tran vdout1_23ck680 FIND v(dout1_23) AT=690.05n

.meas tran vdout1_24ck680 FIND v(dout1_24) AT=690.05n

.meas tran vdout1_25ck680 FIND v(dout1_25) AT=690.05n

.meas tran vdout1_26ck680 FIND v(dout1_26) AT=690.05n

.meas tran vdout1_27ck680 FIND v(dout1_27) AT=690.05n

.meas tran vdout1_28ck680 FIND v(dout1_28) AT=690.05n

.meas tran vdout1_29ck680 FIND v(dout1_29) AT=690.05n

.meas tran vdout1_30ck680 FIND v(dout1_30) AT=690.05n

.meas tran vdout1_31ck680 FIND v(dout1_31) AT=690.05n

.meas tran vdout1_32ck680 FIND v(dout1_32) AT=690.05n

.meas tran vdout1_33ck680 FIND v(dout1_33) AT=690.05n

.meas tran vdout1_34ck680 FIND v(dout1_34) AT=690.05n

.meas tran vdout1_35ck680 FIND v(dout1_35) AT=690.05n

.meas tran vdout1_36ck680 FIND v(dout1_36) AT=690.05n

.meas tran vdout1_37ck680 FIND v(dout1_37) AT=690.05n

.meas tran vdout1_38ck680 FIND v(dout1_38) AT=690.05n

.meas tran vdout1_39ck680 FIND v(dout1_39) AT=690.05n

.meas tran vdout1_40ck680 FIND v(dout1_40) AT=690.05n

.meas tran vdout1_41ck680 FIND v(dout1_41) AT=690.05n

.meas tran vdout1_42ck680 FIND v(dout1_42) AT=690.05n

.meas tran vdout1_43ck680 FIND v(dout1_43) AT=690.05n

.meas tran vdout1_44ck680 FIND v(dout1_44) AT=690.05n

.meas tran vdout1_45ck680 FIND v(dout1_45) AT=690.05n

.meas tran vdout1_46ck680 FIND v(dout1_46) AT=690.05n

.meas tran vdout1_47ck680 FIND v(dout1_47) AT=690.05n

.meas tran vdout1_48ck680 FIND v(dout1_48) AT=690.05n

.meas tran vdout1_49ck680 FIND v(dout1_49) AT=690.05n

.meas tran vdout1_50ck680 FIND v(dout1_50) AT=690.05n

.meas tran vdout1_51ck680 FIND v(dout1_51) AT=690.05n

.meas tran vdout1_52ck680 FIND v(dout1_52) AT=690.05n

.meas tran vdout1_53ck680 FIND v(dout1_53) AT=690.05n

.meas tran vdout1_54ck680 FIND v(dout1_54) AT=690.05n

.meas tran vdout1_55ck680 FIND v(dout1_55) AT=690.05n

.meas tran vdout1_56ck680 FIND v(dout1_56) AT=690.05n

.meas tran vdout1_57ck680 FIND v(dout1_57) AT=690.05n

.meas tran vdout1_58ck680 FIND v(dout1_58) AT=690.05n

.meas tran vdout1_59ck680 FIND v(dout1_59) AT=690.05n

.meas tran vdout1_60ck680 FIND v(dout1_60) AT=690.05n

.meas tran vdout1_61ck680 FIND v(dout1_61) AT=690.05n

.meas tran vdout1_62ck680 FIND v(dout1_62) AT=690.05n

.meas tran vdout1_63ck680 FIND v(dout1_63) AT=690.05n

.meas tran vdout1_64ck680 FIND v(dout1_64) AT=690.05n

.meas tran vdout1_65ck680 FIND v(dout1_65) AT=690.05n

.meas tran vdout1_66ck680 FIND v(dout1_66) AT=690.05n

.meas tran vdout1_67ck680 FIND v(dout1_67) AT=690.05n

.meas tran vdout1_68ck680 FIND v(dout1_68) AT=690.05n

.meas tran vdout1_69ck680 FIND v(dout1_69) AT=690.05n

.meas tran vdout1_70ck680 FIND v(dout1_70) AT=690.05n

.meas tran vdout1_71ck680 FIND v(dout1_71) AT=690.05n

.meas tran vdout1_72ck680 FIND v(dout1_72) AT=690.05n

.meas tran vdout1_73ck680 FIND v(dout1_73) AT=690.05n

.meas tran vdout1_74ck680 FIND v(dout1_74) AT=690.05n

.meas tran vdout1_75ck680 FIND v(dout1_75) AT=690.05n

.meas tran vdout1_76ck680 FIND v(dout1_76) AT=690.05n

.meas tran vdout1_77ck680 FIND v(dout1_77) AT=690.05n

.meas tran vdout1_78ck680 FIND v(dout1_78) AT=690.05n

.meas tran vdout1_79ck680 FIND v(dout1_79) AT=690.05n

.meas tran vdout1_80ck680 FIND v(dout1_80) AT=690.05n

.meas tran vdout1_81ck680 FIND v(dout1_81) AT=690.05n

.meas tran vdout1_82ck680 FIND v(dout1_82) AT=690.05n

.meas tran vdout1_83ck680 FIND v(dout1_83) AT=690.05n

.meas tran vdout1_84ck680 FIND v(dout1_84) AT=690.05n

.meas tran vdout1_85ck680 FIND v(dout1_85) AT=690.05n

.meas tran vdout1_86ck680 FIND v(dout1_86) AT=690.05n

.meas tran vdout1_87ck680 FIND v(dout1_87) AT=690.05n

.meas tran vdout1_88ck680 FIND v(dout1_88) AT=690.05n

.meas tran vdout1_89ck680 FIND v(dout1_89) AT=690.05n

.meas tran vdout1_90ck680 FIND v(dout1_90) AT=690.05n

.meas tran vdout1_91ck680 FIND v(dout1_91) AT=690.05n

.meas tran vdout1_92ck680 FIND v(dout1_92) AT=690.05n

.meas tran vdout1_93ck680 FIND v(dout1_93) AT=690.05n

.meas tran vdout1_94ck680 FIND v(dout1_94) AT=690.05n

.meas tran vdout1_95ck680 FIND v(dout1_95) AT=690.05n

.meas tran vdout1_96ck680 FIND v(dout1_96) AT=690.05n

.meas tran vdout1_97ck680 FIND v(dout1_97) AT=690.05n

.meas tran vdout1_98ck680 FIND v(dout1_98) AT=690.05n

.meas tran vdout1_99ck680 FIND v(dout1_99) AT=690.05n

.meas tran vdout1_100ck680 FIND v(dout1_100) AT=690.05n

.meas tran vdout1_101ck680 FIND v(dout1_101) AT=690.05n

.meas tran vdout1_102ck680 FIND v(dout1_102) AT=690.05n

.meas tran vdout1_103ck680 FIND v(dout1_103) AT=690.05n

.meas tran vdout1_104ck680 FIND v(dout1_104) AT=690.05n

.meas tran vdout1_105ck680 FIND v(dout1_105) AT=690.05n

.meas tran vdout1_106ck680 FIND v(dout1_106) AT=690.05n

.meas tran vdout1_107ck680 FIND v(dout1_107) AT=690.05n

.meas tran vdout1_108ck680 FIND v(dout1_108) AT=690.05n

.meas tran vdout1_109ck680 FIND v(dout1_109) AT=690.05n

.meas tran vdout1_110ck680 FIND v(dout1_110) AT=690.05n

.meas tran vdout1_111ck680 FIND v(dout1_111) AT=690.05n

.meas tran vdout1_112ck680 FIND v(dout1_112) AT=690.05n

.meas tran vdout1_113ck680 FIND v(dout1_113) AT=690.05n

.meas tran vdout1_114ck680 FIND v(dout1_114) AT=690.05n

.meas tran vdout1_115ck680 FIND v(dout1_115) AT=690.05n

.meas tran vdout1_116ck680 FIND v(dout1_116) AT=690.05n

.meas tran vdout1_117ck680 FIND v(dout1_117) AT=690.05n

.meas tran vdout1_118ck680 FIND v(dout1_118) AT=690.05n

.meas tran vdout1_119ck680 FIND v(dout1_119) AT=690.05n

.meas tran vdout1_120ck680 FIND v(dout1_120) AT=690.05n

.meas tran vdout1_121ck680 FIND v(dout1_121) AT=690.05n

.meas tran vdout1_122ck680 FIND v(dout1_122) AT=690.05n

.meas tran vdout1_123ck680 FIND v(dout1_123) AT=690.05n

.meas tran vdout1_124ck680 FIND v(dout1_124) AT=690.05n

.meas tran vdout1_125ck680 FIND v(dout1_125) AT=690.05n

.meas tran vdout1_126ck680 FIND v(dout1_126) AT=690.05n

.meas tran vdout1_127ck680 FIND v(dout1_127) AT=690.05n

.meas tran vdout1_128ck680 FIND v(dout1_128) AT=690.05n

.meas tran vdout1_129ck680 FIND v(dout1_129) AT=690.05n

.meas tran vdout1_130ck680 FIND v(dout1_130) AT=690.05n

.meas tran vdout1_131ck680 FIND v(dout1_131) AT=690.05n

.meas tran vdout1_132ck680 FIND v(dout1_132) AT=690.05n

.meas tran vdout1_133ck680 FIND v(dout1_133) AT=690.05n

.meas tran vdout1_134ck680 FIND v(dout1_134) AT=690.05n

.meas tran vdout1_135ck680 FIND v(dout1_135) AT=690.05n

.meas tran vdout1_136ck680 FIND v(dout1_136) AT=690.05n

.meas tran vdout1_137ck680 FIND v(dout1_137) AT=690.05n

.meas tran vdout1_138ck680 FIND v(dout1_138) AT=690.05n

.meas tran vdout1_139ck680 FIND v(dout1_139) AT=690.05n

.meas tran vdout1_140ck680 FIND v(dout1_140) AT=690.05n

.meas tran vdout1_141ck680 FIND v(dout1_141) AT=690.05n

.meas tran vdout1_142ck680 FIND v(dout1_142) AT=690.05n

.meas tran vdout1_143ck680 FIND v(dout1_143) AT=690.05n

.meas tran vdout1_144ck680 FIND v(dout1_144) AT=690.05n

.meas tran vdout1_145ck680 FIND v(dout1_145) AT=690.05n

.meas tran vdout1_146ck680 FIND v(dout1_146) AT=690.05n

.meas tran vdout1_147ck680 FIND v(dout1_147) AT=690.05n

.meas tran vdout1_148ck680 FIND v(dout1_148) AT=690.05n

.meas tran vdout1_149ck680 FIND v(dout1_149) AT=690.05n

.meas tran vdout1_150ck680 FIND v(dout1_150) AT=690.05n

.meas tran vdout1_151ck680 FIND v(dout1_151) AT=690.05n

.meas tran vdout1_152ck680 FIND v(dout1_152) AT=690.05n

.meas tran vdout1_153ck680 FIND v(dout1_153) AT=690.05n

.meas tran vdout1_154ck680 FIND v(dout1_154) AT=690.05n

.meas tran vdout1_155ck680 FIND v(dout1_155) AT=690.05n

.meas tran vdout1_156ck680 FIND v(dout1_156) AT=690.05n

.meas tran vdout1_157ck680 FIND v(dout1_157) AT=690.05n

.meas tran vdout1_158ck680 FIND v(dout1_158) AT=690.05n

.meas tran vdout1_159ck680 FIND v(dout1_159) AT=690.05n

.meas tran vdout1_160ck680 FIND v(dout1_160) AT=690.05n

.meas tran vdout1_161ck680 FIND v(dout1_161) AT=690.05n

.meas tran vdout1_162ck680 FIND v(dout1_162) AT=690.05n

.meas tran vdout1_163ck680 FIND v(dout1_163) AT=690.05n

.meas tran vdout1_164ck680 FIND v(dout1_164) AT=690.05n

.meas tran vdout1_165ck680 FIND v(dout1_165) AT=690.05n

.meas tran vdout1_166ck680 FIND v(dout1_166) AT=690.05n

.meas tran vdout1_167ck680 FIND v(dout1_167) AT=690.05n

.meas tran vdout1_168ck680 FIND v(dout1_168) AT=690.05n

.meas tran vdout1_169ck680 FIND v(dout1_169) AT=690.05n

.meas tran vdout1_170ck680 FIND v(dout1_170) AT=690.05n

.meas tran vdout1_171ck680 FIND v(dout1_171) AT=690.05n

.meas tran vdout1_172ck680 FIND v(dout1_172) AT=690.05n

.meas tran vdout1_173ck680 FIND v(dout1_173) AT=690.05n

.meas tran vdout1_174ck680 FIND v(dout1_174) AT=690.05n

.meas tran vdout1_175ck680 FIND v(dout1_175) AT=690.05n

.meas tran vdout1_176ck680 FIND v(dout1_176) AT=690.05n

.meas tran vdout1_177ck680 FIND v(dout1_177) AT=690.05n

.meas tran vdout1_178ck680 FIND v(dout1_178) AT=690.05n

.meas tran vdout1_179ck680 FIND v(dout1_179) AT=690.05n

.meas tran vdout1_180ck680 FIND v(dout1_180) AT=690.05n

.meas tran vdout1_181ck680 FIND v(dout1_181) AT=690.05n

.meas tran vdout1_182ck680 FIND v(dout1_182) AT=690.05n

.meas tran vdout1_183ck680 FIND v(dout1_183) AT=690.05n

.meas tran vdout1_184ck680 FIND v(dout1_184) AT=690.05n

.meas tran vdout1_185ck680 FIND v(dout1_185) AT=690.05n

.meas tran vdout1_186ck680 FIND v(dout1_186) AT=690.05n

.meas tran vdout1_187ck680 FIND v(dout1_187) AT=690.05n

.meas tran vdout1_188ck680 FIND v(dout1_188) AT=690.05n

.meas tran vdout1_189ck680 FIND v(dout1_189) AT=690.05n

.meas tran vdout1_190ck680 FIND v(dout1_190) AT=690.05n

.meas tran vdout1_191ck680 FIND v(dout1_191) AT=690.05n

.meas tran vdout1_192ck680 FIND v(dout1_192) AT=690.05n

.meas tran vdout1_193ck680 FIND v(dout1_193) AT=690.05n

.meas tran vdout1_194ck680 FIND v(dout1_194) AT=690.05n

.meas tran vdout1_195ck680 FIND v(dout1_195) AT=690.05n

.meas tran vdout1_196ck680 FIND v(dout1_196) AT=690.05n

.meas tran vdout1_197ck680 FIND v(dout1_197) AT=690.05n

.meas tran vdout1_198ck680 FIND v(dout1_198) AT=690.05n

.meas tran vdout1_199ck680 FIND v(dout1_199) AT=690.05n

.meas tran vdout1_200ck680 FIND v(dout1_200) AT=690.05n

.meas tran vdout1_201ck680 FIND v(dout1_201) AT=690.05n

.meas tran vdout1_202ck680 FIND v(dout1_202) AT=690.05n

.meas tran vdout1_203ck680 FIND v(dout1_203) AT=690.05n

.meas tran vdout1_204ck680 FIND v(dout1_204) AT=690.05n

.meas tran vdout1_205ck680 FIND v(dout1_205) AT=690.05n

.meas tran vdout1_206ck680 FIND v(dout1_206) AT=690.05n

.meas tran vdout1_207ck680 FIND v(dout1_207) AT=690.05n

.meas tran vdout1_208ck680 FIND v(dout1_208) AT=690.05n

.meas tran vdout1_209ck680 FIND v(dout1_209) AT=690.05n

.meas tran vdout1_210ck680 FIND v(dout1_210) AT=690.05n

.meas tran vdout1_211ck680 FIND v(dout1_211) AT=690.05n

.meas tran vdout1_212ck680 FIND v(dout1_212) AT=690.05n

.meas tran vdout1_213ck680 FIND v(dout1_213) AT=690.05n

.meas tran vdout1_214ck680 FIND v(dout1_214) AT=690.05n

.meas tran vdout1_215ck680 FIND v(dout1_215) AT=690.05n

.meas tran vdout1_216ck680 FIND v(dout1_216) AT=690.05n

.meas tran vdout1_217ck680 FIND v(dout1_217) AT=690.05n

.meas tran vdout1_218ck680 FIND v(dout1_218) AT=690.05n

.meas tran vdout1_219ck680 FIND v(dout1_219) AT=690.05n

.meas tran vdout1_220ck680 FIND v(dout1_220) AT=690.05n

.meas tran vdout1_221ck680 FIND v(dout1_221) AT=690.05n

.meas tran vdout1_222ck680 FIND v(dout1_222) AT=690.05n

.meas tran vdout1_223ck680 FIND v(dout1_223) AT=690.05n

.meas tran vdout1_224ck680 FIND v(dout1_224) AT=690.05n

.meas tran vdout1_225ck680 FIND v(dout1_225) AT=690.05n

.meas tran vdout1_226ck680 FIND v(dout1_226) AT=690.05n

.meas tran vdout1_227ck680 FIND v(dout1_227) AT=690.05n

.meas tran vdout1_228ck680 FIND v(dout1_228) AT=690.05n

.meas tran vdout1_229ck680 FIND v(dout1_229) AT=690.05n

.meas tran vdout1_230ck680 FIND v(dout1_230) AT=690.05n

.meas tran vdout1_231ck680 FIND v(dout1_231) AT=690.05n

.meas tran vdout1_232ck680 FIND v(dout1_232) AT=690.05n

.meas tran vdout1_233ck680 FIND v(dout1_233) AT=690.05n

.meas tran vdout1_234ck680 FIND v(dout1_234) AT=690.05n

.meas tran vdout1_235ck680 FIND v(dout1_235) AT=690.05n

.meas tran vdout1_236ck680 FIND v(dout1_236) AT=690.05n

.meas tran vdout1_237ck680 FIND v(dout1_237) AT=690.05n

.meas tran vdout1_238ck680 FIND v(dout1_238) AT=690.05n

.meas tran vdout1_239ck680 FIND v(dout1_239) AT=690.05n

.meas tran vdout1_240ck680 FIND v(dout1_240) AT=690.05n

.meas tran vdout1_241ck680 FIND v(dout1_241) AT=690.05n

.meas tran vdout1_242ck680 FIND v(dout1_242) AT=690.05n

.meas tran vdout1_243ck680 FIND v(dout1_243) AT=690.05n

.meas tran vdout1_244ck680 FIND v(dout1_244) AT=690.05n

.meas tran vdout1_245ck680 FIND v(dout1_245) AT=690.05n

.meas tran vdout1_246ck680 FIND v(dout1_246) AT=690.05n

.meas tran vdout1_247ck680 FIND v(dout1_247) AT=690.05n

.meas tran vdout1_248ck680 FIND v(dout1_248) AT=690.05n

.meas tran vdout1_249ck680 FIND v(dout1_249) AT=690.05n

.meas tran vdout1_250ck680 FIND v(dout1_250) AT=690.05n

.meas tran vdout1_251ck680 FIND v(dout1_251) AT=690.05n

.meas tran vdout1_252ck680 FIND v(dout1_252) AT=690.05n

.meas tran vdout1_253ck680 FIND v(dout1_253) AT=690.05n

.meas tran vdout1_254ck680 FIND v(dout1_254) AT=690.05n

.meas tran vdout1_255ck680 FIND v(dout1_255) AT=690.05n

.meas tran vdout1_256ck680 FIND v(dout1_256) AT=690.05n

.meas tran vdout1_0ck750 FIND v(dout1_0) AT=760.05n

.meas tran vdout1_1ck750 FIND v(dout1_1) AT=760.05n

.meas tran vdout1_2ck750 FIND v(dout1_2) AT=760.05n

.meas tran vdout1_3ck750 FIND v(dout1_3) AT=760.05n

.meas tran vdout1_4ck750 FIND v(dout1_4) AT=760.05n

.meas tran vdout1_5ck750 FIND v(dout1_5) AT=760.05n

.meas tran vdout1_6ck750 FIND v(dout1_6) AT=760.05n

.meas tran vdout1_7ck750 FIND v(dout1_7) AT=760.05n

.meas tran vdout1_8ck750 FIND v(dout1_8) AT=760.05n

.meas tran vdout1_9ck750 FIND v(dout1_9) AT=760.05n

.meas tran vdout1_10ck750 FIND v(dout1_10) AT=760.05n

.meas tran vdout1_11ck750 FIND v(dout1_11) AT=760.05n

.meas tran vdout1_12ck750 FIND v(dout1_12) AT=760.05n

.meas tran vdout1_13ck750 FIND v(dout1_13) AT=760.05n

.meas tran vdout1_14ck750 FIND v(dout1_14) AT=760.05n

.meas tran vdout1_15ck750 FIND v(dout1_15) AT=760.05n

.meas tran vdout1_16ck750 FIND v(dout1_16) AT=760.05n

.meas tran vdout1_17ck750 FIND v(dout1_17) AT=760.05n

.meas tran vdout1_18ck750 FIND v(dout1_18) AT=760.05n

.meas tran vdout1_19ck750 FIND v(dout1_19) AT=760.05n

.meas tran vdout1_20ck750 FIND v(dout1_20) AT=760.05n

.meas tran vdout1_21ck750 FIND v(dout1_21) AT=760.05n

.meas tran vdout1_22ck750 FIND v(dout1_22) AT=760.05n

.meas tran vdout1_23ck750 FIND v(dout1_23) AT=760.05n

.meas tran vdout1_24ck750 FIND v(dout1_24) AT=760.05n

.meas tran vdout1_25ck750 FIND v(dout1_25) AT=760.05n

.meas tran vdout1_26ck750 FIND v(dout1_26) AT=760.05n

.meas tran vdout1_27ck750 FIND v(dout1_27) AT=760.05n

.meas tran vdout1_28ck750 FIND v(dout1_28) AT=760.05n

.meas tran vdout1_29ck750 FIND v(dout1_29) AT=760.05n

.meas tran vdout1_30ck750 FIND v(dout1_30) AT=760.05n

.meas tran vdout1_31ck750 FIND v(dout1_31) AT=760.05n

.meas tran vdout1_32ck750 FIND v(dout1_32) AT=760.05n

.meas tran vdout1_33ck750 FIND v(dout1_33) AT=760.05n

.meas tran vdout1_34ck750 FIND v(dout1_34) AT=760.05n

.meas tran vdout1_35ck750 FIND v(dout1_35) AT=760.05n

.meas tran vdout1_36ck750 FIND v(dout1_36) AT=760.05n

.meas tran vdout1_37ck750 FIND v(dout1_37) AT=760.05n

.meas tran vdout1_38ck750 FIND v(dout1_38) AT=760.05n

.meas tran vdout1_39ck750 FIND v(dout1_39) AT=760.05n

.meas tran vdout1_40ck750 FIND v(dout1_40) AT=760.05n

.meas tran vdout1_41ck750 FIND v(dout1_41) AT=760.05n

.meas tran vdout1_42ck750 FIND v(dout1_42) AT=760.05n

.meas tran vdout1_43ck750 FIND v(dout1_43) AT=760.05n

.meas tran vdout1_44ck750 FIND v(dout1_44) AT=760.05n

.meas tran vdout1_45ck750 FIND v(dout1_45) AT=760.05n

.meas tran vdout1_46ck750 FIND v(dout1_46) AT=760.05n

.meas tran vdout1_47ck750 FIND v(dout1_47) AT=760.05n

.meas tran vdout1_48ck750 FIND v(dout1_48) AT=760.05n

.meas tran vdout1_49ck750 FIND v(dout1_49) AT=760.05n

.meas tran vdout1_50ck750 FIND v(dout1_50) AT=760.05n

.meas tran vdout1_51ck750 FIND v(dout1_51) AT=760.05n

.meas tran vdout1_52ck750 FIND v(dout1_52) AT=760.05n

.meas tran vdout1_53ck750 FIND v(dout1_53) AT=760.05n

.meas tran vdout1_54ck750 FIND v(dout1_54) AT=760.05n

.meas tran vdout1_55ck750 FIND v(dout1_55) AT=760.05n

.meas tran vdout1_56ck750 FIND v(dout1_56) AT=760.05n

.meas tran vdout1_57ck750 FIND v(dout1_57) AT=760.05n

.meas tran vdout1_58ck750 FIND v(dout1_58) AT=760.05n

.meas tran vdout1_59ck750 FIND v(dout1_59) AT=760.05n

.meas tran vdout1_60ck750 FIND v(dout1_60) AT=760.05n

.meas tran vdout1_61ck750 FIND v(dout1_61) AT=760.05n

.meas tran vdout1_62ck750 FIND v(dout1_62) AT=760.05n

.meas tran vdout1_63ck750 FIND v(dout1_63) AT=760.05n

.meas tran vdout1_64ck750 FIND v(dout1_64) AT=760.05n

.meas tran vdout1_65ck750 FIND v(dout1_65) AT=760.05n

.meas tran vdout1_66ck750 FIND v(dout1_66) AT=760.05n

.meas tran vdout1_67ck750 FIND v(dout1_67) AT=760.05n

.meas tran vdout1_68ck750 FIND v(dout1_68) AT=760.05n

.meas tran vdout1_69ck750 FIND v(dout1_69) AT=760.05n

.meas tran vdout1_70ck750 FIND v(dout1_70) AT=760.05n

.meas tran vdout1_71ck750 FIND v(dout1_71) AT=760.05n

.meas tran vdout1_72ck750 FIND v(dout1_72) AT=760.05n

.meas tran vdout1_73ck750 FIND v(dout1_73) AT=760.05n

.meas tran vdout1_74ck750 FIND v(dout1_74) AT=760.05n

.meas tran vdout1_75ck750 FIND v(dout1_75) AT=760.05n

.meas tran vdout1_76ck750 FIND v(dout1_76) AT=760.05n

.meas tran vdout1_77ck750 FIND v(dout1_77) AT=760.05n

.meas tran vdout1_78ck750 FIND v(dout1_78) AT=760.05n

.meas tran vdout1_79ck750 FIND v(dout1_79) AT=760.05n

.meas tran vdout1_80ck750 FIND v(dout1_80) AT=760.05n

.meas tran vdout1_81ck750 FIND v(dout1_81) AT=760.05n

.meas tran vdout1_82ck750 FIND v(dout1_82) AT=760.05n

.meas tran vdout1_83ck750 FIND v(dout1_83) AT=760.05n

.meas tran vdout1_84ck750 FIND v(dout1_84) AT=760.05n

.meas tran vdout1_85ck750 FIND v(dout1_85) AT=760.05n

.meas tran vdout1_86ck750 FIND v(dout1_86) AT=760.05n

.meas tran vdout1_87ck750 FIND v(dout1_87) AT=760.05n

.meas tran vdout1_88ck750 FIND v(dout1_88) AT=760.05n

.meas tran vdout1_89ck750 FIND v(dout1_89) AT=760.05n

.meas tran vdout1_90ck750 FIND v(dout1_90) AT=760.05n

.meas tran vdout1_91ck750 FIND v(dout1_91) AT=760.05n

.meas tran vdout1_92ck750 FIND v(dout1_92) AT=760.05n

.meas tran vdout1_93ck750 FIND v(dout1_93) AT=760.05n

.meas tran vdout1_94ck750 FIND v(dout1_94) AT=760.05n

.meas tran vdout1_95ck750 FIND v(dout1_95) AT=760.05n

.meas tran vdout1_96ck750 FIND v(dout1_96) AT=760.05n

.meas tran vdout1_97ck750 FIND v(dout1_97) AT=760.05n

.meas tran vdout1_98ck750 FIND v(dout1_98) AT=760.05n

.meas tran vdout1_99ck750 FIND v(dout1_99) AT=760.05n

.meas tran vdout1_100ck750 FIND v(dout1_100) AT=760.05n

.meas tran vdout1_101ck750 FIND v(dout1_101) AT=760.05n

.meas tran vdout1_102ck750 FIND v(dout1_102) AT=760.05n

.meas tran vdout1_103ck750 FIND v(dout1_103) AT=760.05n

.meas tran vdout1_104ck750 FIND v(dout1_104) AT=760.05n

.meas tran vdout1_105ck750 FIND v(dout1_105) AT=760.05n

.meas tran vdout1_106ck750 FIND v(dout1_106) AT=760.05n

.meas tran vdout1_107ck750 FIND v(dout1_107) AT=760.05n

.meas tran vdout1_108ck750 FIND v(dout1_108) AT=760.05n

.meas tran vdout1_109ck750 FIND v(dout1_109) AT=760.05n

.meas tran vdout1_110ck750 FIND v(dout1_110) AT=760.05n

.meas tran vdout1_111ck750 FIND v(dout1_111) AT=760.05n

.meas tran vdout1_112ck750 FIND v(dout1_112) AT=760.05n

.meas tran vdout1_113ck750 FIND v(dout1_113) AT=760.05n

.meas tran vdout1_114ck750 FIND v(dout1_114) AT=760.05n

.meas tran vdout1_115ck750 FIND v(dout1_115) AT=760.05n

.meas tran vdout1_116ck750 FIND v(dout1_116) AT=760.05n

.meas tran vdout1_117ck750 FIND v(dout1_117) AT=760.05n

.meas tran vdout1_118ck750 FIND v(dout1_118) AT=760.05n

.meas tran vdout1_119ck750 FIND v(dout1_119) AT=760.05n

.meas tran vdout1_120ck750 FIND v(dout1_120) AT=760.05n

.meas tran vdout1_121ck750 FIND v(dout1_121) AT=760.05n

.meas tran vdout1_122ck750 FIND v(dout1_122) AT=760.05n

.meas tran vdout1_123ck750 FIND v(dout1_123) AT=760.05n

.meas tran vdout1_124ck750 FIND v(dout1_124) AT=760.05n

.meas tran vdout1_125ck750 FIND v(dout1_125) AT=760.05n

.meas tran vdout1_126ck750 FIND v(dout1_126) AT=760.05n

.meas tran vdout1_127ck750 FIND v(dout1_127) AT=760.05n

.meas tran vdout1_128ck750 FIND v(dout1_128) AT=760.05n

.meas tran vdout1_129ck750 FIND v(dout1_129) AT=760.05n

.meas tran vdout1_130ck750 FIND v(dout1_130) AT=760.05n

.meas tran vdout1_131ck750 FIND v(dout1_131) AT=760.05n

.meas tran vdout1_132ck750 FIND v(dout1_132) AT=760.05n

.meas tran vdout1_133ck750 FIND v(dout1_133) AT=760.05n

.meas tran vdout1_134ck750 FIND v(dout1_134) AT=760.05n

.meas tran vdout1_135ck750 FIND v(dout1_135) AT=760.05n

.meas tran vdout1_136ck750 FIND v(dout1_136) AT=760.05n

.meas tran vdout1_137ck750 FIND v(dout1_137) AT=760.05n

.meas tran vdout1_138ck750 FIND v(dout1_138) AT=760.05n

.meas tran vdout1_139ck750 FIND v(dout1_139) AT=760.05n

.meas tran vdout1_140ck750 FIND v(dout1_140) AT=760.05n

.meas tran vdout1_141ck750 FIND v(dout1_141) AT=760.05n

.meas tran vdout1_142ck750 FIND v(dout1_142) AT=760.05n

.meas tran vdout1_143ck750 FIND v(dout1_143) AT=760.05n

.meas tran vdout1_144ck750 FIND v(dout1_144) AT=760.05n

.meas tran vdout1_145ck750 FIND v(dout1_145) AT=760.05n

.meas tran vdout1_146ck750 FIND v(dout1_146) AT=760.05n

.meas tran vdout1_147ck750 FIND v(dout1_147) AT=760.05n

.meas tran vdout1_148ck750 FIND v(dout1_148) AT=760.05n

.meas tran vdout1_149ck750 FIND v(dout1_149) AT=760.05n

.meas tran vdout1_150ck750 FIND v(dout1_150) AT=760.05n

.meas tran vdout1_151ck750 FIND v(dout1_151) AT=760.05n

.meas tran vdout1_152ck750 FIND v(dout1_152) AT=760.05n

.meas tran vdout1_153ck750 FIND v(dout1_153) AT=760.05n

.meas tran vdout1_154ck750 FIND v(dout1_154) AT=760.05n

.meas tran vdout1_155ck750 FIND v(dout1_155) AT=760.05n

.meas tran vdout1_156ck750 FIND v(dout1_156) AT=760.05n

.meas tran vdout1_157ck750 FIND v(dout1_157) AT=760.05n

.meas tran vdout1_158ck750 FIND v(dout1_158) AT=760.05n

.meas tran vdout1_159ck750 FIND v(dout1_159) AT=760.05n

.meas tran vdout1_160ck750 FIND v(dout1_160) AT=760.05n

.meas tran vdout1_161ck750 FIND v(dout1_161) AT=760.05n

.meas tran vdout1_162ck750 FIND v(dout1_162) AT=760.05n

.meas tran vdout1_163ck750 FIND v(dout1_163) AT=760.05n

.meas tran vdout1_164ck750 FIND v(dout1_164) AT=760.05n

.meas tran vdout1_165ck750 FIND v(dout1_165) AT=760.05n

.meas tran vdout1_166ck750 FIND v(dout1_166) AT=760.05n

.meas tran vdout1_167ck750 FIND v(dout1_167) AT=760.05n

.meas tran vdout1_168ck750 FIND v(dout1_168) AT=760.05n

.meas tran vdout1_169ck750 FIND v(dout1_169) AT=760.05n

.meas tran vdout1_170ck750 FIND v(dout1_170) AT=760.05n

.meas tran vdout1_171ck750 FIND v(dout1_171) AT=760.05n

.meas tran vdout1_172ck750 FIND v(dout1_172) AT=760.05n

.meas tran vdout1_173ck750 FIND v(dout1_173) AT=760.05n

.meas tran vdout1_174ck750 FIND v(dout1_174) AT=760.05n

.meas tran vdout1_175ck750 FIND v(dout1_175) AT=760.05n

.meas tran vdout1_176ck750 FIND v(dout1_176) AT=760.05n

.meas tran vdout1_177ck750 FIND v(dout1_177) AT=760.05n

.meas tran vdout1_178ck750 FIND v(dout1_178) AT=760.05n

.meas tran vdout1_179ck750 FIND v(dout1_179) AT=760.05n

.meas tran vdout1_180ck750 FIND v(dout1_180) AT=760.05n

.meas tran vdout1_181ck750 FIND v(dout1_181) AT=760.05n

.meas tran vdout1_182ck750 FIND v(dout1_182) AT=760.05n

.meas tran vdout1_183ck750 FIND v(dout1_183) AT=760.05n

.meas tran vdout1_184ck750 FIND v(dout1_184) AT=760.05n

.meas tran vdout1_185ck750 FIND v(dout1_185) AT=760.05n

.meas tran vdout1_186ck750 FIND v(dout1_186) AT=760.05n

.meas tran vdout1_187ck750 FIND v(dout1_187) AT=760.05n

.meas tran vdout1_188ck750 FIND v(dout1_188) AT=760.05n

.meas tran vdout1_189ck750 FIND v(dout1_189) AT=760.05n

.meas tran vdout1_190ck750 FIND v(dout1_190) AT=760.05n

.meas tran vdout1_191ck750 FIND v(dout1_191) AT=760.05n

.meas tran vdout1_192ck750 FIND v(dout1_192) AT=760.05n

.meas tran vdout1_193ck750 FIND v(dout1_193) AT=760.05n

.meas tran vdout1_194ck750 FIND v(dout1_194) AT=760.05n

.meas tran vdout1_195ck750 FIND v(dout1_195) AT=760.05n

.meas tran vdout1_196ck750 FIND v(dout1_196) AT=760.05n

.meas tran vdout1_197ck750 FIND v(dout1_197) AT=760.05n

.meas tran vdout1_198ck750 FIND v(dout1_198) AT=760.05n

.meas tran vdout1_199ck750 FIND v(dout1_199) AT=760.05n

.meas tran vdout1_200ck750 FIND v(dout1_200) AT=760.05n

.meas tran vdout1_201ck750 FIND v(dout1_201) AT=760.05n

.meas tran vdout1_202ck750 FIND v(dout1_202) AT=760.05n

.meas tran vdout1_203ck750 FIND v(dout1_203) AT=760.05n

.meas tran vdout1_204ck750 FIND v(dout1_204) AT=760.05n

.meas tran vdout1_205ck750 FIND v(dout1_205) AT=760.05n

.meas tran vdout1_206ck750 FIND v(dout1_206) AT=760.05n

.meas tran vdout1_207ck750 FIND v(dout1_207) AT=760.05n

.meas tran vdout1_208ck750 FIND v(dout1_208) AT=760.05n

.meas tran vdout1_209ck750 FIND v(dout1_209) AT=760.05n

.meas tran vdout1_210ck750 FIND v(dout1_210) AT=760.05n

.meas tran vdout1_211ck750 FIND v(dout1_211) AT=760.05n

.meas tran vdout1_212ck750 FIND v(dout1_212) AT=760.05n

.meas tran vdout1_213ck750 FIND v(dout1_213) AT=760.05n

.meas tran vdout1_214ck750 FIND v(dout1_214) AT=760.05n

.meas tran vdout1_215ck750 FIND v(dout1_215) AT=760.05n

.meas tran vdout1_216ck750 FIND v(dout1_216) AT=760.05n

.meas tran vdout1_217ck750 FIND v(dout1_217) AT=760.05n

.meas tran vdout1_218ck750 FIND v(dout1_218) AT=760.05n

.meas tran vdout1_219ck750 FIND v(dout1_219) AT=760.05n

.meas tran vdout1_220ck750 FIND v(dout1_220) AT=760.05n

.meas tran vdout1_221ck750 FIND v(dout1_221) AT=760.05n

.meas tran vdout1_222ck750 FIND v(dout1_222) AT=760.05n

.meas tran vdout1_223ck750 FIND v(dout1_223) AT=760.05n

.meas tran vdout1_224ck750 FIND v(dout1_224) AT=760.05n

.meas tran vdout1_225ck750 FIND v(dout1_225) AT=760.05n

.meas tran vdout1_226ck750 FIND v(dout1_226) AT=760.05n

.meas tran vdout1_227ck750 FIND v(dout1_227) AT=760.05n

.meas tran vdout1_228ck750 FIND v(dout1_228) AT=760.05n

.meas tran vdout1_229ck750 FIND v(dout1_229) AT=760.05n

.meas tran vdout1_230ck750 FIND v(dout1_230) AT=760.05n

.meas tran vdout1_231ck750 FIND v(dout1_231) AT=760.05n

.meas tran vdout1_232ck750 FIND v(dout1_232) AT=760.05n

.meas tran vdout1_233ck750 FIND v(dout1_233) AT=760.05n

.meas tran vdout1_234ck750 FIND v(dout1_234) AT=760.05n

.meas tran vdout1_235ck750 FIND v(dout1_235) AT=760.05n

.meas tran vdout1_236ck750 FIND v(dout1_236) AT=760.05n

.meas tran vdout1_237ck750 FIND v(dout1_237) AT=760.05n

.meas tran vdout1_238ck750 FIND v(dout1_238) AT=760.05n

.meas tran vdout1_239ck750 FIND v(dout1_239) AT=760.05n

.meas tran vdout1_240ck750 FIND v(dout1_240) AT=760.05n

.meas tran vdout1_241ck750 FIND v(dout1_241) AT=760.05n

.meas tran vdout1_242ck750 FIND v(dout1_242) AT=760.05n

.meas tran vdout1_243ck750 FIND v(dout1_243) AT=760.05n

.meas tran vdout1_244ck750 FIND v(dout1_244) AT=760.05n

.meas tran vdout1_245ck750 FIND v(dout1_245) AT=760.05n

.meas tran vdout1_246ck750 FIND v(dout1_246) AT=760.05n

.meas tran vdout1_247ck750 FIND v(dout1_247) AT=760.05n

.meas tran vdout1_248ck750 FIND v(dout1_248) AT=760.05n

.meas tran vdout1_249ck750 FIND v(dout1_249) AT=760.05n

.meas tran vdout1_250ck750 FIND v(dout1_250) AT=760.05n

.meas tran vdout1_251ck750 FIND v(dout1_251) AT=760.05n

.meas tran vdout1_252ck750 FIND v(dout1_252) AT=760.05n

.meas tran vdout1_253ck750 FIND v(dout1_253) AT=760.05n

.meas tran vdout1_254ck750 FIND v(dout1_254) AT=760.05n

.meas tran vdout1_255ck750 FIND v(dout1_255) AT=760.05n

.meas tran vdout1_256ck750 FIND v(dout1_256) AT=760.05n

.meas tran vdout1_0ck760 FIND v(dout1_0) AT=770.05n

.meas tran vdout1_1ck760 FIND v(dout1_1) AT=770.05n

.meas tran vdout1_2ck760 FIND v(dout1_2) AT=770.05n

.meas tran vdout1_3ck760 FIND v(dout1_3) AT=770.05n

.meas tran vdout1_4ck760 FIND v(dout1_4) AT=770.05n

.meas tran vdout1_5ck760 FIND v(dout1_5) AT=770.05n

.meas tran vdout1_6ck760 FIND v(dout1_6) AT=770.05n

.meas tran vdout1_7ck760 FIND v(dout1_7) AT=770.05n

.meas tran vdout1_8ck760 FIND v(dout1_8) AT=770.05n

.meas tran vdout1_9ck760 FIND v(dout1_9) AT=770.05n

.meas tran vdout1_10ck760 FIND v(dout1_10) AT=770.05n

.meas tran vdout1_11ck760 FIND v(dout1_11) AT=770.05n

.meas tran vdout1_12ck760 FIND v(dout1_12) AT=770.05n

.meas tran vdout1_13ck760 FIND v(dout1_13) AT=770.05n

.meas tran vdout1_14ck760 FIND v(dout1_14) AT=770.05n

.meas tran vdout1_15ck760 FIND v(dout1_15) AT=770.05n

.meas tran vdout1_16ck760 FIND v(dout1_16) AT=770.05n

.meas tran vdout1_17ck760 FIND v(dout1_17) AT=770.05n

.meas tran vdout1_18ck760 FIND v(dout1_18) AT=770.05n

.meas tran vdout1_19ck760 FIND v(dout1_19) AT=770.05n

.meas tran vdout1_20ck760 FIND v(dout1_20) AT=770.05n

.meas tran vdout1_21ck760 FIND v(dout1_21) AT=770.05n

.meas tran vdout1_22ck760 FIND v(dout1_22) AT=770.05n

.meas tran vdout1_23ck760 FIND v(dout1_23) AT=770.05n

.meas tran vdout1_24ck760 FIND v(dout1_24) AT=770.05n

.meas tran vdout1_25ck760 FIND v(dout1_25) AT=770.05n

.meas tran vdout1_26ck760 FIND v(dout1_26) AT=770.05n

.meas tran vdout1_27ck760 FIND v(dout1_27) AT=770.05n

.meas tran vdout1_28ck760 FIND v(dout1_28) AT=770.05n

.meas tran vdout1_29ck760 FIND v(dout1_29) AT=770.05n

.meas tran vdout1_30ck760 FIND v(dout1_30) AT=770.05n

.meas tran vdout1_31ck760 FIND v(dout1_31) AT=770.05n

.meas tran vdout1_32ck760 FIND v(dout1_32) AT=770.05n

.meas tran vdout1_33ck760 FIND v(dout1_33) AT=770.05n

.meas tran vdout1_34ck760 FIND v(dout1_34) AT=770.05n

.meas tran vdout1_35ck760 FIND v(dout1_35) AT=770.05n

.meas tran vdout1_36ck760 FIND v(dout1_36) AT=770.05n

.meas tran vdout1_37ck760 FIND v(dout1_37) AT=770.05n

.meas tran vdout1_38ck760 FIND v(dout1_38) AT=770.05n

.meas tran vdout1_39ck760 FIND v(dout1_39) AT=770.05n

.meas tran vdout1_40ck760 FIND v(dout1_40) AT=770.05n

.meas tran vdout1_41ck760 FIND v(dout1_41) AT=770.05n

.meas tran vdout1_42ck760 FIND v(dout1_42) AT=770.05n

.meas tran vdout1_43ck760 FIND v(dout1_43) AT=770.05n

.meas tran vdout1_44ck760 FIND v(dout1_44) AT=770.05n

.meas tran vdout1_45ck760 FIND v(dout1_45) AT=770.05n

.meas tran vdout1_46ck760 FIND v(dout1_46) AT=770.05n

.meas tran vdout1_47ck760 FIND v(dout1_47) AT=770.05n

.meas tran vdout1_48ck760 FIND v(dout1_48) AT=770.05n

.meas tran vdout1_49ck760 FIND v(dout1_49) AT=770.05n

.meas tran vdout1_50ck760 FIND v(dout1_50) AT=770.05n

.meas tran vdout1_51ck760 FIND v(dout1_51) AT=770.05n

.meas tran vdout1_52ck760 FIND v(dout1_52) AT=770.05n

.meas tran vdout1_53ck760 FIND v(dout1_53) AT=770.05n

.meas tran vdout1_54ck760 FIND v(dout1_54) AT=770.05n

.meas tran vdout1_55ck760 FIND v(dout1_55) AT=770.05n

.meas tran vdout1_56ck760 FIND v(dout1_56) AT=770.05n

.meas tran vdout1_57ck760 FIND v(dout1_57) AT=770.05n

.meas tran vdout1_58ck760 FIND v(dout1_58) AT=770.05n

.meas tran vdout1_59ck760 FIND v(dout1_59) AT=770.05n

.meas tran vdout1_60ck760 FIND v(dout1_60) AT=770.05n

.meas tran vdout1_61ck760 FIND v(dout1_61) AT=770.05n

.meas tran vdout1_62ck760 FIND v(dout1_62) AT=770.05n

.meas tran vdout1_63ck760 FIND v(dout1_63) AT=770.05n

.meas tran vdout1_64ck760 FIND v(dout1_64) AT=770.05n

.meas tran vdout1_65ck760 FIND v(dout1_65) AT=770.05n

.meas tran vdout1_66ck760 FIND v(dout1_66) AT=770.05n

.meas tran vdout1_67ck760 FIND v(dout1_67) AT=770.05n

.meas tran vdout1_68ck760 FIND v(dout1_68) AT=770.05n

.meas tran vdout1_69ck760 FIND v(dout1_69) AT=770.05n

.meas tran vdout1_70ck760 FIND v(dout1_70) AT=770.05n

.meas tran vdout1_71ck760 FIND v(dout1_71) AT=770.05n

.meas tran vdout1_72ck760 FIND v(dout1_72) AT=770.05n

.meas tran vdout1_73ck760 FIND v(dout1_73) AT=770.05n

.meas tran vdout1_74ck760 FIND v(dout1_74) AT=770.05n

.meas tran vdout1_75ck760 FIND v(dout1_75) AT=770.05n

.meas tran vdout1_76ck760 FIND v(dout1_76) AT=770.05n

.meas tran vdout1_77ck760 FIND v(dout1_77) AT=770.05n

.meas tran vdout1_78ck760 FIND v(dout1_78) AT=770.05n

.meas tran vdout1_79ck760 FIND v(dout1_79) AT=770.05n

.meas tran vdout1_80ck760 FIND v(dout1_80) AT=770.05n

.meas tran vdout1_81ck760 FIND v(dout1_81) AT=770.05n

.meas tran vdout1_82ck760 FIND v(dout1_82) AT=770.05n

.meas tran vdout1_83ck760 FIND v(dout1_83) AT=770.05n

.meas tran vdout1_84ck760 FIND v(dout1_84) AT=770.05n

.meas tran vdout1_85ck760 FIND v(dout1_85) AT=770.05n

.meas tran vdout1_86ck760 FIND v(dout1_86) AT=770.05n

.meas tran vdout1_87ck760 FIND v(dout1_87) AT=770.05n

.meas tran vdout1_88ck760 FIND v(dout1_88) AT=770.05n

.meas tran vdout1_89ck760 FIND v(dout1_89) AT=770.05n

.meas tran vdout1_90ck760 FIND v(dout1_90) AT=770.05n

.meas tran vdout1_91ck760 FIND v(dout1_91) AT=770.05n

.meas tran vdout1_92ck760 FIND v(dout1_92) AT=770.05n

.meas tran vdout1_93ck760 FIND v(dout1_93) AT=770.05n

.meas tran vdout1_94ck760 FIND v(dout1_94) AT=770.05n

.meas tran vdout1_95ck760 FIND v(dout1_95) AT=770.05n

.meas tran vdout1_96ck760 FIND v(dout1_96) AT=770.05n

.meas tran vdout1_97ck760 FIND v(dout1_97) AT=770.05n

.meas tran vdout1_98ck760 FIND v(dout1_98) AT=770.05n

.meas tran vdout1_99ck760 FIND v(dout1_99) AT=770.05n

.meas tran vdout1_100ck760 FIND v(dout1_100) AT=770.05n

.meas tran vdout1_101ck760 FIND v(dout1_101) AT=770.05n

.meas tran vdout1_102ck760 FIND v(dout1_102) AT=770.05n

.meas tran vdout1_103ck760 FIND v(dout1_103) AT=770.05n

.meas tran vdout1_104ck760 FIND v(dout1_104) AT=770.05n

.meas tran vdout1_105ck760 FIND v(dout1_105) AT=770.05n

.meas tran vdout1_106ck760 FIND v(dout1_106) AT=770.05n

.meas tran vdout1_107ck760 FIND v(dout1_107) AT=770.05n

.meas tran vdout1_108ck760 FIND v(dout1_108) AT=770.05n

.meas tran vdout1_109ck760 FIND v(dout1_109) AT=770.05n

.meas tran vdout1_110ck760 FIND v(dout1_110) AT=770.05n

.meas tran vdout1_111ck760 FIND v(dout1_111) AT=770.05n

.meas tran vdout1_112ck760 FIND v(dout1_112) AT=770.05n

.meas tran vdout1_113ck760 FIND v(dout1_113) AT=770.05n

.meas tran vdout1_114ck760 FIND v(dout1_114) AT=770.05n

.meas tran vdout1_115ck760 FIND v(dout1_115) AT=770.05n

.meas tran vdout1_116ck760 FIND v(dout1_116) AT=770.05n

.meas tran vdout1_117ck760 FIND v(dout1_117) AT=770.05n

.meas tran vdout1_118ck760 FIND v(dout1_118) AT=770.05n

.meas tran vdout1_119ck760 FIND v(dout1_119) AT=770.05n

.meas tran vdout1_120ck760 FIND v(dout1_120) AT=770.05n

.meas tran vdout1_121ck760 FIND v(dout1_121) AT=770.05n

.meas tran vdout1_122ck760 FIND v(dout1_122) AT=770.05n

.meas tran vdout1_123ck760 FIND v(dout1_123) AT=770.05n

.meas tran vdout1_124ck760 FIND v(dout1_124) AT=770.05n

.meas tran vdout1_125ck760 FIND v(dout1_125) AT=770.05n

.meas tran vdout1_126ck760 FIND v(dout1_126) AT=770.05n

.meas tran vdout1_127ck760 FIND v(dout1_127) AT=770.05n

.meas tran vdout1_128ck760 FIND v(dout1_128) AT=770.05n

.meas tran vdout1_129ck760 FIND v(dout1_129) AT=770.05n

.meas tran vdout1_130ck760 FIND v(dout1_130) AT=770.05n

.meas tran vdout1_131ck760 FIND v(dout1_131) AT=770.05n

.meas tran vdout1_132ck760 FIND v(dout1_132) AT=770.05n

.meas tran vdout1_133ck760 FIND v(dout1_133) AT=770.05n

.meas tran vdout1_134ck760 FIND v(dout1_134) AT=770.05n

.meas tran vdout1_135ck760 FIND v(dout1_135) AT=770.05n

.meas tran vdout1_136ck760 FIND v(dout1_136) AT=770.05n

.meas tran vdout1_137ck760 FIND v(dout1_137) AT=770.05n

.meas tran vdout1_138ck760 FIND v(dout1_138) AT=770.05n

.meas tran vdout1_139ck760 FIND v(dout1_139) AT=770.05n

.meas tran vdout1_140ck760 FIND v(dout1_140) AT=770.05n

.meas tran vdout1_141ck760 FIND v(dout1_141) AT=770.05n

.meas tran vdout1_142ck760 FIND v(dout1_142) AT=770.05n

.meas tran vdout1_143ck760 FIND v(dout1_143) AT=770.05n

.meas tran vdout1_144ck760 FIND v(dout1_144) AT=770.05n

.meas tran vdout1_145ck760 FIND v(dout1_145) AT=770.05n

.meas tran vdout1_146ck760 FIND v(dout1_146) AT=770.05n

.meas tran vdout1_147ck760 FIND v(dout1_147) AT=770.05n

.meas tran vdout1_148ck760 FIND v(dout1_148) AT=770.05n

.meas tran vdout1_149ck760 FIND v(dout1_149) AT=770.05n

.meas tran vdout1_150ck760 FIND v(dout1_150) AT=770.05n

.meas tran vdout1_151ck760 FIND v(dout1_151) AT=770.05n

.meas tran vdout1_152ck760 FIND v(dout1_152) AT=770.05n

.meas tran vdout1_153ck760 FIND v(dout1_153) AT=770.05n

.meas tran vdout1_154ck760 FIND v(dout1_154) AT=770.05n

.meas tran vdout1_155ck760 FIND v(dout1_155) AT=770.05n

.meas tran vdout1_156ck760 FIND v(dout1_156) AT=770.05n

.meas tran vdout1_157ck760 FIND v(dout1_157) AT=770.05n

.meas tran vdout1_158ck760 FIND v(dout1_158) AT=770.05n

.meas tran vdout1_159ck760 FIND v(dout1_159) AT=770.05n

.meas tran vdout1_160ck760 FIND v(dout1_160) AT=770.05n

.meas tran vdout1_161ck760 FIND v(dout1_161) AT=770.05n

.meas tran vdout1_162ck760 FIND v(dout1_162) AT=770.05n

.meas tran vdout1_163ck760 FIND v(dout1_163) AT=770.05n

.meas tran vdout1_164ck760 FIND v(dout1_164) AT=770.05n

.meas tran vdout1_165ck760 FIND v(dout1_165) AT=770.05n

.meas tran vdout1_166ck760 FIND v(dout1_166) AT=770.05n

.meas tran vdout1_167ck760 FIND v(dout1_167) AT=770.05n

.meas tran vdout1_168ck760 FIND v(dout1_168) AT=770.05n

.meas tran vdout1_169ck760 FIND v(dout1_169) AT=770.05n

.meas tran vdout1_170ck760 FIND v(dout1_170) AT=770.05n

.meas tran vdout1_171ck760 FIND v(dout1_171) AT=770.05n

.meas tran vdout1_172ck760 FIND v(dout1_172) AT=770.05n

.meas tran vdout1_173ck760 FIND v(dout1_173) AT=770.05n

.meas tran vdout1_174ck760 FIND v(dout1_174) AT=770.05n

.meas tran vdout1_175ck760 FIND v(dout1_175) AT=770.05n

.meas tran vdout1_176ck760 FIND v(dout1_176) AT=770.05n

.meas tran vdout1_177ck760 FIND v(dout1_177) AT=770.05n

.meas tran vdout1_178ck760 FIND v(dout1_178) AT=770.05n

.meas tran vdout1_179ck760 FIND v(dout1_179) AT=770.05n

.meas tran vdout1_180ck760 FIND v(dout1_180) AT=770.05n

.meas tran vdout1_181ck760 FIND v(dout1_181) AT=770.05n

.meas tran vdout1_182ck760 FIND v(dout1_182) AT=770.05n

.meas tran vdout1_183ck760 FIND v(dout1_183) AT=770.05n

.meas tran vdout1_184ck760 FIND v(dout1_184) AT=770.05n

.meas tran vdout1_185ck760 FIND v(dout1_185) AT=770.05n

.meas tran vdout1_186ck760 FIND v(dout1_186) AT=770.05n

.meas tran vdout1_187ck760 FIND v(dout1_187) AT=770.05n

.meas tran vdout1_188ck760 FIND v(dout1_188) AT=770.05n

.meas tran vdout1_189ck760 FIND v(dout1_189) AT=770.05n

.meas tran vdout1_190ck760 FIND v(dout1_190) AT=770.05n

.meas tran vdout1_191ck760 FIND v(dout1_191) AT=770.05n

.meas tran vdout1_192ck760 FIND v(dout1_192) AT=770.05n

.meas tran vdout1_193ck760 FIND v(dout1_193) AT=770.05n

.meas tran vdout1_194ck760 FIND v(dout1_194) AT=770.05n

.meas tran vdout1_195ck760 FIND v(dout1_195) AT=770.05n

.meas tran vdout1_196ck760 FIND v(dout1_196) AT=770.05n

.meas tran vdout1_197ck760 FIND v(dout1_197) AT=770.05n

.meas tran vdout1_198ck760 FIND v(dout1_198) AT=770.05n

.meas tran vdout1_199ck760 FIND v(dout1_199) AT=770.05n

.meas tran vdout1_200ck760 FIND v(dout1_200) AT=770.05n

.meas tran vdout1_201ck760 FIND v(dout1_201) AT=770.05n

.meas tran vdout1_202ck760 FIND v(dout1_202) AT=770.05n

.meas tran vdout1_203ck760 FIND v(dout1_203) AT=770.05n

.meas tran vdout1_204ck760 FIND v(dout1_204) AT=770.05n

.meas tran vdout1_205ck760 FIND v(dout1_205) AT=770.05n

.meas tran vdout1_206ck760 FIND v(dout1_206) AT=770.05n

.meas tran vdout1_207ck760 FIND v(dout1_207) AT=770.05n

.meas tran vdout1_208ck760 FIND v(dout1_208) AT=770.05n

.meas tran vdout1_209ck760 FIND v(dout1_209) AT=770.05n

.meas tran vdout1_210ck760 FIND v(dout1_210) AT=770.05n

.meas tran vdout1_211ck760 FIND v(dout1_211) AT=770.05n

.meas tran vdout1_212ck760 FIND v(dout1_212) AT=770.05n

.meas tran vdout1_213ck760 FIND v(dout1_213) AT=770.05n

.meas tran vdout1_214ck760 FIND v(dout1_214) AT=770.05n

.meas tran vdout1_215ck760 FIND v(dout1_215) AT=770.05n

.meas tran vdout1_216ck760 FIND v(dout1_216) AT=770.05n

.meas tran vdout1_217ck760 FIND v(dout1_217) AT=770.05n

.meas tran vdout1_218ck760 FIND v(dout1_218) AT=770.05n

.meas tran vdout1_219ck760 FIND v(dout1_219) AT=770.05n

.meas tran vdout1_220ck760 FIND v(dout1_220) AT=770.05n

.meas tran vdout1_221ck760 FIND v(dout1_221) AT=770.05n

.meas tran vdout1_222ck760 FIND v(dout1_222) AT=770.05n

.meas tran vdout1_223ck760 FIND v(dout1_223) AT=770.05n

.meas tran vdout1_224ck760 FIND v(dout1_224) AT=770.05n

.meas tran vdout1_225ck760 FIND v(dout1_225) AT=770.05n

.meas tran vdout1_226ck760 FIND v(dout1_226) AT=770.05n

.meas tran vdout1_227ck760 FIND v(dout1_227) AT=770.05n

.meas tran vdout1_228ck760 FIND v(dout1_228) AT=770.05n

.meas tran vdout1_229ck760 FIND v(dout1_229) AT=770.05n

.meas tran vdout1_230ck760 FIND v(dout1_230) AT=770.05n

.meas tran vdout1_231ck760 FIND v(dout1_231) AT=770.05n

.meas tran vdout1_232ck760 FIND v(dout1_232) AT=770.05n

.meas tran vdout1_233ck760 FIND v(dout1_233) AT=770.05n

.meas tran vdout1_234ck760 FIND v(dout1_234) AT=770.05n

.meas tran vdout1_235ck760 FIND v(dout1_235) AT=770.05n

.meas tran vdout1_236ck760 FIND v(dout1_236) AT=770.05n

.meas tran vdout1_237ck760 FIND v(dout1_237) AT=770.05n

.meas tran vdout1_238ck760 FIND v(dout1_238) AT=770.05n

.meas tran vdout1_239ck760 FIND v(dout1_239) AT=770.05n

.meas tran vdout1_240ck760 FIND v(dout1_240) AT=770.05n

.meas tran vdout1_241ck760 FIND v(dout1_241) AT=770.05n

.meas tran vdout1_242ck760 FIND v(dout1_242) AT=770.05n

.meas tran vdout1_243ck760 FIND v(dout1_243) AT=770.05n

.meas tran vdout1_244ck760 FIND v(dout1_244) AT=770.05n

.meas tran vdout1_245ck760 FIND v(dout1_245) AT=770.05n

.meas tran vdout1_246ck760 FIND v(dout1_246) AT=770.05n

.meas tran vdout1_247ck760 FIND v(dout1_247) AT=770.05n

.meas tran vdout1_248ck760 FIND v(dout1_248) AT=770.05n

.meas tran vdout1_249ck760 FIND v(dout1_249) AT=770.05n

.meas tran vdout1_250ck760 FIND v(dout1_250) AT=770.05n

.meas tran vdout1_251ck760 FIND v(dout1_251) AT=770.05n

.meas tran vdout1_252ck760 FIND v(dout1_252) AT=770.05n

.meas tran vdout1_253ck760 FIND v(dout1_253) AT=770.05n

.meas tran vdout1_254ck760 FIND v(dout1_254) AT=770.05n

.meas tran vdout1_255ck760 FIND v(dout1_255) AT=770.05n

.meas tran vdout1_256ck760 FIND v(dout1_256) AT=770.05n

.meas tran vdout1_0ck780 FIND v(dout1_0) AT=790.05n

.meas tran vdout1_1ck780 FIND v(dout1_1) AT=790.05n

.meas tran vdout1_2ck780 FIND v(dout1_2) AT=790.05n

.meas tran vdout1_3ck780 FIND v(dout1_3) AT=790.05n

.meas tran vdout1_4ck780 FIND v(dout1_4) AT=790.05n

.meas tran vdout1_5ck780 FIND v(dout1_5) AT=790.05n

.meas tran vdout1_6ck780 FIND v(dout1_6) AT=790.05n

.meas tran vdout1_7ck780 FIND v(dout1_7) AT=790.05n

.meas tran vdout1_8ck780 FIND v(dout1_8) AT=790.05n

.meas tran vdout1_9ck780 FIND v(dout1_9) AT=790.05n

.meas tran vdout1_10ck780 FIND v(dout1_10) AT=790.05n

.meas tran vdout1_11ck780 FIND v(dout1_11) AT=790.05n

.meas tran vdout1_12ck780 FIND v(dout1_12) AT=790.05n

.meas tran vdout1_13ck780 FIND v(dout1_13) AT=790.05n

.meas tran vdout1_14ck780 FIND v(dout1_14) AT=790.05n

.meas tran vdout1_15ck780 FIND v(dout1_15) AT=790.05n

.meas tran vdout1_16ck780 FIND v(dout1_16) AT=790.05n

.meas tran vdout1_17ck780 FIND v(dout1_17) AT=790.05n

.meas tran vdout1_18ck780 FIND v(dout1_18) AT=790.05n

.meas tran vdout1_19ck780 FIND v(dout1_19) AT=790.05n

.meas tran vdout1_20ck780 FIND v(dout1_20) AT=790.05n

.meas tran vdout1_21ck780 FIND v(dout1_21) AT=790.05n

.meas tran vdout1_22ck780 FIND v(dout1_22) AT=790.05n

.meas tran vdout1_23ck780 FIND v(dout1_23) AT=790.05n

.meas tran vdout1_24ck780 FIND v(dout1_24) AT=790.05n

.meas tran vdout1_25ck780 FIND v(dout1_25) AT=790.05n

.meas tran vdout1_26ck780 FIND v(dout1_26) AT=790.05n

.meas tran vdout1_27ck780 FIND v(dout1_27) AT=790.05n

.meas tran vdout1_28ck780 FIND v(dout1_28) AT=790.05n

.meas tran vdout1_29ck780 FIND v(dout1_29) AT=790.05n

.meas tran vdout1_30ck780 FIND v(dout1_30) AT=790.05n

.meas tran vdout1_31ck780 FIND v(dout1_31) AT=790.05n

.meas tran vdout1_32ck780 FIND v(dout1_32) AT=790.05n

.meas tran vdout1_33ck780 FIND v(dout1_33) AT=790.05n

.meas tran vdout1_34ck780 FIND v(dout1_34) AT=790.05n

.meas tran vdout1_35ck780 FIND v(dout1_35) AT=790.05n

.meas tran vdout1_36ck780 FIND v(dout1_36) AT=790.05n

.meas tran vdout1_37ck780 FIND v(dout1_37) AT=790.05n

.meas tran vdout1_38ck780 FIND v(dout1_38) AT=790.05n

.meas tran vdout1_39ck780 FIND v(dout1_39) AT=790.05n

.meas tran vdout1_40ck780 FIND v(dout1_40) AT=790.05n

.meas tran vdout1_41ck780 FIND v(dout1_41) AT=790.05n

.meas tran vdout1_42ck780 FIND v(dout1_42) AT=790.05n

.meas tran vdout1_43ck780 FIND v(dout1_43) AT=790.05n

.meas tran vdout1_44ck780 FIND v(dout1_44) AT=790.05n

.meas tran vdout1_45ck780 FIND v(dout1_45) AT=790.05n

.meas tran vdout1_46ck780 FIND v(dout1_46) AT=790.05n

.meas tran vdout1_47ck780 FIND v(dout1_47) AT=790.05n

.meas tran vdout1_48ck780 FIND v(dout1_48) AT=790.05n

.meas tran vdout1_49ck780 FIND v(dout1_49) AT=790.05n

.meas tran vdout1_50ck780 FIND v(dout1_50) AT=790.05n

.meas tran vdout1_51ck780 FIND v(dout1_51) AT=790.05n

.meas tran vdout1_52ck780 FIND v(dout1_52) AT=790.05n

.meas tran vdout1_53ck780 FIND v(dout1_53) AT=790.05n

.meas tran vdout1_54ck780 FIND v(dout1_54) AT=790.05n

.meas tran vdout1_55ck780 FIND v(dout1_55) AT=790.05n

.meas tran vdout1_56ck780 FIND v(dout1_56) AT=790.05n

.meas tran vdout1_57ck780 FIND v(dout1_57) AT=790.05n

.meas tran vdout1_58ck780 FIND v(dout1_58) AT=790.05n

.meas tran vdout1_59ck780 FIND v(dout1_59) AT=790.05n

.meas tran vdout1_60ck780 FIND v(dout1_60) AT=790.05n

.meas tran vdout1_61ck780 FIND v(dout1_61) AT=790.05n

.meas tran vdout1_62ck780 FIND v(dout1_62) AT=790.05n

.meas tran vdout1_63ck780 FIND v(dout1_63) AT=790.05n

.meas tran vdout1_64ck780 FIND v(dout1_64) AT=790.05n

.meas tran vdout1_65ck780 FIND v(dout1_65) AT=790.05n

.meas tran vdout1_66ck780 FIND v(dout1_66) AT=790.05n

.meas tran vdout1_67ck780 FIND v(dout1_67) AT=790.05n

.meas tran vdout1_68ck780 FIND v(dout1_68) AT=790.05n

.meas tran vdout1_69ck780 FIND v(dout1_69) AT=790.05n

.meas tran vdout1_70ck780 FIND v(dout1_70) AT=790.05n

.meas tran vdout1_71ck780 FIND v(dout1_71) AT=790.05n

.meas tran vdout1_72ck780 FIND v(dout1_72) AT=790.05n

.meas tran vdout1_73ck780 FIND v(dout1_73) AT=790.05n

.meas tran vdout1_74ck780 FIND v(dout1_74) AT=790.05n

.meas tran vdout1_75ck780 FIND v(dout1_75) AT=790.05n

.meas tran vdout1_76ck780 FIND v(dout1_76) AT=790.05n

.meas tran vdout1_77ck780 FIND v(dout1_77) AT=790.05n

.meas tran vdout1_78ck780 FIND v(dout1_78) AT=790.05n

.meas tran vdout1_79ck780 FIND v(dout1_79) AT=790.05n

.meas tran vdout1_80ck780 FIND v(dout1_80) AT=790.05n

.meas tran vdout1_81ck780 FIND v(dout1_81) AT=790.05n

.meas tran vdout1_82ck780 FIND v(dout1_82) AT=790.05n

.meas tran vdout1_83ck780 FIND v(dout1_83) AT=790.05n

.meas tran vdout1_84ck780 FIND v(dout1_84) AT=790.05n

.meas tran vdout1_85ck780 FIND v(dout1_85) AT=790.05n

.meas tran vdout1_86ck780 FIND v(dout1_86) AT=790.05n

.meas tran vdout1_87ck780 FIND v(dout1_87) AT=790.05n

.meas tran vdout1_88ck780 FIND v(dout1_88) AT=790.05n

.meas tran vdout1_89ck780 FIND v(dout1_89) AT=790.05n

.meas tran vdout1_90ck780 FIND v(dout1_90) AT=790.05n

.meas tran vdout1_91ck780 FIND v(dout1_91) AT=790.05n

.meas tran vdout1_92ck780 FIND v(dout1_92) AT=790.05n

.meas tran vdout1_93ck780 FIND v(dout1_93) AT=790.05n

.meas tran vdout1_94ck780 FIND v(dout1_94) AT=790.05n

.meas tran vdout1_95ck780 FIND v(dout1_95) AT=790.05n

.meas tran vdout1_96ck780 FIND v(dout1_96) AT=790.05n

.meas tran vdout1_97ck780 FIND v(dout1_97) AT=790.05n

.meas tran vdout1_98ck780 FIND v(dout1_98) AT=790.05n

.meas tran vdout1_99ck780 FIND v(dout1_99) AT=790.05n

.meas tran vdout1_100ck780 FIND v(dout1_100) AT=790.05n

.meas tran vdout1_101ck780 FIND v(dout1_101) AT=790.05n

.meas tran vdout1_102ck780 FIND v(dout1_102) AT=790.05n

.meas tran vdout1_103ck780 FIND v(dout1_103) AT=790.05n

.meas tran vdout1_104ck780 FIND v(dout1_104) AT=790.05n

.meas tran vdout1_105ck780 FIND v(dout1_105) AT=790.05n

.meas tran vdout1_106ck780 FIND v(dout1_106) AT=790.05n

.meas tran vdout1_107ck780 FIND v(dout1_107) AT=790.05n

.meas tran vdout1_108ck780 FIND v(dout1_108) AT=790.05n

.meas tran vdout1_109ck780 FIND v(dout1_109) AT=790.05n

.meas tran vdout1_110ck780 FIND v(dout1_110) AT=790.05n

.meas tran vdout1_111ck780 FIND v(dout1_111) AT=790.05n

.meas tran vdout1_112ck780 FIND v(dout1_112) AT=790.05n

.meas tran vdout1_113ck780 FIND v(dout1_113) AT=790.05n

.meas tran vdout1_114ck780 FIND v(dout1_114) AT=790.05n

.meas tran vdout1_115ck780 FIND v(dout1_115) AT=790.05n

.meas tran vdout1_116ck780 FIND v(dout1_116) AT=790.05n

.meas tran vdout1_117ck780 FIND v(dout1_117) AT=790.05n

.meas tran vdout1_118ck780 FIND v(dout1_118) AT=790.05n

.meas tran vdout1_119ck780 FIND v(dout1_119) AT=790.05n

.meas tran vdout1_120ck780 FIND v(dout1_120) AT=790.05n

.meas tran vdout1_121ck780 FIND v(dout1_121) AT=790.05n

.meas tran vdout1_122ck780 FIND v(dout1_122) AT=790.05n

.meas tran vdout1_123ck780 FIND v(dout1_123) AT=790.05n

.meas tran vdout1_124ck780 FIND v(dout1_124) AT=790.05n

.meas tran vdout1_125ck780 FIND v(dout1_125) AT=790.05n

.meas tran vdout1_126ck780 FIND v(dout1_126) AT=790.05n

.meas tran vdout1_127ck780 FIND v(dout1_127) AT=790.05n

.meas tran vdout1_128ck780 FIND v(dout1_128) AT=790.05n

.meas tran vdout1_129ck780 FIND v(dout1_129) AT=790.05n

.meas tran vdout1_130ck780 FIND v(dout1_130) AT=790.05n

.meas tran vdout1_131ck780 FIND v(dout1_131) AT=790.05n

.meas tran vdout1_132ck780 FIND v(dout1_132) AT=790.05n

.meas tran vdout1_133ck780 FIND v(dout1_133) AT=790.05n

.meas tran vdout1_134ck780 FIND v(dout1_134) AT=790.05n

.meas tran vdout1_135ck780 FIND v(dout1_135) AT=790.05n

.meas tran vdout1_136ck780 FIND v(dout1_136) AT=790.05n

.meas tran vdout1_137ck780 FIND v(dout1_137) AT=790.05n

.meas tran vdout1_138ck780 FIND v(dout1_138) AT=790.05n

.meas tran vdout1_139ck780 FIND v(dout1_139) AT=790.05n

.meas tran vdout1_140ck780 FIND v(dout1_140) AT=790.05n

.meas tran vdout1_141ck780 FIND v(dout1_141) AT=790.05n

.meas tran vdout1_142ck780 FIND v(dout1_142) AT=790.05n

.meas tran vdout1_143ck780 FIND v(dout1_143) AT=790.05n

.meas tran vdout1_144ck780 FIND v(dout1_144) AT=790.05n

.meas tran vdout1_145ck780 FIND v(dout1_145) AT=790.05n

.meas tran vdout1_146ck780 FIND v(dout1_146) AT=790.05n

.meas tran vdout1_147ck780 FIND v(dout1_147) AT=790.05n

.meas tran vdout1_148ck780 FIND v(dout1_148) AT=790.05n

.meas tran vdout1_149ck780 FIND v(dout1_149) AT=790.05n

.meas tran vdout1_150ck780 FIND v(dout1_150) AT=790.05n

.meas tran vdout1_151ck780 FIND v(dout1_151) AT=790.05n

.meas tran vdout1_152ck780 FIND v(dout1_152) AT=790.05n

.meas tran vdout1_153ck780 FIND v(dout1_153) AT=790.05n

.meas tran vdout1_154ck780 FIND v(dout1_154) AT=790.05n

.meas tran vdout1_155ck780 FIND v(dout1_155) AT=790.05n

.meas tran vdout1_156ck780 FIND v(dout1_156) AT=790.05n

.meas tran vdout1_157ck780 FIND v(dout1_157) AT=790.05n

.meas tran vdout1_158ck780 FIND v(dout1_158) AT=790.05n

.meas tran vdout1_159ck780 FIND v(dout1_159) AT=790.05n

.meas tran vdout1_160ck780 FIND v(dout1_160) AT=790.05n

.meas tran vdout1_161ck780 FIND v(dout1_161) AT=790.05n

.meas tran vdout1_162ck780 FIND v(dout1_162) AT=790.05n

.meas tran vdout1_163ck780 FIND v(dout1_163) AT=790.05n

.meas tran vdout1_164ck780 FIND v(dout1_164) AT=790.05n

.meas tran vdout1_165ck780 FIND v(dout1_165) AT=790.05n

.meas tran vdout1_166ck780 FIND v(dout1_166) AT=790.05n

.meas tran vdout1_167ck780 FIND v(dout1_167) AT=790.05n

.meas tran vdout1_168ck780 FIND v(dout1_168) AT=790.05n

.meas tran vdout1_169ck780 FIND v(dout1_169) AT=790.05n

.meas tran vdout1_170ck780 FIND v(dout1_170) AT=790.05n

.meas tran vdout1_171ck780 FIND v(dout1_171) AT=790.05n

.meas tran vdout1_172ck780 FIND v(dout1_172) AT=790.05n

.meas tran vdout1_173ck780 FIND v(dout1_173) AT=790.05n

.meas tran vdout1_174ck780 FIND v(dout1_174) AT=790.05n

.meas tran vdout1_175ck780 FIND v(dout1_175) AT=790.05n

.meas tran vdout1_176ck780 FIND v(dout1_176) AT=790.05n

.meas tran vdout1_177ck780 FIND v(dout1_177) AT=790.05n

.meas tran vdout1_178ck780 FIND v(dout1_178) AT=790.05n

.meas tran vdout1_179ck780 FIND v(dout1_179) AT=790.05n

.meas tran vdout1_180ck780 FIND v(dout1_180) AT=790.05n

.meas tran vdout1_181ck780 FIND v(dout1_181) AT=790.05n

.meas tran vdout1_182ck780 FIND v(dout1_182) AT=790.05n

.meas tran vdout1_183ck780 FIND v(dout1_183) AT=790.05n

.meas tran vdout1_184ck780 FIND v(dout1_184) AT=790.05n

.meas tran vdout1_185ck780 FIND v(dout1_185) AT=790.05n

.meas tran vdout1_186ck780 FIND v(dout1_186) AT=790.05n

.meas tran vdout1_187ck780 FIND v(dout1_187) AT=790.05n

.meas tran vdout1_188ck780 FIND v(dout1_188) AT=790.05n

.meas tran vdout1_189ck780 FIND v(dout1_189) AT=790.05n

.meas tran vdout1_190ck780 FIND v(dout1_190) AT=790.05n

.meas tran vdout1_191ck780 FIND v(dout1_191) AT=790.05n

.meas tran vdout1_192ck780 FIND v(dout1_192) AT=790.05n

.meas tran vdout1_193ck780 FIND v(dout1_193) AT=790.05n

.meas tran vdout1_194ck780 FIND v(dout1_194) AT=790.05n

.meas tran vdout1_195ck780 FIND v(dout1_195) AT=790.05n

.meas tran vdout1_196ck780 FIND v(dout1_196) AT=790.05n

.meas tran vdout1_197ck780 FIND v(dout1_197) AT=790.05n

.meas tran vdout1_198ck780 FIND v(dout1_198) AT=790.05n

.meas tran vdout1_199ck780 FIND v(dout1_199) AT=790.05n

.meas tran vdout1_200ck780 FIND v(dout1_200) AT=790.05n

.meas tran vdout1_201ck780 FIND v(dout1_201) AT=790.05n

.meas tran vdout1_202ck780 FIND v(dout1_202) AT=790.05n

.meas tran vdout1_203ck780 FIND v(dout1_203) AT=790.05n

.meas tran vdout1_204ck780 FIND v(dout1_204) AT=790.05n

.meas tran vdout1_205ck780 FIND v(dout1_205) AT=790.05n

.meas tran vdout1_206ck780 FIND v(dout1_206) AT=790.05n

.meas tran vdout1_207ck780 FIND v(dout1_207) AT=790.05n

.meas tran vdout1_208ck780 FIND v(dout1_208) AT=790.05n

.meas tran vdout1_209ck780 FIND v(dout1_209) AT=790.05n

.meas tran vdout1_210ck780 FIND v(dout1_210) AT=790.05n

.meas tran vdout1_211ck780 FIND v(dout1_211) AT=790.05n

.meas tran vdout1_212ck780 FIND v(dout1_212) AT=790.05n

.meas tran vdout1_213ck780 FIND v(dout1_213) AT=790.05n

.meas tran vdout1_214ck780 FIND v(dout1_214) AT=790.05n

.meas tran vdout1_215ck780 FIND v(dout1_215) AT=790.05n

.meas tran vdout1_216ck780 FIND v(dout1_216) AT=790.05n

.meas tran vdout1_217ck780 FIND v(dout1_217) AT=790.05n

.meas tran vdout1_218ck780 FIND v(dout1_218) AT=790.05n

.meas tran vdout1_219ck780 FIND v(dout1_219) AT=790.05n

.meas tran vdout1_220ck780 FIND v(dout1_220) AT=790.05n

.meas tran vdout1_221ck780 FIND v(dout1_221) AT=790.05n

.meas tran vdout1_222ck780 FIND v(dout1_222) AT=790.05n

.meas tran vdout1_223ck780 FIND v(dout1_223) AT=790.05n

.meas tran vdout1_224ck780 FIND v(dout1_224) AT=790.05n

.meas tran vdout1_225ck780 FIND v(dout1_225) AT=790.05n

.meas tran vdout1_226ck780 FIND v(dout1_226) AT=790.05n

.meas tran vdout1_227ck780 FIND v(dout1_227) AT=790.05n

.meas tran vdout1_228ck780 FIND v(dout1_228) AT=790.05n

.meas tran vdout1_229ck780 FIND v(dout1_229) AT=790.05n

.meas tran vdout1_230ck780 FIND v(dout1_230) AT=790.05n

.meas tran vdout1_231ck780 FIND v(dout1_231) AT=790.05n

.meas tran vdout1_232ck780 FIND v(dout1_232) AT=790.05n

.meas tran vdout1_233ck780 FIND v(dout1_233) AT=790.05n

.meas tran vdout1_234ck780 FIND v(dout1_234) AT=790.05n

.meas tran vdout1_235ck780 FIND v(dout1_235) AT=790.05n

.meas tran vdout1_236ck780 FIND v(dout1_236) AT=790.05n

.meas tran vdout1_237ck780 FIND v(dout1_237) AT=790.05n

.meas tran vdout1_238ck780 FIND v(dout1_238) AT=790.05n

.meas tran vdout1_239ck780 FIND v(dout1_239) AT=790.05n

.meas tran vdout1_240ck780 FIND v(dout1_240) AT=790.05n

.meas tran vdout1_241ck780 FIND v(dout1_241) AT=790.05n

.meas tran vdout1_242ck780 FIND v(dout1_242) AT=790.05n

.meas tran vdout1_243ck780 FIND v(dout1_243) AT=790.05n

.meas tran vdout1_244ck780 FIND v(dout1_244) AT=790.05n

.meas tran vdout1_245ck780 FIND v(dout1_245) AT=790.05n

.meas tran vdout1_246ck780 FIND v(dout1_246) AT=790.05n

.meas tran vdout1_247ck780 FIND v(dout1_247) AT=790.05n

.meas tran vdout1_248ck780 FIND v(dout1_248) AT=790.05n

.meas tran vdout1_249ck780 FIND v(dout1_249) AT=790.05n

.meas tran vdout1_250ck780 FIND v(dout1_250) AT=790.05n

.meas tran vdout1_251ck780 FIND v(dout1_251) AT=790.05n

.meas tran vdout1_252ck780 FIND v(dout1_252) AT=790.05n

.meas tran vdout1_253ck780 FIND v(dout1_253) AT=790.05n

.meas tran vdout1_254ck780 FIND v(dout1_254) AT=790.05n

.meas tran vdout1_255ck780 FIND v(dout1_255) AT=790.05n

.meas tran vdout1_256ck780 FIND v(dout1_256) AT=790.05n

.meas tran vdout1_0ck800 FIND v(dout1_0) AT=810.05n

.meas tran vdout1_1ck800 FIND v(dout1_1) AT=810.05n

.meas tran vdout1_2ck800 FIND v(dout1_2) AT=810.05n

.meas tran vdout1_3ck800 FIND v(dout1_3) AT=810.05n

.meas tran vdout1_4ck800 FIND v(dout1_4) AT=810.05n

.meas tran vdout1_5ck800 FIND v(dout1_5) AT=810.05n

.meas tran vdout1_6ck800 FIND v(dout1_6) AT=810.05n

.meas tran vdout1_7ck800 FIND v(dout1_7) AT=810.05n

.meas tran vdout1_8ck800 FIND v(dout1_8) AT=810.05n

.meas tran vdout1_9ck800 FIND v(dout1_9) AT=810.05n

.meas tran vdout1_10ck800 FIND v(dout1_10) AT=810.05n

.meas tran vdout1_11ck800 FIND v(dout1_11) AT=810.05n

.meas tran vdout1_12ck800 FIND v(dout1_12) AT=810.05n

.meas tran vdout1_13ck800 FIND v(dout1_13) AT=810.05n

.meas tran vdout1_14ck800 FIND v(dout1_14) AT=810.05n

.meas tran vdout1_15ck800 FIND v(dout1_15) AT=810.05n

.meas tran vdout1_16ck800 FIND v(dout1_16) AT=810.05n

.meas tran vdout1_17ck800 FIND v(dout1_17) AT=810.05n

.meas tran vdout1_18ck800 FIND v(dout1_18) AT=810.05n

.meas tran vdout1_19ck800 FIND v(dout1_19) AT=810.05n

.meas tran vdout1_20ck800 FIND v(dout1_20) AT=810.05n

.meas tran vdout1_21ck800 FIND v(dout1_21) AT=810.05n

.meas tran vdout1_22ck800 FIND v(dout1_22) AT=810.05n

.meas tran vdout1_23ck800 FIND v(dout1_23) AT=810.05n

.meas tran vdout1_24ck800 FIND v(dout1_24) AT=810.05n

.meas tran vdout1_25ck800 FIND v(dout1_25) AT=810.05n

.meas tran vdout1_26ck800 FIND v(dout1_26) AT=810.05n

.meas tran vdout1_27ck800 FIND v(dout1_27) AT=810.05n

.meas tran vdout1_28ck800 FIND v(dout1_28) AT=810.05n

.meas tran vdout1_29ck800 FIND v(dout1_29) AT=810.05n

.meas tran vdout1_30ck800 FIND v(dout1_30) AT=810.05n

.meas tran vdout1_31ck800 FIND v(dout1_31) AT=810.05n

.meas tran vdout1_32ck800 FIND v(dout1_32) AT=810.05n

.meas tran vdout1_33ck800 FIND v(dout1_33) AT=810.05n

.meas tran vdout1_34ck800 FIND v(dout1_34) AT=810.05n

.meas tran vdout1_35ck800 FIND v(dout1_35) AT=810.05n

.meas tran vdout1_36ck800 FIND v(dout1_36) AT=810.05n

.meas tran vdout1_37ck800 FIND v(dout1_37) AT=810.05n

.meas tran vdout1_38ck800 FIND v(dout1_38) AT=810.05n

.meas tran vdout1_39ck800 FIND v(dout1_39) AT=810.05n

.meas tran vdout1_40ck800 FIND v(dout1_40) AT=810.05n

.meas tran vdout1_41ck800 FIND v(dout1_41) AT=810.05n

.meas tran vdout1_42ck800 FIND v(dout1_42) AT=810.05n

.meas tran vdout1_43ck800 FIND v(dout1_43) AT=810.05n

.meas tran vdout1_44ck800 FIND v(dout1_44) AT=810.05n

.meas tran vdout1_45ck800 FIND v(dout1_45) AT=810.05n

.meas tran vdout1_46ck800 FIND v(dout1_46) AT=810.05n

.meas tran vdout1_47ck800 FIND v(dout1_47) AT=810.05n

.meas tran vdout1_48ck800 FIND v(dout1_48) AT=810.05n

.meas tran vdout1_49ck800 FIND v(dout1_49) AT=810.05n

.meas tran vdout1_50ck800 FIND v(dout1_50) AT=810.05n

.meas tran vdout1_51ck800 FIND v(dout1_51) AT=810.05n

.meas tran vdout1_52ck800 FIND v(dout1_52) AT=810.05n

.meas tran vdout1_53ck800 FIND v(dout1_53) AT=810.05n

.meas tran vdout1_54ck800 FIND v(dout1_54) AT=810.05n

.meas tran vdout1_55ck800 FIND v(dout1_55) AT=810.05n

.meas tran vdout1_56ck800 FIND v(dout1_56) AT=810.05n

.meas tran vdout1_57ck800 FIND v(dout1_57) AT=810.05n

.meas tran vdout1_58ck800 FIND v(dout1_58) AT=810.05n

.meas tran vdout1_59ck800 FIND v(dout1_59) AT=810.05n

.meas tran vdout1_60ck800 FIND v(dout1_60) AT=810.05n

.meas tran vdout1_61ck800 FIND v(dout1_61) AT=810.05n

.meas tran vdout1_62ck800 FIND v(dout1_62) AT=810.05n

.meas tran vdout1_63ck800 FIND v(dout1_63) AT=810.05n

.meas tran vdout1_64ck800 FIND v(dout1_64) AT=810.05n

.meas tran vdout1_65ck800 FIND v(dout1_65) AT=810.05n

.meas tran vdout1_66ck800 FIND v(dout1_66) AT=810.05n

.meas tran vdout1_67ck800 FIND v(dout1_67) AT=810.05n

.meas tran vdout1_68ck800 FIND v(dout1_68) AT=810.05n

.meas tran vdout1_69ck800 FIND v(dout1_69) AT=810.05n

.meas tran vdout1_70ck800 FIND v(dout1_70) AT=810.05n

.meas tran vdout1_71ck800 FIND v(dout1_71) AT=810.05n

.meas tran vdout1_72ck800 FIND v(dout1_72) AT=810.05n

.meas tran vdout1_73ck800 FIND v(dout1_73) AT=810.05n

.meas tran vdout1_74ck800 FIND v(dout1_74) AT=810.05n

.meas tran vdout1_75ck800 FIND v(dout1_75) AT=810.05n

.meas tran vdout1_76ck800 FIND v(dout1_76) AT=810.05n

.meas tran vdout1_77ck800 FIND v(dout1_77) AT=810.05n

.meas tran vdout1_78ck800 FIND v(dout1_78) AT=810.05n

.meas tran vdout1_79ck800 FIND v(dout1_79) AT=810.05n

.meas tran vdout1_80ck800 FIND v(dout1_80) AT=810.05n

.meas tran vdout1_81ck800 FIND v(dout1_81) AT=810.05n

.meas tran vdout1_82ck800 FIND v(dout1_82) AT=810.05n

.meas tran vdout1_83ck800 FIND v(dout1_83) AT=810.05n

.meas tran vdout1_84ck800 FIND v(dout1_84) AT=810.05n

.meas tran vdout1_85ck800 FIND v(dout1_85) AT=810.05n

.meas tran vdout1_86ck800 FIND v(dout1_86) AT=810.05n

.meas tran vdout1_87ck800 FIND v(dout1_87) AT=810.05n

.meas tran vdout1_88ck800 FIND v(dout1_88) AT=810.05n

.meas tran vdout1_89ck800 FIND v(dout1_89) AT=810.05n

.meas tran vdout1_90ck800 FIND v(dout1_90) AT=810.05n

.meas tran vdout1_91ck800 FIND v(dout1_91) AT=810.05n

.meas tran vdout1_92ck800 FIND v(dout1_92) AT=810.05n

.meas tran vdout1_93ck800 FIND v(dout1_93) AT=810.05n

.meas tran vdout1_94ck800 FIND v(dout1_94) AT=810.05n

.meas tran vdout1_95ck800 FIND v(dout1_95) AT=810.05n

.meas tran vdout1_96ck800 FIND v(dout1_96) AT=810.05n

.meas tran vdout1_97ck800 FIND v(dout1_97) AT=810.05n

.meas tran vdout1_98ck800 FIND v(dout1_98) AT=810.05n

.meas tran vdout1_99ck800 FIND v(dout1_99) AT=810.05n

.meas tran vdout1_100ck800 FIND v(dout1_100) AT=810.05n

.meas tran vdout1_101ck800 FIND v(dout1_101) AT=810.05n

.meas tran vdout1_102ck800 FIND v(dout1_102) AT=810.05n

.meas tran vdout1_103ck800 FIND v(dout1_103) AT=810.05n

.meas tran vdout1_104ck800 FIND v(dout1_104) AT=810.05n

.meas tran vdout1_105ck800 FIND v(dout1_105) AT=810.05n

.meas tran vdout1_106ck800 FIND v(dout1_106) AT=810.05n

.meas tran vdout1_107ck800 FIND v(dout1_107) AT=810.05n

.meas tran vdout1_108ck800 FIND v(dout1_108) AT=810.05n

.meas tran vdout1_109ck800 FIND v(dout1_109) AT=810.05n

.meas tran vdout1_110ck800 FIND v(dout1_110) AT=810.05n

.meas tran vdout1_111ck800 FIND v(dout1_111) AT=810.05n

.meas tran vdout1_112ck800 FIND v(dout1_112) AT=810.05n

.meas tran vdout1_113ck800 FIND v(dout1_113) AT=810.05n

.meas tran vdout1_114ck800 FIND v(dout1_114) AT=810.05n

.meas tran vdout1_115ck800 FIND v(dout1_115) AT=810.05n

.meas tran vdout1_116ck800 FIND v(dout1_116) AT=810.05n

.meas tran vdout1_117ck800 FIND v(dout1_117) AT=810.05n

.meas tran vdout1_118ck800 FIND v(dout1_118) AT=810.05n

.meas tran vdout1_119ck800 FIND v(dout1_119) AT=810.05n

.meas tran vdout1_120ck800 FIND v(dout1_120) AT=810.05n

.meas tran vdout1_121ck800 FIND v(dout1_121) AT=810.05n

.meas tran vdout1_122ck800 FIND v(dout1_122) AT=810.05n

.meas tran vdout1_123ck800 FIND v(dout1_123) AT=810.05n

.meas tran vdout1_124ck800 FIND v(dout1_124) AT=810.05n

.meas tran vdout1_125ck800 FIND v(dout1_125) AT=810.05n

.meas tran vdout1_126ck800 FIND v(dout1_126) AT=810.05n

.meas tran vdout1_127ck800 FIND v(dout1_127) AT=810.05n

.meas tran vdout1_128ck800 FIND v(dout1_128) AT=810.05n

.meas tran vdout1_129ck800 FIND v(dout1_129) AT=810.05n

.meas tran vdout1_130ck800 FIND v(dout1_130) AT=810.05n

.meas tran vdout1_131ck800 FIND v(dout1_131) AT=810.05n

.meas tran vdout1_132ck800 FIND v(dout1_132) AT=810.05n

.meas tran vdout1_133ck800 FIND v(dout1_133) AT=810.05n

.meas tran vdout1_134ck800 FIND v(dout1_134) AT=810.05n

.meas tran vdout1_135ck800 FIND v(dout1_135) AT=810.05n

.meas tran vdout1_136ck800 FIND v(dout1_136) AT=810.05n

.meas tran vdout1_137ck800 FIND v(dout1_137) AT=810.05n

.meas tran vdout1_138ck800 FIND v(dout1_138) AT=810.05n

.meas tran vdout1_139ck800 FIND v(dout1_139) AT=810.05n

.meas tran vdout1_140ck800 FIND v(dout1_140) AT=810.05n

.meas tran vdout1_141ck800 FIND v(dout1_141) AT=810.05n

.meas tran vdout1_142ck800 FIND v(dout1_142) AT=810.05n

.meas tran vdout1_143ck800 FIND v(dout1_143) AT=810.05n

.meas tran vdout1_144ck800 FIND v(dout1_144) AT=810.05n

.meas tran vdout1_145ck800 FIND v(dout1_145) AT=810.05n

.meas tran vdout1_146ck800 FIND v(dout1_146) AT=810.05n

.meas tran vdout1_147ck800 FIND v(dout1_147) AT=810.05n

.meas tran vdout1_148ck800 FIND v(dout1_148) AT=810.05n

.meas tran vdout1_149ck800 FIND v(dout1_149) AT=810.05n

.meas tran vdout1_150ck800 FIND v(dout1_150) AT=810.05n

.meas tran vdout1_151ck800 FIND v(dout1_151) AT=810.05n

.meas tran vdout1_152ck800 FIND v(dout1_152) AT=810.05n

.meas tran vdout1_153ck800 FIND v(dout1_153) AT=810.05n

.meas tran vdout1_154ck800 FIND v(dout1_154) AT=810.05n

.meas tran vdout1_155ck800 FIND v(dout1_155) AT=810.05n

.meas tran vdout1_156ck800 FIND v(dout1_156) AT=810.05n

.meas tran vdout1_157ck800 FIND v(dout1_157) AT=810.05n

.meas tran vdout1_158ck800 FIND v(dout1_158) AT=810.05n

.meas tran vdout1_159ck800 FIND v(dout1_159) AT=810.05n

.meas tran vdout1_160ck800 FIND v(dout1_160) AT=810.05n

.meas tran vdout1_161ck800 FIND v(dout1_161) AT=810.05n

.meas tran vdout1_162ck800 FIND v(dout1_162) AT=810.05n

.meas tran vdout1_163ck800 FIND v(dout1_163) AT=810.05n

.meas tran vdout1_164ck800 FIND v(dout1_164) AT=810.05n

.meas tran vdout1_165ck800 FIND v(dout1_165) AT=810.05n

.meas tran vdout1_166ck800 FIND v(dout1_166) AT=810.05n

.meas tran vdout1_167ck800 FIND v(dout1_167) AT=810.05n

.meas tran vdout1_168ck800 FIND v(dout1_168) AT=810.05n

.meas tran vdout1_169ck800 FIND v(dout1_169) AT=810.05n

.meas tran vdout1_170ck800 FIND v(dout1_170) AT=810.05n

.meas tran vdout1_171ck800 FIND v(dout1_171) AT=810.05n

.meas tran vdout1_172ck800 FIND v(dout1_172) AT=810.05n

.meas tran vdout1_173ck800 FIND v(dout1_173) AT=810.05n

.meas tran vdout1_174ck800 FIND v(dout1_174) AT=810.05n

.meas tran vdout1_175ck800 FIND v(dout1_175) AT=810.05n

.meas tran vdout1_176ck800 FIND v(dout1_176) AT=810.05n

.meas tran vdout1_177ck800 FIND v(dout1_177) AT=810.05n

.meas tran vdout1_178ck800 FIND v(dout1_178) AT=810.05n

.meas tran vdout1_179ck800 FIND v(dout1_179) AT=810.05n

.meas tran vdout1_180ck800 FIND v(dout1_180) AT=810.05n

.meas tran vdout1_181ck800 FIND v(dout1_181) AT=810.05n

.meas tran vdout1_182ck800 FIND v(dout1_182) AT=810.05n

.meas tran vdout1_183ck800 FIND v(dout1_183) AT=810.05n

.meas tran vdout1_184ck800 FIND v(dout1_184) AT=810.05n

.meas tran vdout1_185ck800 FIND v(dout1_185) AT=810.05n

.meas tran vdout1_186ck800 FIND v(dout1_186) AT=810.05n

.meas tran vdout1_187ck800 FIND v(dout1_187) AT=810.05n

.meas tran vdout1_188ck800 FIND v(dout1_188) AT=810.05n

.meas tran vdout1_189ck800 FIND v(dout1_189) AT=810.05n

.meas tran vdout1_190ck800 FIND v(dout1_190) AT=810.05n

.meas tran vdout1_191ck800 FIND v(dout1_191) AT=810.05n

.meas tran vdout1_192ck800 FIND v(dout1_192) AT=810.05n

.meas tran vdout1_193ck800 FIND v(dout1_193) AT=810.05n

.meas tran vdout1_194ck800 FIND v(dout1_194) AT=810.05n

.meas tran vdout1_195ck800 FIND v(dout1_195) AT=810.05n

.meas tran vdout1_196ck800 FIND v(dout1_196) AT=810.05n

.meas tran vdout1_197ck800 FIND v(dout1_197) AT=810.05n

.meas tran vdout1_198ck800 FIND v(dout1_198) AT=810.05n

.meas tran vdout1_199ck800 FIND v(dout1_199) AT=810.05n

.meas tran vdout1_200ck800 FIND v(dout1_200) AT=810.05n

.meas tran vdout1_201ck800 FIND v(dout1_201) AT=810.05n

.meas tran vdout1_202ck800 FIND v(dout1_202) AT=810.05n

.meas tran vdout1_203ck800 FIND v(dout1_203) AT=810.05n

.meas tran vdout1_204ck800 FIND v(dout1_204) AT=810.05n

.meas tran vdout1_205ck800 FIND v(dout1_205) AT=810.05n

.meas tran vdout1_206ck800 FIND v(dout1_206) AT=810.05n

.meas tran vdout1_207ck800 FIND v(dout1_207) AT=810.05n

.meas tran vdout1_208ck800 FIND v(dout1_208) AT=810.05n

.meas tran vdout1_209ck800 FIND v(dout1_209) AT=810.05n

.meas tran vdout1_210ck800 FIND v(dout1_210) AT=810.05n

.meas tran vdout1_211ck800 FIND v(dout1_211) AT=810.05n

.meas tran vdout1_212ck800 FIND v(dout1_212) AT=810.05n

.meas tran vdout1_213ck800 FIND v(dout1_213) AT=810.05n

.meas tran vdout1_214ck800 FIND v(dout1_214) AT=810.05n

.meas tran vdout1_215ck800 FIND v(dout1_215) AT=810.05n

.meas tran vdout1_216ck800 FIND v(dout1_216) AT=810.05n

.meas tran vdout1_217ck800 FIND v(dout1_217) AT=810.05n

.meas tran vdout1_218ck800 FIND v(dout1_218) AT=810.05n

.meas tran vdout1_219ck800 FIND v(dout1_219) AT=810.05n

.meas tran vdout1_220ck800 FIND v(dout1_220) AT=810.05n

.meas tran vdout1_221ck800 FIND v(dout1_221) AT=810.05n

.meas tran vdout1_222ck800 FIND v(dout1_222) AT=810.05n

.meas tran vdout1_223ck800 FIND v(dout1_223) AT=810.05n

.meas tran vdout1_224ck800 FIND v(dout1_224) AT=810.05n

.meas tran vdout1_225ck800 FIND v(dout1_225) AT=810.05n

.meas tran vdout1_226ck800 FIND v(dout1_226) AT=810.05n

.meas tran vdout1_227ck800 FIND v(dout1_227) AT=810.05n

.meas tran vdout1_228ck800 FIND v(dout1_228) AT=810.05n

.meas tran vdout1_229ck800 FIND v(dout1_229) AT=810.05n

.meas tran vdout1_230ck800 FIND v(dout1_230) AT=810.05n

.meas tran vdout1_231ck800 FIND v(dout1_231) AT=810.05n

.meas tran vdout1_232ck800 FIND v(dout1_232) AT=810.05n

.meas tran vdout1_233ck800 FIND v(dout1_233) AT=810.05n

.meas tran vdout1_234ck800 FIND v(dout1_234) AT=810.05n

.meas tran vdout1_235ck800 FIND v(dout1_235) AT=810.05n

.meas tran vdout1_236ck800 FIND v(dout1_236) AT=810.05n

.meas tran vdout1_237ck800 FIND v(dout1_237) AT=810.05n

.meas tran vdout1_238ck800 FIND v(dout1_238) AT=810.05n

.meas tran vdout1_239ck800 FIND v(dout1_239) AT=810.05n

.meas tran vdout1_240ck800 FIND v(dout1_240) AT=810.05n

.meas tran vdout1_241ck800 FIND v(dout1_241) AT=810.05n

.meas tran vdout1_242ck800 FIND v(dout1_242) AT=810.05n

.meas tran vdout1_243ck800 FIND v(dout1_243) AT=810.05n

.meas tran vdout1_244ck800 FIND v(dout1_244) AT=810.05n

.meas tran vdout1_245ck800 FIND v(dout1_245) AT=810.05n

.meas tran vdout1_246ck800 FIND v(dout1_246) AT=810.05n

.meas tran vdout1_247ck800 FIND v(dout1_247) AT=810.05n

.meas tran vdout1_248ck800 FIND v(dout1_248) AT=810.05n

.meas tran vdout1_249ck800 FIND v(dout1_249) AT=810.05n

.meas tran vdout1_250ck800 FIND v(dout1_250) AT=810.05n

.meas tran vdout1_251ck800 FIND v(dout1_251) AT=810.05n

.meas tran vdout1_252ck800 FIND v(dout1_252) AT=810.05n

.meas tran vdout1_253ck800 FIND v(dout1_253) AT=810.05n

.meas tran vdout1_254ck800 FIND v(dout1_254) AT=810.05n

.meas tran vdout1_255ck800 FIND v(dout1_255) AT=810.05n

.meas tran vdout1_256ck800 FIND v(dout1_256) AT=810.05n

.meas tran vdout1_0ck820 FIND v(dout1_0) AT=830.05n

.meas tran vdout1_1ck820 FIND v(dout1_1) AT=830.05n

.meas tran vdout1_2ck820 FIND v(dout1_2) AT=830.05n

.meas tran vdout1_3ck820 FIND v(dout1_3) AT=830.05n

.meas tran vdout1_4ck820 FIND v(dout1_4) AT=830.05n

.meas tran vdout1_5ck820 FIND v(dout1_5) AT=830.05n

.meas tran vdout1_6ck820 FIND v(dout1_6) AT=830.05n

.meas tran vdout1_7ck820 FIND v(dout1_7) AT=830.05n

.meas tran vdout1_8ck820 FIND v(dout1_8) AT=830.05n

.meas tran vdout1_9ck820 FIND v(dout1_9) AT=830.05n

.meas tran vdout1_10ck820 FIND v(dout1_10) AT=830.05n

.meas tran vdout1_11ck820 FIND v(dout1_11) AT=830.05n

.meas tran vdout1_12ck820 FIND v(dout1_12) AT=830.05n

.meas tran vdout1_13ck820 FIND v(dout1_13) AT=830.05n

.meas tran vdout1_14ck820 FIND v(dout1_14) AT=830.05n

.meas tran vdout1_15ck820 FIND v(dout1_15) AT=830.05n

.meas tran vdout1_16ck820 FIND v(dout1_16) AT=830.05n

.meas tran vdout1_17ck820 FIND v(dout1_17) AT=830.05n

.meas tran vdout1_18ck820 FIND v(dout1_18) AT=830.05n

.meas tran vdout1_19ck820 FIND v(dout1_19) AT=830.05n

.meas tran vdout1_20ck820 FIND v(dout1_20) AT=830.05n

.meas tran vdout1_21ck820 FIND v(dout1_21) AT=830.05n

.meas tran vdout1_22ck820 FIND v(dout1_22) AT=830.05n

.meas tran vdout1_23ck820 FIND v(dout1_23) AT=830.05n

.meas tran vdout1_24ck820 FIND v(dout1_24) AT=830.05n

.meas tran vdout1_25ck820 FIND v(dout1_25) AT=830.05n

.meas tran vdout1_26ck820 FIND v(dout1_26) AT=830.05n

.meas tran vdout1_27ck820 FIND v(dout1_27) AT=830.05n

.meas tran vdout1_28ck820 FIND v(dout1_28) AT=830.05n

.meas tran vdout1_29ck820 FIND v(dout1_29) AT=830.05n

.meas tran vdout1_30ck820 FIND v(dout1_30) AT=830.05n

.meas tran vdout1_31ck820 FIND v(dout1_31) AT=830.05n

.meas tran vdout1_32ck820 FIND v(dout1_32) AT=830.05n

.meas tran vdout1_33ck820 FIND v(dout1_33) AT=830.05n

.meas tran vdout1_34ck820 FIND v(dout1_34) AT=830.05n

.meas tran vdout1_35ck820 FIND v(dout1_35) AT=830.05n

.meas tran vdout1_36ck820 FIND v(dout1_36) AT=830.05n

.meas tran vdout1_37ck820 FIND v(dout1_37) AT=830.05n

.meas tran vdout1_38ck820 FIND v(dout1_38) AT=830.05n

.meas tran vdout1_39ck820 FIND v(dout1_39) AT=830.05n

.meas tran vdout1_40ck820 FIND v(dout1_40) AT=830.05n

.meas tran vdout1_41ck820 FIND v(dout1_41) AT=830.05n

.meas tran vdout1_42ck820 FIND v(dout1_42) AT=830.05n

.meas tran vdout1_43ck820 FIND v(dout1_43) AT=830.05n

.meas tran vdout1_44ck820 FIND v(dout1_44) AT=830.05n

.meas tran vdout1_45ck820 FIND v(dout1_45) AT=830.05n

.meas tran vdout1_46ck820 FIND v(dout1_46) AT=830.05n

.meas tran vdout1_47ck820 FIND v(dout1_47) AT=830.05n

.meas tran vdout1_48ck820 FIND v(dout1_48) AT=830.05n

.meas tran vdout1_49ck820 FIND v(dout1_49) AT=830.05n

.meas tran vdout1_50ck820 FIND v(dout1_50) AT=830.05n

.meas tran vdout1_51ck820 FIND v(dout1_51) AT=830.05n

.meas tran vdout1_52ck820 FIND v(dout1_52) AT=830.05n

.meas tran vdout1_53ck820 FIND v(dout1_53) AT=830.05n

.meas tran vdout1_54ck820 FIND v(dout1_54) AT=830.05n

.meas tran vdout1_55ck820 FIND v(dout1_55) AT=830.05n

.meas tran vdout1_56ck820 FIND v(dout1_56) AT=830.05n

.meas tran vdout1_57ck820 FIND v(dout1_57) AT=830.05n

.meas tran vdout1_58ck820 FIND v(dout1_58) AT=830.05n

.meas tran vdout1_59ck820 FIND v(dout1_59) AT=830.05n

.meas tran vdout1_60ck820 FIND v(dout1_60) AT=830.05n

.meas tran vdout1_61ck820 FIND v(dout1_61) AT=830.05n

.meas tran vdout1_62ck820 FIND v(dout1_62) AT=830.05n

.meas tran vdout1_63ck820 FIND v(dout1_63) AT=830.05n

.meas tran vdout1_64ck820 FIND v(dout1_64) AT=830.05n

.meas tran vdout1_65ck820 FIND v(dout1_65) AT=830.05n

.meas tran vdout1_66ck820 FIND v(dout1_66) AT=830.05n

.meas tran vdout1_67ck820 FIND v(dout1_67) AT=830.05n

.meas tran vdout1_68ck820 FIND v(dout1_68) AT=830.05n

.meas tran vdout1_69ck820 FIND v(dout1_69) AT=830.05n

.meas tran vdout1_70ck820 FIND v(dout1_70) AT=830.05n

.meas tran vdout1_71ck820 FIND v(dout1_71) AT=830.05n

.meas tran vdout1_72ck820 FIND v(dout1_72) AT=830.05n

.meas tran vdout1_73ck820 FIND v(dout1_73) AT=830.05n

.meas tran vdout1_74ck820 FIND v(dout1_74) AT=830.05n

.meas tran vdout1_75ck820 FIND v(dout1_75) AT=830.05n

.meas tran vdout1_76ck820 FIND v(dout1_76) AT=830.05n

.meas tran vdout1_77ck820 FIND v(dout1_77) AT=830.05n

.meas tran vdout1_78ck820 FIND v(dout1_78) AT=830.05n

.meas tran vdout1_79ck820 FIND v(dout1_79) AT=830.05n

.meas tran vdout1_80ck820 FIND v(dout1_80) AT=830.05n

.meas tran vdout1_81ck820 FIND v(dout1_81) AT=830.05n

.meas tran vdout1_82ck820 FIND v(dout1_82) AT=830.05n

.meas tran vdout1_83ck820 FIND v(dout1_83) AT=830.05n

.meas tran vdout1_84ck820 FIND v(dout1_84) AT=830.05n

.meas tran vdout1_85ck820 FIND v(dout1_85) AT=830.05n

.meas tran vdout1_86ck820 FIND v(dout1_86) AT=830.05n

.meas tran vdout1_87ck820 FIND v(dout1_87) AT=830.05n

.meas tran vdout1_88ck820 FIND v(dout1_88) AT=830.05n

.meas tran vdout1_89ck820 FIND v(dout1_89) AT=830.05n

.meas tran vdout1_90ck820 FIND v(dout1_90) AT=830.05n

.meas tran vdout1_91ck820 FIND v(dout1_91) AT=830.05n

.meas tran vdout1_92ck820 FIND v(dout1_92) AT=830.05n

.meas tran vdout1_93ck820 FIND v(dout1_93) AT=830.05n

.meas tran vdout1_94ck820 FIND v(dout1_94) AT=830.05n

.meas tran vdout1_95ck820 FIND v(dout1_95) AT=830.05n

.meas tran vdout1_96ck820 FIND v(dout1_96) AT=830.05n

.meas tran vdout1_97ck820 FIND v(dout1_97) AT=830.05n

.meas tran vdout1_98ck820 FIND v(dout1_98) AT=830.05n

.meas tran vdout1_99ck820 FIND v(dout1_99) AT=830.05n

.meas tran vdout1_100ck820 FIND v(dout1_100) AT=830.05n

.meas tran vdout1_101ck820 FIND v(dout1_101) AT=830.05n

.meas tran vdout1_102ck820 FIND v(dout1_102) AT=830.05n

.meas tran vdout1_103ck820 FIND v(dout1_103) AT=830.05n

.meas tran vdout1_104ck820 FIND v(dout1_104) AT=830.05n

.meas tran vdout1_105ck820 FIND v(dout1_105) AT=830.05n

.meas tran vdout1_106ck820 FIND v(dout1_106) AT=830.05n

.meas tran vdout1_107ck820 FIND v(dout1_107) AT=830.05n

.meas tran vdout1_108ck820 FIND v(dout1_108) AT=830.05n

.meas tran vdout1_109ck820 FIND v(dout1_109) AT=830.05n

.meas tran vdout1_110ck820 FIND v(dout1_110) AT=830.05n

.meas tran vdout1_111ck820 FIND v(dout1_111) AT=830.05n

.meas tran vdout1_112ck820 FIND v(dout1_112) AT=830.05n

.meas tran vdout1_113ck820 FIND v(dout1_113) AT=830.05n

.meas tran vdout1_114ck820 FIND v(dout1_114) AT=830.05n

.meas tran vdout1_115ck820 FIND v(dout1_115) AT=830.05n

.meas tran vdout1_116ck820 FIND v(dout1_116) AT=830.05n

.meas tran vdout1_117ck820 FIND v(dout1_117) AT=830.05n

.meas tran vdout1_118ck820 FIND v(dout1_118) AT=830.05n

.meas tran vdout1_119ck820 FIND v(dout1_119) AT=830.05n

.meas tran vdout1_120ck820 FIND v(dout1_120) AT=830.05n

.meas tran vdout1_121ck820 FIND v(dout1_121) AT=830.05n

.meas tran vdout1_122ck820 FIND v(dout1_122) AT=830.05n

.meas tran vdout1_123ck820 FIND v(dout1_123) AT=830.05n

.meas tran vdout1_124ck820 FIND v(dout1_124) AT=830.05n

.meas tran vdout1_125ck820 FIND v(dout1_125) AT=830.05n

.meas tran vdout1_126ck820 FIND v(dout1_126) AT=830.05n

.meas tran vdout1_127ck820 FIND v(dout1_127) AT=830.05n

.meas tran vdout1_128ck820 FIND v(dout1_128) AT=830.05n

.meas tran vdout1_129ck820 FIND v(dout1_129) AT=830.05n

.meas tran vdout1_130ck820 FIND v(dout1_130) AT=830.05n

.meas tran vdout1_131ck820 FIND v(dout1_131) AT=830.05n

.meas tran vdout1_132ck820 FIND v(dout1_132) AT=830.05n

.meas tran vdout1_133ck820 FIND v(dout1_133) AT=830.05n

.meas tran vdout1_134ck820 FIND v(dout1_134) AT=830.05n

.meas tran vdout1_135ck820 FIND v(dout1_135) AT=830.05n

.meas tran vdout1_136ck820 FIND v(dout1_136) AT=830.05n

.meas tran vdout1_137ck820 FIND v(dout1_137) AT=830.05n

.meas tran vdout1_138ck820 FIND v(dout1_138) AT=830.05n

.meas tran vdout1_139ck820 FIND v(dout1_139) AT=830.05n

.meas tran vdout1_140ck820 FIND v(dout1_140) AT=830.05n

.meas tran vdout1_141ck820 FIND v(dout1_141) AT=830.05n

.meas tran vdout1_142ck820 FIND v(dout1_142) AT=830.05n

.meas tran vdout1_143ck820 FIND v(dout1_143) AT=830.05n

.meas tran vdout1_144ck820 FIND v(dout1_144) AT=830.05n

.meas tran vdout1_145ck820 FIND v(dout1_145) AT=830.05n

.meas tran vdout1_146ck820 FIND v(dout1_146) AT=830.05n

.meas tran vdout1_147ck820 FIND v(dout1_147) AT=830.05n

.meas tran vdout1_148ck820 FIND v(dout1_148) AT=830.05n

.meas tran vdout1_149ck820 FIND v(dout1_149) AT=830.05n

.meas tran vdout1_150ck820 FIND v(dout1_150) AT=830.05n

.meas tran vdout1_151ck820 FIND v(dout1_151) AT=830.05n

.meas tran vdout1_152ck820 FIND v(dout1_152) AT=830.05n

.meas tran vdout1_153ck820 FIND v(dout1_153) AT=830.05n

.meas tran vdout1_154ck820 FIND v(dout1_154) AT=830.05n

.meas tran vdout1_155ck820 FIND v(dout1_155) AT=830.05n

.meas tran vdout1_156ck820 FIND v(dout1_156) AT=830.05n

.meas tran vdout1_157ck820 FIND v(dout1_157) AT=830.05n

.meas tran vdout1_158ck820 FIND v(dout1_158) AT=830.05n

.meas tran vdout1_159ck820 FIND v(dout1_159) AT=830.05n

.meas tran vdout1_160ck820 FIND v(dout1_160) AT=830.05n

.meas tran vdout1_161ck820 FIND v(dout1_161) AT=830.05n

.meas tran vdout1_162ck820 FIND v(dout1_162) AT=830.05n

.meas tran vdout1_163ck820 FIND v(dout1_163) AT=830.05n

.meas tran vdout1_164ck820 FIND v(dout1_164) AT=830.05n

.meas tran vdout1_165ck820 FIND v(dout1_165) AT=830.05n

.meas tran vdout1_166ck820 FIND v(dout1_166) AT=830.05n

.meas tran vdout1_167ck820 FIND v(dout1_167) AT=830.05n

.meas tran vdout1_168ck820 FIND v(dout1_168) AT=830.05n

.meas tran vdout1_169ck820 FIND v(dout1_169) AT=830.05n

.meas tran vdout1_170ck820 FIND v(dout1_170) AT=830.05n

.meas tran vdout1_171ck820 FIND v(dout1_171) AT=830.05n

.meas tran vdout1_172ck820 FIND v(dout1_172) AT=830.05n

.meas tran vdout1_173ck820 FIND v(dout1_173) AT=830.05n

.meas tran vdout1_174ck820 FIND v(dout1_174) AT=830.05n

.meas tran vdout1_175ck820 FIND v(dout1_175) AT=830.05n

.meas tran vdout1_176ck820 FIND v(dout1_176) AT=830.05n

.meas tran vdout1_177ck820 FIND v(dout1_177) AT=830.05n

.meas tran vdout1_178ck820 FIND v(dout1_178) AT=830.05n

.meas tran vdout1_179ck820 FIND v(dout1_179) AT=830.05n

.meas tran vdout1_180ck820 FIND v(dout1_180) AT=830.05n

.meas tran vdout1_181ck820 FIND v(dout1_181) AT=830.05n

.meas tran vdout1_182ck820 FIND v(dout1_182) AT=830.05n

.meas tran vdout1_183ck820 FIND v(dout1_183) AT=830.05n

.meas tran vdout1_184ck820 FIND v(dout1_184) AT=830.05n

.meas tran vdout1_185ck820 FIND v(dout1_185) AT=830.05n

.meas tran vdout1_186ck820 FIND v(dout1_186) AT=830.05n

.meas tran vdout1_187ck820 FIND v(dout1_187) AT=830.05n

.meas tran vdout1_188ck820 FIND v(dout1_188) AT=830.05n

.meas tran vdout1_189ck820 FIND v(dout1_189) AT=830.05n

.meas tran vdout1_190ck820 FIND v(dout1_190) AT=830.05n

.meas tran vdout1_191ck820 FIND v(dout1_191) AT=830.05n

.meas tran vdout1_192ck820 FIND v(dout1_192) AT=830.05n

.meas tran vdout1_193ck820 FIND v(dout1_193) AT=830.05n

.meas tran vdout1_194ck820 FIND v(dout1_194) AT=830.05n

.meas tran vdout1_195ck820 FIND v(dout1_195) AT=830.05n

.meas tran vdout1_196ck820 FIND v(dout1_196) AT=830.05n

.meas tran vdout1_197ck820 FIND v(dout1_197) AT=830.05n

.meas tran vdout1_198ck820 FIND v(dout1_198) AT=830.05n

.meas tran vdout1_199ck820 FIND v(dout1_199) AT=830.05n

.meas tran vdout1_200ck820 FIND v(dout1_200) AT=830.05n

.meas tran vdout1_201ck820 FIND v(dout1_201) AT=830.05n

.meas tran vdout1_202ck820 FIND v(dout1_202) AT=830.05n

.meas tran vdout1_203ck820 FIND v(dout1_203) AT=830.05n

.meas tran vdout1_204ck820 FIND v(dout1_204) AT=830.05n

.meas tran vdout1_205ck820 FIND v(dout1_205) AT=830.05n

.meas tran vdout1_206ck820 FIND v(dout1_206) AT=830.05n

.meas tran vdout1_207ck820 FIND v(dout1_207) AT=830.05n

.meas tran vdout1_208ck820 FIND v(dout1_208) AT=830.05n

.meas tran vdout1_209ck820 FIND v(dout1_209) AT=830.05n

.meas tran vdout1_210ck820 FIND v(dout1_210) AT=830.05n

.meas tran vdout1_211ck820 FIND v(dout1_211) AT=830.05n

.meas tran vdout1_212ck820 FIND v(dout1_212) AT=830.05n

.meas tran vdout1_213ck820 FIND v(dout1_213) AT=830.05n

.meas tran vdout1_214ck820 FIND v(dout1_214) AT=830.05n

.meas tran vdout1_215ck820 FIND v(dout1_215) AT=830.05n

.meas tran vdout1_216ck820 FIND v(dout1_216) AT=830.05n

.meas tran vdout1_217ck820 FIND v(dout1_217) AT=830.05n

.meas tran vdout1_218ck820 FIND v(dout1_218) AT=830.05n

.meas tran vdout1_219ck820 FIND v(dout1_219) AT=830.05n

.meas tran vdout1_220ck820 FIND v(dout1_220) AT=830.05n

.meas tran vdout1_221ck820 FIND v(dout1_221) AT=830.05n

.meas tran vdout1_222ck820 FIND v(dout1_222) AT=830.05n

.meas tran vdout1_223ck820 FIND v(dout1_223) AT=830.05n

.meas tran vdout1_224ck820 FIND v(dout1_224) AT=830.05n

.meas tran vdout1_225ck820 FIND v(dout1_225) AT=830.05n

.meas tran vdout1_226ck820 FIND v(dout1_226) AT=830.05n

.meas tran vdout1_227ck820 FIND v(dout1_227) AT=830.05n

.meas tran vdout1_228ck820 FIND v(dout1_228) AT=830.05n

.meas tran vdout1_229ck820 FIND v(dout1_229) AT=830.05n

.meas tran vdout1_230ck820 FIND v(dout1_230) AT=830.05n

.meas tran vdout1_231ck820 FIND v(dout1_231) AT=830.05n

.meas tran vdout1_232ck820 FIND v(dout1_232) AT=830.05n

.meas tran vdout1_233ck820 FIND v(dout1_233) AT=830.05n

.meas tran vdout1_234ck820 FIND v(dout1_234) AT=830.05n

.meas tran vdout1_235ck820 FIND v(dout1_235) AT=830.05n

.meas tran vdout1_236ck820 FIND v(dout1_236) AT=830.05n

.meas tran vdout1_237ck820 FIND v(dout1_237) AT=830.05n

.meas tran vdout1_238ck820 FIND v(dout1_238) AT=830.05n

.meas tran vdout1_239ck820 FIND v(dout1_239) AT=830.05n

.meas tran vdout1_240ck820 FIND v(dout1_240) AT=830.05n

.meas tran vdout1_241ck820 FIND v(dout1_241) AT=830.05n

.meas tran vdout1_242ck820 FIND v(dout1_242) AT=830.05n

.meas tran vdout1_243ck820 FIND v(dout1_243) AT=830.05n

.meas tran vdout1_244ck820 FIND v(dout1_244) AT=830.05n

.meas tran vdout1_245ck820 FIND v(dout1_245) AT=830.05n

.meas tran vdout1_246ck820 FIND v(dout1_246) AT=830.05n

.meas tran vdout1_247ck820 FIND v(dout1_247) AT=830.05n

.meas tran vdout1_248ck820 FIND v(dout1_248) AT=830.05n

.meas tran vdout1_249ck820 FIND v(dout1_249) AT=830.05n

.meas tran vdout1_250ck820 FIND v(dout1_250) AT=830.05n

.meas tran vdout1_251ck820 FIND v(dout1_251) AT=830.05n

.meas tran vdout1_252ck820 FIND v(dout1_252) AT=830.05n

.meas tran vdout1_253ck820 FIND v(dout1_253) AT=830.05n

.meas tran vdout1_254ck820 FIND v(dout1_254) AT=830.05n

.meas tran vdout1_255ck820 FIND v(dout1_255) AT=830.05n

.meas tran vdout1_256ck820 FIND v(dout1_256) AT=830.05n

.meas tran vdout1_0ck850 FIND v(dout1_0) AT=860.05n

.meas tran vdout1_1ck850 FIND v(dout1_1) AT=860.05n

.meas tran vdout1_2ck850 FIND v(dout1_2) AT=860.05n

.meas tran vdout1_3ck850 FIND v(dout1_3) AT=860.05n

.meas tran vdout1_4ck850 FIND v(dout1_4) AT=860.05n

.meas tran vdout1_5ck850 FIND v(dout1_5) AT=860.05n

.meas tran vdout1_6ck850 FIND v(dout1_6) AT=860.05n

.meas tran vdout1_7ck850 FIND v(dout1_7) AT=860.05n

.meas tran vdout1_8ck850 FIND v(dout1_8) AT=860.05n

.meas tran vdout1_9ck850 FIND v(dout1_9) AT=860.05n

.meas tran vdout1_10ck850 FIND v(dout1_10) AT=860.05n

.meas tran vdout1_11ck850 FIND v(dout1_11) AT=860.05n

.meas tran vdout1_12ck850 FIND v(dout1_12) AT=860.05n

.meas tran vdout1_13ck850 FIND v(dout1_13) AT=860.05n

.meas tran vdout1_14ck850 FIND v(dout1_14) AT=860.05n

.meas tran vdout1_15ck850 FIND v(dout1_15) AT=860.05n

.meas tran vdout1_16ck850 FIND v(dout1_16) AT=860.05n

.meas tran vdout1_17ck850 FIND v(dout1_17) AT=860.05n

.meas tran vdout1_18ck850 FIND v(dout1_18) AT=860.05n

.meas tran vdout1_19ck850 FIND v(dout1_19) AT=860.05n

.meas tran vdout1_20ck850 FIND v(dout1_20) AT=860.05n

.meas tran vdout1_21ck850 FIND v(dout1_21) AT=860.05n

.meas tran vdout1_22ck850 FIND v(dout1_22) AT=860.05n

.meas tran vdout1_23ck850 FIND v(dout1_23) AT=860.05n

.meas tran vdout1_24ck850 FIND v(dout1_24) AT=860.05n

.meas tran vdout1_25ck850 FIND v(dout1_25) AT=860.05n

.meas tran vdout1_26ck850 FIND v(dout1_26) AT=860.05n

.meas tran vdout1_27ck850 FIND v(dout1_27) AT=860.05n

.meas tran vdout1_28ck850 FIND v(dout1_28) AT=860.05n

.meas tran vdout1_29ck850 FIND v(dout1_29) AT=860.05n

.meas tran vdout1_30ck850 FIND v(dout1_30) AT=860.05n

.meas tran vdout1_31ck850 FIND v(dout1_31) AT=860.05n

.meas tran vdout1_32ck850 FIND v(dout1_32) AT=860.05n

.meas tran vdout1_33ck850 FIND v(dout1_33) AT=860.05n

.meas tran vdout1_34ck850 FIND v(dout1_34) AT=860.05n

.meas tran vdout1_35ck850 FIND v(dout1_35) AT=860.05n

.meas tran vdout1_36ck850 FIND v(dout1_36) AT=860.05n

.meas tran vdout1_37ck850 FIND v(dout1_37) AT=860.05n

.meas tran vdout1_38ck850 FIND v(dout1_38) AT=860.05n

.meas tran vdout1_39ck850 FIND v(dout1_39) AT=860.05n

.meas tran vdout1_40ck850 FIND v(dout1_40) AT=860.05n

.meas tran vdout1_41ck850 FIND v(dout1_41) AT=860.05n

.meas tran vdout1_42ck850 FIND v(dout1_42) AT=860.05n

.meas tran vdout1_43ck850 FIND v(dout1_43) AT=860.05n

.meas tran vdout1_44ck850 FIND v(dout1_44) AT=860.05n

.meas tran vdout1_45ck850 FIND v(dout1_45) AT=860.05n

.meas tran vdout1_46ck850 FIND v(dout1_46) AT=860.05n

.meas tran vdout1_47ck850 FIND v(dout1_47) AT=860.05n

.meas tran vdout1_48ck850 FIND v(dout1_48) AT=860.05n

.meas tran vdout1_49ck850 FIND v(dout1_49) AT=860.05n

.meas tran vdout1_50ck850 FIND v(dout1_50) AT=860.05n

.meas tran vdout1_51ck850 FIND v(dout1_51) AT=860.05n

.meas tran vdout1_52ck850 FIND v(dout1_52) AT=860.05n

.meas tran vdout1_53ck850 FIND v(dout1_53) AT=860.05n

.meas tran vdout1_54ck850 FIND v(dout1_54) AT=860.05n

.meas tran vdout1_55ck850 FIND v(dout1_55) AT=860.05n

.meas tran vdout1_56ck850 FIND v(dout1_56) AT=860.05n

.meas tran vdout1_57ck850 FIND v(dout1_57) AT=860.05n

.meas tran vdout1_58ck850 FIND v(dout1_58) AT=860.05n

.meas tran vdout1_59ck850 FIND v(dout1_59) AT=860.05n

.meas tran vdout1_60ck850 FIND v(dout1_60) AT=860.05n

.meas tran vdout1_61ck850 FIND v(dout1_61) AT=860.05n

.meas tran vdout1_62ck850 FIND v(dout1_62) AT=860.05n

.meas tran vdout1_63ck850 FIND v(dout1_63) AT=860.05n

.meas tran vdout1_64ck850 FIND v(dout1_64) AT=860.05n

.meas tran vdout1_65ck850 FIND v(dout1_65) AT=860.05n

.meas tran vdout1_66ck850 FIND v(dout1_66) AT=860.05n

.meas tran vdout1_67ck850 FIND v(dout1_67) AT=860.05n

.meas tran vdout1_68ck850 FIND v(dout1_68) AT=860.05n

.meas tran vdout1_69ck850 FIND v(dout1_69) AT=860.05n

.meas tran vdout1_70ck850 FIND v(dout1_70) AT=860.05n

.meas tran vdout1_71ck850 FIND v(dout1_71) AT=860.05n

.meas tran vdout1_72ck850 FIND v(dout1_72) AT=860.05n

.meas tran vdout1_73ck850 FIND v(dout1_73) AT=860.05n

.meas tran vdout1_74ck850 FIND v(dout1_74) AT=860.05n

.meas tran vdout1_75ck850 FIND v(dout1_75) AT=860.05n

.meas tran vdout1_76ck850 FIND v(dout1_76) AT=860.05n

.meas tran vdout1_77ck850 FIND v(dout1_77) AT=860.05n

.meas tran vdout1_78ck850 FIND v(dout1_78) AT=860.05n

.meas tran vdout1_79ck850 FIND v(dout1_79) AT=860.05n

.meas tran vdout1_80ck850 FIND v(dout1_80) AT=860.05n

.meas tran vdout1_81ck850 FIND v(dout1_81) AT=860.05n

.meas tran vdout1_82ck850 FIND v(dout1_82) AT=860.05n

.meas tran vdout1_83ck850 FIND v(dout1_83) AT=860.05n

.meas tran vdout1_84ck850 FIND v(dout1_84) AT=860.05n

.meas tran vdout1_85ck850 FIND v(dout1_85) AT=860.05n

.meas tran vdout1_86ck850 FIND v(dout1_86) AT=860.05n

.meas tran vdout1_87ck850 FIND v(dout1_87) AT=860.05n

.meas tran vdout1_88ck850 FIND v(dout1_88) AT=860.05n

.meas tran vdout1_89ck850 FIND v(dout1_89) AT=860.05n

.meas tran vdout1_90ck850 FIND v(dout1_90) AT=860.05n

.meas tran vdout1_91ck850 FIND v(dout1_91) AT=860.05n

.meas tran vdout1_92ck850 FIND v(dout1_92) AT=860.05n

.meas tran vdout1_93ck850 FIND v(dout1_93) AT=860.05n

.meas tran vdout1_94ck850 FIND v(dout1_94) AT=860.05n

.meas tran vdout1_95ck850 FIND v(dout1_95) AT=860.05n

.meas tran vdout1_96ck850 FIND v(dout1_96) AT=860.05n

.meas tran vdout1_97ck850 FIND v(dout1_97) AT=860.05n

.meas tran vdout1_98ck850 FIND v(dout1_98) AT=860.05n

.meas tran vdout1_99ck850 FIND v(dout1_99) AT=860.05n

.meas tran vdout1_100ck850 FIND v(dout1_100) AT=860.05n

.meas tran vdout1_101ck850 FIND v(dout1_101) AT=860.05n

.meas tran vdout1_102ck850 FIND v(dout1_102) AT=860.05n

.meas tran vdout1_103ck850 FIND v(dout1_103) AT=860.05n

.meas tran vdout1_104ck850 FIND v(dout1_104) AT=860.05n

.meas tran vdout1_105ck850 FIND v(dout1_105) AT=860.05n

.meas tran vdout1_106ck850 FIND v(dout1_106) AT=860.05n

.meas tran vdout1_107ck850 FIND v(dout1_107) AT=860.05n

.meas tran vdout1_108ck850 FIND v(dout1_108) AT=860.05n

.meas tran vdout1_109ck850 FIND v(dout1_109) AT=860.05n

.meas tran vdout1_110ck850 FIND v(dout1_110) AT=860.05n

.meas tran vdout1_111ck850 FIND v(dout1_111) AT=860.05n

.meas tran vdout1_112ck850 FIND v(dout1_112) AT=860.05n

.meas tran vdout1_113ck850 FIND v(dout1_113) AT=860.05n

.meas tran vdout1_114ck850 FIND v(dout1_114) AT=860.05n

.meas tran vdout1_115ck850 FIND v(dout1_115) AT=860.05n

.meas tran vdout1_116ck850 FIND v(dout1_116) AT=860.05n

.meas tran vdout1_117ck850 FIND v(dout1_117) AT=860.05n

.meas tran vdout1_118ck850 FIND v(dout1_118) AT=860.05n

.meas tran vdout1_119ck850 FIND v(dout1_119) AT=860.05n

.meas tran vdout1_120ck850 FIND v(dout1_120) AT=860.05n

.meas tran vdout1_121ck850 FIND v(dout1_121) AT=860.05n

.meas tran vdout1_122ck850 FIND v(dout1_122) AT=860.05n

.meas tran vdout1_123ck850 FIND v(dout1_123) AT=860.05n

.meas tran vdout1_124ck850 FIND v(dout1_124) AT=860.05n

.meas tran vdout1_125ck850 FIND v(dout1_125) AT=860.05n

.meas tran vdout1_126ck850 FIND v(dout1_126) AT=860.05n

.meas tran vdout1_127ck850 FIND v(dout1_127) AT=860.05n

.meas tran vdout1_128ck850 FIND v(dout1_128) AT=860.05n

.meas tran vdout1_129ck850 FIND v(dout1_129) AT=860.05n

.meas tran vdout1_130ck850 FIND v(dout1_130) AT=860.05n

.meas tran vdout1_131ck850 FIND v(dout1_131) AT=860.05n

.meas tran vdout1_132ck850 FIND v(dout1_132) AT=860.05n

.meas tran vdout1_133ck850 FIND v(dout1_133) AT=860.05n

.meas tran vdout1_134ck850 FIND v(dout1_134) AT=860.05n

.meas tran vdout1_135ck850 FIND v(dout1_135) AT=860.05n

.meas tran vdout1_136ck850 FIND v(dout1_136) AT=860.05n

.meas tran vdout1_137ck850 FIND v(dout1_137) AT=860.05n

.meas tran vdout1_138ck850 FIND v(dout1_138) AT=860.05n

.meas tran vdout1_139ck850 FIND v(dout1_139) AT=860.05n

.meas tran vdout1_140ck850 FIND v(dout1_140) AT=860.05n

.meas tran vdout1_141ck850 FIND v(dout1_141) AT=860.05n

.meas tran vdout1_142ck850 FIND v(dout1_142) AT=860.05n

.meas tran vdout1_143ck850 FIND v(dout1_143) AT=860.05n

.meas tran vdout1_144ck850 FIND v(dout1_144) AT=860.05n

.meas tran vdout1_145ck850 FIND v(dout1_145) AT=860.05n

.meas tran vdout1_146ck850 FIND v(dout1_146) AT=860.05n

.meas tran vdout1_147ck850 FIND v(dout1_147) AT=860.05n

.meas tran vdout1_148ck850 FIND v(dout1_148) AT=860.05n

.meas tran vdout1_149ck850 FIND v(dout1_149) AT=860.05n

.meas tran vdout1_150ck850 FIND v(dout1_150) AT=860.05n

.meas tran vdout1_151ck850 FIND v(dout1_151) AT=860.05n

.meas tran vdout1_152ck850 FIND v(dout1_152) AT=860.05n

.meas tran vdout1_153ck850 FIND v(dout1_153) AT=860.05n

.meas tran vdout1_154ck850 FIND v(dout1_154) AT=860.05n

.meas tran vdout1_155ck850 FIND v(dout1_155) AT=860.05n

.meas tran vdout1_156ck850 FIND v(dout1_156) AT=860.05n

.meas tran vdout1_157ck850 FIND v(dout1_157) AT=860.05n

.meas tran vdout1_158ck850 FIND v(dout1_158) AT=860.05n

.meas tran vdout1_159ck850 FIND v(dout1_159) AT=860.05n

.meas tran vdout1_160ck850 FIND v(dout1_160) AT=860.05n

.meas tran vdout1_161ck850 FIND v(dout1_161) AT=860.05n

.meas tran vdout1_162ck850 FIND v(dout1_162) AT=860.05n

.meas tran vdout1_163ck850 FIND v(dout1_163) AT=860.05n

.meas tran vdout1_164ck850 FIND v(dout1_164) AT=860.05n

.meas tran vdout1_165ck850 FIND v(dout1_165) AT=860.05n

.meas tran vdout1_166ck850 FIND v(dout1_166) AT=860.05n

.meas tran vdout1_167ck850 FIND v(dout1_167) AT=860.05n

.meas tran vdout1_168ck850 FIND v(dout1_168) AT=860.05n

.meas tran vdout1_169ck850 FIND v(dout1_169) AT=860.05n

.meas tran vdout1_170ck850 FIND v(dout1_170) AT=860.05n

.meas tran vdout1_171ck850 FIND v(dout1_171) AT=860.05n

.meas tran vdout1_172ck850 FIND v(dout1_172) AT=860.05n

.meas tran vdout1_173ck850 FIND v(dout1_173) AT=860.05n

.meas tran vdout1_174ck850 FIND v(dout1_174) AT=860.05n

.meas tran vdout1_175ck850 FIND v(dout1_175) AT=860.05n

.meas tran vdout1_176ck850 FIND v(dout1_176) AT=860.05n

.meas tran vdout1_177ck850 FIND v(dout1_177) AT=860.05n

.meas tran vdout1_178ck850 FIND v(dout1_178) AT=860.05n

.meas tran vdout1_179ck850 FIND v(dout1_179) AT=860.05n

.meas tran vdout1_180ck850 FIND v(dout1_180) AT=860.05n

.meas tran vdout1_181ck850 FIND v(dout1_181) AT=860.05n

.meas tran vdout1_182ck850 FIND v(dout1_182) AT=860.05n

.meas tran vdout1_183ck850 FIND v(dout1_183) AT=860.05n

.meas tran vdout1_184ck850 FIND v(dout1_184) AT=860.05n

.meas tran vdout1_185ck850 FIND v(dout1_185) AT=860.05n

.meas tran vdout1_186ck850 FIND v(dout1_186) AT=860.05n

.meas tran vdout1_187ck850 FIND v(dout1_187) AT=860.05n

.meas tran vdout1_188ck850 FIND v(dout1_188) AT=860.05n

.meas tran vdout1_189ck850 FIND v(dout1_189) AT=860.05n

.meas tran vdout1_190ck850 FIND v(dout1_190) AT=860.05n

.meas tran vdout1_191ck850 FIND v(dout1_191) AT=860.05n

.meas tran vdout1_192ck850 FIND v(dout1_192) AT=860.05n

.meas tran vdout1_193ck850 FIND v(dout1_193) AT=860.05n

.meas tran vdout1_194ck850 FIND v(dout1_194) AT=860.05n

.meas tran vdout1_195ck850 FIND v(dout1_195) AT=860.05n

.meas tran vdout1_196ck850 FIND v(dout1_196) AT=860.05n

.meas tran vdout1_197ck850 FIND v(dout1_197) AT=860.05n

.meas tran vdout1_198ck850 FIND v(dout1_198) AT=860.05n

.meas tran vdout1_199ck850 FIND v(dout1_199) AT=860.05n

.meas tran vdout1_200ck850 FIND v(dout1_200) AT=860.05n

.meas tran vdout1_201ck850 FIND v(dout1_201) AT=860.05n

.meas tran vdout1_202ck850 FIND v(dout1_202) AT=860.05n

.meas tran vdout1_203ck850 FIND v(dout1_203) AT=860.05n

.meas tran vdout1_204ck850 FIND v(dout1_204) AT=860.05n

.meas tran vdout1_205ck850 FIND v(dout1_205) AT=860.05n

.meas tran vdout1_206ck850 FIND v(dout1_206) AT=860.05n

.meas tran vdout1_207ck850 FIND v(dout1_207) AT=860.05n

.meas tran vdout1_208ck850 FIND v(dout1_208) AT=860.05n

.meas tran vdout1_209ck850 FIND v(dout1_209) AT=860.05n

.meas tran vdout1_210ck850 FIND v(dout1_210) AT=860.05n

.meas tran vdout1_211ck850 FIND v(dout1_211) AT=860.05n

.meas tran vdout1_212ck850 FIND v(dout1_212) AT=860.05n

.meas tran vdout1_213ck850 FIND v(dout1_213) AT=860.05n

.meas tran vdout1_214ck850 FIND v(dout1_214) AT=860.05n

.meas tran vdout1_215ck850 FIND v(dout1_215) AT=860.05n

.meas tran vdout1_216ck850 FIND v(dout1_216) AT=860.05n

.meas tran vdout1_217ck850 FIND v(dout1_217) AT=860.05n

.meas tran vdout1_218ck850 FIND v(dout1_218) AT=860.05n

.meas tran vdout1_219ck850 FIND v(dout1_219) AT=860.05n

.meas tran vdout1_220ck850 FIND v(dout1_220) AT=860.05n

.meas tran vdout1_221ck850 FIND v(dout1_221) AT=860.05n

.meas tran vdout1_222ck850 FIND v(dout1_222) AT=860.05n

.meas tran vdout1_223ck850 FIND v(dout1_223) AT=860.05n

.meas tran vdout1_224ck850 FIND v(dout1_224) AT=860.05n

.meas tran vdout1_225ck850 FIND v(dout1_225) AT=860.05n

.meas tran vdout1_226ck850 FIND v(dout1_226) AT=860.05n

.meas tran vdout1_227ck850 FIND v(dout1_227) AT=860.05n

.meas tran vdout1_228ck850 FIND v(dout1_228) AT=860.05n

.meas tran vdout1_229ck850 FIND v(dout1_229) AT=860.05n

.meas tran vdout1_230ck850 FIND v(dout1_230) AT=860.05n

.meas tran vdout1_231ck850 FIND v(dout1_231) AT=860.05n

.meas tran vdout1_232ck850 FIND v(dout1_232) AT=860.05n

.meas tran vdout1_233ck850 FIND v(dout1_233) AT=860.05n

.meas tran vdout1_234ck850 FIND v(dout1_234) AT=860.05n

.meas tran vdout1_235ck850 FIND v(dout1_235) AT=860.05n

.meas tran vdout1_236ck850 FIND v(dout1_236) AT=860.05n

.meas tran vdout1_237ck850 FIND v(dout1_237) AT=860.05n

.meas tran vdout1_238ck850 FIND v(dout1_238) AT=860.05n

.meas tran vdout1_239ck850 FIND v(dout1_239) AT=860.05n

.meas tran vdout1_240ck850 FIND v(dout1_240) AT=860.05n

.meas tran vdout1_241ck850 FIND v(dout1_241) AT=860.05n

.meas tran vdout1_242ck850 FIND v(dout1_242) AT=860.05n

.meas tran vdout1_243ck850 FIND v(dout1_243) AT=860.05n

.meas tran vdout1_244ck850 FIND v(dout1_244) AT=860.05n

.meas tran vdout1_245ck850 FIND v(dout1_245) AT=860.05n

.meas tran vdout1_246ck850 FIND v(dout1_246) AT=860.05n

.meas tran vdout1_247ck850 FIND v(dout1_247) AT=860.05n

.meas tran vdout1_248ck850 FIND v(dout1_248) AT=860.05n

.meas tran vdout1_249ck850 FIND v(dout1_249) AT=860.05n

.meas tran vdout1_250ck850 FIND v(dout1_250) AT=860.05n

.meas tran vdout1_251ck850 FIND v(dout1_251) AT=860.05n

.meas tran vdout1_252ck850 FIND v(dout1_252) AT=860.05n

.meas tran vdout1_253ck850 FIND v(dout1_253) AT=860.05n

.meas tran vdout1_254ck850 FIND v(dout1_254) AT=860.05n

.meas tran vdout1_255ck850 FIND v(dout1_255) AT=860.05n

.meas tran vdout1_256ck850 FIND v(dout1_256) AT=860.05n

.meas tran vdout1_0ck860 FIND v(dout1_0) AT=870.05n

.meas tran vdout1_1ck860 FIND v(dout1_1) AT=870.05n

.meas tran vdout1_2ck860 FIND v(dout1_2) AT=870.05n

.meas tran vdout1_3ck860 FIND v(dout1_3) AT=870.05n

.meas tran vdout1_4ck860 FIND v(dout1_4) AT=870.05n

.meas tran vdout1_5ck860 FIND v(dout1_5) AT=870.05n

.meas tran vdout1_6ck860 FIND v(dout1_6) AT=870.05n

.meas tran vdout1_7ck860 FIND v(dout1_7) AT=870.05n

.meas tran vdout1_8ck860 FIND v(dout1_8) AT=870.05n

.meas tran vdout1_9ck860 FIND v(dout1_9) AT=870.05n

.meas tran vdout1_10ck860 FIND v(dout1_10) AT=870.05n

.meas tran vdout1_11ck860 FIND v(dout1_11) AT=870.05n

.meas tran vdout1_12ck860 FIND v(dout1_12) AT=870.05n

.meas tran vdout1_13ck860 FIND v(dout1_13) AT=870.05n

.meas tran vdout1_14ck860 FIND v(dout1_14) AT=870.05n

.meas tran vdout1_15ck860 FIND v(dout1_15) AT=870.05n

.meas tran vdout1_16ck860 FIND v(dout1_16) AT=870.05n

.meas tran vdout1_17ck860 FIND v(dout1_17) AT=870.05n

.meas tran vdout1_18ck860 FIND v(dout1_18) AT=870.05n

.meas tran vdout1_19ck860 FIND v(dout1_19) AT=870.05n

.meas tran vdout1_20ck860 FIND v(dout1_20) AT=870.05n

.meas tran vdout1_21ck860 FIND v(dout1_21) AT=870.05n

.meas tran vdout1_22ck860 FIND v(dout1_22) AT=870.05n

.meas tran vdout1_23ck860 FIND v(dout1_23) AT=870.05n

.meas tran vdout1_24ck860 FIND v(dout1_24) AT=870.05n

.meas tran vdout1_25ck860 FIND v(dout1_25) AT=870.05n

.meas tran vdout1_26ck860 FIND v(dout1_26) AT=870.05n

.meas tran vdout1_27ck860 FIND v(dout1_27) AT=870.05n

.meas tran vdout1_28ck860 FIND v(dout1_28) AT=870.05n

.meas tran vdout1_29ck860 FIND v(dout1_29) AT=870.05n

.meas tran vdout1_30ck860 FIND v(dout1_30) AT=870.05n

.meas tran vdout1_31ck860 FIND v(dout1_31) AT=870.05n

.meas tran vdout1_32ck860 FIND v(dout1_32) AT=870.05n

.meas tran vdout1_33ck860 FIND v(dout1_33) AT=870.05n

.meas tran vdout1_34ck860 FIND v(dout1_34) AT=870.05n

.meas tran vdout1_35ck860 FIND v(dout1_35) AT=870.05n

.meas tran vdout1_36ck860 FIND v(dout1_36) AT=870.05n

.meas tran vdout1_37ck860 FIND v(dout1_37) AT=870.05n

.meas tran vdout1_38ck860 FIND v(dout1_38) AT=870.05n

.meas tran vdout1_39ck860 FIND v(dout1_39) AT=870.05n

.meas tran vdout1_40ck860 FIND v(dout1_40) AT=870.05n

.meas tran vdout1_41ck860 FIND v(dout1_41) AT=870.05n

.meas tran vdout1_42ck860 FIND v(dout1_42) AT=870.05n

.meas tran vdout1_43ck860 FIND v(dout1_43) AT=870.05n

.meas tran vdout1_44ck860 FIND v(dout1_44) AT=870.05n

.meas tran vdout1_45ck860 FIND v(dout1_45) AT=870.05n

.meas tran vdout1_46ck860 FIND v(dout1_46) AT=870.05n

.meas tran vdout1_47ck860 FIND v(dout1_47) AT=870.05n

.meas tran vdout1_48ck860 FIND v(dout1_48) AT=870.05n

.meas tran vdout1_49ck860 FIND v(dout1_49) AT=870.05n

.meas tran vdout1_50ck860 FIND v(dout1_50) AT=870.05n

.meas tran vdout1_51ck860 FIND v(dout1_51) AT=870.05n

.meas tran vdout1_52ck860 FIND v(dout1_52) AT=870.05n

.meas tran vdout1_53ck860 FIND v(dout1_53) AT=870.05n

.meas tran vdout1_54ck860 FIND v(dout1_54) AT=870.05n

.meas tran vdout1_55ck860 FIND v(dout1_55) AT=870.05n

.meas tran vdout1_56ck860 FIND v(dout1_56) AT=870.05n

.meas tran vdout1_57ck860 FIND v(dout1_57) AT=870.05n

.meas tran vdout1_58ck860 FIND v(dout1_58) AT=870.05n

.meas tran vdout1_59ck860 FIND v(dout1_59) AT=870.05n

.meas tran vdout1_60ck860 FIND v(dout1_60) AT=870.05n

.meas tran vdout1_61ck860 FIND v(dout1_61) AT=870.05n

.meas tran vdout1_62ck860 FIND v(dout1_62) AT=870.05n

.meas tran vdout1_63ck860 FIND v(dout1_63) AT=870.05n

.meas tran vdout1_64ck860 FIND v(dout1_64) AT=870.05n

.meas tran vdout1_65ck860 FIND v(dout1_65) AT=870.05n

.meas tran vdout1_66ck860 FIND v(dout1_66) AT=870.05n

.meas tran vdout1_67ck860 FIND v(dout1_67) AT=870.05n

.meas tran vdout1_68ck860 FIND v(dout1_68) AT=870.05n

.meas tran vdout1_69ck860 FIND v(dout1_69) AT=870.05n

.meas tran vdout1_70ck860 FIND v(dout1_70) AT=870.05n

.meas tran vdout1_71ck860 FIND v(dout1_71) AT=870.05n

.meas tran vdout1_72ck860 FIND v(dout1_72) AT=870.05n

.meas tran vdout1_73ck860 FIND v(dout1_73) AT=870.05n

.meas tran vdout1_74ck860 FIND v(dout1_74) AT=870.05n

.meas tran vdout1_75ck860 FIND v(dout1_75) AT=870.05n

.meas tran vdout1_76ck860 FIND v(dout1_76) AT=870.05n

.meas tran vdout1_77ck860 FIND v(dout1_77) AT=870.05n

.meas tran vdout1_78ck860 FIND v(dout1_78) AT=870.05n

.meas tran vdout1_79ck860 FIND v(dout1_79) AT=870.05n

.meas tran vdout1_80ck860 FIND v(dout1_80) AT=870.05n

.meas tran vdout1_81ck860 FIND v(dout1_81) AT=870.05n

.meas tran vdout1_82ck860 FIND v(dout1_82) AT=870.05n

.meas tran vdout1_83ck860 FIND v(dout1_83) AT=870.05n

.meas tran vdout1_84ck860 FIND v(dout1_84) AT=870.05n

.meas tran vdout1_85ck860 FIND v(dout1_85) AT=870.05n

.meas tran vdout1_86ck860 FIND v(dout1_86) AT=870.05n

.meas tran vdout1_87ck860 FIND v(dout1_87) AT=870.05n

.meas tran vdout1_88ck860 FIND v(dout1_88) AT=870.05n

.meas tran vdout1_89ck860 FIND v(dout1_89) AT=870.05n

.meas tran vdout1_90ck860 FIND v(dout1_90) AT=870.05n

.meas tran vdout1_91ck860 FIND v(dout1_91) AT=870.05n

.meas tran vdout1_92ck860 FIND v(dout1_92) AT=870.05n

.meas tran vdout1_93ck860 FIND v(dout1_93) AT=870.05n

.meas tran vdout1_94ck860 FIND v(dout1_94) AT=870.05n

.meas tran vdout1_95ck860 FIND v(dout1_95) AT=870.05n

.meas tran vdout1_96ck860 FIND v(dout1_96) AT=870.05n

.meas tran vdout1_97ck860 FIND v(dout1_97) AT=870.05n

.meas tran vdout1_98ck860 FIND v(dout1_98) AT=870.05n

.meas tran vdout1_99ck860 FIND v(dout1_99) AT=870.05n

.meas tran vdout1_100ck860 FIND v(dout1_100) AT=870.05n

.meas tran vdout1_101ck860 FIND v(dout1_101) AT=870.05n

.meas tran vdout1_102ck860 FIND v(dout1_102) AT=870.05n

.meas tran vdout1_103ck860 FIND v(dout1_103) AT=870.05n

.meas tran vdout1_104ck860 FIND v(dout1_104) AT=870.05n

.meas tran vdout1_105ck860 FIND v(dout1_105) AT=870.05n

.meas tran vdout1_106ck860 FIND v(dout1_106) AT=870.05n

.meas tran vdout1_107ck860 FIND v(dout1_107) AT=870.05n

.meas tran vdout1_108ck860 FIND v(dout1_108) AT=870.05n

.meas tran vdout1_109ck860 FIND v(dout1_109) AT=870.05n

.meas tran vdout1_110ck860 FIND v(dout1_110) AT=870.05n

.meas tran vdout1_111ck860 FIND v(dout1_111) AT=870.05n

.meas tran vdout1_112ck860 FIND v(dout1_112) AT=870.05n

.meas tran vdout1_113ck860 FIND v(dout1_113) AT=870.05n

.meas tran vdout1_114ck860 FIND v(dout1_114) AT=870.05n

.meas tran vdout1_115ck860 FIND v(dout1_115) AT=870.05n

.meas tran vdout1_116ck860 FIND v(dout1_116) AT=870.05n

.meas tran vdout1_117ck860 FIND v(dout1_117) AT=870.05n

.meas tran vdout1_118ck860 FIND v(dout1_118) AT=870.05n

.meas tran vdout1_119ck860 FIND v(dout1_119) AT=870.05n

.meas tran vdout1_120ck860 FIND v(dout1_120) AT=870.05n

.meas tran vdout1_121ck860 FIND v(dout1_121) AT=870.05n

.meas tran vdout1_122ck860 FIND v(dout1_122) AT=870.05n

.meas tran vdout1_123ck860 FIND v(dout1_123) AT=870.05n

.meas tran vdout1_124ck860 FIND v(dout1_124) AT=870.05n

.meas tran vdout1_125ck860 FIND v(dout1_125) AT=870.05n

.meas tran vdout1_126ck860 FIND v(dout1_126) AT=870.05n

.meas tran vdout1_127ck860 FIND v(dout1_127) AT=870.05n

.meas tran vdout1_128ck860 FIND v(dout1_128) AT=870.05n

.meas tran vdout1_129ck860 FIND v(dout1_129) AT=870.05n

.meas tran vdout1_130ck860 FIND v(dout1_130) AT=870.05n

.meas tran vdout1_131ck860 FIND v(dout1_131) AT=870.05n

.meas tran vdout1_132ck860 FIND v(dout1_132) AT=870.05n

.meas tran vdout1_133ck860 FIND v(dout1_133) AT=870.05n

.meas tran vdout1_134ck860 FIND v(dout1_134) AT=870.05n

.meas tran vdout1_135ck860 FIND v(dout1_135) AT=870.05n

.meas tran vdout1_136ck860 FIND v(dout1_136) AT=870.05n

.meas tran vdout1_137ck860 FIND v(dout1_137) AT=870.05n

.meas tran vdout1_138ck860 FIND v(dout1_138) AT=870.05n

.meas tran vdout1_139ck860 FIND v(dout1_139) AT=870.05n

.meas tran vdout1_140ck860 FIND v(dout1_140) AT=870.05n

.meas tran vdout1_141ck860 FIND v(dout1_141) AT=870.05n

.meas tran vdout1_142ck860 FIND v(dout1_142) AT=870.05n

.meas tran vdout1_143ck860 FIND v(dout1_143) AT=870.05n

.meas tran vdout1_144ck860 FIND v(dout1_144) AT=870.05n

.meas tran vdout1_145ck860 FIND v(dout1_145) AT=870.05n

.meas tran vdout1_146ck860 FIND v(dout1_146) AT=870.05n

.meas tran vdout1_147ck860 FIND v(dout1_147) AT=870.05n

.meas tran vdout1_148ck860 FIND v(dout1_148) AT=870.05n

.meas tran vdout1_149ck860 FIND v(dout1_149) AT=870.05n

.meas tran vdout1_150ck860 FIND v(dout1_150) AT=870.05n

.meas tran vdout1_151ck860 FIND v(dout1_151) AT=870.05n

.meas tran vdout1_152ck860 FIND v(dout1_152) AT=870.05n

.meas tran vdout1_153ck860 FIND v(dout1_153) AT=870.05n

.meas tran vdout1_154ck860 FIND v(dout1_154) AT=870.05n

.meas tran vdout1_155ck860 FIND v(dout1_155) AT=870.05n

.meas tran vdout1_156ck860 FIND v(dout1_156) AT=870.05n

.meas tran vdout1_157ck860 FIND v(dout1_157) AT=870.05n

.meas tran vdout1_158ck860 FIND v(dout1_158) AT=870.05n

.meas tran vdout1_159ck860 FIND v(dout1_159) AT=870.05n

.meas tran vdout1_160ck860 FIND v(dout1_160) AT=870.05n

.meas tran vdout1_161ck860 FIND v(dout1_161) AT=870.05n

.meas tran vdout1_162ck860 FIND v(dout1_162) AT=870.05n

.meas tran vdout1_163ck860 FIND v(dout1_163) AT=870.05n

.meas tran vdout1_164ck860 FIND v(dout1_164) AT=870.05n

.meas tran vdout1_165ck860 FIND v(dout1_165) AT=870.05n

.meas tran vdout1_166ck860 FIND v(dout1_166) AT=870.05n

.meas tran vdout1_167ck860 FIND v(dout1_167) AT=870.05n

.meas tran vdout1_168ck860 FIND v(dout1_168) AT=870.05n

.meas tran vdout1_169ck860 FIND v(dout1_169) AT=870.05n

.meas tran vdout1_170ck860 FIND v(dout1_170) AT=870.05n

.meas tran vdout1_171ck860 FIND v(dout1_171) AT=870.05n

.meas tran vdout1_172ck860 FIND v(dout1_172) AT=870.05n

.meas tran vdout1_173ck860 FIND v(dout1_173) AT=870.05n

.meas tran vdout1_174ck860 FIND v(dout1_174) AT=870.05n

.meas tran vdout1_175ck860 FIND v(dout1_175) AT=870.05n

.meas tran vdout1_176ck860 FIND v(dout1_176) AT=870.05n

.meas tran vdout1_177ck860 FIND v(dout1_177) AT=870.05n

.meas tran vdout1_178ck860 FIND v(dout1_178) AT=870.05n

.meas tran vdout1_179ck860 FIND v(dout1_179) AT=870.05n

.meas tran vdout1_180ck860 FIND v(dout1_180) AT=870.05n

.meas tran vdout1_181ck860 FIND v(dout1_181) AT=870.05n

.meas tran vdout1_182ck860 FIND v(dout1_182) AT=870.05n

.meas tran vdout1_183ck860 FIND v(dout1_183) AT=870.05n

.meas tran vdout1_184ck860 FIND v(dout1_184) AT=870.05n

.meas tran vdout1_185ck860 FIND v(dout1_185) AT=870.05n

.meas tran vdout1_186ck860 FIND v(dout1_186) AT=870.05n

.meas tran vdout1_187ck860 FIND v(dout1_187) AT=870.05n

.meas tran vdout1_188ck860 FIND v(dout1_188) AT=870.05n

.meas tran vdout1_189ck860 FIND v(dout1_189) AT=870.05n

.meas tran vdout1_190ck860 FIND v(dout1_190) AT=870.05n

.meas tran vdout1_191ck860 FIND v(dout1_191) AT=870.05n

.meas tran vdout1_192ck860 FIND v(dout1_192) AT=870.05n

.meas tran vdout1_193ck860 FIND v(dout1_193) AT=870.05n

.meas tran vdout1_194ck860 FIND v(dout1_194) AT=870.05n

.meas tran vdout1_195ck860 FIND v(dout1_195) AT=870.05n

.meas tran vdout1_196ck860 FIND v(dout1_196) AT=870.05n

.meas tran vdout1_197ck860 FIND v(dout1_197) AT=870.05n

.meas tran vdout1_198ck860 FIND v(dout1_198) AT=870.05n

.meas tran vdout1_199ck860 FIND v(dout1_199) AT=870.05n

.meas tran vdout1_200ck860 FIND v(dout1_200) AT=870.05n

.meas tran vdout1_201ck860 FIND v(dout1_201) AT=870.05n

.meas tran vdout1_202ck860 FIND v(dout1_202) AT=870.05n

.meas tran vdout1_203ck860 FIND v(dout1_203) AT=870.05n

.meas tran vdout1_204ck860 FIND v(dout1_204) AT=870.05n

.meas tran vdout1_205ck860 FIND v(dout1_205) AT=870.05n

.meas tran vdout1_206ck860 FIND v(dout1_206) AT=870.05n

.meas tran vdout1_207ck860 FIND v(dout1_207) AT=870.05n

.meas tran vdout1_208ck860 FIND v(dout1_208) AT=870.05n

.meas tran vdout1_209ck860 FIND v(dout1_209) AT=870.05n

.meas tran vdout1_210ck860 FIND v(dout1_210) AT=870.05n

.meas tran vdout1_211ck860 FIND v(dout1_211) AT=870.05n

.meas tran vdout1_212ck860 FIND v(dout1_212) AT=870.05n

.meas tran vdout1_213ck860 FIND v(dout1_213) AT=870.05n

.meas tran vdout1_214ck860 FIND v(dout1_214) AT=870.05n

.meas tran vdout1_215ck860 FIND v(dout1_215) AT=870.05n

.meas tran vdout1_216ck860 FIND v(dout1_216) AT=870.05n

.meas tran vdout1_217ck860 FIND v(dout1_217) AT=870.05n

.meas tran vdout1_218ck860 FIND v(dout1_218) AT=870.05n

.meas tran vdout1_219ck860 FIND v(dout1_219) AT=870.05n

.meas tran vdout1_220ck860 FIND v(dout1_220) AT=870.05n

.meas tran vdout1_221ck860 FIND v(dout1_221) AT=870.05n

.meas tran vdout1_222ck860 FIND v(dout1_222) AT=870.05n

.meas tran vdout1_223ck860 FIND v(dout1_223) AT=870.05n

.meas tran vdout1_224ck860 FIND v(dout1_224) AT=870.05n

.meas tran vdout1_225ck860 FIND v(dout1_225) AT=870.05n

.meas tran vdout1_226ck860 FIND v(dout1_226) AT=870.05n

.meas tran vdout1_227ck860 FIND v(dout1_227) AT=870.05n

.meas tran vdout1_228ck860 FIND v(dout1_228) AT=870.05n

.meas tran vdout1_229ck860 FIND v(dout1_229) AT=870.05n

.meas tran vdout1_230ck860 FIND v(dout1_230) AT=870.05n

.meas tran vdout1_231ck860 FIND v(dout1_231) AT=870.05n

.meas tran vdout1_232ck860 FIND v(dout1_232) AT=870.05n

.meas tran vdout1_233ck860 FIND v(dout1_233) AT=870.05n

.meas tran vdout1_234ck860 FIND v(dout1_234) AT=870.05n

.meas tran vdout1_235ck860 FIND v(dout1_235) AT=870.05n

.meas tran vdout1_236ck860 FIND v(dout1_236) AT=870.05n

.meas tran vdout1_237ck860 FIND v(dout1_237) AT=870.05n

.meas tran vdout1_238ck860 FIND v(dout1_238) AT=870.05n

.meas tran vdout1_239ck860 FIND v(dout1_239) AT=870.05n

.meas tran vdout1_240ck860 FIND v(dout1_240) AT=870.05n

.meas tran vdout1_241ck860 FIND v(dout1_241) AT=870.05n

.meas tran vdout1_242ck860 FIND v(dout1_242) AT=870.05n

.meas tran vdout1_243ck860 FIND v(dout1_243) AT=870.05n

.meas tran vdout1_244ck860 FIND v(dout1_244) AT=870.05n

.meas tran vdout1_245ck860 FIND v(dout1_245) AT=870.05n

.meas tran vdout1_246ck860 FIND v(dout1_246) AT=870.05n

.meas tran vdout1_247ck860 FIND v(dout1_247) AT=870.05n

.meas tran vdout1_248ck860 FIND v(dout1_248) AT=870.05n

.meas tran vdout1_249ck860 FIND v(dout1_249) AT=870.05n

.meas tran vdout1_250ck860 FIND v(dout1_250) AT=870.05n

.meas tran vdout1_251ck860 FIND v(dout1_251) AT=870.05n

.meas tran vdout1_252ck860 FIND v(dout1_252) AT=870.05n

.meas tran vdout1_253ck860 FIND v(dout1_253) AT=870.05n

.meas tran vdout1_254ck860 FIND v(dout1_254) AT=870.05n

.meas tran vdout1_255ck860 FIND v(dout1_255) AT=870.05n

.meas tran vdout1_256ck860 FIND v(dout1_256) AT=870.05n

.meas tran vdout1_0ck880 FIND v(dout1_0) AT=890.05n

.meas tran vdout1_1ck880 FIND v(dout1_1) AT=890.05n

.meas tran vdout1_2ck880 FIND v(dout1_2) AT=890.05n

.meas tran vdout1_3ck880 FIND v(dout1_3) AT=890.05n

.meas tran vdout1_4ck880 FIND v(dout1_4) AT=890.05n

.meas tran vdout1_5ck880 FIND v(dout1_5) AT=890.05n

.meas tran vdout1_6ck880 FIND v(dout1_6) AT=890.05n

.meas tran vdout1_7ck880 FIND v(dout1_7) AT=890.05n

.meas tran vdout1_8ck880 FIND v(dout1_8) AT=890.05n

.meas tran vdout1_9ck880 FIND v(dout1_9) AT=890.05n

.meas tran vdout1_10ck880 FIND v(dout1_10) AT=890.05n

.meas tran vdout1_11ck880 FIND v(dout1_11) AT=890.05n

.meas tran vdout1_12ck880 FIND v(dout1_12) AT=890.05n

.meas tran vdout1_13ck880 FIND v(dout1_13) AT=890.05n

.meas tran vdout1_14ck880 FIND v(dout1_14) AT=890.05n

.meas tran vdout1_15ck880 FIND v(dout1_15) AT=890.05n

.meas tran vdout1_16ck880 FIND v(dout1_16) AT=890.05n

.meas tran vdout1_17ck880 FIND v(dout1_17) AT=890.05n

.meas tran vdout1_18ck880 FIND v(dout1_18) AT=890.05n

.meas tran vdout1_19ck880 FIND v(dout1_19) AT=890.05n

.meas tran vdout1_20ck880 FIND v(dout1_20) AT=890.05n

.meas tran vdout1_21ck880 FIND v(dout1_21) AT=890.05n

.meas tran vdout1_22ck880 FIND v(dout1_22) AT=890.05n

.meas tran vdout1_23ck880 FIND v(dout1_23) AT=890.05n

.meas tran vdout1_24ck880 FIND v(dout1_24) AT=890.05n

.meas tran vdout1_25ck880 FIND v(dout1_25) AT=890.05n

.meas tran vdout1_26ck880 FIND v(dout1_26) AT=890.05n

.meas tran vdout1_27ck880 FIND v(dout1_27) AT=890.05n

.meas tran vdout1_28ck880 FIND v(dout1_28) AT=890.05n

.meas tran vdout1_29ck880 FIND v(dout1_29) AT=890.05n

.meas tran vdout1_30ck880 FIND v(dout1_30) AT=890.05n

.meas tran vdout1_31ck880 FIND v(dout1_31) AT=890.05n

.meas tran vdout1_32ck880 FIND v(dout1_32) AT=890.05n

.meas tran vdout1_33ck880 FIND v(dout1_33) AT=890.05n

.meas tran vdout1_34ck880 FIND v(dout1_34) AT=890.05n

.meas tran vdout1_35ck880 FIND v(dout1_35) AT=890.05n

.meas tran vdout1_36ck880 FIND v(dout1_36) AT=890.05n

.meas tran vdout1_37ck880 FIND v(dout1_37) AT=890.05n

.meas tran vdout1_38ck880 FIND v(dout1_38) AT=890.05n

.meas tran vdout1_39ck880 FIND v(dout1_39) AT=890.05n

.meas tran vdout1_40ck880 FIND v(dout1_40) AT=890.05n

.meas tran vdout1_41ck880 FIND v(dout1_41) AT=890.05n

.meas tran vdout1_42ck880 FIND v(dout1_42) AT=890.05n

.meas tran vdout1_43ck880 FIND v(dout1_43) AT=890.05n

.meas tran vdout1_44ck880 FIND v(dout1_44) AT=890.05n

.meas tran vdout1_45ck880 FIND v(dout1_45) AT=890.05n

.meas tran vdout1_46ck880 FIND v(dout1_46) AT=890.05n

.meas tran vdout1_47ck880 FIND v(dout1_47) AT=890.05n

.meas tran vdout1_48ck880 FIND v(dout1_48) AT=890.05n

.meas tran vdout1_49ck880 FIND v(dout1_49) AT=890.05n

.meas tran vdout1_50ck880 FIND v(dout1_50) AT=890.05n

.meas tran vdout1_51ck880 FIND v(dout1_51) AT=890.05n

.meas tran vdout1_52ck880 FIND v(dout1_52) AT=890.05n

.meas tran vdout1_53ck880 FIND v(dout1_53) AT=890.05n

.meas tran vdout1_54ck880 FIND v(dout1_54) AT=890.05n

.meas tran vdout1_55ck880 FIND v(dout1_55) AT=890.05n

.meas tran vdout1_56ck880 FIND v(dout1_56) AT=890.05n

.meas tran vdout1_57ck880 FIND v(dout1_57) AT=890.05n

.meas tran vdout1_58ck880 FIND v(dout1_58) AT=890.05n

.meas tran vdout1_59ck880 FIND v(dout1_59) AT=890.05n

.meas tran vdout1_60ck880 FIND v(dout1_60) AT=890.05n

.meas tran vdout1_61ck880 FIND v(dout1_61) AT=890.05n

.meas tran vdout1_62ck880 FIND v(dout1_62) AT=890.05n

.meas tran vdout1_63ck880 FIND v(dout1_63) AT=890.05n

.meas tran vdout1_64ck880 FIND v(dout1_64) AT=890.05n

.meas tran vdout1_65ck880 FIND v(dout1_65) AT=890.05n

.meas tran vdout1_66ck880 FIND v(dout1_66) AT=890.05n

.meas tran vdout1_67ck880 FIND v(dout1_67) AT=890.05n

.meas tran vdout1_68ck880 FIND v(dout1_68) AT=890.05n

.meas tran vdout1_69ck880 FIND v(dout1_69) AT=890.05n

.meas tran vdout1_70ck880 FIND v(dout1_70) AT=890.05n

.meas tran vdout1_71ck880 FIND v(dout1_71) AT=890.05n

.meas tran vdout1_72ck880 FIND v(dout1_72) AT=890.05n

.meas tran vdout1_73ck880 FIND v(dout1_73) AT=890.05n

.meas tran vdout1_74ck880 FIND v(dout1_74) AT=890.05n

.meas tran vdout1_75ck880 FIND v(dout1_75) AT=890.05n

.meas tran vdout1_76ck880 FIND v(dout1_76) AT=890.05n

.meas tran vdout1_77ck880 FIND v(dout1_77) AT=890.05n

.meas tran vdout1_78ck880 FIND v(dout1_78) AT=890.05n

.meas tran vdout1_79ck880 FIND v(dout1_79) AT=890.05n

.meas tran vdout1_80ck880 FIND v(dout1_80) AT=890.05n

.meas tran vdout1_81ck880 FIND v(dout1_81) AT=890.05n

.meas tran vdout1_82ck880 FIND v(dout1_82) AT=890.05n

.meas tran vdout1_83ck880 FIND v(dout1_83) AT=890.05n

.meas tran vdout1_84ck880 FIND v(dout1_84) AT=890.05n

.meas tran vdout1_85ck880 FIND v(dout1_85) AT=890.05n

.meas tran vdout1_86ck880 FIND v(dout1_86) AT=890.05n

.meas tran vdout1_87ck880 FIND v(dout1_87) AT=890.05n

.meas tran vdout1_88ck880 FIND v(dout1_88) AT=890.05n

.meas tran vdout1_89ck880 FIND v(dout1_89) AT=890.05n

.meas tran vdout1_90ck880 FIND v(dout1_90) AT=890.05n

.meas tran vdout1_91ck880 FIND v(dout1_91) AT=890.05n

.meas tran vdout1_92ck880 FIND v(dout1_92) AT=890.05n

.meas tran vdout1_93ck880 FIND v(dout1_93) AT=890.05n

.meas tran vdout1_94ck880 FIND v(dout1_94) AT=890.05n

.meas tran vdout1_95ck880 FIND v(dout1_95) AT=890.05n

.meas tran vdout1_96ck880 FIND v(dout1_96) AT=890.05n

.meas tran vdout1_97ck880 FIND v(dout1_97) AT=890.05n

.meas tran vdout1_98ck880 FIND v(dout1_98) AT=890.05n

.meas tran vdout1_99ck880 FIND v(dout1_99) AT=890.05n

.meas tran vdout1_100ck880 FIND v(dout1_100) AT=890.05n

.meas tran vdout1_101ck880 FIND v(dout1_101) AT=890.05n

.meas tran vdout1_102ck880 FIND v(dout1_102) AT=890.05n

.meas tran vdout1_103ck880 FIND v(dout1_103) AT=890.05n

.meas tran vdout1_104ck880 FIND v(dout1_104) AT=890.05n

.meas tran vdout1_105ck880 FIND v(dout1_105) AT=890.05n

.meas tran vdout1_106ck880 FIND v(dout1_106) AT=890.05n

.meas tran vdout1_107ck880 FIND v(dout1_107) AT=890.05n

.meas tran vdout1_108ck880 FIND v(dout1_108) AT=890.05n

.meas tran vdout1_109ck880 FIND v(dout1_109) AT=890.05n

.meas tran vdout1_110ck880 FIND v(dout1_110) AT=890.05n

.meas tran vdout1_111ck880 FIND v(dout1_111) AT=890.05n

.meas tran vdout1_112ck880 FIND v(dout1_112) AT=890.05n

.meas tran vdout1_113ck880 FIND v(dout1_113) AT=890.05n

.meas tran vdout1_114ck880 FIND v(dout1_114) AT=890.05n

.meas tran vdout1_115ck880 FIND v(dout1_115) AT=890.05n

.meas tran vdout1_116ck880 FIND v(dout1_116) AT=890.05n

.meas tran vdout1_117ck880 FIND v(dout1_117) AT=890.05n

.meas tran vdout1_118ck880 FIND v(dout1_118) AT=890.05n

.meas tran vdout1_119ck880 FIND v(dout1_119) AT=890.05n

.meas tran vdout1_120ck880 FIND v(dout1_120) AT=890.05n

.meas tran vdout1_121ck880 FIND v(dout1_121) AT=890.05n

.meas tran vdout1_122ck880 FIND v(dout1_122) AT=890.05n

.meas tran vdout1_123ck880 FIND v(dout1_123) AT=890.05n

.meas tran vdout1_124ck880 FIND v(dout1_124) AT=890.05n

.meas tran vdout1_125ck880 FIND v(dout1_125) AT=890.05n

.meas tran vdout1_126ck880 FIND v(dout1_126) AT=890.05n

.meas tran vdout1_127ck880 FIND v(dout1_127) AT=890.05n

.meas tran vdout1_128ck880 FIND v(dout1_128) AT=890.05n

.meas tran vdout1_129ck880 FIND v(dout1_129) AT=890.05n

.meas tran vdout1_130ck880 FIND v(dout1_130) AT=890.05n

.meas tran vdout1_131ck880 FIND v(dout1_131) AT=890.05n

.meas tran vdout1_132ck880 FIND v(dout1_132) AT=890.05n

.meas tran vdout1_133ck880 FIND v(dout1_133) AT=890.05n

.meas tran vdout1_134ck880 FIND v(dout1_134) AT=890.05n

.meas tran vdout1_135ck880 FIND v(dout1_135) AT=890.05n

.meas tran vdout1_136ck880 FIND v(dout1_136) AT=890.05n

.meas tran vdout1_137ck880 FIND v(dout1_137) AT=890.05n

.meas tran vdout1_138ck880 FIND v(dout1_138) AT=890.05n

.meas tran vdout1_139ck880 FIND v(dout1_139) AT=890.05n

.meas tran vdout1_140ck880 FIND v(dout1_140) AT=890.05n

.meas tran vdout1_141ck880 FIND v(dout1_141) AT=890.05n

.meas tran vdout1_142ck880 FIND v(dout1_142) AT=890.05n

.meas tran vdout1_143ck880 FIND v(dout1_143) AT=890.05n

.meas tran vdout1_144ck880 FIND v(dout1_144) AT=890.05n

.meas tran vdout1_145ck880 FIND v(dout1_145) AT=890.05n

.meas tran vdout1_146ck880 FIND v(dout1_146) AT=890.05n

.meas tran vdout1_147ck880 FIND v(dout1_147) AT=890.05n

.meas tran vdout1_148ck880 FIND v(dout1_148) AT=890.05n

.meas tran vdout1_149ck880 FIND v(dout1_149) AT=890.05n

.meas tran vdout1_150ck880 FIND v(dout1_150) AT=890.05n

.meas tran vdout1_151ck880 FIND v(dout1_151) AT=890.05n

.meas tran vdout1_152ck880 FIND v(dout1_152) AT=890.05n

.meas tran vdout1_153ck880 FIND v(dout1_153) AT=890.05n

.meas tran vdout1_154ck880 FIND v(dout1_154) AT=890.05n

.meas tran vdout1_155ck880 FIND v(dout1_155) AT=890.05n

.meas tran vdout1_156ck880 FIND v(dout1_156) AT=890.05n

.meas tran vdout1_157ck880 FIND v(dout1_157) AT=890.05n

.meas tran vdout1_158ck880 FIND v(dout1_158) AT=890.05n

.meas tran vdout1_159ck880 FIND v(dout1_159) AT=890.05n

.meas tran vdout1_160ck880 FIND v(dout1_160) AT=890.05n

.meas tran vdout1_161ck880 FIND v(dout1_161) AT=890.05n

.meas tran vdout1_162ck880 FIND v(dout1_162) AT=890.05n

.meas tran vdout1_163ck880 FIND v(dout1_163) AT=890.05n

.meas tran vdout1_164ck880 FIND v(dout1_164) AT=890.05n

.meas tran vdout1_165ck880 FIND v(dout1_165) AT=890.05n

.meas tran vdout1_166ck880 FIND v(dout1_166) AT=890.05n

.meas tran vdout1_167ck880 FIND v(dout1_167) AT=890.05n

.meas tran vdout1_168ck880 FIND v(dout1_168) AT=890.05n

.meas tran vdout1_169ck880 FIND v(dout1_169) AT=890.05n

.meas tran vdout1_170ck880 FIND v(dout1_170) AT=890.05n

.meas tran vdout1_171ck880 FIND v(dout1_171) AT=890.05n

.meas tran vdout1_172ck880 FIND v(dout1_172) AT=890.05n

.meas tran vdout1_173ck880 FIND v(dout1_173) AT=890.05n

.meas tran vdout1_174ck880 FIND v(dout1_174) AT=890.05n

.meas tran vdout1_175ck880 FIND v(dout1_175) AT=890.05n

.meas tran vdout1_176ck880 FIND v(dout1_176) AT=890.05n

.meas tran vdout1_177ck880 FIND v(dout1_177) AT=890.05n

.meas tran vdout1_178ck880 FIND v(dout1_178) AT=890.05n

.meas tran vdout1_179ck880 FIND v(dout1_179) AT=890.05n

.meas tran vdout1_180ck880 FIND v(dout1_180) AT=890.05n

.meas tran vdout1_181ck880 FIND v(dout1_181) AT=890.05n

.meas tran vdout1_182ck880 FIND v(dout1_182) AT=890.05n

.meas tran vdout1_183ck880 FIND v(dout1_183) AT=890.05n

.meas tran vdout1_184ck880 FIND v(dout1_184) AT=890.05n

.meas tran vdout1_185ck880 FIND v(dout1_185) AT=890.05n

.meas tran vdout1_186ck880 FIND v(dout1_186) AT=890.05n

.meas tran vdout1_187ck880 FIND v(dout1_187) AT=890.05n

.meas tran vdout1_188ck880 FIND v(dout1_188) AT=890.05n

.meas tran vdout1_189ck880 FIND v(dout1_189) AT=890.05n

.meas tran vdout1_190ck880 FIND v(dout1_190) AT=890.05n

.meas tran vdout1_191ck880 FIND v(dout1_191) AT=890.05n

.meas tran vdout1_192ck880 FIND v(dout1_192) AT=890.05n

.meas tran vdout1_193ck880 FIND v(dout1_193) AT=890.05n

.meas tran vdout1_194ck880 FIND v(dout1_194) AT=890.05n

.meas tran vdout1_195ck880 FIND v(dout1_195) AT=890.05n

.meas tran vdout1_196ck880 FIND v(dout1_196) AT=890.05n

.meas tran vdout1_197ck880 FIND v(dout1_197) AT=890.05n

.meas tran vdout1_198ck880 FIND v(dout1_198) AT=890.05n

.meas tran vdout1_199ck880 FIND v(dout1_199) AT=890.05n

.meas tran vdout1_200ck880 FIND v(dout1_200) AT=890.05n

.meas tran vdout1_201ck880 FIND v(dout1_201) AT=890.05n

.meas tran vdout1_202ck880 FIND v(dout1_202) AT=890.05n

.meas tran vdout1_203ck880 FIND v(dout1_203) AT=890.05n

.meas tran vdout1_204ck880 FIND v(dout1_204) AT=890.05n

.meas tran vdout1_205ck880 FIND v(dout1_205) AT=890.05n

.meas tran vdout1_206ck880 FIND v(dout1_206) AT=890.05n

.meas tran vdout1_207ck880 FIND v(dout1_207) AT=890.05n

.meas tran vdout1_208ck880 FIND v(dout1_208) AT=890.05n

.meas tran vdout1_209ck880 FIND v(dout1_209) AT=890.05n

.meas tran vdout1_210ck880 FIND v(dout1_210) AT=890.05n

.meas tran vdout1_211ck880 FIND v(dout1_211) AT=890.05n

.meas tran vdout1_212ck880 FIND v(dout1_212) AT=890.05n

.meas tran vdout1_213ck880 FIND v(dout1_213) AT=890.05n

.meas tran vdout1_214ck880 FIND v(dout1_214) AT=890.05n

.meas tran vdout1_215ck880 FIND v(dout1_215) AT=890.05n

.meas tran vdout1_216ck880 FIND v(dout1_216) AT=890.05n

.meas tran vdout1_217ck880 FIND v(dout1_217) AT=890.05n

.meas tran vdout1_218ck880 FIND v(dout1_218) AT=890.05n

.meas tran vdout1_219ck880 FIND v(dout1_219) AT=890.05n

.meas tran vdout1_220ck880 FIND v(dout1_220) AT=890.05n

.meas tran vdout1_221ck880 FIND v(dout1_221) AT=890.05n

.meas tran vdout1_222ck880 FIND v(dout1_222) AT=890.05n

.meas tran vdout1_223ck880 FIND v(dout1_223) AT=890.05n

.meas tran vdout1_224ck880 FIND v(dout1_224) AT=890.05n

.meas tran vdout1_225ck880 FIND v(dout1_225) AT=890.05n

.meas tran vdout1_226ck880 FIND v(dout1_226) AT=890.05n

.meas tran vdout1_227ck880 FIND v(dout1_227) AT=890.05n

.meas tran vdout1_228ck880 FIND v(dout1_228) AT=890.05n

.meas tran vdout1_229ck880 FIND v(dout1_229) AT=890.05n

.meas tran vdout1_230ck880 FIND v(dout1_230) AT=890.05n

.meas tran vdout1_231ck880 FIND v(dout1_231) AT=890.05n

.meas tran vdout1_232ck880 FIND v(dout1_232) AT=890.05n

.meas tran vdout1_233ck880 FIND v(dout1_233) AT=890.05n

.meas tran vdout1_234ck880 FIND v(dout1_234) AT=890.05n

.meas tran vdout1_235ck880 FIND v(dout1_235) AT=890.05n

.meas tran vdout1_236ck880 FIND v(dout1_236) AT=890.05n

.meas tran vdout1_237ck880 FIND v(dout1_237) AT=890.05n

.meas tran vdout1_238ck880 FIND v(dout1_238) AT=890.05n

.meas tran vdout1_239ck880 FIND v(dout1_239) AT=890.05n

.meas tran vdout1_240ck880 FIND v(dout1_240) AT=890.05n

.meas tran vdout1_241ck880 FIND v(dout1_241) AT=890.05n

.meas tran vdout1_242ck880 FIND v(dout1_242) AT=890.05n

.meas tran vdout1_243ck880 FIND v(dout1_243) AT=890.05n

.meas tran vdout1_244ck880 FIND v(dout1_244) AT=890.05n

.meas tran vdout1_245ck880 FIND v(dout1_245) AT=890.05n

.meas tran vdout1_246ck880 FIND v(dout1_246) AT=890.05n

.meas tran vdout1_247ck880 FIND v(dout1_247) AT=890.05n

.meas tran vdout1_248ck880 FIND v(dout1_248) AT=890.05n

.meas tran vdout1_249ck880 FIND v(dout1_249) AT=890.05n

.meas tran vdout1_250ck880 FIND v(dout1_250) AT=890.05n

.meas tran vdout1_251ck880 FIND v(dout1_251) AT=890.05n

.meas tran vdout1_252ck880 FIND v(dout1_252) AT=890.05n

.meas tran vdout1_253ck880 FIND v(dout1_253) AT=890.05n

.meas tran vdout1_254ck880 FIND v(dout1_254) AT=890.05n

.meas tran vdout1_255ck880 FIND v(dout1_255) AT=890.05n

.meas tran vdout1_256ck880 FIND v(dout1_256) AT=890.05n

.meas tran vdout1_0ck890 FIND v(dout1_0) AT=900.05n

.meas tran vdout1_1ck890 FIND v(dout1_1) AT=900.05n

.meas tran vdout1_2ck890 FIND v(dout1_2) AT=900.05n

.meas tran vdout1_3ck890 FIND v(dout1_3) AT=900.05n

.meas tran vdout1_4ck890 FIND v(dout1_4) AT=900.05n

.meas tran vdout1_5ck890 FIND v(dout1_5) AT=900.05n

.meas tran vdout1_6ck890 FIND v(dout1_6) AT=900.05n

.meas tran vdout1_7ck890 FIND v(dout1_7) AT=900.05n

.meas tran vdout1_8ck890 FIND v(dout1_8) AT=900.05n

.meas tran vdout1_9ck890 FIND v(dout1_9) AT=900.05n

.meas tran vdout1_10ck890 FIND v(dout1_10) AT=900.05n

.meas tran vdout1_11ck890 FIND v(dout1_11) AT=900.05n

.meas tran vdout1_12ck890 FIND v(dout1_12) AT=900.05n

.meas tran vdout1_13ck890 FIND v(dout1_13) AT=900.05n

.meas tran vdout1_14ck890 FIND v(dout1_14) AT=900.05n

.meas tran vdout1_15ck890 FIND v(dout1_15) AT=900.05n

.meas tran vdout1_16ck890 FIND v(dout1_16) AT=900.05n

.meas tran vdout1_17ck890 FIND v(dout1_17) AT=900.05n

.meas tran vdout1_18ck890 FIND v(dout1_18) AT=900.05n

.meas tran vdout1_19ck890 FIND v(dout1_19) AT=900.05n

.meas tran vdout1_20ck890 FIND v(dout1_20) AT=900.05n

.meas tran vdout1_21ck890 FIND v(dout1_21) AT=900.05n

.meas tran vdout1_22ck890 FIND v(dout1_22) AT=900.05n

.meas tran vdout1_23ck890 FIND v(dout1_23) AT=900.05n

.meas tran vdout1_24ck890 FIND v(dout1_24) AT=900.05n

.meas tran vdout1_25ck890 FIND v(dout1_25) AT=900.05n

.meas tran vdout1_26ck890 FIND v(dout1_26) AT=900.05n

.meas tran vdout1_27ck890 FIND v(dout1_27) AT=900.05n

.meas tran vdout1_28ck890 FIND v(dout1_28) AT=900.05n

.meas tran vdout1_29ck890 FIND v(dout1_29) AT=900.05n

.meas tran vdout1_30ck890 FIND v(dout1_30) AT=900.05n

.meas tran vdout1_31ck890 FIND v(dout1_31) AT=900.05n

.meas tran vdout1_32ck890 FIND v(dout1_32) AT=900.05n

.meas tran vdout1_33ck890 FIND v(dout1_33) AT=900.05n

.meas tran vdout1_34ck890 FIND v(dout1_34) AT=900.05n

.meas tran vdout1_35ck890 FIND v(dout1_35) AT=900.05n

.meas tran vdout1_36ck890 FIND v(dout1_36) AT=900.05n

.meas tran vdout1_37ck890 FIND v(dout1_37) AT=900.05n

.meas tran vdout1_38ck890 FIND v(dout1_38) AT=900.05n

.meas tran vdout1_39ck890 FIND v(dout1_39) AT=900.05n

.meas tran vdout1_40ck890 FIND v(dout1_40) AT=900.05n

.meas tran vdout1_41ck890 FIND v(dout1_41) AT=900.05n

.meas tran vdout1_42ck890 FIND v(dout1_42) AT=900.05n

.meas tran vdout1_43ck890 FIND v(dout1_43) AT=900.05n

.meas tran vdout1_44ck890 FIND v(dout1_44) AT=900.05n

.meas tran vdout1_45ck890 FIND v(dout1_45) AT=900.05n

.meas tran vdout1_46ck890 FIND v(dout1_46) AT=900.05n

.meas tran vdout1_47ck890 FIND v(dout1_47) AT=900.05n

.meas tran vdout1_48ck890 FIND v(dout1_48) AT=900.05n

.meas tran vdout1_49ck890 FIND v(dout1_49) AT=900.05n

.meas tran vdout1_50ck890 FIND v(dout1_50) AT=900.05n

.meas tran vdout1_51ck890 FIND v(dout1_51) AT=900.05n

.meas tran vdout1_52ck890 FIND v(dout1_52) AT=900.05n

.meas tran vdout1_53ck890 FIND v(dout1_53) AT=900.05n

.meas tran vdout1_54ck890 FIND v(dout1_54) AT=900.05n

.meas tran vdout1_55ck890 FIND v(dout1_55) AT=900.05n

.meas tran vdout1_56ck890 FIND v(dout1_56) AT=900.05n

.meas tran vdout1_57ck890 FIND v(dout1_57) AT=900.05n

.meas tran vdout1_58ck890 FIND v(dout1_58) AT=900.05n

.meas tran vdout1_59ck890 FIND v(dout1_59) AT=900.05n

.meas tran vdout1_60ck890 FIND v(dout1_60) AT=900.05n

.meas tran vdout1_61ck890 FIND v(dout1_61) AT=900.05n

.meas tran vdout1_62ck890 FIND v(dout1_62) AT=900.05n

.meas tran vdout1_63ck890 FIND v(dout1_63) AT=900.05n

.meas tran vdout1_64ck890 FIND v(dout1_64) AT=900.05n

.meas tran vdout1_65ck890 FIND v(dout1_65) AT=900.05n

.meas tran vdout1_66ck890 FIND v(dout1_66) AT=900.05n

.meas tran vdout1_67ck890 FIND v(dout1_67) AT=900.05n

.meas tran vdout1_68ck890 FIND v(dout1_68) AT=900.05n

.meas tran vdout1_69ck890 FIND v(dout1_69) AT=900.05n

.meas tran vdout1_70ck890 FIND v(dout1_70) AT=900.05n

.meas tran vdout1_71ck890 FIND v(dout1_71) AT=900.05n

.meas tran vdout1_72ck890 FIND v(dout1_72) AT=900.05n

.meas tran vdout1_73ck890 FIND v(dout1_73) AT=900.05n

.meas tran vdout1_74ck890 FIND v(dout1_74) AT=900.05n

.meas tran vdout1_75ck890 FIND v(dout1_75) AT=900.05n

.meas tran vdout1_76ck890 FIND v(dout1_76) AT=900.05n

.meas tran vdout1_77ck890 FIND v(dout1_77) AT=900.05n

.meas tran vdout1_78ck890 FIND v(dout1_78) AT=900.05n

.meas tran vdout1_79ck890 FIND v(dout1_79) AT=900.05n

.meas tran vdout1_80ck890 FIND v(dout1_80) AT=900.05n

.meas tran vdout1_81ck890 FIND v(dout1_81) AT=900.05n

.meas tran vdout1_82ck890 FIND v(dout1_82) AT=900.05n

.meas tran vdout1_83ck890 FIND v(dout1_83) AT=900.05n

.meas tran vdout1_84ck890 FIND v(dout1_84) AT=900.05n

.meas tran vdout1_85ck890 FIND v(dout1_85) AT=900.05n

.meas tran vdout1_86ck890 FIND v(dout1_86) AT=900.05n

.meas tran vdout1_87ck890 FIND v(dout1_87) AT=900.05n

.meas tran vdout1_88ck890 FIND v(dout1_88) AT=900.05n

.meas tran vdout1_89ck890 FIND v(dout1_89) AT=900.05n

.meas tran vdout1_90ck890 FIND v(dout1_90) AT=900.05n

.meas tran vdout1_91ck890 FIND v(dout1_91) AT=900.05n

.meas tran vdout1_92ck890 FIND v(dout1_92) AT=900.05n

.meas tran vdout1_93ck890 FIND v(dout1_93) AT=900.05n

.meas tran vdout1_94ck890 FIND v(dout1_94) AT=900.05n

.meas tran vdout1_95ck890 FIND v(dout1_95) AT=900.05n

.meas tran vdout1_96ck890 FIND v(dout1_96) AT=900.05n

.meas tran vdout1_97ck890 FIND v(dout1_97) AT=900.05n

.meas tran vdout1_98ck890 FIND v(dout1_98) AT=900.05n

.meas tran vdout1_99ck890 FIND v(dout1_99) AT=900.05n

.meas tran vdout1_100ck890 FIND v(dout1_100) AT=900.05n

.meas tran vdout1_101ck890 FIND v(dout1_101) AT=900.05n

.meas tran vdout1_102ck890 FIND v(dout1_102) AT=900.05n

.meas tran vdout1_103ck890 FIND v(dout1_103) AT=900.05n

.meas tran vdout1_104ck890 FIND v(dout1_104) AT=900.05n

.meas tran vdout1_105ck890 FIND v(dout1_105) AT=900.05n

.meas tran vdout1_106ck890 FIND v(dout1_106) AT=900.05n

.meas tran vdout1_107ck890 FIND v(dout1_107) AT=900.05n

.meas tran vdout1_108ck890 FIND v(dout1_108) AT=900.05n

.meas tran vdout1_109ck890 FIND v(dout1_109) AT=900.05n

.meas tran vdout1_110ck890 FIND v(dout1_110) AT=900.05n

.meas tran vdout1_111ck890 FIND v(dout1_111) AT=900.05n

.meas tran vdout1_112ck890 FIND v(dout1_112) AT=900.05n

.meas tran vdout1_113ck890 FIND v(dout1_113) AT=900.05n

.meas tran vdout1_114ck890 FIND v(dout1_114) AT=900.05n

.meas tran vdout1_115ck890 FIND v(dout1_115) AT=900.05n

.meas tran vdout1_116ck890 FIND v(dout1_116) AT=900.05n

.meas tran vdout1_117ck890 FIND v(dout1_117) AT=900.05n

.meas tran vdout1_118ck890 FIND v(dout1_118) AT=900.05n

.meas tran vdout1_119ck890 FIND v(dout1_119) AT=900.05n

.meas tran vdout1_120ck890 FIND v(dout1_120) AT=900.05n

.meas tran vdout1_121ck890 FIND v(dout1_121) AT=900.05n

.meas tran vdout1_122ck890 FIND v(dout1_122) AT=900.05n

.meas tran vdout1_123ck890 FIND v(dout1_123) AT=900.05n

.meas tran vdout1_124ck890 FIND v(dout1_124) AT=900.05n

.meas tran vdout1_125ck890 FIND v(dout1_125) AT=900.05n

.meas tran vdout1_126ck890 FIND v(dout1_126) AT=900.05n

.meas tran vdout1_127ck890 FIND v(dout1_127) AT=900.05n

.meas tran vdout1_128ck890 FIND v(dout1_128) AT=900.05n

.meas tran vdout1_129ck890 FIND v(dout1_129) AT=900.05n

.meas tran vdout1_130ck890 FIND v(dout1_130) AT=900.05n

.meas tran vdout1_131ck890 FIND v(dout1_131) AT=900.05n

.meas tran vdout1_132ck890 FIND v(dout1_132) AT=900.05n

.meas tran vdout1_133ck890 FIND v(dout1_133) AT=900.05n

.meas tran vdout1_134ck890 FIND v(dout1_134) AT=900.05n

.meas tran vdout1_135ck890 FIND v(dout1_135) AT=900.05n

.meas tran vdout1_136ck890 FIND v(dout1_136) AT=900.05n

.meas tran vdout1_137ck890 FIND v(dout1_137) AT=900.05n

.meas tran vdout1_138ck890 FIND v(dout1_138) AT=900.05n

.meas tran vdout1_139ck890 FIND v(dout1_139) AT=900.05n

.meas tran vdout1_140ck890 FIND v(dout1_140) AT=900.05n

.meas tran vdout1_141ck890 FIND v(dout1_141) AT=900.05n

.meas tran vdout1_142ck890 FIND v(dout1_142) AT=900.05n

.meas tran vdout1_143ck890 FIND v(dout1_143) AT=900.05n

.meas tran vdout1_144ck890 FIND v(dout1_144) AT=900.05n

.meas tran vdout1_145ck890 FIND v(dout1_145) AT=900.05n

.meas tran vdout1_146ck890 FIND v(dout1_146) AT=900.05n

.meas tran vdout1_147ck890 FIND v(dout1_147) AT=900.05n

.meas tran vdout1_148ck890 FIND v(dout1_148) AT=900.05n

.meas tran vdout1_149ck890 FIND v(dout1_149) AT=900.05n

.meas tran vdout1_150ck890 FIND v(dout1_150) AT=900.05n

.meas tran vdout1_151ck890 FIND v(dout1_151) AT=900.05n

.meas tran vdout1_152ck890 FIND v(dout1_152) AT=900.05n

.meas tran vdout1_153ck890 FIND v(dout1_153) AT=900.05n

.meas tran vdout1_154ck890 FIND v(dout1_154) AT=900.05n

.meas tran vdout1_155ck890 FIND v(dout1_155) AT=900.05n

.meas tran vdout1_156ck890 FIND v(dout1_156) AT=900.05n

.meas tran vdout1_157ck890 FIND v(dout1_157) AT=900.05n

.meas tran vdout1_158ck890 FIND v(dout1_158) AT=900.05n

.meas tran vdout1_159ck890 FIND v(dout1_159) AT=900.05n

.meas tran vdout1_160ck890 FIND v(dout1_160) AT=900.05n

.meas tran vdout1_161ck890 FIND v(dout1_161) AT=900.05n

.meas tran vdout1_162ck890 FIND v(dout1_162) AT=900.05n

.meas tran vdout1_163ck890 FIND v(dout1_163) AT=900.05n

.meas tran vdout1_164ck890 FIND v(dout1_164) AT=900.05n

.meas tran vdout1_165ck890 FIND v(dout1_165) AT=900.05n

.meas tran vdout1_166ck890 FIND v(dout1_166) AT=900.05n

.meas tran vdout1_167ck890 FIND v(dout1_167) AT=900.05n

.meas tran vdout1_168ck890 FIND v(dout1_168) AT=900.05n

.meas tran vdout1_169ck890 FIND v(dout1_169) AT=900.05n

.meas tran vdout1_170ck890 FIND v(dout1_170) AT=900.05n

.meas tran vdout1_171ck890 FIND v(dout1_171) AT=900.05n

.meas tran vdout1_172ck890 FIND v(dout1_172) AT=900.05n

.meas tran vdout1_173ck890 FIND v(dout1_173) AT=900.05n

.meas tran vdout1_174ck890 FIND v(dout1_174) AT=900.05n

.meas tran vdout1_175ck890 FIND v(dout1_175) AT=900.05n

.meas tran vdout1_176ck890 FIND v(dout1_176) AT=900.05n

.meas tran vdout1_177ck890 FIND v(dout1_177) AT=900.05n

.meas tran vdout1_178ck890 FIND v(dout1_178) AT=900.05n

.meas tran vdout1_179ck890 FIND v(dout1_179) AT=900.05n

.meas tran vdout1_180ck890 FIND v(dout1_180) AT=900.05n

.meas tran vdout1_181ck890 FIND v(dout1_181) AT=900.05n

.meas tran vdout1_182ck890 FIND v(dout1_182) AT=900.05n

.meas tran vdout1_183ck890 FIND v(dout1_183) AT=900.05n

.meas tran vdout1_184ck890 FIND v(dout1_184) AT=900.05n

.meas tran vdout1_185ck890 FIND v(dout1_185) AT=900.05n

.meas tran vdout1_186ck890 FIND v(dout1_186) AT=900.05n

.meas tran vdout1_187ck890 FIND v(dout1_187) AT=900.05n

.meas tran vdout1_188ck890 FIND v(dout1_188) AT=900.05n

.meas tran vdout1_189ck890 FIND v(dout1_189) AT=900.05n

.meas tran vdout1_190ck890 FIND v(dout1_190) AT=900.05n

.meas tran vdout1_191ck890 FIND v(dout1_191) AT=900.05n

.meas tran vdout1_192ck890 FIND v(dout1_192) AT=900.05n

.meas tran vdout1_193ck890 FIND v(dout1_193) AT=900.05n

.meas tran vdout1_194ck890 FIND v(dout1_194) AT=900.05n

.meas tran vdout1_195ck890 FIND v(dout1_195) AT=900.05n

.meas tran vdout1_196ck890 FIND v(dout1_196) AT=900.05n

.meas tran vdout1_197ck890 FIND v(dout1_197) AT=900.05n

.meas tran vdout1_198ck890 FIND v(dout1_198) AT=900.05n

.meas tran vdout1_199ck890 FIND v(dout1_199) AT=900.05n

.meas tran vdout1_200ck890 FIND v(dout1_200) AT=900.05n

.meas tran vdout1_201ck890 FIND v(dout1_201) AT=900.05n

.meas tran vdout1_202ck890 FIND v(dout1_202) AT=900.05n

.meas tran vdout1_203ck890 FIND v(dout1_203) AT=900.05n

.meas tran vdout1_204ck890 FIND v(dout1_204) AT=900.05n

.meas tran vdout1_205ck890 FIND v(dout1_205) AT=900.05n

.meas tran vdout1_206ck890 FIND v(dout1_206) AT=900.05n

.meas tran vdout1_207ck890 FIND v(dout1_207) AT=900.05n

.meas tran vdout1_208ck890 FIND v(dout1_208) AT=900.05n

.meas tran vdout1_209ck890 FIND v(dout1_209) AT=900.05n

.meas tran vdout1_210ck890 FIND v(dout1_210) AT=900.05n

.meas tran vdout1_211ck890 FIND v(dout1_211) AT=900.05n

.meas tran vdout1_212ck890 FIND v(dout1_212) AT=900.05n

.meas tran vdout1_213ck890 FIND v(dout1_213) AT=900.05n

.meas tran vdout1_214ck890 FIND v(dout1_214) AT=900.05n

.meas tran vdout1_215ck890 FIND v(dout1_215) AT=900.05n

.meas tran vdout1_216ck890 FIND v(dout1_216) AT=900.05n

.meas tran vdout1_217ck890 FIND v(dout1_217) AT=900.05n

.meas tran vdout1_218ck890 FIND v(dout1_218) AT=900.05n

.meas tran vdout1_219ck890 FIND v(dout1_219) AT=900.05n

.meas tran vdout1_220ck890 FIND v(dout1_220) AT=900.05n

.meas tran vdout1_221ck890 FIND v(dout1_221) AT=900.05n

.meas tran vdout1_222ck890 FIND v(dout1_222) AT=900.05n

.meas tran vdout1_223ck890 FIND v(dout1_223) AT=900.05n

.meas tran vdout1_224ck890 FIND v(dout1_224) AT=900.05n

.meas tran vdout1_225ck890 FIND v(dout1_225) AT=900.05n

.meas tran vdout1_226ck890 FIND v(dout1_226) AT=900.05n

.meas tran vdout1_227ck890 FIND v(dout1_227) AT=900.05n

.meas tran vdout1_228ck890 FIND v(dout1_228) AT=900.05n

.meas tran vdout1_229ck890 FIND v(dout1_229) AT=900.05n

.meas tran vdout1_230ck890 FIND v(dout1_230) AT=900.05n

.meas tran vdout1_231ck890 FIND v(dout1_231) AT=900.05n

.meas tran vdout1_232ck890 FIND v(dout1_232) AT=900.05n

.meas tran vdout1_233ck890 FIND v(dout1_233) AT=900.05n

.meas tran vdout1_234ck890 FIND v(dout1_234) AT=900.05n

.meas tran vdout1_235ck890 FIND v(dout1_235) AT=900.05n

.meas tran vdout1_236ck890 FIND v(dout1_236) AT=900.05n

.meas tran vdout1_237ck890 FIND v(dout1_237) AT=900.05n

.meas tran vdout1_238ck890 FIND v(dout1_238) AT=900.05n

.meas tran vdout1_239ck890 FIND v(dout1_239) AT=900.05n

.meas tran vdout1_240ck890 FIND v(dout1_240) AT=900.05n

.meas tran vdout1_241ck890 FIND v(dout1_241) AT=900.05n

.meas tran vdout1_242ck890 FIND v(dout1_242) AT=900.05n

.meas tran vdout1_243ck890 FIND v(dout1_243) AT=900.05n

.meas tran vdout1_244ck890 FIND v(dout1_244) AT=900.05n

.meas tran vdout1_245ck890 FIND v(dout1_245) AT=900.05n

.meas tran vdout1_246ck890 FIND v(dout1_246) AT=900.05n

.meas tran vdout1_247ck890 FIND v(dout1_247) AT=900.05n

.meas tran vdout1_248ck890 FIND v(dout1_248) AT=900.05n

.meas tran vdout1_249ck890 FIND v(dout1_249) AT=900.05n

.meas tran vdout1_250ck890 FIND v(dout1_250) AT=900.05n

.meas tran vdout1_251ck890 FIND v(dout1_251) AT=900.05n

.meas tran vdout1_252ck890 FIND v(dout1_252) AT=900.05n

.meas tran vdout1_253ck890 FIND v(dout1_253) AT=900.05n

.meas tran vdout1_254ck890 FIND v(dout1_254) AT=900.05n

.meas tran vdout1_255ck890 FIND v(dout1_255) AT=900.05n

.meas tran vdout1_256ck890 FIND v(dout1_256) AT=900.05n

.meas tran vdout1_0ck940 FIND v(dout1_0) AT=950.05n

.meas tran vdout1_1ck940 FIND v(dout1_1) AT=950.05n

.meas tran vdout1_2ck940 FIND v(dout1_2) AT=950.05n

.meas tran vdout1_3ck940 FIND v(dout1_3) AT=950.05n

.meas tran vdout1_4ck940 FIND v(dout1_4) AT=950.05n

.meas tran vdout1_5ck940 FIND v(dout1_5) AT=950.05n

.meas tran vdout1_6ck940 FIND v(dout1_6) AT=950.05n

.meas tran vdout1_7ck940 FIND v(dout1_7) AT=950.05n

.meas tran vdout1_8ck940 FIND v(dout1_8) AT=950.05n

.meas tran vdout1_9ck940 FIND v(dout1_9) AT=950.05n

.meas tran vdout1_10ck940 FIND v(dout1_10) AT=950.05n

.meas tran vdout1_11ck940 FIND v(dout1_11) AT=950.05n

.meas tran vdout1_12ck940 FIND v(dout1_12) AT=950.05n

.meas tran vdout1_13ck940 FIND v(dout1_13) AT=950.05n

.meas tran vdout1_14ck940 FIND v(dout1_14) AT=950.05n

.meas tran vdout1_15ck940 FIND v(dout1_15) AT=950.05n

.meas tran vdout1_16ck940 FIND v(dout1_16) AT=950.05n

.meas tran vdout1_17ck940 FIND v(dout1_17) AT=950.05n

.meas tran vdout1_18ck940 FIND v(dout1_18) AT=950.05n

.meas tran vdout1_19ck940 FIND v(dout1_19) AT=950.05n

.meas tran vdout1_20ck940 FIND v(dout1_20) AT=950.05n

.meas tran vdout1_21ck940 FIND v(dout1_21) AT=950.05n

.meas tran vdout1_22ck940 FIND v(dout1_22) AT=950.05n

.meas tran vdout1_23ck940 FIND v(dout1_23) AT=950.05n

.meas tran vdout1_24ck940 FIND v(dout1_24) AT=950.05n

.meas tran vdout1_25ck940 FIND v(dout1_25) AT=950.05n

.meas tran vdout1_26ck940 FIND v(dout1_26) AT=950.05n

.meas tran vdout1_27ck940 FIND v(dout1_27) AT=950.05n

.meas tran vdout1_28ck940 FIND v(dout1_28) AT=950.05n

.meas tran vdout1_29ck940 FIND v(dout1_29) AT=950.05n

.meas tran vdout1_30ck940 FIND v(dout1_30) AT=950.05n

.meas tran vdout1_31ck940 FIND v(dout1_31) AT=950.05n

.meas tran vdout1_32ck940 FIND v(dout1_32) AT=950.05n

.meas tran vdout1_33ck940 FIND v(dout1_33) AT=950.05n

.meas tran vdout1_34ck940 FIND v(dout1_34) AT=950.05n

.meas tran vdout1_35ck940 FIND v(dout1_35) AT=950.05n

.meas tran vdout1_36ck940 FIND v(dout1_36) AT=950.05n

.meas tran vdout1_37ck940 FIND v(dout1_37) AT=950.05n

.meas tran vdout1_38ck940 FIND v(dout1_38) AT=950.05n

.meas tran vdout1_39ck940 FIND v(dout1_39) AT=950.05n

.meas tran vdout1_40ck940 FIND v(dout1_40) AT=950.05n

.meas tran vdout1_41ck940 FIND v(dout1_41) AT=950.05n

.meas tran vdout1_42ck940 FIND v(dout1_42) AT=950.05n

.meas tran vdout1_43ck940 FIND v(dout1_43) AT=950.05n

.meas tran vdout1_44ck940 FIND v(dout1_44) AT=950.05n

.meas tran vdout1_45ck940 FIND v(dout1_45) AT=950.05n

.meas tran vdout1_46ck940 FIND v(dout1_46) AT=950.05n

.meas tran vdout1_47ck940 FIND v(dout1_47) AT=950.05n

.meas tran vdout1_48ck940 FIND v(dout1_48) AT=950.05n

.meas tran vdout1_49ck940 FIND v(dout1_49) AT=950.05n

.meas tran vdout1_50ck940 FIND v(dout1_50) AT=950.05n

.meas tran vdout1_51ck940 FIND v(dout1_51) AT=950.05n

.meas tran vdout1_52ck940 FIND v(dout1_52) AT=950.05n

.meas tran vdout1_53ck940 FIND v(dout1_53) AT=950.05n

.meas tran vdout1_54ck940 FIND v(dout1_54) AT=950.05n

.meas tran vdout1_55ck940 FIND v(dout1_55) AT=950.05n

.meas tran vdout1_56ck940 FIND v(dout1_56) AT=950.05n

.meas tran vdout1_57ck940 FIND v(dout1_57) AT=950.05n

.meas tran vdout1_58ck940 FIND v(dout1_58) AT=950.05n

.meas tran vdout1_59ck940 FIND v(dout1_59) AT=950.05n

.meas tran vdout1_60ck940 FIND v(dout1_60) AT=950.05n

.meas tran vdout1_61ck940 FIND v(dout1_61) AT=950.05n

.meas tran vdout1_62ck940 FIND v(dout1_62) AT=950.05n

.meas tran vdout1_63ck940 FIND v(dout1_63) AT=950.05n

.meas tran vdout1_64ck940 FIND v(dout1_64) AT=950.05n

.meas tran vdout1_65ck940 FIND v(dout1_65) AT=950.05n

.meas tran vdout1_66ck940 FIND v(dout1_66) AT=950.05n

.meas tran vdout1_67ck940 FIND v(dout1_67) AT=950.05n

.meas tran vdout1_68ck940 FIND v(dout1_68) AT=950.05n

.meas tran vdout1_69ck940 FIND v(dout1_69) AT=950.05n

.meas tran vdout1_70ck940 FIND v(dout1_70) AT=950.05n

.meas tran vdout1_71ck940 FIND v(dout1_71) AT=950.05n

.meas tran vdout1_72ck940 FIND v(dout1_72) AT=950.05n

.meas tran vdout1_73ck940 FIND v(dout1_73) AT=950.05n

.meas tran vdout1_74ck940 FIND v(dout1_74) AT=950.05n

.meas tran vdout1_75ck940 FIND v(dout1_75) AT=950.05n

.meas tran vdout1_76ck940 FIND v(dout1_76) AT=950.05n

.meas tran vdout1_77ck940 FIND v(dout1_77) AT=950.05n

.meas tran vdout1_78ck940 FIND v(dout1_78) AT=950.05n

.meas tran vdout1_79ck940 FIND v(dout1_79) AT=950.05n

.meas tran vdout1_80ck940 FIND v(dout1_80) AT=950.05n

.meas tran vdout1_81ck940 FIND v(dout1_81) AT=950.05n

.meas tran vdout1_82ck940 FIND v(dout1_82) AT=950.05n

.meas tran vdout1_83ck940 FIND v(dout1_83) AT=950.05n

.meas tran vdout1_84ck940 FIND v(dout1_84) AT=950.05n

.meas tran vdout1_85ck940 FIND v(dout1_85) AT=950.05n

.meas tran vdout1_86ck940 FIND v(dout1_86) AT=950.05n

.meas tran vdout1_87ck940 FIND v(dout1_87) AT=950.05n

.meas tran vdout1_88ck940 FIND v(dout1_88) AT=950.05n

.meas tran vdout1_89ck940 FIND v(dout1_89) AT=950.05n

.meas tran vdout1_90ck940 FIND v(dout1_90) AT=950.05n

.meas tran vdout1_91ck940 FIND v(dout1_91) AT=950.05n

.meas tran vdout1_92ck940 FIND v(dout1_92) AT=950.05n

.meas tran vdout1_93ck940 FIND v(dout1_93) AT=950.05n

.meas tran vdout1_94ck940 FIND v(dout1_94) AT=950.05n

.meas tran vdout1_95ck940 FIND v(dout1_95) AT=950.05n

.meas tran vdout1_96ck940 FIND v(dout1_96) AT=950.05n

.meas tran vdout1_97ck940 FIND v(dout1_97) AT=950.05n

.meas tran vdout1_98ck940 FIND v(dout1_98) AT=950.05n

.meas tran vdout1_99ck940 FIND v(dout1_99) AT=950.05n

.meas tran vdout1_100ck940 FIND v(dout1_100) AT=950.05n

.meas tran vdout1_101ck940 FIND v(dout1_101) AT=950.05n

.meas tran vdout1_102ck940 FIND v(dout1_102) AT=950.05n

.meas tran vdout1_103ck940 FIND v(dout1_103) AT=950.05n

.meas tran vdout1_104ck940 FIND v(dout1_104) AT=950.05n

.meas tran vdout1_105ck940 FIND v(dout1_105) AT=950.05n

.meas tran vdout1_106ck940 FIND v(dout1_106) AT=950.05n

.meas tran vdout1_107ck940 FIND v(dout1_107) AT=950.05n

.meas tran vdout1_108ck940 FIND v(dout1_108) AT=950.05n

.meas tran vdout1_109ck940 FIND v(dout1_109) AT=950.05n

.meas tran vdout1_110ck940 FIND v(dout1_110) AT=950.05n

.meas tran vdout1_111ck940 FIND v(dout1_111) AT=950.05n

.meas tran vdout1_112ck940 FIND v(dout1_112) AT=950.05n

.meas tran vdout1_113ck940 FIND v(dout1_113) AT=950.05n

.meas tran vdout1_114ck940 FIND v(dout1_114) AT=950.05n

.meas tran vdout1_115ck940 FIND v(dout1_115) AT=950.05n

.meas tran vdout1_116ck940 FIND v(dout1_116) AT=950.05n

.meas tran vdout1_117ck940 FIND v(dout1_117) AT=950.05n

.meas tran vdout1_118ck940 FIND v(dout1_118) AT=950.05n

.meas tran vdout1_119ck940 FIND v(dout1_119) AT=950.05n

.meas tran vdout1_120ck940 FIND v(dout1_120) AT=950.05n

.meas tran vdout1_121ck940 FIND v(dout1_121) AT=950.05n

.meas tran vdout1_122ck940 FIND v(dout1_122) AT=950.05n

.meas tran vdout1_123ck940 FIND v(dout1_123) AT=950.05n

.meas tran vdout1_124ck940 FIND v(dout1_124) AT=950.05n

.meas tran vdout1_125ck940 FIND v(dout1_125) AT=950.05n

.meas tran vdout1_126ck940 FIND v(dout1_126) AT=950.05n

.meas tran vdout1_127ck940 FIND v(dout1_127) AT=950.05n

.meas tran vdout1_128ck940 FIND v(dout1_128) AT=950.05n

.meas tran vdout1_129ck940 FIND v(dout1_129) AT=950.05n

.meas tran vdout1_130ck940 FIND v(dout1_130) AT=950.05n

.meas tran vdout1_131ck940 FIND v(dout1_131) AT=950.05n

.meas tran vdout1_132ck940 FIND v(dout1_132) AT=950.05n

.meas tran vdout1_133ck940 FIND v(dout1_133) AT=950.05n

.meas tran vdout1_134ck940 FIND v(dout1_134) AT=950.05n

.meas tran vdout1_135ck940 FIND v(dout1_135) AT=950.05n

.meas tran vdout1_136ck940 FIND v(dout1_136) AT=950.05n

.meas tran vdout1_137ck940 FIND v(dout1_137) AT=950.05n

.meas tran vdout1_138ck940 FIND v(dout1_138) AT=950.05n

.meas tran vdout1_139ck940 FIND v(dout1_139) AT=950.05n

.meas tran vdout1_140ck940 FIND v(dout1_140) AT=950.05n

.meas tran vdout1_141ck940 FIND v(dout1_141) AT=950.05n

.meas tran vdout1_142ck940 FIND v(dout1_142) AT=950.05n

.meas tran vdout1_143ck940 FIND v(dout1_143) AT=950.05n

.meas tran vdout1_144ck940 FIND v(dout1_144) AT=950.05n

.meas tran vdout1_145ck940 FIND v(dout1_145) AT=950.05n

.meas tran vdout1_146ck940 FIND v(dout1_146) AT=950.05n

.meas tran vdout1_147ck940 FIND v(dout1_147) AT=950.05n

.meas tran vdout1_148ck940 FIND v(dout1_148) AT=950.05n

.meas tran vdout1_149ck940 FIND v(dout1_149) AT=950.05n

.meas tran vdout1_150ck940 FIND v(dout1_150) AT=950.05n

.meas tran vdout1_151ck940 FIND v(dout1_151) AT=950.05n

.meas tran vdout1_152ck940 FIND v(dout1_152) AT=950.05n

.meas tran vdout1_153ck940 FIND v(dout1_153) AT=950.05n

.meas tran vdout1_154ck940 FIND v(dout1_154) AT=950.05n

.meas tran vdout1_155ck940 FIND v(dout1_155) AT=950.05n

.meas tran vdout1_156ck940 FIND v(dout1_156) AT=950.05n

.meas tran vdout1_157ck940 FIND v(dout1_157) AT=950.05n

.meas tran vdout1_158ck940 FIND v(dout1_158) AT=950.05n

.meas tran vdout1_159ck940 FIND v(dout1_159) AT=950.05n

.meas tran vdout1_160ck940 FIND v(dout1_160) AT=950.05n

.meas tran vdout1_161ck940 FIND v(dout1_161) AT=950.05n

.meas tran vdout1_162ck940 FIND v(dout1_162) AT=950.05n

.meas tran vdout1_163ck940 FIND v(dout1_163) AT=950.05n

.meas tran vdout1_164ck940 FIND v(dout1_164) AT=950.05n

.meas tran vdout1_165ck940 FIND v(dout1_165) AT=950.05n

.meas tran vdout1_166ck940 FIND v(dout1_166) AT=950.05n

.meas tran vdout1_167ck940 FIND v(dout1_167) AT=950.05n

.meas tran vdout1_168ck940 FIND v(dout1_168) AT=950.05n

.meas tran vdout1_169ck940 FIND v(dout1_169) AT=950.05n

.meas tran vdout1_170ck940 FIND v(dout1_170) AT=950.05n

.meas tran vdout1_171ck940 FIND v(dout1_171) AT=950.05n

.meas tran vdout1_172ck940 FIND v(dout1_172) AT=950.05n

.meas tran vdout1_173ck940 FIND v(dout1_173) AT=950.05n

.meas tran vdout1_174ck940 FIND v(dout1_174) AT=950.05n

.meas tran vdout1_175ck940 FIND v(dout1_175) AT=950.05n

.meas tran vdout1_176ck940 FIND v(dout1_176) AT=950.05n

.meas tran vdout1_177ck940 FIND v(dout1_177) AT=950.05n

.meas tran vdout1_178ck940 FIND v(dout1_178) AT=950.05n

.meas tran vdout1_179ck940 FIND v(dout1_179) AT=950.05n

.meas tran vdout1_180ck940 FIND v(dout1_180) AT=950.05n

.meas tran vdout1_181ck940 FIND v(dout1_181) AT=950.05n

.meas tran vdout1_182ck940 FIND v(dout1_182) AT=950.05n

.meas tran vdout1_183ck940 FIND v(dout1_183) AT=950.05n

.meas tran vdout1_184ck940 FIND v(dout1_184) AT=950.05n

.meas tran vdout1_185ck940 FIND v(dout1_185) AT=950.05n

.meas tran vdout1_186ck940 FIND v(dout1_186) AT=950.05n

.meas tran vdout1_187ck940 FIND v(dout1_187) AT=950.05n

.meas tran vdout1_188ck940 FIND v(dout1_188) AT=950.05n

.meas tran vdout1_189ck940 FIND v(dout1_189) AT=950.05n

.meas tran vdout1_190ck940 FIND v(dout1_190) AT=950.05n

.meas tran vdout1_191ck940 FIND v(dout1_191) AT=950.05n

.meas tran vdout1_192ck940 FIND v(dout1_192) AT=950.05n

.meas tran vdout1_193ck940 FIND v(dout1_193) AT=950.05n

.meas tran vdout1_194ck940 FIND v(dout1_194) AT=950.05n

.meas tran vdout1_195ck940 FIND v(dout1_195) AT=950.05n

.meas tran vdout1_196ck940 FIND v(dout1_196) AT=950.05n

.meas tran vdout1_197ck940 FIND v(dout1_197) AT=950.05n

.meas tran vdout1_198ck940 FIND v(dout1_198) AT=950.05n

.meas tran vdout1_199ck940 FIND v(dout1_199) AT=950.05n

.meas tran vdout1_200ck940 FIND v(dout1_200) AT=950.05n

.meas tran vdout1_201ck940 FIND v(dout1_201) AT=950.05n

.meas tran vdout1_202ck940 FIND v(dout1_202) AT=950.05n

.meas tran vdout1_203ck940 FIND v(dout1_203) AT=950.05n

.meas tran vdout1_204ck940 FIND v(dout1_204) AT=950.05n

.meas tran vdout1_205ck940 FIND v(dout1_205) AT=950.05n

.meas tran vdout1_206ck940 FIND v(dout1_206) AT=950.05n

.meas tran vdout1_207ck940 FIND v(dout1_207) AT=950.05n

.meas tran vdout1_208ck940 FIND v(dout1_208) AT=950.05n

.meas tran vdout1_209ck940 FIND v(dout1_209) AT=950.05n

.meas tran vdout1_210ck940 FIND v(dout1_210) AT=950.05n

.meas tran vdout1_211ck940 FIND v(dout1_211) AT=950.05n

.meas tran vdout1_212ck940 FIND v(dout1_212) AT=950.05n

.meas tran vdout1_213ck940 FIND v(dout1_213) AT=950.05n

.meas tran vdout1_214ck940 FIND v(dout1_214) AT=950.05n

.meas tran vdout1_215ck940 FIND v(dout1_215) AT=950.05n

.meas tran vdout1_216ck940 FIND v(dout1_216) AT=950.05n

.meas tran vdout1_217ck940 FIND v(dout1_217) AT=950.05n

.meas tran vdout1_218ck940 FIND v(dout1_218) AT=950.05n

.meas tran vdout1_219ck940 FIND v(dout1_219) AT=950.05n

.meas tran vdout1_220ck940 FIND v(dout1_220) AT=950.05n

.meas tran vdout1_221ck940 FIND v(dout1_221) AT=950.05n

.meas tran vdout1_222ck940 FIND v(dout1_222) AT=950.05n

.meas tran vdout1_223ck940 FIND v(dout1_223) AT=950.05n

.meas tran vdout1_224ck940 FIND v(dout1_224) AT=950.05n

.meas tran vdout1_225ck940 FIND v(dout1_225) AT=950.05n

.meas tran vdout1_226ck940 FIND v(dout1_226) AT=950.05n

.meas tran vdout1_227ck940 FIND v(dout1_227) AT=950.05n

.meas tran vdout1_228ck940 FIND v(dout1_228) AT=950.05n

.meas tran vdout1_229ck940 FIND v(dout1_229) AT=950.05n

.meas tran vdout1_230ck940 FIND v(dout1_230) AT=950.05n

.meas tran vdout1_231ck940 FIND v(dout1_231) AT=950.05n

.meas tran vdout1_232ck940 FIND v(dout1_232) AT=950.05n

.meas tran vdout1_233ck940 FIND v(dout1_233) AT=950.05n

.meas tran vdout1_234ck940 FIND v(dout1_234) AT=950.05n

.meas tran vdout1_235ck940 FIND v(dout1_235) AT=950.05n

.meas tran vdout1_236ck940 FIND v(dout1_236) AT=950.05n

.meas tran vdout1_237ck940 FIND v(dout1_237) AT=950.05n

.meas tran vdout1_238ck940 FIND v(dout1_238) AT=950.05n

.meas tran vdout1_239ck940 FIND v(dout1_239) AT=950.05n

.meas tran vdout1_240ck940 FIND v(dout1_240) AT=950.05n

.meas tran vdout1_241ck940 FIND v(dout1_241) AT=950.05n

.meas tran vdout1_242ck940 FIND v(dout1_242) AT=950.05n

.meas tran vdout1_243ck940 FIND v(dout1_243) AT=950.05n

.meas tran vdout1_244ck940 FIND v(dout1_244) AT=950.05n

.meas tran vdout1_245ck940 FIND v(dout1_245) AT=950.05n

.meas tran vdout1_246ck940 FIND v(dout1_246) AT=950.05n

.meas tran vdout1_247ck940 FIND v(dout1_247) AT=950.05n

.meas tran vdout1_248ck940 FIND v(dout1_248) AT=950.05n

.meas tran vdout1_249ck940 FIND v(dout1_249) AT=950.05n

.meas tran vdout1_250ck940 FIND v(dout1_250) AT=950.05n

.meas tran vdout1_251ck940 FIND v(dout1_251) AT=950.05n

.meas tran vdout1_252ck940 FIND v(dout1_252) AT=950.05n

.meas tran vdout1_253ck940 FIND v(dout1_253) AT=950.05n

.meas tran vdout1_254ck940 FIND v(dout1_254) AT=950.05n

.meas tran vdout1_255ck940 FIND v(dout1_255) AT=950.05n

.meas tran vdout1_256ck940 FIND v(dout1_256) AT=950.05n

.meas tran vdout1_0ck960 FIND v(dout1_0) AT=970.05n

.meas tran vdout1_1ck960 FIND v(dout1_1) AT=970.05n

.meas tran vdout1_2ck960 FIND v(dout1_2) AT=970.05n

.meas tran vdout1_3ck960 FIND v(dout1_3) AT=970.05n

.meas tran vdout1_4ck960 FIND v(dout1_4) AT=970.05n

.meas tran vdout1_5ck960 FIND v(dout1_5) AT=970.05n

.meas tran vdout1_6ck960 FIND v(dout1_6) AT=970.05n

.meas tran vdout1_7ck960 FIND v(dout1_7) AT=970.05n

.meas tran vdout1_8ck960 FIND v(dout1_8) AT=970.05n

.meas tran vdout1_9ck960 FIND v(dout1_9) AT=970.05n

.meas tran vdout1_10ck960 FIND v(dout1_10) AT=970.05n

.meas tran vdout1_11ck960 FIND v(dout1_11) AT=970.05n

.meas tran vdout1_12ck960 FIND v(dout1_12) AT=970.05n

.meas tran vdout1_13ck960 FIND v(dout1_13) AT=970.05n

.meas tran vdout1_14ck960 FIND v(dout1_14) AT=970.05n

.meas tran vdout1_15ck960 FIND v(dout1_15) AT=970.05n

.meas tran vdout1_16ck960 FIND v(dout1_16) AT=970.05n

.meas tran vdout1_17ck960 FIND v(dout1_17) AT=970.05n

.meas tran vdout1_18ck960 FIND v(dout1_18) AT=970.05n

.meas tran vdout1_19ck960 FIND v(dout1_19) AT=970.05n

.meas tran vdout1_20ck960 FIND v(dout1_20) AT=970.05n

.meas tran vdout1_21ck960 FIND v(dout1_21) AT=970.05n

.meas tran vdout1_22ck960 FIND v(dout1_22) AT=970.05n

.meas tran vdout1_23ck960 FIND v(dout1_23) AT=970.05n

.meas tran vdout1_24ck960 FIND v(dout1_24) AT=970.05n

.meas tran vdout1_25ck960 FIND v(dout1_25) AT=970.05n

.meas tran vdout1_26ck960 FIND v(dout1_26) AT=970.05n

.meas tran vdout1_27ck960 FIND v(dout1_27) AT=970.05n

.meas tran vdout1_28ck960 FIND v(dout1_28) AT=970.05n

.meas tran vdout1_29ck960 FIND v(dout1_29) AT=970.05n

.meas tran vdout1_30ck960 FIND v(dout1_30) AT=970.05n

.meas tran vdout1_31ck960 FIND v(dout1_31) AT=970.05n

.meas tran vdout1_32ck960 FIND v(dout1_32) AT=970.05n

.meas tran vdout1_33ck960 FIND v(dout1_33) AT=970.05n

.meas tran vdout1_34ck960 FIND v(dout1_34) AT=970.05n

.meas tran vdout1_35ck960 FIND v(dout1_35) AT=970.05n

.meas tran vdout1_36ck960 FIND v(dout1_36) AT=970.05n

.meas tran vdout1_37ck960 FIND v(dout1_37) AT=970.05n

.meas tran vdout1_38ck960 FIND v(dout1_38) AT=970.05n

.meas tran vdout1_39ck960 FIND v(dout1_39) AT=970.05n

.meas tran vdout1_40ck960 FIND v(dout1_40) AT=970.05n

.meas tran vdout1_41ck960 FIND v(dout1_41) AT=970.05n

.meas tran vdout1_42ck960 FIND v(dout1_42) AT=970.05n

.meas tran vdout1_43ck960 FIND v(dout1_43) AT=970.05n

.meas tran vdout1_44ck960 FIND v(dout1_44) AT=970.05n

.meas tran vdout1_45ck960 FIND v(dout1_45) AT=970.05n

.meas tran vdout1_46ck960 FIND v(dout1_46) AT=970.05n

.meas tran vdout1_47ck960 FIND v(dout1_47) AT=970.05n

.meas tran vdout1_48ck960 FIND v(dout1_48) AT=970.05n

.meas tran vdout1_49ck960 FIND v(dout1_49) AT=970.05n

.meas tran vdout1_50ck960 FIND v(dout1_50) AT=970.05n

.meas tran vdout1_51ck960 FIND v(dout1_51) AT=970.05n

.meas tran vdout1_52ck960 FIND v(dout1_52) AT=970.05n

.meas tran vdout1_53ck960 FIND v(dout1_53) AT=970.05n

.meas tran vdout1_54ck960 FIND v(dout1_54) AT=970.05n

.meas tran vdout1_55ck960 FIND v(dout1_55) AT=970.05n

.meas tran vdout1_56ck960 FIND v(dout1_56) AT=970.05n

.meas tran vdout1_57ck960 FIND v(dout1_57) AT=970.05n

.meas tran vdout1_58ck960 FIND v(dout1_58) AT=970.05n

.meas tran vdout1_59ck960 FIND v(dout1_59) AT=970.05n

.meas tran vdout1_60ck960 FIND v(dout1_60) AT=970.05n

.meas tran vdout1_61ck960 FIND v(dout1_61) AT=970.05n

.meas tran vdout1_62ck960 FIND v(dout1_62) AT=970.05n

.meas tran vdout1_63ck960 FIND v(dout1_63) AT=970.05n

.meas tran vdout1_64ck960 FIND v(dout1_64) AT=970.05n

.meas tran vdout1_65ck960 FIND v(dout1_65) AT=970.05n

.meas tran vdout1_66ck960 FIND v(dout1_66) AT=970.05n

.meas tran vdout1_67ck960 FIND v(dout1_67) AT=970.05n

.meas tran vdout1_68ck960 FIND v(dout1_68) AT=970.05n

.meas tran vdout1_69ck960 FIND v(dout1_69) AT=970.05n

.meas tran vdout1_70ck960 FIND v(dout1_70) AT=970.05n

.meas tran vdout1_71ck960 FIND v(dout1_71) AT=970.05n

.meas tran vdout1_72ck960 FIND v(dout1_72) AT=970.05n

.meas tran vdout1_73ck960 FIND v(dout1_73) AT=970.05n

.meas tran vdout1_74ck960 FIND v(dout1_74) AT=970.05n

.meas tran vdout1_75ck960 FIND v(dout1_75) AT=970.05n

.meas tran vdout1_76ck960 FIND v(dout1_76) AT=970.05n

.meas tran vdout1_77ck960 FIND v(dout1_77) AT=970.05n

.meas tran vdout1_78ck960 FIND v(dout1_78) AT=970.05n

.meas tran vdout1_79ck960 FIND v(dout1_79) AT=970.05n

.meas tran vdout1_80ck960 FIND v(dout1_80) AT=970.05n

.meas tran vdout1_81ck960 FIND v(dout1_81) AT=970.05n

.meas tran vdout1_82ck960 FIND v(dout1_82) AT=970.05n

.meas tran vdout1_83ck960 FIND v(dout1_83) AT=970.05n

.meas tran vdout1_84ck960 FIND v(dout1_84) AT=970.05n

.meas tran vdout1_85ck960 FIND v(dout1_85) AT=970.05n

.meas tran vdout1_86ck960 FIND v(dout1_86) AT=970.05n

.meas tran vdout1_87ck960 FIND v(dout1_87) AT=970.05n

.meas tran vdout1_88ck960 FIND v(dout1_88) AT=970.05n

.meas tran vdout1_89ck960 FIND v(dout1_89) AT=970.05n

.meas tran vdout1_90ck960 FIND v(dout1_90) AT=970.05n

.meas tran vdout1_91ck960 FIND v(dout1_91) AT=970.05n

.meas tran vdout1_92ck960 FIND v(dout1_92) AT=970.05n

.meas tran vdout1_93ck960 FIND v(dout1_93) AT=970.05n

.meas tran vdout1_94ck960 FIND v(dout1_94) AT=970.05n

.meas tran vdout1_95ck960 FIND v(dout1_95) AT=970.05n

.meas tran vdout1_96ck960 FIND v(dout1_96) AT=970.05n

.meas tran vdout1_97ck960 FIND v(dout1_97) AT=970.05n

.meas tran vdout1_98ck960 FIND v(dout1_98) AT=970.05n

.meas tran vdout1_99ck960 FIND v(dout1_99) AT=970.05n

.meas tran vdout1_100ck960 FIND v(dout1_100) AT=970.05n

.meas tran vdout1_101ck960 FIND v(dout1_101) AT=970.05n

.meas tran vdout1_102ck960 FIND v(dout1_102) AT=970.05n

.meas tran vdout1_103ck960 FIND v(dout1_103) AT=970.05n

.meas tran vdout1_104ck960 FIND v(dout1_104) AT=970.05n

.meas tran vdout1_105ck960 FIND v(dout1_105) AT=970.05n

.meas tran vdout1_106ck960 FIND v(dout1_106) AT=970.05n

.meas tran vdout1_107ck960 FIND v(dout1_107) AT=970.05n

.meas tran vdout1_108ck960 FIND v(dout1_108) AT=970.05n

.meas tran vdout1_109ck960 FIND v(dout1_109) AT=970.05n

.meas tran vdout1_110ck960 FIND v(dout1_110) AT=970.05n

.meas tran vdout1_111ck960 FIND v(dout1_111) AT=970.05n

.meas tran vdout1_112ck960 FIND v(dout1_112) AT=970.05n

.meas tran vdout1_113ck960 FIND v(dout1_113) AT=970.05n

.meas tran vdout1_114ck960 FIND v(dout1_114) AT=970.05n

.meas tran vdout1_115ck960 FIND v(dout1_115) AT=970.05n

.meas tran vdout1_116ck960 FIND v(dout1_116) AT=970.05n

.meas tran vdout1_117ck960 FIND v(dout1_117) AT=970.05n

.meas tran vdout1_118ck960 FIND v(dout1_118) AT=970.05n

.meas tran vdout1_119ck960 FIND v(dout1_119) AT=970.05n

.meas tran vdout1_120ck960 FIND v(dout1_120) AT=970.05n

.meas tran vdout1_121ck960 FIND v(dout1_121) AT=970.05n

.meas tran vdout1_122ck960 FIND v(dout1_122) AT=970.05n

.meas tran vdout1_123ck960 FIND v(dout1_123) AT=970.05n

.meas tran vdout1_124ck960 FIND v(dout1_124) AT=970.05n

.meas tran vdout1_125ck960 FIND v(dout1_125) AT=970.05n

.meas tran vdout1_126ck960 FIND v(dout1_126) AT=970.05n

.meas tran vdout1_127ck960 FIND v(dout1_127) AT=970.05n

.meas tran vdout1_128ck960 FIND v(dout1_128) AT=970.05n

.meas tran vdout1_129ck960 FIND v(dout1_129) AT=970.05n

.meas tran vdout1_130ck960 FIND v(dout1_130) AT=970.05n

.meas tran vdout1_131ck960 FIND v(dout1_131) AT=970.05n

.meas tran vdout1_132ck960 FIND v(dout1_132) AT=970.05n

.meas tran vdout1_133ck960 FIND v(dout1_133) AT=970.05n

.meas tran vdout1_134ck960 FIND v(dout1_134) AT=970.05n

.meas tran vdout1_135ck960 FIND v(dout1_135) AT=970.05n

.meas tran vdout1_136ck960 FIND v(dout1_136) AT=970.05n

.meas tran vdout1_137ck960 FIND v(dout1_137) AT=970.05n

.meas tran vdout1_138ck960 FIND v(dout1_138) AT=970.05n

.meas tran vdout1_139ck960 FIND v(dout1_139) AT=970.05n

.meas tran vdout1_140ck960 FIND v(dout1_140) AT=970.05n

.meas tran vdout1_141ck960 FIND v(dout1_141) AT=970.05n

.meas tran vdout1_142ck960 FIND v(dout1_142) AT=970.05n

.meas tran vdout1_143ck960 FIND v(dout1_143) AT=970.05n

.meas tran vdout1_144ck960 FIND v(dout1_144) AT=970.05n

.meas tran vdout1_145ck960 FIND v(dout1_145) AT=970.05n

.meas tran vdout1_146ck960 FIND v(dout1_146) AT=970.05n

.meas tran vdout1_147ck960 FIND v(dout1_147) AT=970.05n

.meas tran vdout1_148ck960 FIND v(dout1_148) AT=970.05n

.meas tran vdout1_149ck960 FIND v(dout1_149) AT=970.05n

.meas tran vdout1_150ck960 FIND v(dout1_150) AT=970.05n

.meas tran vdout1_151ck960 FIND v(dout1_151) AT=970.05n

.meas tran vdout1_152ck960 FIND v(dout1_152) AT=970.05n

.meas tran vdout1_153ck960 FIND v(dout1_153) AT=970.05n

.meas tran vdout1_154ck960 FIND v(dout1_154) AT=970.05n

.meas tran vdout1_155ck960 FIND v(dout1_155) AT=970.05n

.meas tran vdout1_156ck960 FIND v(dout1_156) AT=970.05n

.meas tran vdout1_157ck960 FIND v(dout1_157) AT=970.05n

.meas tran vdout1_158ck960 FIND v(dout1_158) AT=970.05n

.meas tran vdout1_159ck960 FIND v(dout1_159) AT=970.05n

.meas tran vdout1_160ck960 FIND v(dout1_160) AT=970.05n

.meas tran vdout1_161ck960 FIND v(dout1_161) AT=970.05n

.meas tran vdout1_162ck960 FIND v(dout1_162) AT=970.05n

.meas tran vdout1_163ck960 FIND v(dout1_163) AT=970.05n

.meas tran vdout1_164ck960 FIND v(dout1_164) AT=970.05n

.meas tran vdout1_165ck960 FIND v(dout1_165) AT=970.05n

.meas tran vdout1_166ck960 FIND v(dout1_166) AT=970.05n

.meas tran vdout1_167ck960 FIND v(dout1_167) AT=970.05n

.meas tran vdout1_168ck960 FIND v(dout1_168) AT=970.05n

.meas tran vdout1_169ck960 FIND v(dout1_169) AT=970.05n

.meas tran vdout1_170ck960 FIND v(dout1_170) AT=970.05n

.meas tran vdout1_171ck960 FIND v(dout1_171) AT=970.05n

.meas tran vdout1_172ck960 FIND v(dout1_172) AT=970.05n

.meas tran vdout1_173ck960 FIND v(dout1_173) AT=970.05n

.meas tran vdout1_174ck960 FIND v(dout1_174) AT=970.05n

.meas tran vdout1_175ck960 FIND v(dout1_175) AT=970.05n

.meas tran vdout1_176ck960 FIND v(dout1_176) AT=970.05n

.meas tran vdout1_177ck960 FIND v(dout1_177) AT=970.05n

.meas tran vdout1_178ck960 FIND v(dout1_178) AT=970.05n

.meas tran vdout1_179ck960 FIND v(dout1_179) AT=970.05n

.meas tran vdout1_180ck960 FIND v(dout1_180) AT=970.05n

.meas tran vdout1_181ck960 FIND v(dout1_181) AT=970.05n

.meas tran vdout1_182ck960 FIND v(dout1_182) AT=970.05n

.meas tran vdout1_183ck960 FIND v(dout1_183) AT=970.05n

.meas tran vdout1_184ck960 FIND v(dout1_184) AT=970.05n

.meas tran vdout1_185ck960 FIND v(dout1_185) AT=970.05n

.meas tran vdout1_186ck960 FIND v(dout1_186) AT=970.05n

.meas tran vdout1_187ck960 FIND v(dout1_187) AT=970.05n

.meas tran vdout1_188ck960 FIND v(dout1_188) AT=970.05n

.meas tran vdout1_189ck960 FIND v(dout1_189) AT=970.05n

.meas tran vdout1_190ck960 FIND v(dout1_190) AT=970.05n

.meas tran vdout1_191ck960 FIND v(dout1_191) AT=970.05n

.meas tran vdout1_192ck960 FIND v(dout1_192) AT=970.05n

.meas tran vdout1_193ck960 FIND v(dout1_193) AT=970.05n

.meas tran vdout1_194ck960 FIND v(dout1_194) AT=970.05n

.meas tran vdout1_195ck960 FIND v(dout1_195) AT=970.05n

.meas tran vdout1_196ck960 FIND v(dout1_196) AT=970.05n

.meas tran vdout1_197ck960 FIND v(dout1_197) AT=970.05n

.meas tran vdout1_198ck960 FIND v(dout1_198) AT=970.05n

.meas tran vdout1_199ck960 FIND v(dout1_199) AT=970.05n

.meas tran vdout1_200ck960 FIND v(dout1_200) AT=970.05n

.meas tran vdout1_201ck960 FIND v(dout1_201) AT=970.05n

.meas tran vdout1_202ck960 FIND v(dout1_202) AT=970.05n

.meas tran vdout1_203ck960 FIND v(dout1_203) AT=970.05n

.meas tran vdout1_204ck960 FIND v(dout1_204) AT=970.05n

.meas tran vdout1_205ck960 FIND v(dout1_205) AT=970.05n

.meas tran vdout1_206ck960 FIND v(dout1_206) AT=970.05n

.meas tran vdout1_207ck960 FIND v(dout1_207) AT=970.05n

.meas tran vdout1_208ck960 FIND v(dout1_208) AT=970.05n

.meas tran vdout1_209ck960 FIND v(dout1_209) AT=970.05n

.meas tran vdout1_210ck960 FIND v(dout1_210) AT=970.05n

.meas tran vdout1_211ck960 FIND v(dout1_211) AT=970.05n

.meas tran vdout1_212ck960 FIND v(dout1_212) AT=970.05n

.meas tran vdout1_213ck960 FIND v(dout1_213) AT=970.05n

.meas tran vdout1_214ck960 FIND v(dout1_214) AT=970.05n

.meas tran vdout1_215ck960 FIND v(dout1_215) AT=970.05n

.meas tran vdout1_216ck960 FIND v(dout1_216) AT=970.05n

.meas tran vdout1_217ck960 FIND v(dout1_217) AT=970.05n

.meas tran vdout1_218ck960 FIND v(dout1_218) AT=970.05n

.meas tran vdout1_219ck960 FIND v(dout1_219) AT=970.05n

.meas tran vdout1_220ck960 FIND v(dout1_220) AT=970.05n

.meas tran vdout1_221ck960 FIND v(dout1_221) AT=970.05n

.meas tran vdout1_222ck960 FIND v(dout1_222) AT=970.05n

.meas tran vdout1_223ck960 FIND v(dout1_223) AT=970.05n

.meas tran vdout1_224ck960 FIND v(dout1_224) AT=970.05n

.meas tran vdout1_225ck960 FIND v(dout1_225) AT=970.05n

.meas tran vdout1_226ck960 FIND v(dout1_226) AT=970.05n

.meas tran vdout1_227ck960 FIND v(dout1_227) AT=970.05n

.meas tran vdout1_228ck960 FIND v(dout1_228) AT=970.05n

.meas tran vdout1_229ck960 FIND v(dout1_229) AT=970.05n

.meas tran vdout1_230ck960 FIND v(dout1_230) AT=970.05n

.meas tran vdout1_231ck960 FIND v(dout1_231) AT=970.05n

.meas tran vdout1_232ck960 FIND v(dout1_232) AT=970.05n

.meas tran vdout1_233ck960 FIND v(dout1_233) AT=970.05n

.meas tran vdout1_234ck960 FIND v(dout1_234) AT=970.05n

.meas tran vdout1_235ck960 FIND v(dout1_235) AT=970.05n

.meas tran vdout1_236ck960 FIND v(dout1_236) AT=970.05n

.meas tran vdout1_237ck960 FIND v(dout1_237) AT=970.05n

.meas tran vdout1_238ck960 FIND v(dout1_238) AT=970.05n

.meas tran vdout1_239ck960 FIND v(dout1_239) AT=970.05n

.meas tran vdout1_240ck960 FIND v(dout1_240) AT=970.05n

.meas tran vdout1_241ck960 FIND v(dout1_241) AT=970.05n

.meas tran vdout1_242ck960 FIND v(dout1_242) AT=970.05n

.meas tran vdout1_243ck960 FIND v(dout1_243) AT=970.05n

.meas tran vdout1_244ck960 FIND v(dout1_244) AT=970.05n

.meas tran vdout1_245ck960 FIND v(dout1_245) AT=970.05n

.meas tran vdout1_246ck960 FIND v(dout1_246) AT=970.05n

.meas tran vdout1_247ck960 FIND v(dout1_247) AT=970.05n

.meas tran vdout1_248ck960 FIND v(dout1_248) AT=970.05n

.meas tran vdout1_249ck960 FIND v(dout1_249) AT=970.05n

.meas tran vdout1_250ck960 FIND v(dout1_250) AT=970.05n

.meas tran vdout1_251ck960 FIND v(dout1_251) AT=970.05n

.meas tran vdout1_252ck960 FIND v(dout1_252) AT=970.05n

.meas tran vdout1_253ck960 FIND v(dout1_253) AT=970.05n

.meas tran vdout1_254ck960 FIND v(dout1_254) AT=970.05n

.meas tran vdout1_255ck960 FIND v(dout1_255) AT=970.05n

.meas tran vdout1_256ck960 FIND v(dout1_256) AT=970.05n

.meas tran vdout1_0ck980 FIND v(dout1_0) AT=990.05n

.meas tran vdout1_1ck980 FIND v(dout1_1) AT=990.05n

.meas tran vdout1_2ck980 FIND v(dout1_2) AT=990.05n

.meas tran vdout1_3ck980 FIND v(dout1_3) AT=990.05n

.meas tran vdout1_4ck980 FIND v(dout1_4) AT=990.05n

.meas tran vdout1_5ck980 FIND v(dout1_5) AT=990.05n

.meas tran vdout1_6ck980 FIND v(dout1_6) AT=990.05n

.meas tran vdout1_7ck980 FIND v(dout1_7) AT=990.05n

.meas tran vdout1_8ck980 FIND v(dout1_8) AT=990.05n

.meas tran vdout1_9ck980 FIND v(dout1_9) AT=990.05n

.meas tran vdout1_10ck980 FIND v(dout1_10) AT=990.05n

.meas tran vdout1_11ck980 FIND v(dout1_11) AT=990.05n

.meas tran vdout1_12ck980 FIND v(dout1_12) AT=990.05n

.meas tran vdout1_13ck980 FIND v(dout1_13) AT=990.05n

.meas tran vdout1_14ck980 FIND v(dout1_14) AT=990.05n

.meas tran vdout1_15ck980 FIND v(dout1_15) AT=990.05n

.meas tran vdout1_16ck980 FIND v(dout1_16) AT=990.05n

.meas tran vdout1_17ck980 FIND v(dout1_17) AT=990.05n

.meas tran vdout1_18ck980 FIND v(dout1_18) AT=990.05n

.meas tran vdout1_19ck980 FIND v(dout1_19) AT=990.05n

.meas tran vdout1_20ck980 FIND v(dout1_20) AT=990.05n

.meas tran vdout1_21ck980 FIND v(dout1_21) AT=990.05n

.meas tran vdout1_22ck980 FIND v(dout1_22) AT=990.05n

.meas tran vdout1_23ck980 FIND v(dout1_23) AT=990.05n

.meas tran vdout1_24ck980 FIND v(dout1_24) AT=990.05n

.meas tran vdout1_25ck980 FIND v(dout1_25) AT=990.05n

.meas tran vdout1_26ck980 FIND v(dout1_26) AT=990.05n

.meas tran vdout1_27ck980 FIND v(dout1_27) AT=990.05n

.meas tran vdout1_28ck980 FIND v(dout1_28) AT=990.05n

.meas tran vdout1_29ck980 FIND v(dout1_29) AT=990.05n

.meas tran vdout1_30ck980 FIND v(dout1_30) AT=990.05n

.meas tran vdout1_31ck980 FIND v(dout1_31) AT=990.05n

.meas tran vdout1_32ck980 FIND v(dout1_32) AT=990.05n

.meas tran vdout1_33ck980 FIND v(dout1_33) AT=990.05n

.meas tran vdout1_34ck980 FIND v(dout1_34) AT=990.05n

.meas tran vdout1_35ck980 FIND v(dout1_35) AT=990.05n

.meas tran vdout1_36ck980 FIND v(dout1_36) AT=990.05n

.meas tran vdout1_37ck980 FIND v(dout1_37) AT=990.05n

.meas tran vdout1_38ck980 FIND v(dout1_38) AT=990.05n

.meas tran vdout1_39ck980 FIND v(dout1_39) AT=990.05n

.meas tran vdout1_40ck980 FIND v(dout1_40) AT=990.05n

.meas tran vdout1_41ck980 FIND v(dout1_41) AT=990.05n

.meas tran vdout1_42ck980 FIND v(dout1_42) AT=990.05n

.meas tran vdout1_43ck980 FIND v(dout1_43) AT=990.05n

.meas tran vdout1_44ck980 FIND v(dout1_44) AT=990.05n

.meas tran vdout1_45ck980 FIND v(dout1_45) AT=990.05n

.meas tran vdout1_46ck980 FIND v(dout1_46) AT=990.05n

.meas tran vdout1_47ck980 FIND v(dout1_47) AT=990.05n

.meas tran vdout1_48ck980 FIND v(dout1_48) AT=990.05n

.meas tran vdout1_49ck980 FIND v(dout1_49) AT=990.05n

.meas tran vdout1_50ck980 FIND v(dout1_50) AT=990.05n

.meas tran vdout1_51ck980 FIND v(dout1_51) AT=990.05n

.meas tran vdout1_52ck980 FIND v(dout1_52) AT=990.05n

.meas tran vdout1_53ck980 FIND v(dout1_53) AT=990.05n

.meas tran vdout1_54ck980 FIND v(dout1_54) AT=990.05n

.meas tran vdout1_55ck980 FIND v(dout1_55) AT=990.05n

.meas tran vdout1_56ck980 FIND v(dout1_56) AT=990.05n

.meas tran vdout1_57ck980 FIND v(dout1_57) AT=990.05n

.meas tran vdout1_58ck980 FIND v(dout1_58) AT=990.05n

.meas tran vdout1_59ck980 FIND v(dout1_59) AT=990.05n

.meas tran vdout1_60ck980 FIND v(dout1_60) AT=990.05n

.meas tran vdout1_61ck980 FIND v(dout1_61) AT=990.05n

.meas tran vdout1_62ck980 FIND v(dout1_62) AT=990.05n

.meas tran vdout1_63ck980 FIND v(dout1_63) AT=990.05n

.meas tran vdout1_64ck980 FIND v(dout1_64) AT=990.05n

.meas tran vdout1_65ck980 FIND v(dout1_65) AT=990.05n

.meas tran vdout1_66ck980 FIND v(dout1_66) AT=990.05n

.meas tran vdout1_67ck980 FIND v(dout1_67) AT=990.05n

.meas tran vdout1_68ck980 FIND v(dout1_68) AT=990.05n

.meas tran vdout1_69ck980 FIND v(dout1_69) AT=990.05n

.meas tran vdout1_70ck980 FIND v(dout1_70) AT=990.05n

.meas tran vdout1_71ck980 FIND v(dout1_71) AT=990.05n

.meas tran vdout1_72ck980 FIND v(dout1_72) AT=990.05n

.meas tran vdout1_73ck980 FIND v(dout1_73) AT=990.05n

.meas tran vdout1_74ck980 FIND v(dout1_74) AT=990.05n

.meas tran vdout1_75ck980 FIND v(dout1_75) AT=990.05n

.meas tran vdout1_76ck980 FIND v(dout1_76) AT=990.05n

.meas tran vdout1_77ck980 FIND v(dout1_77) AT=990.05n

.meas tran vdout1_78ck980 FIND v(dout1_78) AT=990.05n

.meas tran vdout1_79ck980 FIND v(dout1_79) AT=990.05n

.meas tran vdout1_80ck980 FIND v(dout1_80) AT=990.05n

.meas tran vdout1_81ck980 FIND v(dout1_81) AT=990.05n

.meas tran vdout1_82ck980 FIND v(dout1_82) AT=990.05n

.meas tran vdout1_83ck980 FIND v(dout1_83) AT=990.05n

.meas tran vdout1_84ck980 FIND v(dout1_84) AT=990.05n

.meas tran vdout1_85ck980 FIND v(dout1_85) AT=990.05n

.meas tran vdout1_86ck980 FIND v(dout1_86) AT=990.05n

.meas tran vdout1_87ck980 FIND v(dout1_87) AT=990.05n

.meas tran vdout1_88ck980 FIND v(dout1_88) AT=990.05n

.meas tran vdout1_89ck980 FIND v(dout1_89) AT=990.05n

.meas tran vdout1_90ck980 FIND v(dout1_90) AT=990.05n

.meas tran vdout1_91ck980 FIND v(dout1_91) AT=990.05n

.meas tran vdout1_92ck980 FIND v(dout1_92) AT=990.05n

.meas tran vdout1_93ck980 FIND v(dout1_93) AT=990.05n

.meas tran vdout1_94ck980 FIND v(dout1_94) AT=990.05n

.meas tran vdout1_95ck980 FIND v(dout1_95) AT=990.05n

.meas tran vdout1_96ck980 FIND v(dout1_96) AT=990.05n

.meas tran vdout1_97ck980 FIND v(dout1_97) AT=990.05n

.meas tran vdout1_98ck980 FIND v(dout1_98) AT=990.05n

.meas tran vdout1_99ck980 FIND v(dout1_99) AT=990.05n

.meas tran vdout1_100ck980 FIND v(dout1_100) AT=990.05n

.meas tran vdout1_101ck980 FIND v(dout1_101) AT=990.05n

.meas tran vdout1_102ck980 FIND v(dout1_102) AT=990.05n

.meas tran vdout1_103ck980 FIND v(dout1_103) AT=990.05n

.meas tran vdout1_104ck980 FIND v(dout1_104) AT=990.05n

.meas tran vdout1_105ck980 FIND v(dout1_105) AT=990.05n

.meas tran vdout1_106ck980 FIND v(dout1_106) AT=990.05n

.meas tran vdout1_107ck980 FIND v(dout1_107) AT=990.05n

.meas tran vdout1_108ck980 FIND v(dout1_108) AT=990.05n

.meas tran vdout1_109ck980 FIND v(dout1_109) AT=990.05n

.meas tran vdout1_110ck980 FIND v(dout1_110) AT=990.05n

.meas tran vdout1_111ck980 FIND v(dout1_111) AT=990.05n

.meas tran vdout1_112ck980 FIND v(dout1_112) AT=990.05n

.meas tran vdout1_113ck980 FIND v(dout1_113) AT=990.05n

.meas tran vdout1_114ck980 FIND v(dout1_114) AT=990.05n

.meas tran vdout1_115ck980 FIND v(dout1_115) AT=990.05n

.meas tran vdout1_116ck980 FIND v(dout1_116) AT=990.05n

.meas tran vdout1_117ck980 FIND v(dout1_117) AT=990.05n

.meas tran vdout1_118ck980 FIND v(dout1_118) AT=990.05n

.meas tran vdout1_119ck980 FIND v(dout1_119) AT=990.05n

.meas tran vdout1_120ck980 FIND v(dout1_120) AT=990.05n

.meas tran vdout1_121ck980 FIND v(dout1_121) AT=990.05n

.meas tran vdout1_122ck980 FIND v(dout1_122) AT=990.05n

.meas tran vdout1_123ck980 FIND v(dout1_123) AT=990.05n

.meas tran vdout1_124ck980 FIND v(dout1_124) AT=990.05n

.meas tran vdout1_125ck980 FIND v(dout1_125) AT=990.05n

.meas tran vdout1_126ck980 FIND v(dout1_126) AT=990.05n

.meas tran vdout1_127ck980 FIND v(dout1_127) AT=990.05n

.meas tran vdout1_128ck980 FIND v(dout1_128) AT=990.05n

.meas tran vdout1_129ck980 FIND v(dout1_129) AT=990.05n

.meas tran vdout1_130ck980 FIND v(dout1_130) AT=990.05n

.meas tran vdout1_131ck980 FIND v(dout1_131) AT=990.05n

.meas tran vdout1_132ck980 FIND v(dout1_132) AT=990.05n

.meas tran vdout1_133ck980 FIND v(dout1_133) AT=990.05n

.meas tran vdout1_134ck980 FIND v(dout1_134) AT=990.05n

.meas tran vdout1_135ck980 FIND v(dout1_135) AT=990.05n

.meas tran vdout1_136ck980 FIND v(dout1_136) AT=990.05n

.meas tran vdout1_137ck980 FIND v(dout1_137) AT=990.05n

.meas tran vdout1_138ck980 FIND v(dout1_138) AT=990.05n

.meas tran vdout1_139ck980 FIND v(dout1_139) AT=990.05n

.meas tran vdout1_140ck980 FIND v(dout1_140) AT=990.05n

.meas tran vdout1_141ck980 FIND v(dout1_141) AT=990.05n

.meas tran vdout1_142ck980 FIND v(dout1_142) AT=990.05n

.meas tran vdout1_143ck980 FIND v(dout1_143) AT=990.05n

.meas tran vdout1_144ck980 FIND v(dout1_144) AT=990.05n

.meas tran vdout1_145ck980 FIND v(dout1_145) AT=990.05n

.meas tran vdout1_146ck980 FIND v(dout1_146) AT=990.05n

.meas tran vdout1_147ck980 FIND v(dout1_147) AT=990.05n

.meas tran vdout1_148ck980 FIND v(dout1_148) AT=990.05n

.meas tran vdout1_149ck980 FIND v(dout1_149) AT=990.05n

.meas tran vdout1_150ck980 FIND v(dout1_150) AT=990.05n

.meas tran vdout1_151ck980 FIND v(dout1_151) AT=990.05n

.meas tran vdout1_152ck980 FIND v(dout1_152) AT=990.05n

.meas tran vdout1_153ck980 FIND v(dout1_153) AT=990.05n

.meas tran vdout1_154ck980 FIND v(dout1_154) AT=990.05n

.meas tran vdout1_155ck980 FIND v(dout1_155) AT=990.05n

.meas tran vdout1_156ck980 FIND v(dout1_156) AT=990.05n

.meas tran vdout1_157ck980 FIND v(dout1_157) AT=990.05n

.meas tran vdout1_158ck980 FIND v(dout1_158) AT=990.05n

.meas tran vdout1_159ck980 FIND v(dout1_159) AT=990.05n

.meas tran vdout1_160ck980 FIND v(dout1_160) AT=990.05n

.meas tran vdout1_161ck980 FIND v(dout1_161) AT=990.05n

.meas tran vdout1_162ck980 FIND v(dout1_162) AT=990.05n

.meas tran vdout1_163ck980 FIND v(dout1_163) AT=990.05n

.meas tran vdout1_164ck980 FIND v(dout1_164) AT=990.05n

.meas tran vdout1_165ck980 FIND v(dout1_165) AT=990.05n

.meas tran vdout1_166ck980 FIND v(dout1_166) AT=990.05n

.meas tran vdout1_167ck980 FIND v(dout1_167) AT=990.05n

.meas tran vdout1_168ck980 FIND v(dout1_168) AT=990.05n

.meas tran vdout1_169ck980 FIND v(dout1_169) AT=990.05n

.meas tran vdout1_170ck980 FIND v(dout1_170) AT=990.05n

.meas tran vdout1_171ck980 FIND v(dout1_171) AT=990.05n

.meas tran vdout1_172ck980 FIND v(dout1_172) AT=990.05n

.meas tran vdout1_173ck980 FIND v(dout1_173) AT=990.05n

.meas tran vdout1_174ck980 FIND v(dout1_174) AT=990.05n

.meas tran vdout1_175ck980 FIND v(dout1_175) AT=990.05n

.meas tran vdout1_176ck980 FIND v(dout1_176) AT=990.05n

.meas tran vdout1_177ck980 FIND v(dout1_177) AT=990.05n

.meas tran vdout1_178ck980 FIND v(dout1_178) AT=990.05n

.meas tran vdout1_179ck980 FIND v(dout1_179) AT=990.05n

.meas tran vdout1_180ck980 FIND v(dout1_180) AT=990.05n

.meas tran vdout1_181ck980 FIND v(dout1_181) AT=990.05n

.meas tran vdout1_182ck980 FIND v(dout1_182) AT=990.05n

.meas tran vdout1_183ck980 FIND v(dout1_183) AT=990.05n

.meas tran vdout1_184ck980 FIND v(dout1_184) AT=990.05n

.meas tran vdout1_185ck980 FIND v(dout1_185) AT=990.05n

.meas tran vdout1_186ck980 FIND v(dout1_186) AT=990.05n

.meas tran vdout1_187ck980 FIND v(dout1_187) AT=990.05n

.meas tran vdout1_188ck980 FIND v(dout1_188) AT=990.05n

.meas tran vdout1_189ck980 FIND v(dout1_189) AT=990.05n

.meas tran vdout1_190ck980 FIND v(dout1_190) AT=990.05n

.meas tran vdout1_191ck980 FIND v(dout1_191) AT=990.05n

.meas tran vdout1_192ck980 FIND v(dout1_192) AT=990.05n

.meas tran vdout1_193ck980 FIND v(dout1_193) AT=990.05n

.meas tran vdout1_194ck980 FIND v(dout1_194) AT=990.05n

.meas tran vdout1_195ck980 FIND v(dout1_195) AT=990.05n

.meas tran vdout1_196ck980 FIND v(dout1_196) AT=990.05n

.meas tran vdout1_197ck980 FIND v(dout1_197) AT=990.05n

.meas tran vdout1_198ck980 FIND v(dout1_198) AT=990.05n

.meas tran vdout1_199ck980 FIND v(dout1_199) AT=990.05n

.meas tran vdout1_200ck980 FIND v(dout1_200) AT=990.05n

.meas tran vdout1_201ck980 FIND v(dout1_201) AT=990.05n

.meas tran vdout1_202ck980 FIND v(dout1_202) AT=990.05n

.meas tran vdout1_203ck980 FIND v(dout1_203) AT=990.05n

.meas tran vdout1_204ck980 FIND v(dout1_204) AT=990.05n

.meas tran vdout1_205ck980 FIND v(dout1_205) AT=990.05n

.meas tran vdout1_206ck980 FIND v(dout1_206) AT=990.05n

.meas tran vdout1_207ck980 FIND v(dout1_207) AT=990.05n

.meas tran vdout1_208ck980 FIND v(dout1_208) AT=990.05n

.meas tran vdout1_209ck980 FIND v(dout1_209) AT=990.05n

.meas tran vdout1_210ck980 FIND v(dout1_210) AT=990.05n

.meas tran vdout1_211ck980 FIND v(dout1_211) AT=990.05n

.meas tran vdout1_212ck980 FIND v(dout1_212) AT=990.05n

.meas tran vdout1_213ck980 FIND v(dout1_213) AT=990.05n

.meas tran vdout1_214ck980 FIND v(dout1_214) AT=990.05n

.meas tran vdout1_215ck980 FIND v(dout1_215) AT=990.05n

.meas tran vdout1_216ck980 FIND v(dout1_216) AT=990.05n

.meas tran vdout1_217ck980 FIND v(dout1_217) AT=990.05n

.meas tran vdout1_218ck980 FIND v(dout1_218) AT=990.05n

.meas tran vdout1_219ck980 FIND v(dout1_219) AT=990.05n

.meas tran vdout1_220ck980 FIND v(dout1_220) AT=990.05n

.meas tran vdout1_221ck980 FIND v(dout1_221) AT=990.05n

.meas tran vdout1_222ck980 FIND v(dout1_222) AT=990.05n

.meas tran vdout1_223ck980 FIND v(dout1_223) AT=990.05n

.meas tran vdout1_224ck980 FIND v(dout1_224) AT=990.05n

.meas tran vdout1_225ck980 FIND v(dout1_225) AT=990.05n

.meas tran vdout1_226ck980 FIND v(dout1_226) AT=990.05n

.meas tran vdout1_227ck980 FIND v(dout1_227) AT=990.05n

.meas tran vdout1_228ck980 FIND v(dout1_228) AT=990.05n

.meas tran vdout1_229ck980 FIND v(dout1_229) AT=990.05n

.meas tran vdout1_230ck980 FIND v(dout1_230) AT=990.05n

.meas tran vdout1_231ck980 FIND v(dout1_231) AT=990.05n

.meas tran vdout1_232ck980 FIND v(dout1_232) AT=990.05n

.meas tran vdout1_233ck980 FIND v(dout1_233) AT=990.05n

.meas tran vdout1_234ck980 FIND v(dout1_234) AT=990.05n

.meas tran vdout1_235ck980 FIND v(dout1_235) AT=990.05n

.meas tran vdout1_236ck980 FIND v(dout1_236) AT=990.05n

.meas tran vdout1_237ck980 FIND v(dout1_237) AT=990.05n

.meas tran vdout1_238ck980 FIND v(dout1_238) AT=990.05n

.meas tran vdout1_239ck980 FIND v(dout1_239) AT=990.05n

.meas tran vdout1_240ck980 FIND v(dout1_240) AT=990.05n

.meas tran vdout1_241ck980 FIND v(dout1_241) AT=990.05n

.meas tran vdout1_242ck980 FIND v(dout1_242) AT=990.05n

.meas tran vdout1_243ck980 FIND v(dout1_243) AT=990.05n

.meas tran vdout1_244ck980 FIND v(dout1_244) AT=990.05n

.meas tran vdout1_245ck980 FIND v(dout1_245) AT=990.05n

.meas tran vdout1_246ck980 FIND v(dout1_246) AT=990.05n

.meas tran vdout1_247ck980 FIND v(dout1_247) AT=990.05n

.meas tran vdout1_248ck980 FIND v(dout1_248) AT=990.05n

.meas tran vdout1_249ck980 FIND v(dout1_249) AT=990.05n

.meas tran vdout1_250ck980 FIND v(dout1_250) AT=990.05n

.meas tran vdout1_251ck980 FIND v(dout1_251) AT=990.05n

.meas tran vdout1_252ck980 FIND v(dout1_252) AT=990.05n

.meas tran vdout1_253ck980 FIND v(dout1_253) AT=990.05n

.meas tran vdout1_254ck980 FIND v(dout1_254) AT=990.05n

.meas tran vdout1_255ck980 FIND v(dout1_255) AT=990.05n

.meas tran vdout1_256ck980 FIND v(dout1_256) AT=990.05n

.meas tran vdout1_0ck990 FIND v(dout1_0) AT=1000.05n

.meas tran vdout1_1ck990 FIND v(dout1_1) AT=1000.05n

.meas tran vdout1_2ck990 FIND v(dout1_2) AT=1000.05n

.meas tran vdout1_3ck990 FIND v(dout1_3) AT=1000.05n

.meas tran vdout1_4ck990 FIND v(dout1_4) AT=1000.05n

.meas tran vdout1_5ck990 FIND v(dout1_5) AT=1000.05n

.meas tran vdout1_6ck990 FIND v(dout1_6) AT=1000.05n

.meas tran vdout1_7ck990 FIND v(dout1_7) AT=1000.05n

.meas tran vdout1_8ck990 FIND v(dout1_8) AT=1000.05n

.meas tran vdout1_9ck990 FIND v(dout1_9) AT=1000.05n

.meas tran vdout1_10ck990 FIND v(dout1_10) AT=1000.05n

.meas tran vdout1_11ck990 FIND v(dout1_11) AT=1000.05n

.meas tran vdout1_12ck990 FIND v(dout1_12) AT=1000.05n

.meas tran vdout1_13ck990 FIND v(dout1_13) AT=1000.05n

.meas tran vdout1_14ck990 FIND v(dout1_14) AT=1000.05n

.meas tran vdout1_15ck990 FIND v(dout1_15) AT=1000.05n

.meas tran vdout1_16ck990 FIND v(dout1_16) AT=1000.05n

.meas tran vdout1_17ck990 FIND v(dout1_17) AT=1000.05n

.meas tran vdout1_18ck990 FIND v(dout1_18) AT=1000.05n

.meas tran vdout1_19ck990 FIND v(dout1_19) AT=1000.05n

.meas tran vdout1_20ck990 FIND v(dout1_20) AT=1000.05n

.meas tran vdout1_21ck990 FIND v(dout1_21) AT=1000.05n

.meas tran vdout1_22ck990 FIND v(dout1_22) AT=1000.05n

.meas tran vdout1_23ck990 FIND v(dout1_23) AT=1000.05n

.meas tran vdout1_24ck990 FIND v(dout1_24) AT=1000.05n

.meas tran vdout1_25ck990 FIND v(dout1_25) AT=1000.05n

.meas tran vdout1_26ck990 FIND v(dout1_26) AT=1000.05n

.meas tran vdout1_27ck990 FIND v(dout1_27) AT=1000.05n

.meas tran vdout1_28ck990 FIND v(dout1_28) AT=1000.05n

.meas tran vdout1_29ck990 FIND v(dout1_29) AT=1000.05n

.meas tran vdout1_30ck990 FIND v(dout1_30) AT=1000.05n

.meas tran vdout1_31ck990 FIND v(dout1_31) AT=1000.05n

.meas tran vdout1_32ck990 FIND v(dout1_32) AT=1000.05n

.meas tran vdout1_33ck990 FIND v(dout1_33) AT=1000.05n

.meas tran vdout1_34ck990 FIND v(dout1_34) AT=1000.05n

.meas tran vdout1_35ck990 FIND v(dout1_35) AT=1000.05n

.meas tran vdout1_36ck990 FIND v(dout1_36) AT=1000.05n

.meas tran vdout1_37ck990 FIND v(dout1_37) AT=1000.05n

.meas tran vdout1_38ck990 FIND v(dout1_38) AT=1000.05n

.meas tran vdout1_39ck990 FIND v(dout1_39) AT=1000.05n

.meas tran vdout1_40ck990 FIND v(dout1_40) AT=1000.05n

.meas tran vdout1_41ck990 FIND v(dout1_41) AT=1000.05n

.meas tran vdout1_42ck990 FIND v(dout1_42) AT=1000.05n

.meas tran vdout1_43ck990 FIND v(dout1_43) AT=1000.05n

.meas tran vdout1_44ck990 FIND v(dout1_44) AT=1000.05n

.meas tran vdout1_45ck990 FIND v(dout1_45) AT=1000.05n

.meas tran vdout1_46ck990 FIND v(dout1_46) AT=1000.05n

.meas tran vdout1_47ck990 FIND v(dout1_47) AT=1000.05n

.meas tran vdout1_48ck990 FIND v(dout1_48) AT=1000.05n

.meas tran vdout1_49ck990 FIND v(dout1_49) AT=1000.05n

.meas tran vdout1_50ck990 FIND v(dout1_50) AT=1000.05n

.meas tran vdout1_51ck990 FIND v(dout1_51) AT=1000.05n

.meas tran vdout1_52ck990 FIND v(dout1_52) AT=1000.05n

.meas tran vdout1_53ck990 FIND v(dout1_53) AT=1000.05n

.meas tran vdout1_54ck990 FIND v(dout1_54) AT=1000.05n

.meas tran vdout1_55ck990 FIND v(dout1_55) AT=1000.05n

.meas tran vdout1_56ck990 FIND v(dout1_56) AT=1000.05n

.meas tran vdout1_57ck990 FIND v(dout1_57) AT=1000.05n

.meas tran vdout1_58ck990 FIND v(dout1_58) AT=1000.05n

.meas tran vdout1_59ck990 FIND v(dout1_59) AT=1000.05n

.meas tran vdout1_60ck990 FIND v(dout1_60) AT=1000.05n

.meas tran vdout1_61ck990 FIND v(dout1_61) AT=1000.05n

.meas tran vdout1_62ck990 FIND v(dout1_62) AT=1000.05n

.meas tran vdout1_63ck990 FIND v(dout1_63) AT=1000.05n

.meas tran vdout1_64ck990 FIND v(dout1_64) AT=1000.05n

.meas tran vdout1_65ck990 FIND v(dout1_65) AT=1000.05n

.meas tran vdout1_66ck990 FIND v(dout1_66) AT=1000.05n

.meas tran vdout1_67ck990 FIND v(dout1_67) AT=1000.05n

.meas tran vdout1_68ck990 FIND v(dout1_68) AT=1000.05n

.meas tran vdout1_69ck990 FIND v(dout1_69) AT=1000.05n

.meas tran vdout1_70ck990 FIND v(dout1_70) AT=1000.05n

.meas tran vdout1_71ck990 FIND v(dout1_71) AT=1000.05n

.meas tran vdout1_72ck990 FIND v(dout1_72) AT=1000.05n

.meas tran vdout1_73ck990 FIND v(dout1_73) AT=1000.05n

.meas tran vdout1_74ck990 FIND v(dout1_74) AT=1000.05n

.meas tran vdout1_75ck990 FIND v(dout1_75) AT=1000.05n

.meas tran vdout1_76ck990 FIND v(dout1_76) AT=1000.05n

.meas tran vdout1_77ck990 FIND v(dout1_77) AT=1000.05n

.meas tran vdout1_78ck990 FIND v(dout1_78) AT=1000.05n

.meas tran vdout1_79ck990 FIND v(dout1_79) AT=1000.05n

.meas tran vdout1_80ck990 FIND v(dout1_80) AT=1000.05n

.meas tran vdout1_81ck990 FIND v(dout1_81) AT=1000.05n

.meas tran vdout1_82ck990 FIND v(dout1_82) AT=1000.05n

.meas tran vdout1_83ck990 FIND v(dout1_83) AT=1000.05n

.meas tran vdout1_84ck990 FIND v(dout1_84) AT=1000.05n

.meas tran vdout1_85ck990 FIND v(dout1_85) AT=1000.05n

.meas tran vdout1_86ck990 FIND v(dout1_86) AT=1000.05n

.meas tran vdout1_87ck990 FIND v(dout1_87) AT=1000.05n

.meas tran vdout1_88ck990 FIND v(dout1_88) AT=1000.05n

.meas tran vdout1_89ck990 FIND v(dout1_89) AT=1000.05n

.meas tran vdout1_90ck990 FIND v(dout1_90) AT=1000.05n

.meas tran vdout1_91ck990 FIND v(dout1_91) AT=1000.05n

.meas tran vdout1_92ck990 FIND v(dout1_92) AT=1000.05n

.meas tran vdout1_93ck990 FIND v(dout1_93) AT=1000.05n

.meas tran vdout1_94ck990 FIND v(dout1_94) AT=1000.05n

.meas tran vdout1_95ck990 FIND v(dout1_95) AT=1000.05n

.meas tran vdout1_96ck990 FIND v(dout1_96) AT=1000.05n

.meas tran vdout1_97ck990 FIND v(dout1_97) AT=1000.05n

.meas tran vdout1_98ck990 FIND v(dout1_98) AT=1000.05n

.meas tran vdout1_99ck990 FIND v(dout1_99) AT=1000.05n

.meas tran vdout1_100ck990 FIND v(dout1_100) AT=1000.05n

.meas tran vdout1_101ck990 FIND v(dout1_101) AT=1000.05n

.meas tran vdout1_102ck990 FIND v(dout1_102) AT=1000.05n

.meas tran vdout1_103ck990 FIND v(dout1_103) AT=1000.05n

.meas tran vdout1_104ck990 FIND v(dout1_104) AT=1000.05n

.meas tran vdout1_105ck990 FIND v(dout1_105) AT=1000.05n

.meas tran vdout1_106ck990 FIND v(dout1_106) AT=1000.05n

.meas tran vdout1_107ck990 FIND v(dout1_107) AT=1000.05n

.meas tran vdout1_108ck990 FIND v(dout1_108) AT=1000.05n

.meas tran vdout1_109ck990 FIND v(dout1_109) AT=1000.05n

.meas tran vdout1_110ck990 FIND v(dout1_110) AT=1000.05n

.meas tran vdout1_111ck990 FIND v(dout1_111) AT=1000.05n

.meas tran vdout1_112ck990 FIND v(dout1_112) AT=1000.05n

.meas tran vdout1_113ck990 FIND v(dout1_113) AT=1000.05n

.meas tran vdout1_114ck990 FIND v(dout1_114) AT=1000.05n

.meas tran vdout1_115ck990 FIND v(dout1_115) AT=1000.05n

.meas tran vdout1_116ck990 FIND v(dout1_116) AT=1000.05n

.meas tran vdout1_117ck990 FIND v(dout1_117) AT=1000.05n

.meas tran vdout1_118ck990 FIND v(dout1_118) AT=1000.05n

.meas tran vdout1_119ck990 FIND v(dout1_119) AT=1000.05n

.meas tran vdout1_120ck990 FIND v(dout1_120) AT=1000.05n

.meas tran vdout1_121ck990 FIND v(dout1_121) AT=1000.05n

.meas tran vdout1_122ck990 FIND v(dout1_122) AT=1000.05n

.meas tran vdout1_123ck990 FIND v(dout1_123) AT=1000.05n

.meas tran vdout1_124ck990 FIND v(dout1_124) AT=1000.05n

.meas tran vdout1_125ck990 FIND v(dout1_125) AT=1000.05n

.meas tran vdout1_126ck990 FIND v(dout1_126) AT=1000.05n

.meas tran vdout1_127ck990 FIND v(dout1_127) AT=1000.05n

.meas tran vdout1_128ck990 FIND v(dout1_128) AT=1000.05n

.meas tran vdout1_129ck990 FIND v(dout1_129) AT=1000.05n

.meas tran vdout1_130ck990 FIND v(dout1_130) AT=1000.05n

.meas tran vdout1_131ck990 FIND v(dout1_131) AT=1000.05n

.meas tran vdout1_132ck990 FIND v(dout1_132) AT=1000.05n

.meas tran vdout1_133ck990 FIND v(dout1_133) AT=1000.05n

.meas tran vdout1_134ck990 FIND v(dout1_134) AT=1000.05n

.meas tran vdout1_135ck990 FIND v(dout1_135) AT=1000.05n

.meas tran vdout1_136ck990 FIND v(dout1_136) AT=1000.05n

.meas tran vdout1_137ck990 FIND v(dout1_137) AT=1000.05n

.meas tran vdout1_138ck990 FIND v(dout1_138) AT=1000.05n

.meas tran vdout1_139ck990 FIND v(dout1_139) AT=1000.05n

.meas tran vdout1_140ck990 FIND v(dout1_140) AT=1000.05n

.meas tran vdout1_141ck990 FIND v(dout1_141) AT=1000.05n

.meas tran vdout1_142ck990 FIND v(dout1_142) AT=1000.05n

.meas tran vdout1_143ck990 FIND v(dout1_143) AT=1000.05n

.meas tran vdout1_144ck990 FIND v(dout1_144) AT=1000.05n

.meas tran vdout1_145ck990 FIND v(dout1_145) AT=1000.05n

.meas tran vdout1_146ck990 FIND v(dout1_146) AT=1000.05n

.meas tran vdout1_147ck990 FIND v(dout1_147) AT=1000.05n

.meas tran vdout1_148ck990 FIND v(dout1_148) AT=1000.05n

.meas tran vdout1_149ck990 FIND v(dout1_149) AT=1000.05n

.meas tran vdout1_150ck990 FIND v(dout1_150) AT=1000.05n

.meas tran vdout1_151ck990 FIND v(dout1_151) AT=1000.05n

.meas tran vdout1_152ck990 FIND v(dout1_152) AT=1000.05n

.meas tran vdout1_153ck990 FIND v(dout1_153) AT=1000.05n

.meas tran vdout1_154ck990 FIND v(dout1_154) AT=1000.05n

.meas tran vdout1_155ck990 FIND v(dout1_155) AT=1000.05n

.meas tran vdout1_156ck990 FIND v(dout1_156) AT=1000.05n

.meas tran vdout1_157ck990 FIND v(dout1_157) AT=1000.05n

.meas tran vdout1_158ck990 FIND v(dout1_158) AT=1000.05n

.meas tran vdout1_159ck990 FIND v(dout1_159) AT=1000.05n

.meas tran vdout1_160ck990 FIND v(dout1_160) AT=1000.05n

.meas tran vdout1_161ck990 FIND v(dout1_161) AT=1000.05n

.meas tran vdout1_162ck990 FIND v(dout1_162) AT=1000.05n

.meas tran vdout1_163ck990 FIND v(dout1_163) AT=1000.05n

.meas tran vdout1_164ck990 FIND v(dout1_164) AT=1000.05n

.meas tran vdout1_165ck990 FIND v(dout1_165) AT=1000.05n

.meas tran vdout1_166ck990 FIND v(dout1_166) AT=1000.05n

.meas tran vdout1_167ck990 FIND v(dout1_167) AT=1000.05n

.meas tran vdout1_168ck990 FIND v(dout1_168) AT=1000.05n

.meas tran vdout1_169ck990 FIND v(dout1_169) AT=1000.05n

.meas tran vdout1_170ck990 FIND v(dout1_170) AT=1000.05n

.meas tran vdout1_171ck990 FIND v(dout1_171) AT=1000.05n

.meas tran vdout1_172ck990 FIND v(dout1_172) AT=1000.05n

.meas tran vdout1_173ck990 FIND v(dout1_173) AT=1000.05n

.meas tran vdout1_174ck990 FIND v(dout1_174) AT=1000.05n

.meas tran vdout1_175ck990 FIND v(dout1_175) AT=1000.05n

.meas tran vdout1_176ck990 FIND v(dout1_176) AT=1000.05n

.meas tran vdout1_177ck990 FIND v(dout1_177) AT=1000.05n

.meas tran vdout1_178ck990 FIND v(dout1_178) AT=1000.05n

.meas tran vdout1_179ck990 FIND v(dout1_179) AT=1000.05n

.meas tran vdout1_180ck990 FIND v(dout1_180) AT=1000.05n

.meas tran vdout1_181ck990 FIND v(dout1_181) AT=1000.05n

.meas tran vdout1_182ck990 FIND v(dout1_182) AT=1000.05n

.meas tran vdout1_183ck990 FIND v(dout1_183) AT=1000.05n

.meas tran vdout1_184ck990 FIND v(dout1_184) AT=1000.05n

.meas tran vdout1_185ck990 FIND v(dout1_185) AT=1000.05n

.meas tran vdout1_186ck990 FIND v(dout1_186) AT=1000.05n

.meas tran vdout1_187ck990 FIND v(dout1_187) AT=1000.05n

.meas tran vdout1_188ck990 FIND v(dout1_188) AT=1000.05n

.meas tran vdout1_189ck990 FIND v(dout1_189) AT=1000.05n

.meas tran vdout1_190ck990 FIND v(dout1_190) AT=1000.05n

.meas tran vdout1_191ck990 FIND v(dout1_191) AT=1000.05n

.meas tran vdout1_192ck990 FIND v(dout1_192) AT=1000.05n

.meas tran vdout1_193ck990 FIND v(dout1_193) AT=1000.05n

.meas tran vdout1_194ck990 FIND v(dout1_194) AT=1000.05n

.meas tran vdout1_195ck990 FIND v(dout1_195) AT=1000.05n

.meas tran vdout1_196ck990 FIND v(dout1_196) AT=1000.05n

.meas tran vdout1_197ck990 FIND v(dout1_197) AT=1000.05n

.meas tran vdout1_198ck990 FIND v(dout1_198) AT=1000.05n

.meas tran vdout1_199ck990 FIND v(dout1_199) AT=1000.05n

.meas tran vdout1_200ck990 FIND v(dout1_200) AT=1000.05n

.meas tran vdout1_201ck990 FIND v(dout1_201) AT=1000.05n

.meas tran vdout1_202ck990 FIND v(dout1_202) AT=1000.05n

.meas tran vdout1_203ck990 FIND v(dout1_203) AT=1000.05n

.meas tran vdout1_204ck990 FIND v(dout1_204) AT=1000.05n

.meas tran vdout1_205ck990 FIND v(dout1_205) AT=1000.05n

.meas tran vdout1_206ck990 FIND v(dout1_206) AT=1000.05n

.meas tran vdout1_207ck990 FIND v(dout1_207) AT=1000.05n

.meas tran vdout1_208ck990 FIND v(dout1_208) AT=1000.05n

.meas tran vdout1_209ck990 FIND v(dout1_209) AT=1000.05n

.meas tran vdout1_210ck990 FIND v(dout1_210) AT=1000.05n

.meas tran vdout1_211ck990 FIND v(dout1_211) AT=1000.05n

.meas tran vdout1_212ck990 FIND v(dout1_212) AT=1000.05n

.meas tran vdout1_213ck990 FIND v(dout1_213) AT=1000.05n

.meas tran vdout1_214ck990 FIND v(dout1_214) AT=1000.05n

.meas tran vdout1_215ck990 FIND v(dout1_215) AT=1000.05n

.meas tran vdout1_216ck990 FIND v(dout1_216) AT=1000.05n

.meas tran vdout1_217ck990 FIND v(dout1_217) AT=1000.05n

.meas tran vdout1_218ck990 FIND v(dout1_218) AT=1000.05n

.meas tran vdout1_219ck990 FIND v(dout1_219) AT=1000.05n

.meas tran vdout1_220ck990 FIND v(dout1_220) AT=1000.05n

.meas tran vdout1_221ck990 FIND v(dout1_221) AT=1000.05n

.meas tran vdout1_222ck990 FIND v(dout1_222) AT=1000.05n

.meas tran vdout1_223ck990 FIND v(dout1_223) AT=1000.05n

.meas tran vdout1_224ck990 FIND v(dout1_224) AT=1000.05n

.meas tran vdout1_225ck990 FIND v(dout1_225) AT=1000.05n

.meas tran vdout1_226ck990 FIND v(dout1_226) AT=1000.05n

.meas tran vdout1_227ck990 FIND v(dout1_227) AT=1000.05n

.meas tran vdout1_228ck990 FIND v(dout1_228) AT=1000.05n

.meas tran vdout1_229ck990 FIND v(dout1_229) AT=1000.05n

.meas tran vdout1_230ck990 FIND v(dout1_230) AT=1000.05n

.meas tran vdout1_231ck990 FIND v(dout1_231) AT=1000.05n

.meas tran vdout1_232ck990 FIND v(dout1_232) AT=1000.05n

.meas tran vdout1_233ck990 FIND v(dout1_233) AT=1000.05n

.meas tran vdout1_234ck990 FIND v(dout1_234) AT=1000.05n

.meas tran vdout1_235ck990 FIND v(dout1_235) AT=1000.05n

.meas tran vdout1_236ck990 FIND v(dout1_236) AT=1000.05n

.meas tran vdout1_237ck990 FIND v(dout1_237) AT=1000.05n

.meas tran vdout1_238ck990 FIND v(dout1_238) AT=1000.05n

.meas tran vdout1_239ck990 FIND v(dout1_239) AT=1000.05n

.meas tran vdout1_240ck990 FIND v(dout1_240) AT=1000.05n

.meas tran vdout1_241ck990 FIND v(dout1_241) AT=1000.05n

.meas tran vdout1_242ck990 FIND v(dout1_242) AT=1000.05n

.meas tran vdout1_243ck990 FIND v(dout1_243) AT=1000.05n

.meas tran vdout1_244ck990 FIND v(dout1_244) AT=1000.05n

.meas tran vdout1_245ck990 FIND v(dout1_245) AT=1000.05n

.meas tran vdout1_246ck990 FIND v(dout1_246) AT=1000.05n

.meas tran vdout1_247ck990 FIND v(dout1_247) AT=1000.05n

.meas tran vdout1_248ck990 FIND v(dout1_248) AT=1000.05n

.meas tran vdout1_249ck990 FIND v(dout1_249) AT=1000.05n

.meas tran vdout1_250ck990 FIND v(dout1_250) AT=1000.05n

.meas tran vdout1_251ck990 FIND v(dout1_251) AT=1000.05n

.meas tran vdout1_252ck990 FIND v(dout1_252) AT=1000.05n

.meas tran vdout1_253ck990 FIND v(dout1_253) AT=1000.05n

.meas tran vdout1_254ck990 FIND v(dout1_254) AT=1000.05n

.meas tran vdout1_255ck990 FIND v(dout1_255) AT=1000.05n

.meas tran vdout1_256ck990 FIND v(dout1_256) AT=1000.05n

.meas tran vdout1_0ck1040 FIND v(dout1_0) AT=1050.05n

.meas tran vdout1_1ck1040 FIND v(dout1_1) AT=1050.05n

.meas tran vdout1_2ck1040 FIND v(dout1_2) AT=1050.05n

.meas tran vdout1_3ck1040 FIND v(dout1_3) AT=1050.05n

.meas tran vdout1_4ck1040 FIND v(dout1_4) AT=1050.05n

.meas tran vdout1_5ck1040 FIND v(dout1_5) AT=1050.05n

.meas tran vdout1_6ck1040 FIND v(dout1_6) AT=1050.05n

.meas tran vdout1_7ck1040 FIND v(dout1_7) AT=1050.05n

.meas tran vdout1_8ck1040 FIND v(dout1_8) AT=1050.05n

.meas tran vdout1_9ck1040 FIND v(dout1_9) AT=1050.05n

.meas tran vdout1_10ck1040 FIND v(dout1_10) AT=1050.05n

.meas tran vdout1_11ck1040 FIND v(dout1_11) AT=1050.05n

.meas tran vdout1_12ck1040 FIND v(dout1_12) AT=1050.05n

.meas tran vdout1_13ck1040 FIND v(dout1_13) AT=1050.05n

.meas tran vdout1_14ck1040 FIND v(dout1_14) AT=1050.05n

.meas tran vdout1_15ck1040 FIND v(dout1_15) AT=1050.05n

.meas tran vdout1_16ck1040 FIND v(dout1_16) AT=1050.05n

.meas tran vdout1_17ck1040 FIND v(dout1_17) AT=1050.05n

.meas tran vdout1_18ck1040 FIND v(dout1_18) AT=1050.05n

.meas tran vdout1_19ck1040 FIND v(dout1_19) AT=1050.05n

.meas tran vdout1_20ck1040 FIND v(dout1_20) AT=1050.05n

.meas tran vdout1_21ck1040 FIND v(dout1_21) AT=1050.05n

.meas tran vdout1_22ck1040 FIND v(dout1_22) AT=1050.05n

.meas tran vdout1_23ck1040 FIND v(dout1_23) AT=1050.05n

.meas tran vdout1_24ck1040 FIND v(dout1_24) AT=1050.05n

.meas tran vdout1_25ck1040 FIND v(dout1_25) AT=1050.05n

.meas tran vdout1_26ck1040 FIND v(dout1_26) AT=1050.05n

.meas tran vdout1_27ck1040 FIND v(dout1_27) AT=1050.05n

.meas tran vdout1_28ck1040 FIND v(dout1_28) AT=1050.05n

.meas tran vdout1_29ck1040 FIND v(dout1_29) AT=1050.05n

.meas tran vdout1_30ck1040 FIND v(dout1_30) AT=1050.05n

.meas tran vdout1_31ck1040 FIND v(dout1_31) AT=1050.05n

.meas tran vdout1_32ck1040 FIND v(dout1_32) AT=1050.05n

.meas tran vdout1_33ck1040 FIND v(dout1_33) AT=1050.05n

.meas tran vdout1_34ck1040 FIND v(dout1_34) AT=1050.05n

.meas tran vdout1_35ck1040 FIND v(dout1_35) AT=1050.05n

.meas tran vdout1_36ck1040 FIND v(dout1_36) AT=1050.05n

.meas tran vdout1_37ck1040 FIND v(dout1_37) AT=1050.05n

.meas tran vdout1_38ck1040 FIND v(dout1_38) AT=1050.05n

.meas tran vdout1_39ck1040 FIND v(dout1_39) AT=1050.05n

.meas tran vdout1_40ck1040 FIND v(dout1_40) AT=1050.05n

.meas tran vdout1_41ck1040 FIND v(dout1_41) AT=1050.05n

.meas tran vdout1_42ck1040 FIND v(dout1_42) AT=1050.05n

.meas tran vdout1_43ck1040 FIND v(dout1_43) AT=1050.05n

.meas tran vdout1_44ck1040 FIND v(dout1_44) AT=1050.05n

.meas tran vdout1_45ck1040 FIND v(dout1_45) AT=1050.05n

.meas tran vdout1_46ck1040 FIND v(dout1_46) AT=1050.05n

.meas tran vdout1_47ck1040 FIND v(dout1_47) AT=1050.05n

.meas tran vdout1_48ck1040 FIND v(dout1_48) AT=1050.05n

.meas tran vdout1_49ck1040 FIND v(dout1_49) AT=1050.05n

.meas tran vdout1_50ck1040 FIND v(dout1_50) AT=1050.05n

.meas tran vdout1_51ck1040 FIND v(dout1_51) AT=1050.05n

.meas tran vdout1_52ck1040 FIND v(dout1_52) AT=1050.05n

.meas tran vdout1_53ck1040 FIND v(dout1_53) AT=1050.05n

.meas tran vdout1_54ck1040 FIND v(dout1_54) AT=1050.05n

.meas tran vdout1_55ck1040 FIND v(dout1_55) AT=1050.05n

.meas tran vdout1_56ck1040 FIND v(dout1_56) AT=1050.05n

.meas tran vdout1_57ck1040 FIND v(dout1_57) AT=1050.05n

.meas tran vdout1_58ck1040 FIND v(dout1_58) AT=1050.05n

.meas tran vdout1_59ck1040 FIND v(dout1_59) AT=1050.05n

.meas tran vdout1_60ck1040 FIND v(dout1_60) AT=1050.05n

.meas tran vdout1_61ck1040 FIND v(dout1_61) AT=1050.05n

.meas tran vdout1_62ck1040 FIND v(dout1_62) AT=1050.05n

.meas tran vdout1_63ck1040 FIND v(dout1_63) AT=1050.05n

.meas tran vdout1_64ck1040 FIND v(dout1_64) AT=1050.05n

.meas tran vdout1_65ck1040 FIND v(dout1_65) AT=1050.05n

.meas tran vdout1_66ck1040 FIND v(dout1_66) AT=1050.05n

.meas tran vdout1_67ck1040 FIND v(dout1_67) AT=1050.05n

.meas tran vdout1_68ck1040 FIND v(dout1_68) AT=1050.05n

.meas tran vdout1_69ck1040 FIND v(dout1_69) AT=1050.05n

.meas tran vdout1_70ck1040 FIND v(dout1_70) AT=1050.05n

.meas tran vdout1_71ck1040 FIND v(dout1_71) AT=1050.05n

.meas tran vdout1_72ck1040 FIND v(dout1_72) AT=1050.05n

.meas tran vdout1_73ck1040 FIND v(dout1_73) AT=1050.05n

.meas tran vdout1_74ck1040 FIND v(dout1_74) AT=1050.05n

.meas tran vdout1_75ck1040 FIND v(dout1_75) AT=1050.05n

.meas tran vdout1_76ck1040 FIND v(dout1_76) AT=1050.05n

.meas tran vdout1_77ck1040 FIND v(dout1_77) AT=1050.05n

.meas tran vdout1_78ck1040 FIND v(dout1_78) AT=1050.05n

.meas tran vdout1_79ck1040 FIND v(dout1_79) AT=1050.05n

.meas tran vdout1_80ck1040 FIND v(dout1_80) AT=1050.05n

.meas tran vdout1_81ck1040 FIND v(dout1_81) AT=1050.05n

.meas tran vdout1_82ck1040 FIND v(dout1_82) AT=1050.05n

.meas tran vdout1_83ck1040 FIND v(dout1_83) AT=1050.05n

.meas tran vdout1_84ck1040 FIND v(dout1_84) AT=1050.05n

.meas tran vdout1_85ck1040 FIND v(dout1_85) AT=1050.05n

.meas tran vdout1_86ck1040 FIND v(dout1_86) AT=1050.05n

.meas tran vdout1_87ck1040 FIND v(dout1_87) AT=1050.05n

.meas tran vdout1_88ck1040 FIND v(dout1_88) AT=1050.05n

.meas tran vdout1_89ck1040 FIND v(dout1_89) AT=1050.05n

.meas tran vdout1_90ck1040 FIND v(dout1_90) AT=1050.05n

.meas tran vdout1_91ck1040 FIND v(dout1_91) AT=1050.05n

.meas tran vdout1_92ck1040 FIND v(dout1_92) AT=1050.05n

.meas tran vdout1_93ck1040 FIND v(dout1_93) AT=1050.05n

.meas tran vdout1_94ck1040 FIND v(dout1_94) AT=1050.05n

.meas tran vdout1_95ck1040 FIND v(dout1_95) AT=1050.05n

.meas tran vdout1_96ck1040 FIND v(dout1_96) AT=1050.05n

.meas tran vdout1_97ck1040 FIND v(dout1_97) AT=1050.05n

.meas tran vdout1_98ck1040 FIND v(dout1_98) AT=1050.05n

.meas tran vdout1_99ck1040 FIND v(dout1_99) AT=1050.05n

.meas tran vdout1_100ck1040 FIND v(dout1_100) AT=1050.05n

.meas tran vdout1_101ck1040 FIND v(dout1_101) AT=1050.05n

.meas tran vdout1_102ck1040 FIND v(dout1_102) AT=1050.05n

.meas tran vdout1_103ck1040 FIND v(dout1_103) AT=1050.05n

.meas tran vdout1_104ck1040 FIND v(dout1_104) AT=1050.05n

.meas tran vdout1_105ck1040 FIND v(dout1_105) AT=1050.05n

.meas tran vdout1_106ck1040 FIND v(dout1_106) AT=1050.05n

.meas tran vdout1_107ck1040 FIND v(dout1_107) AT=1050.05n

.meas tran vdout1_108ck1040 FIND v(dout1_108) AT=1050.05n

.meas tran vdout1_109ck1040 FIND v(dout1_109) AT=1050.05n

.meas tran vdout1_110ck1040 FIND v(dout1_110) AT=1050.05n

.meas tran vdout1_111ck1040 FIND v(dout1_111) AT=1050.05n

.meas tran vdout1_112ck1040 FIND v(dout1_112) AT=1050.05n

.meas tran vdout1_113ck1040 FIND v(dout1_113) AT=1050.05n

.meas tran vdout1_114ck1040 FIND v(dout1_114) AT=1050.05n

.meas tran vdout1_115ck1040 FIND v(dout1_115) AT=1050.05n

.meas tran vdout1_116ck1040 FIND v(dout1_116) AT=1050.05n

.meas tran vdout1_117ck1040 FIND v(dout1_117) AT=1050.05n

.meas tran vdout1_118ck1040 FIND v(dout1_118) AT=1050.05n

.meas tran vdout1_119ck1040 FIND v(dout1_119) AT=1050.05n

.meas tran vdout1_120ck1040 FIND v(dout1_120) AT=1050.05n

.meas tran vdout1_121ck1040 FIND v(dout1_121) AT=1050.05n

.meas tran vdout1_122ck1040 FIND v(dout1_122) AT=1050.05n

.meas tran vdout1_123ck1040 FIND v(dout1_123) AT=1050.05n

.meas tran vdout1_124ck1040 FIND v(dout1_124) AT=1050.05n

.meas tran vdout1_125ck1040 FIND v(dout1_125) AT=1050.05n

.meas tran vdout1_126ck1040 FIND v(dout1_126) AT=1050.05n

.meas tran vdout1_127ck1040 FIND v(dout1_127) AT=1050.05n

.meas tran vdout1_128ck1040 FIND v(dout1_128) AT=1050.05n

.meas tran vdout1_129ck1040 FIND v(dout1_129) AT=1050.05n

.meas tran vdout1_130ck1040 FIND v(dout1_130) AT=1050.05n

.meas tran vdout1_131ck1040 FIND v(dout1_131) AT=1050.05n

.meas tran vdout1_132ck1040 FIND v(dout1_132) AT=1050.05n

.meas tran vdout1_133ck1040 FIND v(dout1_133) AT=1050.05n

.meas tran vdout1_134ck1040 FIND v(dout1_134) AT=1050.05n

.meas tran vdout1_135ck1040 FIND v(dout1_135) AT=1050.05n

.meas tran vdout1_136ck1040 FIND v(dout1_136) AT=1050.05n

.meas tran vdout1_137ck1040 FIND v(dout1_137) AT=1050.05n

.meas tran vdout1_138ck1040 FIND v(dout1_138) AT=1050.05n

.meas tran vdout1_139ck1040 FIND v(dout1_139) AT=1050.05n

.meas tran vdout1_140ck1040 FIND v(dout1_140) AT=1050.05n

.meas tran vdout1_141ck1040 FIND v(dout1_141) AT=1050.05n

.meas tran vdout1_142ck1040 FIND v(dout1_142) AT=1050.05n

.meas tran vdout1_143ck1040 FIND v(dout1_143) AT=1050.05n

.meas tran vdout1_144ck1040 FIND v(dout1_144) AT=1050.05n

.meas tran vdout1_145ck1040 FIND v(dout1_145) AT=1050.05n

.meas tran vdout1_146ck1040 FIND v(dout1_146) AT=1050.05n

.meas tran vdout1_147ck1040 FIND v(dout1_147) AT=1050.05n

.meas tran vdout1_148ck1040 FIND v(dout1_148) AT=1050.05n

.meas tran vdout1_149ck1040 FIND v(dout1_149) AT=1050.05n

.meas tran vdout1_150ck1040 FIND v(dout1_150) AT=1050.05n

.meas tran vdout1_151ck1040 FIND v(dout1_151) AT=1050.05n

.meas tran vdout1_152ck1040 FIND v(dout1_152) AT=1050.05n

.meas tran vdout1_153ck1040 FIND v(dout1_153) AT=1050.05n

.meas tran vdout1_154ck1040 FIND v(dout1_154) AT=1050.05n

.meas tran vdout1_155ck1040 FIND v(dout1_155) AT=1050.05n

.meas tran vdout1_156ck1040 FIND v(dout1_156) AT=1050.05n

.meas tran vdout1_157ck1040 FIND v(dout1_157) AT=1050.05n

.meas tran vdout1_158ck1040 FIND v(dout1_158) AT=1050.05n

.meas tran vdout1_159ck1040 FIND v(dout1_159) AT=1050.05n

.meas tran vdout1_160ck1040 FIND v(dout1_160) AT=1050.05n

.meas tran vdout1_161ck1040 FIND v(dout1_161) AT=1050.05n

.meas tran vdout1_162ck1040 FIND v(dout1_162) AT=1050.05n

.meas tran vdout1_163ck1040 FIND v(dout1_163) AT=1050.05n

.meas tran vdout1_164ck1040 FIND v(dout1_164) AT=1050.05n

.meas tran vdout1_165ck1040 FIND v(dout1_165) AT=1050.05n

.meas tran vdout1_166ck1040 FIND v(dout1_166) AT=1050.05n

.meas tran vdout1_167ck1040 FIND v(dout1_167) AT=1050.05n

.meas tran vdout1_168ck1040 FIND v(dout1_168) AT=1050.05n

.meas tran vdout1_169ck1040 FIND v(dout1_169) AT=1050.05n

.meas tran vdout1_170ck1040 FIND v(dout1_170) AT=1050.05n

.meas tran vdout1_171ck1040 FIND v(dout1_171) AT=1050.05n

.meas tran vdout1_172ck1040 FIND v(dout1_172) AT=1050.05n

.meas tran vdout1_173ck1040 FIND v(dout1_173) AT=1050.05n

.meas tran vdout1_174ck1040 FIND v(dout1_174) AT=1050.05n

.meas tran vdout1_175ck1040 FIND v(dout1_175) AT=1050.05n

.meas tran vdout1_176ck1040 FIND v(dout1_176) AT=1050.05n

.meas tran vdout1_177ck1040 FIND v(dout1_177) AT=1050.05n

.meas tran vdout1_178ck1040 FIND v(dout1_178) AT=1050.05n

.meas tran vdout1_179ck1040 FIND v(dout1_179) AT=1050.05n

.meas tran vdout1_180ck1040 FIND v(dout1_180) AT=1050.05n

.meas tran vdout1_181ck1040 FIND v(dout1_181) AT=1050.05n

.meas tran vdout1_182ck1040 FIND v(dout1_182) AT=1050.05n

.meas tran vdout1_183ck1040 FIND v(dout1_183) AT=1050.05n

.meas tran vdout1_184ck1040 FIND v(dout1_184) AT=1050.05n

.meas tran vdout1_185ck1040 FIND v(dout1_185) AT=1050.05n

.meas tran vdout1_186ck1040 FIND v(dout1_186) AT=1050.05n

.meas tran vdout1_187ck1040 FIND v(dout1_187) AT=1050.05n

.meas tran vdout1_188ck1040 FIND v(dout1_188) AT=1050.05n

.meas tran vdout1_189ck1040 FIND v(dout1_189) AT=1050.05n

.meas tran vdout1_190ck1040 FIND v(dout1_190) AT=1050.05n

.meas tran vdout1_191ck1040 FIND v(dout1_191) AT=1050.05n

.meas tran vdout1_192ck1040 FIND v(dout1_192) AT=1050.05n

.meas tran vdout1_193ck1040 FIND v(dout1_193) AT=1050.05n

.meas tran vdout1_194ck1040 FIND v(dout1_194) AT=1050.05n

.meas tran vdout1_195ck1040 FIND v(dout1_195) AT=1050.05n

.meas tran vdout1_196ck1040 FIND v(dout1_196) AT=1050.05n

.meas tran vdout1_197ck1040 FIND v(dout1_197) AT=1050.05n

.meas tran vdout1_198ck1040 FIND v(dout1_198) AT=1050.05n

.meas tran vdout1_199ck1040 FIND v(dout1_199) AT=1050.05n

.meas tran vdout1_200ck1040 FIND v(dout1_200) AT=1050.05n

.meas tran vdout1_201ck1040 FIND v(dout1_201) AT=1050.05n

.meas tran vdout1_202ck1040 FIND v(dout1_202) AT=1050.05n

.meas tran vdout1_203ck1040 FIND v(dout1_203) AT=1050.05n

.meas tran vdout1_204ck1040 FIND v(dout1_204) AT=1050.05n

.meas tran vdout1_205ck1040 FIND v(dout1_205) AT=1050.05n

.meas tran vdout1_206ck1040 FIND v(dout1_206) AT=1050.05n

.meas tran vdout1_207ck1040 FIND v(dout1_207) AT=1050.05n

.meas tran vdout1_208ck1040 FIND v(dout1_208) AT=1050.05n

.meas tran vdout1_209ck1040 FIND v(dout1_209) AT=1050.05n

.meas tran vdout1_210ck1040 FIND v(dout1_210) AT=1050.05n

.meas tran vdout1_211ck1040 FIND v(dout1_211) AT=1050.05n

.meas tran vdout1_212ck1040 FIND v(dout1_212) AT=1050.05n

.meas tran vdout1_213ck1040 FIND v(dout1_213) AT=1050.05n

.meas tran vdout1_214ck1040 FIND v(dout1_214) AT=1050.05n

.meas tran vdout1_215ck1040 FIND v(dout1_215) AT=1050.05n

.meas tran vdout1_216ck1040 FIND v(dout1_216) AT=1050.05n

.meas tran vdout1_217ck1040 FIND v(dout1_217) AT=1050.05n

.meas tran vdout1_218ck1040 FIND v(dout1_218) AT=1050.05n

.meas tran vdout1_219ck1040 FIND v(dout1_219) AT=1050.05n

.meas tran vdout1_220ck1040 FIND v(dout1_220) AT=1050.05n

.meas tran vdout1_221ck1040 FIND v(dout1_221) AT=1050.05n

.meas tran vdout1_222ck1040 FIND v(dout1_222) AT=1050.05n

.meas tran vdout1_223ck1040 FIND v(dout1_223) AT=1050.05n

.meas tran vdout1_224ck1040 FIND v(dout1_224) AT=1050.05n

.meas tran vdout1_225ck1040 FIND v(dout1_225) AT=1050.05n

.meas tran vdout1_226ck1040 FIND v(dout1_226) AT=1050.05n

.meas tran vdout1_227ck1040 FIND v(dout1_227) AT=1050.05n

.meas tran vdout1_228ck1040 FIND v(dout1_228) AT=1050.05n

.meas tran vdout1_229ck1040 FIND v(dout1_229) AT=1050.05n

.meas tran vdout1_230ck1040 FIND v(dout1_230) AT=1050.05n

.meas tran vdout1_231ck1040 FIND v(dout1_231) AT=1050.05n

.meas tran vdout1_232ck1040 FIND v(dout1_232) AT=1050.05n

.meas tran vdout1_233ck1040 FIND v(dout1_233) AT=1050.05n

.meas tran vdout1_234ck1040 FIND v(dout1_234) AT=1050.05n

.meas tran vdout1_235ck1040 FIND v(dout1_235) AT=1050.05n

.meas tran vdout1_236ck1040 FIND v(dout1_236) AT=1050.05n

.meas tran vdout1_237ck1040 FIND v(dout1_237) AT=1050.05n

.meas tran vdout1_238ck1040 FIND v(dout1_238) AT=1050.05n

.meas tran vdout1_239ck1040 FIND v(dout1_239) AT=1050.05n

.meas tran vdout1_240ck1040 FIND v(dout1_240) AT=1050.05n

.meas tran vdout1_241ck1040 FIND v(dout1_241) AT=1050.05n

.meas tran vdout1_242ck1040 FIND v(dout1_242) AT=1050.05n

.meas tran vdout1_243ck1040 FIND v(dout1_243) AT=1050.05n

.meas tran vdout1_244ck1040 FIND v(dout1_244) AT=1050.05n

.meas tran vdout1_245ck1040 FIND v(dout1_245) AT=1050.05n

.meas tran vdout1_246ck1040 FIND v(dout1_246) AT=1050.05n

.meas tran vdout1_247ck1040 FIND v(dout1_247) AT=1050.05n

.meas tran vdout1_248ck1040 FIND v(dout1_248) AT=1050.05n

.meas tran vdout1_249ck1040 FIND v(dout1_249) AT=1050.05n

.meas tran vdout1_250ck1040 FIND v(dout1_250) AT=1050.05n

.meas tran vdout1_251ck1040 FIND v(dout1_251) AT=1050.05n

.meas tran vdout1_252ck1040 FIND v(dout1_252) AT=1050.05n

.meas tran vdout1_253ck1040 FIND v(dout1_253) AT=1050.05n

.meas tran vdout1_254ck1040 FIND v(dout1_254) AT=1050.05n

.meas tran vdout1_255ck1040 FIND v(dout1_255) AT=1050.05n

.meas tran vdout1_256ck1040 FIND v(dout1_256) AT=1050.05n

.meas tran vdout1_0ck1050 FIND v(dout1_0) AT=1060.05n

.meas tran vdout1_1ck1050 FIND v(dout1_1) AT=1060.05n

.meas tran vdout1_2ck1050 FIND v(dout1_2) AT=1060.05n

.meas tran vdout1_3ck1050 FIND v(dout1_3) AT=1060.05n

.meas tran vdout1_4ck1050 FIND v(dout1_4) AT=1060.05n

.meas tran vdout1_5ck1050 FIND v(dout1_5) AT=1060.05n

.meas tran vdout1_6ck1050 FIND v(dout1_6) AT=1060.05n

.meas tran vdout1_7ck1050 FIND v(dout1_7) AT=1060.05n

.meas tran vdout1_8ck1050 FIND v(dout1_8) AT=1060.05n

.meas tran vdout1_9ck1050 FIND v(dout1_9) AT=1060.05n

.meas tran vdout1_10ck1050 FIND v(dout1_10) AT=1060.05n

.meas tran vdout1_11ck1050 FIND v(dout1_11) AT=1060.05n

.meas tran vdout1_12ck1050 FIND v(dout1_12) AT=1060.05n

.meas tran vdout1_13ck1050 FIND v(dout1_13) AT=1060.05n

.meas tran vdout1_14ck1050 FIND v(dout1_14) AT=1060.05n

.meas tran vdout1_15ck1050 FIND v(dout1_15) AT=1060.05n

.meas tran vdout1_16ck1050 FIND v(dout1_16) AT=1060.05n

.meas tran vdout1_17ck1050 FIND v(dout1_17) AT=1060.05n

.meas tran vdout1_18ck1050 FIND v(dout1_18) AT=1060.05n

.meas tran vdout1_19ck1050 FIND v(dout1_19) AT=1060.05n

.meas tran vdout1_20ck1050 FIND v(dout1_20) AT=1060.05n

.meas tran vdout1_21ck1050 FIND v(dout1_21) AT=1060.05n

.meas tran vdout1_22ck1050 FIND v(dout1_22) AT=1060.05n

.meas tran vdout1_23ck1050 FIND v(dout1_23) AT=1060.05n

.meas tran vdout1_24ck1050 FIND v(dout1_24) AT=1060.05n

.meas tran vdout1_25ck1050 FIND v(dout1_25) AT=1060.05n

.meas tran vdout1_26ck1050 FIND v(dout1_26) AT=1060.05n

.meas tran vdout1_27ck1050 FIND v(dout1_27) AT=1060.05n

.meas tran vdout1_28ck1050 FIND v(dout1_28) AT=1060.05n

.meas tran vdout1_29ck1050 FIND v(dout1_29) AT=1060.05n

.meas tran vdout1_30ck1050 FIND v(dout1_30) AT=1060.05n

.meas tran vdout1_31ck1050 FIND v(dout1_31) AT=1060.05n

.meas tran vdout1_32ck1050 FIND v(dout1_32) AT=1060.05n

.meas tran vdout1_33ck1050 FIND v(dout1_33) AT=1060.05n

.meas tran vdout1_34ck1050 FIND v(dout1_34) AT=1060.05n

.meas tran vdout1_35ck1050 FIND v(dout1_35) AT=1060.05n

.meas tran vdout1_36ck1050 FIND v(dout1_36) AT=1060.05n

.meas tran vdout1_37ck1050 FIND v(dout1_37) AT=1060.05n

.meas tran vdout1_38ck1050 FIND v(dout1_38) AT=1060.05n

.meas tran vdout1_39ck1050 FIND v(dout1_39) AT=1060.05n

.meas tran vdout1_40ck1050 FIND v(dout1_40) AT=1060.05n

.meas tran vdout1_41ck1050 FIND v(dout1_41) AT=1060.05n

.meas tran vdout1_42ck1050 FIND v(dout1_42) AT=1060.05n

.meas tran vdout1_43ck1050 FIND v(dout1_43) AT=1060.05n

.meas tran vdout1_44ck1050 FIND v(dout1_44) AT=1060.05n

.meas tran vdout1_45ck1050 FIND v(dout1_45) AT=1060.05n

.meas tran vdout1_46ck1050 FIND v(dout1_46) AT=1060.05n

.meas tran vdout1_47ck1050 FIND v(dout1_47) AT=1060.05n

.meas tran vdout1_48ck1050 FIND v(dout1_48) AT=1060.05n

.meas tran vdout1_49ck1050 FIND v(dout1_49) AT=1060.05n

.meas tran vdout1_50ck1050 FIND v(dout1_50) AT=1060.05n

.meas tran vdout1_51ck1050 FIND v(dout1_51) AT=1060.05n

.meas tran vdout1_52ck1050 FIND v(dout1_52) AT=1060.05n

.meas tran vdout1_53ck1050 FIND v(dout1_53) AT=1060.05n

.meas tran vdout1_54ck1050 FIND v(dout1_54) AT=1060.05n

.meas tran vdout1_55ck1050 FIND v(dout1_55) AT=1060.05n

.meas tran vdout1_56ck1050 FIND v(dout1_56) AT=1060.05n

.meas tran vdout1_57ck1050 FIND v(dout1_57) AT=1060.05n

.meas tran vdout1_58ck1050 FIND v(dout1_58) AT=1060.05n

.meas tran vdout1_59ck1050 FIND v(dout1_59) AT=1060.05n

.meas tran vdout1_60ck1050 FIND v(dout1_60) AT=1060.05n

.meas tran vdout1_61ck1050 FIND v(dout1_61) AT=1060.05n

.meas tran vdout1_62ck1050 FIND v(dout1_62) AT=1060.05n

.meas tran vdout1_63ck1050 FIND v(dout1_63) AT=1060.05n

.meas tran vdout1_64ck1050 FIND v(dout1_64) AT=1060.05n

.meas tran vdout1_65ck1050 FIND v(dout1_65) AT=1060.05n

.meas tran vdout1_66ck1050 FIND v(dout1_66) AT=1060.05n

.meas tran vdout1_67ck1050 FIND v(dout1_67) AT=1060.05n

.meas tran vdout1_68ck1050 FIND v(dout1_68) AT=1060.05n

.meas tran vdout1_69ck1050 FIND v(dout1_69) AT=1060.05n

.meas tran vdout1_70ck1050 FIND v(dout1_70) AT=1060.05n

.meas tran vdout1_71ck1050 FIND v(dout1_71) AT=1060.05n

.meas tran vdout1_72ck1050 FIND v(dout1_72) AT=1060.05n

.meas tran vdout1_73ck1050 FIND v(dout1_73) AT=1060.05n

.meas tran vdout1_74ck1050 FIND v(dout1_74) AT=1060.05n

.meas tran vdout1_75ck1050 FIND v(dout1_75) AT=1060.05n

.meas tran vdout1_76ck1050 FIND v(dout1_76) AT=1060.05n

.meas tran vdout1_77ck1050 FIND v(dout1_77) AT=1060.05n

.meas tran vdout1_78ck1050 FIND v(dout1_78) AT=1060.05n

.meas tran vdout1_79ck1050 FIND v(dout1_79) AT=1060.05n

.meas tran vdout1_80ck1050 FIND v(dout1_80) AT=1060.05n

.meas tran vdout1_81ck1050 FIND v(dout1_81) AT=1060.05n

.meas tran vdout1_82ck1050 FIND v(dout1_82) AT=1060.05n

.meas tran vdout1_83ck1050 FIND v(dout1_83) AT=1060.05n

.meas tran vdout1_84ck1050 FIND v(dout1_84) AT=1060.05n

.meas tran vdout1_85ck1050 FIND v(dout1_85) AT=1060.05n

.meas tran vdout1_86ck1050 FIND v(dout1_86) AT=1060.05n

.meas tran vdout1_87ck1050 FIND v(dout1_87) AT=1060.05n

.meas tran vdout1_88ck1050 FIND v(dout1_88) AT=1060.05n

.meas tran vdout1_89ck1050 FIND v(dout1_89) AT=1060.05n

.meas tran vdout1_90ck1050 FIND v(dout1_90) AT=1060.05n

.meas tran vdout1_91ck1050 FIND v(dout1_91) AT=1060.05n

.meas tran vdout1_92ck1050 FIND v(dout1_92) AT=1060.05n

.meas tran vdout1_93ck1050 FIND v(dout1_93) AT=1060.05n

.meas tran vdout1_94ck1050 FIND v(dout1_94) AT=1060.05n

.meas tran vdout1_95ck1050 FIND v(dout1_95) AT=1060.05n

.meas tran vdout1_96ck1050 FIND v(dout1_96) AT=1060.05n

.meas tran vdout1_97ck1050 FIND v(dout1_97) AT=1060.05n

.meas tran vdout1_98ck1050 FIND v(dout1_98) AT=1060.05n

.meas tran vdout1_99ck1050 FIND v(dout1_99) AT=1060.05n

.meas tran vdout1_100ck1050 FIND v(dout1_100) AT=1060.05n

.meas tran vdout1_101ck1050 FIND v(dout1_101) AT=1060.05n

.meas tran vdout1_102ck1050 FIND v(dout1_102) AT=1060.05n

.meas tran vdout1_103ck1050 FIND v(dout1_103) AT=1060.05n

.meas tran vdout1_104ck1050 FIND v(dout1_104) AT=1060.05n

.meas tran vdout1_105ck1050 FIND v(dout1_105) AT=1060.05n

.meas tran vdout1_106ck1050 FIND v(dout1_106) AT=1060.05n

.meas tran vdout1_107ck1050 FIND v(dout1_107) AT=1060.05n

.meas tran vdout1_108ck1050 FIND v(dout1_108) AT=1060.05n

.meas tran vdout1_109ck1050 FIND v(dout1_109) AT=1060.05n

.meas tran vdout1_110ck1050 FIND v(dout1_110) AT=1060.05n

.meas tran vdout1_111ck1050 FIND v(dout1_111) AT=1060.05n

.meas tran vdout1_112ck1050 FIND v(dout1_112) AT=1060.05n

.meas tran vdout1_113ck1050 FIND v(dout1_113) AT=1060.05n

.meas tran vdout1_114ck1050 FIND v(dout1_114) AT=1060.05n

.meas tran vdout1_115ck1050 FIND v(dout1_115) AT=1060.05n

.meas tran vdout1_116ck1050 FIND v(dout1_116) AT=1060.05n

.meas tran vdout1_117ck1050 FIND v(dout1_117) AT=1060.05n

.meas tran vdout1_118ck1050 FIND v(dout1_118) AT=1060.05n

.meas tran vdout1_119ck1050 FIND v(dout1_119) AT=1060.05n

.meas tran vdout1_120ck1050 FIND v(dout1_120) AT=1060.05n

.meas tran vdout1_121ck1050 FIND v(dout1_121) AT=1060.05n

.meas tran vdout1_122ck1050 FIND v(dout1_122) AT=1060.05n

.meas tran vdout1_123ck1050 FIND v(dout1_123) AT=1060.05n

.meas tran vdout1_124ck1050 FIND v(dout1_124) AT=1060.05n

.meas tran vdout1_125ck1050 FIND v(dout1_125) AT=1060.05n

.meas tran vdout1_126ck1050 FIND v(dout1_126) AT=1060.05n

.meas tran vdout1_127ck1050 FIND v(dout1_127) AT=1060.05n

.meas tran vdout1_128ck1050 FIND v(dout1_128) AT=1060.05n

.meas tran vdout1_129ck1050 FIND v(dout1_129) AT=1060.05n

.meas tran vdout1_130ck1050 FIND v(dout1_130) AT=1060.05n

.meas tran vdout1_131ck1050 FIND v(dout1_131) AT=1060.05n

.meas tran vdout1_132ck1050 FIND v(dout1_132) AT=1060.05n

.meas tran vdout1_133ck1050 FIND v(dout1_133) AT=1060.05n

.meas tran vdout1_134ck1050 FIND v(dout1_134) AT=1060.05n

.meas tran vdout1_135ck1050 FIND v(dout1_135) AT=1060.05n

.meas tran vdout1_136ck1050 FIND v(dout1_136) AT=1060.05n

.meas tran vdout1_137ck1050 FIND v(dout1_137) AT=1060.05n

.meas tran vdout1_138ck1050 FIND v(dout1_138) AT=1060.05n

.meas tran vdout1_139ck1050 FIND v(dout1_139) AT=1060.05n

.meas tran vdout1_140ck1050 FIND v(dout1_140) AT=1060.05n

.meas tran vdout1_141ck1050 FIND v(dout1_141) AT=1060.05n

.meas tran vdout1_142ck1050 FIND v(dout1_142) AT=1060.05n

.meas tran vdout1_143ck1050 FIND v(dout1_143) AT=1060.05n

.meas tran vdout1_144ck1050 FIND v(dout1_144) AT=1060.05n

.meas tran vdout1_145ck1050 FIND v(dout1_145) AT=1060.05n

.meas tran vdout1_146ck1050 FIND v(dout1_146) AT=1060.05n

.meas tran vdout1_147ck1050 FIND v(dout1_147) AT=1060.05n

.meas tran vdout1_148ck1050 FIND v(dout1_148) AT=1060.05n

.meas tran vdout1_149ck1050 FIND v(dout1_149) AT=1060.05n

.meas tran vdout1_150ck1050 FIND v(dout1_150) AT=1060.05n

.meas tran vdout1_151ck1050 FIND v(dout1_151) AT=1060.05n

.meas tran vdout1_152ck1050 FIND v(dout1_152) AT=1060.05n

.meas tran vdout1_153ck1050 FIND v(dout1_153) AT=1060.05n

.meas tran vdout1_154ck1050 FIND v(dout1_154) AT=1060.05n

.meas tran vdout1_155ck1050 FIND v(dout1_155) AT=1060.05n

.meas tran vdout1_156ck1050 FIND v(dout1_156) AT=1060.05n

.meas tran vdout1_157ck1050 FIND v(dout1_157) AT=1060.05n

.meas tran vdout1_158ck1050 FIND v(dout1_158) AT=1060.05n

.meas tran vdout1_159ck1050 FIND v(dout1_159) AT=1060.05n

.meas tran vdout1_160ck1050 FIND v(dout1_160) AT=1060.05n

.meas tran vdout1_161ck1050 FIND v(dout1_161) AT=1060.05n

.meas tran vdout1_162ck1050 FIND v(dout1_162) AT=1060.05n

.meas tran vdout1_163ck1050 FIND v(dout1_163) AT=1060.05n

.meas tran vdout1_164ck1050 FIND v(dout1_164) AT=1060.05n

.meas tran vdout1_165ck1050 FIND v(dout1_165) AT=1060.05n

.meas tran vdout1_166ck1050 FIND v(dout1_166) AT=1060.05n

.meas tran vdout1_167ck1050 FIND v(dout1_167) AT=1060.05n

.meas tran vdout1_168ck1050 FIND v(dout1_168) AT=1060.05n

.meas tran vdout1_169ck1050 FIND v(dout1_169) AT=1060.05n

.meas tran vdout1_170ck1050 FIND v(dout1_170) AT=1060.05n

.meas tran vdout1_171ck1050 FIND v(dout1_171) AT=1060.05n

.meas tran vdout1_172ck1050 FIND v(dout1_172) AT=1060.05n

.meas tran vdout1_173ck1050 FIND v(dout1_173) AT=1060.05n

.meas tran vdout1_174ck1050 FIND v(dout1_174) AT=1060.05n

.meas tran vdout1_175ck1050 FIND v(dout1_175) AT=1060.05n

.meas tran vdout1_176ck1050 FIND v(dout1_176) AT=1060.05n

.meas tran vdout1_177ck1050 FIND v(dout1_177) AT=1060.05n

.meas tran vdout1_178ck1050 FIND v(dout1_178) AT=1060.05n

.meas tran vdout1_179ck1050 FIND v(dout1_179) AT=1060.05n

.meas tran vdout1_180ck1050 FIND v(dout1_180) AT=1060.05n

.meas tran vdout1_181ck1050 FIND v(dout1_181) AT=1060.05n

.meas tran vdout1_182ck1050 FIND v(dout1_182) AT=1060.05n

.meas tran vdout1_183ck1050 FIND v(dout1_183) AT=1060.05n

.meas tran vdout1_184ck1050 FIND v(dout1_184) AT=1060.05n

.meas tran vdout1_185ck1050 FIND v(dout1_185) AT=1060.05n

.meas tran vdout1_186ck1050 FIND v(dout1_186) AT=1060.05n

.meas tran vdout1_187ck1050 FIND v(dout1_187) AT=1060.05n

.meas tran vdout1_188ck1050 FIND v(dout1_188) AT=1060.05n

.meas tran vdout1_189ck1050 FIND v(dout1_189) AT=1060.05n

.meas tran vdout1_190ck1050 FIND v(dout1_190) AT=1060.05n

.meas tran vdout1_191ck1050 FIND v(dout1_191) AT=1060.05n

.meas tran vdout1_192ck1050 FIND v(dout1_192) AT=1060.05n

.meas tran vdout1_193ck1050 FIND v(dout1_193) AT=1060.05n

.meas tran vdout1_194ck1050 FIND v(dout1_194) AT=1060.05n

.meas tran vdout1_195ck1050 FIND v(dout1_195) AT=1060.05n

.meas tran vdout1_196ck1050 FIND v(dout1_196) AT=1060.05n

.meas tran vdout1_197ck1050 FIND v(dout1_197) AT=1060.05n

.meas tran vdout1_198ck1050 FIND v(dout1_198) AT=1060.05n

.meas tran vdout1_199ck1050 FIND v(dout1_199) AT=1060.05n

.meas tran vdout1_200ck1050 FIND v(dout1_200) AT=1060.05n

.meas tran vdout1_201ck1050 FIND v(dout1_201) AT=1060.05n

.meas tran vdout1_202ck1050 FIND v(dout1_202) AT=1060.05n

.meas tran vdout1_203ck1050 FIND v(dout1_203) AT=1060.05n

.meas tran vdout1_204ck1050 FIND v(dout1_204) AT=1060.05n

.meas tran vdout1_205ck1050 FIND v(dout1_205) AT=1060.05n

.meas tran vdout1_206ck1050 FIND v(dout1_206) AT=1060.05n

.meas tran vdout1_207ck1050 FIND v(dout1_207) AT=1060.05n

.meas tran vdout1_208ck1050 FIND v(dout1_208) AT=1060.05n

.meas tran vdout1_209ck1050 FIND v(dout1_209) AT=1060.05n

.meas tran vdout1_210ck1050 FIND v(dout1_210) AT=1060.05n

.meas tran vdout1_211ck1050 FIND v(dout1_211) AT=1060.05n

.meas tran vdout1_212ck1050 FIND v(dout1_212) AT=1060.05n

.meas tran vdout1_213ck1050 FIND v(dout1_213) AT=1060.05n

.meas tran vdout1_214ck1050 FIND v(dout1_214) AT=1060.05n

.meas tran vdout1_215ck1050 FIND v(dout1_215) AT=1060.05n

.meas tran vdout1_216ck1050 FIND v(dout1_216) AT=1060.05n

.meas tran vdout1_217ck1050 FIND v(dout1_217) AT=1060.05n

.meas tran vdout1_218ck1050 FIND v(dout1_218) AT=1060.05n

.meas tran vdout1_219ck1050 FIND v(dout1_219) AT=1060.05n

.meas tran vdout1_220ck1050 FIND v(dout1_220) AT=1060.05n

.meas tran vdout1_221ck1050 FIND v(dout1_221) AT=1060.05n

.meas tran vdout1_222ck1050 FIND v(dout1_222) AT=1060.05n

.meas tran vdout1_223ck1050 FIND v(dout1_223) AT=1060.05n

.meas tran vdout1_224ck1050 FIND v(dout1_224) AT=1060.05n

.meas tran vdout1_225ck1050 FIND v(dout1_225) AT=1060.05n

.meas tran vdout1_226ck1050 FIND v(dout1_226) AT=1060.05n

.meas tran vdout1_227ck1050 FIND v(dout1_227) AT=1060.05n

.meas tran vdout1_228ck1050 FIND v(dout1_228) AT=1060.05n

.meas tran vdout1_229ck1050 FIND v(dout1_229) AT=1060.05n

.meas tran vdout1_230ck1050 FIND v(dout1_230) AT=1060.05n

.meas tran vdout1_231ck1050 FIND v(dout1_231) AT=1060.05n

.meas tran vdout1_232ck1050 FIND v(dout1_232) AT=1060.05n

.meas tran vdout1_233ck1050 FIND v(dout1_233) AT=1060.05n

.meas tran vdout1_234ck1050 FIND v(dout1_234) AT=1060.05n

.meas tran vdout1_235ck1050 FIND v(dout1_235) AT=1060.05n

.meas tran vdout1_236ck1050 FIND v(dout1_236) AT=1060.05n

.meas tran vdout1_237ck1050 FIND v(dout1_237) AT=1060.05n

.meas tran vdout1_238ck1050 FIND v(dout1_238) AT=1060.05n

.meas tran vdout1_239ck1050 FIND v(dout1_239) AT=1060.05n

.meas tran vdout1_240ck1050 FIND v(dout1_240) AT=1060.05n

.meas tran vdout1_241ck1050 FIND v(dout1_241) AT=1060.05n

.meas tran vdout1_242ck1050 FIND v(dout1_242) AT=1060.05n

.meas tran vdout1_243ck1050 FIND v(dout1_243) AT=1060.05n

.meas tran vdout1_244ck1050 FIND v(dout1_244) AT=1060.05n

.meas tran vdout1_245ck1050 FIND v(dout1_245) AT=1060.05n

.meas tran vdout1_246ck1050 FIND v(dout1_246) AT=1060.05n

.meas tran vdout1_247ck1050 FIND v(dout1_247) AT=1060.05n

.meas tran vdout1_248ck1050 FIND v(dout1_248) AT=1060.05n

.meas tran vdout1_249ck1050 FIND v(dout1_249) AT=1060.05n

.meas tran vdout1_250ck1050 FIND v(dout1_250) AT=1060.05n

.meas tran vdout1_251ck1050 FIND v(dout1_251) AT=1060.05n

.meas tran vdout1_252ck1050 FIND v(dout1_252) AT=1060.05n

.meas tran vdout1_253ck1050 FIND v(dout1_253) AT=1060.05n

.meas tran vdout1_254ck1050 FIND v(dout1_254) AT=1060.05n

.meas tran vdout1_255ck1050 FIND v(dout1_255) AT=1060.05n

.meas tran vdout1_256ck1050 FIND v(dout1_256) AT=1060.05n

.meas tran vdout1_0ck1060 FIND v(dout1_0) AT=1070.05n

.meas tran vdout1_1ck1060 FIND v(dout1_1) AT=1070.05n

.meas tran vdout1_2ck1060 FIND v(dout1_2) AT=1070.05n

.meas tran vdout1_3ck1060 FIND v(dout1_3) AT=1070.05n

.meas tran vdout1_4ck1060 FIND v(dout1_4) AT=1070.05n

.meas tran vdout1_5ck1060 FIND v(dout1_5) AT=1070.05n

.meas tran vdout1_6ck1060 FIND v(dout1_6) AT=1070.05n

.meas tran vdout1_7ck1060 FIND v(dout1_7) AT=1070.05n

.meas tran vdout1_8ck1060 FIND v(dout1_8) AT=1070.05n

.meas tran vdout1_9ck1060 FIND v(dout1_9) AT=1070.05n

.meas tran vdout1_10ck1060 FIND v(dout1_10) AT=1070.05n

.meas tran vdout1_11ck1060 FIND v(dout1_11) AT=1070.05n

.meas tran vdout1_12ck1060 FIND v(dout1_12) AT=1070.05n

.meas tran vdout1_13ck1060 FIND v(dout1_13) AT=1070.05n

.meas tran vdout1_14ck1060 FIND v(dout1_14) AT=1070.05n

.meas tran vdout1_15ck1060 FIND v(dout1_15) AT=1070.05n

.meas tran vdout1_16ck1060 FIND v(dout1_16) AT=1070.05n

.meas tran vdout1_17ck1060 FIND v(dout1_17) AT=1070.05n

.meas tran vdout1_18ck1060 FIND v(dout1_18) AT=1070.05n

.meas tran vdout1_19ck1060 FIND v(dout1_19) AT=1070.05n

.meas tran vdout1_20ck1060 FIND v(dout1_20) AT=1070.05n

.meas tran vdout1_21ck1060 FIND v(dout1_21) AT=1070.05n

.meas tran vdout1_22ck1060 FIND v(dout1_22) AT=1070.05n

.meas tran vdout1_23ck1060 FIND v(dout1_23) AT=1070.05n

.meas tran vdout1_24ck1060 FIND v(dout1_24) AT=1070.05n

.meas tran vdout1_25ck1060 FIND v(dout1_25) AT=1070.05n

.meas tran vdout1_26ck1060 FIND v(dout1_26) AT=1070.05n

.meas tran vdout1_27ck1060 FIND v(dout1_27) AT=1070.05n

.meas tran vdout1_28ck1060 FIND v(dout1_28) AT=1070.05n

.meas tran vdout1_29ck1060 FIND v(dout1_29) AT=1070.05n

.meas tran vdout1_30ck1060 FIND v(dout1_30) AT=1070.05n

.meas tran vdout1_31ck1060 FIND v(dout1_31) AT=1070.05n

.meas tran vdout1_32ck1060 FIND v(dout1_32) AT=1070.05n

.meas tran vdout1_33ck1060 FIND v(dout1_33) AT=1070.05n

.meas tran vdout1_34ck1060 FIND v(dout1_34) AT=1070.05n

.meas tran vdout1_35ck1060 FIND v(dout1_35) AT=1070.05n

.meas tran vdout1_36ck1060 FIND v(dout1_36) AT=1070.05n

.meas tran vdout1_37ck1060 FIND v(dout1_37) AT=1070.05n

.meas tran vdout1_38ck1060 FIND v(dout1_38) AT=1070.05n

.meas tran vdout1_39ck1060 FIND v(dout1_39) AT=1070.05n

.meas tran vdout1_40ck1060 FIND v(dout1_40) AT=1070.05n

.meas tran vdout1_41ck1060 FIND v(dout1_41) AT=1070.05n

.meas tran vdout1_42ck1060 FIND v(dout1_42) AT=1070.05n

.meas tran vdout1_43ck1060 FIND v(dout1_43) AT=1070.05n

.meas tran vdout1_44ck1060 FIND v(dout1_44) AT=1070.05n

.meas tran vdout1_45ck1060 FIND v(dout1_45) AT=1070.05n

.meas tran vdout1_46ck1060 FIND v(dout1_46) AT=1070.05n

.meas tran vdout1_47ck1060 FIND v(dout1_47) AT=1070.05n

.meas tran vdout1_48ck1060 FIND v(dout1_48) AT=1070.05n

.meas tran vdout1_49ck1060 FIND v(dout1_49) AT=1070.05n

.meas tran vdout1_50ck1060 FIND v(dout1_50) AT=1070.05n

.meas tran vdout1_51ck1060 FIND v(dout1_51) AT=1070.05n

.meas tran vdout1_52ck1060 FIND v(dout1_52) AT=1070.05n

.meas tran vdout1_53ck1060 FIND v(dout1_53) AT=1070.05n

.meas tran vdout1_54ck1060 FIND v(dout1_54) AT=1070.05n

.meas tran vdout1_55ck1060 FIND v(dout1_55) AT=1070.05n

.meas tran vdout1_56ck1060 FIND v(dout1_56) AT=1070.05n

.meas tran vdout1_57ck1060 FIND v(dout1_57) AT=1070.05n

.meas tran vdout1_58ck1060 FIND v(dout1_58) AT=1070.05n

.meas tran vdout1_59ck1060 FIND v(dout1_59) AT=1070.05n

.meas tran vdout1_60ck1060 FIND v(dout1_60) AT=1070.05n

.meas tran vdout1_61ck1060 FIND v(dout1_61) AT=1070.05n

.meas tran vdout1_62ck1060 FIND v(dout1_62) AT=1070.05n

.meas tran vdout1_63ck1060 FIND v(dout1_63) AT=1070.05n

.meas tran vdout1_64ck1060 FIND v(dout1_64) AT=1070.05n

.meas tran vdout1_65ck1060 FIND v(dout1_65) AT=1070.05n

.meas tran vdout1_66ck1060 FIND v(dout1_66) AT=1070.05n

.meas tran vdout1_67ck1060 FIND v(dout1_67) AT=1070.05n

.meas tran vdout1_68ck1060 FIND v(dout1_68) AT=1070.05n

.meas tran vdout1_69ck1060 FIND v(dout1_69) AT=1070.05n

.meas tran vdout1_70ck1060 FIND v(dout1_70) AT=1070.05n

.meas tran vdout1_71ck1060 FIND v(dout1_71) AT=1070.05n

.meas tran vdout1_72ck1060 FIND v(dout1_72) AT=1070.05n

.meas tran vdout1_73ck1060 FIND v(dout1_73) AT=1070.05n

.meas tran vdout1_74ck1060 FIND v(dout1_74) AT=1070.05n

.meas tran vdout1_75ck1060 FIND v(dout1_75) AT=1070.05n

.meas tran vdout1_76ck1060 FIND v(dout1_76) AT=1070.05n

.meas tran vdout1_77ck1060 FIND v(dout1_77) AT=1070.05n

.meas tran vdout1_78ck1060 FIND v(dout1_78) AT=1070.05n

.meas tran vdout1_79ck1060 FIND v(dout1_79) AT=1070.05n

.meas tran vdout1_80ck1060 FIND v(dout1_80) AT=1070.05n

.meas tran vdout1_81ck1060 FIND v(dout1_81) AT=1070.05n

.meas tran vdout1_82ck1060 FIND v(dout1_82) AT=1070.05n

.meas tran vdout1_83ck1060 FIND v(dout1_83) AT=1070.05n

.meas tran vdout1_84ck1060 FIND v(dout1_84) AT=1070.05n

.meas tran vdout1_85ck1060 FIND v(dout1_85) AT=1070.05n

.meas tran vdout1_86ck1060 FIND v(dout1_86) AT=1070.05n

.meas tran vdout1_87ck1060 FIND v(dout1_87) AT=1070.05n

.meas tran vdout1_88ck1060 FIND v(dout1_88) AT=1070.05n

.meas tran vdout1_89ck1060 FIND v(dout1_89) AT=1070.05n

.meas tran vdout1_90ck1060 FIND v(dout1_90) AT=1070.05n

.meas tran vdout1_91ck1060 FIND v(dout1_91) AT=1070.05n

.meas tran vdout1_92ck1060 FIND v(dout1_92) AT=1070.05n

.meas tran vdout1_93ck1060 FIND v(dout1_93) AT=1070.05n

.meas tran vdout1_94ck1060 FIND v(dout1_94) AT=1070.05n

.meas tran vdout1_95ck1060 FIND v(dout1_95) AT=1070.05n

.meas tran vdout1_96ck1060 FIND v(dout1_96) AT=1070.05n

.meas tran vdout1_97ck1060 FIND v(dout1_97) AT=1070.05n

.meas tran vdout1_98ck1060 FIND v(dout1_98) AT=1070.05n

.meas tran vdout1_99ck1060 FIND v(dout1_99) AT=1070.05n

.meas tran vdout1_100ck1060 FIND v(dout1_100) AT=1070.05n

.meas tran vdout1_101ck1060 FIND v(dout1_101) AT=1070.05n

.meas tran vdout1_102ck1060 FIND v(dout1_102) AT=1070.05n

.meas tran vdout1_103ck1060 FIND v(dout1_103) AT=1070.05n

.meas tran vdout1_104ck1060 FIND v(dout1_104) AT=1070.05n

.meas tran vdout1_105ck1060 FIND v(dout1_105) AT=1070.05n

.meas tran vdout1_106ck1060 FIND v(dout1_106) AT=1070.05n

.meas tran vdout1_107ck1060 FIND v(dout1_107) AT=1070.05n

.meas tran vdout1_108ck1060 FIND v(dout1_108) AT=1070.05n

.meas tran vdout1_109ck1060 FIND v(dout1_109) AT=1070.05n

.meas tran vdout1_110ck1060 FIND v(dout1_110) AT=1070.05n

.meas tran vdout1_111ck1060 FIND v(dout1_111) AT=1070.05n

.meas tran vdout1_112ck1060 FIND v(dout1_112) AT=1070.05n

.meas tran vdout1_113ck1060 FIND v(dout1_113) AT=1070.05n

.meas tran vdout1_114ck1060 FIND v(dout1_114) AT=1070.05n

.meas tran vdout1_115ck1060 FIND v(dout1_115) AT=1070.05n

.meas tran vdout1_116ck1060 FIND v(dout1_116) AT=1070.05n

.meas tran vdout1_117ck1060 FIND v(dout1_117) AT=1070.05n

.meas tran vdout1_118ck1060 FIND v(dout1_118) AT=1070.05n

.meas tran vdout1_119ck1060 FIND v(dout1_119) AT=1070.05n

.meas tran vdout1_120ck1060 FIND v(dout1_120) AT=1070.05n

.meas tran vdout1_121ck1060 FIND v(dout1_121) AT=1070.05n

.meas tran vdout1_122ck1060 FIND v(dout1_122) AT=1070.05n

.meas tran vdout1_123ck1060 FIND v(dout1_123) AT=1070.05n

.meas tran vdout1_124ck1060 FIND v(dout1_124) AT=1070.05n

.meas tran vdout1_125ck1060 FIND v(dout1_125) AT=1070.05n

.meas tran vdout1_126ck1060 FIND v(dout1_126) AT=1070.05n

.meas tran vdout1_127ck1060 FIND v(dout1_127) AT=1070.05n

.meas tran vdout1_128ck1060 FIND v(dout1_128) AT=1070.05n

.meas tran vdout1_129ck1060 FIND v(dout1_129) AT=1070.05n

.meas tran vdout1_130ck1060 FIND v(dout1_130) AT=1070.05n

.meas tran vdout1_131ck1060 FIND v(dout1_131) AT=1070.05n

.meas tran vdout1_132ck1060 FIND v(dout1_132) AT=1070.05n

.meas tran vdout1_133ck1060 FIND v(dout1_133) AT=1070.05n

.meas tran vdout1_134ck1060 FIND v(dout1_134) AT=1070.05n

.meas tran vdout1_135ck1060 FIND v(dout1_135) AT=1070.05n

.meas tran vdout1_136ck1060 FIND v(dout1_136) AT=1070.05n

.meas tran vdout1_137ck1060 FIND v(dout1_137) AT=1070.05n

.meas tran vdout1_138ck1060 FIND v(dout1_138) AT=1070.05n

.meas tran vdout1_139ck1060 FIND v(dout1_139) AT=1070.05n

.meas tran vdout1_140ck1060 FIND v(dout1_140) AT=1070.05n

.meas tran vdout1_141ck1060 FIND v(dout1_141) AT=1070.05n

.meas tran vdout1_142ck1060 FIND v(dout1_142) AT=1070.05n

.meas tran vdout1_143ck1060 FIND v(dout1_143) AT=1070.05n

.meas tran vdout1_144ck1060 FIND v(dout1_144) AT=1070.05n

.meas tran vdout1_145ck1060 FIND v(dout1_145) AT=1070.05n

.meas tran vdout1_146ck1060 FIND v(dout1_146) AT=1070.05n

.meas tran vdout1_147ck1060 FIND v(dout1_147) AT=1070.05n

.meas tran vdout1_148ck1060 FIND v(dout1_148) AT=1070.05n

.meas tran vdout1_149ck1060 FIND v(dout1_149) AT=1070.05n

.meas tran vdout1_150ck1060 FIND v(dout1_150) AT=1070.05n

.meas tran vdout1_151ck1060 FIND v(dout1_151) AT=1070.05n

.meas tran vdout1_152ck1060 FIND v(dout1_152) AT=1070.05n

.meas tran vdout1_153ck1060 FIND v(dout1_153) AT=1070.05n

.meas tran vdout1_154ck1060 FIND v(dout1_154) AT=1070.05n

.meas tran vdout1_155ck1060 FIND v(dout1_155) AT=1070.05n

.meas tran vdout1_156ck1060 FIND v(dout1_156) AT=1070.05n

.meas tran vdout1_157ck1060 FIND v(dout1_157) AT=1070.05n

.meas tran vdout1_158ck1060 FIND v(dout1_158) AT=1070.05n

.meas tran vdout1_159ck1060 FIND v(dout1_159) AT=1070.05n

.meas tran vdout1_160ck1060 FIND v(dout1_160) AT=1070.05n

.meas tran vdout1_161ck1060 FIND v(dout1_161) AT=1070.05n

.meas tran vdout1_162ck1060 FIND v(dout1_162) AT=1070.05n

.meas tran vdout1_163ck1060 FIND v(dout1_163) AT=1070.05n

.meas tran vdout1_164ck1060 FIND v(dout1_164) AT=1070.05n

.meas tran vdout1_165ck1060 FIND v(dout1_165) AT=1070.05n

.meas tran vdout1_166ck1060 FIND v(dout1_166) AT=1070.05n

.meas tran vdout1_167ck1060 FIND v(dout1_167) AT=1070.05n

.meas tran vdout1_168ck1060 FIND v(dout1_168) AT=1070.05n

.meas tran vdout1_169ck1060 FIND v(dout1_169) AT=1070.05n

.meas tran vdout1_170ck1060 FIND v(dout1_170) AT=1070.05n

.meas tran vdout1_171ck1060 FIND v(dout1_171) AT=1070.05n

.meas tran vdout1_172ck1060 FIND v(dout1_172) AT=1070.05n

.meas tran vdout1_173ck1060 FIND v(dout1_173) AT=1070.05n

.meas tran vdout1_174ck1060 FIND v(dout1_174) AT=1070.05n

.meas tran vdout1_175ck1060 FIND v(dout1_175) AT=1070.05n

.meas tran vdout1_176ck1060 FIND v(dout1_176) AT=1070.05n

.meas tran vdout1_177ck1060 FIND v(dout1_177) AT=1070.05n

.meas tran vdout1_178ck1060 FIND v(dout1_178) AT=1070.05n

.meas tran vdout1_179ck1060 FIND v(dout1_179) AT=1070.05n

.meas tran vdout1_180ck1060 FIND v(dout1_180) AT=1070.05n

.meas tran vdout1_181ck1060 FIND v(dout1_181) AT=1070.05n

.meas tran vdout1_182ck1060 FIND v(dout1_182) AT=1070.05n

.meas tran vdout1_183ck1060 FIND v(dout1_183) AT=1070.05n

.meas tran vdout1_184ck1060 FIND v(dout1_184) AT=1070.05n

.meas tran vdout1_185ck1060 FIND v(dout1_185) AT=1070.05n

.meas tran vdout1_186ck1060 FIND v(dout1_186) AT=1070.05n

.meas tran vdout1_187ck1060 FIND v(dout1_187) AT=1070.05n

.meas tran vdout1_188ck1060 FIND v(dout1_188) AT=1070.05n

.meas tran vdout1_189ck1060 FIND v(dout1_189) AT=1070.05n

.meas tran vdout1_190ck1060 FIND v(dout1_190) AT=1070.05n

.meas tran vdout1_191ck1060 FIND v(dout1_191) AT=1070.05n

.meas tran vdout1_192ck1060 FIND v(dout1_192) AT=1070.05n

.meas tran vdout1_193ck1060 FIND v(dout1_193) AT=1070.05n

.meas tran vdout1_194ck1060 FIND v(dout1_194) AT=1070.05n

.meas tran vdout1_195ck1060 FIND v(dout1_195) AT=1070.05n

.meas tran vdout1_196ck1060 FIND v(dout1_196) AT=1070.05n

.meas tran vdout1_197ck1060 FIND v(dout1_197) AT=1070.05n

.meas tran vdout1_198ck1060 FIND v(dout1_198) AT=1070.05n

.meas tran vdout1_199ck1060 FIND v(dout1_199) AT=1070.05n

.meas tran vdout1_200ck1060 FIND v(dout1_200) AT=1070.05n

.meas tran vdout1_201ck1060 FIND v(dout1_201) AT=1070.05n

.meas tran vdout1_202ck1060 FIND v(dout1_202) AT=1070.05n

.meas tran vdout1_203ck1060 FIND v(dout1_203) AT=1070.05n

.meas tran vdout1_204ck1060 FIND v(dout1_204) AT=1070.05n

.meas tran vdout1_205ck1060 FIND v(dout1_205) AT=1070.05n

.meas tran vdout1_206ck1060 FIND v(dout1_206) AT=1070.05n

.meas tran vdout1_207ck1060 FIND v(dout1_207) AT=1070.05n

.meas tran vdout1_208ck1060 FIND v(dout1_208) AT=1070.05n

.meas tran vdout1_209ck1060 FIND v(dout1_209) AT=1070.05n

.meas tran vdout1_210ck1060 FIND v(dout1_210) AT=1070.05n

.meas tran vdout1_211ck1060 FIND v(dout1_211) AT=1070.05n

.meas tran vdout1_212ck1060 FIND v(dout1_212) AT=1070.05n

.meas tran vdout1_213ck1060 FIND v(dout1_213) AT=1070.05n

.meas tran vdout1_214ck1060 FIND v(dout1_214) AT=1070.05n

.meas tran vdout1_215ck1060 FIND v(dout1_215) AT=1070.05n

.meas tran vdout1_216ck1060 FIND v(dout1_216) AT=1070.05n

.meas tran vdout1_217ck1060 FIND v(dout1_217) AT=1070.05n

.meas tran vdout1_218ck1060 FIND v(dout1_218) AT=1070.05n

.meas tran vdout1_219ck1060 FIND v(dout1_219) AT=1070.05n

.meas tran vdout1_220ck1060 FIND v(dout1_220) AT=1070.05n

.meas tran vdout1_221ck1060 FIND v(dout1_221) AT=1070.05n

.meas tran vdout1_222ck1060 FIND v(dout1_222) AT=1070.05n

.meas tran vdout1_223ck1060 FIND v(dout1_223) AT=1070.05n

.meas tran vdout1_224ck1060 FIND v(dout1_224) AT=1070.05n

.meas tran vdout1_225ck1060 FIND v(dout1_225) AT=1070.05n

.meas tran vdout1_226ck1060 FIND v(dout1_226) AT=1070.05n

.meas tran vdout1_227ck1060 FIND v(dout1_227) AT=1070.05n

.meas tran vdout1_228ck1060 FIND v(dout1_228) AT=1070.05n

.meas tran vdout1_229ck1060 FIND v(dout1_229) AT=1070.05n

.meas tran vdout1_230ck1060 FIND v(dout1_230) AT=1070.05n

.meas tran vdout1_231ck1060 FIND v(dout1_231) AT=1070.05n

.meas tran vdout1_232ck1060 FIND v(dout1_232) AT=1070.05n

.meas tran vdout1_233ck1060 FIND v(dout1_233) AT=1070.05n

.meas tran vdout1_234ck1060 FIND v(dout1_234) AT=1070.05n

.meas tran vdout1_235ck1060 FIND v(dout1_235) AT=1070.05n

.meas tran vdout1_236ck1060 FIND v(dout1_236) AT=1070.05n

.meas tran vdout1_237ck1060 FIND v(dout1_237) AT=1070.05n

.meas tran vdout1_238ck1060 FIND v(dout1_238) AT=1070.05n

.meas tran vdout1_239ck1060 FIND v(dout1_239) AT=1070.05n

.meas tran vdout1_240ck1060 FIND v(dout1_240) AT=1070.05n

.meas tran vdout1_241ck1060 FIND v(dout1_241) AT=1070.05n

.meas tran vdout1_242ck1060 FIND v(dout1_242) AT=1070.05n

.meas tran vdout1_243ck1060 FIND v(dout1_243) AT=1070.05n

.meas tran vdout1_244ck1060 FIND v(dout1_244) AT=1070.05n

.meas tran vdout1_245ck1060 FIND v(dout1_245) AT=1070.05n

.meas tran vdout1_246ck1060 FIND v(dout1_246) AT=1070.05n

.meas tran vdout1_247ck1060 FIND v(dout1_247) AT=1070.05n

.meas tran vdout1_248ck1060 FIND v(dout1_248) AT=1070.05n

.meas tran vdout1_249ck1060 FIND v(dout1_249) AT=1070.05n

.meas tran vdout1_250ck1060 FIND v(dout1_250) AT=1070.05n

.meas tran vdout1_251ck1060 FIND v(dout1_251) AT=1070.05n

.meas tran vdout1_252ck1060 FIND v(dout1_252) AT=1070.05n

.meas tran vdout1_253ck1060 FIND v(dout1_253) AT=1070.05n

.meas tran vdout1_254ck1060 FIND v(dout1_254) AT=1070.05n

.meas tran vdout1_255ck1060 FIND v(dout1_255) AT=1070.05n

.meas tran vdout1_256ck1060 FIND v(dout1_256) AT=1070.05n

.meas tran vdout1_0ck1080 FIND v(dout1_0) AT=1090.05n

.meas tran vdout1_1ck1080 FIND v(dout1_1) AT=1090.05n

.meas tran vdout1_2ck1080 FIND v(dout1_2) AT=1090.05n

.meas tran vdout1_3ck1080 FIND v(dout1_3) AT=1090.05n

.meas tran vdout1_4ck1080 FIND v(dout1_4) AT=1090.05n

.meas tran vdout1_5ck1080 FIND v(dout1_5) AT=1090.05n

.meas tran vdout1_6ck1080 FIND v(dout1_6) AT=1090.05n

.meas tran vdout1_7ck1080 FIND v(dout1_7) AT=1090.05n

.meas tran vdout1_8ck1080 FIND v(dout1_8) AT=1090.05n

.meas tran vdout1_9ck1080 FIND v(dout1_9) AT=1090.05n

.meas tran vdout1_10ck1080 FIND v(dout1_10) AT=1090.05n

.meas tran vdout1_11ck1080 FIND v(dout1_11) AT=1090.05n

.meas tran vdout1_12ck1080 FIND v(dout1_12) AT=1090.05n

.meas tran vdout1_13ck1080 FIND v(dout1_13) AT=1090.05n

.meas tran vdout1_14ck1080 FIND v(dout1_14) AT=1090.05n

.meas tran vdout1_15ck1080 FIND v(dout1_15) AT=1090.05n

.meas tran vdout1_16ck1080 FIND v(dout1_16) AT=1090.05n

.meas tran vdout1_17ck1080 FIND v(dout1_17) AT=1090.05n

.meas tran vdout1_18ck1080 FIND v(dout1_18) AT=1090.05n

.meas tran vdout1_19ck1080 FIND v(dout1_19) AT=1090.05n

.meas tran vdout1_20ck1080 FIND v(dout1_20) AT=1090.05n

.meas tran vdout1_21ck1080 FIND v(dout1_21) AT=1090.05n

.meas tran vdout1_22ck1080 FIND v(dout1_22) AT=1090.05n

.meas tran vdout1_23ck1080 FIND v(dout1_23) AT=1090.05n

.meas tran vdout1_24ck1080 FIND v(dout1_24) AT=1090.05n

.meas tran vdout1_25ck1080 FIND v(dout1_25) AT=1090.05n

.meas tran vdout1_26ck1080 FIND v(dout1_26) AT=1090.05n

.meas tran vdout1_27ck1080 FIND v(dout1_27) AT=1090.05n

.meas tran vdout1_28ck1080 FIND v(dout1_28) AT=1090.05n

.meas tran vdout1_29ck1080 FIND v(dout1_29) AT=1090.05n

.meas tran vdout1_30ck1080 FIND v(dout1_30) AT=1090.05n

.meas tran vdout1_31ck1080 FIND v(dout1_31) AT=1090.05n

.meas tran vdout1_32ck1080 FIND v(dout1_32) AT=1090.05n

.meas tran vdout1_33ck1080 FIND v(dout1_33) AT=1090.05n

.meas tran vdout1_34ck1080 FIND v(dout1_34) AT=1090.05n

.meas tran vdout1_35ck1080 FIND v(dout1_35) AT=1090.05n

.meas tran vdout1_36ck1080 FIND v(dout1_36) AT=1090.05n

.meas tran vdout1_37ck1080 FIND v(dout1_37) AT=1090.05n

.meas tran vdout1_38ck1080 FIND v(dout1_38) AT=1090.05n

.meas tran vdout1_39ck1080 FIND v(dout1_39) AT=1090.05n

.meas tran vdout1_40ck1080 FIND v(dout1_40) AT=1090.05n

.meas tran vdout1_41ck1080 FIND v(dout1_41) AT=1090.05n

.meas tran vdout1_42ck1080 FIND v(dout1_42) AT=1090.05n

.meas tran vdout1_43ck1080 FIND v(dout1_43) AT=1090.05n

.meas tran vdout1_44ck1080 FIND v(dout1_44) AT=1090.05n

.meas tran vdout1_45ck1080 FIND v(dout1_45) AT=1090.05n

.meas tran vdout1_46ck1080 FIND v(dout1_46) AT=1090.05n

.meas tran vdout1_47ck1080 FIND v(dout1_47) AT=1090.05n

.meas tran vdout1_48ck1080 FIND v(dout1_48) AT=1090.05n

.meas tran vdout1_49ck1080 FIND v(dout1_49) AT=1090.05n

.meas tran vdout1_50ck1080 FIND v(dout1_50) AT=1090.05n

.meas tran vdout1_51ck1080 FIND v(dout1_51) AT=1090.05n

.meas tran vdout1_52ck1080 FIND v(dout1_52) AT=1090.05n

.meas tran vdout1_53ck1080 FIND v(dout1_53) AT=1090.05n

.meas tran vdout1_54ck1080 FIND v(dout1_54) AT=1090.05n

.meas tran vdout1_55ck1080 FIND v(dout1_55) AT=1090.05n

.meas tran vdout1_56ck1080 FIND v(dout1_56) AT=1090.05n

.meas tran vdout1_57ck1080 FIND v(dout1_57) AT=1090.05n

.meas tran vdout1_58ck1080 FIND v(dout1_58) AT=1090.05n

.meas tran vdout1_59ck1080 FIND v(dout1_59) AT=1090.05n

.meas tran vdout1_60ck1080 FIND v(dout1_60) AT=1090.05n

.meas tran vdout1_61ck1080 FIND v(dout1_61) AT=1090.05n

.meas tran vdout1_62ck1080 FIND v(dout1_62) AT=1090.05n

.meas tran vdout1_63ck1080 FIND v(dout1_63) AT=1090.05n

.meas tran vdout1_64ck1080 FIND v(dout1_64) AT=1090.05n

.meas tran vdout1_65ck1080 FIND v(dout1_65) AT=1090.05n

.meas tran vdout1_66ck1080 FIND v(dout1_66) AT=1090.05n

.meas tran vdout1_67ck1080 FIND v(dout1_67) AT=1090.05n

.meas tran vdout1_68ck1080 FIND v(dout1_68) AT=1090.05n

.meas tran vdout1_69ck1080 FIND v(dout1_69) AT=1090.05n

.meas tran vdout1_70ck1080 FIND v(dout1_70) AT=1090.05n

.meas tran vdout1_71ck1080 FIND v(dout1_71) AT=1090.05n

.meas tran vdout1_72ck1080 FIND v(dout1_72) AT=1090.05n

.meas tran vdout1_73ck1080 FIND v(dout1_73) AT=1090.05n

.meas tran vdout1_74ck1080 FIND v(dout1_74) AT=1090.05n

.meas tran vdout1_75ck1080 FIND v(dout1_75) AT=1090.05n

.meas tran vdout1_76ck1080 FIND v(dout1_76) AT=1090.05n

.meas tran vdout1_77ck1080 FIND v(dout1_77) AT=1090.05n

.meas tran vdout1_78ck1080 FIND v(dout1_78) AT=1090.05n

.meas tran vdout1_79ck1080 FIND v(dout1_79) AT=1090.05n

.meas tran vdout1_80ck1080 FIND v(dout1_80) AT=1090.05n

.meas tran vdout1_81ck1080 FIND v(dout1_81) AT=1090.05n

.meas tran vdout1_82ck1080 FIND v(dout1_82) AT=1090.05n

.meas tran vdout1_83ck1080 FIND v(dout1_83) AT=1090.05n

.meas tran vdout1_84ck1080 FIND v(dout1_84) AT=1090.05n

.meas tran vdout1_85ck1080 FIND v(dout1_85) AT=1090.05n

.meas tran vdout1_86ck1080 FIND v(dout1_86) AT=1090.05n

.meas tran vdout1_87ck1080 FIND v(dout1_87) AT=1090.05n

.meas tran vdout1_88ck1080 FIND v(dout1_88) AT=1090.05n

.meas tran vdout1_89ck1080 FIND v(dout1_89) AT=1090.05n

.meas tran vdout1_90ck1080 FIND v(dout1_90) AT=1090.05n

.meas tran vdout1_91ck1080 FIND v(dout1_91) AT=1090.05n

.meas tran vdout1_92ck1080 FIND v(dout1_92) AT=1090.05n

.meas tran vdout1_93ck1080 FIND v(dout1_93) AT=1090.05n

.meas tran vdout1_94ck1080 FIND v(dout1_94) AT=1090.05n

.meas tran vdout1_95ck1080 FIND v(dout1_95) AT=1090.05n

.meas tran vdout1_96ck1080 FIND v(dout1_96) AT=1090.05n

.meas tran vdout1_97ck1080 FIND v(dout1_97) AT=1090.05n

.meas tran vdout1_98ck1080 FIND v(dout1_98) AT=1090.05n

.meas tran vdout1_99ck1080 FIND v(dout1_99) AT=1090.05n

.meas tran vdout1_100ck1080 FIND v(dout1_100) AT=1090.05n

.meas tran vdout1_101ck1080 FIND v(dout1_101) AT=1090.05n

.meas tran vdout1_102ck1080 FIND v(dout1_102) AT=1090.05n

.meas tran vdout1_103ck1080 FIND v(dout1_103) AT=1090.05n

.meas tran vdout1_104ck1080 FIND v(dout1_104) AT=1090.05n

.meas tran vdout1_105ck1080 FIND v(dout1_105) AT=1090.05n

.meas tran vdout1_106ck1080 FIND v(dout1_106) AT=1090.05n

.meas tran vdout1_107ck1080 FIND v(dout1_107) AT=1090.05n

.meas tran vdout1_108ck1080 FIND v(dout1_108) AT=1090.05n

.meas tran vdout1_109ck1080 FIND v(dout1_109) AT=1090.05n

.meas tran vdout1_110ck1080 FIND v(dout1_110) AT=1090.05n

.meas tran vdout1_111ck1080 FIND v(dout1_111) AT=1090.05n

.meas tran vdout1_112ck1080 FIND v(dout1_112) AT=1090.05n

.meas tran vdout1_113ck1080 FIND v(dout1_113) AT=1090.05n

.meas tran vdout1_114ck1080 FIND v(dout1_114) AT=1090.05n

.meas tran vdout1_115ck1080 FIND v(dout1_115) AT=1090.05n

.meas tran vdout1_116ck1080 FIND v(dout1_116) AT=1090.05n

.meas tran vdout1_117ck1080 FIND v(dout1_117) AT=1090.05n

.meas tran vdout1_118ck1080 FIND v(dout1_118) AT=1090.05n

.meas tran vdout1_119ck1080 FIND v(dout1_119) AT=1090.05n

.meas tran vdout1_120ck1080 FIND v(dout1_120) AT=1090.05n

.meas tran vdout1_121ck1080 FIND v(dout1_121) AT=1090.05n

.meas tran vdout1_122ck1080 FIND v(dout1_122) AT=1090.05n

.meas tran vdout1_123ck1080 FIND v(dout1_123) AT=1090.05n

.meas tran vdout1_124ck1080 FIND v(dout1_124) AT=1090.05n

.meas tran vdout1_125ck1080 FIND v(dout1_125) AT=1090.05n

.meas tran vdout1_126ck1080 FIND v(dout1_126) AT=1090.05n

.meas tran vdout1_127ck1080 FIND v(dout1_127) AT=1090.05n

.meas tran vdout1_128ck1080 FIND v(dout1_128) AT=1090.05n

.meas tran vdout1_129ck1080 FIND v(dout1_129) AT=1090.05n

.meas tran vdout1_130ck1080 FIND v(dout1_130) AT=1090.05n

.meas tran vdout1_131ck1080 FIND v(dout1_131) AT=1090.05n

.meas tran vdout1_132ck1080 FIND v(dout1_132) AT=1090.05n

.meas tran vdout1_133ck1080 FIND v(dout1_133) AT=1090.05n

.meas tran vdout1_134ck1080 FIND v(dout1_134) AT=1090.05n

.meas tran vdout1_135ck1080 FIND v(dout1_135) AT=1090.05n

.meas tran vdout1_136ck1080 FIND v(dout1_136) AT=1090.05n

.meas tran vdout1_137ck1080 FIND v(dout1_137) AT=1090.05n

.meas tran vdout1_138ck1080 FIND v(dout1_138) AT=1090.05n

.meas tran vdout1_139ck1080 FIND v(dout1_139) AT=1090.05n

.meas tran vdout1_140ck1080 FIND v(dout1_140) AT=1090.05n

.meas tran vdout1_141ck1080 FIND v(dout1_141) AT=1090.05n

.meas tran vdout1_142ck1080 FIND v(dout1_142) AT=1090.05n

.meas tran vdout1_143ck1080 FIND v(dout1_143) AT=1090.05n

.meas tran vdout1_144ck1080 FIND v(dout1_144) AT=1090.05n

.meas tran vdout1_145ck1080 FIND v(dout1_145) AT=1090.05n

.meas tran vdout1_146ck1080 FIND v(dout1_146) AT=1090.05n

.meas tran vdout1_147ck1080 FIND v(dout1_147) AT=1090.05n

.meas tran vdout1_148ck1080 FIND v(dout1_148) AT=1090.05n

.meas tran vdout1_149ck1080 FIND v(dout1_149) AT=1090.05n

.meas tran vdout1_150ck1080 FIND v(dout1_150) AT=1090.05n

.meas tran vdout1_151ck1080 FIND v(dout1_151) AT=1090.05n

.meas tran vdout1_152ck1080 FIND v(dout1_152) AT=1090.05n

.meas tran vdout1_153ck1080 FIND v(dout1_153) AT=1090.05n

.meas tran vdout1_154ck1080 FIND v(dout1_154) AT=1090.05n

.meas tran vdout1_155ck1080 FIND v(dout1_155) AT=1090.05n

.meas tran vdout1_156ck1080 FIND v(dout1_156) AT=1090.05n

.meas tran vdout1_157ck1080 FIND v(dout1_157) AT=1090.05n

.meas tran vdout1_158ck1080 FIND v(dout1_158) AT=1090.05n

.meas tran vdout1_159ck1080 FIND v(dout1_159) AT=1090.05n

.meas tran vdout1_160ck1080 FIND v(dout1_160) AT=1090.05n

.meas tran vdout1_161ck1080 FIND v(dout1_161) AT=1090.05n

.meas tran vdout1_162ck1080 FIND v(dout1_162) AT=1090.05n

.meas tran vdout1_163ck1080 FIND v(dout1_163) AT=1090.05n

.meas tran vdout1_164ck1080 FIND v(dout1_164) AT=1090.05n

.meas tran vdout1_165ck1080 FIND v(dout1_165) AT=1090.05n

.meas tran vdout1_166ck1080 FIND v(dout1_166) AT=1090.05n

.meas tran vdout1_167ck1080 FIND v(dout1_167) AT=1090.05n

.meas tran vdout1_168ck1080 FIND v(dout1_168) AT=1090.05n

.meas tran vdout1_169ck1080 FIND v(dout1_169) AT=1090.05n

.meas tran vdout1_170ck1080 FIND v(dout1_170) AT=1090.05n

.meas tran vdout1_171ck1080 FIND v(dout1_171) AT=1090.05n

.meas tran vdout1_172ck1080 FIND v(dout1_172) AT=1090.05n

.meas tran vdout1_173ck1080 FIND v(dout1_173) AT=1090.05n

.meas tran vdout1_174ck1080 FIND v(dout1_174) AT=1090.05n

.meas tran vdout1_175ck1080 FIND v(dout1_175) AT=1090.05n

.meas tran vdout1_176ck1080 FIND v(dout1_176) AT=1090.05n

.meas tran vdout1_177ck1080 FIND v(dout1_177) AT=1090.05n

.meas tran vdout1_178ck1080 FIND v(dout1_178) AT=1090.05n

.meas tran vdout1_179ck1080 FIND v(dout1_179) AT=1090.05n

.meas tran vdout1_180ck1080 FIND v(dout1_180) AT=1090.05n

.meas tran vdout1_181ck1080 FIND v(dout1_181) AT=1090.05n

.meas tran vdout1_182ck1080 FIND v(dout1_182) AT=1090.05n

.meas tran vdout1_183ck1080 FIND v(dout1_183) AT=1090.05n

.meas tran vdout1_184ck1080 FIND v(dout1_184) AT=1090.05n

.meas tran vdout1_185ck1080 FIND v(dout1_185) AT=1090.05n

.meas tran vdout1_186ck1080 FIND v(dout1_186) AT=1090.05n

.meas tran vdout1_187ck1080 FIND v(dout1_187) AT=1090.05n

.meas tran vdout1_188ck1080 FIND v(dout1_188) AT=1090.05n

.meas tran vdout1_189ck1080 FIND v(dout1_189) AT=1090.05n

.meas tran vdout1_190ck1080 FIND v(dout1_190) AT=1090.05n

.meas tran vdout1_191ck1080 FIND v(dout1_191) AT=1090.05n

.meas tran vdout1_192ck1080 FIND v(dout1_192) AT=1090.05n

.meas tran vdout1_193ck1080 FIND v(dout1_193) AT=1090.05n

.meas tran vdout1_194ck1080 FIND v(dout1_194) AT=1090.05n

.meas tran vdout1_195ck1080 FIND v(dout1_195) AT=1090.05n

.meas tran vdout1_196ck1080 FIND v(dout1_196) AT=1090.05n

.meas tran vdout1_197ck1080 FIND v(dout1_197) AT=1090.05n

.meas tran vdout1_198ck1080 FIND v(dout1_198) AT=1090.05n

.meas tran vdout1_199ck1080 FIND v(dout1_199) AT=1090.05n

.meas tran vdout1_200ck1080 FIND v(dout1_200) AT=1090.05n

.meas tran vdout1_201ck1080 FIND v(dout1_201) AT=1090.05n

.meas tran vdout1_202ck1080 FIND v(dout1_202) AT=1090.05n

.meas tran vdout1_203ck1080 FIND v(dout1_203) AT=1090.05n

.meas tran vdout1_204ck1080 FIND v(dout1_204) AT=1090.05n

.meas tran vdout1_205ck1080 FIND v(dout1_205) AT=1090.05n

.meas tran vdout1_206ck1080 FIND v(dout1_206) AT=1090.05n

.meas tran vdout1_207ck1080 FIND v(dout1_207) AT=1090.05n

.meas tran vdout1_208ck1080 FIND v(dout1_208) AT=1090.05n

.meas tran vdout1_209ck1080 FIND v(dout1_209) AT=1090.05n

.meas tran vdout1_210ck1080 FIND v(dout1_210) AT=1090.05n

.meas tran vdout1_211ck1080 FIND v(dout1_211) AT=1090.05n

.meas tran vdout1_212ck1080 FIND v(dout1_212) AT=1090.05n

.meas tran vdout1_213ck1080 FIND v(dout1_213) AT=1090.05n

.meas tran vdout1_214ck1080 FIND v(dout1_214) AT=1090.05n

.meas tran vdout1_215ck1080 FIND v(dout1_215) AT=1090.05n

.meas tran vdout1_216ck1080 FIND v(dout1_216) AT=1090.05n

.meas tran vdout1_217ck1080 FIND v(dout1_217) AT=1090.05n

.meas tran vdout1_218ck1080 FIND v(dout1_218) AT=1090.05n

.meas tran vdout1_219ck1080 FIND v(dout1_219) AT=1090.05n

.meas tran vdout1_220ck1080 FIND v(dout1_220) AT=1090.05n

.meas tran vdout1_221ck1080 FIND v(dout1_221) AT=1090.05n

.meas tran vdout1_222ck1080 FIND v(dout1_222) AT=1090.05n

.meas tran vdout1_223ck1080 FIND v(dout1_223) AT=1090.05n

.meas tran vdout1_224ck1080 FIND v(dout1_224) AT=1090.05n

.meas tran vdout1_225ck1080 FIND v(dout1_225) AT=1090.05n

.meas tran vdout1_226ck1080 FIND v(dout1_226) AT=1090.05n

.meas tran vdout1_227ck1080 FIND v(dout1_227) AT=1090.05n

.meas tran vdout1_228ck1080 FIND v(dout1_228) AT=1090.05n

.meas tran vdout1_229ck1080 FIND v(dout1_229) AT=1090.05n

.meas tran vdout1_230ck1080 FIND v(dout1_230) AT=1090.05n

.meas tran vdout1_231ck1080 FIND v(dout1_231) AT=1090.05n

.meas tran vdout1_232ck1080 FIND v(dout1_232) AT=1090.05n

.meas tran vdout1_233ck1080 FIND v(dout1_233) AT=1090.05n

.meas tran vdout1_234ck1080 FIND v(dout1_234) AT=1090.05n

.meas tran vdout1_235ck1080 FIND v(dout1_235) AT=1090.05n

.meas tran vdout1_236ck1080 FIND v(dout1_236) AT=1090.05n

.meas tran vdout1_237ck1080 FIND v(dout1_237) AT=1090.05n

.meas tran vdout1_238ck1080 FIND v(dout1_238) AT=1090.05n

.meas tran vdout1_239ck1080 FIND v(dout1_239) AT=1090.05n

.meas tran vdout1_240ck1080 FIND v(dout1_240) AT=1090.05n

.meas tran vdout1_241ck1080 FIND v(dout1_241) AT=1090.05n

.meas tran vdout1_242ck1080 FIND v(dout1_242) AT=1090.05n

.meas tran vdout1_243ck1080 FIND v(dout1_243) AT=1090.05n

.meas tran vdout1_244ck1080 FIND v(dout1_244) AT=1090.05n

.meas tran vdout1_245ck1080 FIND v(dout1_245) AT=1090.05n

.meas tran vdout1_246ck1080 FIND v(dout1_246) AT=1090.05n

.meas tran vdout1_247ck1080 FIND v(dout1_247) AT=1090.05n

.meas tran vdout1_248ck1080 FIND v(dout1_248) AT=1090.05n

.meas tran vdout1_249ck1080 FIND v(dout1_249) AT=1090.05n

.meas tran vdout1_250ck1080 FIND v(dout1_250) AT=1090.05n

.meas tran vdout1_251ck1080 FIND v(dout1_251) AT=1090.05n

.meas tran vdout1_252ck1080 FIND v(dout1_252) AT=1090.05n

.meas tran vdout1_253ck1080 FIND v(dout1_253) AT=1090.05n

.meas tran vdout1_254ck1080 FIND v(dout1_254) AT=1090.05n

.meas tran vdout1_255ck1080 FIND v(dout1_255) AT=1090.05n

.meas tran vdout1_256ck1080 FIND v(dout1_256) AT=1090.05n

.meas tran vdout1_0ck1090 FIND v(dout1_0) AT=1100.05n

.meas tran vdout1_1ck1090 FIND v(dout1_1) AT=1100.05n

.meas tran vdout1_2ck1090 FIND v(dout1_2) AT=1100.05n

.meas tran vdout1_3ck1090 FIND v(dout1_3) AT=1100.05n

.meas tran vdout1_4ck1090 FIND v(dout1_4) AT=1100.05n

.meas tran vdout1_5ck1090 FIND v(dout1_5) AT=1100.05n

.meas tran vdout1_6ck1090 FIND v(dout1_6) AT=1100.05n

.meas tran vdout1_7ck1090 FIND v(dout1_7) AT=1100.05n

.meas tran vdout1_8ck1090 FIND v(dout1_8) AT=1100.05n

.meas tran vdout1_9ck1090 FIND v(dout1_9) AT=1100.05n

.meas tran vdout1_10ck1090 FIND v(dout1_10) AT=1100.05n

.meas tran vdout1_11ck1090 FIND v(dout1_11) AT=1100.05n

.meas tran vdout1_12ck1090 FIND v(dout1_12) AT=1100.05n

.meas tran vdout1_13ck1090 FIND v(dout1_13) AT=1100.05n

.meas tran vdout1_14ck1090 FIND v(dout1_14) AT=1100.05n

.meas tran vdout1_15ck1090 FIND v(dout1_15) AT=1100.05n

.meas tran vdout1_16ck1090 FIND v(dout1_16) AT=1100.05n

.meas tran vdout1_17ck1090 FIND v(dout1_17) AT=1100.05n

.meas tran vdout1_18ck1090 FIND v(dout1_18) AT=1100.05n

.meas tran vdout1_19ck1090 FIND v(dout1_19) AT=1100.05n

.meas tran vdout1_20ck1090 FIND v(dout1_20) AT=1100.05n

.meas tran vdout1_21ck1090 FIND v(dout1_21) AT=1100.05n

.meas tran vdout1_22ck1090 FIND v(dout1_22) AT=1100.05n

.meas tran vdout1_23ck1090 FIND v(dout1_23) AT=1100.05n

.meas tran vdout1_24ck1090 FIND v(dout1_24) AT=1100.05n

.meas tran vdout1_25ck1090 FIND v(dout1_25) AT=1100.05n

.meas tran vdout1_26ck1090 FIND v(dout1_26) AT=1100.05n

.meas tran vdout1_27ck1090 FIND v(dout1_27) AT=1100.05n

.meas tran vdout1_28ck1090 FIND v(dout1_28) AT=1100.05n

.meas tran vdout1_29ck1090 FIND v(dout1_29) AT=1100.05n

.meas tran vdout1_30ck1090 FIND v(dout1_30) AT=1100.05n

.meas tran vdout1_31ck1090 FIND v(dout1_31) AT=1100.05n

.meas tran vdout1_32ck1090 FIND v(dout1_32) AT=1100.05n

.meas tran vdout1_33ck1090 FIND v(dout1_33) AT=1100.05n

.meas tran vdout1_34ck1090 FIND v(dout1_34) AT=1100.05n

.meas tran vdout1_35ck1090 FIND v(dout1_35) AT=1100.05n

.meas tran vdout1_36ck1090 FIND v(dout1_36) AT=1100.05n

.meas tran vdout1_37ck1090 FIND v(dout1_37) AT=1100.05n

.meas tran vdout1_38ck1090 FIND v(dout1_38) AT=1100.05n

.meas tran vdout1_39ck1090 FIND v(dout1_39) AT=1100.05n

.meas tran vdout1_40ck1090 FIND v(dout1_40) AT=1100.05n

.meas tran vdout1_41ck1090 FIND v(dout1_41) AT=1100.05n

.meas tran vdout1_42ck1090 FIND v(dout1_42) AT=1100.05n

.meas tran vdout1_43ck1090 FIND v(dout1_43) AT=1100.05n

.meas tran vdout1_44ck1090 FIND v(dout1_44) AT=1100.05n

.meas tran vdout1_45ck1090 FIND v(dout1_45) AT=1100.05n

.meas tran vdout1_46ck1090 FIND v(dout1_46) AT=1100.05n

.meas tran vdout1_47ck1090 FIND v(dout1_47) AT=1100.05n

.meas tran vdout1_48ck1090 FIND v(dout1_48) AT=1100.05n

.meas tran vdout1_49ck1090 FIND v(dout1_49) AT=1100.05n

.meas tran vdout1_50ck1090 FIND v(dout1_50) AT=1100.05n

.meas tran vdout1_51ck1090 FIND v(dout1_51) AT=1100.05n

.meas tran vdout1_52ck1090 FIND v(dout1_52) AT=1100.05n

.meas tran vdout1_53ck1090 FIND v(dout1_53) AT=1100.05n

.meas tran vdout1_54ck1090 FIND v(dout1_54) AT=1100.05n

.meas tran vdout1_55ck1090 FIND v(dout1_55) AT=1100.05n

.meas tran vdout1_56ck1090 FIND v(dout1_56) AT=1100.05n

.meas tran vdout1_57ck1090 FIND v(dout1_57) AT=1100.05n

.meas tran vdout1_58ck1090 FIND v(dout1_58) AT=1100.05n

.meas tran vdout1_59ck1090 FIND v(dout1_59) AT=1100.05n

.meas tran vdout1_60ck1090 FIND v(dout1_60) AT=1100.05n

.meas tran vdout1_61ck1090 FIND v(dout1_61) AT=1100.05n

.meas tran vdout1_62ck1090 FIND v(dout1_62) AT=1100.05n

.meas tran vdout1_63ck1090 FIND v(dout1_63) AT=1100.05n

.meas tran vdout1_64ck1090 FIND v(dout1_64) AT=1100.05n

.meas tran vdout1_65ck1090 FIND v(dout1_65) AT=1100.05n

.meas tran vdout1_66ck1090 FIND v(dout1_66) AT=1100.05n

.meas tran vdout1_67ck1090 FIND v(dout1_67) AT=1100.05n

.meas tran vdout1_68ck1090 FIND v(dout1_68) AT=1100.05n

.meas tran vdout1_69ck1090 FIND v(dout1_69) AT=1100.05n

.meas tran vdout1_70ck1090 FIND v(dout1_70) AT=1100.05n

.meas tran vdout1_71ck1090 FIND v(dout1_71) AT=1100.05n

.meas tran vdout1_72ck1090 FIND v(dout1_72) AT=1100.05n

.meas tran vdout1_73ck1090 FIND v(dout1_73) AT=1100.05n

.meas tran vdout1_74ck1090 FIND v(dout1_74) AT=1100.05n

.meas tran vdout1_75ck1090 FIND v(dout1_75) AT=1100.05n

.meas tran vdout1_76ck1090 FIND v(dout1_76) AT=1100.05n

.meas tran vdout1_77ck1090 FIND v(dout1_77) AT=1100.05n

.meas tran vdout1_78ck1090 FIND v(dout1_78) AT=1100.05n

.meas tran vdout1_79ck1090 FIND v(dout1_79) AT=1100.05n

.meas tran vdout1_80ck1090 FIND v(dout1_80) AT=1100.05n

.meas tran vdout1_81ck1090 FIND v(dout1_81) AT=1100.05n

.meas tran vdout1_82ck1090 FIND v(dout1_82) AT=1100.05n

.meas tran vdout1_83ck1090 FIND v(dout1_83) AT=1100.05n

.meas tran vdout1_84ck1090 FIND v(dout1_84) AT=1100.05n

.meas tran vdout1_85ck1090 FIND v(dout1_85) AT=1100.05n

.meas tran vdout1_86ck1090 FIND v(dout1_86) AT=1100.05n

.meas tran vdout1_87ck1090 FIND v(dout1_87) AT=1100.05n

.meas tran vdout1_88ck1090 FIND v(dout1_88) AT=1100.05n

.meas tran vdout1_89ck1090 FIND v(dout1_89) AT=1100.05n

.meas tran vdout1_90ck1090 FIND v(dout1_90) AT=1100.05n

.meas tran vdout1_91ck1090 FIND v(dout1_91) AT=1100.05n

.meas tran vdout1_92ck1090 FIND v(dout1_92) AT=1100.05n

.meas tran vdout1_93ck1090 FIND v(dout1_93) AT=1100.05n

.meas tran vdout1_94ck1090 FIND v(dout1_94) AT=1100.05n

.meas tran vdout1_95ck1090 FIND v(dout1_95) AT=1100.05n

.meas tran vdout1_96ck1090 FIND v(dout1_96) AT=1100.05n

.meas tran vdout1_97ck1090 FIND v(dout1_97) AT=1100.05n

.meas tran vdout1_98ck1090 FIND v(dout1_98) AT=1100.05n

.meas tran vdout1_99ck1090 FIND v(dout1_99) AT=1100.05n

.meas tran vdout1_100ck1090 FIND v(dout1_100) AT=1100.05n

.meas tran vdout1_101ck1090 FIND v(dout1_101) AT=1100.05n

.meas tran vdout1_102ck1090 FIND v(dout1_102) AT=1100.05n

.meas tran vdout1_103ck1090 FIND v(dout1_103) AT=1100.05n

.meas tran vdout1_104ck1090 FIND v(dout1_104) AT=1100.05n

.meas tran vdout1_105ck1090 FIND v(dout1_105) AT=1100.05n

.meas tran vdout1_106ck1090 FIND v(dout1_106) AT=1100.05n

.meas tran vdout1_107ck1090 FIND v(dout1_107) AT=1100.05n

.meas tran vdout1_108ck1090 FIND v(dout1_108) AT=1100.05n

.meas tran vdout1_109ck1090 FIND v(dout1_109) AT=1100.05n

.meas tran vdout1_110ck1090 FIND v(dout1_110) AT=1100.05n

.meas tran vdout1_111ck1090 FIND v(dout1_111) AT=1100.05n

.meas tran vdout1_112ck1090 FIND v(dout1_112) AT=1100.05n

.meas tran vdout1_113ck1090 FIND v(dout1_113) AT=1100.05n

.meas tran vdout1_114ck1090 FIND v(dout1_114) AT=1100.05n

.meas tran vdout1_115ck1090 FIND v(dout1_115) AT=1100.05n

.meas tran vdout1_116ck1090 FIND v(dout1_116) AT=1100.05n

.meas tran vdout1_117ck1090 FIND v(dout1_117) AT=1100.05n

.meas tran vdout1_118ck1090 FIND v(dout1_118) AT=1100.05n

.meas tran vdout1_119ck1090 FIND v(dout1_119) AT=1100.05n

.meas tran vdout1_120ck1090 FIND v(dout1_120) AT=1100.05n

.meas tran vdout1_121ck1090 FIND v(dout1_121) AT=1100.05n

.meas tran vdout1_122ck1090 FIND v(dout1_122) AT=1100.05n

.meas tran vdout1_123ck1090 FIND v(dout1_123) AT=1100.05n

.meas tran vdout1_124ck1090 FIND v(dout1_124) AT=1100.05n

.meas tran vdout1_125ck1090 FIND v(dout1_125) AT=1100.05n

.meas tran vdout1_126ck1090 FIND v(dout1_126) AT=1100.05n

.meas tran vdout1_127ck1090 FIND v(dout1_127) AT=1100.05n

.meas tran vdout1_128ck1090 FIND v(dout1_128) AT=1100.05n

.meas tran vdout1_129ck1090 FIND v(dout1_129) AT=1100.05n

.meas tran vdout1_130ck1090 FIND v(dout1_130) AT=1100.05n

.meas tran vdout1_131ck1090 FIND v(dout1_131) AT=1100.05n

.meas tran vdout1_132ck1090 FIND v(dout1_132) AT=1100.05n

.meas tran vdout1_133ck1090 FIND v(dout1_133) AT=1100.05n

.meas tran vdout1_134ck1090 FIND v(dout1_134) AT=1100.05n

.meas tran vdout1_135ck1090 FIND v(dout1_135) AT=1100.05n

.meas tran vdout1_136ck1090 FIND v(dout1_136) AT=1100.05n

.meas tran vdout1_137ck1090 FIND v(dout1_137) AT=1100.05n

.meas tran vdout1_138ck1090 FIND v(dout1_138) AT=1100.05n

.meas tran vdout1_139ck1090 FIND v(dout1_139) AT=1100.05n

.meas tran vdout1_140ck1090 FIND v(dout1_140) AT=1100.05n

.meas tran vdout1_141ck1090 FIND v(dout1_141) AT=1100.05n

.meas tran vdout1_142ck1090 FIND v(dout1_142) AT=1100.05n

.meas tran vdout1_143ck1090 FIND v(dout1_143) AT=1100.05n

.meas tran vdout1_144ck1090 FIND v(dout1_144) AT=1100.05n

.meas tran vdout1_145ck1090 FIND v(dout1_145) AT=1100.05n

.meas tran vdout1_146ck1090 FIND v(dout1_146) AT=1100.05n

.meas tran vdout1_147ck1090 FIND v(dout1_147) AT=1100.05n

.meas tran vdout1_148ck1090 FIND v(dout1_148) AT=1100.05n

.meas tran vdout1_149ck1090 FIND v(dout1_149) AT=1100.05n

.meas tran vdout1_150ck1090 FIND v(dout1_150) AT=1100.05n

.meas tran vdout1_151ck1090 FIND v(dout1_151) AT=1100.05n

.meas tran vdout1_152ck1090 FIND v(dout1_152) AT=1100.05n

.meas tran vdout1_153ck1090 FIND v(dout1_153) AT=1100.05n

.meas tran vdout1_154ck1090 FIND v(dout1_154) AT=1100.05n

.meas tran vdout1_155ck1090 FIND v(dout1_155) AT=1100.05n

.meas tran vdout1_156ck1090 FIND v(dout1_156) AT=1100.05n

.meas tran vdout1_157ck1090 FIND v(dout1_157) AT=1100.05n

.meas tran vdout1_158ck1090 FIND v(dout1_158) AT=1100.05n

.meas tran vdout1_159ck1090 FIND v(dout1_159) AT=1100.05n

.meas tran vdout1_160ck1090 FIND v(dout1_160) AT=1100.05n

.meas tran vdout1_161ck1090 FIND v(dout1_161) AT=1100.05n

.meas tran vdout1_162ck1090 FIND v(dout1_162) AT=1100.05n

.meas tran vdout1_163ck1090 FIND v(dout1_163) AT=1100.05n

.meas tran vdout1_164ck1090 FIND v(dout1_164) AT=1100.05n

.meas tran vdout1_165ck1090 FIND v(dout1_165) AT=1100.05n

.meas tran vdout1_166ck1090 FIND v(dout1_166) AT=1100.05n

.meas tran vdout1_167ck1090 FIND v(dout1_167) AT=1100.05n

.meas tran vdout1_168ck1090 FIND v(dout1_168) AT=1100.05n

.meas tran vdout1_169ck1090 FIND v(dout1_169) AT=1100.05n

.meas tran vdout1_170ck1090 FIND v(dout1_170) AT=1100.05n

.meas tran vdout1_171ck1090 FIND v(dout1_171) AT=1100.05n

.meas tran vdout1_172ck1090 FIND v(dout1_172) AT=1100.05n

.meas tran vdout1_173ck1090 FIND v(dout1_173) AT=1100.05n

.meas tran vdout1_174ck1090 FIND v(dout1_174) AT=1100.05n

.meas tran vdout1_175ck1090 FIND v(dout1_175) AT=1100.05n

.meas tran vdout1_176ck1090 FIND v(dout1_176) AT=1100.05n

.meas tran vdout1_177ck1090 FIND v(dout1_177) AT=1100.05n

.meas tran vdout1_178ck1090 FIND v(dout1_178) AT=1100.05n

.meas tran vdout1_179ck1090 FIND v(dout1_179) AT=1100.05n

.meas tran vdout1_180ck1090 FIND v(dout1_180) AT=1100.05n

.meas tran vdout1_181ck1090 FIND v(dout1_181) AT=1100.05n

.meas tran vdout1_182ck1090 FIND v(dout1_182) AT=1100.05n

.meas tran vdout1_183ck1090 FIND v(dout1_183) AT=1100.05n

.meas tran vdout1_184ck1090 FIND v(dout1_184) AT=1100.05n

.meas tran vdout1_185ck1090 FIND v(dout1_185) AT=1100.05n

.meas tran vdout1_186ck1090 FIND v(dout1_186) AT=1100.05n

.meas tran vdout1_187ck1090 FIND v(dout1_187) AT=1100.05n

.meas tran vdout1_188ck1090 FIND v(dout1_188) AT=1100.05n

.meas tran vdout1_189ck1090 FIND v(dout1_189) AT=1100.05n

.meas tran vdout1_190ck1090 FIND v(dout1_190) AT=1100.05n

.meas tran vdout1_191ck1090 FIND v(dout1_191) AT=1100.05n

.meas tran vdout1_192ck1090 FIND v(dout1_192) AT=1100.05n

.meas tran vdout1_193ck1090 FIND v(dout1_193) AT=1100.05n

.meas tran vdout1_194ck1090 FIND v(dout1_194) AT=1100.05n

.meas tran vdout1_195ck1090 FIND v(dout1_195) AT=1100.05n

.meas tran vdout1_196ck1090 FIND v(dout1_196) AT=1100.05n

.meas tran vdout1_197ck1090 FIND v(dout1_197) AT=1100.05n

.meas tran vdout1_198ck1090 FIND v(dout1_198) AT=1100.05n

.meas tran vdout1_199ck1090 FIND v(dout1_199) AT=1100.05n

.meas tran vdout1_200ck1090 FIND v(dout1_200) AT=1100.05n

.meas tran vdout1_201ck1090 FIND v(dout1_201) AT=1100.05n

.meas tran vdout1_202ck1090 FIND v(dout1_202) AT=1100.05n

.meas tran vdout1_203ck1090 FIND v(dout1_203) AT=1100.05n

.meas tran vdout1_204ck1090 FIND v(dout1_204) AT=1100.05n

.meas tran vdout1_205ck1090 FIND v(dout1_205) AT=1100.05n

.meas tran vdout1_206ck1090 FIND v(dout1_206) AT=1100.05n

.meas tran vdout1_207ck1090 FIND v(dout1_207) AT=1100.05n

.meas tran vdout1_208ck1090 FIND v(dout1_208) AT=1100.05n

.meas tran vdout1_209ck1090 FIND v(dout1_209) AT=1100.05n

.meas tran vdout1_210ck1090 FIND v(dout1_210) AT=1100.05n

.meas tran vdout1_211ck1090 FIND v(dout1_211) AT=1100.05n

.meas tran vdout1_212ck1090 FIND v(dout1_212) AT=1100.05n

.meas tran vdout1_213ck1090 FIND v(dout1_213) AT=1100.05n

.meas tran vdout1_214ck1090 FIND v(dout1_214) AT=1100.05n

.meas tran vdout1_215ck1090 FIND v(dout1_215) AT=1100.05n

.meas tran vdout1_216ck1090 FIND v(dout1_216) AT=1100.05n

.meas tran vdout1_217ck1090 FIND v(dout1_217) AT=1100.05n

.meas tran vdout1_218ck1090 FIND v(dout1_218) AT=1100.05n

.meas tran vdout1_219ck1090 FIND v(dout1_219) AT=1100.05n

.meas tran vdout1_220ck1090 FIND v(dout1_220) AT=1100.05n

.meas tran vdout1_221ck1090 FIND v(dout1_221) AT=1100.05n

.meas tran vdout1_222ck1090 FIND v(dout1_222) AT=1100.05n

.meas tran vdout1_223ck1090 FIND v(dout1_223) AT=1100.05n

.meas tran vdout1_224ck1090 FIND v(dout1_224) AT=1100.05n

.meas tran vdout1_225ck1090 FIND v(dout1_225) AT=1100.05n

.meas tran vdout1_226ck1090 FIND v(dout1_226) AT=1100.05n

.meas tran vdout1_227ck1090 FIND v(dout1_227) AT=1100.05n

.meas tran vdout1_228ck1090 FIND v(dout1_228) AT=1100.05n

.meas tran vdout1_229ck1090 FIND v(dout1_229) AT=1100.05n

.meas tran vdout1_230ck1090 FIND v(dout1_230) AT=1100.05n

.meas tran vdout1_231ck1090 FIND v(dout1_231) AT=1100.05n

.meas tran vdout1_232ck1090 FIND v(dout1_232) AT=1100.05n

.meas tran vdout1_233ck1090 FIND v(dout1_233) AT=1100.05n

.meas tran vdout1_234ck1090 FIND v(dout1_234) AT=1100.05n

.meas tran vdout1_235ck1090 FIND v(dout1_235) AT=1100.05n

.meas tran vdout1_236ck1090 FIND v(dout1_236) AT=1100.05n

.meas tran vdout1_237ck1090 FIND v(dout1_237) AT=1100.05n

.meas tran vdout1_238ck1090 FIND v(dout1_238) AT=1100.05n

.meas tran vdout1_239ck1090 FIND v(dout1_239) AT=1100.05n

.meas tran vdout1_240ck1090 FIND v(dout1_240) AT=1100.05n

.meas tran vdout1_241ck1090 FIND v(dout1_241) AT=1100.05n

.meas tran vdout1_242ck1090 FIND v(dout1_242) AT=1100.05n

.meas tran vdout1_243ck1090 FIND v(dout1_243) AT=1100.05n

.meas tran vdout1_244ck1090 FIND v(dout1_244) AT=1100.05n

.meas tran vdout1_245ck1090 FIND v(dout1_245) AT=1100.05n

.meas tran vdout1_246ck1090 FIND v(dout1_246) AT=1100.05n

.meas tran vdout1_247ck1090 FIND v(dout1_247) AT=1100.05n

.meas tran vdout1_248ck1090 FIND v(dout1_248) AT=1100.05n

.meas tran vdout1_249ck1090 FIND v(dout1_249) AT=1100.05n

.meas tran vdout1_250ck1090 FIND v(dout1_250) AT=1100.05n

.meas tran vdout1_251ck1090 FIND v(dout1_251) AT=1100.05n

.meas tran vdout1_252ck1090 FIND v(dout1_252) AT=1100.05n

.meas tran vdout1_253ck1090 FIND v(dout1_253) AT=1100.05n

.meas tran vdout1_254ck1090 FIND v(dout1_254) AT=1100.05n

.meas tran vdout1_255ck1090 FIND v(dout1_255) AT=1100.05n

.meas tran vdout1_256ck1090 FIND v(dout1_256) AT=1100.05n

.meas tran vdout1_0ck1100 FIND v(dout1_0) AT=1110.05n

.meas tran vdout1_1ck1100 FIND v(dout1_1) AT=1110.05n

.meas tran vdout1_2ck1100 FIND v(dout1_2) AT=1110.05n

.meas tran vdout1_3ck1100 FIND v(dout1_3) AT=1110.05n

.meas tran vdout1_4ck1100 FIND v(dout1_4) AT=1110.05n

.meas tran vdout1_5ck1100 FIND v(dout1_5) AT=1110.05n

.meas tran vdout1_6ck1100 FIND v(dout1_6) AT=1110.05n

.meas tran vdout1_7ck1100 FIND v(dout1_7) AT=1110.05n

.meas tran vdout1_8ck1100 FIND v(dout1_8) AT=1110.05n

.meas tran vdout1_9ck1100 FIND v(dout1_9) AT=1110.05n

.meas tran vdout1_10ck1100 FIND v(dout1_10) AT=1110.05n

.meas tran vdout1_11ck1100 FIND v(dout1_11) AT=1110.05n

.meas tran vdout1_12ck1100 FIND v(dout1_12) AT=1110.05n

.meas tran vdout1_13ck1100 FIND v(dout1_13) AT=1110.05n

.meas tran vdout1_14ck1100 FIND v(dout1_14) AT=1110.05n

.meas tran vdout1_15ck1100 FIND v(dout1_15) AT=1110.05n

.meas tran vdout1_16ck1100 FIND v(dout1_16) AT=1110.05n

.meas tran vdout1_17ck1100 FIND v(dout1_17) AT=1110.05n

.meas tran vdout1_18ck1100 FIND v(dout1_18) AT=1110.05n

.meas tran vdout1_19ck1100 FIND v(dout1_19) AT=1110.05n

.meas tran vdout1_20ck1100 FIND v(dout1_20) AT=1110.05n

.meas tran vdout1_21ck1100 FIND v(dout1_21) AT=1110.05n

.meas tran vdout1_22ck1100 FIND v(dout1_22) AT=1110.05n

.meas tran vdout1_23ck1100 FIND v(dout1_23) AT=1110.05n

.meas tran vdout1_24ck1100 FIND v(dout1_24) AT=1110.05n

.meas tran vdout1_25ck1100 FIND v(dout1_25) AT=1110.05n

.meas tran vdout1_26ck1100 FIND v(dout1_26) AT=1110.05n

.meas tran vdout1_27ck1100 FIND v(dout1_27) AT=1110.05n

.meas tran vdout1_28ck1100 FIND v(dout1_28) AT=1110.05n

.meas tran vdout1_29ck1100 FIND v(dout1_29) AT=1110.05n

.meas tran vdout1_30ck1100 FIND v(dout1_30) AT=1110.05n

.meas tran vdout1_31ck1100 FIND v(dout1_31) AT=1110.05n

.meas tran vdout1_32ck1100 FIND v(dout1_32) AT=1110.05n

.meas tran vdout1_33ck1100 FIND v(dout1_33) AT=1110.05n

.meas tran vdout1_34ck1100 FIND v(dout1_34) AT=1110.05n

.meas tran vdout1_35ck1100 FIND v(dout1_35) AT=1110.05n

.meas tran vdout1_36ck1100 FIND v(dout1_36) AT=1110.05n

.meas tran vdout1_37ck1100 FIND v(dout1_37) AT=1110.05n

.meas tran vdout1_38ck1100 FIND v(dout1_38) AT=1110.05n

.meas tran vdout1_39ck1100 FIND v(dout1_39) AT=1110.05n

.meas tran vdout1_40ck1100 FIND v(dout1_40) AT=1110.05n

.meas tran vdout1_41ck1100 FIND v(dout1_41) AT=1110.05n

.meas tran vdout1_42ck1100 FIND v(dout1_42) AT=1110.05n

.meas tran vdout1_43ck1100 FIND v(dout1_43) AT=1110.05n

.meas tran vdout1_44ck1100 FIND v(dout1_44) AT=1110.05n

.meas tran vdout1_45ck1100 FIND v(dout1_45) AT=1110.05n

.meas tran vdout1_46ck1100 FIND v(dout1_46) AT=1110.05n

.meas tran vdout1_47ck1100 FIND v(dout1_47) AT=1110.05n

.meas tran vdout1_48ck1100 FIND v(dout1_48) AT=1110.05n

.meas tran vdout1_49ck1100 FIND v(dout1_49) AT=1110.05n

.meas tran vdout1_50ck1100 FIND v(dout1_50) AT=1110.05n

.meas tran vdout1_51ck1100 FIND v(dout1_51) AT=1110.05n

.meas tran vdout1_52ck1100 FIND v(dout1_52) AT=1110.05n

.meas tran vdout1_53ck1100 FIND v(dout1_53) AT=1110.05n

.meas tran vdout1_54ck1100 FIND v(dout1_54) AT=1110.05n

.meas tran vdout1_55ck1100 FIND v(dout1_55) AT=1110.05n

.meas tran vdout1_56ck1100 FIND v(dout1_56) AT=1110.05n

.meas tran vdout1_57ck1100 FIND v(dout1_57) AT=1110.05n

.meas tran vdout1_58ck1100 FIND v(dout1_58) AT=1110.05n

.meas tran vdout1_59ck1100 FIND v(dout1_59) AT=1110.05n

.meas tran vdout1_60ck1100 FIND v(dout1_60) AT=1110.05n

.meas tran vdout1_61ck1100 FIND v(dout1_61) AT=1110.05n

.meas tran vdout1_62ck1100 FIND v(dout1_62) AT=1110.05n

.meas tran vdout1_63ck1100 FIND v(dout1_63) AT=1110.05n

.meas tran vdout1_64ck1100 FIND v(dout1_64) AT=1110.05n

.meas tran vdout1_65ck1100 FIND v(dout1_65) AT=1110.05n

.meas tran vdout1_66ck1100 FIND v(dout1_66) AT=1110.05n

.meas tran vdout1_67ck1100 FIND v(dout1_67) AT=1110.05n

.meas tran vdout1_68ck1100 FIND v(dout1_68) AT=1110.05n

.meas tran vdout1_69ck1100 FIND v(dout1_69) AT=1110.05n

.meas tran vdout1_70ck1100 FIND v(dout1_70) AT=1110.05n

.meas tran vdout1_71ck1100 FIND v(dout1_71) AT=1110.05n

.meas tran vdout1_72ck1100 FIND v(dout1_72) AT=1110.05n

.meas tran vdout1_73ck1100 FIND v(dout1_73) AT=1110.05n

.meas tran vdout1_74ck1100 FIND v(dout1_74) AT=1110.05n

.meas tran vdout1_75ck1100 FIND v(dout1_75) AT=1110.05n

.meas tran vdout1_76ck1100 FIND v(dout1_76) AT=1110.05n

.meas tran vdout1_77ck1100 FIND v(dout1_77) AT=1110.05n

.meas tran vdout1_78ck1100 FIND v(dout1_78) AT=1110.05n

.meas tran vdout1_79ck1100 FIND v(dout1_79) AT=1110.05n

.meas tran vdout1_80ck1100 FIND v(dout1_80) AT=1110.05n

.meas tran vdout1_81ck1100 FIND v(dout1_81) AT=1110.05n

.meas tran vdout1_82ck1100 FIND v(dout1_82) AT=1110.05n

.meas tran vdout1_83ck1100 FIND v(dout1_83) AT=1110.05n

.meas tran vdout1_84ck1100 FIND v(dout1_84) AT=1110.05n

.meas tran vdout1_85ck1100 FIND v(dout1_85) AT=1110.05n

.meas tran vdout1_86ck1100 FIND v(dout1_86) AT=1110.05n

.meas tran vdout1_87ck1100 FIND v(dout1_87) AT=1110.05n

.meas tran vdout1_88ck1100 FIND v(dout1_88) AT=1110.05n

.meas tran vdout1_89ck1100 FIND v(dout1_89) AT=1110.05n

.meas tran vdout1_90ck1100 FIND v(dout1_90) AT=1110.05n

.meas tran vdout1_91ck1100 FIND v(dout1_91) AT=1110.05n

.meas tran vdout1_92ck1100 FIND v(dout1_92) AT=1110.05n

.meas tran vdout1_93ck1100 FIND v(dout1_93) AT=1110.05n

.meas tran vdout1_94ck1100 FIND v(dout1_94) AT=1110.05n

.meas tran vdout1_95ck1100 FIND v(dout1_95) AT=1110.05n

.meas tran vdout1_96ck1100 FIND v(dout1_96) AT=1110.05n

.meas tran vdout1_97ck1100 FIND v(dout1_97) AT=1110.05n

.meas tran vdout1_98ck1100 FIND v(dout1_98) AT=1110.05n

.meas tran vdout1_99ck1100 FIND v(dout1_99) AT=1110.05n

.meas tran vdout1_100ck1100 FIND v(dout1_100) AT=1110.05n

.meas tran vdout1_101ck1100 FIND v(dout1_101) AT=1110.05n

.meas tran vdout1_102ck1100 FIND v(dout1_102) AT=1110.05n

.meas tran vdout1_103ck1100 FIND v(dout1_103) AT=1110.05n

.meas tran vdout1_104ck1100 FIND v(dout1_104) AT=1110.05n

.meas tran vdout1_105ck1100 FIND v(dout1_105) AT=1110.05n

.meas tran vdout1_106ck1100 FIND v(dout1_106) AT=1110.05n

.meas tran vdout1_107ck1100 FIND v(dout1_107) AT=1110.05n

.meas tran vdout1_108ck1100 FIND v(dout1_108) AT=1110.05n

.meas tran vdout1_109ck1100 FIND v(dout1_109) AT=1110.05n

.meas tran vdout1_110ck1100 FIND v(dout1_110) AT=1110.05n

.meas tran vdout1_111ck1100 FIND v(dout1_111) AT=1110.05n

.meas tran vdout1_112ck1100 FIND v(dout1_112) AT=1110.05n

.meas tran vdout1_113ck1100 FIND v(dout1_113) AT=1110.05n

.meas tran vdout1_114ck1100 FIND v(dout1_114) AT=1110.05n

.meas tran vdout1_115ck1100 FIND v(dout1_115) AT=1110.05n

.meas tran vdout1_116ck1100 FIND v(dout1_116) AT=1110.05n

.meas tran vdout1_117ck1100 FIND v(dout1_117) AT=1110.05n

.meas tran vdout1_118ck1100 FIND v(dout1_118) AT=1110.05n

.meas tran vdout1_119ck1100 FIND v(dout1_119) AT=1110.05n

.meas tran vdout1_120ck1100 FIND v(dout1_120) AT=1110.05n

.meas tran vdout1_121ck1100 FIND v(dout1_121) AT=1110.05n

.meas tran vdout1_122ck1100 FIND v(dout1_122) AT=1110.05n

.meas tran vdout1_123ck1100 FIND v(dout1_123) AT=1110.05n

.meas tran vdout1_124ck1100 FIND v(dout1_124) AT=1110.05n

.meas tran vdout1_125ck1100 FIND v(dout1_125) AT=1110.05n

.meas tran vdout1_126ck1100 FIND v(dout1_126) AT=1110.05n

.meas tran vdout1_127ck1100 FIND v(dout1_127) AT=1110.05n

.meas tran vdout1_128ck1100 FIND v(dout1_128) AT=1110.05n

.meas tran vdout1_129ck1100 FIND v(dout1_129) AT=1110.05n

.meas tran vdout1_130ck1100 FIND v(dout1_130) AT=1110.05n

.meas tran vdout1_131ck1100 FIND v(dout1_131) AT=1110.05n

.meas tran vdout1_132ck1100 FIND v(dout1_132) AT=1110.05n

.meas tran vdout1_133ck1100 FIND v(dout1_133) AT=1110.05n

.meas tran vdout1_134ck1100 FIND v(dout1_134) AT=1110.05n

.meas tran vdout1_135ck1100 FIND v(dout1_135) AT=1110.05n

.meas tran vdout1_136ck1100 FIND v(dout1_136) AT=1110.05n

.meas tran vdout1_137ck1100 FIND v(dout1_137) AT=1110.05n

.meas tran vdout1_138ck1100 FIND v(dout1_138) AT=1110.05n

.meas tran vdout1_139ck1100 FIND v(dout1_139) AT=1110.05n

.meas tran vdout1_140ck1100 FIND v(dout1_140) AT=1110.05n

.meas tran vdout1_141ck1100 FIND v(dout1_141) AT=1110.05n

.meas tran vdout1_142ck1100 FIND v(dout1_142) AT=1110.05n

.meas tran vdout1_143ck1100 FIND v(dout1_143) AT=1110.05n

.meas tran vdout1_144ck1100 FIND v(dout1_144) AT=1110.05n

.meas tran vdout1_145ck1100 FIND v(dout1_145) AT=1110.05n

.meas tran vdout1_146ck1100 FIND v(dout1_146) AT=1110.05n

.meas tran vdout1_147ck1100 FIND v(dout1_147) AT=1110.05n

.meas tran vdout1_148ck1100 FIND v(dout1_148) AT=1110.05n

.meas tran vdout1_149ck1100 FIND v(dout1_149) AT=1110.05n

.meas tran vdout1_150ck1100 FIND v(dout1_150) AT=1110.05n

.meas tran vdout1_151ck1100 FIND v(dout1_151) AT=1110.05n

.meas tran vdout1_152ck1100 FIND v(dout1_152) AT=1110.05n

.meas tran vdout1_153ck1100 FIND v(dout1_153) AT=1110.05n

.meas tran vdout1_154ck1100 FIND v(dout1_154) AT=1110.05n

.meas tran vdout1_155ck1100 FIND v(dout1_155) AT=1110.05n

.meas tran vdout1_156ck1100 FIND v(dout1_156) AT=1110.05n

.meas tran vdout1_157ck1100 FIND v(dout1_157) AT=1110.05n

.meas tran vdout1_158ck1100 FIND v(dout1_158) AT=1110.05n

.meas tran vdout1_159ck1100 FIND v(dout1_159) AT=1110.05n

.meas tran vdout1_160ck1100 FIND v(dout1_160) AT=1110.05n

.meas tran vdout1_161ck1100 FIND v(dout1_161) AT=1110.05n

.meas tran vdout1_162ck1100 FIND v(dout1_162) AT=1110.05n

.meas tran vdout1_163ck1100 FIND v(dout1_163) AT=1110.05n

.meas tran vdout1_164ck1100 FIND v(dout1_164) AT=1110.05n

.meas tran vdout1_165ck1100 FIND v(dout1_165) AT=1110.05n

.meas tran vdout1_166ck1100 FIND v(dout1_166) AT=1110.05n

.meas tran vdout1_167ck1100 FIND v(dout1_167) AT=1110.05n

.meas tran vdout1_168ck1100 FIND v(dout1_168) AT=1110.05n

.meas tran vdout1_169ck1100 FIND v(dout1_169) AT=1110.05n

.meas tran vdout1_170ck1100 FIND v(dout1_170) AT=1110.05n

.meas tran vdout1_171ck1100 FIND v(dout1_171) AT=1110.05n

.meas tran vdout1_172ck1100 FIND v(dout1_172) AT=1110.05n

.meas tran vdout1_173ck1100 FIND v(dout1_173) AT=1110.05n

.meas tran vdout1_174ck1100 FIND v(dout1_174) AT=1110.05n

.meas tran vdout1_175ck1100 FIND v(dout1_175) AT=1110.05n

.meas tran vdout1_176ck1100 FIND v(dout1_176) AT=1110.05n

.meas tran vdout1_177ck1100 FIND v(dout1_177) AT=1110.05n

.meas tran vdout1_178ck1100 FIND v(dout1_178) AT=1110.05n

.meas tran vdout1_179ck1100 FIND v(dout1_179) AT=1110.05n

.meas tran vdout1_180ck1100 FIND v(dout1_180) AT=1110.05n

.meas tran vdout1_181ck1100 FIND v(dout1_181) AT=1110.05n

.meas tran vdout1_182ck1100 FIND v(dout1_182) AT=1110.05n

.meas tran vdout1_183ck1100 FIND v(dout1_183) AT=1110.05n

.meas tran vdout1_184ck1100 FIND v(dout1_184) AT=1110.05n

.meas tran vdout1_185ck1100 FIND v(dout1_185) AT=1110.05n

.meas tran vdout1_186ck1100 FIND v(dout1_186) AT=1110.05n

.meas tran vdout1_187ck1100 FIND v(dout1_187) AT=1110.05n

.meas tran vdout1_188ck1100 FIND v(dout1_188) AT=1110.05n

.meas tran vdout1_189ck1100 FIND v(dout1_189) AT=1110.05n

.meas tran vdout1_190ck1100 FIND v(dout1_190) AT=1110.05n

.meas tran vdout1_191ck1100 FIND v(dout1_191) AT=1110.05n

.meas tran vdout1_192ck1100 FIND v(dout1_192) AT=1110.05n

.meas tran vdout1_193ck1100 FIND v(dout1_193) AT=1110.05n

.meas tran vdout1_194ck1100 FIND v(dout1_194) AT=1110.05n

.meas tran vdout1_195ck1100 FIND v(dout1_195) AT=1110.05n

.meas tran vdout1_196ck1100 FIND v(dout1_196) AT=1110.05n

.meas tran vdout1_197ck1100 FIND v(dout1_197) AT=1110.05n

.meas tran vdout1_198ck1100 FIND v(dout1_198) AT=1110.05n

.meas tran vdout1_199ck1100 FIND v(dout1_199) AT=1110.05n

.meas tran vdout1_200ck1100 FIND v(dout1_200) AT=1110.05n

.meas tran vdout1_201ck1100 FIND v(dout1_201) AT=1110.05n

.meas tran vdout1_202ck1100 FIND v(dout1_202) AT=1110.05n

.meas tran vdout1_203ck1100 FIND v(dout1_203) AT=1110.05n

.meas tran vdout1_204ck1100 FIND v(dout1_204) AT=1110.05n

.meas tran vdout1_205ck1100 FIND v(dout1_205) AT=1110.05n

.meas tran vdout1_206ck1100 FIND v(dout1_206) AT=1110.05n

.meas tran vdout1_207ck1100 FIND v(dout1_207) AT=1110.05n

.meas tran vdout1_208ck1100 FIND v(dout1_208) AT=1110.05n

.meas tran vdout1_209ck1100 FIND v(dout1_209) AT=1110.05n

.meas tran vdout1_210ck1100 FIND v(dout1_210) AT=1110.05n

.meas tran vdout1_211ck1100 FIND v(dout1_211) AT=1110.05n

.meas tran vdout1_212ck1100 FIND v(dout1_212) AT=1110.05n

.meas tran vdout1_213ck1100 FIND v(dout1_213) AT=1110.05n

.meas tran vdout1_214ck1100 FIND v(dout1_214) AT=1110.05n

.meas tran vdout1_215ck1100 FIND v(dout1_215) AT=1110.05n

.meas tran vdout1_216ck1100 FIND v(dout1_216) AT=1110.05n

.meas tran vdout1_217ck1100 FIND v(dout1_217) AT=1110.05n

.meas tran vdout1_218ck1100 FIND v(dout1_218) AT=1110.05n

.meas tran vdout1_219ck1100 FIND v(dout1_219) AT=1110.05n

.meas tran vdout1_220ck1100 FIND v(dout1_220) AT=1110.05n

.meas tran vdout1_221ck1100 FIND v(dout1_221) AT=1110.05n

.meas tran vdout1_222ck1100 FIND v(dout1_222) AT=1110.05n

.meas tran vdout1_223ck1100 FIND v(dout1_223) AT=1110.05n

.meas tran vdout1_224ck1100 FIND v(dout1_224) AT=1110.05n

.meas tran vdout1_225ck1100 FIND v(dout1_225) AT=1110.05n

.meas tran vdout1_226ck1100 FIND v(dout1_226) AT=1110.05n

.meas tran vdout1_227ck1100 FIND v(dout1_227) AT=1110.05n

.meas tran vdout1_228ck1100 FIND v(dout1_228) AT=1110.05n

.meas tran vdout1_229ck1100 FIND v(dout1_229) AT=1110.05n

.meas tran vdout1_230ck1100 FIND v(dout1_230) AT=1110.05n

.meas tran vdout1_231ck1100 FIND v(dout1_231) AT=1110.05n

.meas tran vdout1_232ck1100 FIND v(dout1_232) AT=1110.05n

.meas tran vdout1_233ck1100 FIND v(dout1_233) AT=1110.05n

.meas tran vdout1_234ck1100 FIND v(dout1_234) AT=1110.05n

.meas tran vdout1_235ck1100 FIND v(dout1_235) AT=1110.05n

.meas tran vdout1_236ck1100 FIND v(dout1_236) AT=1110.05n

.meas tran vdout1_237ck1100 FIND v(dout1_237) AT=1110.05n

.meas tran vdout1_238ck1100 FIND v(dout1_238) AT=1110.05n

.meas tran vdout1_239ck1100 FIND v(dout1_239) AT=1110.05n

.meas tran vdout1_240ck1100 FIND v(dout1_240) AT=1110.05n

.meas tran vdout1_241ck1100 FIND v(dout1_241) AT=1110.05n

.meas tran vdout1_242ck1100 FIND v(dout1_242) AT=1110.05n

.meas tran vdout1_243ck1100 FIND v(dout1_243) AT=1110.05n

.meas tran vdout1_244ck1100 FIND v(dout1_244) AT=1110.05n

.meas tran vdout1_245ck1100 FIND v(dout1_245) AT=1110.05n

.meas tran vdout1_246ck1100 FIND v(dout1_246) AT=1110.05n

.meas tran vdout1_247ck1100 FIND v(dout1_247) AT=1110.05n

.meas tran vdout1_248ck1100 FIND v(dout1_248) AT=1110.05n

.meas tran vdout1_249ck1100 FIND v(dout1_249) AT=1110.05n

.meas tran vdout1_250ck1100 FIND v(dout1_250) AT=1110.05n

.meas tran vdout1_251ck1100 FIND v(dout1_251) AT=1110.05n

.meas tran vdout1_252ck1100 FIND v(dout1_252) AT=1110.05n

.meas tran vdout1_253ck1100 FIND v(dout1_253) AT=1110.05n

.meas tran vdout1_254ck1100 FIND v(dout1_254) AT=1110.05n

.meas tran vdout1_255ck1100 FIND v(dout1_255) AT=1110.05n

.meas tran vdout1_256ck1100 FIND v(dout1_256) AT=1110.05n

.meas tran vdout1_0ck1130 FIND v(dout1_0) AT=1140.05n

.meas tran vdout1_1ck1130 FIND v(dout1_1) AT=1140.05n

.meas tran vdout1_2ck1130 FIND v(dout1_2) AT=1140.05n

.meas tran vdout1_3ck1130 FIND v(dout1_3) AT=1140.05n

.meas tran vdout1_4ck1130 FIND v(dout1_4) AT=1140.05n

.meas tran vdout1_5ck1130 FIND v(dout1_5) AT=1140.05n

.meas tran vdout1_6ck1130 FIND v(dout1_6) AT=1140.05n

.meas tran vdout1_7ck1130 FIND v(dout1_7) AT=1140.05n

.meas tran vdout1_8ck1130 FIND v(dout1_8) AT=1140.05n

.meas tran vdout1_9ck1130 FIND v(dout1_9) AT=1140.05n

.meas tran vdout1_10ck1130 FIND v(dout1_10) AT=1140.05n

.meas tran vdout1_11ck1130 FIND v(dout1_11) AT=1140.05n

.meas tran vdout1_12ck1130 FIND v(dout1_12) AT=1140.05n

.meas tran vdout1_13ck1130 FIND v(dout1_13) AT=1140.05n

.meas tran vdout1_14ck1130 FIND v(dout1_14) AT=1140.05n

.meas tran vdout1_15ck1130 FIND v(dout1_15) AT=1140.05n

.meas tran vdout1_16ck1130 FIND v(dout1_16) AT=1140.05n

.meas tran vdout1_17ck1130 FIND v(dout1_17) AT=1140.05n

.meas tran vdout1_18ck1130 FIND v(dout1_18) AT=1140.05n

.meas tran vdout1_19ck1130 FIND v(dout1_19) AT=1140.05n

.meas tran vdout1_20ck1130 FIND v(dout1_20) AT=1140.05n

.meas tran vdout1_21ck1130 FIND v(dout1_21) AT=1140.05n

.meas tran vdout1_22ck1130 FIND v(dout1_22) AT=1140.05n

.meas tran vdout1_23ck1130 FIND v(dout1_23) AT=1140.05n

.meas tran vdout1_24ck1130 FIND v(dout1_24) AT=1140.05n

.meas tran vdout1_25ck1130 FIND v(dout1_25) AT=1140.05n

.meas tran vdout1_26ck1130 FIND v(dout1_26) AT=1140.05n

.meas tran vdout1_27ck1130 FIND v(dout1_27) AT=1140.05n

.meas tran vdout1_28ck1130 FIND v(dout1_28) AT=1140.05n

.meas tran vdout1_29ck1130 FIND v(dout1_29) AT=1140.05n

.meas tran vdout1_30ck1130 FIND v(dout1_30) AT=1140.05n

.meas tran vdout1_31ck1130 FIND v(dout1_31) AT=1140.05n

.meas tran vdout1_32ck1130 FIND v(dout1_32) AT=1140.05n

.meas tran vdout1_33ck1130 FIND v(dout1_33) AT=1140.05n

.meas tran vdout1_34ck1130 FIND v(dout1_34) AT=1140.05n

.meas tran vdout1_35ck1130 FIND v(dout1_35) AT=1140.05n

.meas tran vdout1_36ck1130 FIND v(dout1_36) AT=1140.05n

.meas tran vdout1_37ck1130 FIND v(dout1_37) AT=1140.05n

.meas tran vdout1_38ck1130 FIND v(dout1_38) AT=1140.05n

.meas tran vdout1_39ck1130 FIND v(dout1_39) AT=1140.05n

.meas tran vdout1_40ck1130 FIND v(dout1_40) AT=1140.05n

.meas tran vdout1_41ck1130 FIND v(dout1_41) AT=1140.05n

.meas tran vdout1_42ck1130 FIND v(dout1_42) AT=1140.05n

.meas tran vdout1_43ck1130 FIND v(dout1_43) AT=1140.05n

.meas tran vdout1_44ck1130 FIND v(dout1_44) AT=1140.05n

.meas tran vdout1_45ck1130 FIND v(dout1_45) AT=1140.05n

.meas tran vdout1_46ck1130 FIND v(dout1_46) AT=1140.05n

.meas tran vdout1_47ck1130 FIND v(dout1_47) AT=1140.05n

.meas tran vdout1_48ck1130 FIND v(dout1_48) AT=1140.05n

.meas tran vdout1_49ck1130 FIND v(dout1_49) AT=1140.05n

.meas tran vdout1_50ck1130 FIND v(dout1_50) AT=1140.05n

.meas tran vdout1_51ck1130 FIND v(dout1_51) AT=1140.05n

.meas tran vdout1_52ck1130 FIND v(dout1_52) AT=1140.05n

.meas tran vdout1_53ck1130 FIND v(dout1_53) AT=1140.05n

.meas tran vdout1_54ck1130 FIND v(dout1_54) AT=1140.05n

.meas tran vdout1_55ck1130 FIND v(dout1_55) AT=1140.05n

.meas tran vdout1_56ck1130 FIND v(dout1_56) AT=1140.05n

.meas tran vdout1_57ck1130 FIND v(dout1_57) AT=1140.05n

.meas tran vdout1_58ck1130 FIND v(dout1_58) AT=1140.05n

.meas tran vdout1_59ck1130 FIND v(dout1_59) AT=1140.05n

.meas tran vdout1_60ck1130 FIND v(dout1_60) AT=1140.05n

.meas tran vdout1_61ck1130 FIND v(dout1_61) AT=1140.05n

.meas tran vdout1_62ck1130 FIND v(dout1_62) AT=1140.05n

.meas tran vdout1_63ck1130 FIND v(dout1_63) AT=1140.05n

.meas tran vdout1_64ck1130 FIND v(dout1_64) AT=1140.05n

.meas tran vdout1_65ck1130 FIND v(dout1_65) AT=1140.05n

.meas tran vdout1_66ck1130 FIND v(dout1_66) AT=1140.05n

.meas tran vdout1_67ck1130 FIND v(dout1_67) AT=1140.05n

.meas tran vdout1_68ck1130 FIND v(dout1_68) AT=1140.05n

.meas tran vdout1_69ck1130 FIND v(dout1_69) AT=1140.05n

.meas tran vdout1_70ck1130 FIND v(dout1_70) AT=1140.05n

.meas tran vdout1_71ck1130 FIND v(dout1_71) AT=1140.05n

.meas tran vdout1_72ck1130 FIND v(dout1_72) AT=1140.05n

.meas tran vdout1_73ck1130 FIND v(dout1_73) AT=1140.05n

.meas tran vdout1_74ck1130 FIND v(dout1_74) AT=1140.05n

.meas tran vdout1_75ck1130 FIND v(dout1_75) AT=1140.05n

.meas tran vdout1_76ck1130 FIND v(dout1_76) AT=1140.05n

.meas tran vdout1_77ck1130 FIND v(dout1_77) AT=1140.05n

.meas tran vdout1_78ck1130 FIND v(dout1_78) AT=1140.05n

.meas tran vdout1_79ck1130 FIND v(dout1_79) AT=1140.05n

.meas tran vdout1_80ck1130 FIND v(dout1_80) AT=1140.05n

.meas tran vdout1_81ck1130 FIND v(dout1_81) AT=1140.05n

.meas tran vdout1_82ck1130 FIND v(dout1_82) AT=1140.05n

.meas tran vdout1_83ck1130 FIND v(dout1_83) AT=1140.05n

.meas tran vdout1_84ck1130 FIND v(dout1_84) AT=1140.05n

.meas tran vdout1_85ck1130 FIND v(dout1_85) AT=1140.05n

.meas tran vdout1_86ck1130 FIND v(dout1_86) AT=1140.05n

.meas tran vdout1_87ck1130 FIND v(dout1_87) AT=1140.05n

.meas tran vdout1_88ck1130 FIND v(dout1_88) AT=1140.05n

.meas tran vdout1_89ck1130 FIND v(dout1_89) AT=1140.05n

.meas tran vdout1_90ck1130 FIND v(dout1_90) AT=1140.05n

.meas tran vdout1_91ck1130 FIND v(dout1_91) AT=1140.05n

.meas tran vdout1_92ck1130 FIND v(dout1_92) AT=1140.05n

.meas tran vdout1_93ck1130 FIND v(dout1_93) AT=1140.05n

.meas tran vdout1_94ck1130 FIND v(dout1_94) AT=1140.05n

.meas tran vdout1_95ck1130 FIND v(dout1_95) AT=1140.05n

.meas tran vdout1_96ck1130 FIND v(dout1_96) AT=1140.05n

.meas tran vdout1_97ck1130 FIND v(dout1_97) AT=1140.05n

.meas tran vdout1_98ck1130 FIND v(dout1_98) AT=1140.05n

.meas tran vdout1_99ck1130 FIND v(dout1_99) AT=1140.05n

.meas tran vdout1_100ck1130 FIND v(dout1_100) AT=1140.05n

.meas tran vdout1_101ck1130 FIND v(dout1_101) AT=1140.05n

.meas tran vdout1_102ck1130 FIND v(dout1_102) AT=1140.05n

.meas tran vdout1_103ck1130 FIND v(dout1_103) AT=1140.05n

.meas tran vdout1_104ck1130 FIND v(dout1_104) AT=1140.05n

.meas tran vdout1_105ck1130 FIND v(dout1_105) AT=1140.05n

.meas tran vdout1_106ck1130 FIND v(dout1_106) AT=1140.05n

.meas tran vdout1_107ck1130 FIND v(dout1_107) AT=1140.05n

.meas tran vdout1_108ck1130 FIND v(dout1_108) AT=1140.05n

.meas tran vdout1_109ck1130 FIND v(dout1_109) AT=1140.05n

.meas tran vdout1_110ck1130 FIND v(dout1_110) AT=1140.05n

.meas tran vdout1_111ck1130 FIND v(dout1_111) AT=1140.05n

.meas tran vdout1_112ck1130 FIND v(dout1_112) AT=1140.05n

.meas tran vdout1_113ck1130 FIND v(dout1_113) AT=1140.05n

.meas tran vdout1_114ck1130 FIND v(dout1_114) AT=1140.05n

.meas tran vdout1_115ck1130 FIND v(dout1_115) AT=1140.05n

.meas tran vdout1_116ck1130 FIND v(dout1_116) AT=1140.05n

.meas tran vdout1_117ck1130 FIND v(dout1_117) AT=1140.05n

.meas tran vdout1_118ck1130 FIND v(dout1_118) AT=1140.05n

.meas tran vdout1_119ck1130 FIND v(dout1_119) AT=1140.05n

.meas tran vdout1_120ck1130 FIND v(dout1_120) AT=1140.05n

.meas tran vdout1_121ck1130 FIND v(dout1_121) AT=1140.05n

.meas tran vdout1_122ck1130 FIND v(dout1_122) AT=1140.05n

.meas tran vdout1_123ck1130 FIND v(dout1_123) AT=1140.05n

.meas tran vdout1_124ck1130 FIND v(dout1_124) AT=1140.05n

.meas tran vdout1_125ck1130 FIND v(dout1_125) AT=1140.05n

.meas tran vdout1_126ck1130 FIND v(dout1_126) AT=1140.05n

.meas tran vdout1_127ck1130 FIND v(dout1_127) AT=1140.05n

.meas tran vdout1_128ck1130 FIND v(dout1_128) AT=1140.05n

.meas tran vdout1_129ck1130 FIND v(dout1_129) AT=1140.05n

.meas tran vdout1_130ck1130 FIND v(dout1_130) AT=1140.05n

.meas tran vdout1_131ck1130 FIND v(dout1_131) AT=1140.05n

.meas tran vdout1_132ck1130 FIND v(dout1_132) AT=1140.05n

.meas tran vdout1_133ck1130 FIND v(dout1_133) AT=1140.05n

.meas tran vdout1_134ck1130 FIND v(dout1_134) AT=1140.05n

.meas tran vdout1_135ck1130 FIND v(dout1_135) AT=1140.05n

.meas tran vdout1_136ck1130 FIND v(dout1_136) AT=1140.05n

.meas tran vdout1_137ck1130 FIND v(dout1_137) AT=1140.05n

.meas tran vdout1_138ck1130 FIND v(dout1_138) AT=1140.05n

.meas tran vdout1_139ck1130 FIND v(dout1_139) AT=1140.05n

.meas tran vdout1_140ck1130 FIND v(dout1_140) AT=1140.05n

.meas tran vdout1_141ck1130 FIND v(dout1_141) AT=1140.05n

.meas tran vdout1_142ck1130 FIND v(dout1_142) AT=1140.05n

.meas tran vdout1_143ck1130 FIND v(dout1_143) AT=1140.05n

.meas tran vdout1_144ck1130 FIND v(dout1_144) AT=1140.05n

.meas tran vdout1_145ck1130 FIND v(dout1_145) AT=1140.05n

.meas tran vdout1_146ck1130 FIND v(dout1_146) AT=1140.05n

.meas tran vdout1_147ck1130 FIND v(dout1_147) AT=1140.05n

.meas tran vdout1_148ck1130 FIND v(dout1_148) AT=1140.05n

.meas tran vdout1_149ck1130 FIND v(dout1_149) AT=1140.05n

.meas tran vdout1_150ck1130 FIND v(dout1_150) AT=1140.05n

.meas tran vdout1_151ck1130 FIND v(dout1_151) AT=1140.05n

.meas tran vdout1_152ck1130 FIND v(dout1_152) AT=1140.05n

.meas tran vdout1_153ck1130 FIND v(dout1_153) AT=1140.05n

.meas tran vdout1_154ck1130 FIND v(dout1_154) AT=1140.05n

.meas tran vdout1_155ck1130 FIND v(dout1_155) AT=1140.05n

.meas tran vdout1_156ck1130 FIND v(dout1_156) AT=1140.05n

.meas tran vdout1_157ck1130 FIND v(dout1_157) AT=1140.05n

.meas tran vdout1_158ck1130 FIND v(dout1_158) AT=1140.05n

.meas tran vdout1_159ck1130 FIND v(dout1_159) AT=1140.05n

.meas tran vdout1_160ck1130 FIND v(dout1_160) AT=1140.05n

.meas tran vdout1_161ck1130 FIND v(dout1_161) AT=1140.05n

.meas tran vdout1_162ck1130 FIND v(dout1_162) AT=1140.05n

.meas tran vdout1_163ck1130 FIND v(dout1_163) AT=1140.05n

.meas tran vdout1_164ck1130 FIND v(dout1_164) AT=1140.05n

.meas tran vdout1_165ck1130 FIND v(dout1_165) AT=1140.05n

.meas tran vdout1_166ck1130 FIND v(dout1_166) AT=1140.05n

.meas tran vdout1_167ck1130 FIND v(dout1_167) AT=1140.05n

.meas tran vdout1_168ck1130 FIND v(dout1_168) AT=1140.05n

.meas tran vdout1_169ck1130 FIND v(dout1_169) AT=1140.05n

.meas tran vdout1_170ck1130 FIND v(dout1_170) AT=1140.05n

.meas tran vdout1_171ck1130 FIND v(dout1_171) AT=1140.05n

.meas tran vdout1_172ck1130 FIND v(dout1_172) AT=1140.05n

.meas tran vdout1_173ck1130 FIND v(dout1_173) AT=1140.05n

.meas tran vdout1_174ck1130 FIND v(dout1_174) AT=1140.05n

.meas tran vdout1_175ck1130 FIND v(dout1_175) AT=1140.05n

.meas tran vdout1_176ck1130 FIND v(dout1_176) AT=1140.05n

.meas tran vdout1_177ck1130 FIND v(dout1_177) AT=1140.05n

.meas tran vdout1_178ck1130 FIND v(dout1_178) AT=1140.05n

.meas tran vdout1_179ck1130 FIND v(dout1_179) AT=1140.05n

.meas tran vdout1_180ck1130 FIND v(dout1_180) AT=1140.05n

.meas tran vdout1_181ck1130 FIND v(dout1_181) AT=1140.05n

.meas tran vdout1_182ck1130 FIND v(dout1_182) AT=1140.05n

.meas tran vdout1_183ck1130 FIND v(dout1_183) AT=1140.05n

.meas tran vdout1_184ck1130 FIND v(dout1_184) AT=1140.05n

.meas tran vdout1_185ck1130 FIND v(dout1_185) AT=1140.05n

.meas tran vdout1_186ck1130 FIND v(dout1_186) AT=1140.05n

.meas tran vdout1_187ck1130 FIND v(dout1_187) AT=1140.05n

.meas tran vdout1_188ck1130 FIND v(dout1_188) AT=1140.05n

.meas tran vdout1_189ck1130 FIND v(dout1_189) AT=1140.05n

.meas tran vdout1_190ck1130 FIND v(dout1_190) AT=1140.05n

.meas tran vdout1_191ck1130 FIND v(dout1_191) AT=1140.05n

.meas tran vdout1_192ck1130 FIND v(dout1_192) AT=1140.05n

.meas tran vdout1_193ck1130 FIND v(dout1_193) AT=1140.05n

.meas tran vdout1_194ck1130 FIND v(dout1_194) AT=1140.05n

.meas tran vdout1_195ck1130 FIND v(dout1_195) AT=1140.05n

.meas tran vdout1_196ck1130 FIND v(dout1_196) AT=1140.05n

.meas tran vdout1_197ck1130 FIND v(dout1_197) AT=1140.05n

.meas tran vdout1_198ck1130 FIND v(dout1_198) AT=1140.05n

.meas tran vdout1_199ck1130 FIND v(dout1_199) AT=1140.05n

.meas tran vdout1_200ck1130 FIND v(dout1_200) AT=1140.05n

.meas tran vdout1_201ck1130 FIND v(dout1_201) AT=1140.05n

.meas tran vdout1_202ck1130 FIND v(dout1_202) AT=1140.05n

.meas tran vdout1_203ck1130 FIND v(dout1_203) AT=1140.05n

.meas tran vdout1_204ck1130 FIND v(dout1_204) AT=1140.05n

.meas tran vdout1_205ck1130 FIND v(dout1_205) AT=1140.05n

.meas tran vdout1_206ck1130 FIND v(dout1_206) AT=1140.05n

.meas tran vdout1_207ck1130 FIND v(dout1_207) AT=1140.05n

.meas tran vdout1_208ck1130 FIND v(dout1_208) AT=1140.05n

.meas tran vdout1_209ck1130 FIND v(dout1_209) AT=1140.05n

.meas tran vdout1_210ck1130 FIND v(dout1_210) AT=1140.05n

.meas tran vdout1_211ck1130 FIND v(dout1_211) AT=1140.05n

.meas tran vdout1_212ck1130 FIND v(dout1_212) AT=1140.05n

.meas tran vdout1_213ck1130 FIND v(dout1_213) AT=1140.05n

.meas tran vdout1_214ck1130 FIND v(dout1_214) AT=1140.05n

.meas tran vdout1_215ck1130 FIND v(dout1_215) AT=1140.05n

.meas tran vdout1_216ck1130 FIND v(dout1_216) AT=1140.05n

.meas tran vdout1_217ck1130 FIND v(dout1_217) AT=1140.05n

.meas tran vdout1_218ck1130 FIND v(dout1_218) AT=1140.05n

.meas tran vdout1_219ck1130 FIND v(dout1_219) AT=1140.05n

.meas tran vdout1_220ck1130 FIND v(dout1_220) AT=1140.05n

.meas tran vdout1_221ck1130 FIND v(dout1_221) AT=1140.05n

.meas tran vdout1_222ck1130 FIND v(dout1_222) AT=1140.05n

.meas tran vdout1_223ck1130 FIND v(dout1_223) AT=1140.05n

.meas tran vdout1_224ck1130 FIND v(dout1_224) AT=1140.05n

.meas tran vdout1_225ck1130 FIND v(dout1_225) AT=1140.05n

.meas tran vdout1_226ck1130 FIND v(dout1_226) AT=1140.05n

.meas tran vdout1_227ck1130 FIND v(dout1_227) AT=1140.05n

.meas tran vdout1_228ck1130 FIND v(dout1_228) AT=1140.05n

.meas tran vdout1_229ck1130 FIND v(dout1_229) AT=1140.05n

.meas tran vdout1_230ck1130 FIND v(dout1_230) AT=1140.05n

.meas tran vdout1_231ck1130 FIND v(dout1_231) AT=1140.05n

.meas tran vdout1_232ck1130 FIND v(dout1_232) AT=1140.05n

.meas tran vdout1_233ck1130 FIND v(dout1_233) AT=1140.05n

.meas tran vdout1_234ck1130 FIND v(dout1_234) AT=1140.05n

.meas tran vdout1_235ck1130 FIND v(dout1_235) AT=1140.05n

.meas tran vdout1_236ck1130 FIND v(dout1_236) AT=1140.05n

.meas tran vdout1_237ck1130 FIND v(dout1_237) AT=1140.05n

.meas tran vdout1_238ck1130 FIND v(dout1_238) AT=1140.05n

.meas tran vdout1_239ck1130 FIND v(dout1_239) AT=1140.05n

.meas tran vdout1_240ck1130 FIND v(dout1_240) AT=1140.05n

.meas tran vdout1_241ck1130 FIND v(dout1_241) AT=1140.05n

.meas tran vdout1_242ck1130 FIND v(dout1_242) AT=1140.05n

.meas tran vdout1_243ck1130 FIND v(dout1_243) AT=1140.05n

.meas tran vdout1_244ck1130 FIND v(dout1_244) AT=1140.05n

.meas tran vdout1_245ck1130 FIND v(dout1_245) AT=1140.05n

.meas tran vdout1_246ck1130 FIND v(dout1_246) AT=1140.05n

.meas tran vdout1_247ck1130 FIND v(dout1_247) AT=1140.05n

.meas tran vdout1_248ck1130 FIND v(dout1_248) AT=1140.05n

.meas tran vdout1_249ck1130 FIND v(dout1_249) AT=1140.05n

.meas tran vdout1_250ck1130 FIND v(dout1_250) AT=1140.05n

.meas tran vdout1_251ck1130 FIND v(dout1_251) AT=1140.05n

.meas tran vdout1_252ck1130 FIND v(dout1_252) AT=1140.05n

.meas tran vdout1_253ck1130 FIND v(dout1_253) AT=1140.05n

.meas tran vdout1_254ck1130 FIND v(dout1_254) AT=1140.05n

.meas tran vdout1_255ck1130 FIND v(dout1_255) AT=1140.05n

.meas tran vdout1_256ck1130 FIND v(dout1_256) AT=1140.05n

.meas tran vdout1_0ck1140 FIND v(dout1_0) AT=1150.05n

.meas tran vdout1_1ck1140 FIND v(dout1_1) AT=1150.05n

.meas tran vdout1_2ck1140 FIND v(dout1_2) AT=1150.05n

.meas tran vdout1_3ck1140 FIND v(dout1_3) AT=1150.05n

.meas tran vdout1_4ck1140 FIND v(dout1_4) AT=1150.05n

.meas tran vdout1_5ck1140 FIND v(dout1_5) AT=1150.05n

.meas tran vdout1_6ck1140 FIND v(dout1_6) AT=1150.05n

.meas tran vdout1_7ck1140 FIND v(dout1_7) AT=1150.05n

.meas tran vdout1_8ck1140 FIND v(dout1_8) AT=1150.05n

.meas tran vdout1_9ck1140 FIND v(dout1_9) AT=1150.05n

.meas tran vdout1_10ck1140 FIND v(dout1_10) AT=1150.05n

.meas tran vdout1_11ck1140 FIND v(dout1_11) AT=1150.05n

.meas tran vdout1_12ck1140 FIND v(dout1_12) AT=1150.05n

.meas tran vdout1_13ck1140 FIND v(dout1_13) AT=1150.05n

.meas tran vdout1_14ck1140 FIND v(dout1_14) AT=1150.05n

.meas tran vdout1_15ck1140 FIND v(dout1_15) AT=1150.05n

.meas tran vdout1_16ck1140 FIND v(dout1_16) AT=1150.05n

.meas tran vdout1_17ck1140 FIND v(dout1_17) AT=1150.05n

.meas tran vdout1_18ck1140 FIND v(dout1_18) AT=1150.05n

.meas tran vdout1_19ck1140 FIND v(dout1_19) AT=1150.05n

.meas tran vdout1_20ck1140 FIND v(dout1_20) AT=1150.05n

.meas tran vdout1_21ck1140 FIND v(dout1_21) AT=1150.05n

.meas tran vdout1_22ck1140 FIND v(dout1_22) AT=1150.05n

.meas tran vdout1_23ck1140 FIND v(dout1_23) AT=1150.05n

.meas tran vdout1_24ck1140 FIND v(dout1_24) AT=1150.05n

.meas tran vdout1_25ck1140 FIND v(dout1_25) AT=1150.05n

.meas tran vdout1_26ck1140 FIND v(dout1_26) AT=1150.05n

.meas tran vdout1_27ck1140 FIND v(dout1_27) AT=1150.05n

.meas tran vdout1_28ck1140 FIND v(dout1_28) AT=1150.05n

.meas tran vdout1_29ck1140 FIND v(dout1_29) AT=1150.05n

.meas tran vdout1_30ck1140 FIND v(dout1_30) AT=1150.05n

.meas tran vdout1_31ck1140 FIND v(dout1_31) AT=1150.05n

.meas tran vdout1_32ck1140 FIND v(dout1_32) AT=1150.05n

.meas tran vdout1_33ck1140 FIND v(dout1_33) AT=1150.05n

.meas tran vdout1_34ck1140 FIND v(dout1_34) AT=1150.05n

.meas tran vdout1_35ck1140 FIND v(dout1_35) AT=1150.05n

.meas tran vdout1_36ck1140 FIND v(dout1_36) AT=1150.05n

.meas tran vdout1_37ck1140 FIND v(dout1_37) AT=1150.05n

.meas tran vdout1_38ck1140 FIND v(dout1_38) AT=1150.05n

.meas tran vdout1_39ck1140 FIND v(dout1_39) AT=1150.05n

.meas tran vdout1_40ck1140 FIND v(dout1_40) AT=1150.05n

.meas tran vdout1_41ck1140 FIND v(dout1_41) AT=1150.05n

.meas tran vdout1_42ck1140 FIND v(dout1_42) AT=1150.05n

.meas tran vdout1_43ck1140 FIND v(dout1_43) AT=1150.05n

.meas tran vdout1_44ck1140 FIND v(dout1_44) AT=1150.05n

.meas tran vdout1_45ck1140 FIND v(dout1_45) AT=1150.05n

.meas tran vdout1_46ck1140 FIND v(dout1_46) AT=1150.05n

.meas tran vdout1_47ck1140 FIND v(dout1_47) AT=1150.05n

.meas tran vdout1_48ck1140 FIND v(dout1_48) AT=1150.05n

.meas tran vdout1_49ck1140 FIND v(dout1_49) AT=1150.05n

.meas tran vdout1_50ck1140 FIND v(dout1_50) AT=1150.05n

.meas tran vdout1_51ck1140 FIND v(dout1_51) AT=1150.05n

.meas tran vdout1_52ck1140 FIND v(dout1_52) AT=1150.05n

.meas tran vdout1_53ck1140 FIND v(dout1_53) AT=1150.05n

.meas tran vdout1_54ck1140 FIND v(dout1_54) AT=1150.05n

.meas tran vdout1_55ck1140 FIND v(dout1_55) AT=1150.05n

.meas tran vdout1_56ck1140 FIND v(dout1_56) AT=1150.05n

.meas tran vdout1_57ck1140 FIND v(dout1_57) AT=1150.05n

.meas tran vdout1_58ck1140 FIND v(dout1_58) AT=1150.05n

.meas tran vdout1_59ck1140 FIND v(dout1_59) AT=1150.05n

.meas tran vdout1_60ck1140 FIND v(dout1_60) AT=1150.05n

.meas tran vdout1_61ck1140 FIND v(dout1_61) AT=1150.05n

.meas tran vdout1_62ck1140 FIND v(dout1_62) AT=1150.05n

.meas tran vdout1_63ck1140 FIND v(dout1_63) AT=1150.05n

.meas tran vdout1_64ck1140 FIND v(dout1_64) AT=1150.05n

.meas tran vdout1_65ck1140 FIND v(dout1_65) AT=1150.05n

.meas tran vdout1_66ck1140 FIND v(dout1_66) AT=1150.05n

.meas tran vdout1_67ck1140 FIND v(dout1_67) AT=1150.05n

.meas tran vdout1_68ck1140 FIND v(dout1_68) AT=1150.05n

.meas tran vdout1_69ck1140 FIND v(dout1_69) AT=1150.05n

.meas tran vdout1_70ck1140 FIND v(dout1_70) AT=1150.05n

.meas tran vdout1_71ck1140 FIND v(dout1_71) AT=1150.05n

.meas tran vdout1_72ck1140 FIND v(dout1_72) AT=1150.05n

.meas tran vdout1_73ck1140 FIND v(dout1_73) AT=1150.05n

.meas tran vdout1_74ck1140 FIND v(dout1_74) AT=1150.05n

.meas tran vdout1_75ck1140 FIND v(dout1_75) AT=1150.05n

.meas tran vdout1_76ck1140 FIND v(dout1_76) AT=1150.05n

.meas tran vdout1_77ck1140 FIND v(dout1_77) AT=1150.05n

.meas tran vdout1_78ck1140 FIND v(dout1_78) AT=1150.05n

.meas tran vdout1_79ck1140 FIND v(dout1_79) AT=1150.05n

.meas tran vdout1_80ck1140 FIND v(dout1_80) AT=1150.05n

.meas tran vdout1_81ck1140 FIND v(dout1_81) AT=1150.05n

.meas tran vdout1_82ck1140 FIND v(dout1_82) AT=1150.05n

.meas tran vdout1_83ck1140 FIND v(dout1_83) AT=1150.05n

.meas tran vdout1_84ck1140 FIND v(dout1_84) AT=1150.05n

.meas tran vdout1_85ck1140 FIND v(dout1_85) AT=1150.05n

.meas tran vdout1_86ck1140 FIND v(dout1_86) AT=1150.05n

.meas tran vdout1_87ck1140 FIND v(dout1_87) AT=1150.05n

.meas tran vdout1_88ck1140 FIND v(dout1_88) AT=1150.05n

.meas tran vdout1_89ck1140 FIND v(dout1_89) AT=1150.05n

.meas tran vdout1_90ck1140 FIND v(dout1_90) AT=1150.05n

.meas tran vdout1_91ck1140 FIND v(dout1_91) AT=1150.05n

.meas tran vdout1_92ck1140 FIND v(dout1_92) AT=1150.05n

.meas tran vdout1_93ck1140 FIND v(dout1_93) AT=1150.05n

.meas tran vdout1_94ck1140 FIND v(dout1_94) AT=1150.05n

.meas tran vdout1_95ck1140 FIND v(dout1_95) AT=1150.05n

.meas tran vdout1_96ck1140 FIND v(dout1_96) AT=1150.05n

.meas tran vdout1_97ck1140 FIND v(dout1_97) AT=1150.05n

.meas tran vdout1_98ck1140 FIND v(dout1_98) AT=1150.05n

.meas tran vdout1_99ck1140 FIND v(dout1_99) AT=1150.05n

.meas tran vdout1_100ck1140 FIND v(dout1_100) AT=1150.05n

.meas tran vdout1_101ck1140 FIND v(dout1_101) AT=1150.05n

.meas tran vdout1_102ck1140 FIND v(dout1_102) AT=1150.05n

.meas tran vdout1_103ck1140 FIND v(dout1_103) AT=1150.05n

.meas tran vdout1_104ck1140 FIND v(dout1_104) AT=1150.05n

.meas tran vdout1_105ck1140 FIND v(dout1_105) AT=1150.05n

.meas tran vdout1_106ck1140 FIND v(dout1_106) AT=1150.05n

.meas tran vdout1_107ck1140 FIND v(dout1_107) AT=1150.05n

.meas tran vdout1_108ck1140 FIND v(dout1_108) AT=1150.05n

.meas tran vdout1_109ck1140 FIND v(dout1_109) AT=1150.05n

.meas tran vdout1_110ck1140 FIND v(dout1_110) AT=1150.05n

.meas tran vdout1_111ck1140 FIND v(dout1_111) AT=1150.05n

.meas tran vdout1_112ck1140 FIND v(dout1_112) AT=1150.05n

.meas tran vdout1_113ck1140 FIND v(dout1_113) AT=1150.05n

.meas tran vdout1_114ck1140 FIND v(dout1_114) AT=1150.05n

.meas tran vdout1_115ck1140 FIND v(dout1_115) AT=1150.05n

.meas tran vdout1_116ck1140 FIND v(dout1_116) AT=1150.05n

.meas tran vdout1_117ck1140 FIND v(dout1_117) AT=1150.05n

.meas tran vdout1_118ck1140 FIND v(dout1_118) AT=1150.05n

.meas tran vdout1_119ck1140 FIND v(dout1_119) AT=1150.05n

.meas tran vdout1_120ck1140 FIND v(dout1_120) AT=1150.05n

.meas tran vdout1_121ck1140 FIND v(dout1_121) AT=1150.05n

.meas tran vdout1_122ck1140 FIND v(dout1_122) AT=1150.05n

.meas tran vdout1_123ck1140 FIND v(dout1_123) AT=1150.05n

.meas tran vdout1_124ck1140 FIND v(dout1_124) AT=1150.05n

.meas tran vdout1_125ck1140 FIND v(dout1_125) AT=1150.05n

.meas tran vdout1_126ck1140 FIND v(dout1_126) AT=1150.05n

.meas tran vdout1_127ck1140 FIND v(dout1_127) AT=1150.05n

.meas tran vdout1_128ck1140 FIND v(dout1_128) AT=1150.05n

.meas tran vdout1_129ck1140 FIND v(dout1_129) AT=1150.05n

.meas tran vdout1_130ck1140 FIND v(dout1_130) AT=1150.05n

.meas tran vdout1_131ck1140 FIND v(dout1_131) AT=1150.05n

.meas tran vdout1_132ck1140 FIND v(dout1_132) AT=1150.05n

.meas tran vdout1_133ck1140 FIND v(dout1_133) AT=1150.05n

.meas tran vdout1_134ck1140 FIND v(dout1_134) AT=1150.05n

.meas tran vdout1_135ck1140 FIND v(dout1_135) AT=1150.05n

.meas tran vdout1_136ck1140 FIND v(dout1_136) AT=1150.05n

.meas tran vdout1_137ck1140 FIND v(dout1_137) AT=1150.05n

.meas tran vdout1_138ck1140 FIND v(dout1_138) AT=1150.05n

.meas tran vdout1_139ck1140 FIND v(dout1_139) AT=1150.05n

.meas tran vdout1_140ck1140 FIND v(dout1_140) AT=1150.05n

.meas tran vdout1_141ck1140 FIND v(dout1_141) AT=1150.05n

.meas tran vdout1_142ck1140 FIND v(dout1_142) AT=1150.05n

.meas tran vdout1_143ck1140 FIND v(dout1_143) AT=1150.05n

.meas tran vdout1_144ck1140 FIND v(dout1_144) AT=1150.05n

.meas tran vdout1_145ck1140 FIND v(dout1_145) AT=1150.05n

.meas tran vdout1_146ck1140 FIND v(dout1_146) AT=1150.05n

.meas tran vdout1_147ck1140 FIND v(dout1_147) AT=1150.05n

.meas tran vdout1_148ck1140 FIND v(dout1_148) AT=1150.05n

.meas tran vdout1_149ck1140 FIND v(dout1_149) AT=1150.05n

.meas tran vdout1_150ck1140 FIND v(dout1_150) AT=1150.05n

.meas tran vdout1_151ck1140 FIND v(dout1_151) AT=1150.05n

.meas tran vdout1_152ck1140 FIND v(dout1_152) AT=1150.05n

.meas tran vdout1_153ck1140 FIND v(dout1_153) AT=1150.05n

.meas tran vdout1_154ck1140 FIND v(dout1_154) AT=1150.05n

.meas tran vdout1_155ck1140 FIND v(dout1_155) AT=1150.05n

.meas tran vdout1_156ck1140 FIND v(dout1_156) AT=1150.05n

.meas tran vdout1_157ck1140 FIND v(dout1_157) AT=1150.05n

.meas tran vdout1_158ck1140 FIND v(dout1_158) AT=1150.05n

.meas tran vdout1_159ck1140 FIND v(dout1_159) AT=1150.05n

.meas tran vdout1_160ck1140 FIND v(dout1_160) AT=1150.05n

.meas tran vdout1_161ck1140 FIND v(dout1_161) AT=1150.05n

.meas tran vdout1_162ck1140 FIND v(dout1_162) AT=1150.05n

.meas tran vdout1_163ck1140 FIND v(dout1_163) AT=1150.05n

.meas tran vdout1_164ck1140 FIND v(dout1_164) AT=1150.05n

.meas tran vdout1_165ck1140 FIND v(dout1_165) AT=1150.05n

.meas tran vdout1_166ck1140 FIND v(dout1_166) AT=1150.05n

.meas tran vdout1_167ck1140 FIND v(dout1_167) AT=1150.05n

.meas tran vdout1_168ck1140 FIND v(dout1_168) AT=1150.05n

.meas tran vdout1_169ck1140 FIND v(dout1_169) AT=1150.05n

.meas tran vdout1_170ck1140 FIND v(dout1_170) AT=1150.05n

.meas tran vdout1_171ck1140 FIND v(dout1_171) AT=1150.05n

.meas tran vdout1_172ck1140 FIND v(dout1_172) AT=1150.05n

.meas tran vdout1_173ck1140 FIND v(dout1_173) AT=1150.05n

.meas tran vdout1_174ck1140 FIND v(dout1_174) AT=1150.05n

.meas tran vdout1_175ck1140 FIND v(dout1_175) AT=1150.05n

.meas tran vdout1_176ck1140 FIND v(dout1_176) AT=1150.05n

.meas tran vdout1_177ck1140 FIND v(dout1_177) AT=1150.05n

.meas tran vdout1_178ck1140 FIND v(dout1_178) AT=1150.05n

.meas tran vdout1_179ck1140 FIND v(dout1_179) AT=1150.05n

.meas tran vdout1_180ck1140 FIND v(dout1_180) AT=1150.05n

.meas tran vdout1_181ck1140 FIND v(dout1_181) AT=1150.05n

.meas tran vdout1_182ck1140 FIND v(dout1_182) AT=1150.05n

.meas tran vdout1_183ck1140 FIND v(dout1_183) AT=1150.05n

.meas tran vdout1_184ck1140 FIND v(dout1_184) AT=1150.05n

.meas tran vdout1_185ck1140 FIND v(dout1_185) AT=1150.05n

.meas tran vdout1_186ck1140 FIND v(dout1_186) AT=1150.05n

.meas tran vdout1_187ck1140 FIND v(dout1_187) AT=1150.05n

.meas tran vdout1_188ck1140 FIND v(dout1_188) AT=1150.05n

.meas tran vdout1_189ck1140 FIND v(dout1_189) AT=1150.05n

.meas tran vdout1_190ck1140 FIND v(dout1_190) AT=1150.05n

.meas tran vdout1_191ck1140 FIND v(dout1_191) AT=1150.05n

.meas tran vdout1_192ck1140 FIND v(dout1_192) AT=1150.05n

.meas tran vdout1_193ck1140 FIND v(dout1_193) AT=1150.05n

.meas tran vdout1_194ck1140 FIND v(dout1_194) AT=1150.05n

.meas tran vdout1_195ck1140 FIND v(dout1_195) AT=1150.05n

.meas tran vdout1_196ck1140 FIND v(dout1_196) AT=1150.05n

.meas tran vdout1_197ck1140 FIND v(dout1_197) AT=1150.05n

.meas tran vdout1_198ck1140 FIND v(dout1_198) AT=1150.05n

.meas tran vdout1_199ck1140 FIND v(dout1_199) AT=1150.05n

.meas tran vdout1_200ck1140 FIND v(dout1_200) AT=1150.05n

.meas tran vdout1_201ck1140 FIND v(dout1_201) AT=1150.05n

.meas tran vdout1_202ck1140 FIND v(dout1_202) AT=1150.05n

.meas tran vdout1_203ck1140 FIND v(dout1_203) AT=1150.05n

.meas tran vdout1_204ck1140 FIND v(dout1_204) AT=1150.05n

.meas tran vdout1_205ck1140 FIND v(dout1_205) AT=1150.05n

.meas tran vdout1_206ck1140 FIND v(dout1_206) AT=1150.05n

.meas tran vdout1_207ck1140 FIND v(dout1_207) AT=1150.05n

.meas tran vdout1_208ck1140 FIND v(dout1_208) AT=1150.05n

.meas tran vdout1_209ck1140 FIND v(dout1_209) AT=1150.05n

.meas tran vdout1_210ck1140 FIND v(dout1_210) AT=1150.05n

.meas tran vdout1_211ck1140 FIND v(dout1_211) AT=1150.05n

.meas tran vdout1_212ck1140 FIND v(dout1_212) AT=1150.05n

.meas tran vdout1_213ck1140 FIND v(dout1_213) AT=1150.05n

.meas tran vdout1_214ck1140 FIND v(dout1_214) AT=1150.05n

.meas tran vdout1_215ck1140 FIND v(dout1_215) AT=1150.05n

.meas tran vdout1_216ck1140 FIND v(dout1_216) AT=1150.05n

.meas tran vdout1_217ck1140 FIND v(dout1_217) AT=1150.05n

.meas tran vdout1_218ck1140 FIND v(dout1_218) AT=1150.05n

.meas tran vdout1_219ck1140 FIND v(dout1_219) AT=1150.05n

.meas tran vdout1_220ck1140 FIND v(dout1_220) AT=1150.05n

.meas tran vdout1_221ck1140 FIND v(dout1_221) AT=1150.05n

.meas tran vdout1_222ck1140 FIND v(dout1_222) AT=1150.05n

.meas tran vdout1_223ck1140 FIND v(dout1_223) AT=1150.05n

.meas tran vdout1_224ck1140 FIND v(dout1_224) AT=1150.05n

.meas tran vdout1_225ck1140 FIND v(dout1_225) AT=1150.05n

.meas tran vdout1_226ck1140 FIND v(dout1_226) AT=1150.05n

.meas tran vdout1_227ck1140 FIND v(dout1_227) AT=1150.05n

.meas tran vdout1_228ck1140 FIND v(dout1_228) AT=1150.05n

.meas tran vdout1_229ck1140 FIND v(dout1_229) AT=1150.05n

.meas tran vdout1_230ck1140 FIND v(dout1_230) AT=1150.05n

.meas tran vdout1_231ck1140 FIND v(dout1_231) AT=1150.05n

.meas tran vdout1_232ck1140 FIND v(dout1_232) AT=1150.05n

.meas tran vdout1_233ck1140 FIND v(dout1_233) AT=1150.05n

.meas tran vdout1_234ck1140 FIND v(dout1_234) AT=1150.05n

.meas tran vdout1_235ck1140 FIND v(dout1_235) AT=1150.05n

.meas tran vdout1_236ck1140 FIND v(dout1_236) AT=1150.05n

.meas tran vdout1_237ck1140 FIND v(dout1_237) AT=1150.05n

.meas tran vdout1_238ck1140 FIND v(dout1_238) AT=1150.05n

.meas tran vdout1_239ck1140 FIND v(dout1_239) AT=1150.05n

.meas tran vdout1_240ck1140 FIND v(dout1_240) AT=1150.05n

.meas tran vdout1_241ck1140 FIND v(dout1_241) AT=1150.05n

.meas tran vdout1_242ck1140 FIND v(dout1_242) AT=1150.05n

.meas tran vdout1_243ck1140 FIND v(dout1_243) AT=1150.05n

.meas tran vdout1_244ck1140 FIND v(dout1_244) AT=1150.05n

.meas tran vdout1_245ck1140 FIND v(dout1_245) AT=1150.05n

.meas tran vdout1_246ck1140 FIND v(dout1_246) AT=1150.05n

.meas tran vdout1_247ck1140 FIND v(dout1_247) AT=1150.05n

.meas tran vdout1_248ck1140 FIND v(dout1_248) AT=1150.05n

.meas tran vdout1_249ck1140 FIND v(dout1_249) AT=1150.05n

.meas tran vdout1_250ck1140 FIND v(dout1_250) AT=1150.05n

.meas tran vdout1_251ck1140 FIND v(dout1_251) AT=1150.05n

.meas tran vdout1_252ck1140 FIND v(dout1_252) AT=1150.05n

.meas tran vdout1_253ck1140 FIND v(dout1_253) AT=1150.05n

.meas tran vdout1_254ck1140 FIND v(dout1_254) AT=1150.05n

.meas tran vdout1_255ck1140 FIND v(dout1_255) AT=1150.05n

.meas tran vdout1_256ck1140 FIND v(dout1_256) AT=1150.05n

.meas tran vdout1_0ck1240 FIND v(dout1_0) AT=1250.05n

.meas tran vdout1_1ck1240 FIND v(dout1_1) AT=1250.05n

.meas tran vdout1_2ck1240 FIND v(dout1_2) AT=1250.05n

.meas tran vdout1_3ck1240 FIND v(dout1_3) AT=1250.05n

.meas tran vdout1_4ck1240 FIND v(dout1_4) AT=1250.05n

.meas tran vdout1_5ck1240 FIND v(dout1_5) AT=1250.05n

.meas tran vdout1_6ck1240 FIND v(dout1_6) AT=1250.05n

.meas tran vdout1_7ck1240 FIND v(dout1_7) AT=1250.05n

.meas tran vdout1_8ck1240 FIND v(dout1_8) AT=1250.05n

.meas tran vdout1_9ck1240 FIND v(dout1_9) AT=1250.05n

.meas tran vdout1_10ck1240 FIND v(dout1_10) AT=1250.05n

.meas tran vdout1_11ck1240 FIND v(dout1_11) AT=1250.05n

.meas tran vdout1_12ck1240 FIND v(dout1_12) AT=1250.05n

.meas tran vdout1_13ck1240 FIND v(dout1_13) AT=1250.05n

.meas tran vdout1_14ck1240 FIND v(dout1_14) AT=1250.05n

.meas tran vdout1_15ck1240 FIND v(dout1_15) AT=1250.05n

.meas tran vdout1_16ck1240 FIND v(dout1_16) AT=1250.05n

.meas tran vdout1_17ck1240 FIND v(dout1_17) AT=1250.05n

.meas tran vdout1_18ck1240 FIND v(dout1_18) AT=1250.05n

.meas tran vdout1_19ck1240 FIND v(dout1_19) AT=1250.05n

.meas tran vdout1_20ck1240 FIND v(dout1_20) AT=1250.05n

.meas tran vdout1_21ck1240 FIND v(dout1_21) AT=1250.05n

.meas tran vdout1_22ck1240 FIND v(dout1_22) AT=1250.05n

.meas tran vdout1_23ck1240 FIND v(dout1_23) AT=1250.05n

.meas tran vdout1_24ck1240 FIND v(dout1_24) AT=1250.05n

.meas tran vdout1_25ck1240 FIND v(dout1_25) AT=1250.05n

.meas tran vdout1_26ck1240 FIND v(dout1_26) AT=1250.05n

.meas tran vdout1_27ck1240 FIND v(dout1_27) AT=1250.05n

.meas tran vdout1_28ck1240 FIND v(dout1_28) AT=1250.05n

.meas tran vdout1_29ck1240 FIND v(dout1_29) AT=1250.05n

.meas tran vdout1_30ck1240 FIND v(dout1_30) AT=1250.05n

.meas tran vdout1_31ck1240 FIND v(dout1_31) AT=1250.05n

.meas tran vdout1_32ck1240 FIND v(dout1_32) AT=1250.05n

.meas tran vdout1_33ck1240 FIND v(dout1_33) AT=1250.05n

.meas tran vdout1_34ck1240 FIND v(dout1_34) AT=1250.05n

.meas tran vdout1_35ck1240 FIND v(dout1_35) AT=1250.05n

.meas tran vdout1_36ck1240 FIND v(dout1_36) AT=1250.05n

.meas tran vdout1_37ck1240 FIND v(dout1_37) AT=1250.05n

.meas tran vdout1_38ck1240 FIND v(dout1_38) AT=1250.05n

.meas tran vdout1_39ck1240 FIND v(dout1_39) AT=1250.05n

.meas tran vdout1_40ck1240 FIND v(dout1_40) AT=1250.05n

.meas tran vdout1_41ck1240 FIND v(dout1_41) AT=1250.05n

.meas tran vdout1_42ck1240 FIND v(dout1_42) AT=1250.05n

.meas tran vdout1_43ck1240 FIND v(dout1_43) AT=1250.05n

.meas tran vdout1_44ck1240 FIND v(dout1_44) AT=1250.05n

.meas tran vdout1_45ck1240 FIND v(dout1_45) AT=1250.05n

.meas tran vdout1_46ck1240 FIND v(dout1_46) AT=1250.05n

.meas tran vdout1_47ck1240 FIND v(dout1_47) AT=1250.05n

.meas tran vdout1_48ck1240 FIND v(dout1_48) AT=1250.05n

.meas tran vdout1_49ck1240 FIND v(dout1_49) AT=1250.05n

.meas tran vdout1_50ck1240 FIND v(dout1_50) AT=1250.05n

.meas tran vdout1_51ck1240 FIND v(dout1_51) AT=1250.05n

.meas tran vdout1_52ck1240 FIND v(dout1_52) AT=1250.05n

.meas tran vdout1_53ck1240 FIND v(dout1_53) AT=1250.05n

.meas tran vdout1_54ck1240 FIND v(dout1_54) AT=1250.05n

.meas tran vdout1_55ck1240 FIND v(dout1_55) AT=1250.05n

.meas tran vdout1_56ck1240 FIND v(dout1_56) AT=1250.05n

.meas tran vdout1_57ck1240 FIND v(dout1_57) AT=1250.05n

.meas tran vdout1_58ck1240 FIND v(dout1_58) AT=1250.05n

.meas tran vdout1_59ck1240 FIND v(dout1_59) AT=1250.05n

.meas tran vdout1_60ck1240 FIND v(dout1_60) AT=1250.05n

.meas tran vdout1_61ck1240 FIND v(dout1_61) AT=1250.05n

.meas tran vdout1_62ck1240 FIND v(dout1_62) AT=1250.05n

.meas tran vdout1_63ck1240 FIND v(dout1_63) AT=1250.05n

.meas tran vdout1_64ck1240 FIND v(dout1_64) AT=1250.05n

.meas tran vdout1_65ck1240 FIND v(dout1_65) AT=1250.05n

.meas tran vdout1_66ck1240 FIND v(dout1_66) AT=1250.05n

.meas tran vdout1_67ck1240 FIND v(dout1_67) AT=1250.05n

.meas tran vdout1_68ck1240 FIND v(dout1_68) AT=1250.05n

.meas tran vdout1_69ck1240 FIND v(dout1_69) AT=1250.05n

.meas tran vdout1_70ck1240 FIND v(dout1_70) AT=1250.05n

.meas tran vdout1_71ck1240 FIND v(dout1_71) AT=1250.05n

.meas tran vdout1_72ck1240 FIND v(dout1_72) AT=1250.05n

.meas tran vdout1_73ck1240 FIND v(dout1_73) AT=1250.05n

.meas tran vdout1_74ck1240 FIND v(dout1_74) AT=1250.05n

.meas tran vdout1_75ck1240 FIND v(dout1_75) AT=1250.05n

.meas tran vdout1_76ck1240 FIND v(dout1_76) AT=1250.05n

.meas tran vdout1_77ck1240 FIND v(dout1_77) AT=1250.05n

.meas tran vdout1_78ck1240 FIND v(dout1_78) AT=1250.05n

.meas tran vdout1_79ck1240 FIND v(dout1_79) AT=1250.05n

.meas tran vdout1_80ck1240 FIND v(dout1_80) AT=1250.05n

.meas tran vdout1_81ck1240 FIND v(dout1_81) AT=1250.05n

.meas tran vdout1_82ck1240 FIND v(dout1_82) AT=1250.05n

.meas tran vdout1_83ck1240 FIND v(dout1_83) AT=1250.05n

.meas tran vdout1_84ck1240 FIND v(dout1_84) AT=1250.05n

.meas tran vdout1_85ck1240 FIND v(dout1_85) AT=1250.05n

.meas tran vdout1_86ck1240 FIND v(dout1_86) AT=1250.05n

.meas tran vdout1_87ck1240 FIND v(dout1_87) AT=1250.05n

.meas tran vdout1_88ck1240 FIND v(dout1_88) AT=1250.05n

.meas tran vdout1_89ck1240 FIND v(dout1_89) AT=1250.05n

.meas tran vdout1_90ck1240 FIND v(dout1_90) AT=1250.05n

.meas tran vdout1_91ck1240 FIND v(dout1_91) AT=1250.05n

.meas tran vdout1_92ck1240 FIND v(dout1_92) AT=1250.05n

.meas tran vdout1_93ck1240 FIND v(dout1_93) AT=1250.05n

.meas tran vdout1_94ck1240 FIND v(dout1_94) AT=1250.05n

.meas tran vdout1_95ck1240 FIND v(dout1_95) AT=1250.05n

.meas tran vdout1_96ck1240 FIND v(dout1_96) AT=1250.05n

.meas tran vdout1_97ck1240 FIND v(dout1_97) AT=1250.05n

.meas tran vdout1_98ck1240 FIND v(dout1_98) AT=1250.05n

.meas tran vdout1_99ck1240 FIND v(dout1_99) AT=1250.05n

.meas tran vdout1_100ck1240 FIND v(dout1_100) AT=1250.05n

.meas tran vdout1_101ck1240 FIND v(dout1_101) AT=1250.05n

.meas tran vdout1_102ck1240 FIND v(dout1_102) AT=1250.05n

.meas tran vdout1_103ck1240 FIND v(dout1_103) AT=1250.05n

.meas tran vdout1_104ck1240 FIND v(dout1_104) AT=1250.05n

.meas tran vdout1_105ck1240 FIND v(dout1_105) AT=1250.05n

.meas tran vdout1_106ck1240 FIND v(dout1_106) AT=1250.05n

.meas tran vdout1_107ck1240 FIND v(dout1_107) AT=1250.05n

.meas tran vdout1_108ck1240 FIND v(dout1_108) AT=1250.05n

.meas tran vdout1_109ck1240 FIND v(dout1_109) AT=1250.05n

.meas tran vdout1_110ck1240 FIND v(dout1_110) AT=1250.05n

.meas tran vdout1_111ck1240 FIND v(dout1_111) AT=1250.05n

.meas tran vdout1_112ck1240 FIND v(dout1_112) AT=1250.05n

.meas tran vdout1_113ck1240 FIND v(dout1_113) AT=1250.05n

.meas tran vdout1_114ck1240 FIND v(dout1_114) AT=1250.05n

.meas tran vdout1_115ck1240 FIND v(dout1_115) AT=1250.05n

.meas tran vdout1_116ck1240 FIND v(dout1_116) AT=1250.05n

.meas tran vdout1_117ck1240 FIND v(dout1_117) AT=1250.05n

.meas tran vdout1_118ck1240 FIND v(dout1_118) AT=1250.05n

.meas tran vdout1_119ck1240 FIND v(dout1_119) AT=1250.05n

.meas tran vdout1_120ck1240 FIND v(dout1_120) AT=1250.05n

.meas tran vdout1_121ck1240 FIND v(dout1_121) AT=1250.05n

.meas tran vdout1_122ck1240 FIND v(dout1_122) AT=1250.05n

.meas tran vdout1_123ck1240 FIND v(dout1_123) AT=1250.05n

.meas tran vdout1_124ck1240 FIND v(dout1_124) AT=1250.05n

.meas tran vdout1_125ck1240 FIND v(dout1_125) AT=1250.05n

.meas tran vdout1_126ck1240 FIND v(dout1_126) AT=1250.05n

.meas tran vdout1_127ck1240 FIND v(dout1_127) AT=1250.05n

.meas tran vdout1_128ck1240 FIND v(dout1_128) AT=1250.05n

.meas tran vdout1_129ck1240 FIND v(dout1_129) AT=1250.05n

.meas tran vdout1_130ck1240 FIND v(dout1_130) AT=1250.05n

.meas tran vdout1_131ck1240 FIND v(dout1_131) AT=1250.05n

.meas tran vdout1_132ck1240 FIND v(dout1_132) AT=1250.05n

.meas tran vdout1_133ck1240 FIND v(dout1_133) AT=1250.05n

.meas tran vdout1_134ck1240 FIND v(dout1_134) AT=1250.05n

.meas tran vdout1_135ck1240 FIND v(dout1_135) AT=1250.05n

.meas tran vdout1_136ck1240 FIND v(dout1_136) AT=1250.05n

.meas tran vdout1_137ck1240 FIND v(dout1_137) AT=1250.05n

.meas tran vdout1_138ck1240 FIND v(dout1_138) AT=1250.05n

.meas tran vdout1_139ck1240 FIND v(dout1_139) AT=1250.05n

.meas tran vdout1_140ck1240 FIND v(dout1_140) AT=1250.05n

.meas tran vdout1_141ck1240 FIND v(dout1_141) AT=1250.05n

.meas tran vdout1_142ck1240 FIND v(dout1_142) AT=1250.05n

.meas tran vdout1_143ck1240 FIND v(dout1_143) AT=1250.05n

.meas tran vdout1_144ck1240 FIND v(dout1_144) AT=1250.05n

.meas tran vdout1_145ck1240 FIND v(dout1_145) AT=1250.05n

.meas tran vdout1_146ck1240 FIND v(dout1_146) AT=1250.05n

.meas tran vdout1_147ck1240 FIND v(dout1_147) AT=1250.05n

.meas tran vdout1_148ck1240 FIND v(dout1_148) AT=1250.05n

.meas tran vdout1_149ck1240 FIND v(dout1_149) AT=1250.05n

.meas tran vdout1_150ck1240 FIND v(dout1_150) AT=1250.05n

.meas tran vdout1_151ck1240 FIND v(dout1_151) AT=1250.05n

.meas tran vdout1_152ck1240 FIND v(dout1_152) AT=1250.05n

.meas tran vdout1_153ck1240 FIND v(dout1_153) AT=1250.05n

.meas tran vdout1_154ck1240 FIND v(dout1_154) AT=1250.05n

.meas tran vdout1_155ck1240 FIND v(dout1_155) AT=1250.05n

.meas tran vdout1_156ck1240 FIND v(dout1_156) AT=1250.05n

.meas tran vdout1_157ck1240 FIND v(dout1_157) AT=1250.05n

.meas tran vdout1_158ck1240 FIND v(dout1_158) AT=1250.05n

.meas tran vdout1_159ck1240 FIND v(dout1_159) AT=1250.05n

.meas tran vdout1_160ck1240 FIND v(dout1_160) AT=1250.05n

.meas tran vdout1_161ck1240 FIND v(dout1_161) AT=1250.05n

.meas tran vdout1_162ck1240 FIND v(dout1_162) AT=1250.05n

.meas tran vdout1_163ck1240 FIND v(dout1_163) AT=1250.05n

.meas tran vdout1_164ck1240 FIND v(dout1_164) AT=1250.05n

.meas tran vdout1_165ck1240 FIND v(dout1_165) AT=1250.05n

.meas tran vdout1_166ck1240 FIND v(dout1_166) AT=1250.05n

.meas tran vdout1_167ck1240 FIND v(dout1_167) AT=1250.05n

.meas tran vdout1_168ck1240 FIND v(dout1_168) AT=1250.05n

.meas tran vdout1_169ck1240 FIND v(dout1_169) AT=1250.05n

.meas tran vdout1_170ck1240 FIND v(dout1_170) AT=1250.05n

.meas tran vdout1_171ck1240 FIND v(dout1_171) AT=1250.05n

.meas tran vdout1_172ck1240 FIND v(dout1_172) AT=1250.05n

.meas tran vdout1_173ck1240 FIND v(dout1_173) AT=1250.05n

.meas tran vdout1_174ck1240 FIND v(dout1_174) AT=1250.05n

.meas tran vdout1_175ck1240 FIND v(dout1_175) AT=1250.05n

.meas tran vdout1_176ck1240 FIND v(dout1_176) AT=1250.05n

.meas tran vdout1_177ck1240 FIND v(dout1_177) AT=1250.05n

.meas tran vdout1_178ck1240 FIND v(dout1_178) AT=1250.05n

.meas tran vdout1_179ck1240 FIND v(dout1_179) AT=1250.05n

.meas tran vdout1_180ck1240 FIND v(dout1_180) AT=1250.05n

.meas tran vdout1_181ck1240 FIND v(dout1_181) AT=1250.05n

.meas tran vdout1_182ck1240 FIND v(dout1_182) AT=1250.05n

.meas tran vdout1_183ck1240 FIND v(dout1_183) AT=1250.05n

.meas tran vdout1_184ck1240 FIND v(dout1_184) AT=1250.05n

.meas tran vdout1_185ck1240 FIND v(dout1_185) AT=1250.05n

.meas tran vdout1_186ck1240 FIND v(dout1_186) AT=1250.05n

.meas tran vdout1_187ck1240 FIND v(dout1_187) AT=1250.05n

.meas tran vdout1_188ck1240 FIND v(dout1_188) AT=1250.05n

.meas tran vdout1_189ck1240 FIND v(dout1_189) AT=1250.05n

.meas tran vdout1_190ck1240 FIND v(dout1_190) AT=1250.05n

.meas tran vdout1_191ck1240 FIND v(dout1_191) AT=1250.05n

.meas tran vdout1_192ck1240 FIND v(dout1_192) AT=1250.05n

.meas tran vdout1_193ck1240 FIND v(dout1_193) AT=1250.05n

.meas tran vdout1_194ck1240 FIND v(dout1_194) AT=1250.05n

.meas tran vdout1_195ck1240 FIND v(dout1_195) AT=1250.05n

.meas tran vdout1_196ck1240 FIND v(dout1_196) AT=1250.05n

.meas tran vdout1_197ck1240 FIND v(dout1_197) AT=1250.05n

.meas tran vdout1_198ck1240 FIND v(dout1_198) AT=1250.05n

.meas tran vdout1_199ck1240 FIND v(dout1_199) AT=1250.05n

.meas tran vdout1_200ck1240 FIND v(dout1_200) AT=1250.05n

.meas tran vdout1_201ck1240 FIND v(dout1_201) AT=1250.05n

.meas tran vdout1_202ck1240 FIND v(dout1_202) AT=1250.05n

.meas tran vdout1_203ck1240 FIND v(dout1_203) AT=1250.05n

.meas tran vdout1_204ck1240 FIND v(dout1_204) AT=1250.05n

.meas tran vdout1_205ck1240 FIND v(dout1_205) AT=1250.05n

.meas tran vdout1_206ck1240 FIND v(dout1_206) AT=1250.05n

.meas tran vdout1_207ck1240 FIND v(dout1_207) AT=1250.05n

.meas tran vdout1_208ck1240 FIND v(dout1_208) AT=1250.05n

.meas tran vdout1_209ck1240 FIND v(dout1_209) AT=1250.05n

.meas tran vdout1_210ck1240 FIND v(dout1_210) AT=1250.05n

.meas tran vdout1_211ck1240 FIND v(dout1_211) AT=1250.05n

.meas tran vdout1_212ck1240 FIND v(dout1_212) AT=1250.05n

.meas tran vdout1_213ck1240 FIND v(dout1_213) AT=1250.05n

.meas tran vdout1_214ck1240 FIND v(dout1_214) AT=1250.05n

.meas tran vdout1_215ck1240 FIND v(dout1_215) AT=1250.05n

.meas tran vdout1_216ck1240 FIND v(dout1_216) AT=1250.05n

.meas tran vdout1_217ck1240 FIND v(dout1_217) AT=1250.05n

.meas tran vdout1_218ck1240 FIND v(dout1_218) AT=1250.05n

.meas tran vdout1_219ck1240 FIND v(dout1_219) AT=1250.05n

.meas tran vdout1_220ck1240 FIND v(dout1_220) AT=1250.05n

.meas tran vdout1_221ck1240 FIND v(dout1_221) AT=1250.05n

.meas tran vdout1_222ck1240 FIND v(dout1_222) AT=1250.05n

.meas tran vdout1_223ck1240 FIND v(dout1_223) AT=1250.05n

.meas tran vdout1_224ck1240 FIND v(dout1_224) AT=1250.05n

.meas tran vdout1_225ck1240 FIND v(dout1_225) AT=1250.05n

.meas tran vdout1_226ck1240 FIND v(dout1_226) AT=1250.05n

.meas tran vdout1_227ck1240 FIND v(dout1_227) AT=1250.05n

.meas tran vdout1_228ck1240 FIND v(dout1_228) AT=1250.05n

.meas tran vdout1_229ck1240 FIND v(dout1_229) AT=1250.05n

.meas tran vdout1_230ck1240 FIND v(dout1_230) AT=1250.05n

.meas tran vdout1_231ck1240 FIND v(dout1_231) AT=1250.05n

.meas tran vdout1_232ck1240 FIND v(dout1_232) AT=1250.05n

.meas tran vdout1_233ck1240 FIND v(dout1_233) AT=1250.05n

.meas tran vdout1_234ck1240 FIND v(dout1_234) AT=1250.05n

.meas tran vdout1_235ck1240 FIND v(dout1_235) AT=1250.05n

.meas tran vdout1_236ck1240 FIND v(dout1_236) AT=1250.05n

.meas tran vdout1_237ck1240 FIND v(dout1_237) AT=1250.05n

.meas tran vdout1_238ck1240 FIND v(dout1_238) AT=1250.05n

.meas tran vdout1_239ck1240 FIND v(dout1_239) AT=1250.05n

.meas tran vdout1_240ck1240 FIND v(dout1_240) AT=1250.05n

.meas tran vdout1_241ck1240 FIND v(dout1_241) AT=1250.05n

.meas tran vdout1_242ck1240 FIND v(dout1_242) AT=1250.05n

.meas tran vdout1_243ck1240 FIND v(dout1_243) AT=1250.05n

.meas tran vdout1_244ck1240 FIND v(dout1_244) AT=1250.05n

.meas tran vdout1_245ck1240 FIND v(dout1_245) AT=1250.05n

.meas tran vdout1_246ck1240 FIND v(dout1_246) AT=1250.05n

.meas tran vdout1_247ck1240 FIND v(dout1_247) AT=1250.05n

.meas tran vdout1_248ck1240 FIND v(dout1_248) AT=1250.05n

.meas tran vdout1_249ck1240 FIND v(dout1_249) AT=1250.05n

.meas tran vdout1_250ck1240 FIND v(dout1_250) AT=1250.05n

.meas tran vdout1_251ck1240 FIND v(dout1_251) AT=1250.05n

.meas tran vdout1_252ck1240 FIND v(dout1_252) AT=1250.05n

.meas tran vdout1_253ck1240 FIND v(dout1_253) AT=1250.05n

.meas tran vdout1_254ck1240 FIND v(dout1_254) AT=1250.05n

.meas tran vdout1_255ck1240 FIND v(dout1_255) AT=1250.05n

.meas tran vdout1_256ck1240 FIND v(dout1_256) AT=1250.05n

.meas tran vdout1_0ck1250 FIND v(dout1_0) AT=1260.05n

.meas tran vdout1_1ck1250 FIND v(dout1_1) AT=1260.05n

.meas tran vdout1_2ck1250 FIND v(dout1_2) AT=1260.05n

.meas tran vdout1_3ck1250 FIND v(dout1_3) AT=1260.05n

.meas tran vdout1_4ck1250 FIND v(dout1_4) AT=1260.05n

.meas tran vdout1_5ck1250 FIND v(dout1_5) AT=1260.05n

.meas tran vdout1_6ck1250 FIND v(dout1_6) AT=1260.05n

.meas tran vdout1_7ck1250 FIND v(dout1_7) AT=1260.05n

.meas tran vdout1_8ck1250 FIND v(dout1_8) AT=1260.05n

.meas tran vdout1_9ck1250 FIND v(dout1_9) AT=1260.05n

.meas tran vdout1_10ck1250 FIND v(dout1_10) AT=1260.05n

.meas tran vdout1_11ck1250 FIND v(dout1_11) AT=1260.05n

.meas tran vdout1_12ck1250 FIND v(dout1_12) AT=1260.05n

.meas tran vdout1_13ck1250 FIND v(dout1_13) AT=1260.05n

.meas tran vdout1_14ck1250 FIND v(dout1_14) AT=1260.05n

.meas tran vdout1_15ck1250 FIND v(dout1_15) AT=1260.05n

.meas tran vdout1_16ck1250 FIND v(dout1_16) AT=1260.05n

.meas tran vdout1_17ck1250 FIND v(dout1_17) AT=1260.05n

.meas tran vdout1_18ck1250 FIND v(dout1_18) AT=1260.05n

.meas tran vdout1_19ck1250 FIND v(dout1_19) AT=1260.05n

.meas tran vdout1_20ck1250 FIND v(dout1_20) AT=1260.05n

.meas tran vdout1_21ck1250 FIND v(dout1_21) AT=1260.05n

.meas tran vdout1_22ck1250 FIND v(dout1_22) AT=1260.05n

.meas tran vdout1_23ck1250 FIND v(dout1_23) AT=1260.05n

.meas tran vdout1_24ck1250 FIND v(dout1_24) AT=1260.05n

.meas tran vdout1_25ck1250 FIND v(dout1_25) AT=1260.05n

.meas tran vdout1_26ck1250 FIND v(dout1_26) AT=1260.05n

.meas tran vdout1_27ck1250 FIND v(dout1_27) AT=1260.05n

.meas tran vdout1_28ck1250 FIND v(dout1_28) AT=1260.05n

.meas tran vdout1_29ck1250 FIND v(dout1_29) AT=1260.05n

.meas tran vdout1_30ck1250 FIND v(dout1_30) AT=1260.05n

.meas tran vdout1_31ck1250 FIND v(dout1_31) AT=1260.05n

.meas tran vdout1_32ck1250 FIND v(dout1_32) AT=1260.05n

.meas tran vdout1_33ck1250 FIND v(dout1_33) AT=1260.05n

.meas tran vdout1_34ck1250 FIND v(dout1_34) AT=1260.05n

.meas tran vdout1_35ck1250 FIND v(dout1_35) AT=1260.05n

.meas tran vdout1_36ck1250 FIND v(dout1_36) AT=1260.05n

.meas tran vdout1_37ck1250 FIND v(dout1_37) AT=1260.05n

.meas tran vdout1_38ck1250 FIND v(dout1_38) AT=1260.05n

.meas tran vdout1_39ck1250 FIND v(dout1_39) AT=1260.05n

.meas tran vdout1_40ck1250 FIND v(dout1_40) AT=1260.05n

.meas tran vdout1_41ck1250 FIND v(dout1_41) AT=1260.05n

.meas tran vdout1_42ck1250 FIND v(dout1_42) AT=1260.05n

.meas tran vdout1_43ck1250 FIND v(dout1_43) AT=1260.05n

.meas tran vdout1_44ck1250 FIND v(dout1_44) AT=1260.05n

.meas tran vdout1_45ck1250 FIND v(dout1_45) AT=1260.05n

.meas tran vdout1_46ck1250 FIND v(dout1_46) AT=1260.05n

.meas tran vdout1_47ck1250 FIND v(dout1_47) AT=1260.05n

.meas tran vdout1_48ck1250 FIND v(dout1_48) AT=1260.05n

.meas tran vdout1_49ck1250 FIND v(dout1_49) AT=1260.05n

.meas tran vdout1_50ck1250 FIND v(dout1_50) AT=1260.05n

.meas tran vdout1_51ck1250 FIND v(dout1_51) AT=1260.05n

.meas tran vdout1_52ck1250 FIND v(dout1_52) AT=1260.05n

.meas tran vdout1_53ck1250 FIND v(dout1_53) AT=1260.05n

.meas tran vdout1_54ck1250 FIND v(dout1_54) AT=1260.05n

.meas tran vdout1_55ck1250 FIND v(dout1_55) AT=1260.05n

.meas tran vdout1_56ck1250 FIND v(dout1_56) AT=1260.05n

.meas tran vdout1_57ck1250 FIND v(dout1_57) AT=1260.05n

.meas tran vdout1_58ck1250 FIND v(dout1_58) AT=1260.05n

.meas tran vdout1_59ck1250 FIND v(dout1_59) AT=1260.05n

.meas tran vdout1_60ck1250 FIND v(dout1_60) AT=1260.05n

.meas tran vdout1_61ck1250 FIND v(dout1_61) AT=1260.05n

.meas tran vdout1_62ck1250 FIND v(dout1_62) AT=1260.05n

.meas tran vdout1_63ck1250 FIND v(dout1_63) AT=1260.05n

.meas tran vdout1_64ck1250 FIND v(dout1_64) AT=1260.05n

.meas tran vdout1_65ck1250 FIND v(dout1_65) AT=1260.05n

.meas tran vdout1_66ck1250 FIND v(dout1_66) AT=1260.05n

.meas tran vdout1_67ck1250 FIND v(dout1_67) AT=1260.05n

.meas tran vdout1_68ck1250 FIND v(dout1_68) AT=1260.05n

.meas tran vdout1_69ck1250 FIND v(dout1_69) AT=1260.05n

.meas tran vdout1_70ck1250 FIND v(dout1_70) AT=1260.05n

.meas tran vdout1_71ck1250 FIND v(dout1_71) AT=1260.05n

.meas tran vdout1_72ck1250 FIND v(dout1_72) AT=1260.05n

.meas tran vdout1_73ck1250 FIND v(dout1_73) AT=1260.05n

.meas tran vdout1_74ck1250 FIND v(dout1_74) AT=1260.05n

.meas tran vdout1_75ck1250 FIND v(dout1_75) AT=1260.05n

.meas tran vdout1_76ck1250 FIND v(dout1_76) AT=1260.05n

.meas tran vdout1_77ck1250 FIND v(dout1_77) AT=1260.05n

.meas tran vdout1_78ck1250 FIND v(dout1_78) AT=1260.05n

.meas tran vdout1_79ck1250 FIND v(dout1_79) AT=1260.05n

.meas tran vdout1_80ck1250 FIND v(dout1_80) AT=1260.05n

.meas tran vdout1_81ck1250 FIND v(dout1_81) AT=1260.05n

.meas tran vdout1_82ck1250 FIND v(dout1_82) AT=1260.05n

.meas tran vdout1_83ck1250 FIND v(dout1_83) AT=1260.05n

.meas tran vdout1_84ck1250 FIND v(dout1_84) AT=1260.05n

.meas tran vdout1_85ck1250 FIND v(dout1_85) AT=1260.05n

.meas tran vdout1_86ck1250 FIND v(dout1_86) AT=1260.05n

.meas tran vdout1_87ck1250 FIND v(dout1_87) AT=1260.05n

.meas tran vdout1_88ck1250 FIND v(dout1_88) AT=1260.05n

.meas tran vdout1_89ck1250 FIND v(dout1_89) AT=1260.05n

.meas tran vdout1_90ck1250 FIND v(dout1_90) AT=1260.05n

.meas tran vdout1_91ck1250 FIND v(dout1_91) AT=1260.05n

.meas tran vdout1_92ck1250 FIND v(dout1_92) AT=1260.05n

.meas tran vdout1_93ck1250 FIND v(dout1_93) AT=1260.05n

.meas tran vdout1_94ck1250 FIND v(dout1_94) AT=1260.05n

.meas tran vdout1_95ck1250 FIND v(dout1_95) AT=1260.05n

.meas tran vdout1_96ck1250 FIND v(dout1_96) AT=1260.05n

.meas tran vdout1_97ck1250 FIND v(dout1_97) AT=1260.05n

.meas tran vdout1_98ck1250 FIND v(dout1_98) AT=1260.05n

.meas tran vdout1_99ck1250 FIND v(dout1_99) AT=1260.05n

.meas tran vdout1_100ck1250 FIND v(dout1_100) AT=1260.05n

.meas tran vdout1_101ck1250 FIND v(dout1_101) AT=1260.05n

.meas tran vdout1_102ck1250 FIND v(dout1_102) AT=1260.05n

.meas tran vdout1_103ck1250 FIND v(dout1_103) AT=1260.05n

.meas tran vdout1_104ck1250 FIND v(dout1_104) AT=1260.05n

.meas tran vdout1_105ck1250 FIND v(dout1_105) AT=1260.05n

.meas tran vdout1_106ck1250 FIND v(dout1_106) AT=1260.05n

.meas tran vdout1_107ck1250 FIND v(dout1_107) AT=1260.05n

.meas tran vdout1_108ck1250 FIND v(dout1_108) AT=1260.05n

.meas tran vdout1_109ck1250 FIND v(dout1_109) AT=1260.05n

.meas tran vdout1_110ck1250 FIND v(dout1_110) AT=1260.05n

.meas tran vdout1_111ck1250 FIND v(dout1_111) AT=1260.05n

.meas tran vdout1_112ck1250 FIND v(dout1_112) AT=1260.05n

.meas tran vdout1_113ck1250 FIND v(dout1_113) AT=1260.05n

.meas tran vdout1_114ck1250 FIND v(dout1_114) AT=1260.05n

.meas tran vdout1_115ck1250 FIND v(dout1_115) AT=1260.05n

.meas tran vdout1_116ck1250 FIND v(dout1_116) AT=1260.05n

.meas tran vdout1_117ck1250 FIND v(dout1_117) AT=1260.05n

.meas tran vdout1_118ck1250 FIND v(dout1_118) AT=1260.05n

.meas tran vdout1_119ck1250 FIND v(dout1_119) AT=1260.05n

.meas tran vdout1_120ck1250 FIND v(dout1_120) AT=1260.05n

.meas tran vdout1_121ck1250 FIND v(dout1_121) AT=1260.05n

.meas tran vdout1_122ck1250 FIND v(dout1_122) AT=1260.05n

.meas tran vdout1_123ck1250 FIND v(dout1_123) AT=1260.05n

.meas tran vdout1_124ck1250 FIND v(dout1_124) AT=1260.05n

.meas tran vdout1_125ck1250 FIND v(dout1_125) AT=1260.05n

.meas tran vdout1_126ck1250 FIND v(dout1_126) AT=1260.05n

.meas tran vdout1_127ck1250 FIND v(dout1_127) AT=1260.05n

.meas tran vdout1_128ck1250 FIND v(dout1_128) AT=1260.05n

.meas tran vdout1_129ck1250 FIND v(dout1_129) AT=1260.05n

.meas tran vdout1_130ck1250 FIND v(dout1_130) AT=1260.05n

.meas tran vdout1_131ck1250 FIND v(dout1_131) AT=1260.05n

.meas tran vdout1_132ck1250 FIND v(dout1_132) AT=1260.05n

.meas tran vdout1_133ck1250 FIND v(dout1_133) AT=1260.05n

.meas tran vdout1_134ck1250 FIND v(dout1_134) AT=1260.05n

.meas tran vdout1_135ck1250 FIND v(dout1_135) AT=1260.05n

.meas tran vdout1_136ck1250 FIND v(dout1_136) AT=1260.05n

.meas tran vdout1_137ck1250 FIND v(dout1_137) AT=1260.05n

.meas tran vdout1_138ck1250 FIND v(dout1_138) AT=1260.05n

.meas tran vdout1_139ck1250 FIND v(dout1_139) AT=1260.05n

.meas tran vdout1_140ck1250 FIND v(dout1_140) AT=1260.05n

.meas tran vdout1_141ck1250 FIND v(dout1_141) AT=1260.05n

.meas tran vdout1_142ck1250 FIND v(dout1_142) AT=1260.05n

.meas tran vdout1_143ck1250 FIND v(dout1_143) AT=1260.05n

.meas tran vdout1_144ck1250 FIND v(dout1_144) AT=1260.05n

.meas tran vdout1_145ck1250 FIND v(dout1_145) AT=1260.05n

.meas tran vdout1_146ck1250 FIND v(dout1_146) AT=1260.05n

.meas tran vdout1_147ck1250 FIND v(dout1_147) AT=1260.05n

.meas tran vdout1_148ck1250 FIND v(dout1_148) AT=1260.05n

.meas tran vdout1_149ck1250 FIND v(dout1_149) AT=1260.05n

.meas tran vdout1_150ck1250 FIND v(dout1_150) AT=1260.05n

.meas tran vdout1_151ck1250 FIND v(dout1_151) AT=1260.05n

.meas tran vdout1_152ck1250 FIND v(dout1_152) AT=1260.05n

.meas tran vdout1_153ck1250 FIND v(dout1_153) AT=1260.05n

.meas tran vdout1_154ck1250 FIND v(dout1_154) AT=1260.05n

.meas tran vdout1_155ck1250 FIND v(dout1_155) AT=1260.05n

.meas tran vdout1_156ck1250 FIND v(dout1_156) AT=1260.05n

.meas tran vdout1_157ck1250 FIND v(dout1_157) AT=1260.05n

.meas tran vdout1_158ck1250 FIND v(dout1_158) AT=1260.05n

.meas tran vdout1_159ck1250 FIND v(dout1_159) AT=1260.05n

.meas tran vdout1_160ck1250 FIND v(dout1_160) AT=1260.05n

.meas tran vdout1_161ck1250 FIND v(dout1_161) AT=1260.05n

.meas tran vdout1_162ck1250 FIND v(dout1_162) AT=1260.05n

.meas tran vdout1_163ck1250 FIND v(dout1_163) AT=1260.05n

.meas tran vdout1_164ck1250 FIND v(dout1_164) AT=1260.05n

.meas tran vdout1_165ck1250 FIND v(dout1_165) AT=1260.05n

.meas tran vdout1_166ck1250 FIND v(dout1_166) AT=1260.05n

.meas tran vdout1_167ck1250 FIND v(dout1_167) AT=1260.05n

.meas tran vdout1_168ck1250 FIND v(dout1_168) AT=1260.05n

.meas tran vdout1_169ck1250 FIND v(dout1_169) AT=1260.05n

.meas tran vdout1_170ck1250 FIND v(dout1_170) AT=1260.05n

.meas tran vdout1_171ck1250 FIND v(dout1_171) AT=1260.05n

.meas tran vdout1_172ck1250 FIND v(dout1_172) AT=1260.05n

.meas tran vdout1_173ck1250 FIND v(dout1_173) AT=1260.05n

.meas tran vdout1_174ck1250 FIND v(dout1_174) AT=1260.05n

.meas tran vdout1_175ck1250 FIND v(dout1_175) AT=1260.05n

.meas tran vdout1_176ck1250 FIND v(dout1_176) AT=1260.05n

.meas tran vdout1_177ck1250 FIND v(dout1_177) AT=1260.05n

.meas tran vdout1_178ck1250 FIND v(dout1_178) AT=1260.05n

.meas tran vdout1_179ck1250 FIND v(dout1_179) AT=1260.05n

.meas tran vdout1_180ck1250 FIND v(dout1_180) AT=1260.05n

.meas tran vdout1_181ck1250 FIND v(dout1_181) AT=1260.05n

.meas tran vdout1_182ck1250 FIND v(dout1_182) AT=1260.05n

.meas tran vdout1_183ck1250 FIND v(dout1_183) AT=1260.05n

.meas tran vdout1_184ck1250 FIND v(dout1_184) AT=1260.05n

.meas tran vdout1_185ck1250 FIND v(dout1_185) AT=1260.05n

.meas tran vdout1_186ck1250 FIND v(dout1_186) AT=1260.05n

.meas tran vdout1_187ck1250 FIND v(dout1_187) AT=1260.05n

.meas tran vdout1_188ck1250 FIND v(dout1_188) AT=1260.05n

.meas tran vdout1_189ck1250 FIND v(dout1_189) AT=1260.05n

.meas tran vdout1_190ck1250 FIND v(dout1_190) AT=1260.05n

.meas tran vdout1_191ck1250 FIND v(dout1_191) AT=1260.05n

.meas tran vdout1_192ck1250 FIND v(dout1_192) AT=1260.05n

.meas tran vdout1_193ck1250 FIND v(dout1_193) AT=1260.05n

.meas tran vdout1_194ck1250 FIND v(dout1_194) AT=1260.05n

.meas tran vdout1_195ck1250 FIND v(dout1_195) AT=1260.05n

.meas tran vdout1_196ck1250 FIND v(dout1_196) AT=1260.05n

.meas tran vdout1_197ck1250 FIND v(dout1_197) AT=1260.05n

.meas tran vdout1_198ck1250 FIND v(dout1_198) AT=1260.05n

.meas tran vdout1_199ck1250 FIND v(dout1_199) AT=1260.05n

.meas tran vdout1_200ck1250 FIND v(dout1_200) AT=1260.05n

.meas tran vdout1_201ck1250 FIND v(dout1_201) AT=1260.05n

.meas tran vdout1_202ck1250 FIND v(dout1_202) AT=1260.05n

.meas tran vdout1_203ck1250 FIND v(dout1_203) AT=1260.05n

.meas tran vdout1_204ck1250 FIND v(dout1_204) AT=1260.05n

.meas tran vdout1_205ck1250 FIND v(dout1_205) AT=1260.05n

.meas tran vdout1_206ck1250 FIND v(dout1_206) AT=1260.05n

.meas tran vdout1_207ck1250 FIND v(dout1_207) AT=1260.05n

.meas tran vdout1_208ck1250 FIND v(dout1_208) AT=1260.05n

.meas tran vdout1_209ck1250 FIND v(dout1_209) AT=1260.05n

.meas tran vdout1_210ck1250 FIND v(dout1_210) AT=1260.05n

.meas tran vdout1_211ck1250 FIND v(dout1_211) AT=1260.05n

.meas tran vdout1_212ck1250 FIND v(dout1_212) AT=1260.05n

.meas tran vdout1_213ck1250 FIND v(dout1_213) AT=1260.05n

.meas tran vdout1_214ck1250 FIND v(dout1_214) AT=1260.05n

.meas tran vdout1_215ck1250 FIND v(dout1_215) AT=1260.05n

.meas tran vdout1_216ck1250 FIND v(dout1_216) AT=1260.05n

.meas tran vdout1_217ck1250 FIND v(dout1_217) AT=1260.05n

.meas tran vdout1_218ck1250 FIND v(dout1_218) AT=1260.05n

.meas tran vdout1_219ck1250 FIND v(dout1_219) AT=1260.05n

.meas tran vdout1_220ck1250 FIND v(dout1_220) AT=1260.05n

.meas tran vdout1_221ck1250 FIND v(dout1_221) AT=1260.05n

.meas tran vdout1_222ck1250 FIND v(dout1_222) AT=1260.05n

.meas tran vdout1_223ck1250 FIND v(dout1_223) AT=1260.05n

.meas tran vdout1_224ck1250 FIND v(dout1_224) AT=1260.05n

.meas tran vdout1_225ck1250 FIND v(dout1_225) AT=1260.05n

.meas tran vdout1_226ck1250 FIND v(dout1_226) AT=1260.05n

.meas tran vdout1_227ck1250 FIND v(dout1_227) AT=1260.05n

.meas tran vdout1_228ck1250 FIND v(dout1_228) AT=1260.05n

.meas tran vdout1_229ck1250 FIND v(dout1_229) AT=1260.05n

.meas tran vdout1_230ck1250 FIND v(dout1_230) AT=1260.05n

.meas tran vdout1_231ck1250 FIND v(dout1_231) AT=1260.05n

.meas tran vdout1_232ck1250 FIND v(dout1_232) AT=1260.05n

.meas tran vdout1_233ck1250 FIND v(dout1_233) AT=1260.05n

.meas tran vdout1_234ck1250 FIND v(dout1_234) AT=1260.05n

.meas tran vdout1_235ck1250 FIND v(dout1_235) AT=1260.05n

.meas tran vdout1_236ck1250 FIND v(dout1_236) AT=1260.05n

.meas tran vdout1_237ck1250 FIND v(dout1_237) AT=1260.05n

.meas tran vdout1_238ck1250 FIND v(dout1_238) AT=1260.05n

.meas tran vdout1_239ck1250 FIND v(dout1_239) AT=1260.05n

.meas tran vdout1_240ck1250 FIND v(dout1_240) AT=1260.05n

.meas tran vdout1_241ck1250 FIND v(dout1_241) AT=1260.05n

.meas tran vdout1_242ck1250 FIND v(dout1_242) AT=1260.05n

.meas tran vdout1_243ck1250 FIND v(dout1_243) AT=1260.05n

.meas tran vdout1_244ck1250 FIND v(dout1_244) AT=1260.05n

.meas tran vdout1_245ck1250 FIND v(dout1_245) AT=1260.05n

.meas tran vdout1_246ck1250 FIND v(dout1_246) AT=1260.05n

.meas tran vdout1_247ck1250 FIND v(dout1_247) AT=1260.05n

.meas tran vdout1_248ck1250 FIND v(dout1_248) AT=1260.05n

.meas tran vdout1_249ck1250 FIND v(dout1_249) AT=1260.05n

.meas tran vdout1_250ck1250 FIND v(dout1_250) AT=1260.05n

.meas tran vdout1_251ck1250 FIND v(dout1_251) AT=1260.05n

.meas tran vdout1_252ck1250 FIND v(dout1_252) AT=1260.05n

.meas tran vdout1_253ck1250 FIND v(dout1_253) AT=1260.05n

.meas tran vdout1_254ck1250 FIND v(dout1_254) AT=1260.05n

.meas tran vdout1_255ck1250 FIND v(dout1_255) AT=1260.05n

.meas tran vdout1_256ck1250 FIND v(dout1_256) AT=1260.05n

.meas tran vdout1_0ck1280 FIND v(dout1_0) AT=1290.05n

.meas tran vdout1_1ck1280 FIND v(dout1_1) AT=1290.05n

.meas tran vdout1_2ck1280 FIND v(dout1_2) AT=1290.05n

.meas tran vdout1_3ck1280 FIND v(dout1_3) AT=1290.05n

.meas tran vdout1_4ck1280 FIND v(dout1_4) AT=1290.05n

.meas tran vdout1_5ck1280 FIND v(dout1_5) AT=1290.05n

.meas tran vdout1_6ck1280 FIND v(dout1_6) AT=1290.05n

.meas tran vdout1_7ck1280 FIND v(dout1_7) AT=1290.05n

.meas tran vdout1_8ck1280 FIND v(dout1_8) AT=1290.05n

.meas tran vdout1_9ck1280 FIND v(dout1_9) AT=1290.05n

.meas tran vdout1_10ck1280 FIND v(dout1_10) AT=1290.05n

.meas tran vdout1_11ck1280 FIND v(dout1_11) AT=1290.05n

.meas tran vdout1_12ck1280 FIND v(dout1_12) AT=1290.05n

.meas tran vdout1_13ck1280 FIND v(dout1_13) AT=1290.05n

.meas tran vdout1_14ck1280 FIND v(dout1_14) AT=1290.05n

.meas tran vdout1_15ck1280 FIND v(dout1_15) AT=1290.05n

.meas tran vdout1_16ck1280 FIND v(dout1_16) AT=1290.05n

.meas tran vdout1_17ck1280 FIND v(dout1_17) AT=1290.05n

.meas tran vdout1_18ck1280 FIND v(dout1_18) AT=1290.05n

.meas tran vdout1_19ck1280 FIND v(dout1_19) AT=1290.05n

.meas tran vdout1_20ck1280 FIND v(dout1_20) AT=1290.05n

.meas tran vdout1_21ck1280 FIND v(dout1_21) AT=1290.05n

.meas tran vdout1_22ck1280 FIND v(dout1_22) AT=1290.05n

.meas tran vdout1_23ck1280 FIND v(dout1_23) AT=1290.05n

.meas tran vdout1_24ck1280 FIND v(dout1_24) AT=1290.05n

.meas tran vdout1_25ck1280 FIND v(dout1_25) AT=1290.05n

.meas tran vdout1_26ck1280 FIND v(dout1_26) AT=1290.05n

.meas tran vdout1_27ck1280 FIND v(dout1_27) AT=1290.05n

.meas tran vdout1_28ck1280 FIND v(dout1_28) AT=1290.05n

.meas tran vdout1_29ck1280 FIND v(dout1_29) AT=1290.05n

.meas tran vdout1_30ck1280 FIND v(dout1_30) AT=1290.05n

.meas tran vdout1_31ck1280 FIND v(dout1_31) AT=1290.05n

.meas tran vdout1_32ck1280 FIND v(dout1_32) AT=1290.05n

.meas tran vdout1_33ck1280 FIND v(dout1_33) AT=1290.05n

.meas tran vdout1_34ck1280 FIND v(dout1_34) AT=1290.05n

.meas tran vdout1_35ck1280 FIND v(dout1_35) AT=1290.05n

.meas tran vdout1_36ck1280 FIND v(dout1_36) AT=1290.05n

.meas tran vdout1_37ck1280 FIND v(dout1_37) AT=1290.05n

.meas tran vdout1_38ck1280 FIND v(dout1_38) AT=1290.05n

.meas tran vdout1_39ck1280 FIND v(dout1_39) AT=1290.05n

.meas tran vdout1_40ck1280 FIND v(dout1_40) AT=1290.05n

.meas tran vdout1_41ck1280 FIND v(dout1_41) AT=1290.05n

.meas tran vdout1_42ck1280 FIND v(dout1_42) AT=1290.05n

.meas tran vdout1_43ck1280 FIND v(dout1_43) AT=1290.05n

.meas tran vdout1_44ck1280 FIND v(dout1_44) AT=1290.05n

.meas tran vdout1_45ck1280 FIND v(dout1_45) AT=1290.05n

.meas tran vdout1_46ck1280 FIND v(dout1_46) AT=1290.05n

.meas tran vdout1_47ck1280 FIND v(dout1_47) AT=1290.05n

.meas tran vdout1_48ck1280 FIND v(dout1_48) AT=1290.05n

.meas tran vdout1_49ck1280 FIND v(dout1_49) AT=1290.05n

.meas tran vdout1_50ck1280 FIND v(dout1_50) AT=1290.05n

.meas tran vdout1_51ck1280 FIND v(dout1_51) AT=1290.05n

.meas tran vdout1_52ck1280 FIND v(dout1_52) AT=1290.05n

.meas tran vdout1_53ck1280 FIND v(dout1_53) AT=1290.05n

.meas tran vdout1_54ck1280 FIND v(dout1_54) AT=1290.05n

.meas tran vdout1_55ck1280 FIND v(dout1_55) AT=1290.05n

.meas tran vdout1_56ck1280 FIND v(dout1_56) AT=1290.05n

.meas tran vdout1_57ck1280 FIND v(dout1_57) AT=1290.05n

.meas tran vdout1_58ck1280 FIND v(dout1_58) AT=1290.05n

.meas tran vdout1_59ck1280 FIND v(dout1_59) AT=1290.05n

.meas tran vdout1_60ck1280 FIND v(dout1_60) AT=1290.05n

.meas tran vdout1_61ck1280 FIND v(dout1_61) AT=1290.05n

.meas tran vdout1_62ck1280 FIND v(dout1_62) AT=1290.05n

.meas tran vdout1_63ck1280 FIND v(dout1_63) AT=1290.05n

.meas tran vdout1_64ck1280 FIND v(dout1_64) AT=1290.05n

.meas tran vdout1_65ck1280 FIND v(dout1_65) AT=1290.05n

.meas tran vdout1_66ck1280 FIND v(dout1_66) AT=1290.05n

.meas tran vdout1_67ck1280 FIND v(dout1_67) AT=1290.05n

.meas tran vdout1_68ck1280 FIND v(dout1_68) AT=1290.05n

.meas tran vdout1_69ck1280 FIND v(dout1_69) AT=1290.05n

.meas tran vdout1_70ck1280 FIND v(dout1_70) AT=1290.05n

.meas tran vdout1_71ck1280 FIND v(dout1_71) AT=1290.05n

.meas tran vdout1_72ck1280 FIND v(dout1_72) AT=1290.05n

.meas tran vdout1_73ck1280 FIND v(dout1_73) AT=1290.05n

.meas tran vdout1_74ck1280 FIND v(dout1_74) AT=1290.05n

.meas tran vdout1_75ck1280 FIND v(dout1_75) AT=1290.05n

.meas tran vdout1_76ck1280 FIND v(dout1_76) AT=1290.05n

.meas tran vdout1_77ck1280 FIND v(dout1_77) AT=1290.05n

.meas tran vdout1_78ck1280 FIND v(dout1_78) AT=1290.05n

.meas tran vdout1_79ck1280 FIND v(dout1_79) AT=1290.05n

.meas tran vdout1_80ck1280 FIND v(dout1_80) AT=1290.05n

.meas tran vdout1_81ck1280 FIND v(dout1_81) AT=1290.05n

.meas tran vdout1_82ck1280 FIND v(dout1_82) AT=1290.05n

.meas tran vdout1_83ck1280 FIND v(dout1_83) AT=1290.05n

.meas tran vdout1_84ck1280 FIND v(dout1_84) AT=1290.05n

.meas tran vdout1_85ck1280 FIND v(dout1_85) AT=1290.05n

.meas tran vdout1_86ck1280 FIND v(dout1_86) AT=1290.05n

.meas tran vdout1_87ck1280 FIND v(dout1_87) AT=1290.05n

.meas tran vdout1_88ck1280 FIND v(dout1_88) AT=1290.05n

.meas tran vdout1_89ck1280 FIND v(dout1_89) AT=1290.05n

.meas tran vdout1_90ck1280 FIND v(dout1_90) AT=1290.05n

.meas tran vdout1_91ck1280 FIND v(dout1_91) AT=1290.05n

.meas tran vdout1_92ck1280 FIND v(dout1_92) AT=1290.05n

.meas tran vdout1_93ck1280 FIND v(dout1_93) AT=1290.05n

.meas tran vdout1_94ck1280 FIND v(dout1_94) AT=1290.05n

.meas tran vdout1_95ck1280 FIND v(dout1_95) AT=1290.05n

.meas tran vdout1_96ck1280 FIND v(dout1_96) AT=1290.05n

.meas tran vdout1_97ck1280 FIND v(dout1_97) AT=1290.05n

.meas tran vdout1_98ck1280 FIND v(dout1_98) AT=1290.05n

.meas tran vdout1_99ck1280 FIND v(dout1_99) AT=1290.05n

.meas tran vdout1_100ck1280 FIND v(dout1_100) AT=1290.05n

.meas tran vdout1_101ck1280 FIND v(dout1_101) AT=1290.05n

.meas tran vdout1_102ck1280 FIND v(dout1_102) AT=1290.05n

.meas tran vdout1_103ck1280 FIND v(dout1_103) AT=1290.05n

.meas tran vdout1_104ck1280 FIND v(dout1_104) AT=1290.05n

.meas tran vdout1_105ck1280 FIND v(dout1_105) AT=1290.05n

.meas tran vdout1_106ck1280 FIND v(dout1_106) AT=1290.05n

.meas tran vdout1_107ck1280 FIND v(dout1_107) AT=1290.05n

.meas tran vdout1_108ck1280 FIND v(dout1_108) AT=1290.05n

.meas tran vdout1_109ck1280 FIND v(dout1_109) AT=1290.05n

.meas tran vdout1_110ck1280 FIND v(dout1_110) AT=1290.05n

.meas tran vdout1_111ck1280 FIND v(dout1_111) AT=1290.05n

.meas tran vdout1_112ck1280 FIND v(dout1_112) AT=1290.05n

.meas tran vdout1_113ck1280 FIND v(dout1_113) AT=1290.05n

.meas tran vdout1_114ck1280 FIND v(dout1_114) AT=1290.05n

.meas tran vdout1_115ck1280 FIND v(dout1_115) AT=1290.05n

.meas tran vdout1_116ck1280 FIND v(dout1_116) AT=1290.05n

.meas tran vdout1_117ck1280 FIND v(dout1_117) AT=1290.05n

.meas tran vdout1_118ck1280 FIND v(dout1_118) AT=1290.05n

.meas tran vdout1_119ck1280 FIND v(dout1_119) AT=1290.05n

.meas tran vdout1_120ck1280 FIND v(dout1_120) AT=1290.05n

.meas tran vdout1_121ck1280 FIND v(dout1_121) AT=1290.05n

.meas tran vdout1_122ck1280 FIND v(dout1_122) AT=1290.05n

.meas tran vdout1_123ck1280 FIND v(dout1_123) AT=1290.05n

.meas tran vdout1_124ck1280 FIND v(dout1_124) AT=1290.05n

.meas tran vdout1_125ck1280 FIND v(dout1_125) AT=1290.05n

.meas tran vdout1_126ck1280 FIND v(dout1_126) AT=1290.05n

.meas tran vdout1_127ck1280 FIND v(dout1_127) AT=1290.05n

.meas tran vdout1_128ck1280 FIND v(dout1_128) AT=1290.05n

.meas tran vdout1_129ck1280 FIND v(dout1_129) AT=1290.05n

.meas tran vdout1_130ck1280 FIND v(dout1_130) AT=1290.05n

.meas tran vdout1_131ck1280 FIND v(dout1_131) AT=1290.05n

.meas tran vdout1_132ck1280 FIND v(dout1_132) AT=1290.05n

.meas tran vdout1_133ck1280 FIND v(dout1_133) AT=1290.05n

.meas tran vdout1_134ck1280 FIND v(dout1_134) AT=1290.05n

.meas tran vdout1_135ck1280 FIND v(dout1_135) AT=1290.05n

.meas tran vdout1_136ck1280 FIND v(dout1_136) AT=1290.05n

.meas tran vdout1_137ck1280 FIND v(dout1_137) AT=1290.05n

.meas tran vdout1_138ck1280 FIND v(dout1_138) AT=1290.05n

.meas tran vdout1_139ck1280 FIND v(dout1_139) AT=1290.05n

.meas tran vdout1_140ck1280 FIND v(dout1_140) AT=1290.05n

.meas tran vdout1_141ck1280 FIND v(dout1_141) AT=1290.05n

.meas tran vdout1_142ck1280 FIND v(dout1_142) AT=1290.05n

.meas tran vdout1_143ck1280 FIND v(dout1_143) AT=1290.05n

.meas tran vdout1_144ck1280 FIND v(dout1_144) AT=1290.05n

.meas tran vdout1_145ck1280 FIND v(dout1_145) AT=1290.05n

.meas tran vdout1_146ck1280 FIND v(dout1_146) AT=1290.05n

.meas tran vdout1_147ck1280 FIND v(dout1_147) AT=1290.05n

.meas tran vdout1_148ck1280 FIND v(dout1_148) AT=1290.05n

.meas tran vdout1_149ck1280 FIND v(dout1_149) AT=1290.05n

.meas tran vdout1_150ck1280 FIND v(dout1_150) AT=1290.05n

.meas tran vdout1_151ck1280 FIND v(dout1_151) AT=1290.05n

.meas tran vdout1_152ck1280 FIND v(dout1_152) AT=1290.05n

.meas tran vdout1_153ck1280 FIND v(dout1_153) AT=1290.05n

.meas tran vdout1_154ck1280 FIND v(dout1_154) AT=1290.05n

.meas tran vdout1_155ck1280 FIND v(dout1_155) AT=1290.05n

.meas tran vdout1_156ck1280 FIND v(dout1_156) AT=1290.05n

.meas tran vdout1_157ck1280 FIND v(dout1_157) AT=1290.05n

.meas tran vdout1_158ck1280 FIND v(dout1_158) AT=1290.05n

.meas tran vdout1_159ck1280 FIND v(dout1_159) AT=1290.05n

.meas tran vdout1_160ck1280 FIND v(dout1_160) AT=1290.05n

.meas tran vdout1_161ck1280 FIND v(dout1_161) AT=1290.05n

.meas tran vdout1_162ck1280 FIND v(dout1_162) AT=1290.05n

.meas tran vdout1_163ck1280 FIND v(dout1_163) AT=1290.05n

.meas tran vdout1_164ck1280 FIND v(dout1_164) AT=1290.05n

.meas tran vdout1_165ck1280 FIND v(dout1_165) AT=1290.05n

.meas tran vdout1_166ck1280 FIND v(dout1_166) AT=1290.05n

.meas tran vdout1_167ck1280 FIND v(dout1_167) AT=1290.05n

.meas tran vdout1_168ck1280 FIND v(dout1_168) AT=1290.05n

.meas tran vdout1_169ck1280 FIND v(dout1_169) AT=1290.05n

.meas tran vdout1_170ck1280 FIND v(dout1_170) AT=1290.05n

.meas tran vdout1_171ck1280 FIND v(dout1_171) AT=1290.05n

.meas tran vdout1_172ck1280 FIND v(dout1_172) AT=1290.05n

.meas tran vdout1_173ck1280 FIND v(dout1_173) AT=1290.05n

.meas tran vdout1_174ck1280 FIND v(dout1_174) AT=1290.05n

.meas tran vdout1_175ck1280 FIND v(dout1_175) AT=1290.05n

.meas tran vdout1_176ck1280 FIND v(dout1_176) AT=1290.05n

.meas tran vdout1_177ck1280 FIND v(dout1_177) AT=1290.05n

.meas tran vdout1_178ck1280 FIND v(dout1_178) AT=1290.05n

.meas tran vdout1_179ck1280 FIND v(dout1_179) AT=1290.05n

.meas tran vdout1_180ck1280 FIND v(dout1_180) AT=1290.05n

.meas tran vdout1_181ck1280 FIND v(dout1_181) AT=1290.05n

.meas tran vdout1_182ck1280 FIND v(dout1_182) AT=1290.05n

.meas tran vdout1_183ck1280 FIND v(dout1_183) AT=1290.05n

.meas tran vdout1_184ck1280 FIND v(dout1_184) AT=1290.05n

.meas tran vdout1_185ck1280 FIND v(dout1_185) AT=1290.05n

.meas tran vdout1_186ck1280 FIND v(dout1_186) AT=1290.05n

.meas tran vdout1_187ck1280 FIND v(dout1_187) AT=1290.05n

.meas tran vdout1_188ck1280 FIND v(dout1_188) AT=1290.05n

.meas tran vdout1_189ck1280 FIND v(dout1_189) AT=1290.05n

.meas tran vdout1_190ck1280 FIND v(dout1_190) AT=1290.05n

.meas tran vdout1_191ck1280 FIND v(dout1_191) AT=1290.05n

.meas tran vdout1_192ck1280 FIND v(dout1_192) AT=1290.05n

.meas tran vdout1_193ck1280 FIND v(dout1_193) AT=1290.05n

.meas tran vdout1_194ck1280 FIND v(dout1_194) AT=1290.05n

.meas tran vdout1_195ck1280 FIND v(dout1_195) AT=1290.05n

.meas tran vdout1_196ck1280 FIND v(dout1_196) AT=1290.05n

.meas tran vdout1_197ck1280 FIND v(dout1_197) AT=1290.05n

.meas tran vdout1_198ck1280 FIND v(dout1_198) AT=1290.05n

.meas tran vdout1_199ck1280 FIND v(dout1_199) AT=1290.05n

.meas tran vdout1_200ck1280 FIND v(dout1_200) AT=1290.05n

.meas tran vdout1_201ck1280 FIND v(dout1_201) AT=1290.05n

.meas tran vdout1_202ck1280 FIND v(dout1_202) AT=1290.05n

.meas tran vdout1_203ck1280 FIND v(dout1_203) AT=1290.05n

.meas tran vdout1_204ck1280 FIND v(dout1_204) AT=1290.05n

.meas tran vdout1_205ck1280 FIND v(dout1_205) AT=1290.05n

.meas tran vdout1_206ck1280 FIND v(dout1_206) AT=1290.05n

.meas tran vdout1_207ck1280 FIND v(dout1_207) AT=1290.05n

.meas tran vdout1_208ck1280 FIND v(dout1_208) AT=1290.05n

.meas tran vdout1_209ck1280 FIND v(dout1_209) AT=1290.05n

.meas tran vdout1_210ck1280 FIND v(dout1_210) AT=1290.05n

.meas tran vdout1_211ck1280 FIND v(dout1_211) AT=1290.05n

.meas tran vdout1_212ck1280 FIND v(dout1_212) AT=1290.05n

.meas tran vdout1_213ck1280 FIND v(dout1_213) AT=1290.05n

.meas tran vdout1_214ck1280 FIND v(dout1_214) AT=1290.05n

.meas tran vdout1_215ck1280 FIND v(dout1_215) AT=1290.05n

.meas tran vdout1_216ck1280 FIND v(dout1_216) AT=1290.05n

.meas tran vdout1_217ck1280 FIND v(dout1_217) AT=1290.05n

.meas tran vdout1_218ck1280 FIND v(dout1_218) AT=1290.05n

.meas tran vdout1_219ck1280 FIND v(dout1_219) AT=1290.05n

.meas tran vdout1_220ck1280 FIND v(dout1_220) AT=1290.05n

.meas tran vdout1_221ck1280 FIND v(dout1_221) AT=1290.05n

.meas tran vdout1_222ck1280 FIND v(dout1_222) AT=1290.05n

.meas tran vdout1_223ck1280 FIND v(dout1_223) AT=1290.05n

.meas tran vdout1_224ck1280 FIND v(dout1_224) AT=1290.05n

.meas tran vdout1_225ck1280 FIND v(dout1_225) AT=1290.05n

.meas tran vdout1_226ck1280 FIND v(dout1_226) AT=1290.05n

.meas tran vdout1_227ck1280 FIND v(dout1_227) AT=1290.05n

.meas tran vdout1_228ck1280 FIND v(dout1_228) AT=1290.05n

.meas tran vdout1_229ck1280 FIND v(dout1_229) AT=1290.05n

.meas tran vdout1_230ck1280 FIND v(dout1_230) AT=1290.05n

.meas tran vdout1_231ck1280 FIND v(dout1_231) AT=1290.05n

.meas tran vdout1_232ck1280 FIND v(dout1_232) AT=1290.05n

.meas tran vdout1_233ck1280 FIND v(dout1_233) AT=1290.05n

.meas tran vdout1_234ck1280 FIND v(dout1_234) AT=1290.05n

.meas tran vdout1_235ck1280 FIND v(dout1_235) AT=1290.05n

.meas tran vdout1_236ck1280 FIND v(dout1_236) AT=1290.05n

.meas tran vdout1_237ck1280 FIND v(dout1_237) AT=1290.05n

.meas tran vdout1_238ck1280 FIND v(dout1_238) AT=1290.05n

.meas tran vdout1_239ck1280 FIND v(dout1_239) AT=1290.05n

.meas tran vdout1_240ck1280 FIND v(dout1_240) AT=1290.05n

.meas tran vdout1_241ck1280 FIND v(dout1_241) AT=1290.05n

.meas tran vdout1_242ck1280 FIND v(dout1_242) AT=1290.05n

.meas tran vdout1_243ck1280 FIND v(dout1_243) AT=1290.05n

.meas tran vdout1_244ck1280 FIND v(dout1_244) AT=1290.05n

.meas tran vdout1_245ck1280 FIND v(dout1_245) AT=1290.05n

.meas tran vdout1_246ck1280 FIND v(dout1_246) AT=1290.05n

.meas tran vdout1_247ck1280 FIND v(dout1_247) AT=1290.05n

.meas tran vdout1_248ck1280 FIND v(dout1_248) AT=1290.05n

.meas tran vdout1_249ck1280 FIND v(dout1_249) AT=1290.05n

.meas tran vdout1_250ck1280 FIND v(dout1_250) AT=1290.05n

.meas tran vdout1_251ck1280 FIND v(dout1_251) AT=1290.05n

.meas tran vdout1_252ck1280 FIND v(dout1_252) AT=1290.05n

.meas tran vdout1_253ck1280 FIND v(dout1_253) AT=1290.05n

.meas tran vdout1_254ck1280 FIND v(dout1_254) AT=1290.05n

.meas tran vdout1_255ck1280 FIND v(dout1_255) AT=1290.05n

.meas tran vdout1_256ck1280 FIND v(dout1_256) AT=1290.05n

.meas tran vdout1_0ck1290 FIND v(dout1_0) AT=1300.05n

.meas tran vdout1_1ck1290 FIND v(dout1_1) AT=1300.05n

.meas tran vdout1_2ck1290 FIND v(dout1_2) AT=1300.05n

.meas tran vdout1_3ck1290 FIND v(dout1_3) AT=1300.05n

.meas tran vdout1_4ck1290 FIND v(dout1_4) AT=1300.05n

.meas tran vdout1_5ck1290 FIND v(dout1_5) AT=1300.05n

.meas tran vdout1_6ck1290 FIND v(dout1_6) AT=1300.05n

.meas tran vdout1_7ck1290 FIND v(dout1_7) AT=1300.05n

.meas tran vdout1_8ck1290 FIND v(dout1_8) AT=1300.05n

.meas tran vdout1_9ck1290 FIND v(dout1_9) AT=1300.05n

.meas tran vdout1_10ck1290 FIND v(dout1_10) AT=1300.05n

.meas tran vdout1_11ck1290 FIND v(dout1_11) AT=1300.05n

.meas tran vdout1_12ck1290 FIND v(dout1_12) AT=1300.05n

.meas tran vdout1_13ck1290 FIND v(dout1_13) AT=1300.05n

.meas tran vdout1_14ck1290 FIND v(dout1_14) AT=1300.05n

.meas tran vdout1_15ck1290 FIND v(dout1_15) AT=1300.05n

.meas tran vdout1_16ck1290 FIND v(dout1_16) AT=1300.05n

.meas tran vdout1_17ck1290 FIND v(dout1_17) AT=1300.05n

.meas tran vdout1_18ck1290 FIND v(dout1_18) AT=1300.05n

.meas tran vdout1_19ck1290 FIND v(dout1_19) AT=1300.05n

.meas tran vdout1_20ck1290 FIND v(dout1_20) AT=1300.05n

.meas tran vdout1_21ck1290 FIND v(dout1_21) AT=1300.05n

.meas tran vdout1_22ck1290 FIND v(dout1_22) AT=1300.05n

.meas tran vdout1_23ck1290 FIND v(dout1_23) AT=1300.05n

.meas tran vdout1_24ck1290 FIND v(dout1_24) AT=1300.05n

.meas tran vdout1_25ck1290 FIND v(dout1_25) AT=1300.05n

.meas tran vdout1_26ck1290 FIND v(dout1_26) AT=1300.05n

.meas tran vdout1_27ck1290 FIND v(dout1_27) AT=1300.05n

.meas tran vdout1_28ck1290 FIND v(dout1_28) AT=1300.05n

.meas tran vdout1_29ck1290 FIND v(dout1_29) AT=1300.05n

.meas tran vdout1_30ck1290 FIND v(dout1_30) AT=1300.05n

.meas tran vdout1_31ck1290 FIND v(dout1_31) AT=1300.05n

.meas tran vdout1_32ck1290 FIND v(dout1_32) AT=1300.05n

.meas tran vdout1_33ck1290 FIND v(dout1_33) AT=1300.05n

.meas tran vdout1_34ck1290 FIND v(dout1_34) AT=1300.05n

.meas tran vdout1_35ck1290 FIND v(dout1_35) AT=1300.05n

.meas tran vdout1_36ck1290 FIND v(dout1_36) AT=1300.05n

.meas tran vdout1_37ck1290 FIND v(dout1_37) AT=1300.05n

.meas tran vdout1_38ck1290 FIND v(dout1_38) AT=1300.05n

.meas tran vdout1_39ck1290 FIND v(dout1_39) AT=1300.05n

.meas tran vdout1_40ck1290 FIND v(dout1_40) AT=1300.05n

.meas tran vdout1_41ck1290 FIND v(dout1_41) AT=1300.05n

.meas tran vdout1_42ck1290 FIND v(dout1_42) AT=1300.05n

.meas tran vdout1_43ck1290 FIND v(dout1_43) AT=1300.05n

.meas tran vdout1_44ck1290 FIND v(dout1_44) AT=1300.05n

.meas tran vdout1_45ck1290 FIND v(dout1_45) AT=1300.05n

.meas tran vdout1_46ck1290 FIND v(dout1_46) AT=1300.05n

.meas tran vdout1_47ck1290 FIND v(dout1_47) AT=1300.05n

.meas tran vdout1_48ck1290 FIND v(dout1_48) AT=1300.05n

.meas tran vdout1_49ck1290 FIND v(dout1_49) AT=1300.05n

.meas tran vdout1_50ck1290 FIND v(dout1_50) AT=1300.05n

.meas tran vdout1_51ck1290 FIND v(dout1_51) AT=1300.05n

.meas tran vdout1_52ck1290 FIND v(dout1_52) AT=1300.05n

.meas tran vdout1_53ck1290 FIND v(dout1_53) AT=1300.05n

.meas tran vdout1_54ck1290 FIND v(dout1_54) AT=1300.05n

.meas tran vdout1_55ck1290 FIND v(dout1_55) AT=1300.05n

.meas tran vdout1_56ck1290 FIND v(dout1_56) AT=1300.05n

.meas tran vdout1_57ck1290 FIND v(dout1_57) AT=1300.05n

.meas tran vdout1_58ck1290 FIND v(dout1_58) AT=1300.05n

.meas tran vdout1_59ck1290 FIND v(dout1_59) AT=1300.05n

.meas tran vdout1_60ck1290 FIND v(dout1_60) AT=1300.05n

.meas tran vdout1_61ck1290 FIND v(dout1_61) AT=1300.05n

.meas tran vdout1_62ck1290 FIND v(dout1_62) AT=1300.05n

.meas tran vdout1_63ck1290 FIND v(dout1_63) AT=1300.05n

.meas tran vdout1_64ck1290 FIND v(dout1_64) AT=1300.05n

.meas tran vdout1_65ck1290 FIND v(dout1_65) AT=1300.05n

.meas tran vdout1_66ck1290 FIND v(dout1_66) AT=1300.05n

.meas tran vdout1_67ck1290 FIND v(dout1_67) AT=1300.05n

.meas tran vdout1_68ck1290 FIND v(dout1_68) AT=1300.05n

.meas tran vdout1_69ck1290 FIND v(dout1_69) AT=1300.05n

.meas tran vdout1_70ck1290 FIND v(dout1_70) AT=1300.05n

.meas tran vdout1_71ck1290 FIND v(dout1_71) AT=1300.05n

.meas tran vdout1_72ck1290 FIND v(dout1_72) AT=1300.05n

.meas tran vdout1_73ck1290 FIND v(dout1_73) AT=1300.05n

.meas tran vdout1_74ck1290 FIND v(dout1_74) AT=1300.05n

.meas tran vdout1_75ck1290 FIND v(dout1_75) AT=1300.05n

.meas tran vdout1_76ck1290 FIND v(dout1_76) AT=1300.05n

.meas tran vdout1_77ck1290 FIND v(dout1_77) AT=1300.05n

.meas tran vdout1_78ck1290 FIND v(dout1_78) AT=1300.05n

.meas tran vdout1_79ck1290 FIND v(dout1_79) AT=1300.05n

.meas tran vdout1_80ck1290 FIND v(dout1_80) AT=1300.05n

.meas tran vdout1_81ck1290 FIND v(dout1_81) AT=1300.05n

.meas tran vdout1_82ck1290 FIND v(dout1_82) AT=1300.05n

.meas tran vdout1_83ck1290 FIND v(dout1_83) AT=1300.05n

.meas tran vdout1_84ck1290 FIND v(dout1_84) AT=1300.05n

.meas tran vdout1_85ck1290 FIND v(dout1_85) AT=1300.05n

.meas tran vdout1_86ck1290 FIND v(dout1_86) AT=1300.05n

.meas tran vdout1_87ck1290 FIND v(dout1_87) AT=1300.05n

.meas tran vdout1_88ck1290 FIND v(dout1_88) AT=1300.05n

.meas tran vdout1_89ck1290 FIND v(dout1_89) AT=1300.05n

.meas tran vdout1_90ck1290 FIND v(dout1_90) AT=1300.05n

.meas tran vdout1_91ck1290 FIND v(dout1_91) AT=1300.05n

.meas tran vdout1_92ck1290 FIND v(dout1_92) AT=1300.05n

.meas tran vdout1_93ck1290 FIND v(dout1_93) AT=1300.05n

.meas tran vdout1_94ck1290 FIND v(dout1_94) AT=1300.05n

.meas tran vdout1_95ck1290 FIND v(dout1_95) AT=1300.05n

.meas tran vdout1_96ck1290 FIND v(dout1_96) AT=1300.05n

.meas tran vdout1_97ck1290 FIND v(dout1_97) AT=1300.05n

.meas tran vdout1_98ck1290 FIND v(dout1_98) AT=1300.05n

.meas tran vdout1_99ck1290 FIND v(dout1_99) AT=1300.05n

.meas tran vdout1_100ck1290 FIND v(dout1_100) AT=1300.05n

.meas tran vdout1_101ck1290 FIND v(dout1_101) AT=1300.05n

.meas tran vdout1_102ck1290 FIND v(dout1_102) AT=1300.05n

.meas tran vdout1_103ck1290 FIND v(dout1_103) AT=1300.05n

.meas tran vdout1_104ck1290 FIND v(dout1_104) AT=1300.05n

.meas tran vdout1_105ck1290 FIND v(dout1_105) AT=1300.05n

.meas tran vdout1_106ck1290 FIND v(dout1_106) AT=1300.05n

.meas tran vdout1_107ck1290 FIND v(dout1_107) AT=1300.05n

.meas tran vdout1_108ck1290 FIND v(dout1_108) AT=1300.05n

.meas tran vdout1_109ck1290 FIND v(dout1_109) AT=1300.05n

.meas tran vdout1_110ck1290 FIND v(dout1_110) AT=1300.05n

.meas tran vdout1_111ck1290 FIND v(dout1_111) AT=1300.05n

.meas tran vdout1_112ck1290 FIND v(dout1_112) AT=1300.05n

.meas tran vdout1_113ck1290 FIND v(dout1_113) AT=1300.05n

.meas tran vdout1_114ck1290 FIND v(dout1_114) AT=1300.05n

.meas tran vdout1_115ck1290 FIND v(dout1_115) AT=1300.05n

.meas tran vdout1_116ck1290 FIND v(dout1_116) AT=1300.05n

.meas tran vdout1_117ck1290 FIND v(dout1_117) AT=1300.05n

.meas tran vdout1_118ck1290 FIND v(dout1_118) AT=1300.05n

.meas tran vdout1_119ck1290 FIND v(dout1_119) AT=1300.05n

.meas tran vdout1_120ck1290 FIND v(dout1_120) AT=1300.05n

.meas tran vdout1_121ck1290 FIND v(dout1_121) AT=1300.05n

.meas tran vdout1_122ck1290 FIND v(dout1_122) AT=1300.05n

.meas tran vdout1_123ck1290 FIND v(dout1_123) AT=1300.05n

.meas tran vdout1_124ck1290 FIND v(dout1_124) AT=1300.05n

.meas tran vdout1_125ck1290 FIND v(dout1_125) AT=1300.05n

.meas tran vdout1_126ck1290 FIND v(dout1_126) AT=1300.05n

.meas tran vdout1_127ck1290 FIND v(dout1_127) AT=1300.05n

.meas tran vdout1_128ck1290 FIND v(dout1_128) AT=1300.05n

.meas tran vdout1_129ck1290 FIND v(dout1_129) AT=1300.05n

.meas tran vdout1_130ck1290 FIND v(dout1_130) AT=1300.05n

.meas tran vdout1_131ck1290 FIND v(dout1_131) AT=1300.05n

.meas tran vdout1_132ck1290 FIND v(dout1_132) AT=1300.05n

.meas tran vdout1_133ck1290 FIND v(dout1_133) AT=1300.05n

.meas tran vdout1_134ck1290 FIND v(dout1_134) AT=1300.05n

.meas tran vdout1_135ck1290 FIND v(dout1_135) AT=1300.05n

.meas tran vdout1_136ck1290 FIND v(dout1_136) AT=1300.05n

.meas tran vdout1_137ck1290 FIND v(dout1_137) AT=1300.05n

.meas tran vdout1_138ck1290 FIND v(dout1_138) AT=1300.05n

.meas tran vdout1_139ck1290 FIND v(dout1_139) AT=1300.05n

.meas tran vdout1_140ck1290 FIND v(dout1_140) AT=1300.05n

.meas tran vdout1_141ck1290 FIND v(dout1_141) AT=1300.05n

.meas tran vdout1_142ck1290 FIND v(dout1_142) AT=1300.05n

.meas tran vdout1_143ck1290 FIND v(dout1_143) AT=1300.05n

.meas tran vdout1_144ck1290 FIND v(dout1_144) AT=1300.05n

.meas tran vdout1_145ck1290 FIND v(dout1_145) AT=1300.05n

.meas tran vdout1_146ck1290 FIND v(dout1_146) AT=1300.05n

.meas tran vdout1_147ck1290 FIND v(dout1_147) AT=1300.05n

.meas tran vdout1_148ck1290 FIND v(dout1_148) AT=1300.05n

.meas tran vdout1_149ck1290 FIND v(dout1_149) AT=1300.05n

.meas tran vdout1_150ck1290 FIND v(dout1_150) AT=1300.05n

.meas tran vdout1_151ck1290 FIND v(dout1_151) AT=1300.05n

.meas tran vdout1_152ck1290 FIND v(dout1_152) AT=1300.05n

.meas tran vdout1_153ck1290 FIND v(dout1_153) AT=1300.05n

.meas tran vdout1_154ck1290 FIND v(dout1_154) AT=1300.05n

.meas tran vdout1_155ck1290 FIND v(dout1_155) AT=1300.05n

.meas tran vdout1_156ck1290 FIND v(dout1_156) AT=1300.05n

.meas tran vdout1_157ck1290 FIND v(dout1_157) AT=1300.05n

.meas tran vdout1_158ck1290 FIND v(dout1_158) AT=1300.05n

.meas tran vdout1_159ck1290 FIND v(dout1_159) AT=1300.05n

.meas tran vdout1_160ck1290 FIND v(dout1_160) AT=1300.05n

.meas tran vdout1_161ck1290 FIND v(dout1_161) AT=1300.05n

.meas tran vdout1_162ck1290 FIND v(dout1_162) AT=1300.05n

.meas tran vdout1_163ck1290 FIND v(dout1_163) AT=1300.05n

.meas tran vdout1_164ck1290 FIND v(dout1_164) AT=1300.05n

.meas tran vdout1_165ck1290 FIND v(dout1_165) AT=1300.05n

.meas tran vdout1_166ck1290 FIND v(dout1_166) AT=1300.05n

.meas tran vdout1_167ck1290 FIND v(dout1_167) AT=1300.05n

.meas tran vdout1_168ck1290 FIND v(dout1_168) AT=1300.05n

.meas tran vdout1_169ck1290 FIND v(dout1_169) AT=1300.05n

.meas tran vdout1_170ck1290 FIND v(dout1_170) AT=1300.05n

.meas tran vdout1_171ck1290 FIND v(dout1_171) AT=1300.05n

.meas tran vdout1_172ck1290 FIND v(dout1_172) AT=1300.05n

.meas tran vdout1_173ck1290 FIND v(dout1_173) AT=1300.05n

.meas tran vdout1_174ck1290 FIND v(dout1_174) AT=1300.05n

.meas tran vdout1_175ck1290 FIND v(dout1_175) AT=1300.05n

.meas tran vdout1_176ck1290 FIND v(dout1_176) AT=1300.05n

.meas tran vdout1_177ck1290 FIND v(dout1_177) AT=1300.05n

.meas tran vdout1_178ck1290 FIND v(dout1_178) AT=1300.05n

.meas tran vdout1_179ck1290 FIND v(dout1_179) AT=1300.05n

.meas tran vdout1_180ck1290 FIND v(dout1_180) AT=1300.05n

.meas tran vdout1_181ck1290 FIND v(dout1_181) AT=1300.05n

.meas tran vdout1_182ck1290 FIND v(dout1_182) AT=1300.05n

.meas tran vdout1_183ck1290 FIND v(dout1_183) AT=1300.05n

.meas tran vdout1_184ck1290 FIND v(dout1_184) AT=1300.05n

.meas tran vdout1_185ck1290 FIND v(dout1_185) AT=1300.05n

.meas tran vdout1_186ck1290 FIND v(dout1_186) AT=1300.05n

.meas tran vdout1_187ck1290 FIND v(dout1_187) AT=1300.05n

.meas tran vdout1_188ck1290 FIND v(dout1_188) AT=1300.05n

.meas tran vdout1_189ck1290 FIND v(dout1_189) AT=1300.05n

.meas tran vdout1_190ck1290 FIND v(dout1_190) AT=1300.05n

.meas tran vdout1_191ck1290 FIND v(dout1_191) AT=1300.05n

.meas tran vdout1_192ck1290 FIND v(dout1_192) AT=1300.05n

.meas tran vdout1_193ck1290 FIND v(dout1_193) AT=1300.05n

.meas tran vdout1_194ck1290 FIND v(dout1_194) AT=1300.05n

.meas tran vdout1_195ck1290 FIND v(dout1_195) AT=1300.05n

.meas tran vdout1_196ck1290 FIND v(dout1_196) AT=1300.05n

.meas tran vdout1_197ck1290 FIND v(dout1_197) AT=1300.05n

.meas tran vdout1_198ck1290 FIND v(dout1_198) AT=1300.05n

.meas tran vdout1_199ck1290 FIND v(dout1_199) AT=1300.05n

.meas tran vdout1_200ck1290 FIND v(dout1_200) AT=1300.05n

.meas tran vdout1_201ck1290 FIND v(dout1_201) AT=1300.05n

.meas tran vdout1_202ck1290 FIND v(dout1_202) AT=1300.05n

.meas tran vdout1_203ck1290 FIND v(dout1_203) AT=1300.05n

.meas tran vdout1_204ck1290 FIND v(dout1_204) AT=1300.05n

.meas tran vdout1_205ck1290 FIND v(dout1_205) AT=1300.05n

.meas tran vdout1_206ck1290 FIND v(dout1_206) AT=1300.05n

.meas tran vdout1_207ck1290 FIND v(dout1_207) AT=1300.05n

.meas tran vdout1_208ck1290 FIND v(dout1_208) AT=1300.05n

.meas tran vdout1_209ck1290 FIND v(dout1_209) AT=1300.05n

.meas tran vdout1_210ck1290 FIND v(dout1_210) AT=1300.05n

.meas tran vdout1_211ck1290 FIND v(dout1_211) AT=1300.05n

.meas tran vdout1_212ck1290 FIND v(dout1_212) AT=1300.05n

.meas tran vdout1_213ck1290 FIND v(dout1_213) AT=1300.05n

.meas tran vdout1_214ck1290 FIND v(dout1_214) AT=1300.05n

.meas tran vdout1_215ck1290 FIND v(dout1_215) AT=1300.05n

.meas tran vdout1_216ck1290 FIND v(dout1_216) AT=1300.05n

.meas tran vdout1_217ck1290 FIND v(dout1_217) AT=1300.05n

.meas tran vdout1_218ck1290 FIND v(dout1_218) AT=1300.05n

.meas tran vdout1_219ck1290 FIND v(dout1_219) AT=1300.05n

.meas tran vdout1_220ck1290 FIND v(dout1_220) AT=1300.05n

.meas tran vdout1_221ck1290 FIND v(dout1_221) AT=1300.05n

.meas tran vdout1_222ck1290 FIND v(dout1_222) AT=1300.05n

.meas tran vdout1_223ck1290 FIND v(dout1_223) AT=1300.05n

.meas tran vdout1_224ck1290 FIND v(dout1_224) AT=1300.05n

.meas tran vdout1_225ck1290 FIND v(dout1_225) AT=1300.05n

.meas tran vdout1_226ck1290 FIND v(dout1_226) AT=1300.05n

.meas tran vdout1_227ck1290 FIND v(dout1_227) AT=1300.05n

.meas tran vdout1_228ck1290 FIND v(dout1_228) AT=1300.05n

.meas tran vdout1_229ck1290 FIND v(dout1_229) AT=1300.05n

.meas tran vdout1_230ck1290 FIND v(dout1_230) AT=1300.05n

.meas tran vdout1_231ck1290 FIND v(dout1_231) AT=1300.05n

.meas tran vdout1_232ck1290 FIND v(dout1_232) AT=1300.05n

.meas tran vdout1_233ck1290 FIND v(dout1_233) AT=1300.05n

.meas tran vdout1_234ck1290 FIND v(dout1_234) AT=1300.05n

.meas tran vdout1_235ck1290 FIND v(dout1_235) AT=1300.05n

.meas tran vdout1_236ck1290 FIND v(dout1_236) AT=1300.05n

.meas tran vdout1_237ck1290 FIND v(dout1_237) AT=1300.05n

.meas tran vdout1_238ck1290 FIND v(dout1_238) AT=1300.05n

.meas tran vdout1_239ck1290 FIND v(dout1_239) AT=1300.05n

.meas tran vdout1_240ck1290 FIND v(dout1_240) AT=1300.05n

.meas tran vdout1_241ck1290 FIND v(dout1_241) AT=1300.05n

.meas tran vdout1_242ck1290 FIND v(dout1_242) AT=1300.05n

.meas tran vdout1_243ck1290 FIND v(dout1_243) AT=1300.05n

.meas tran vdout1_244ck1290 FIND v(dout1_244) AT=1300.05n

.meas tran vdout1_245ck1290 FIND v(dout1_245) AT=1300.05n

.meas tran vdout1_246ck1290 FIND v(dout1_246) AT=1300.05n

.meas tran vdout1_247ck1290 FIND v(dout1_247) AT=1300.05n

.meas tran vdout1_248ck1290 FIND v(dout1_248) AT=1300.05n

.meas tran vdout1_249ck1290 FIND v(dout1_249) AT=1300.05n

.meas tran vdout1_250ck1290 FIND v(dout1_250) AT=1300.05n

.meas tran vdout1_251ck1290 FIND v(dout1_251) AT=1300.05n

.meas tran vdout1_252ck1290 FIND v(dout1_252) AT=1300.05n

.meas tran vdout1_253ck1290 FIND v(dout1_253) AT=1300.05n

.meas tran vdout1_254ck1290 FIND v(dout1_254) AT=1300.05n

.meas tran vdout1_255ck1290 FIND v(dout1_255) AT=1300.05n

.meas tran vdout1_256ck1290 FIND v(dout1_256) AT=1300.05n

.meas tran vdout1_0ck1320 FIND v(dout1_0) AT=1330.05n

.meas tran vdout1_1ck1320 FIND v(dout1_1) AT=1330.05n

.meas tran vdout1_2ck1320 FIND v(dout1_2) AT=1330.05n

.meas tran vdout1_3ck1320 FIND v(dout1_3) AT=1330.05n

.meas tran vdout1_4ck1320 FIND v(dout1_4) AT=1330.05n

.meas tran vdout1_5ck1320 FIND v(dout1_5) AT=1330.05n

.meas tran vdout1_6ck1320 FIND v(dout1_6) AT=1330.05n

.meas tran vdout1_7ck1320 FIND v(dout1_7) AT=1330.05n

.meas tran vdout1_8ck1320 FIND v(dout1_8) AT=1330.05n

.meas tran vdout1_9ck1320 FIND v(dout1_9) AT=1330.05n

.meas tran vdout1_10ck1320 FIND v(dout1_10) AT=1330.05n

.meas tran vdout1_11ck1320 FIND v(dout1_11) AT=1330.05n

.meas tran vdout1_12ck1320 FIND v(dout1_12) AT=1330.05n

.meas tran vdout1_13ck1320 FIND v(dout1_13) AT=1330.05n

.meas tran vdout1_14ck1320 FIND v(dout1_14) AT=1330.05n

.meas tran vdout1_15ck1320 FIND v(dout1_15) AT=1330.05n

.meas tran vdout1_16ck1320 FIND v(dout1_16) AT=1330.05n

.meas tran vdout1_17ck1320 FIND v(dout1_17) AT=1330.05n

.meas tran vdout1_18ck1320 FIND v(dout1_18) AT=1330.05n

.meas tran vdout1_19ck1320 FIND v(dout1_19) AT=1330.05n

.meas tran vdout1_20ck1320 FIND v(dout1_20) AT=1330.05n

.meas tran vdout1_21ck1320 FIND v(dout1_21) AT=1330.05n

.meas tran vdout1_22ck1320 FIND v(dout1_22) AT=1330.05n

.meas tran vdout1_23ck1320 FIND v(dout1_23) AT=1330.05n

.meas tran vdout1_24ck1320 FIND v(dout1_24) AT=1330.05n

.meas tran vdout1_25ck1320 FIND v(dout1_25) AT=1330.05n

.meas tran vdout1_26ck1320 FIND v(dout1_26) AT=1330.05n

.meas tran vdout1_27ck1320 FIND v(dout1_27) AT=1330.05n

.meas tran vdout1_28ck1320 FIND v(dout1_28) AT=1330.05n

.meas tran vdout1_29ck1320 FIND v(dout1_29) AT=1330.05n

.meas tran vdout1_30ck1320 FIND v(dout1_30) AT=1330.05n

.meas tran vdout1_31ck1320 FIND v(dout1_31) AT=1330.05n

.meas tran vdout1_32ck1320 FIND v(dout1_32) AT=1330.05n

.meas tran vdout1_33ck1320 FIND v(dout1_33) AT=1330.05n

.meas tran vdout1_34ck1320 FIND v(dout1_34) AT=1330.05n

.meas tran vdout1_35ck1320 FIND v(dout1_35) AT=1330.05n

.meas tran vdout1_36ck1320 FIND v(dout1_36) AT=1330.05n

.meas tran vdout1_37ck1320 FIND v(dout1_37) AT=1330.05n

.meas tran vdout1_38ck1320 FIND v(dout1_38) AT=1330.05n

.meas tran vdout1_39ck1320 FIND v(dout1_39) AT=1330.05n

.meas tran vdout1_40ck1320 FIND v(dout1_40) AT=1330.05n

.meas tran vdout1_41ck1320 FIND v(dout1_41) AT=1330.05n

.meas tran vdout1_42ck1320 FIND v(dout1_42) AT=1330.05n

.meas tran vdout1_43ck1320 FIND v(dout1_43) AT=1330.05n

.meas tran vdout1_44ck1320 FIND v(dout1_44) AT=1330.05n

.meas tran vdout1_45ck1320 FIND v(dout1_45) AT=1330.05n

.meas tran vdout1_46ck1320 FIND v(dout1_46) AT=1330.05n

.meas tran vdout1_47ck1320 FIND v(dout1_47) AT=1330.05n

.meas tran vdout1_48ck1320 FIND v(dout1_48) AT=1330.05n

.meas tran vdout1_49ck1320 FIND v(dout1_49) AT=1330.05n

.meas tran vdout1_50ck1320 FIND v(dout1_50) AT=1330.05n

.meas tran vdout1_51ck1320 FIND v(dout1_51) AT=1330.05n

.meas tran vdout1_52ck1320 FIND v(dout1_52) AT=1330.05n

.meas tran vdout1_53ck1320 FIND v(dout1_53) AT=1330.05n

.meas tran vdout1_54ck1320 FIND v(dout1_54) AT=1330.05n

.meas tran vdout1_55ck1320 FIND v(dout1_55) AT=1330.05n

.meas tran vdout1_56ck1320 FIND v(dout1_56) AT=1330.05n

.meas tran vdout1_57ck1320 FIND v(dout1_57) AT=1330.05n

.meas tran vdout1_58ck1320 FIND v(dout1_58) AT=1330.05n

.meas tran vdout1_59ck1320 FIND v(dout1_59) AT=1330.05n

.meas tran vdout1_60ck1320 FIND v(dout1_60) AT=1330.05n

.meas tran vdout1_61ck1320 FIND v(dout1_61) AT=1330.05n

.meas tran vdout1_62ck1320 FIND v(dout1_62) AT=1330.05n

.meas tran vdout1_63ck1320 FIND v(dout1_63) AT=1330.05n

.meas tran vdout1_64ck1320 FIND v(dout1_64) AT=1330.05n

.meas tran vdout1_65ck1320 FIND v(dout1_65) AT=1330.05n

.meas tran vdout1_66ck1320 FIND v(dout1_66) AT=1330.05n

.meas tran vdout1_67ck1320 FIND v(dout1_67) AT=1330.05n

.meas tran vdout1_68ck1320 FIND v(dout1_68) AT=1330.05n

.meas tran vdout1_69ck1320 FIND v(dout1_69) AT=1330.05n

.meas tran vdout1_70ck1320 FIND v(dout1_70) AT=1330.05n

.meas tran vdout1_71ck1320 FIND v(dout1_71) AT=1330.05n

.meas tran vdout1_72ck1320 FIND v(dout1_72) AT=1330.05n

.meas tran vdout1_73ck1320 FIND v(dout1_73) AT=1330.05n

.meas tran vdout1_74ck1320 FIND v(dout1_74) AT=1330.05n

.meas tran vdout1_75ck1320 FIND v(dout1_75) AT=1330.05n

.meas tran vdout1_76ck1320 FIND v(dout1_76) AT=1330.05n

.meas tran vdout1_77ck1320 FIND v(dout1_77) AT=1330.05n

.meas tran vdout1_78ck1320 FIND v(dout1_78) AT=1330.05n

.meas tran vdout1_79ck1320 FIND v(dout1_79) AT=1330.05n

.meas tran vdout1_80ck1320 FIND v(dout1_80) AT=1330.05n

.meas tran vdout1_81ck1320 FIND v(dout1_81) AT=1330.05n

.meas tran vdout1_82ck1320 FIND v(dout1_82) AT=1330.05n

.meas tran vdout1_83ck1320 FIND v(dout1_83) AT=1330.05n

.meas tran vdout1_84ck1320 FIND v(dout1_84) AT=1330.05n

.meas tran vdout1_85ck1320 FIND v(dout1_85) AT=1330.05n

.meas tran vdout1_86ck1320 FIND v(dout1_86) AT=1330.05n

.meas tran vdout1_87ck1320 FIND v(dout1_87) AT=1330.05n

.meas tran vdout1_88ck1320 FIND v(dout1_88) AT=1330.05n

.meas tran vdout1_89ck1320 FIND v(dout1_89) AT=1330.05n

.meas tran vdout1_90ck1320 FIND v(dout1_90) AT=1330.05n

.meas tran vdout1_91ck1320 FIND v(dout1_91) AT=1330.05n

.meas tran vdout1_92ck1320 FIND v(dout1_92) AT=1330.05n

.meas tran vdout1_93ck1320 FIND v(dout1_93) AT=1330.05n

.meas tran vdout1_94ck1320 FIND v(dout1_94) AT=1330.05n

.meas tran vdout1_95ck1320 FIND v(dout1_95) AT=1330.05n

.meas tran vdout1_96ck1320 FIND v(dout1_96) AT=1330.05n

.meas tran vdout1_97ck1320 FIND v(dout1_97) AT=1330.05n

.meas tran vdout1_98ck1320 FIND v(dout1_98) AT=1330.05n

.meas tran vdout1_99ck1320 FIND v(dout1_99) AT=1330.05n

.meas tran vdout1_100ck1320 FIND v(dout1_100) AT=1330.05n

.meas tran vdout1_101ck1320 FIND v(dout1_101) AT=1330.05n

.meas tran vdout1_102ck1320 FIND v(dout1_102) AT=1330.05n

.meas tran vdout1_103ck1320 FIND v(dout1_103) AT=1330.05n

.meas tran vdout1_104ck1320 FIND v(dout1_104) AT=1330.05n

.meas tran vdout1_105ck1320 FIND v(dout1_105) AT=1330.05n

.meas tran vdout1_106ck1320 FIND v(dout1_106) AT=1330.05n

.meas tran vdout1_107ck1320 FIND v(dout1_107) AT=1330.05n

.meas tran vdout1_108ck1320 FIND v(dout1_108) AT=1330.05n

.meas tran vdout1_109ck1320 FIND v(dout1_109) AT=1330.05n

.meas tran vdout1_110ck1320 FIND v(dout1_110) AT=1330.05n

.meas tran vdout1_111ck1320 FIND v(dout1_111) AT=1330.05n

.meas tran vdout1_112ck1320 FIND v(dout1_112) AT=1330.05n

.meas tran vdout1_113ck1320 FIND v(dout1_113) AT=1330.05n

.meas tran vdout1_114ck1320 FIND v(dout1_114) AT=1330.05n

.meas tran vdout1_115ck1320 FIND v(dout1_115) AT=1330.05n

.meas tran vdout1_116ck1320 FIND v(dout1_116) AT=1330.05n

.meas tran vdout1_117ck1320 FIND v(dout1_117) AT=1330.05n

.meas tran vdout1_118ck1320 FIND v(dout1_118) AT=1330.05n

.meas tran vdout1_119ck1320 FIND v(dout1_119) AT=1330.05n

.meas tran vdout1_120ck1320 FIND v(dout1_120) AT=1330.05n

.meas tran vdout1_121ck1320 FIND v(dout1_121) AT=1330.05n

.meas tran vdout1_122ck1320 FIND v(dout1_122) AT=1330.05n

.meas tran vdout1_123ck1320 FIND v(dout1_123) AT=1330.05n

.meas tran vdout1_124ck1320 FIND v(dout1_124) AT=1330.05n

.meas tran vdout1_125ck1320 FIND v(dout1_125) AT=1330.05n

.meas tran vdout1_126ck1320 FIND v(dout1_126) AT=1330.05n

.meas tran vdout1_127ck1320 FIND v(dout1_127) AT=1330.05n

.meas tran vdout1_128ck1320 FIND v(dout1_128) AT=1330.05n

.meas tran vdout1_129ck1320 FIND v(dout1_129) AT=1330.05n

.meas tran vdout1_130ck1320 FIND v(dout1_130) AT=1330.05n

.meas tran vdout1_131ck1320 FIND v(dout1_131) AT=1330.05n

.meas tran vdout1_132ck1320 FIND v(dout1_132) AT=1330.05n

.meas tran vdout1_133ck1320 FIND v(dout1_133) AT=1330.05n

.meas tran vdout1_134ck1320 FIND v(dout1_134) AT=1330.05n

.meas tran vdout1_135ck1320 FIND v(dout1_135) AT=1330.05n

.meas tran vdout1_136ck1320 FIND v(dout1_136) AT=1330.05n

.meas tran vdout1_137ck1320 FIND v(dout1_137) AT=1330.05n

.meas tran vdout1_138ck1320 FIND v(dout1_138) AT=1330.05n

.meas tran vdout1_139ck1320 FIND v(dout1_139) AT=1330.05n

.meas tran vdout1_140ck1320 FIND v(dout1_140) AT=1330.05n

.meas tran vdout1_141ck1320 FIND v(dout1_141) AT=1330.05n

.meas tran vdout1_142ck1320 FIND v(dout1_142) AT=1330.05n

.meas tran vdout1_143ck1320 FIND v(dout1_143) AT=1330.05n

.meas tran vdout1_144ck1320 FIND v(dout1_144) AT=1330.05n

.meas tran vdout1_145ck1320 FIND v(dout1_145) AT=1330.05n

.meas tran vdout1_146ck1320 FIND v(dout1_146) AT=1330.05n

.meas tran vdout1_147ck1320 FIND v(dout1_147) AT=1330.05n

.meas tran vdout1_148ck1320 FIND v(dout1_148) AT=1330.05n

.meas tran vdout1_149ck1320 FIND v(dout1_149) AT=1330.05n

.meas tran vdout1_150ck1320 FIND v(dout1_150) AT=1330.05n

.meas tran vdout1_151ck1320 FIND v(dout1_151) AT=1330.05n

.meas tran vdout1_152ck1320 FIND v(dout1_152) AT=1330.05n

.meas tran vdout1_153ck1320 FIND v(dout1_153) AT=1330.05n

.meas tran vdout1_154ck1320 FIND v(dout1_154) AT=1330.05n

.meas tran vdout1_155ck1320 FIND v(dout1_155) AT=1330.05n

.meas tran vdout1_156ck1320 FIND v(dout1_156) AT=1330.05n

.meas tran vdout1_157ck1320 FIND v(dout1_157) AT=1330.05n

.meas tran vdout1_158ck1320 FIND v(dout1_158) AT=1330.05n

.meas tran vdout1_159ck1320 FIND v(dout1_159) AT=1330.05n

.meas tran vdout1_160ck1320 FIND v(dout1_160) AT=1330.05n

.meas tran vdout1_161ck1320 FIND v(dout1_161) AT=1330.05n

.meas tran vdout1_162ck1320 FIND v(dout1_162) AT=1330.05n

.meas tran vdout1_163ck1320 FIND v(dout1_163) AT=1330.05n

.meas tran vdout1_164ck1320 FIND v(dout1_164) AT=1330.05n

.meas tran vdout1_165ck1320 FIND v(dout1_165) AT=1330.05n

.meas tran vdout1_166ck1320 FIND v(dout1_166) AT=1330.05n

.meas tran vdout1_167ck1320 FIND v(dout1_167) AT=1330.05n

.meas tran vdout1_168ck1320 FIND v(dout1_168) AT=1330.05n

.meas tran vdout1_169ck1320 FIND v(dout1_169) AT=1330.05n

.meas tran vdout1_170ck1320 FIND v(dout1_170) AT=1330.05n

.meas tran vdout1_171ck1320 FIND v(dout1_171) AT=1330.05n

.meas tran vdout1_172ck1320 FIND v(dout1_172) AT=1330.05n

.meas tran vdout1_173ck1320 FIND v(dout1_173) AT=1330.05n

.meas tran vdout1_174ck1320 FIND v(dout1_174) AT=1330.05n

.meas tran vdout1_175ck1320 FIND v(dout1_175) AT=1330.05n

.meas tran vdout1_176ck1320 FIND v(dout1_176) AT=1330.05n

.meas tran vdout1_177ck1320 FIND v(dout1_177) AT=1330.05n

.meas tran vdout1_178ck1320 FIND v(dout1_178) AT=1330.05n

.meas tran vdout1_179ck1320 FIND v(dout1_179) AT=1330.05n

.meas tran vdout1_180ck1320 FIND v(dout1_180) AT=1330.05n

.meas tran vdout1_181ck1320 FIND v(dout1_181) AT=1330.05n

.meas tran vdout1_182ck1320 FIND v(dout1_182) AT=1330.05n

.meas tran vdout1_183ck1320 FIND v(dout1_183) AT=1330.05n

.meas tran vdout1_184ck1320 FIND v(dout1_184) AT=1330.05n

.meas tran vdout1_185ck1320 FIND v(dout1_185) AT=1330.05n

.meas tran vdout1_186ck1320 FIND v(dout1_186) AT=1330.05n

.meas tran vdout1_187ck1320 FIND v(dout1_187) AT=1330.05n

.meas tran vdout1_188ck1320 FIND v(dout1_188) AT=1330.05n

.meas tran vdout1_189ck1320 FIND v(dout1_189) AT=1330.05n

.meas tran vdout1_190ck1320 FIND v(dout1_190) AT=1330.05n

.meas tran vdout1_191ck1320 FIND v(dout1_191) AT=1330.05n

.meas tran vdout1_192ck1320 FIND v(dout1_192) AT=1330.05n

.meas tran vdout1_193ck1320 FIND v(dout1_193) AT=1330.05n

.meas tran vdout1_194ck1320 FIND v(dout1_194) AT=1330.05n

.meas tran vdout1_195ck1320 FIND v(dout1_195) AT=1330.05n

.meas tran vdout1_196ck1320 FIND v(dout1_196) AT=1330.05n

.meas tran vdout1_197ck1320 FIND v(dout1_197) AT=1330.05n

.meas tran vdout1_198ck1320 FIND v(dout1_198) AT=1330.05n

.meas tran vdout1_199ck1320 FIND v(dout1_199) AT=1330.05n

.meas tran vdout1_200ck1320 FIND v(dout1_200) AT=1330.05n

.meas tran vdout1_201ck1320 FIND v(dout1_201) AT=1330.05n

.meas tran vdout1_202ck1320 FIND v(dout1_202) AT=1330.05n

.meas tran vdout1_203ck1320 FIND v(dout1_203) AT=1330.05n

.meas tran vdout1_204ck1320 FIND v(dout1_204) AT=1330.05n

.meas tran vdout1_205ck1320 FIND v(dout1_205) AT=1330.05n

.meas tran vdout1_206ck1320 FIND v(dout1_206) AT=1330.05n

.meas tran vdout1_207ck1320 FIND v(dout1_207) AT=1330.05n

.meas tran vdout1_208ck1320 FIND v(dout1_208) AT=1330.05n

.meas tran vdout1_209ck1320 FIND v(dout1_209) AT=1330.05n

.meas tran vdout1_210ck1320 FIND v(dout1_210) AT=1330.05n

.meas tran vdout1_211ck1320 FIND v(dout1_211) AT=1330.05n

.meas tran vdout1_212ck1320 FIND v(dout1_212) AT=1330.05n

.meas tran vdout1_213ck1320 FIND v(dout1_213) AT=1330.05n

.meas tran vdout1_214ck1320 FIND v(dout1_214) AT=1330.05n

.meas tran vdout1_215ck1320 FIND v(dout1_215) AT=1330.05n

.meas tran vdout1_216ck1320 FIND v(dout1_216) AT=1330.05n

.meas tran vdout1_217ck1320 FIND v(dout1_217) AT=1330.05n

.meas tran vdout1_218ck1320 FIND v(dout1_218) AT=1330.05n

.meas tran vdout1_219ck1320 FIND v(dout1_219) AT=1330.05n

.meas tran vdout1_220ck1320 FIND v(dout1_220) AT=1330.05n

.meas tran vdout1_221ck1320 FIND v(dout1_221) AT=1330.05n

.meas tran vdout1_222ck1320 FIND v(dout1_222) AT=1330.05n

.meas tran vdout1_223ck1320 FIND v(dout1_223) AT=1330.05n

.meas tran vdout1_224ck1320 FIND v(dout1_224) AT=1330.05n

.meas tran vdout1_225ck1320 FIND v(dout1_225) AT=1330.05n

.meas tran vdout1_226ck1320 FIND v(dout1_226) AT=1330.05n

.meas tran vdout1_227ck1320 FIND v(dout1_227) AT=1330.05n

.meas tran vdout1_228ck1320 FIND v(dout1_228) AT=1330.05n

.meas tran vdout1_229ck1320 FIND v(dout1_229) AT=1330.05n

.meas tran vdout1_230ck1320 FIND v(dout1_230) AT=1330.05n

.meas tran vdout1_231ck1320 FIND v(dout1_231) AT=1330.05n

.meas tran vdout1_232ck1320 FIND v(dout1_232) AT=1330.05n

.meas tran vdout1_233ck1320 FIND v(dout1_233) AT=1330.05n

.meas tran vdout1_234ck1320 FIND v(dout1_234) AT=1330.05n

.meas tran vdout1_235ck1320 FIND v(dout1_235) AT=1330.05n

.meas tran vdout1_236ck1320 FIND v(dout1_236) AT=1330.05n

.meas tran vdout1_237ck1320 FIND v(dout1_237) AT=1330.05n

.meas tran vdout1_238ck1320 FIND v(dout1_238) AT=1330.05n

.meas tran vdout1_239ck1320 FIND v(dout1_239) AT=1330.05n

.meas tran vdout1_240ck1320 FIND v(dout1_240) AT=1330.05n

.meas tran vdout1_241ck1320 FIND v(dout1_241) AT=1330.05n

.meas tran vdout1_242ck1320 FIND v(dout1_242) AT=1330.05n

.meas tran vdout1_243ck1320 FIND v(dout1_243) AT=1330.05n

.meas tran vdout1_244ck1320 FIND v(dout1_244) AT=1330.05n

.meas tran vdout1_245ck1320 FIND v(dout1_245) AT=1330.05n

.meas tran vdout1_246ck1320 FIND v(dout1_246) AT=1330.05n

.meas tran vdout1_247ck1320 FIND v(dout1_247) AT=1330.05n

.meas tran vdout1_248ck1320 FIND v(dout1_248) AT=1330.05n

.meas tran vdout1_249ck1320 FIND v(dout1_249) AT=1330.05n

.meas tran vdout1_250ck1320 FIND v(dout1_250) AT=1330.05n

.meas tran vdout1_251ck1320 FIND v(dout1_251) AT=1330.05n

.meas tran vdout1_252ck1320 FIND v(dout1_252) AT=1330.05n

.meas tran vdout1_253ck1320 FIND v(dout1_253) AT=1330.05n

.meas tran vdout1_254ck1320 FIND v(dout1_254) AT=1330.05n

.meas tran vdout1_255ck1320 FIND v(dout1_255) AT=1330.05n

.meas tran vdout1_256ck1320 FIND v(dout1_256) AT=1330.05n

.meas tran vdout1_0ck1370 FIND v(dout1_0) AT=1380.05n

.meas tran vdout1_1ck1370 FIND v(dout1_1) AT=1380.05n

.meas tran vdout1_2ck1370 FIND v(dout1_2) AT=1380.05n

.meas tran vdout1_3ck1370 FIND v(dout1_3) AT=1380.05n

.meas tran vdout1_4ck1370 FIND v(dout1_4) AT=1380.05n

.meas tran vdout1_5ck1370 FIND v(dout1_5) AT=1380.05n

.meas tran vdout1_6ck1370 FIND v(dout1_6) AT=1380.05n

.meas tran vdout1_7ck1370 FIND v(dout1_7) AT=1380.05n

.meas tran vdout1_8ck1370 FIND v(dout1_8) AT=1380.05n

.meas tran vdout1_9ck1370 FIND v(dout1_9) AT=1380.05n

.meas tran vdout1_10ck1370 FIND v(dout1_10) AT=1380.05n

.meas tran vdout1_11ck1370 FIND v(dout1_11) AT=1380.05n

.meas tran vdout1_12ck1370 FIND v(dout1_12) AT=1380.05n

.meas tran vdout1_13ck1370 FIND v(dout1_13) AT=1380.05n

.meas tran vdout1_14ck1370 FIND v(dout1_14) AT=1380.05n

.meas tran vdout1_15ck1370 FIND v(dout1_15) AT=1380.05n

.meas tran vdout1_16ck1370 FIND v(dout1_16) AT=1380.05n

.meas tran vdout1_17ck1370 FIND v(dout1_17) AT=1380.05n

.meas tran vdout1_18ck1370 FIND v(dout1_18) AT=1380.05n

.meas tran vdout1_19ck1370 FIND v(dout1_19) AT=1380.05n

.meas tran vdout1_20ck1370 FIND v(dout1_20) AT=1380.05n

.meas tran vdout1_21ck1370 FIND v(dout1_21) AT=1380.05n

.meas tran vdout1_22ck1370 FIND v(dout1_22) AT=1380.05n

.meas tran vdout1_23ck1370 FIND v(dout1_23) AT=1380.05n

.meas tran vdout1_24ck1370 FIND v(dout1_24) AT=1380.05n

.meas tran vdout1_25ck1370 FIND v(dout1_25) AT=1380.05n

.meas tran vdout1_26ck1370 FIND v(dout1_26) AT=1380.05n

.meas tran vdout1_27ck1370 FIND v(dout1_27) AT=1380.05n

.meas tran vdout1_28ck1370 FIND v(dout1_28) AT=1380.05n

.meas tran vdout1_29ck1370 FIND v(dout1_29) AT=1380.05n

.meas tran vdout1_30ck1370 FIND v(dout1_30) AT=1380.05n

.meas tran vdout1_31ck1370 FIND v(dout1_31) AT=1380.05n

.meas tran vdout1_32ck1370 FIND v(dout1_32) AT=1380.05n

.meas tran vdout1_33ck1370 FIND v(dout1_33) AT=1380.05n

.meas tran vdout1_34ck1370 FIND v(dout1_34) AT=1380.05n

.meas tran vdout1_35ck1370 FIND v(dout1_35) AT=1380.05n

.meas tran vdout1_36ck1370 FIND v(dout1_36) AT=1380.05n

.meas tran vdout1_37ck1370 FIND v(dout1_37) AT=1380.05n

.meas tran vdout1_38ck1370 FIND v(dout1_38) AT=1380.05n

.meas tran vdout1_39ck1370 FIND v(dout1_39) AT=1380.05n

.meas tran vdout1_40ck1370 FIND v(dout1_40) AT=1380.05n

.meas tran vdout1_41ck1370 FIND v(dout1_41) AT=1380.05n

.meas tran vdout1_42ck1370 FIND v(dout1_42) AT=1380.05n

.meas tran vdout1_43ck1370 FIND v(dout1_43) AT=1380.05n

.meas tran vdout1_44ck1370 FIND v(dout1_44) AT=1380.05n

.meas tran vdout1_45ck1370 FIND v(dout1_45) AT=1380.05n

.meas tran vdout1_46ck1370 FIND v(dout1_46) AT=1380.05n

.meas tran vdout1_47ck1370 FIND v(dout1_47) AT=1380.05n

.meas tran vdout1_48ck1370 FIND v(dout1_48) AT=1380.05n

.meas tran vdout1_49ck1370 FIND v(dout1_49) AT=1380.05n

.meas tran vdout1_50ck1370 FIND v(dout1_50) AT=1380.05n

.meas tran vdout1_51ck1370 FIND v(dout1_51) AT=1380.05n

.meas tran vdout1_52ck1370 FIND v(dout1_52) AT=1380.05n

.meas tran vdout1_53ck1370 FIND v(dout1_53) AT=1380.05n

.meas tran vdout1_54ck1370 FIND v(dout1_54) AT=1380.05n

.meas tran vdout1_55ck1370 FIND v(dout1_55) AT=1380.05n

.meas tran vdout1_56ck1370 FIND v(dout1_56) AT=1380.05n

.meas tran vdout1_57ck1370 FIND v(dout1_57) AT=1380.05n

.meas tran vdout1_58ck1370 FIND v(dout1_58) AT=1380.05n

.meas tran vdout1_59ck1370 FIND v(dout1_59) AT=1380.05n

.meas tran vdout1_60ck1370 FIND v(dout1_60) AT=1380.05n

.meas tran vdout1_61ck1370 FIND v(dout1_61) AT=1380.05n

.meas tran vdout1_62ck1370 FIND v(dout1_62) AT=1380.05n

.meas tran vdout1_63ck1370 FIND v(dout1_63) AT=1380.05n

.meas tran vdout1_64ck1370 FIND v(dout1_64) AT=1380.05n

.meas tran vdout1_65ck1370 FIND v(dout1_65) AT=1380.05n

.meas tran vdout1_66ck1370 FIND v(dout1_66) AT=1380.05n

.meas tran vdout1_67ck1370 FIND v(dout1_67) AT=1380.05n

.meas tran vdout1_68ck1370 FIND v(dout1_68) AT=1380.05n

.meas tran vdout1_69ck1370 FIND v(dout1_69) AT=1380.05n

.meas tran vdout1_70ck1370 FIND v(dout1_70) AT=1380.05n

.meas tran vdout1_71ck1370 FIND v(dout1_71) AT=1380.05n

.meas tran vdout1_72ck1370 FIND v(dout1_72) AT=1380.05n

.meas tran vdout1_73ck1370 FIND v(dout1_73) AT=1380.05n

.meas tran vdout1_74ck1370 FIND v(dout1_74) AT=1380.05n

.meas tran vdout1_75ck1370 FIND v(dout1_75) AT=1380.05n

.meas tran vdout1_76ck1370 FIND v(dout1_76) AT=1380.05n

.meas tran vdout1_77ck1370 FIND v(dout1_77) AT=1380.05n

.meas tran vdout1_78ck1370 FIND v(dout1_78) AT=1380.05n

.meas tran vdout1_79ck1370 FIND v(dout1_79) AT=1380.05n

.meas tran vdout1_80ck1370 FIND v(dout1_80) AT=1380.05n

.meas tran vdout1_81ck1370 FIND v(dout1_81) AT=1380.05n

.meas tran vdout1_82ck1370 FIND v(dout1_82) AT=1380.05n

.meas tran vdout1_83ck1370 FIND v(dout1_83) AT=1380.05n

.meas tran vdout1_84ck1370 FIND v(dout1_84) AT=1380.05n

.meas tran vdout1_85ck1370 FIND v(dout1_85) AT=1380.05n

.meas tran vdout1_86ck1370 FIND v(dout1_86) AT=1380.05n

.meas tran vdout1_87ck1370 FIND v(dout1_87) AT=1380.05n

.meas tran vdout1_88ck1370 FIND v(dout1_88) AT=1380.05n

.meas tran vdout1_89ck1370 FIND v(dout1_89) AT=1380.05n

.meas tran vdout1_90ck1370 FIND v(dout1_90) AT=1380.05n

.meas tran vdout1_91ck1370 FIND v(dout1_91) AT=1380.05n

.meas tran vdout1_92ck1370 FIND v(dout1_92) AT=1380.05n

.meas tran vdout1_93ck1370 FIND v(dout1_93) AT=1380.05n

.meas tran vdout1_94ck1370 FIND v(dout1_94) AT=1380.05n

.meas tran vdout1_95ck1370 FIND v(dout1_95) AT=1380.05n

.meas tran vdout1_96ck1370 FIND v(dout1_96) AT=1380.05n

.meas tran vdout1_97ck1370 FIND v(dout1_97) AT=1380.05n

.meas tran vdout1_98ck1370 FIND v(dout1_98) AT=1380.05n

.meas tran vdout1_99ck1370 FIND v(dout1_99) AT=1380.05n

.meas tran vdout1_100ck1370 FIND v(dout1_100) AT=1380.05n

.meas tran vdout1_101ck1370 FIND v(dout1_101) AT=1380.05n

.meas tran vdout1_102ck1370 FIND v(dout1_102) AT=1380.05n

.meas tran vdout1_103ck1370 FIND v(dout1_103) AT=1380.05n

.meas tran vdout1_104ck1370 FIND v(dout1_104) AT=1380.05n

.meas tran vdout1_105ck1370 FIND v(dout1_105) AT=1380.05n

.meas tran vdout1_106ck1370 FIND v(dout1_106) AT=1380.05n

.meas tran vdout1_107ck1370 FIND v(dout1_107) AT=1380.05n

.meas tran vdout1_108ck1370 FIND v(dout1_108) AT=1380.05n

.meas tran vdout1_109ck1370 FIND v(dout1_109) AT=1380.05n

.meas tran vdout1_110ck1370 FIND v(dout1_110) AT=1380.05n

.meas tran vdout1_111ck1370 FIND v(dout1_111) AT=1380.05n

.meas tran vdout1_112ck1370 FIND v(dout1_112) AT=1380.05n

.meas tran vdout1_113ck1370 FIND v(dout1_113) AT=1380.05n

.meas tran vdout1_114ck1370 FIND v(dout1_114) AT=1380.05n

.meas tran vdout1_115ck1370 FIND v(dout1_115) AT=1380.05n

.meas tran vdout1_116ck1370 FIND v(dout1_116) AT=1380.05n

.meas tran vdout1_117ck1370 FIND v(dout1_117) AT=1380.05n

.meas tran vdout1_118ck1370 FIND v(dout1_118) AT=1380.05n

.meas tran vdout1_119ck1370 FIND v(dout1_119) AT=1380.05n

.meas tran vdout1_120ck1370 FIND v(dout1_120) AT=1380.05n

.meas tran vdout1_121ck1370 FIND v(dout1_121) AT=1380.05n

.meas tran vdout1_122ck1370 FIND v(dout1_122) AT=1380.05n

.meas tran vdout1_123ck1370 FIND v(dout1_123) AT=1380.05n

.meas tran vdout1_124ck1370 FIND v(dout1_124) AT=1380.05n

.meas tran vdout1_125ck1370 FIND v(dout1_125) AT=1380.05n

.meas tran vdout1_126ck1370 FIND v(dout1_126) AT=1380.05n

.meas tran vdout1_127ck1370 FIND v(dout1_127) AT=1380.05n

.meas tran vdout1_128ck1370 FIND v(dout1_128) AT=1380.05n

.meas tran vdout1_129ck1370 FIND v(dout1_129) AT=1380.05n

.meas tran vdout1_130ck1370 FIND v(dout1_130) AT=1380.05n

.meas tran vdout1_131ck1370 FIND v(dout1_131) AT=1380.05n

.meas tran vdout1_132ck1370 FIND v(dout1_132) AT=1380.05n

.meas tran vdout1_133ck1370 FIND v(dout1_133) AT=1380.05n

.meas tran vdout1_134ck1370 FIND v(dout1_134) AT=1380.05n

.meas tran vdout1_135ck1370 FIND v(dout1_135) AT=1380.05n

.meas tran vdout1_136ck1370 FIND v(dout1_136) AT=1380.05n

.meas tran vdout1_137ck1370 FIND v(dout1_137) AT=1380.05n

.meas tran vdout1_138ck1370 FIND v(dout1_138) AT=1380.05n

.meas tran vdout1_139ck1370 FIND v(dout1_139) AT=1380.05n

.meas tran vdout1_140ck1370 FIND v(dout1_140) AT=1380.05n

.meas tran vdout1_141ck1370 FIND v(dout1_141) AT=1380.05n

.meas tran vdout1_142ck1370 FIND v(dout1_142) AT=1380.05n

.meas tran vdout1_143ck1370 FIND v(dout1_143) AT=1380.05n

.meas tran vdout1_144ck1370 FIND v(dout1_144) AT=1380.05n

.meas tran vdout1_145ck1370 FIND v(dout1_145) AT=1380.05n

.meas tran vdout1_146ck1370 FIND v(dout1_146) AT=1380.05n

.meas tran vdout1_147ck1370 FIND v(dout1_147) AT=1380.05n

.meas tran vdout1_148ck1370 FIND v(dout1_148) AT=1380.05n

.meas tran vdout1_149ck1370 FIND v(dout1_149) AT=1380.05n

.meas tran vdout1_150ck1370 FIND v(dout1_150) AT=1380.05n

.meas tran vdout1_151ck1370 FIND v(dout1_151) AT=1380.05n

.meas tran vdout1_152ck1370 FIND v(dout1_152) AT=1380.05n

.meas tran vdout1_153ck1370 FIND v(dout1_153) AT=1380.05n

.meas tran vdout1_154ck1370 FIND v(dout1_154) AT=1380.05n

.meas tran vdout1_155ck1370 FIND v(dout1_155) AT=1380.05n

.meas tran vdout1_156ck1370 FIND v(dout1_156) AT=1380.05n

.meas tran vdout1_157ck1370 FIND v(dout1_157) AT=1380.05n

.meas tran vdout1_158ck1370 FIND v(dout1_158) AT=1380.05n

.meas tran vdout1_159ck1370 FIND v(dout1_159) AT=1380.05n

.meas tran vdout1_160ck1370 FIND v(dout1_160) AT=1380.05n

.meas tran vdout1_161ck1370 FIND v(dout1_161) AT=1380.05n

.meas tran vdout1_162ck1370 FIND v(dout1_162) AT=1380.05n

.meas tran vdout1_163ck1370 FIND v(dout1_163) AT=1380.05n

.meas tran vdout1_164ck1370 FIND v(dout1_164) AT=1380.05n

.meas tran vdout1_165ck1370 FIND v(dout1_165) AT=1380.05n

.meas tran vdout1_166ck1370 FIND v(dout1_166) AT=1380.05n

.meas tran vdout1_167ck1370 FIND v(dout1_167) AT=1380.05n

.meas tran vdout1_168ck1370 FIND v(dout1_168) AT=1380.05n

.meas tran vdout1_169ck1370 FIND v(dout1_169) AT=1380.05n

.meas tran vdout1_170ck1370 FIND v(dout1_170) AT=1380.05n

.meas tran vdout1_171ck1370 FIND v(dout1_171) AT=1380.05n

.meas tran vdout1_172ck1370 FIND v(dout1_172) AT=1380.05n

.meas tran vdout1_173ck1370 FIND v(dout1_173) AT=1380.05n

.meas tran vdout1_174ck1370 FIND v(dout1_174) AT=1380.05n

.meas tran vdout1_175ck1370 FIND v(dout1_175) AT=1380.05n

.meas tran vdout1_176ck1370 FIND v(dout1_176) AT=1380.05n

.meas tran vdout1_177ck1370 FIND v(dout1_177) AT=1380.05n

.meas tran vdout1_178ck1370 FIND v(dout1_178) AT=1380.05n

.meas tran vdout1_179ck1370 FIND v(dout1_179) AT=1380.05n

.meas tran vdout1_180ck1370 FIND v(dout1_180) AT=1380.05n

.meas tran vdout1_181ck1370 FIND v(dout1_181) AT=1380.05n

.meas tran vdout1_182ck1370 FIND v(dout1_182) AT=1380.05n

.meas tran vdout1_183ck1370 FIND v(dout1_183) AT=1380.05n

.meas tran vdout1_184ck1370 FIND v(dout1_184) AT=1380.05n

.meas tran vdout1_185ck1370 FIND v(dout1_185) AT=1380.05n

.meas tran vdout1_186ck1370 FIND v(dout1_186) AT=1380.05n

.meas tran vdout1_187ck1370 FIND v(dout1_187) AT=1380.05n

.meas tran vdout1_188ck1370 FIND v(dout1_188) AT=1380.05n

.meas tran vdout1_189ck1370 FIND v(dout1_189) AT=1380.05n

.meas tran vdout1_190ck1370 FIND v(dout1_190) AT=1380.05n

.meas tran vdout1_191ck1370 FIND v(dout1_191) AT=1380.05n

.meas tran vdout1_192ck1370 FIND v(dout1_192) AT=1380.05n

.meas tran vdout1_193ck1370 FIND v(dout1_193) AT=1380.05n

.meas tran vdout1_194ck1370 FIND v(dout1_194) AT=1380.05n

.meas tran vdout1_195ck1370 FIND v(dout1_195) AT=1380.05n

.meas tran vdout1_196ck1370 FIND v(dout1_196) AT=1380.05n

.meas tran vdout1_197ck1370 FIND v(dout1_197) AT=1380.05n

.meas tran vdout1_198ck1370 FIND v(dout1_198) AT=1380.05n

.meas tran vdout1_199ck1370 FIND v(dout1_199) AT=1380.05n

.meas tran vdout1_200ck1370 FIND v(dout1_200) AT=1380.05n

.meas tran vdout1_201ck1370 FIND v(dout1_201) AT=1380.05n

.meas tran vdout1_202ck1370 FIND v(dout1_202) AT=1380.05n

.meas tran vdout1_203ck1370 FIND v(dout1_203) AT=1380.05n

.meas tran vdout1_204ck1370 FIND v(dout1_204) AT=1380.05n

.meas tran vdout1_205ck1370 FIND v(dout1_205) AT=1380.05n

.meas tran vdout1_206ck1370 FIND v(dout1_206) AT=1380.05n

.meas tran vdout1_207ck1370 FIND v(dout1_207) AT=1380.05n

.meas tran vdout1_208ck1370 FIND v(dout1_208) AT=1380.05n

.meas tran vdout1_209ck1370 FIND v(dout1_209) AT=1380.05n

.meas tran vdout1_210ck1370 FIND v(dout1_210) AT=1380.05n

.meas tran vdout1_211ck1370 FIND v(dout1_211) AT=1380.05n

.meas tran vdout1_212ck1370 FIND v(dout1_212) AT=1380.05n

.meas tran vdout1_213ck1370 FIND v(dout1_213) AT=1380.05n

.meas tran vdout1_214ck1370 FIND v(dout1_214) AT=1380.05n

.meas tran vdout1_215ck1370 FIND v(dout1_215) AT=1380.05n

.meas tran vdout1_216ck1370 FIND v(dout1_216) AT=1380.05n

.meas tran vdout1_217ck1370 FIND v(dout1_217) AT=1380.05n

.meas tran vdout1_218ck1370 FIND v(dout1_218) AT=1380.05n

.meas tran vdout1_219ck1370 FIND v(dout1_219) AT=1380.05n

.meas tran vdout1_220ck1370 FIND v(dout1_220) AT=1380.05n

.meas tran vdout1_221ck1370 FIND v(dout1_221) AT=1380.05n

.meas tran vdout1_222ck1370 FIND v(dout1_222) AT=1380.05n

.meas tran vdout1_223ck1370 FIND v(dout1_223) AT=1380.05n

.meas tran vdout1_224ck1370 FIND v(dout1_224) AT=1380.05n

.meas tran vdout1_225ck1370 FIND v(dout1_225) AT=1380.05n

.meas tran vdout1_226ck1370 FIND v(dout1_226) AT=1380.05n

.meas tran vdout1_227ck1370 FIND v(dout1_227) AT=1380.05n

.meas tran vdout1_228ck1370 FIND v(dout1_228) AT=1380.05n

.meas tran vdout1_229ck1370 FIND v(dout1_229) AT=1380.05n

.meas tran vdout1_230ck1370 FIND v(dout1_230) AT=1380.05n

.meas tran vdout1_231ck1370 FIND v(dout1_231) AT=1380.05n

.meas tran vdout1_232ck1370 FIND v(dout1_232) AT=1380.05n

.meas tran vdout1_233ck1370 FIND v(dout1_233) AT=1380.05n

.meas tran vdout1_234ck1370 FIND v(dout1_234) AT=1380.05n

.meas tran vdout1_235ck1370 FIND v(dout1_235) AT=1380.05n

.meas tran vdout1_236ck1370 FIND v(dout1_236) AT=1380.05n

.meas tran vdout1_237ck1370 FIND v(dout1_237) AT=1380.05n

.meas tran vdout1_238ck1370 FIND v(dout1_238) AT=1380.05n

.meas tran vdout1_239ck1370 FIND v(dout1_239) AT=1380.05n

.meas tran vdout1_240ck1370 FIND v(dout1_240) AT=1380.05n

.meas tran vdout1_241ck1370 FIND v(dout1_241) AT=1380.05n

.meas tran vdout1_242ck1370 FIND v(dout1_242) AT=1380.05n

.meas tran vdout1_243ck1370 FIND v(dout1_243) AT=1380.05n

.meas tran vdout1_244ck1370 FIND v(dout1_244) AT=1380.05n

.meas tran vdout1_245ck1370 FIND v(dout1_245) AT=1380.05n

.meas tran vdout1_246ck1370 FIND v(dout1_246) AT=1380.05n

.meas tran vdout1_247ck1370 FIND v(dout1_247) AT=1380.05n

.meas tran vdout1_248ck1370 FIND v(dout1_248) AT=1380.05n

.meas tran vdout1_249ck1370 FIND v(dout1_249) AT=1380.05n

.meas tran vdout1_250ck1370 FIND v(dout1_250) AT=1380.05n

.meas tran vdout1_251ck1370 FIND v(dout1_251) AT=1380.05n

.meas tran vdout1_252ck1370 FIND v(dout1_252) AT=1380.05n

.meas tran vdout1_253ck1370 FIND v(dout1_253) AT=1380.05n

.meas tran vdout1_254ck1370 FIND v(dout1_254) AT=1380.05n

.meas tran vdout1_255ck1370 FIND v(dout1_255) AT=1380.05n

.meas tran vdout1_256ck1370 FIND v(dout1_256) AT=1380.05n

.meas tran vdout1_0ck1400 FIND v(dout1_0) AT=1410.05n

.meas tran vdout1_1ck1400 FIND v(dout1_1) AT=1410.05n

.meas tran vdout1_2ck1400 FIND v(dout1_2) AT=1410.05n

.meas tran vdout1_3ck1400 FIND v(dout1_3) AT=1410.05n

.meas tran vdout1_4ck1400 FIND v(dout1_4) AT=1410.05n

.meas tran vdout1_5ck1400 FIND v(dout1_5) AT=1410.05n

.meas tran vdout1_6ck1400 FIND v(dout1_6) AT=1410.05n

.meas tran vdout1_7ck1400 FIND v(dout1_7) AT=1410.05n

.meas tran vdout1_8ck1400 FIND v(dout1_8) AT=1410.05n

.meas tran vdout1_9ck1400 FIND v(dout1_9) AT=1410.05n

.meas tran vdout1_10ck1400 FIND v(dout1_10) AT=1410.05n

.meas tran vdout1_11ck1400 FIND v(dout1_11) AT=1410.05n

.meas tran vdout1_12ck1400 FIND v(dout1_12) AT=1410.05n

.meas tran vdout1_13ck1400 FIND v(dout1_13) AT=1410.05n

.meas tran vdout1_14ck1400 FIND v(dout1_14) AT=1410.05n

.meas tran vdout1_15ck1400 FIND v(dout1_15) AT=1410.05n

.meas tran vdout1_16ck1400 FIND v(dout1_16) AT=1410.05n

.meas tran vdout1_17ck1400 FIND v(dout1_17) AT=1410.05n

.meas tran vdout1_18ck1400 FIND v(dout1_18) AT=1410.05n

.meas tran vdout1_19ck1400 FIND v(dout1_19) AT=1410.05n

.meas tran vdout1_20ck1400 FIND v(dout1_20) AT=1410.05n

.meas tran vdout1_21ck1400 FIND v(dout1_21) AT=1410.05n

.meas tran vdout1_22ck1400 FIND v(dout1_22) AT=1410.05n

.meas tran vdout1_23ck1400 FIND v(dout1_23) AT=1410.05n

.meas tran vdout1_24ck1400 FIND v(dout1_24) AT=1410.05n

.meas tran vdout1_25ck1400 FIND v(dout1_25) AT=1410.05n

.meas tran vdout1_26ck1400 FIND v(dout1_26) AT=1410.05n

.meas tran vdout1_27ck1400 FIND v(dout1_27) AT=1410.05n

.meas tran vdout1_28ck1400 FIND v(dout1_28) AT=1410.05n

.meas tran vdout1_29ck1400 FIND v(dout1_29) AT=1410.05n

.meas tran vdout1_30ck1400 FIND v(dout1_30) AT=1410.05n

.meas tran vdout1_31ck1400 FIND v(dout1_31) AT=1410.05n

.meas tran vdout1_32ck1400 FIND v(dout1_32) AT=1410.05n

.meas tran vdout1_33ck1400 FIND v(dout1_33) AT=1410.05n

.meas tran vdout1_34ck1400 FIND v(dout1_34) AT=1410.05n

.meas tran vdout1_35ck1400 FIND v(dout1_35) AT=1410.05n

.meas tran vdout1_36ck1400 FIND v(dout1_36) AT=1410.05n

.meas tran vdout1_37ck1400 FIND v(dout1_37) AT=1410.05n

.meas tran vdout1_38ck1400 FIND v(dout1_38) AT=1410.05n

.meas tran vdout1_39ck1400 FIND v(dout1_39) AT=1410.05n

.meas tran vdout1_40ck1400 FIND v(dout1_40) AT=1410.05n

.meas tran vdout1_41ck1400 FIND v(dout1_41) AT=1410.05n

.meas tran vdout1_42ck1400 FIND v(dout1_42) AT=1410.05n

.meas tran vdout1_43ck1400 FIND v(dout1_43) AT=1410.05n

.meas tran vdout1_44ck1400 FIND v(dout1_44) AT=1410.05n

.meas tran vdout1_45ck1400 FIND v(dout1_45) AT=1410.05n

.meas tran vdout1_46ck1400 FIND v(dout1_46) AT=1410.05n

.meas tran vdout1_47ck1400 FIND v(dout1_47) AT=1410.05n

.meas tran vdout1_48ck1400 FIND v(dout1_48) AT=1410.05n

.meas tran vdout1_49ck1400 FIND v(dout1_49) AT=1410.05n

.meas tran vdout1_50ck1400 FIND v(dout1_50) AT=1410.05n

.meas tran vdout1_51ck1400 FIND v(dout1_51) AT=1410.05n

.meas tran vdout1_52ck1400 FIND v(dout1_52) AT=1410.05n

.meas tran vdout1_53ck1400 FIND v(dout1_53) AT=1410.05n

.meas tran vdout1_54ck1400 FIND v(dout1_54) AT=1410.05n

.meas tran vdout1_55ck1400 FIND v(dout1_55) AT=1410.05n

.meas tran vdout1_56ck1400 FIND v(dout1_56) AT=1410.05n

.meas tran vdout1_57ck1400 FIND v(dout1_57) AT=1410.05n

.meas tran vdout1_58ck1400 FIND v(dout1_58) AT=1410.05n

.meas tran vdout1_59ck1400 FIND v(dout1_59) AT=1410.05n

.meas tran vdout1_60ck1400 FIND v(dout1_60) AT=1410.05n

.meas tran vdout1_61ck1400 FIND v(dout1_61) AT=1410.05n

.meas tran vdout1_62ck1400 FIND v(dout1_62) AT=1410.05n

.meas tran vdout1_63ck1400 FIND v(dout1_63) AT=1410.05n

.meas tran vdout1_64ck1400 FIND v(dout1_64) AT=1410.05n

.meas tran vdout1_65ck1400 FIND v(dout1_65) AT=1410.05n

.meas tran vdout1_66ck1400 FIND v(dout1_66) AT=1410.05n

.meas tran vdout1_67ck1400 FIND v(dout1_67) AT=1410.05n

.meas tran vdout1_68ck1400 FIND v(dout1_68) AT=1410.05n

.meas tran vdout1_69ck1400 FIND v(dout1_69) AT=1410.05n

.meas tran vdout1_70ck1400 FIND v(dout1_70) AT=1410.05n

.meas tran vdout1_71ck1400 FIND v(dout1_71) AT=1410.05n

.meas tran vdout1_72ck1400 FIND v(dout1_72) AT=1410.05n

.meas tran vdout1_73ck1400 FIND v(dout1_73) AT=1410.05n

.meas tran vdout1_74ck1400 FIND v(dout1_74) AT=1410.05n

.meas tran vdout1_75ck1400 FIND v(dout1_75) AT=1410.05n

.meas tran vdout1_76ck1400 FIND v(dout1_76) AT=1410.05n

.meas tran vdout1_77ck1400 FIND v(dout1_77) AT=1410.05n

.meas tran vdout1_78ck1400 FIND v(dout1_78) AT=1410.05n

.meas tran vdout1_79ck1400 FIND v(dout1_79) AT=1410.05n

.meas tran vdout1_80ck1400 FIND v(dout1_80) AT=1410.05n

.meas tran vdout1_81ck1400 FIND v(dout1_81) AT=1410.05n

.meas tran vdout1_82ck1400 FIND v(dout1_82) AT=1410.05n

.meas tran vdout1_83ck1400 FIND v(dout1_83) AT=1410.05n

.meas tran vdout1_84ck1400 FIND v(dout1_84) AT=1410.05n

.meas tran vdout1_85ck1400 FIND v(dout1_85) AT=1410.05n

.meas tran vdout1_86ck1400 FIND v(dout1_86) AT=1410.05n

.meas tran vdout1_87ck1400 FIND v(dout1_87) AT=1410.05n

.meas tran vdout1_88ck1400 FIND v(dout1_88) AT=1410.05n

.meas tran vdout1_89ck1400 FIND v(dout1_89) AT=1410.05n

.meas tran vdout1_90ck1400 FIND v(dout1_90) AT=1410.05n

.meas tran vdout1_91ck1400 FIND v(dout1_91) AT=1410.05n

.meas tran vdout1_92ck1400 FIND v(dout1_92) AT=1410.05n

.meas tran vdout1_93ck1400 FIND v(dout1_93) AT=1410.05n

.meas tran vdout1_94ck1400 FIND v(dout1_94) AT=1410.05n

.meas tran vdout1_95ck1400 FIND v(dout1_95) AT=1410.05n

.meas tran vdout1_96ck1400 FIND v(dout1_96) AT=1410.05n

.meas tran vdout1_97ck1400 FIND v(dout1_97) AT=1410.05n

.meas tran vdout1_98ck1400 FIND v(dout1_98) AT=1410.05n

.meas tran vdout1_99ck1400 FIND v(dout1_99) AT=1410.05n

.meas tran vdout1_100ck1400 FIND v(dout1_100) AT=1410.05n

.meas tran vdout1_101ck1400 FIND v(dout1_101) AT=1410.05n

.meas tran vdout1_102ck1400 FIND v(dout1_102) AT=1410.05n

.meas tran vdout1_103ck1400 FIND v(dout1_103) AT=1410.05n

.meas tran vdout1_104ck1400 FIND v(dout1_104) AT=1410.05n

.meas tran vdout1_105ck1400 FIND v(dout1_105) AT=1410.05n

.meas tran vdout1_106ck1400 FIND v(dout1_106) AT=1410.05n

.meas tran vdout1_107ck1400 FIND v(dout1_107) AT=1410.05n

.meas tran vdout1_108ck1400 FIND v(dout1_108) AT=1410.05n

.meas tran vdout1_109ck1400 FIND v(dout1_109) AT=1410.05n

.meas tran vdout1_110ck1400 FIND v(dout1_110) AT=1410.05n

.meas tran vdout1_111ck1400 FIND v(dout1_111) AT=1410.05n

.meas tran vdout1_112ck1400 FIND v(dout1_112) AT=1410.05n

.meas tran vdout1_113ck1400 FIND v(dout1_113) AT=1410.05n

.meas tran vdout1_114ck1400 FIND v(dout1_114) AT=1410.05n

.meas tran vdout1_115ck1400 FIND v(dout1_115) AT=1410.05n

.meas tran vdout1_116ck1400 FIND v(dout1_116) AT=1410.05n

.meas tran vdout1_117ck1400 FIND v(dout1_117) AT=1410.05n

.meas tran vdout1_118ck1400 FIND v(dout1_118) AT=1410.05n

.meas tran vdout1_119ck1400 FIND v(dout1_119) AT=1410.05n

.meas tran vdout1_120ck1400 FIND v(dout1_120) AT=1410.05n

.meas tran vdout1_121ck1400 FIND v(dout1_121) AT=1410.05n

.meas tran vdout1_122ck1400 FIND v(dout1_122) AT=1410.05n

.meas tran vdout1_123ck1400 FIND v(dout1_123) AT=1410.05n

.meas tran vdout1_124ck1400 FIND v(dout1_124) AT=1410.05n

.meas tran vdout1_125ck1400 FIND v(dout1_125) AT=1410.05n

.meas tran vdout1_126ck1400 FIND v(dout1_126) AT=1410.05n

.meas tran vdout1_127ck1400 FIND v(dout1_127) AT=1410.05n

.meas tran vdout1_128ck1400 FIND v(dout1_128) AT=1410.05n

.meas tran vdout1_129ck1400 FIND v(dout1_129) AT=1410.05n

.meas tran vdout1_130ck1400 FIND v(dout1_130) AT=1410.05n

.meas tran vdout1_131ck1400 FIND v(dout1_131) AT=1410.05n

.meas tran vdout1_132ck1400 FIND v(dout1_132) AT=1410.05n

.meas tran vdout1_133ck1400 FIND v(dout1_133) AT=1410.05n

.meas tran vdout1_134ck1400 FIND v(dout1_134) AT=1410.05n

.meas tran vdout1_135ck1400 FIND v(dout1_135) AT=1410.05n

.meas tran vdout1_136ck1400 FIND v(dout1_136) AT=1410.05n

.meas tran vdout1_137ck1400 FIND v(dout1_137) AT=1410.05n

.meas tran vdout1_138ck1400 FIND v(dout1_138) AT=1410.05n

.meas tran vdout1_139ck1400 FIND v(dout1_139) AT=1410.05n

.meas tran vdout1_140ck1400 FIND v(dout1_140) AT=1410.05n

.meas tran vdout1_141ck1400 FIND v(dout1_141) AT=1410.05n

.meas tran vdout1_142ck1400 FIND v(dout1_142) AT=1410.05n

.meas tran vdout1_143ck1400 FIND v(dout1_143) AT=1410.05n

.meas tran vdout1_144ck1400 FIND v(dout1_144) AT=1410.05n

.meas tran vdout1_145ck1400 FIND v(dout1_145) AT=1410.05n

.meas tran vdout1_146ck1400 FIND v(dout1_146) AT=1410.05n

.meas tran vdout1_147ck1400 FIND v(dout1_147) AT=1410.05n

.meas tran vdout1_148ck1400 FIND v(dout1_148) AT=1410.05n

.meas tran vdout1_149ck1400 FIND v(dout1_149) AT=1410.05n

.meas tran vdout1_150ck1400 FIND v(dout1_150) AT=1410.05n

.meas tran vdout1_151ck1400 FIND v(dout1_151) AT=1410.05n

.meas tran vdout1_152ck1400 FIND v(dout1_152) AT=1410.05n

.meas tran vdout1_153ck1400 FIND v(dout1_153) AT=1410.05n

.meas tran vdout1_154ck1400 FIND v(dout1_154) AT=1410.05n

.meas tran vdout1_155ck1400 FIND v(dout1_155) AT=1410.05n

.meas tran vdout1_156ck1400 FIND v(dout1_156) AT=1410.05n

.meas tran vdout1_157ck1400 FIND v(dout1_157) AT=1410.05n

.meas tran vdout1_158ck1400 FIND v(dout1_158) AT=1410.05n

.meas tran vdout1_159ck1400 FIND v(dout1_159) AT=1410.05n

.meas tran vdout1_160ck1400 FIND v(dout1_160) AT=1410.05n

.meas tran vdout1_161ck1400 FIND v(dout1_161) AT=1410.05n

.meas tran vdout1_162ck1400 FIND v(dout1_162) AT=1410.05n

.meas tran vdout1_163ck1400 FIND v(dout1_163) AT=1410.05n

.meas tran vdout1_164ck1400 FIND v(dout1_164) AT=1410.05n

.meas tran vdout1_165ck1400 FIND v(dout1_165) AT=1410.05n

.meas tran vdout1_166ck1400 FIND v(dout1_166) AT=1410.05n

.meas tran vdout1_167ck1400 FIND v(dout1_167) AT=1410.05n

.meas tran vdout1_168ck1400 FIND v(dout1_168) AT=1410.05n

.meas tran vdout1_169ck1400 FIND v(dout1_169) AT=1410.05n

.meas tran vdout1_170ck1400 FIND v(dout1_170) AT=1410.05n

.meas tran vdout1_171ck1400 FIND v(dout1_171) AT=1410.05n

.meas tran vdout1_172ck1400 FIND v(dout1_172) AT=1410.05n

.meas tran vdout1_173ck1400 FIND v(dout1_173) AT=1410.05n

.meas tran vdout1_174ck1400 FIND v(dout1_174) AT=1410.05n

.meas tran vdout1_175ck1400 FIND v(dout1_175) AT=1410.05n

.meas tran vdout1_176ck1400 FIND v(dout1_176) AT=1410.05n

.meas tran vdout1_177ck1400 FIND v(dout1_177) AT=1410.05n

.meas tran vdout1_178ck1400 FIND v(dout1_178) AT=1410.05n

.meas tran vdout1_179ck1400 FIND v(dout1_179) AT=1410.05n

.meas tran vdout1_180ck1400 FIND v(dout1_180) AT=1410.05n

.meas tran vdout1_181ck1400 FIND v(dout1_181) AT=1410.05n

.meas tran vdout1_182ck1400 FIND v(dout1_182) AT=1410.05n

.meas tran vdout1_183ck1400 FIND v(dout1_183) AT=1410.05n

.meas tran vdout1_184ck1400 FIND v(dout1_184) AT=1410.05n

.meas tran vdout1_185ck1400 FIND v(dout1_185) AT=1410.05n

.meas tran vdout1_186ck1400 FIND v(dout1_186) AT=1410.05n

.meas tran vdout1_187ck1400 FIND v(dout1_187) AT=1410.05n

.meas tran vdout1_188ck1400 FIND v(dout1_188) AT=1410.05n

.meas tran vdout1_189ck1400 FIND v(dout1_189) AT=1410.05n

.meas tran vdout1_190ck1400 FIND v(dout1_190) AT=1410.05n

.meas tran vdout1_191ck1400 FIND v(dout1_191) AT=1410.05n

.meas tran vdout1_192ck1400 FIND v(dout1_192) AT=1410.05n

.meas tran vdout1_193ck1400 FIND v(dout1_193) AT=1410.05n

.meas tran vdout1_194ck1400 FIND v(dout1_194) AT=1410.05n

.meas tran vdout1_195ck1400 FIND v(dout1_195) AT=1410.05n

.meas tran vdout1_196ck1400 FIND v(dout1_196) AT=1410.05n

.meas tran vdout1_197ck1400 FIND v(dout1_197) AT=1410.05n

.meas tran vdout1_198ck1400 FIND v(dout1_198) AT=1410.05n

.meas tran vdout1_199ck1400 FIND v(dout1_199) AT=1410.05n

.meas tran vdout1_200ck1400 FIND v(dout1_200) AT=1410.05n

.meas tran vdout1_201ck1400 FIND v(dout1_201) AT=1410.05n

.meas tran vdout1_202ck1400 FIND v(dout1_202) AT=1410.05n

.meas tran vdout1_203ck1400 FIND v(dout1_203) AT=1410.05n

.meas tran vdout1_204ck1400 FIND v(dout1_204) AT=1410.05n

.meas tran vdout1_205ck1400 FIND v(dout1_205) AT=1410.05n

.meas tran vdout1_206ck1400 FIND v(dout1_206) AT=1410.05n

.meas tran vdout1_207ck1400 FIND v(dout1_207) AT=1410.05n

.meas tran vdout1_208ck1400 FIND v(dout1_208) AT=1410.05n

.meas tran vdout1_209ck1400 FIND v(dout1_209) AT=1410.05n

.meas tran vdout1_210ck1400 FIND v(dout1_210) AT=1410.05n

.meas tran vdout1_211ck1400 FIND v(dout1_211) AT=1410.05n

.meas tran vdout1_212ck1400 FIND v(dout1_212) AT=1410.05n

.meas tran vdout1_213ck1400 FIND v(dout1_213) AT=1410.05n

.meas tran vdout1_214ck1400 FIND v(dout1_214) AT=1410.05n

.meas tran vdout1_215ck1400 FIND v(dout1_215) AT=1410.05n

.meas tran vdout1_216ck1400 FIND v(dout1_216) AT=1410.05n

.meas tran vdout1_217ck1400 FIND v(dout1_217) AT=1410.05n

.meas tran vdout1_218ck1400 FIND v(dout1_218) AT=1410.05n

.meas tran vdout1_219ck1400 FIND v(dout1_219) AT=1410.05n

.meas tran vdout1_220ck1400 FIND v(dout1_220) AT=1410.05n

.meas tran vdout1_221ck1400 FIND v(dout1_221) AT=1410.05n

.meas tran vdout1_222ck1400 FIND v(dout1_222) AT=1410.05n

.meas tran vdout1_223ck1400 FIND v(dout1_223) AT=1410.05n

.meas tran vdout1_224ck1400 FIND v(dout1_224) AT=1410.05n

.meas tran vdout1_225ck1400 FIND v(dout1_225) AT=1410.05n

.meas tran vdout1_226ck1400 FIND v(dout1_226) AT=1410.05n

.meas tran vdout1_227ck1400 FIND v(dout1_227) AT=1410.05n

.meas tran vdout1_228ck1400 FIND v(dout1_228) AT=1410.05n

.meas tran vdout1_229ck1400 FIND v(dout1_229) AT=1410.05n

.meas tran vdout1_230ck1400 FIND v(dout1_230) AT=1410.05n

.meas tran vdout1_231ck1400 FIND v(dout1_231) AT=1410.05n

.meas tran vdout1_232ck1400 FIND v(dout1_232) AT=1410.05n

.meas tran vdout1_233ck1400 FIND v(dout1_233) AT=1410.05n

.meas tran vdout1_234ck1400 FIND v(dout1_234) AT=1410.05n

.meas tran vdout1_235ck1400 FIND v(dout1_235) AT=1410.05n

.meas tran vdout1_236ck1400 FIND v(dout1_236) AT=1410.05n

.meas tran vdout1_237ck1400 FIND v(dout1_237) AT=1410.05n

.meas tran vdout1_238ck1400 FIND v(dout1_238) AT=1410.05n

.meas tran vdout1_239ck1400 FIND v(dout1_239) AT=1410.05n

.meas tran vdout1_240ck1400 FIND v(dout1_240) AT=1410.05n

.meas tran vdout1_241ck1400 FIND v(dout1_241) AT=1410.05n

.meas tran vdout1_242ck1400 FIND v(dout1_242) AT=1410.05n

.meas tran vdout1_243ck1400 FIND v(dout1_243) AT=1410.05n

.meas tran vdout1_244ck1400 FIND v(dout1_244) AT=1410.05n

.meas tran vdout1_245ck1400 FIND v(dout1_245) AT=1410.05n

.meas tran vdout1_246ck1400 FIND v(dout1_246) AT=1410.05n

.meas tran vdout1_247ck1400 FIND v(dout1_247) AT=1410.05n

.meas tran vdout1_248ck1400 FIND v(dout1_248) AT=1410.05n

.meas tran vdout1_249ck1400 FIND v(dout1_249) AT=1410.05n

.meas tran vdout1_250ck1400 FIND v(dout1_250) AT=1410.05n

.meas tran vdout1_251ck1400 FIND v(dout1_251) AT=1410.05n

.meas tran vdout1_252ck1400 FIND v(dout1_252) AT=1410.05n

.meas tran vdout1_253ck1400 FIND v(dout1_253) AT=1410.05n

.meas tran vdout1_254ck1400 FIND v(dout1_254) AT=1410.05n

.meas tran vdout1_255ck1400 FIND v(dout1_255) AT=1410.05n

.meas tran vdout1_256ck1400 FIND v(dout1_256) AT=1410.05n

.meas tran vdout1_0ck1440 FIND v(dout1_0) AT=1450.05n

.meas tran vdout1_1ck1440 FIND v(dout1_1) AT=1450.05n

.meas tran vdout1_2ck1440 FIND v(dout1_2) AT=1450.05n

.meas tran vdout1_3ck1440 FIND v(dout1_3) AT=1450.05n

.meas tran vdout1_4ck1440 FIND v(dout1_4) AT=1450.05n

.meas tran vdout1_5ck1440 FIND v(dout1_5) AT=1450.05n

.meas tran vdout1_6ck1440 FIND v(dout1_6) AT=1450.05n

.meas tran vdout1_7ck1440 FIND v(dout1_7) AT=1450.05n

.meas tran vdout1_8ck1440 FIND v(dout1_8) AT=1450.05n

.meas tran vdout1_9ck1440 FIND v(dout1_9) AT=1450.05n

.meas tran vdout1_10ck1440 FIND v(dout1_10) AT=1450.05n

.meas tran vdout1_11ck1440 FIND v(dout1_11) AT=1450.05n

.meas tran vdout1_12ck1440 FIND v(dout1_12) AT=1450.05n

.meas tran vdout1_13ck1440 FIND v(dout1_13) AT=1450.05n

.meas tran vdout1_14ck1440 FIND v(dout1_14) AT=1450.05n

.meas tran vdout1_15ck1440 FIND v(dout1_15) AT=1450.05n

.meas tran vdout1_16ck1440 FIND v(dout1_16) AT=1450.05n

.meas tran vdout1_17ck1440 FIND v(dout1_17) AT=1450.05n

.meas tran vdout1_18ck1440 FIND v(dout1_18) AT=1450.05n

.meas tran vdout1_19ck1440 FIND v(dout1_19) AT=1450.05n

.meas tran vdout1_20ck1440 FIND v(dout1_20) AT=1450.05n

.meas tran vdout1_21ck1440 FIND v(dout1_21) AT=1450.05n

.meas tran vdout1_22ck1440 FIND v(dout1_22) AT=1450.05n

.meas tran vdout1_23ck1440 FIND v(dout1_23) AT=1450.05n

.meas tran vdout1_24ck1440 FIND v(dout1_24) AT=1450.05n

.meas tran vdout1_25ck1440 FIND v(dout1_25) AT=1450.05n

.meas tran vdout1_26ck1440 FIND v(dout1_26) AT=1450.05n

.meas tran vdout1_27ck1440 FIND v(dout1_27) AT=1450.05n

.meas tran vdout1_28ck1440 FIND v(dout1_28) AT=1450.05n

.meas tran vdout1_29ck1440 FIND v(dout1_29) AT=1450.05n

.meas tran vdout1_30ck1440 FIND v(dout1_30) AT=1450.05n

.meas tran vdout1_31ck1440 FIND v(dout1_31) AT=1450.05n

.meas tran vdout1_32ck1440 FIND v(dout1_32) AT=1450.05n

.meas tran vdout1_33ck1440 FIND v(dout1_33) AT=1450.05n

.meas tran vdout1_34ck1440 FIND v(dout1_34) AT=1450.05n

.meas tran vdout1_35ck1440 FIND v(dout1_35) AT=1450.05n

.meas tran vdout1_36ck1440 FIND v(dout1_36) AT=1450.05n

.meas tran vdout1_37ck1440 FIND v(dout1_37) AT=1450.05n

.meas tran vdout1_38ck1440 FIND v(dout1_38) AT=1450.05n

.meas tran vdout1_39ck1440 FIND v(dout1_39) AT=1450.05n

.meas tran vdout1_40ck1440 FIND v(dout1_40) AT=1450.05n

.meas tran vdout1_41ck1440 FIND v(dout1_41) AT=1450.05n

.meas tran vdout1_42ck1440 FIND v(dout1_42) AT=1450.05n

.meas tran vdout1_43ck1440 FIND v(dout1_43) AT=1450.05n

.meas tran vdout1_44ck1440 FIND v(dout1_44) AT=1450.05n

.meas tran vdout1_45ck1440 FIND v(dout1_45) AT=1450.05n

.meas tran vdout1_46ck1440 FIND v(dout1_46) AT=1450.05n

.meas tran vdout1_47ck1440 FIND v(dout1_47) AT=1450.05n

.meas tran vdout1_48ck1440 FIND v(dout1_48) AT=1450.05n

.meas tran vdout1_49ck1440 FIND v(dout1_49) AT=1450.05n

.meas tran vdout1_50ck1440 FIND v(dout1_50) AT=1450.05n

.meas tran vdout1_51ck1440 FIND v(dout1_51) AT=1450.05n

.meas tran vdout1_52ck1440 FIND v(dout1_52) AT=1450.05n

.meas tran vdout1_53ck1440 FIND v(dout1_53) AT=1450.05n

.meas tran vdout1_54ck1440 FIND v(dout1_54) AT=1450.05n

.meas tran vdout1_55ck1440 FIND v(dout1_55) AT=1450.05n

.meas tran vdout1_56ck1440 FIND v(dout1_56) AT=1450.05n

.meas tran vdout1_57ck1440 FIND v(dout1_57) AT=1450.05n

.meas tran vdout1_58ck1440 FIND v(dout1_58) AT=1450.05n

.meas tran vdout1_59ck1440 FIND v(dout1_59) AT=1450.05n

.meas tran vdout1_60ck1440 FIND v(dout1_60) AT=1450.05n

.meas tran vdout1_61ck1440 FIND v(dout1_61) AT=1450.05n

.meas tran vdout1_62ck1440 FIND v(dout1_62) AT=1450.05n

.meas tran vdout1_63ck1440 FIND v(dout1_63) AT=1450.05n

.meas tran vdout1_64ck1440 FIND v(dout1_64) AT=1450.05n

.meas tran vdout1_65ck1440 FIND v(dout1_65) AT=1450.05n

.meas tran vdout1_66ck1440 FIND v(dout1_66) AT=1450.05n

.meas tran vdout1_67ck1440 FIND v(dout1_67) AT=1450.05n

.meas tran vdout1_68ck1440 FIND v(dout1_68) AT=1450.05n

.meas tran vdout1_69ck1440 FIND v(dout1_69) AT=1450.05n

.meas tran vdout1_70ck1440 FIND v(dout1_70) AT=1450.05n

.meas tran vdout1_71ck1440 FIND v(dout1_71) AT=1450.05n

.meas tran vdout1_72ck1440 FIND v(dout1_72) AT=1450.05n

.meas tran vdout1_73ck1440 FIND v(dout1_73) AT=1450.05n

.meas tran vdout1_74ck1440 FIND v(dout1_74) AT=1450.05n

.meas tran vdout1_75ck1440 FIND v(dout1_75) AT=1450.05n

.meas tran vdout1_76ck1440 FIND v(dout1_76) AT=1450.05n

.meas tran vdout1_77ck1440 FIND v(dout1_77) AT=1450.05n

.meas tran vdout1_78ck1440 FIND v(dout1_78) AT=1450.05n

.meas tran vdout1_79ck1440 FIND v(dout1_79) AT=1450.05n

.meas tran vdout1_80ck1440 FIND v(dout1_80) AT=1450.05n

.meas tran vdout1_81ck1440 FIND v(dout1_81) AT=1450.05n

.meas tran vdout1_82ck1440 FIND v(dout1_82) AT=1450.05n

.meas tran vdout1_83ck1440 FIND v(dout1_83) AT=1450.05n

.meas tran vdout1_84ck1440 FIND v(dout1_84) AT=1450.05n

.meas tran vdout1_85ck1440 FIND v(dout1_85) AT=1450.05n

.meas tran vdout1_86ck1440 FIND v(dout1_86) AT=1450.05n

.meas tran vdout1_87ck1440 FIND v(dout1_87) AT=1450.05n

.meas tran vdout1_88ck1440 FIND v(dout1_88) AT=1450.05n

.meas tran vdout1_89ck1440 FIND v(dout1_89) AT=1450.05n

.meas tran vdout1_90ck1440 FIND v(dout1_90) AT=1450.05n

.meas tran vdout1_91ck1440 FIND v(dout1_91) AT=1450.05n

.meas tran vdout1_92ck1440 FIND v(dout1_92) AT=1450.05n

.meas tran vdout1_93ck1440 FIND v(dout1_93) AT=1450.05n

.meas tran vdout1_94ck1440 FIND v(dout1_94) AT=1450.05n

.meas tran vdout1_95ck1440 FIND v(dout1_95) AT=1450.05n

.meas tran vdout1_96ck1440 FIND v(dout1_96) AT=1450.05n

.meas tran vdout1_97ck1440 FIND v(dout1_97) AT=1450.05n

.meas tran vdout1_98ck1440 FIND v(dout1_98) AT=1450.05n

.meas tran vdout1_99ck1440 FIND v(dout1_99) AT=1450.05n

.meas tran vdout1_100ck1440 FIND v(dout1_100) AT=1450.05n

.meas tran vdout1_101ck1440 FIND v(dout1_101) AT=1450.05n

.meas tran vdout1_102ck1440 FIND v(dout1_102) AT=1450.05n

.meas tran vdout1_103ck1440 FIND v(dout1_103) AT=1450.05n

.meas tran vdout1_104ck1440 FIND v(dout1_104) AT=1450.05n

.meas tran vdout1_105ck1440 FIND v(dout1_105) AT=1450.05n

.meas tran vdout1_106ck1440 FIND v(dout1_106) AT=1450.05n

.meas tran vdout1_107ck1440 FIND v(dout1_107) AT=1450.05n

.meas tran vdout1_108ck1440 FIND v(dout1_108) AT=1450.05n

.meas tran vdout1_109ck1440 FIND v(dout1_109) AT=1450.05n

.meas tran vdout1_110ck1440 FIND v(dout1_110) AT=1450.05n

.meas tran vdout1_111ck1440 FIND v(dout1_111) AT=1450.05n

.meas tran vdout1_112ck1440 FIND v(dout1_112) AT=1450.05n

.meas tran vdout1_113ck1440 FIND v(dout1_113) AT=1450.05n

.meas tran vdout1_114ck1440 FIND v(dout1_114) AT=1450.05n

.meas tran vdout1_115ck1440 FIND v(dout1_115) AT=1450.05n

.meas tran vdout1_116ck1440 FIND v(dout1_116) AT=1450.05n

.meas tran vdout1_117ck1440 FIND v(dout1_117) AT=1450.05n

.meas tran vdout1_118ck1440 FIND v(dout1_118) AT=1450.05n

.meas tran vdout1_119ck1440 FIND v(dout1_119) AT=1450.05n

.meas tran vdout1_120ck1440 FIND v(dout1_120) AT=1450.05n

.meas tran vdout1_121ck1440 FIND v(dout1_121) AT=1450.05n

.meas tran vdout1_122ck1440 FIND v(dout1_122) AT=1450.05n

.meas tran vdout1_123ck1440 FIND v(dout1_123) AT=1450.05n

.meas tran vdout1_124ck1440 FIND v(dout1_124) AT=1450.05n

.meas tran vdout1_125ck1440 FIND v(dout1_125) AT=1450.05n

.meas tran vdout1_126ck1440 FIND v(dout1_126) AT=1450.05n

.meas tran vdout1_127ck1440 FIND v(dout1_127) AT=1450.05n

.meas tran vdout1_128ck1440 FIND v(dout1_128) AT=1450.05n

.meas tran vdout1_129ck1440 FIND v(dout1_129) AT=1450.05n

.meas tran vdout1_130ck1440 FIND v(dout1_130) AT=1450.05n

.meas tran vdout1_131ck1440 FIND v(dout1_131) AT=1450.05n

.meas tran vdout1_132ck1440 FIND v(dout1_132) AT=1450.05n

.meas tran vdout1_133ck1440 FIND v(dout1_133) AT=1450.05n

.meas tran vdout1_134ck1440 FIND v(dout1_134) AT=1450.05n

.meas tran vdout1_135ck1440 FIND v(dout1_135) AT=1450.05n

.meas tran vdout1_136ck1440 FIND v(dout1_136) AT=1450.05n

.meas tran vdout1_137ck1440 FIND v(dout1_137) AT=1450.05n

.meas tran vdout1_138ck1440 FIND v(dout1_138) AT=1450.05n

.meas tran vdout1_139ck1440 FIND v(dout1_139) AT=1450.05n

.meas tran vdout1_140ck1440 FIND v(dout1_140) AT=1450.05n

.meas tran vdout1_141ck1440 FIND v(dout1_141) AT=1450.05n

.meas tran vdout1_142ck1440 FIND v(dout1_142) AT=1450.05n

.meas tran vdout1_143ck1440 FIND v(dout1_143) AT=1450.05n

.meas tran vdout1_144ck1440 FIND v(dout1_144) AT=1450.05n

.meas tran vdout1_145ck1440 FIND v(dout1_145) AT=1450.05n

.meas tran vdout1_146ck1440 FIND v(dout1_146) AT=1450.05n

.meas tran vdout1_147ck1440 FIND v(dout1_147) AT=1450.05n

.meas tran vdout1_148ck1440 FIND v(dout1_148) AT=1450.05n

.meas tran vdout1_149ck1440 FIND v(dout1_149) AT=1450.05n

.meas tran vdout1_150ck1440 FIND v(dout1_150) AT=1450.05n

.meas tran vdout1_151ck1440 FIND v(dout1_151) AT=1450.05n

.meas tran vdout1_152ck1440 FIND v(dout1_152) AT=1450.05n

.meas tran vdout1_153ck1440 FIND v(dout1_153) AT=1450.05n

.meas tran vdout1_154ck1440 FIND v(dout1_154) AT=1450.05n

.meas tran vdout1_155ck1440 FIND v(dout1_155) AT=1450.05n

.meas tran vdout1_156ck1440 FIND v(dout1_156) AT=1450.05n

.meas tran vdout1_157ck1440 FIND v(dout1_157) AT=1450.05n

.meas tran vdout1_158ck1440 FIND v(dout1_158) AT=1450.05n

.meas tran vdout1_159ck1440 FIND v(dout1_159) AT=1450.05n

.meas tran vdout1_160ck1440 FIND v(dout1_160) AT=1450.05n

.meas tran vdout1_161ck1440 FIND v(dout1_161) AT=1450.05n

.meas tran vdout1_162ck1440 FIND v(dout1_162) AT=1450.05n

.meas tran vdout1_163ck1440 FIND v(dout1_163) AT=1450.05n

.meas tran vdout1_164ck1440 FIND v(dout1_164) AT=1450.05n

.meas tran vdout1_165ck1440 FIND v(dout1_165) AT=1450.05n

.meas tran vdout1_166ck1440 FIND v(dout1_166) AT=1450.05n

.meas tran vdout1_167ck1440 FIND v(dout1_167) AT=1450.05n

.meas tran vdout1_168ck1440 FIND v(dout1_168) AT=1450.05n

.meas tran vdout1_169ck1440 FIND v(dout1_169) AT=1450.05n

.meas tran vdout1_170ck1440 FIND v(dout1_170) AT=1450.05n

.meas tran vdout1_171ck1440 FIND v(dout1_171) AT=1450.05n

.meas tran vdout1_172ck1440 FIND v(dout1_172) AT=1450.05n

.meas tran vdout1_173ck1440 FIND v(dout1_173) AT=1450.05n

.meas tran vdout1_174ck1440 FIND v(dout1_174) AT=1450.05n

.meas tran vdout1_175ck1440 FIND v(dout1_175) AT=1450.05n

.meas tran vdout1_176ck1440 FIND v(dout1_176) AT=1450.05n

.meas tran vdout1_177ck1440 FIND v(dout1_177) AT=1450.05n

.meas tran vdout1_178ck1440 FIND v(dout1_178) AT=1450.05n

.meas tran vdout1_179ck1440 FIND v(dout1_179) AT=1450.05n

.meas tran vdout1_180ck1440 FIND v(dout1_180) AT=1450.05n

.meas tran vdout1_181ck1440 FIND v(dout1_181) AT=1450.05n

.meas tran vdout1_182ck1440 FIND v(dout1_182) AT=1450.05n

.meas tran vdout1_183ck1440 FIND v(dout1_183) AT=1450.05n

.meas tran vdout1_184ck1440 FIND v(dout1_184) AT=1450.05n

.meas tran vdout1_185ck1440 FIND v(dout1_185) AT=1450.05n

.meas tran vdout1_186ck1440 FIND v(dout1_186) AT=1450.05n

.meas tran vdout1_187ck1440 FIND v(dout1_187) AT=1450.05n

.meas tran vdout1_188ck1440 FIND v(dout1_188) AT=1450.05n

.meas tran vdout1_189ck1440 FIND v(dout1_189) AT=1450.05n

.meas tran vdout1_190ck1440 FIND v(dout1_190) AT=1450.05n

.meas tran vdout1_191ck1440 FIND v(dout1_191) AT=1450.05n

.meas tran vdout1_192ck1440 FIND v(dout1_192) AT=1450.05n

.meas tran vdout1_193ck1440 FIND v(dout1_193) AT=1450.05n

.meas tran vdout1_194ck1440 FIND v(dout1_194) AT=1450.05n

.meas tran vdout1_195ck1440 FIND v(dout1_195) AT=1450.05n

.meas tran vdout1_196ck1440 FIND v(dout1_196) AT=1450.05n

.meas tran vdout1_197ck1440 FIND v(dout1_197) AT=1450.05n

.meas tran vdout1_198ck1440 FIND v(dout1_198) AT=1450.05n

.meas tran vdout1_199ck1440 FIND v(dout1_199) AT=1450.05n

.meas tran vdout1_200ck1440 FIND v(dout1_200) AT=1450.05n

.meas tran vdout1_201ck1440 FIND v(dout1_201) AT=1450.05n

.meas tran vdout1_202ck1440 FIND v(dout1_202) AT=1450.05n

.meas tran vdout1_203ck1440 FIND v(dout1_203) AT=1450.05n

.meas tran vdout1_204ck1440 FIND v(dout1_204) AT=1450.05n

.meas tran vdout1_205ck1440 FIND v(dout1_205) AT=1450.05n

.meas tran vdout1_206ck1440 FIND v(dout1_206) AT=1450.05n

.meas tran vdout1_207ck1440 FIND v(dout1_207) AT=1450.05n

.meas tran vdout1_208ck1440 FIND v(dout1_208) AT=1450.05n

.meas tran vdout1_209ck1440 FIND v(dout1_209) AT=1450.05n

.meas tran vdout1_210ck1440 FIND v(dout1_210) AT=1450.05n

.meas tran vdout1_211ck1440 FIND v(dout1_211) AT=1450.05n

.meas tran vdout1_212ck1440 FIND v(dout1_212) AT=1450.05n

.meas tran vdout1_213ck1440 FIND v(dout1_213) AT=1450.05n

.meas tran vdout1_214ck1440 FIND v(dout1_214) AT=1450.05n

.meas tran vdout1_215ck1440 FIND v(dout1_215) AT=1450.05n

.meas tran vdout1_216ck1440 FIND v(dout1_216) AT=1450.05n

.meas tran vdout1_217ck1440 FIND v(dout1_217) AT=1450.05n

.meas tran vdout1_218ck1440 FIND v(dout1_218) AT=1450.05n

.meas tran vdout1_219ck1440 FIND v(dout1_219) AT=1450.05n

.meas tran vdout1_220ck1440 FIND v(dout1_220) AT=1450.05n

.meas tran vdout1_221ck1440 FIND v(dout1_221) AT=1450.05n

.meas tran vdout1_222ck1440 FIND v(dout1_222) AT=1450.05n

.meas tran vdout1_223ck1440 FIND v(dout1_223) AT=1450.05n

.meas tran vdout1_224ck1440 FIND v(dout1_224) AT=1450.05n

.meas tran vdout1_225ck1440 FIND v(dout1_225) AT=1450.05n

.meas tran vdout1_226ck1440 FIND v(dout1_226) AT=1450.05n

.meas tran vdout1_227ck1440 FIND v(dout1_227) AT=1450.05n

.meas tran vdout1_228ck1440 FIND v(dout1_228) AT=1450.05n

.meas tran vdout1_229ck1440 FIND v(dout1_229) AT=1450.05n

.meas tran vdout1_230ck1440 FIND v(dout1_230) AT=1450.05n

.meas tran vdout1_231ck1440 FIND v(dout1_231) AT=1450.05n

.meas tran vdout1_232ck1440 FIND v(dout1_232) AT=1450.05n

.meas tran vdout1_233ck1440 FIND v(dout1_233) AT=1450.05n

.meas tran vdout1_234ck1440 FIND v(dout1_234) AT=1450.05n

.meas tran vdout1_235ck1440 FIND v(dout1_235) AT=1450.05n

.meas tran vdout1_236ck1440 FIND v(dout1_236) AT=1450.05n

.meas tran vdout1_237ck1440 FIND v(dout1_237) AT=1450.05n

.meas tran vdout1_238ck1440 FIND v(dout1_238) AT=1450.05n

.meas tran vdout1_239ck1440 FIND v(dout1_239) AT=1450.05n

.meas tran vdout1_240ck1440 FIND v(dout1_240) AT=1450.05n

.meas tran vdout1_241ck1440 FIND v(dout1_241) AT=1450.05n

.meas tran vdout1_242ck1440 FIND v(dout1_242) AT=1450.05n

.meas tran vdout1_243ck1440 FIND v(dout1_243) AT=1450.05n

.meas tran vdout1_244ck1440 FIND v(dout1_244) AT=1450.05n

.meas tran vdout1_245ck1440 FIND v(dout1_245) AT=1450.05n

.meas tran vdout1_246ck1440 FIND v(dout1_246) AT=1450.05n

.meas tran vdout1_247ck1440 FIND v(dout1_247) AT=1450.05n

.meas tran vdout1_248ck1440 FIND v(dout1_248) AT=1450.05n

.meas tran vdout1_249ck1440 FIND v(dout1_249) AT=1450.05n

.meas tran vdout1_250ck1440 FIND v(dout1_250) AT=1450.05n

.meas tran vdout1_251ck1440 FIND v(dout1_251) AT=1450.05n

.meas tran vdout1_252ck1440 FIND v(dout1_252) AT=1450.05n

.meas tran vdout1_253ck1440 FIND v(dout1_253) AT=1450.05n

.meas tran vdout1_254ck1440 FIND v(dout1_254) AT=1450.05n

.meas tran vdout1_255ck1440 FIND v(dout1_255) AT=1450.05n

.meas tran vdout1_256ck1440 FIND v(dout1_256) AT=1450.05n

.meas tran vdout1_0ck1450 FIND v(dout1_0) AT=1460.05n

.meas tran vdout1_1ck1450 FIND v(dout1_1) AT=1460.05n

.meas tran vdout1_2ck1450 FIND v(dout1_2) AT=1460.05n

.meas tran vdout1_3ck1450 FIND v(dout1_3) AT=1460.05n

.meas tran vdout1_4ck1450 FIND v(dout1_4) AT=1460.05n

.meas tran vdout1_5ck1450 FIND v(dout1_5) AT=1460.05n

.meas tran vdout1_6ck1450 FIND v(dout1_6) AT=1460.05n

.meas tran vdout1_7ck1450 FIND v(dout1_7) AT=1460.05n

.meas tran vdout1_8ck1450 FIND v(dout1_8) AT=1460.05n

.meas tran vdout1_9ck1450 FIND v(dout1_9) AT=1460.05n

.meas tran vdout1_10ck1450 FIND v(dout1_10) AT=1460.05n

.meas tran vdout1_11ck1450 FIND v(dout1_11) AT=1460.05n

.meas tran vdout1_12ck1450 FIND v(dout1_12) AT=1460.05n

.meas tran vdout1_13ck1450 FIND v(dout1_13) AT=1460.05n

.meas tran vdout1_14ck1450 FIND v(dout1_14) AT=1460.05n

.meas tran vdout1_15ck1450 FIND v(dout1_15) AT=1460.05n

.meas tran vdout1_16ck1450 FIND v(dout1_16) AT=1460.05n

.meas tran vdout1_17ck1450 FIND v(dout1_17) AT=1460.05n

.meas tran vdout1_18ck1450 FIND v(dout1_18) AT=1460.05n

.meas tran vdout1_19ck1450 FIND v(dout1_19) AT=1460.05n

.meas tran vdout1_20ck1450 FIND v(dout1_20) AT=1460.05n

.meas tran vdout1_21ck1450 FIND v(dout1_21) AT=1460.05n

.meas tran vdout1_22ck1450 FIND v(dout1_22) AT=1460.05n

.meas tran vdout1_23ck1450 FIND v(dout1_23) AT=1460.05n

.meas tran vdout1_24ck1450 FIND v(dout1_24) AT=1460.05n

.meas tran vdout1_25ck1450 FIND v(dout1_25) AT=1460.05n

.meas tran vdout1_26ck1450 FIND v(dout1_26) AT=1460.05n

.meas tran vdout1_27ck1450 FIND v(dout1_27) AT=1460.05n

.meas tran vdout1_28ck1450 FIND v(dout1_28) AT=1460.05n

.meas tran vdout1_29ck1450 FIND v(dout1_29) AT=1460.05n

.meas tran vdout1_30ck1450 FIND v(dout1_30) AT=1460.05n

.meas tran vdout1_31ck1450 FIND v(dout1_31) AT=1460.05n

.meas tran vdout1_32ck1450 FIND v(dout1_32) AT=1460.05n

.meas tran vdout1_33ck1450 FIND v(dout1_33) AT=1460.05n

.meas tran vdout1_34ck1450 FIND v(dout1_34) AT=1460.05n

.meas tran vdout1_35ck1450 FIND v(dout1_35) AT=1460.05n

.meas tran vdout1_36ck1450 FIND v(dout1_36) AT=1460.05n

.meas tran vdout1_37ck1450 FIND v(dout1_37) AT=1460.05n

.meas tran vdout1_38ck1450 FIND v(dout1_38) AT=1460.05n

.meas tran vdout1_39ck1450 FIND v(dout1_39) AT=1460.05n

.meas tran vdout1_40ck1450 FIND v(dout1_40) AT=1460.05n

.meas tran vdout1_41ck1450 FIND v(dout1_41) AT=1460.05n

.meas tran vdout1_42ck1450 FIND v(dout1_42) AT=1460.05n

.meas tran vdout1_43ck1450 FIND v(dout1_43) AT=1460.05n

.meas tran vdout1_44ck1450 FIND v(dout1_44) AT=1460.05n

.meas tran vdout1_45ck1450 FIND v(dout1_45) AT=1460.05n

.meas tran vdout1_46ck1450 FIND v(dout1_46) AT=1460.05n

.meas tran vdout1_47ck1450 FIND v(dout1_47) AT=1460.05n

.meas tran vdout1_48ck1450 FIND v(dout1_48) AT=1460.05n

.meas tran vdout1_49ck1450 FIND v(dout1_49) AT=1460.05n

.meas tran vdout1_50ck1450 FIND v(dout1_50) AT=1460.05n

.meas tran vdout1_51ck1450 FIND v(dout1_51) AT=1460.05n

.meas tran vdout1_52ck1450 FIND v(dout1_52) AT=1460.05n

.meas tran vdout1_53ck1450 FIND v(dout1_53) AT=1460.05n

.meas tran vdout1_54ck1450 FIND v(dout1_54) AT=1460.05n

.meas tran vdout1_55ck1450 FIND v(dout1_55) AT=1460.05n

.meas tran vdout1_56ck1450 FIND v(dout1_56) AT=1460.05n

.meas tran vdout1_57ck1450 FIND v(dout1_57) AT=1460.05n

.meas tran vdout1_58ck1450 FIND v(dout1_58) AT=1460.05n

.meas tran vdout1_59ck1450 FIND v(dout1_59) AT=1460.05n

.meas tran vdout1_60ck1450 FIND v(dout1_60) AT=1460.05n

.meas tran vdout1_61ck1450 FIND v(dout1_61) AT=1460.05n

.meas tran vdout1_62ck1450 FIND v(dout1_62) AT=1460.05n

.meas tran vdout1_63ck1450 FIND v(dout1_63) AT=1460.05n

.meas tran vdout1_64ck1450 FIND v(dout1_64) AT=1460.05n

.meas tran vdout1_65ck1450 FIND v(dout1_65) AT=1460.05n

.meas tran vdout1_66ck1450 FIND v(dout1_66) AT=1460.05n

.meas tran vdout1_67ck1450 FIND v(dout1_67) AT=1460.05n

.meas tran vdout1_68ck1450 FIND v(dout1_68) AT=1460.05n

.meas tran vdout1_69ck1450 FIND v(dout1_69) AT=1460.05n

.meas tran vdout1_70ck1450 FIND v(dout1_70) AT=1460.05n

.meas tran vdout1_71ck1450 FIND v(dout1_71) AT=1460.05n

.meas tran vdout1_72ck1450 FIND v(dout1_72) AT=1460.05n

.meas tran vdout1_73ck1450 FIND v(dout1_73) AT=1460.05n

.meas tran vdout1_74ck1450 FIND v(dout1_74) AT=1460.05n

.meas tran vdout1_75ck1450 FIND v(dout1_75) AT=1460.05n

.meas tran vdout1_76ck1450 FIND v(dout1_76) AT=1460.05n

.meas tran vdout1_77ck1450 FIND v(dout1_77) AT=1460.05n

.meas tran vdout1_78ck1450 FIND v(dout1_78) AT=1460.05n

.meas tran vdout1_79ck1450 FIND v(dout1_79) AT=1460.05n

.meas tran vdout1_80ck1450 FIND v(dout1_80) AT=1460.05n

.meas tran vdout1_81ck1450 FIND v(dout1_81) AT=1460.05n

.meas tran vdout1_82ck1450 FIND v(dout1_82) AT=1460.05n

.meas tran vdout1_83ck1450 FIND v(dout1_83) AT=1460.05n

.meas tran vdout1_84ck1450 FIND v(dout1_84) AT=1460.05n

.meas tran vdout1_85ck1450 FIND v(dout1_85) AT=1460.05n

.meas tran vdout1_86ck1450 FIND v(dout1_86) AT=1460.05n

.meas tran vdout1_87ck1450 FIND v(dout1_87) AT=1460.05n

.meas tran vdout1_88ck1450 FIND v(dout1_88) AT=1460.05n

.meas tran vdout1_89ck1450 FIND v(dout1_89) AT=1460.05n

.meas tran vdout1_90ck1450 FIND v(dout1_90) AT=1460.05n

.meas tran vdout1_91ck1450 FIND v(dout1_91) AT=1460.05n

.meas tran vdout1_92ck1450 FIND v(dout1_92) AT=1460.05n

.meas tran vdout1_93ck1450 FIND v(dout1_93) AT=1460.05n

.meas tran vdout1_94ck1450 FIND v(dout1_94) AT=1460.05n

.meas tran vdout1_95ck1450 FIND v(dout1_95) AT=1460.05n

.meas tran vdout1_96ck1450 FIND v(dout1_96) AT=1460.05n

.meas tran vdout1_97ck1450 FIND v(dout1_97) AT=1460.05n

.meas tran vdout1_98ck1450 FIND v(dout1_98) AT=1460.05n

.meas tran vdout1_99ck1450 FIND v(dout1_99) AT=1460.05n

.meas tran vdout1_100ck1450 FIND v(dout1_100) AT=1460.05n

.meas tran vdout1_101ck1450 FIND v(dout1_101) AT=1460.05n

.meas tran vdout1_102ck1450 FIND v(dout1_102) AT=1460.05n

.meas tran vdout1_103ck1450 FIND v(dout1_103) AT=1460.05n

.meas tran vdout1_104ck1450 FIND v(dout1_104) AT=1460.05n

.meas tran vdout1_105ck1450 FIND v(dout1_105) AT=1460.05n

.meas tran vdout1_106ck1450 FIND v(dout1_106) AT=1460.05n

.meas tran vdout1_107ck1450 FIND v(dout1_107) AT=1460.05n

.meas tran vdout1_108ck1450 FIND v(dout1_108) AT=1460.05n

.meas tran vdout1_109ck1450 FIND v(dout1_109) AT=1460.05n

.meas tran vdout1_110ck1450 FIND v(dout1_110) AT=1460.05n

.meas tran vdout1_111ck1450 FIND v(dout1_111) AT=1460.05n

.meas tran vdout1_112ck1450 FIND v(dout1_112) AT=1460.05n

.meas tran vdout1_113ck1450 FIND v(dout1_113) AT=1460.05n

.meas tran vdout1_114ck1450 FIND v(dout1_114) AT=1460.05n

.meas tran vdout1_115ck1450 FIND v(dout1_115) AT=1460.05n

.meas tran vdout1_116ck1450 FIND v(dout1_116) AT=1460.05n

.meas tran vdout1_117ck1450 FIND v(dout1_117) AT=1460.05n

.meas tran vdout1_118ck1450 FIND v(dout1_118) AT=1460.05n

.meas tran vdout1_119ck1450 FIND v(dout1_119) AT=1460.05n

.meas tran vdout1_120ck1450 FIND v(dout1_120) AT=1460.05n

.meas tran vdout1_121ck1450 FIND v(dout1_121) AT=1460.05n

.meas tran vdout1_122ck1450 FIND v(dout1_122) AT=1460.05n

.meas tran vdout1_123ck1450 FIND v(dout1_123) AT=1460.05n

.meas tran vdout1_124ck1450 FIND v(dout1_124) AT=1460.05n

.meas tran vdout1_125ck1450 FIND v(dout1_125) AT=1460.05n

.meas tran vdout1_126ck1450 FIND v(dout1_126) AT=1460.05n

.meas tran vdout1_127ck1450 FIND v(dout1_127) AT=1460.05n

.meas tran vdout1_128ck1450 FIND v(dout1_128) AT=1460.05n

.meas tran vdout1_129ck1450 FIND v(dout1_129) AT=1460.05n

.meas tran vdout1_130ck1450 FIND v(dout1_130) AT=1460.05n

.meas tran vdout1_131ck1450 FIND v(dout1_131) AT=1460.05n

.meas tran vdout1_132ck1450 FIND v(dout1_132) AT=1460.05n

.meas tran vdout1_133ck1450 FIND v(dout1_133) AT=1460.05n

.meas tran vdout1_134ck1450 FIND v(dout1_134) AT=1460.05n

.meas tran vdout1_135ck1450 FIND v(dout1_135) AT=1460.05n

.meas tran vdout1_136ck1450 FIND v(dout1_136) AT=1460.05n

.meas tran vdout1_137ck1450 FIND v(dout1_137) AT=1460.05n

.meas tran vdout1_138ck1450 FIND v(dout1_138) AT=1460.05n

.meas tran vdout1_139ck1450 FIND v(dout1_139) AT=1460.05n

.meas tran vdout1_140ck1450 FIND v(dout1_140) AT=1460.05n

.meas tran vdout1_141ck1450 FIND v(dout1_141) AT=1460.05n

.meas tran vdout1_142ck1450 FIND v(dout1_142) AT=1460.05n

.meas tran vdout1_143ck1450 FIND v(dout1_143) AT=1460.05n

.meas tran vdout1_144ck1450 FIND v(dout1_144) AT=1460.05n

.meas tran vdout1_145ck1450 FIND v(dout1_145) AT=1460.05n

.meas tran vdout1_146ck1450 FIND v(dout1_146) AT=1460.05n

.meas tran vdout1_147ck1450 FIND v(dout1_147) AT=1460.05n

.meas tran vdout1_148ck1450 FIND v(dout1_148) AT=1460.05n

.meas tran vdout1_149ck1450 FIND v(dout1_149) AT=1460.05n

.meas tran vdout1_150ck1450 FIND v(dout1_150) AT=1460.05n

.meas tran vdout1_151ck1450 FIND v(dout1_151) AT=1460.05n

.meas tran vdout1_152ck1450 FIND v(dout1_152) AT=1460.05n

.meas tran vdout1_153ck1450 FIND v(dout1_153) AT=1460.05n

.meas tran vdout1_154ck1450 FIND v(dout1_154) AT=1460.05n

.meas tran vdout1_155ck1450 FIND v(dout1_155) AT=1460.05n

.meas tran vdout1_156ck1450 FIND v(dout1_156) AT=1460.05n

.meas tran vdout1_157ck1450 FIND v(dout1_157) AT=1460.05n

.meas tran vdout1_158ck1450 FIND v(dout1_158) AT=1460.05n

.meas tran vdout1_159ck1450 FIND v(dout1_159) AT=1460.05n

.meas tran vdout1_160ck1450 FIND v(dout1_160) AT=1460.05n

.meas tran vdout1_161ck1450 FIND v(dout1_161) AT=1460.05n

.meas tran vdout1_162ck1450 FIND v(dout1_162) AT=1460.05n

.meas tran vdout1_163ck1450 FIND v(dout1_163) AT=1460.05n

.meas tran vdout1_164ck1450 FIND v(dout1_164) AT=1460.05n

.meas tran vdout1_165ck1450 FIND v(dout1_165) AT=1460.05n

.meas tran vdout1_166ck1450 FIND v(dout1_166) AT=1460.05n

.meas tran vdout1_167ck1450 FIND v(dout1_167) AT=1460.05n

.meas tran vdout1_168ck1450 FIND v(dout1_168) AT=1460.05n

.meas tran vdout1_169ck1450 FIND v(dout1_169) AT=1460.05n

.meas tran vdout1_170ck1450 FIND v(dout1_170) AT=1460.05n

.meas tran vdout1_171ck1450 FIND v(dout1_171) AT=1460.05n

.meas tran vdout1_172ck1450 FIND v(dout1_172) AT=1460.05n

.meas tran vdout1_173ck1450 FIND v(dout1_173) AT=1460.05n

.meas tran vdout1_174ck1450 FIND v(dout1_174) AT=1460.05n

.meas tran vdout1_175ck1450 FIND v(dout1_175) AT=1460.05n

.meas tran vdout1_176ck1450 FIND v(dout1_176) AT=1460.05n

.meas tran vdout1_177ck1450 FIND v(dout1_177) AT=1460.05n

.meas tran vdout1_178ck1450 FIND v(dout1_178) AT=1460.05n

.meas tran vdout1_179ck1450 FIND v(dout1_179) AT=1460.05n

.meas tran vdout1_180ck1450 FIND v(dout1_180) AT=1460.05n

.meas tran vdout1_181ck1450 FIND v(dout1_181) AT=1460.05n

.meas tran vdout1_182ck1450 FIND v(dout1_182) AT=1460.05n

.meas tran vdout1_183ck1450 FIND v(dout1_183) AT=1460.05n

.meas tran vdout1_184ck1450 FIND v(dout1_184) AT=1460.05n

.meas tran vdout1_185ck1450 FIND v(dout1_185) AT=1460.05n

.meas tran vdout1_186ck1450 FIND v(dout1_186) AT=1460.05n

.meas tran vdout1_187ck1450 FIND v(dout1_187) AT=1460.05n

.meas tran vdout1_188ck1450 FIND v(dout1_188) AT=1460.05n

.meas tran vdout1_189ck1450 FIND v(dout1_189) AT=1460.05n

.meas tran vdout1_190ck1450 FIND v(dout1_190) AT=1460.05n

.meas tran vdout1_191ck1450 FIND v(dout1_191) AT=1460.05n

.meas tran vdout1_192ck1450 FIND v(dout1_192) AT=1460.05n

.meas tran vdout1_193ck1450 FIND v(dout1_193) AT=1460.05n

.meas tran vdout1_194ck1450 FIND v(dout1_194) AT=1460.05n

.meas tran vdout1_195ck1450 FIND v(dout1_195) AT=1460.05n

.meas tran vdout1_196ck1450 FIND v(dout1_196) AT=1460.05n

.meas tran vdout1_197ck1450 FIND v(dout1_197) AT=1460.05n

.meas tran vdout1_198ck1450 FIND v(dout1_198) AT=1460.05n

.meas tran vdout1_199ck1450 FIND v(dout1_199) AT=1460.05n

.meas tran vdout1_200ck1450 FIND v(dout1_200) AT=1460.05n

.meas tran vdout1_201ck1450 FIND v(dout1_201) AT=1460.05n

.meas tran vdout1_202ck1450 FIND v(dout1_202) AT=1460.05n

.meas tran vdout1_203ck1450 FIND v(dout1_203) AT=1460.05n

.meas tran vdout1_204ck1450 FIND v(dout1_204) AT=1460.05n

.meas tran vdout1_205ck1450 FIND v(dout1_205) AT=1460.05n

.meas tran vdout1_206ck1450 FIND v(dout1_206) AT=1460.05n

.meas tran vdout1_207ck1450 FIND v(dout1_207) AT=1460.05n

.meas tran vdout1_208ck1450 FIND v(dout1_208) AT=1460.05n

.meas tran vdout1_209ck1450 FIND v(dout1_209) AT=1460.05n

.meas tran vdout1_210ck1450 FIND v(dout1_210) AT=1460.05n

.meas tran vdout1_211ck1450 FIND v(dout1_211) AT=1460.05n

.meas tran vdout1_212ck1450 FIND v(dout1_212) AT=1460.05n

.meas tran vdout1_213ck1450 FIND v(dout1_213) AT=1460.05n

.meas tran vdout1_214ck1450 FIND v(dout1_214) AT=1460.05n

.meas tran vdout1_215ck1450 FIND v(dout1_215) AT=1460.05n

.meas tran vdout1_216ck1450 FIND v(dout1_216) AT=1460.05n

.meas tran vdout1_217ck1450 FIND v(dout1_217) AT=1460.05n

.meas tran vdout1_218ck1450 FIND v(dout1_218) AT=1460.05n

.meas tran vdout1_219ck1450 FIND v(dout1_219) AT=1460.05n

.meas tran vdout1_220ck1450 FIND v(dout1_220) AT=1460.05n

.meas tran vdout1_221ck1450 FIND v(dout1_221) AT=1460.05n

.meas tran vdout1_222ck1450 FIND v(dout1_222) AT=1460.05n

.meas tran vdout1_223ck1450 FIND v(dout1_223) AT=1460.05n

.meas tran vdout1_224ck1450 FIND v(dout1_224) AT=1460.05n

.meas tran vdout1_225ck1450 FIND v(dout1_225) AT=1460.05n

.meas tran vdout1_226ck1450 FIND v(dout1_226) AT=1460.05n

.meas tran vdout1_227ck1450 FIND v(dout1_227) AT=1460.05n

.meas tran vdout1_228ck1450 FIND v(dout1_228) AT=1460.05n

.meas tran vdout1_229ck1450 FIND v(dout1_229) AT=1460.05n

.meas tran vdout1_230ck1450 FIND v(dout1_230) AT=1460.05n

.meas tran vdout1_231ck1450 FIND v(dout1_231) AT=1460.05n

.meas tran vdout1_232ck1450 FIND v(dout1_232) AT=1460.05n

.meas tran vdout1_233ck1450 FIND v(dout1_233) AT=1460.05n

.meas tran vdout1_234ck1450 FIND v(dout1_234) AT=1460.05n

.meas tran vdout1_235ck1450 FIND v(dout1_235) AT=1460.05n

.meas tran vdout1_236ck1450 FIND v(dout1_236) AT=1460.05n

.meas tran vdout1_237ck1450 FIND v(dout1_237) AT=1460.05n

.meas tran vdout1_238ck1450 FIND v(dout1_238) AT=1460.05n

.meas tran vdout1_239ck1450 FIND v(dout1_239) AT=1460.05n

.meas tran vdout1_240ck1450 FIND v(dout1_240) AT=1460.05n

.meas tran vdout1_241ck1450 FIND v(dout1_241) AT=1460.05n

.meas tran vdout1_242ck1450 FIND v(dout1_242) AT=1460.05n

.meas tran vdout1_243ck1450 FIND v(dout1_243) AT=1460.05n

.meas tran vdout1_244ck1450 FIND v(dout1_244) AT=1460.05n

.meas tran vdout1_245ck1450 FIND v(dout1_245) AT=1460.05n

.meas tran vdout1_246ck1450 FIND v(dout1_246) AT=1460.05n

.meas tran vdout1_247ck1450 FIND v(dout1_247) AT=1460.05n

.meas tran vdout1_248ck1450 FIND v(dout1_248) AT=1460.05n

.meas tran vdout1_249ck1450 FIND v(dout1_249) AT=1460.05n

.meas tran vdout1_250ck1450 FIND v(dout1_250) AT=1460.05n

.meas tran vdout1_251ck1450 FIND v(dout1_251) AT=1460.05n

.meas tran vdout1_252ck1450 FIND v(dout1_252) AT=1460.05n

.meas tran vdout1_253ck1450 FIND v(dout1_253) AT=1460.05n

.meas tran vdout1_254ck1450 FIND v(dout1_254) AT=1460.05n

.meas tran vdout1_255ck1450 FIND v(dout1_255) AT=1460.05n

.meas tran vdout1_256ck1450 FIND v(dout1_256) AT=1460.05n

.meas tran vdout1_0ck1500 FIND v(dout1_0) AT=1510.05n

.meas tran vdout1_1ck1500 FIND v(dout1_1) AT=1510.05n

.meas tran vdout1_2ck1500 FIND v(dout1_2) AT=1510.05n

.meas tran vdout1_3ck1500 FIND v(dout1_3) AT=1510.05n

.meas tran vdout1_4ck1500 FIND v(dout1_4) AT=1510.05n

.meas tran vdout1_5ck1500 FIND v(dout1_5) AT=1510.05n

.meas tran vdout1_6ck1500 FIND v(dout1_6) AT=1510.05n

.meas tran vdout1_7ck1500 FIND v(dout1_7) AT=1510.05n

.meas tran vdout1_8ck1500 FIND v(dout1_8) AT=1510.05n

.meas tran vdout1_9ck1500 FIND v(dout1_9) AT=1510.05n

.meas tran vdout1_10ck1500 FIND v(dout1_10) AT=1510.05n

.meas tran vdout1_11ck1500 FIND v(dout1_11) AT=1510.05n

.meas tran vdout1_12ck1500 FIND v(dout1_12) AT=1510.05n

.meas tran vdout1_13ck1500 FIND v(dout1_13) AT=1510.05n

.meas tran vdout1_14ck1500 FIND v(dout1_14) AT=1510.05n

.meas tran vdout1_15ck1500 FIND v(dout1_15) AT=1510.05n

.meas tran vdout1_16ck1500 FIND v(dout1_16) AT=1510.05n

.meas tran vdout1_17ck1500 FIND v(dout1_17) AT=1510.05n

.meas tran vdout1_18ck1500 FIND v(dout1_18) AT=1510.05n

.meas tran vdout1_19ck1500 FIND v(dout1_19) AT=1510.05n

.meas tran vdout1_20ck1500 FIND v(dout1_20) AT=1510.05n

.meas tran vdout1_21ck1500 FIND v(dout1_21) AT=1510.05n

.meas tran vdout1_22ck1500 FIND v(dout1_22) AT=1510.05n

.meas tran vdout1_23ck1500 FIND v(dout1_23) AT=1510.05n

.meas tran vdout1_24ck1500 FIND v(dout1_24) AT=1510.05n

.meas tran vdout1_25ck1500 FIND v(dout1_25) AT=1510.05n

.meas tran vdout1_26ck1500 FIND v(dout1_26) AT=1510.05n

.meas tran vdout1_27ck1500 FIND v(dout1_27) AT=1510.05n

.meas tran vdout1_28ck1500 FIND v(dout1_28) AT=1510.05n

.meas tran vdout1_29ck1500 FIND v(dout1_29) AT=1510.05n

.meas tran vdout1_30ck1500 FIND v(dout1_30) AT=1510.05n

.meas tran vdout1_31ck1500 FIND v(dout1_31) AT=1510.05n

.meas tran vdout1_32ck1500 FIND v(dout1_32) AT=1510.05n

.meas tran vdout1_33ck1500 FIND v(dout1_33) AT=1510.05n

.meas tran vdout1_34ck1500 FIND v(dout1_34) AT=1510.05n

.meas tran vdout1_35ck1500 FIND v(dout1_35) AT=1510.05n

.meas tran vdout1_36ck1500 FIND v(dout1_36) AT=1510.05n

.meas tran vdout1_37ck1500 FIND v(dout1_37) AT=1510.05n

.meas tran vdout1_38ck1500 FIND v(dout1_38) AT=1510.05n

.meas tran vdout1_39ck1500 FIND v(dout1_39) AT=1510.05n

.meas tran vdout1_40ck1500 FIND v(dout1_40) AT=1510.05n

.meas tran vdout1_41ck1500 FIND v(dout1_41) AT=1510.05n

.meas tran vdout1_42ck1500 FIND v(dout1_42) AT=1510.05n

.meas tran vdout1_43ck1500 FIND v(dout1_43) AT=1510.05n

.meas tran vdout1_44ck1500 FIND v(dout1_44) AT=1510.05n

.meas tran vdout1_45ck1500 FIND v(dout1_45) AT=1510.05n

.meas tran vdout1_46ck1500 FIND v(dout1_46) AT=1510.05n

.meas tran vdout1_47ck1500 FIND v(dout1_47) AT=1510.05n

.meas tran vdout1_48ck1500 FIND v(dout1_48) AT=1510.05n

.meas tran vdout1_49ck1500 FIND v(dout1_49) AT=1510.05n

.meas tran vdout1_50ck1500 FIND v(dout1_50) AT=1510.05n

.meas tran vdout1_51ck1500 FIND v(dout1_51) AT=1510.05n

.meas tran vdout1_52ck1500 FIND v(dout1_52) AT=1510.05n

.meas tran vdout1_53ck1500 FIND v(dout1_53) AT=1510.05n

.meas tran vdout1_54ck1500 FIND v(dout1_54) AT=1510.05n

.meas tran vdout1_55ck1500 FIND v(dout1_55) AT=1510.05n

.meas tran vdout1_56ck1500 FIND v(dout1_56) AT=1510.05n

.meas tran vdout1_57ck1500 FIND v(dout1_57) AT=1510.05n

.meas tran vdout1_58ck1500 FIND v(dout1_58) AT=1510.05n

.meas tran vdout1_59ck1500 FIND v(dout1_59) AT=1510.05n

.meas tran vdout1_60ck1500 FIND v(dout1_60) AT=1510.05n

.meas tran vdout1_61ck1500 FIND v(dout1_61) AT=1510.05n

.meas tran vdout1_62ck1500 FIND v(dout1_62) AT=1510.05n

.meas tran vdout1_63ck1500 FIND v(dout1_63) AT=1510.05n

.meas tran vdout1_64ck1500 FIND v(dout1_64) AT=1510.05n

.meas tran vdout1_65ck1500 FIND v(dout1_65) AT=1510.05n

.meas tran vdout1_66ck1500 FIND v(dout1_66) AT=1510.05n

.meas tran vdout1_67ck1500 FIND v(dout1_67) AT=1510.05n

.meas tran vdout1_68ck1500 FIND v(dout1_68) AT=1510.05n

.meas tran vdout1_69ck1500 FIND v(dout1_69) AT=1510.05n

.meas tran vdout1_70ck1500 FIND v(dout1_70) AT=1510.05n

.meas tran vdout1_71ck1500 FIND v(dout1_71) AT=1510.05n

.meas tran vdout1_72ck1500 FIND v(dout1_72) AT=1510.05n

.meas tran vdout1_73ck1500 FIND v(dout1_73) AT=1510.05n

.meas tran vdout1_74ck1500 FIND v(dout1_74) AT=1510.05n

.meas tran vdout1_75ck1500 FIND v(dout1_75) AT=1510.05n

.meas tran vdout1_76ck1500 FIND v(dout1_76) AT=1510.05n

.meas tran vdout1_77ck1500 FIND v(dout1_77) AT=1510.05n

.meas tran vdout1_78ck1500 FIND v(dout1_78) AT=1510.05n

.meas tran vdout1_79ck1500 FIND v(dout1_79) AT=1510.05n

.meas tran vdout1_80ck1500 FIND v(dout1_80) AT=1510.05n

.meas tran vdout1_81ck1500 FIND v(dout1_81) AT=1510.05n

.meas tran vdout1_82ck1500 FIND v(dout1_82) AT=1510.05n

.meas tran vdout1_83ck1500 FIND v(dout1_83) AT=1510.05n

.meas tran vdout1_84ck1500 FIND v(dout1_84) AT=1510.05n

.meas tran vdout1_85ck1500 FIND v(dout1_85) AT=1510.05n

.meas tran vdout1_86ck1500 FIND v(dout1_86) AT=1510.05n

.meas tran vdout1_87ck1500 FIND v(dout1_87) AT=1510.05n

.meas tran vdout1_88ck1500 FIND v(dout1_88) AT=1510.05n

.meas tran vdout1_89ck1500 FIND v(dout1_89) AT=1510.05n

.meas tran vdout1_90ck1500 FIND v(dout1_90) AT=1510.05n

.meas tran vdout1_91ck1500 FIND v(dout1_91) AT=1510.05n

.meas tran vdout1_92ck1500 FIND v(dout1_92) AT=1510.05n

.meas tran vdout1_93ck1500 FIND v(dout1_93) AT=1510.05n

.meas tran vdout1_94ck1500 FIND v(dout1_94) AT=1510.05n

.meas tran vdout1_95ck1500 FIND v(dout1_95) AT=1510.05n

.meas tran vdout1_96ck1500 FIND v(dout1_96) AT=1510.05n

.meas tran vdout1_97ck1500 FIND v(dout1_97) AT=1510.05n

.meas tran vdout1_98ck1500 FIND v(dout1_98) AT=1510.05n

.meas tran vdout1_99ck1500 FIND v(dout1_99) AT=1510.05n

.meas tran vdout1_100ck1500 FIND v(dout1_100) AT=1510.05n

.meas tran vdout1_101ck1500 FIND v(dout1_101) AT=1510.05n

.meas tran vdout1_102ck1500 FIND v(dout1_102) AT=1510.05n

.meas tran vdout1_103ck1500 FIND v(dout1_103) AT=1510.05n

.meas tran vdout1_104ck1500 FIND v(dout1_104) AT=1510.05n

.meas tran vdout1_105ck1500 FIND v(dout1_105) AT=1510.05n

.meas tran vdout1_106ck1500 FIND v(dout1_106) AT=1510.05n

.meas tran vdout1_107ck1500 FIND v(dout1_107) AT=1510.05n

.meas tran vdout1_108ck1500 FIND v(dout1_108) AT=1510.05n

.meas tran vdout1_109ck1500 FIND v(dout1_109) AT=1510.05n

.meas tran vdout1_110ck1500 FIND v(dout1_110) AT=1510.05n

.meas tran vdout1_111ck1500 FIND v(dout1_111) AT=1510.05n

.meas tran vdout1_112ck1500 FIND v(dout1_112) AT=1510.05n

.meas tran vdout1_113ck1500 FIND v(dout1_113) AT=1510.05n

.meas tran vdout1_114ck1500 FIND v(dout1_114) AT=1510.05n

.meas tran vdout1_115ck1500 FIND v(dout1_115) AT=1510.05n

.meas tran vdout1_116ck1500 FIND v(dout1_116) AT=1510.05n

.meas tran vdout1_117ck1500 FIND v(dout1_117) AT=1510.05n

.meas tran vdout1_118ck1500 FIND v(dout1_118) AT=1510.05n

.meas tran vdout1_119ck1500 FIND v(dout1_119) AT=1510.05n

.meas tran vdout1_120ck1500 FIND v(dout1_120) AT=1510.05n

.meas tran vdout1_121ck1500 FIND v(dout1_121) AT=1510.05n

.meas tran vdout1_122ck1500 FIND v(dout1_122) AT=1510.05n

.meas tran vdout1_123ck1500 FIND v(dout1_123) AT=1510.05n

.meas tran vdout1_124ck1500 FIND v(dout1_124) AT=1510.05n

.meas tran vdout1_125ck1500 FIND v(dout1_125) AT=1510.05n

.meas tran vdout1_126ck1500 FIND v(dout1_126) AT=1510.05n

.meas tran vdout1_127ck1500 FIND v(dout1_127) AT=1510.05n

.meas tran vdout1_128ck1500 FIND v(dout1_128) AT=1510.05n

.meas tran vdout1_129ck1500 FIND v(dout1_129) AT=1510.05n

.meas tran vdout1_130ck1500 FIND v(dout1_130) AT=1510.05n

.meas tran vdout1_131ck1500 FIND v(dout1_131) AT=1510.05n

.meas tran vdout1_132ck1500 FIND v(dout1_132) AT=1510.05n

.meas tran vdout1_133ck1500 FIND v(dout1_133) AT=1510.05n

.meas tran vdout1_134ck1500 FIND v(dout1_134) AT=1510.05n

.meas tran vdout1_135ck1500 FIND v(dout1_135) AT=1510.05n

.meas tran vdout1_136ck1500 FIND v(dout1_136) AT=1510.05n

.meas tran vdout1_137ck1500 FIND v(dout1_137) AT=1510.05n

.meas tran vdout1_138ck1500 FIND v(dout1_138) AT=1510.05n

.meas tran vdout1_139ck1500 FIND v(dout1_139) AT=1510.05n

.meas tran vdout1_140ck1500 FIND v(dout1_140) AT=1510.05n

.meas tran vdout1_141ck1500 FIND v(dout1_141) AT=1510.05n

.meas tran vdout1_142ck1500 FIND v(dout1_142) AT=1510.05n

.meas tran vdout1_143ck1500 FIND v(dout1_143) AT=1510.05n

.meas tran vdout1_144ck1500 FIND v(dout1_144) AT=1510.05n

.meas tran vdout1_145ck1500 FIND v(dout1_145) AT=1510.05n

.meas tran vdout1_146ck1500 FIND v(dout1_146) AT=1510.05n

.meas tran vdout1_147ck1500 FIND v(dout1_147) AT=1510.05n

.meas tran vdout1_148ck1500 FIND v(dout1_148) AT=1510.05n

.meas tran vdout1_149ck1500 FIND v(dout1_149) AT=1510.05n

.meas tran vdout1_150ck1500 FIND v(dout1_150) AT=1510.05n

.meas tran vdout1_151ck1500 FIND v(dout1_151) AT=1510.05n

.meas tran vdout1_152ck1500 FIND v(dout1_152) AT=1510.05n

.meas tran vdout1_153ck1500 FIND v(dout1_153) AT=1510.05n

.meas tran vdout1_154ck1500 FIND v(dout1_154) AT=1510.05n

.meas tran vdout1_155ck1500 FIND v(dout1_155) AT=1510.05n

.meas tran vdout1_156ck1500 FIND v(dout1_156) AT=1510.05n

.meas tran vdout1_157ck1500 FIND v(dout1_157) AT=1510.05n

.meas tran vdout1_158ck1500 FIND v(dout1_158) AT=1510.05n

.meas tran vdout1_159ck1500 FIND v(dout1_159) AT=1510.05n

.meas tran vdout1_160ck1500 FIND v(dout1_160) AT=1510.05n

.meas tran vdout1_161ck1500 FIND v(dout1_161) AT=1510.05n

.meas tran vdout1_162ck1500 FIND v(dout1_162) AT=1510.05n

.meas tran vdout1_163ck1500 FIND v(dout1_163) AT=1510.05n

.meas tran vdout1_164ck1500 FIND v(dout1_164) AT=1510.05n

.meas tran vdout1_165ck1500 FIND v(dout1_165) AT=1510.05n

.meas tran vdout1_166ck1500 FIND v(dout1_166) AT=1510.05n

.meas tran vdout1_167ck1500 FIND v(dout1_167) AT=1510.05n

.meas tran vdout1_168ck1500 FIND v(dout1_168) AT=1510.05n

.meas tran vdout1_169ck1500 FIND v(dout1_169) AT=1510.05n

.meas tran vdout1_170ck1500 FIND v(dout1_170) AT=1510.05n

.meas tran vdout1_171ck1500 FIND v(dout1_171) AT=1510.05n

.meas tran vdout1_172ck1500 FIND v(dout1_172) AT=1510.05n

.meas tran vdout1_173ck1500 FIND v(dout1_173) AT=1510.05n

.meas tran vdout1_174ck1500 FIND v(dout1_174) AT=1510.05n

.meas tran vdout1_175ck1500 FIND v(dout1_175) AT=1510.05n

.meas tran vdout1_176ck1500 FIND v(dout1_176) AT=1510.05n

.meas tran vdout1_177ck1500 FIND v(dout1_177) AT=1510.05n

.meas tran vdout1_178ck1500 FIND v(dout1_178) AT=1510.05n

.meas tran vdout1_179ck1500 FIND v(dout1_179) AT=1510.05n

.meas tran vdout1_180ck1500 FIND v(dout1_180) AT=1510.05n

.meas tran vdout1_181ck1500 FIND v(dout1_181) AT=1510.05n

.meas tran vdout1_182ck1500 FIND v(dout1_182) AT=1510.05n

.meas tran vdout1_183ck1500 FIND v(dout1_183) AT=1510.05n

.meas tran vdout1_184ck1500 FIND v(dout1_184) AT=1510.05n

.meas tran vdout1_185ck1500 FIND v(dout1_185) AT=1510.05n

.meas tran vdout1_186ck1500 FIND v(dout1_186) AT=1510.05n

.meas tran vdout1_187ck1500 FIND v(dout1_187) AT=1510.05n

.meas tran vdout1_188ck1500 FIND v(dout1_188) AT=1510.05n

.meas tran vdout1_189ck1500 FIND v(dout1_189) AT=1510.05n

.meas tran vdout1_190ck1500 FIND v(dout1_190) AT=1510.05n

.meas tran vdout1_191ck1500 FIND v(dout1_191) AT=1510.05n

.meas tran vdout1_192ck1500 FIND v(dout1_192) AT=1510.05n

.meas tran vdout1_193ck1500 FIND v(dout1_193) AT=1510.05n

.meas tran vdout1_194ck1500 FIND v(dout1_194) AT=1510.05n

.meas tran vdout1_195ck1500 FIND v(dout1_195) AT=1510.05n

.meas tran vdout1_196ck1500 FIND v(dout1_196) AT=1510.05n

.meas tran vdout1_197ck1500 FIND v(dout1_197) AT=1510.05n

.meas tran vdout1_198ck1500 FIND v(dout1_198) AT=1510.05n

.meas tran vdout1_199ck1500 FIND v(dout1_199) AT=1510.05n

.meas tran vdout1_200ck1500 FIND v(dout1_200) AT=1510.05n

.meas tran vdout1_201ck1500 FIND v(dout1_201) AT=1510.05n

.meas tran vdout1_202ck1500 FIND v(dout1_202) AT=1510.05n

.meas tran vdout1_203ck1500 FIND v(dout1_203) AT=1510.05n

.meas tran vdout1_204ck1500 FIND v(dout1_204) AT=1510.05n

.meas tran vdout1_205ck1500 FIND v(dout1_205) AT=1510.05n

.meas tran vdout1_206ck1500 FIND v(dout1_206) AT=1510.05n

.meas tran vdout1_207ck1500 FIND v(dout1_207) AT=1510.05n

.meas tran vdout1_208ck1500 FIND v(dout1_208) AT=1510.05n

.meas tran vdout1_209ck1500 FIND v(dout1_209) AT=1510.05n

.meas tran vdout1_210ck1500 FIND v(dout1_210) AT=1510.05n

.meas tran vdout1_211ck1500 FIND v(dout1_211) AT=1510.05n

.meas tran vdout1_212ck1500 FIND v(dout1_212) AT=1510.05n

.meas tran vdout1_213ck1500 FIND v(dout1_213) AT=1510.05n

.meas tran vdout1_214ck1500 FIND v(dout1_214) AT=1510.05n

.meas tran vdout1_215ck1500 FIND v(dout1_215) AT=1510.05n

.meas tran vdout1_216ck1500 FIND v(dout1_216) AT=1510.05n

.meas tran vdout1_217ck1500 FIND v(dout1_217) AT=1510.05n

.meas tran vdout1_218ck1500 FIND v(dout1_218) AT=1510.05n

.meas tran vdout1_219ck1500 FIND v(dout1_219) AT=1510.05n

.meas tran vdout1_220ck1500 FIND v(dout1_220) AT=1510.05n

.meas tran vdout1_221ck1500 FIND v(dout1_221) AT=1510.05n

.meas tran vdout1_222ck1500 FIND v(dout1_222) AT=1510.05n

.meas tran vdout1_223ck1500 FIND v(dout1_223) AT=1510.05n

.meas tran vdout1_224ck1500 FIND v(dout1_224) AT=1510.05n

.meas tran vdout1_225ck1500 FIND v(dout1_225) AT=1510.05n

.meas tran vdout1_226ck1500 FIND v(dout1_226) AT=1510.05n

.meas tran vdout1_227ck1500 FIND v(dout1_227) AT=1510.05n

.meas tran vdout1_228ck1500 FIND v(dout1_228) AT=1510.05n

.meas tran vdout1_229ck1500 FIND v(dout1_229) AT=1510.05n

.meas tran vdout1_230ck1500 FIND v(dout1_230) AT=1510.05n

.meas tran vdout1_231ck1500 FIND v(dout1_231) AT=1510.05n

.meas tran vdout1_232ck1500 FIND v(dout1_232) AT=1510.05n

.meas tran vdout1_233ck1500 FIND v(dout1_233) AT=1510.05n

.meas tran vdout1_234ck1500 FIND v(dout1_234) AT=1510.05n

.meas tran vdout1_235ck1500 FIND v(dout1_235) AT=1510.05n

.meas tran vdout1_236ck1500 FIND v(dout1_236) AT=1510.05n

.meas tran vdout1_237ck1500 FIND v(dout1_237) AT=1510.05n

.meas tran vdout1_238ck1500 FIND v(dout1_238) AT=1510.05n

.meas tran vdout1_239ck1500 FIND v(dout1_239) AT=1510.05n

.meas tran vdout1_240ck1500 FIND v(dout1_240) AT=1510.05n

.meas tran vdout1_241ck1500 FIND v(dout1_241) AT=1510.05n

.meas tran vdout1_242ck1500 FIND v(dout1_242) AT=1510.05n

.meas tran vdout1_243ck1500 FIND v(dout1_243) AT=1510.05n

.meas tran vdout1_244ck1500 FIND v(dout1_244) AT=1510.05n

.meas tran vdout1_245ck1500 FIND v(dout1_245) AT=1510.05n

.meas tran vdout1_246ck1500 FIND v(dout1_246) AT=1510.05n

.meas tran vdout1_247ck1500 FIND v(dout1_247) AT=1510.05n

.meas tran vdout1_248ck1500 FIND v(dout1_248) AT=1510.05n

.meas tran vdout1_249ck1500 FIND v(dout1_249) AT=1510.05n

.meas tran vdout1_250ck1500 FIND v(dout1_250) AT=1510.05n

.meas tran vdout1_251ck1500 FIND v(dout1_251) AT=1510.05n

.meas tran vdout1_252ck1500 FIND v(dout1_252) AT=1510.05n

.meas tran vdout1_253ck1500 FIND v(dout1_253) AT=1510.05n

.meas tran vdout1_254ck1500 FIND v(dout1_254) AT=1510.05n

.meas tran vdout1_255ck1500 FIND v(dout1_255) AT=1510.05n

.meas tran vdout1_256ck1500 FIND v(dout1_256) AT=1510.05n

.meas tran vdout1_0ck1540 FIND v(dout1_0) AT=1550.05n

.meas tran vdout1_1ck1540 FIND v(dout1_1) AT=1550.05n

.meas tran vdout1_2ck1540 FIND v(dout1_2) AT=1550.05n

.meas tran vdout1_3ck1540 FIND v(dout1_3) AT=1550.05n

.meas tran vdout1_4ck1540 FIND v(dout1_4) AT=1550.05n

.meas tran vdout1_5ck1540 FIND v(dout1_5) AT=1550.05n

.meas tran vdout1_6ck1540 FIND v(dout1_6) AT=1550.05n

.meas tran vdout1_7ck1540 FIND v(dout1_7) AT=1550.05n

.meas tran vdout1_8ck1540 FIND v(dout1_8) AT=1550.05n

.meas tran vdout1_9ck1540 FIND v(dout1_9) AT=1550.05n

.meas tran vdout1_10ck1540 FIND v(dout1_10) AT=1550.05n

.meas tran vdout1_11ck1540 FIND v(dout1_11) AT=1550.05n

.meas tran vdout1_12ck1540 FIND v(dout1_12) AT=1550.05n

.meas tran vdout1_13ck1540 FIND v(dout1_13) AT=1550.05n

.meas tran vdout1_14ck1540 FIND v(dout1_14) AT=1550.05n

.meas tran vdout1_15ck1540 FIND v(dout1_15) AT=1550.05n

.meas tran vdout1_16ck1540 FIND v(dout1_16) AT=1550.05n

.meas tran vdout1_17ck1540 FIND v(dout1_17) AT=1550.05n

.meas tran vdout1_18ck1540 FIND v(dout1_18) AT=1550.05n

.meas tran vdout1_19ck1540 FIND v(dout1_19) AT=1550.05n

.meas tran vdout1_20ck1540 FIND v(dout1_20) AT=1550.05n

.meas tran vdout1_21ck1540 FIND v(dout1_21) AT=1550.05n

.meas tran vdout1_22ck1540 FIND v(dout1_22) AT=1550.05n

.meas tran vdout1_23ck1540 FIND v(dout1_23) AT=1550.05n

.meas tran vdout1_24ck1540 FIND v(dout1_24) AT=1550.05n

.meas tran vdout1_25ck1540 FIND v(dout1_25) AT=1550.05n

.meas tran vdout1_26ck1540 FIND v(dout1_26) AT=1550.05n

.meas tran vdout1_27ck1540 FIND v(dout1_27) AT=1550.05n

.meas tran vdout1_28ck1540 FIND v(dout1_28) AT=1550.05n

.meas tran vdout1_29ck1540 FIND v(dout1_29) AT=1550.05n

.meas tran vdout1_30ck1540 FIND v(dout1_30) AT=1550.05n

.meas tran vdout1_31ck1540 FIND v(dout1_31) AT=1550.05n

.meas tran vdout1_32ck1540 FIND v(dout1_32) AT=1550.05n

.meas tran vdout1_33ck1540 FIND v(dout1_33) AT=1550.05n

.meas tran vdout1_34ck1540 FIND v(dout1_34) AT=1550.05n

.meas tran vdout1_35ck1540 FIND v(dout1_35) AT=1550.05n

.meas tran vdout1_36ck1540 FIND v(dout1_36) AT=1550.05n

.meas tran vdout1_37ck1540 FIND v(dout1_37) AT=1550.05n

.meas tran vdout1_38ck1540 FIND v(dout1_38) AT=1550.05n

.meas tran vdout1_39ck1540 FIND v(dout1_39) AT=1550.05n

.meas tran vdout1_40ck1540 FIND v(dout1_40) AT=1550.05n

.meas tran vdout1_41ck1540 FIND v(dout1_41) AT=1550.05n

.meas tran vdout1_42ck1540 FIND v(dout1_42) AT=1550.05n

.meas tran vdout1_43ck1540 FIND v(dout1_43) AT=1550.05n

.meas tran vdout1_44ck1540 FIND v(dout1_44) AT=1550.05n

.meas tran vdout1_45ck1540 FIND v(dout1_45) AT=1550.05n

.meas tran vdout1_46ck1540 FIND v(dout1_46) AT=1550.05n

.meas tran vdout1_47ck1540 FIND v(dout1_47) AT=1550.05n

.meas tran vdout1_48ck1540 FIND v(dout1_48) AT=1550.05n

.meas tran vdout1_49ck1540 FIND v(dout1_49) AT=1550.05n

.meas tran vdout1_50ck1540 FIND v(dout1_50) AT=1550.05n

.meas tran vdout1_51ck1540 FIND v(dout1_51) AT=1550.05n

.meas tran vdout1_52ck1540 FIND v(dout1_52) AT=1550.05n

.meas tran vdout1_53ck1540 FIND v(dout1_53) AT=1550.05n

.meas tran vdout1_54ck1540 FIND v(dout1_54) AT=1550.05n

.meas tran vdout1_55ck1540 FIND v(dout1_55) AT=1550.05n

.meas tran vdout1_56ck1540 FIND v(dout1_56) AT=1550.05n

.meas tran vdout1_57ck1540 FIND v(dout1_57) AT=1550.05n

.meas tran vdout1_58ck1540 FIND v(dout1_58) AT=1550.05n

.meas tran vdout1_59ck1540 FIND v(dout1_59) AT=1550.05n

.meas tran vdout1_60ck1540 FIND v(dout1_60) AT=1550.05n

.meas tran vdout1_61ck1540 FIND v(dout1_61) AT=1550.05n

.meas tran vdout1_62ck1540 FIND v(dout1_62) AT=1550.05n

.meas tran vdout1_63ck1540 FIND v(dout1_63) AT=1550.05n

.meas tran vdout1_64ck1540 FIND v(dout1_64) AT=1550.05n

.meas tran vdout1_65ck1540 FIND v(dout1_65) AT=1550.05n

.meas tran vdout1_66ck1540 FIND v(dout1_66) AT=1550.05n

.meas tran vdout1_67ck1540 FIND v(dout1_67) AT=1550.05n

.meas tran vdout1_68ck1540 FIND v(dout1_68) AT=1550.05n

.meas tran vdout1_69ck1540 FIND v(dout1_69) AT=1550.05n

.meas tran vdout1_70ck1540 FIND v(dout1_70) AT=1550.05n

.meas tran vdout1_71ck1540 FIND v(dout1_71) AT=1550.05n

.meas tran vdout1_72ck1540 FIND v(dout1_72) AT=1550.05n

.meas tran vdout1_73ck1540 FIND v(dout1_73) AT=1550.05n

.meas tran vdout1_74ck1540 FIND v(dout1_74) AT=1550.05n

.meas tran vdout1_75ck1540 FIND v(dout1_75) AT=1550.05n

.meas tran vdout1_76ck1540 FIND v(dout1_76) AT=1550.05n

.meas tran vdout1_77ck1540 FIND v(dout1_77) AT=1550.05n

.meas tran vdout1_78ck1540 FIND v(dout1_78) AT=1550.05n

.meas tran vdout1_79ck1540 FIND v(dout1_79) AT=1550.05n

.meas tran vdout1_80ck1540 FIND v(dout1_80) AT=1550.05n

.meas tran vdout1_81ck1540 FIND v(dout1_81) AT=1550.05n

.meas tran vdout1_82ck1540 FIND v(dout1_82) AT=1550.05n

.meas tran vdout1_83ck1540 FIND v(dout1_83) AT=1550.05n

.meas tran vdout1_84ck1540 FIND v(dout1_84) AT=1550.05n

.meas tran vdout1_85ck1540 FIND v(dout1_85) AT=1550.05n

.meas tran vdout1_86ck1540 FIND v(dout1_86) AT=1550.05n

.meas tran vdout1_87ck1540 FIND v(dout1_87) AT=1550.05n

.meas tran vdout1_88ck1540 FIND v(dout1_88) AT=1550.05n

.meas tran vdout1_89ck1540 FIND v(dout1_89) AT=1550.05n

.meas tran vdout1_90ck1540 FIND v(dout1_90) AT=1550.05n

.meas tran vdout1_91ck1540 FIND v(dout1_91) AT=1550.05n

.meas tran vdout1_92ck1540 FIND v(dout1_92) AT=1550.05n

.meas tran vdout1_93ck1540 FIND v(dout1_93) AT=1550.05n

.meas tran vdout1_94ck1540 FIND v(dout1_94) AT=1550.05n

.meas tran vdout1_95ck1540 FIND v(dout1_95) AT=1550.05n

.meas tran vdout1_96ck1540 FIND v(dout1_96) AT=1550.05n

.meas tran vdout1_97ck1540 FIND v(dout1_97) AT=1550.05n

.meas tran vdout1_98ck1540 FIND v(dout1_98) AT=1550.05n

.meas tran vdout1_99ck1540 FIND v(dout1_99) AT=1550.05n

.meas tran vdout1_100ck1540 FIND v(dout1_100) AT=1550.05n

.meas tran vdout1_101ck1540 FIND v(dout1_101) AT=1550.05n

.meas tran vdout1_102ck1540 FIND v(dout1_102) AT=1550.05n

.meas tran vdout1_103ck1540 FIND v(dout1_103) AT=1550.05n

.meas tran vdout1_104ck1540 FIND v(dout1_104) AT=1550.05n

.meas tran vdout1_105ck1540 FIND v(dout1_105) AT=1550.05n

.meas tran vdout1_106ck1540 FIND v(dout1_106) AT=1550.05n

.meas tran vdout1_107ck1540 FIND v(dout1_107) AT=1550.05n

.meas tran vdout1_108ck1540 FIND v(dout1_108) AT=1550.05n

.meas tran vdout1_109ck1540 FIND v(dout1_109) AT=1550.05n

.meas tran vdout1_110ck1540 FIND v(dout1_110) AT=1550.05n

.meas tran vdout1_111ck1540 FIND v(dout1_111) AT=1550.05n

.meas tran vdout1_112ck1540 FIND v(dout1_112) AT=1550.05n

.meas tran vdout1_113ck1540 FIND v(dout1_113) AT=1550.05n

.meas tran vdout1_114ck1540 FIND v(dout1_114) AT=1550.05n

.meas tran vdout1_115ck1540 FIND v(dout1_115) AT=1550.05n

.meas tran vdout1_116ck1540 FIND v(dout1_116) AT=1550.05n

.meas tran vdout1_117ck1540 FIND v(dout1_117) AT=1550.05n

.meas tran vdout1_118ck1540 FIND v(dout1_118) AT=1550.05n

.meas tran vdout1_119ck1540 FIND v(dout1_119) AT=1550.05n

.meas tran vdout1_120ck1540 FIND v(dout1_120) AT=1550.05n

.meas tran vdout1_121ck1540 FIND v(dout1_121) AT=1550.05n

.meas tran vdout1_122ck1540 FIND v(dout1_122) AT=1550.05n

.meas tran vdout1_123ck1540 FIND v(dout1_123) AT=1550.05n

.meas tran vdout1_124ck1540 FIND v(dout1_124) AT=1550.05n

.meas tran vdout1_125ck1540 FIND v(dout1_125) AT=1550.05n

.meas tran vdout1_126ck1540 FIND v(dout1_126) AT=1550.05n

.meas tran vdout1_127ck1540 FIND v(dout1_127) AT=1550.05n

.meas tran vdout1_128ck1540 FIND v(dout1_128) AT=1550.05n

.meas tran vdout1_129ck1540 FIND v(dout1_129) AT=1550.05n

.meas tran vdout1_130ck1540 FIND v(dout1_130) AT=1550.05n

.meas tran vdout1_131ck1540 FIND v(dout1_131) AT=1550.05n

.meas tran vdout1_132ck1540 FIND v(dout1_132) AT=1550.05n

.meas tran vdout1_133ck1540 FIND v(dout1_133) AT=1550.05n

.meas tran vdout1_134ck1540 FIND v(dout1_134) AT=1550.05n

.meas tran vdout1_135ck1540 FIND v(dout1_135) AT=1550.05n

.meas tran vdout1_136ck1540 FIND v(dout1_136) AT=1550.05n

.meas tran vdout1_137ck1540 FIND v(dout1_137) AT=1550.05n

.meas tran vdout1_138ck1540 FIND v(dout1_138) AT=1550.05n

.meas tran vdout1_139ck1540 FIND v(dout1_139) AT=1550.05n

.meas tran vdout1_140ck1540 FIND v(dout1_140) AT=1550.05n

.meas tran vdout1_141ck1540 FIND v(dout1_141) AT=1550.05n

.meas tran vdout1_142ck1540 FIND v(dout1_142) AT=1550.05n

.meas tran vdout1_143ck1540 FIND v(dout1_143) AT=1550.05n

.meas tran vdout1_144ck1540 FIND v(dout1_144) AT=1550.05n

.meas tran vdout1_145ck1540 FIND v(dout1_145) AT=1550.05n

.meas tran vdout1_146ck1540 FIND v(dout1_146) AT=1550.05n

.meas tran vdout1_147ck1540 FIND v(dout1_147) AT=1550.05n

.meas tran vdout1_148ck1540 FIND v(dout1_148) AT=1550.05n

.meas tran vdout1_149ck1540 FIND v(dout1_149) AT=1550.05n

.meas tran vdout1_150ck1540 FIND v(dout1_150) AT=1550.05n

.meas tran vdout1_151ck1540 FIND v(dout1_151) AT=1550.05n

.meas tran vdout1_152ck1540 FIND v(dout1_152) AT=1550.05n

.meas tran vdout1_153ck1540 FIND v(dout1_153) AT=1550.05n

.meas tran vdout1_154ck1540 FIND v(dout1_154) AT=1550.05n

.meas tran vdout1_155ck1540 FIND v(dout1_155) AT=1550.05n

.meas tran vdout1_156ck1540 FIND v(dout1_156) AT=1550.05n

.meas tran vdout1_157ck1540 FIND v(dout1_157) AT=1550.05n

.meas tran vdout1_158ck1540 FIND v(dout1_158) AT=1550.05n

.meas tran vdout1_159ck1540 FIND v(dout1_159) AT=1550.05n

.meas tran vdout1_160ck1540 FIND v(dout1_160) AT=1550.05n

.meas tran vdout1_161ck1540 FIND v(dout1_161) AT=1550.05n

.meas tran vdout1_162ck1540 FIND v(dout1_162) AT=1550.05n

.meas tran vdout1_163ck1540 FIND v(dout1_163) AT=1550.05n

.meas tran vdout1_164ck1540 FIND v(dout1_164) AT=1550.05n

.meas tran vdout1_165ck1540 FIND v(dout1_165) AT=1550.05n

.meas tran vdout1_166ck1540 FIND v(dout1_166) AT=1550.05n

.meas tran vdout1_167ck1540 FIND v(dout1_167) AT=1550.05n

.meas tran vdout1_168ck1540 FIND v(dout1_168) AT=1550.05n

.meas tran vdout1_169ck1540 FIND v(dout1_169) AT=1550.05n

.meas tran vdout1_170ck1540 FIND v(dout1_170) AT=1550.05n

.meas tran vdout1_171ck1540 FIND v(dout1_171) AT=1550.05n

.meas tran vdout1_172ck1540 FIND v(dout1_172) AT=1550.05n

.meas tran vdout1_173ck1540 FIND v(dout1_173) AT=1550.05n

.meas tran vdout1_174ck1540 FIND v(dout1_174) AT=1550.05n

.meas tran vdout1_175ck1540 FIND v(dout1_175) AT=1550.05n

.meas tran vdout1_176ck1540 FIND v(dout1_176) AT=1550.05n

.meas tran vdout1_177ck1540 FIND v(dout1_177) AT=1550.05n

.meas tran vdout1_178ck1540 FIND v(dout1_178) AT=1550.05n

.meas tran vdout1_179ck1540 FIND v(dout1_179) AT=1550.05n

.meas tran vdout1_180ck1540 FIND v(dout1_180) AT=1550.05n

.meas tran vdout1_181ck1540 FIND v(dout1_181) AT=1550.05n

.meas tran vdout1_182ck1540 FIND v(dout1_182) AT=1550.05n

.meas tran vdout1_183ck1540 FIND v(dout1_183) AT=1550.05n

.meas tran vdout1_184ck1540 FIND v(dout1_184) AT=1550.05n

.meas tran vdout1_185ck1540 FIND v(dout1_185) AT=1550.05n

.meas tran vdout1_186ck1540 FIND v(dout1_186) AT=1550.05n

.meas tran vdout1_187ck1540 FIND v(dout1_187) AT=1550.05n

.meas tran vdout1_188ck1540 FIND v(dout1_188) AT=1550.05n

.meas tran vdout1_189ck1540 FIND v(dout1_189) AT=1550.05n

.meas tran vdout1_190ck1540 FIND v(dout1_190) AT=1550.05n

.meas tran vdout1_191ck1540 FIND v(dout1_191) AT=1550.05n

.meas tran vdout1_192ck1540 FIND v(dout1_192) AT=1550.05n

.meas tran vdout1_193ck1540 FIND v(dout1_193) AT=1550.05n

.meas tran vdout1_194ck1540 FIND v(dout1_194) AT=1550.05n

.meas tran vdout1_195ck1540 FIND v(dout1_195) AT=1550.05n

.meas tran vdout1_196ck1540 FIND v(dout1_196) AT=1550.05n

.meas tran vdout1_197ck1540 FIND v(dout1_197) AT=1550.05n

.meas tran vdout1_198ck1540 FIND v(dout1_198) AT=1550.05n

.meas tran vdout1_199ck1540 FIND v(dout1_199) AT=1550.05n

.meas tran vdout1_200ck1540 FIND v(dout1_200) AT=1550.05n

.meas tran vdout1_201ck1540 FIND v(dout1_201) AT=1550.05n

.meas tran vdout1_202ck1540 FIND v(dout1_202) AT=1550.05n

.meas tran vdout1_203ck1540 FIND v(dout1_203) AT=1550.05n

.meas tran vdout1_204ck1540 FIND v(dout1_204) AT=1550.05n

.meas tran vdout1_205ck1540 FIND v(dout1_205) AT=1550.05n

.meas tran vdout1_206ck1540 FIND v(dout1_206) AT=1550.05n

.meas tran vdout1_207ck1540 FIND v(dout1_207) AT=1550.05n

.meas tran vdout1_208ck1540 FIND v(dout1_208) AT=1550.05n

.meas tran vdout1_209ck1540 FIND v(dout1_209) AT=1550.05n

.meas tran vdout1_210ck1540 FIND v(dout1_210) AT=1550.05n

.meas tran vdout1_211ck1540 FIND v(dout1_211) AT=1550.05n

.meas tran vdout1_212ck1540 FIND v(dout1_212) AT=1550.05n

.meas tran vdout1_213ck1540 FIND v(dout1_213) AT=1550.05n

.meas tran vdout1_214ck1540 FIND v(dout1_214) AT=1550.05n

.meas tran vdout1_215ck1540 FIND v(dout1_215) AT=1550.05n

.meas tran vdout1_216ck1540 FIND v(dout1_216) AT=1550.05n

.meas tran vdout1_217ck1540 FIND v(dout1_217) AT=1550.05n

.meas tran vdout1_218ck1540 FIND v(dout1_218) AT=1550.05n

.meas tran vdout1_219ck1540 FIND v(dout1_219) AT=1550.05n

.meas tran vdout1_220ck1540 FIND v(dout1_220) AT=1550.05n

.meas tran vdout1_221ck1540 FIND v(dout1_221) AT=1550.05n

.meas tran vdout1_222ck1540 FIND v(dout1_222) AT=1550.05n

.meas tran vdout1_223ck1540 FIND v(dout1_223) AT=1550.05n

.meas tran vdout1_224ck1540 FIND v(dout1_224) AT=1550.05n

.meas tran vdout1_225ck1540 FIND v(dout1_225) AT=1550.05n

.meas tran vdout1_226ck1540 FIND v(dout1_226) AT=1550.05n

.meas tran vdout1_227ck1540 FIND v(dout1_227) AT=1550.05n

.meas tran vdout1_228ck1540 FIND v(dout1_228) AT=1550.05n

.meas tran vdout1_229ck1540 FIND v(dout1_229) AT=1550.05n

.meas tran vdout1_230ck1540 FIND v(dout1_230) AT=1550.05n

.meas tran vdout1_231ck1540 FIND v(dout1_231) AT=1550.05n

.meas tran vdout1_232ck1540 FIND v(dout1_232) AT=1550.05n

.meas tran vdout1_233ck1540 FIND v(dout1_233) AT=1550.05n

.meas tran vdout1_234ck1540 FIND v(dout1_234) AT=1550.05n

.meas tran vdout1_235ck1540 FIND v(dout1_235) AT=1550.05n

.meas tran vdout1_236ck1540 FIND v(dout1_236) AT=1550.05n

.meas tran vdout1_237ck1540 FIND v(dout1_237) AT=1550.05n

.meas tran vdout1_238ck1540 FIND v(dout1_238) AT=1550.05n

.meas tran vdout1_239ck1540 FIND v(dout1_239) AT=1550.05n

.meas tran vdout1_240ck1540 FIND v(dout1_240) AT=1550.05n

.meas tran vdout1_241ck1540 FIND v(dout1_241) AT=1550.05n

.meas tran vdout1_242ck1540 FIND v(dout1_242) AT=1550.05n

.meas tran vdout1_243ck1540 FIND v(dout1_243) AT=1550.05n

.meas tran vdout1_244ck1540 FIND v(dout1_244) AT=1550.05n

.meas tran vdout1_245ck1540 FIND v(dout1_245) AT=1550.05n

.meas tran vdout1_246ck1540 FIND v(dout1_246) AT=1550.05n

.meas tran vdout1_247ck1540 FIND v(dout1_247) AT=1550.05n

.meas tran vdout1_248ck1540 FIND v(dout1_248) AT=1550.05n

.meas tran vdout1_249ck1540 FIND v(dout1_249) AT=1550.05n

.meas tran vdout1_250ck1540 FIND v(dout1_250) AT=1550.05n

.meas tran vdout1_251ck1540 FIND v(dout1_251) AT=1550.05n

.meas tran vdout1_252ck1540 FIND v(dout1_252) AT=1550.05n

.meas tran vdout1_253ck1540 FIND v(dout1_253) AT=1550.05n

.meas tran vdout1_254ck1540 FIND v(dout1_254) AT=1550.05n

.meas tran vdout1_255ck1540 FIND v(dout1_255) AT=1550.05n

.meas tran vdout1_256ck1540 FIND v(dout1_256) AT=1550.05n

.meas tran vdout1_0ck1550 FIND v(dout1_0) AT=1560.05n

.meas tran vdout1_1ck1550 FIND v(dout1_1) AT=1560.05n

.meas tran vdout1_2ck1550 FIND v(dout1_2) AT=1560.05n

.meas tran vdout1_3ck1550 FIND v(dout1_3) AT=1560.05n

.meas tran vdout1_4ck1550 FIND v(dout1_4) AT=1560.05n

.meas tran vdout1_5ck1550 FIND v(dout1_5) AT=1560.05n

.meas tran vdout1_6ck1550 FIND v(dout1_6) AT=1560.05n

.meas tran vdout1_7ck1550 FIND v(dout1_7) AT=1560.05n

.meas tran vdout1_8ck1550 FIND v(dout1_8) AT=1560.05n

.meas tran vdout1_9ck1550 FIND v(dout1_9) AT=1560.05n

.meas tran vdout1_10ck1550 FIND v(dout1_10) AT=1560.05n

.meas tran vdout1_11ck1550 FIND v(dout1_11) AT=1560.05n

.meas tran vdout1_12ck1550 FIND v(dout1_12) AT=1560.05n

.meas tran vdout1_13ck1550 FIND v(dout1_13) AT=1560.05n

.meas tran vdout1_14ck1550 FIND v(dout1_14) AT=1560.05n

.meas tran vdout1_15ck1550 FIND v(dout1_15) AT=1560.05n

.meas tran vdout1_16ck1550 FIND v(dout1_16) AT=1560.05n

.meas tran vdout1_17ck1550 FIND v(dout1_17) AT=1560.05n

.meas tran vdout1_18ck1550 FIND v(dout1_18) AT=1560.05n

.meas tran vdout1_19ck1550 FIND v(dout1_19) AT=1560.05n

.meas tran vdout1_20ck1550 FIND v(dout1_20) AT=1560.05n

.meas tran vdout1_21ck1550 FIND v(dout1_21) AT=1560.05n

.meas tran vdout1_22ck1550 FIND v(dout1_22) AT=1560.05n

.meas tran vdout1_23ck1550 FIND v(dout1_23) AT=1560.05n

.meas tran vdout1_24ck1550 FIND v(dout1_24) AT=1560.05n

.meas tran vdout1_25ck1550 FIND v(dout1_25) AT=1560.05n

.meas tran vdout1_26ck1550 FIND v(dout1_26) AT=1560.05n

.meas tran vdout1_27ck1550 FIND v(dout1_27) AT=1560.05n

.meas tran vdout1_28ck1550 FIND v(dout1_28) AT=1560.05n

.meas tran vdout1_29ck1550 FIND v(dout1_29) AT=1560.05n

.meas tran vdout1_30ck1550 FIND v(dout1_30) AT=1560.05n

.meas tran vdout1_31ck1550 FIND v(dout1_31) AT=1560.05n

.meas tran vdout1_32ck1550 FIND v(dout1_32) AT=1560.05n

.meas tran vdout1_33ck1550 FIND v(dout1_33) AT=1560.05n

.meas tran vdout1_34ck1550 FIND v(dout1_34) AT=1560.05n

.meas tran vdout1_35ck1550 FIND v(dout1_35) AT=1560.05n

.meas tran vdout1_36ck1550 FIND v(dout1_36) AT=1560.05n

.meas tran vdout1_37ck1550 FIND v(dout1_37) AT=1560.05n

.meas tran vdout1_38ck1550 FIND v(dout1_38) AT=1560.05n

.meas tran vdout1_39ck1550 FIND v(dout1_39) AT=1560.05n

.meas tran vdout1_40ck1550 FIND v(dout1_40) AT=1560.05n

.meas tran vdout1_41ck1550 FIND v(dout1_41) AT=1560.05n

.meas tran vdout1_42ck1550 FIND v(dout1_42) AT=1560.05n

.meas tran vdout1_43ck1550 FIND v(dout1_43) AT=1560.05n

.meas tran vdout1_44ck1550 FIND v(dout1_44) AT=1560.05n

.meas tran vdout1_45ck1550 FIND v(dout1_45) AT=1560.05n

.meas tran vdout1_46ck1550 FIND v(dout1_46) AT=1560.05n

.meas tran vdout1_47ck1550 FIND v(dout1_47) AT=1560.05n

.meas tran vdout1_48ck1550 FIND v(dout1_48) AT=1560.05n

.meas tran vdout1_49ck1550 FIND v(dout1_49) AT=1560.05n

.meas tran vdout1_50ck1550 FIND v(dout1_50) AT=1560.05n

.meas tran vdout1_51ck1550 FIND v(dout1_51) AT=1560.05n

.meas tran vdout1_52ck1550 FIND v(dout1_52) AT=1560.05n

.meas tran vdout1_53ck1550 FIND v(dout1_53) AT=1560.05n

.meas tran vdout1_54ck1550 FIND v(dout1_54) AT=1560.05n

.meas tran vdout1_55ck1550 FIND v(dout1_55) AT=1560.05n

.meas tran vdout1_56ck1550 FIND v(dout1_56) AT=1560.05n

.meas tran vdout1_57ck1550 FIND v(dout1_57) AT=1560.05n

.meas tran vdout1_58ck1550 FIND v(dout1_58) AT=1560.05n

.meas tran vdout1_59ck1550 FIND v(dout1_59) AT=1560.05n

.meas tran vdout1_60ck1550 FIND v(dout1_60) AT=1560.05n

.meas tran vdout1_61ck1550 FIND v(dout1_61) AT=1560.05n

.meas tran vdout1_62ck1550 FIND v(dout1_62) AT=1560.05n

.meas tran vdout1_63ck1550 FIND v(dout1_63) AT=1560.05n

.meas tran vdout1_64ck1550 FIND v(dout1_64) AT=1560.05n

.meas tran vdout1_65ck1550 FIND v(dout1_65) AT=1560.05n

.meas tran vdout1_66ck1550 FIND v(dout1_66) AT=1560.05n

.meas tran vdout1_67ck1550 FIND v(dout1_67) AT=1560.05n

.meas tran vdout1_68ck1550 FIND v(dout1_68) AT=1560.05n

.meas tran vdout1_69ck1550 FIND v(dout1_69) AT=1560.05n

.meas tran vdout1_70ck1550 FIND v(dout1_70) AT=1560.05n

.meas tran vdout1_71ck1550 FIND v(dout1_71) AT=1560.05n

.meas tran vdout1_72ck1550 FIND v(dout1_72) AT=1560.05n

.meas tran vdout1_73ck1550 FIND v(dout1_73) AT=1560.05n

.meas tran vdout1_74ck1550 FIND v(dout1_74) AT=1560.05n

.meas tran vdout1_75ck1550 FIND v(dout1_75) AT=1560.05n

.meas tran vdout1_76ck1550 FIND v(dout1_76) AT=1560.05n

.meas tran vdout1_77ck1550 FIND v(dout1_77) AT=1560.05n

.meas tran vdout1_78ck1550 FIND v(dout1_78) AT=1560.05n

.meas tran vdout1_79ck1550 FIND v(dout1_79) AT=1560.05n

.meas tran vdout1_80ck1550 FIND v(dout1_80) AT=1560.05n

.meas tran vdout1_81ck1550 FIND v(dout1_81) AT=1560.05n

.meas tran vdout1_82ck1550 FIND v(dout1_82) AT=1560.05n

.meas tran vdout1_83ck1550 FIND v(dout1_83) AT=1560.05n

.meas tran vdout1_84ck1550 FIND v(dout1_84) AT=1560.05n

.meas tran vdout1_85ck1550 FIND v(dout1_85) AT=1560.05n

.meas tran vdout1_86ck1550 FIND v(dout1_86) AT=1560.05n

.meas tran vdout1_87ck1550 FIND v(dout1_87) AT=1560.05n

.meas tran vdout1_88ck1550 FIND v(dout1_88) AT=1560.05n

.meas tran vdout1_89ck1550 FIND v(dout1_89) AT=1560.05n

.meas tran vdout1_90ck1550 FIND v(dout1_90) AT=1560.05n

.meas tran vdout1_91ck1550 FIND v(dout1_91) AT=1560.05n

.meas tran vdout1_92ck1550 FIND v(dout1_92) AT=1560.05n

.meas tran vdout1_93ck1550 FIND v(dout1_93) AT=1560.05n

.meas tran vdout1_94ck1550 FIND v(dout1_94) AT=1560.05n

.meas tran vdout1_95ck1550 FIND v(dout1_95) AT=1560.05n

.meas tran vdout1_96ck1550 FIND v(dout1_96) AT=1560.05n

.meas tran vdout1_97ck1550 FIND v(dout1_97) AT=1560.05n

.meas tran vdout1_98ck1550 FIND v(dout1_98) AT=1560.05n

.meas tran vdout1_99ck1550 FIND v(dout1_99) AT=1560.05n

.meas tran vdout1_100ck1550 FIND v(dout1_100) AT=1560.05n

.meas tran vdout1_101ck1550 FIND v(dout1_101) AT=1560.05n

.meas tran vdout1_102ck1550 FIND v(dout1_102) AT=1560.05n

.meas tran vdout1_103ck1550 FIND v(dout1_103) AT=1560.05n

.meas tran vdout1_104ck1550 FIND v(dout1_104) AT=1560.05n

.meas tran vdout1_105ck1550 FIND v(dout1_105) AT=1560.05n

.meas tran vdout1_106ck1550 FIND v(dout1_106) AT=1560.05n

.meas tran vdout1_107ck1550 FIND v(dout1_107) AT=1560.05n

.meas tran vdout1_108ck1550 FIND v(dout1_108) AT=1560.05n

.meas tran vdout1_109ck1550 FIND v(dout1_109) AT=1560.05n

.meas tran vdout1_110ck1550 FIND v(dout1_110) AT=1560.05n

.meas tran vdout1_111ck1550 FIND v(dout1_111) AT=1560.05n

.meas tran vdout1_112ck1550 FIND v(dout1_112) AT=1560.05n

.meas tran vdout1_113ck1550 FIND v(dout1_113) AT=1560.05n

.meas tran vdout1_114ck1550 FIND v(dout1_114) AT=1560.05n

.meas tran vdout1_115ck1550 FIND v(dout1_115) AT=1560.05n

.meas tran vdout1_116ck1550 FIND v(dout1_116) AT=1560.05n

.meas tran vdout1_117ck1550 FIND v(dout1_117) AT=1560.05n

.meas tran vdout1_118ck1550 FIND v(dout1_118) AT=1560.05n

.meas tran vdout1_119ck1550 FIND v(dout1_119) AT=1560.05n

.meas tran vdout1_120ck1550 FIND v(dout1_120) AT=1560.05n

.meas tran vdout1_121ck1550 FIND v(dout1_121) AT=1560.05n

.meas tran vdout1_122ck1550 FIND v(dout1_122) AT=1560.05n

.meas tran vdout1_123ck1550 FIND v(dout1_123) AT=1560.05n

.meas tran vdout1_124ck1550 FIND v(dout1_124) AT=1560.05n

.meas tran vdout1_125ck1550 FIND v(dout1_125) AT=1560.05n

.meas tran vdout1_126ck1550 FIND v(dout1_126) AT=1560.05n

.meas tran vdout1_127ck1550 FIND v(dout1_127) AT=1560.05n

.meas tran vdout1_128ck1550 FIND v(dout1_128) AT=1560.05n

.meas tran vdout1_129ck1550 FIND v(dout1_129) AT=1560.05n

.meas tran vdout1_130ck1550 FIND v(dout1_130) AT=1560.05n

.meas tran vdout1_131ck1550 FIND v(dout1_131) AT=1560.05n

.meas tran vdout1_132ck1550 FIND v(dout1_132) AT=1560.05n

.meas tran vdout1_133ck1550 FIND v(dout1_133) AT=1560.05n

.meas tran vdout1_134ck1550 FIND v(dout1_134) AT=1560.05n

.meas tran vdout1_135ck1550 FIND v(dout1_135) AT=1560.05n

.meas tran vdout1_136ck1550 FIND v(dout1_136) AT=1560.05n

.meas tran vdout1_137ck1550 FIND v(dout1_137) AT=1560.05n

.meas tran vdout1_138ck1550 FIND v(dout1_138) AT=1560.05n

.meas tran vdout1_139ck1550 FIND v(dout1_139) AT=1560.05n

.meas tran vdout1_140ck1550 FIND v(dout1_140) AT=1560.05n

.meas tran vdout1_141ck1550 FIND v(dout1_141) AT=1560.05n

.meas tran vdout1_142ck1550 FIND v(dout1_142) AT=1560.05n

.meas tran vdout1_143ck1550 FIND v(dout1_143) AT=1560.05n

.meas tran vdout1_144ck1550 FIND v(dout1_144) AT=1560.05n

.meas tran vdout1_145ck1550 FIND v(dout1_145) AT=1560.05n

.meas tran vdout1_146ck1550 FIND v(dout1_146) AT=1560.05n

.meas tran vdout1_147ck1550 FIND v(dout1_147) AT=1560.05n

.meas tran vdout1_148ck1550 FIND v(dout1_148) AT=1560.05n

.meas tran vdout1_149ck1550 FIND v(dout1_149) AT=1560.05n

.meas tran vdout1_150ck1550 FIND v(dout1_150) AT=1560.05n

.meas tran vdout1_151ck1550 FIND v(dout1_151) AT=1560.05n

.meas tran vdout1_152ck1550 FIND v(dout1_152) AT=1560.05n

.meas tran vdout1_153ck1550 FIND v(dout1_153) AT=1560.05n

.meas tran vdout1_154ck1550 FIND v(dout1_154) AT=1560.05n

.meas tran vdout1_155ck1550 FIND v(dout1_155) AT=1560.05n

.meas tran vdout1_156ck1550 FIND v(dout1_156) AT=1560.05n

.meas tran vdout1_157ck1550 FIND v(dout1_157) AT=1560.05n

.meas tran vdout1_158ck1550 FIND v(dout1_158) AT=1560.05n

.meas tran vdout1_159ck1550 FIND v(dout1_159) AT=1560.05n

.meas tran vdout1_160ck1550 FIND v(dout1_160) AT=1560.05n

.meas tran vdout1_161ck1550 FIND v(dout1_161) AT=1560.05n

.meas tran vdout1_162ck1550 FIND v(dout1_162) AT=1560.05n

.meas tran vdout1_163ck1550 FIND v(dout1_163) AT=1560.05n

.meas tran vdout1_164ck1550 FIND v(dout1_164) AT=1560.05n

.meas tran vdout1_165ck1550 FIND v(dout1_165) AT=1560.05n

.meas tran vdout1_166ck1550 FIND v(dout1_166) AT=1560.05n

.meas tran vdout1_167ck1550 FIND v(dout1_167) AT=1560.05n

.meas tran vdout1_168ck1550 FIND v(dout1_168) AT=1560.05n

.meas tran vdout1_169ck1550 FIND v(dout1_169) AT=1560.05n

.meas tran vdout1_170ck1550 FIND v(dout1_170) AT=1560.05n

.meas tran vdout1_171ck1550 FIND v(dout1_171) AT=1560.05n

.meas tran vdout1_172ck1550 FIND v(dout1_172) AT=1560.05n

.meas tran vdout1_173ck1550 FIND v(dout1_173) AT=1560.05n

.meas tran vdout1_174ck1550 FIND v(dout1_174) AT=1560.05n

.meas tran vdout1_175ck1550 FIND v(dout1_175) AT=1560.05n

.meas tran vdout1_176ck1550 FIND v(dout1_176) AT=1560.05n

.meas tran vdout1_177ck1550 FIND v(dout1_177) AT=1560.05n

.meas tran vdout1_178ck1550 FIND v(dout1_178) AT=1560.05n

.meas tran vdout1_179ck1550 FIND v(dout1_179) AT=1560.05n

.meas tran vdout1_180ck1550 FIND v(dout1_180) AT=1560.05n

.meas tran vdout1_181ck1550 FIND v(dout1_181) AT=1560.05n

.meas tran vdout1_182ck1550 FIND v(dout1_182) AT=1560.05n

.meas tran vdout1_183ck1550 FIND v(dout1_183) AT=1560.05n

.meas tran vdout1_184ck1550 FIND v(dout1_184) AT=1560.05n

.meas tran vdout1_185ck1550 FIND v(dout1_185) AT=1560.05n

.meas tran vdout1_186ck1550 FIND v(dout1_186) AT=1560.05n

.meas tran vdout1_187ck1550 FIND v(dout1_187) AT=1560.05n

.meas tran vdout1_188ck1550 FIND v(dout1_188) AT=1560.05n

.meas tran vdout1_189ck1550 FIND v(dout1_189) AT=1560.05n

.meas tran vdout1_190ck1550 FIND v(dout1_190) AT=1560.05n

.meas tran vdout1_191ck1550 FIND v(dout1_191) AT=1560.05n

.meas tran vdout1_192ck1550 FIND v(dout1_192) AT=1560.05n

.meas tran vdout1_193ck1550 FIND v(dout1_193) AT=1560.05n

.meas tran vdout1_194ck1550 FIND v(dout1_194) AT=1560.05n

.meas tran vdout1_195ck1550 FIND v(dout1_195) AT=1560.05n

.meas tran vdout1_196ck1550 FIND v(dout1_196) AT=1560.05n

.meas tran vdout1_197ck1550 FIND v(dout1_197) AT=1560.05n

.meas tran vdout1_198ck1550 FIND v(dout1_198) AT=1560.05n

.meas tran vdout1_199ck1550 FIND v(dout1_199) AT=1560.05n

.meas tran vdout1_200ck1550 FIND v(dout1_200) AT=1560.05n

.meas tran vdout1_201ck1550 FIND v(dout1_201) AT=1560.05n

.meas tran vdout1_202ck1550 FIND v(dout1_202) AT=1560.05n

.meas tran vdout1_203ck1550 FIND v(dout1_203) AT=1560.05n

.meas tran vdout1_204ck1550 FIND v(dout1_204) AT=1560.05n

.meas tran vdout1_205ck1550 FIND v(dout1_205) AT=1560.05n

.meas tran vdout1_206ck1550 FIND v(dout1_206) AT=1560.05n

.meas tran vdout1_207ck1550 FIND v(dout1_207) AT=1560.05n

.meas tran vdout1_208ck1550 FIND v(dout1_208) AT=1560.05n

.meas tran vdout1_209ck1550 FIND v(dout1_209) AT=1560.05n

.meas tran vdout1_210ck1550 FIND v(dout1_210) AT=1560.05n

.meas tran vdout1_211ck1550 FIND v(dout1_211) AT=1560.05n

.meas tran vdout1_212ck1550 FIND v(dout1_212) AT=1560.05n

.meas tran vdout1_213ck1550 FIND v(dout1_213) AT=1560.05n

.meas tran vdout1_214ck1550 FIND v(dout1_214) AT=1560.05n

.meas tran vdout1_215ck1550 FIND v(dout1_215) AT=1560.05n

.meas tran vdout1_216ck1550 FIND v(dout1_216) AT=1560.05n

.meas tran vdout1_217ck1550 FIND v(dout1_217) AT=1560.05n

.meas tran vdout1_218ck1550 FIND v(dout1_218) AT=1560.05n

.meas tran vdout1_219ck1550 FIND v(dout1_219) AT=1560.05n

.meas tran vdout1_220ck1550 FIND v(dout1_220) AT=1560.05n

.meas tran vdout1_221ck1550 FIND v(dout1_221) AT=1560.05n

.meas tran vdout1_222ck1550 FIND v(dout1_222) AT=1560.05n

.meas tran vdout1_223ck1550 FIND v(dout1_223) AT=1560.05n

.meas tran vdout1_224ck1550 FIND v(dout1_224) AT=1560.05n

.meas tran vdout1_225ck1550 FIND v(dout1_225) AT=1560.05n

.meas tran vdout1_226ck1550 FIND v(dout1_226) AT=1560.05n

.meas tran vdout1_227ck1550 FIND v(dout1_227) AT=1560.05n

.meas tran vdout1_228ck1550 FIND v(dout1_228) AT=1560.05n

.meas tran vdout1_229ck1550 FIND v(dout1_229) AT=1560.05n

.meas tran vdout1_230ck1550 FIND v(dout1_230) AT=1560.05n

.meas tran vdout1_231ck1550 FIND v(dout1_231) AT=1560.05n

.meas tran vdout1_232ck1550 FIND v(dout1_232) AT=1560.05n

.meas tran vdout1_233ck1550 FIND v(dout1_233) AT=1560.05n

.meas tran vdout1_234ck1550 FIND v(dout1_234) AT=1560.05n

.meas tran vdout1_235ck1550 FIND v(dout1_235) AT=1560.05n

.meas tran vdout1_236ck1550 FIND v(dout1_236) AT=1560.05n

.meas tran vdout1_237ck1550 FIND v(dout1_237) AT=1560.05n

.meas tran vdout1_238ck1550 FIND v(dout1_238) AT=1560.05n

.meas tran vdout1_239ck1550 FIND v(dout1_239) AT=1560.05n

.meas tran vdout1_240ck1550 FIND v(dout1_240) AT=1560.05n

.meas tran vdout1_241ck1550 FIND v(dout1_241) AT=1560.05n

.meas tran vdout1_242ck1550 FIND v(dout1_242) AT=1560.05n

.meas tran vdout1_243ck1550 FIND v(dout1_243) AT=1560.05n

.meas tran vdout1_244ck1550 FIND v(dout1_244) AT=1560.05n

.meas tran vdout1_245ck1550 FIND v(dout1_245) AT=1560.05n

.meas tran vdout1_246ck1550 FIND v(dout1_246) AT=1560.05n

.meas tran vdout1_247ck1550 FIND v(dout1_247) AT=1560.05n

.meas tran vdout1_248ck1550 FIND v(dout1_248) AT=1560.05n

.meas tran vdout1_249ck1550 FIND v(dout1_249) AT=1560.05n

.meas tran vdout1_250ck1550 FIND v(dout1_250) AT=1560.05n

.meas tran vdout1_251ck1550 FIND v(dout1_251) AT=1560.05n

.meas tran vdout1_252ck1550 FIND v(dout1_252) AT=1560.05n

.meas tran vdout1_253ck1550 FIND v(dout1_253) AT=1560.05n

.meas tran vdout1_254ck1550 FIND v(dout1_254) AT=1560.05n

.meas tran vdout1_255ck1550 FIND v(dout1_255) AT=1560.05n

.meas tran vdout1_256ck1550 FIND v(dout1_256) AT=1560.05n

.meas tran vdout1_0ck1560 FIND v(dout1_0) AT=1570.05n

.meas tran vdout1_1ck1560 FIND v(dout1_1) AT=1570.05n

.meas tran vdout1_2ck1560 FIND v(dout1_2) AT=1570.05n

.meas tran vdout1_3ck1560 FIND v(dout1_3) AT=1570.05n

.meas tran vdout1_4ck1560 FIND v(dout1_4) AT=1570.05n

.meas tran vdout1_5ck1560 FIND v(dout1_5) AT=1570.05n

.meas tran vdout1_6ck1560 FIND v(dout1_6) AT=1570.05n

.meas tran vdout1_7ck1560 FIND v(dout1_7) AT=1570.05n

.meas tran vdout1_8ck1560 FIND v(dout1_8) AT=1570.05n

.meas tran vdout1_9ck1560 FIND v(dout1_9) AT=1570.05n

.meas tran vdout1_10ck1560 FIND v(dout1_10) AT=1570.05n

.meas tran vdout1_11ck1560 FIND v(dout1_11) AT=1570.05n

.meas tran vdout1_12ck1560 FIND v(dout1_12) AT=1570.05n

.meas tran vdout1_13ck1560 FIND v(dout1_13) AT=1570.05n

.meas tran vdout1_14ck1560 FIND v(dout1_14) AT=1570.05n

.meas tran vdout1_15ck1560 FIND v(dout1_15) AT=1570.05n

.meas tran vdout1_16ck1560 FIND v(dout1_16) AT=1570.05n

.meas tran vdout1_17ck1560 FIND v(dout1_17) AT=1570.05n

.meas tran vdout1_18ck1560 FIND v(dout1_18) AT=1570.05n

.meas tran vdout1_19ck1560 FIND v(dout1_19) AT=1570.05n

.meas tran vdout1_20ck1560 FIND v(dout1_20) AT=1570.05n

.meas tran vdout1_21ck1560 FIND v(dout1_21) AT=1570.05n

.meas tran vdout1_22ck1560 FIND v(dout1_22) AT=1570.05n

.meas tran vdout1_23ck1560 FIND v(dout1_23) AT=1570.05n

.meas tran vdout1_24ck1560 FIND v(dout1_24) AT=1570.05n

.meas tran vdout1_25ck1560 FIND v(dout1_25) AT=1570.05n

.meas tran vdout1_26ck1560 FIND v(dout1_26) AT=1570.05n

.meas tran vdout1_27ck1560 FIND v(dout1_27) AT=1570.05n

.meas tran vdout1_28ck1560 FIND v(dout1_28) AT=1570.05n

.meas tran vdout1_29ck1560 FIND v(dout1_29) AT=1570.05n

.meas tran vdout1_30ck1560 FIND v(dout1_30) AT=1570.05n

.meas tran vdout1_31ck1560 FIND v(dout1_31) AT=1570.05n

.meas tran vdout1_32ck1560 FIND v(dout1_32) AT=1570.05n

.meas tran vdout1_33ck1560 FIND v(dout1_33) AT=1570.05n

.meas tran vdout1_34ck1560 FIND v(dout1_34) AT=1570.05n

.meas tran vdout1_35ck1560 FIND v(dout1_35) AT=1570.05n

.meas tran vdout1_36ck1560 FIND v(dout1_36) AT=1570.05n

.meas tran vdout1_37ck1560 FIND v(dout1_37) AT=1570.05n

.meas tran vdout1_38ck1560 FIND v(dout1_38) AT=1570.05n

.meas tran vdout1_39ck1560 FIND v(dout1_39) AT=1570.05n

.meas tran vdout1_40ck1560 FIND v(dout1_40) AT=1570.05n

.meas tran vdout1_41ck1560 FIND v(dout1_41) AT=1570.05n

.meas tran vdout1_42ck1560 FIND v(dout1_42) AT=1570.05n

.meas tran vdout1_43ck1560 FIND v(dout1_43) AT=1570.05n

.meas tran vdout1_44ck1560 FIND v(dout1_44) AT=1570.05n

.meas tran vdout1_45ck1560 FIND v(dout1_45) AT=1570.05n

.meas tran vdout1_46ck1560 FIND v(dout1_46) AT=1570.05n

.meas tran vdout1_47ck1560 FIND v(dout1_47) AT=1570.05n

.meas tran vdout1_48ck1560 FIND v(dout1_48) AT=1570.05n

.meas tran vdout1_49ck1560 FIND v(dout1_49) AT=1570.05n

.meas tran vdout1_50ck1560 FIND v(dout1_50) AT=1570.05n

.meas tran vdout1_51ck1560 FIND v(dout1_51) AT=1570.05n

.meas tran vdout1_52ck1560 FIND v(dout1_52) AT=1570.05n

.meas tran vdout1_53ck1560 FIND v(dout1_53) AT=1570.05n

.meas tran vdout1_54ck1560 FIND v(dout1_54) AT=1570.05n

.meas tran vdout1_55ck1560 FIND v(dout1_55) AT=1570.05n

.meas tran vdout1_56ck1560 FIND v(dout1_56) AT=1570.05n

.meas tran vdout1_57ck1560 FIND v(dout1_57) AT=1570.05n

.meas tran vdout1_58ck1560 FIND v(dout1_58) AT=1570.05n

.meas tran vdout1_59ck1560 FIND v(dout1_59) AT=1570.05n

.meas tran vdout1_60ck1560 FIND v(dout1_60) AT=1570.05n

.meas tran vdout1_61ck1560 FIND v(dout1_61) AT=1570.05n

.meas tran vdout1_62ck1560 FIND v(dout1_62) AT=1570.05n

.meas tran vdout1_63ck1560 FIND v(dout1_63) AT=1570.05n

.meas tran vdout1_64ck1560 FIND v(dout1_64) AT=1570.05n

.meas tran vdout1_65ck1560 FIND v(dout1_65) AT=1570.05n

.meas tran vdout1_66ck1560 FIND v(dout1_66) AT=1570.05n

.meas tran vdout1_67ck1560 FIND v(dout1_67) AT=1570.05n

.meas tran vdout1_68ck1560 FIND v(dout1_68) AT=1570.05n

.meas tran vdout1_69ck1560 FIND v(dout1_69) AT=1570.05n

.meas tran vdout1_70ck1560 FIND v(dout1_70) AT=1570.05n

.meas tran vdout1_71ck1560 FIND v(dout1_71) AT=1570.05n

.meas tran vdout1_72ck1560 FIND v(dout1_72) AT=1570.05n

.meas tran vdout1_73ck1560 FIND v(dout1_73) AT=1570.05n

.meas tran vdout1_74ck1560 FIND v(dout1_74) AT=1570.05n

.meas tran vdout1_75ck1560 FIND v(dout1_75) AT=1570.05n

.meas tran vdout1_76ck1560 FIND v(dout1_76) AT=1570.05n

.meas tran vdout1_77ck1560 FIND v(dout1_77) AT=1570.05n

.meas tran vdout1_78ck1560 FIND v(dout1_78) AT=1570.05n

.meas tran vdout1_79ck1560 FIND v(dout1_79) AT=1570.05n

.meas tran vdout1_80ck1560 FIND v(dout1_80) AT=1570.05n

.meas tran vdout1_81ck1560 FIND v(dout1_81) AT=1570.05n

.meas tran vdout1_82ck1560 FIND v(dout1_82) AT=1570.05n

.meas tran vdout1_83ck1560 FIND v(dout1_83) AT=1570.05n

.meas tran vdout1_84ck1560 FIND v(dout1_84) AT=1570.05n

.meas tran vdout1_85ck1560 FIND v(dout1_85) AT=1570.05n

.meas tran vdout1_86ck1560 FIND v(dout1_86) AT=1570.05n

.meas tran vdout1_87ck1560 FIND v(dout1_87) AT=1570.05n

.meas tran vdout1_88ck1560 FIND v(dout1_88) AT=1570.05n

.meas tran vdout1_89ck1560 FIND v(dout1_89) AT=1570.05n

.meas tran vdout1_90ck1560 FIND v(dout1_90) AT=1570.05n

.meas tran vdout1_91ck1560 FIND v(dout1_91) AT=1570.05n

.meas tran vdout1_92ck1560 FIND v(dout1_92) AT=1570.05n

.meas tran vdout1_93ck1560 FIND v(dout1_93) AT=1570.05n

.meas tran vdout1_94ck1560 FIND v(dout1_94) AT=1570.05n

.meas tran vdout1_95ck1560 FIND v(dout1_95) AT=1570.05n

.meas tran vdout1_96ck1560 FIND v(dout1_96) AT=1570.05n

.meas tran vdout1_97ck1560 FIND v(dout1_97) AT=1570.05n

.meas tran vdout1_98ck1560 FIND v(dout1_98) AT=1570.05n

.meas tran vdout1_99ck1560 FIND v(dout1_99) AT=1570.05n

.meas tran vdout1_100ck1560 FIND v(dout1_100) AT=1570.05n

.meas tran vdout1_101ck1560 FIND v(dout1_101) AT=1570.05n

.meas tran vdout1_102ck1560 FIND v(dout1_102) AT=1570.05n

.meas tran vdout1_103ck1560 FIND v(dout1_103) AT=1570.05n

.meas tran vdout1_104ck1560 FIND v(dout1_104) AT=1570.05n

.meas tran vdout1_105ck1560 FIND v(dout1_105) AT=1570.05n

.meas tran vdout1_106ck1560 FIND v(dout1_106) AT=1570.05n

.meas tran vdout1_107ck1560 FIND v(dout1_107) AT=1570.05n

.meas tran vdout1_108ck1560 FIND v(dout1_108) AT=1570.05n

.meas tran vdout1_109ck1560 FIND v(dout1_109) AT=1570.05n

.meas tran vdout1_110ck1560 FIND v(dout1_110) AT=1570.05n

.meas tran vdout1_111ck1560 FIND v(dout1_111) AT=1570.05n

.meas tran vdout1_112ck1560 FIND v(dout1_112) AT=1570.05n

.meas tran vdout1_113ck1560 FIND v(dout1_113) AT=1570.05n

.meas tran vdout1_114ck1560 FIND v(dout1_114) AT=1570.05n

.meas tran vdout1_115ck1560 FIND v(dout1_115) AT=1570.05n

.meas tran vdout1_116ck1560 FIND v(dout1_116) AT=1570.05n

.meas tran vdout1_117ck1560 FIND v(dout1_117) AT=1570.05n

.meas tran vdout1_118ck1560 FIND v(dout1_118) AT=1570.05n

.meas tran vdout1_119ck1560 FIND v(dout1_119) AT=1570.05n

.meas tran vdout1_120ck1560 FIND v(dout1_120) AT=1570.05n

.meas tran vdout1_121ck1560 FIND v(dout1_121) AT=1570.05n

.meas tran vdout1_122ck1560 FIND v(dout1_122) AT=1570.05n

.meas tran vdout1_123ck1560 FIND v(dout1_123) AT=1570.05n

.meas tran vdout1_124ck1560 FIND v(dout1_124) AT=1570.05n

.meas tran vdout1_125ck1560 FIND v(dout1_125) AT=1570.05n

.meas tran vdout1_126ck1560 FIND v(dout1_126) AT=1570.05n

.meas tran vdout1_127ck1560 FIND v(dout1_127) AT=1570.05n

.meas tran vdout1_128ck1560 FIND v(dout1_128) AT=1570.05n

.meas tran vdout1_129ck1560 FIND v(dout1_129) AT=1570.05n

.meas tran vdout1_130ck1560 FIND v(dout1_130) AT=1570.05n

.meas tran vdout1_131ck1560 FIND v(dout1_131) AT=1570.05n

.meas tran vdout1_132ck1560 FIND v(dout1_132) AT=1570.05n

.meas tran vdout1_133ck1560 FIND v(dout1_133) AT=1570.05n

.meas tran vdout1_134ck1560 FIND v(dout1_134) AT=1570.05n

.meas tran vdout1_135ck1560 FIND v(dout1_135) AT=1570.05n

.meas tran vdout1_136ck1560 FIND v(dout1_136) AT=1570.05n

.meas tran vdout1_137ck1560 FIND v(dout1_137) AT=1570.05n

.meas tran vdout1_138ck1560 FIND v(dout1_138) AT=1570.05n

.meas tran vdout1_139ck1560 FIND v(dout1_139) AT=1570.05n

.meas tran vdout1_140ck1560 FIND v(dout1_140) AT=1570.05n

.meas tran vdout1_141ck1560 FIND v(dout1_141) AT=1570.05n

.meas tran vdout1_142ck1560 FIND v(dout1_142) AT=1570.05n

.meas tran vdout1_143ck1560 FIND v(dout1_143) AT=1570.05n

.meas tran vdout1_144ck1560 FIND v(dout1_144) AT=1570.05n

.meas tran vdout1_145ck1560 FIND v(dout1_145) AT=1570.05n

.meas tran vdout1_146ck1560 FIND v(dout1_146) AT=1570.05n

.meas tran vdout1_147ck1560 FIND v(dout1_147) AT=1570.05n

.meas tran vdout1_148ck1560 FIND v(dout1_148) AT=1570.05n

.meas tran vdout1_149ck1560 FIND v(dout1_149) AT=1570.05n

.meas tran vdout1_150ck1560 FIND v(dout1_150) AT=1570.05n

.meas tran vdout1_151ck1560 FIND v(dout1_151) AT=1570.05n

.meas tran vdout1_152ck1560 FIND v(dout1_152) AT=1570.05n

.meas tran vdout1_153ck1560 FIND v(dout1_153) AT=1570.05n

.meas tran vdout1_154ck1560 FIND v(dout1_154) AT=1570.05n

.meas tran vdout1_155ck1560 FIND v(dout1_155) AT=1570.05n

.meas tran vdout1_156ck1560 FIND v(dout1_156) AT=1570.05n

.meas tran vdout1_157ck1560 FIND v(dout1_157) AT=1570.05n

.meas tran vdout1_158ck1560 FIND v(dout1_158) AT=1570.05n

.meas tran vdout1_159ck1560 FIND v(dout1_159) AT=1570.05n

.meas tran vdout1_160ck1560 FIND v(dout1_160) AT=1570.05n

.meas tran vdout1_161ck1560 FIND v(dout1_161) AT=1570.05n

.meas tran vdout1_162ck1560 FIND v(dout1_162) AT=1570.05n

.meas tran vdout1_163ck1560 FIND v(dout1_163) AT=1570.05n

.meas tran vdout1_164ck1560 FIND v(dout1_164) AT=1570.05n

.meas tran vdout1_165ck1560 FIND v(dout1_165) AT=1570.05n

.meas tran vdout1_166ck1560 FIND v(dout1_166) AT=1570.05n

.meas tran vdout1_167ck1560 FIND v(dout1_167) AT=1570.05n

.meas tran vdout1_168ck1560 FIND v(dout1_168) AT=1570.05n

.meas tran vdout1_169ck1560 FIND v(dout1_169) AT=1570.05n

.meas tran vdout1_170ck1560 FIND v(dout1_170) AT=1570.05n

.meas tran vdout1_171ck1560 FIND v(dout1_171) AT=1570.05n

.meas tran vdout1_172ck1560 FIND v(dout1_172) AT=1570.05n

.meas tran vdout1_173ck1560 FIND v(dout1_173) AT=1570.05n

.meas tran vdout1_174ck1560 FIND v(dout1_174) AT=1570.05n

.meas tran vdout1_175ck1560 FIND v(dout1_175) AT=1570.05n

.meas tran vdout1_176ck1560 FIND v(dout1_176) AT=1570.05n

.meas tran vdout1_177ck1560 FIND v(dout1_177) AT=1570.05n

.meas tran vdout1_178ck1560 FIND v(dout1_178) AT=1570.05n

.meas tran vdout1_179ck1560 FIND v(dout1_179) AT=1570.05n

.meas tran vdout1_180ck1560 FIND v(dout1_180) AT=1570.05n

.meas tran vdout1_181ck1560 FIND v(dout1_181) AT=1570.05n

.meas tran vdout1_182ck1560 FIND v(dout1_182) AT=1570.05n

.meas tran vdout1_183ck1560 FIND v(dout1_183) AT=1570.05n

.meas tran vdout1_184ck1560 FIND v(dout1_184) AT=1570.05n

.meas tran vdout1_185ck1560 FIND v(dout1_185) AT=1570.05n

.meas tran vdout1_186ck1560 FIND v(dout1_186) AT=1570.05n

.meas tran vdout1_187ck1560 FIND v(dout1_187) AT=1570.05n

.meas tran vdout1_188ck1560 FIND v(dout1_188) AT=1570.05n

.meas tran vdout1_189ck1560 FIND v(dout1_189) AT=1570.05n

.meas tran vdout1_190ck1560 FIND v(dout1_190) AT=1570.05n

.meas tran vdout1_191ck1560 FIND v(dout1_191) AT=1570.05n

.meas tran vdout1_192ck1560 FIND v(dout1_192) AT=1570.05n

.meas tran vdout1_193ck1560 FIND v(dout1_193) AT=1570.05n

.meas tran vdout1_194ck1560 FIND v(dout1_194) AT=1570.05n

.meas tran vdout1_195ck1560 FIND v(dout1_195) AT=1570.05n

.meas tran vdout1_196ck1560 FIND v(dout1_196) AT=1570.05n

.meas tran vdout1_197ck1560 FIND v(dout1_197) AT=1570.05n

.meas tran vdout1_198ck1560 FIND v(dout1_198) AT=1570.05n

.meas tran vdout1_199ck1560 FIND v(dout1_199) AT=1570.05n

.meas tran vdout1_200ck1560 FIND v(dout1_200) AT=1570.05n

.meas tran vdout1_201ck1560 FIND v(dout1_201) AT=1570.05n

.meas tran vdout1_202ck1560 FIND v(dout1_202) AT=1570.05n

.meas tran vdout1_203ck1560 FIND v(dout1_203) AT=1570.05n

.meas tran vdout1_204ck1560 FIND v(dout1_204) AT=1570.05n

.meas tran vdout1_205ck1560 FIND v(dout1_205) AT=1570.05n

.meas tran vdout1_206ck1560 FIND v(dout1_206) AT=1570.05n

.meas tran vdout1_207ck1560 FIND v(dout1_207) AT=1570.05n

.meas tran vdout1_208ck1560 FIND v(dout1_208) AT=1570.05n

.meas tran vdout1_209ck1560 FIND v(dout1_209) AT=1570.05n

.meas tran vdout1_210ck1560 FIND v(dout1_210) AT=1570.05n

.meas tran vdout1_211ck1560 FIND v(dout1_211) AT=1570.05n

.meas tran vdout1_212ck1560 FIND v(dout1_212) AT=1570.05n

.meas tran vdout1_213ck1560 FIND v(dout1_213) AT=1570.05n

.meas tran vdout1_214ck1560 FIND v(dout1_214) AT=1570.05n

.meas tran vdout1_215ck1560 FIND v(dout1_215) AT=1570.05n

.meas tran vdout1_216ck1560 FIND v(dout1_216) AT=1570.05n

.meas tran vdout1_217ck1560 FIND v(dout1_217) AT=1570.05n

.meas tran vdout1_218ck1560 FIND v(dout1_218) AT=1570.05n

.meas tran vdout1_219ck1560 FIND v(dout1_219) AT=1570.05n

.meas tran vdout1_220ck1560 FIND v(dout1_220) AT=1570.05n

.meas tran vdout1_221ck1560 FIND v(dout1_221) AT=1570.05n

.meas tran vdout1_222ck1560 FIND v(dout1_222) AT=1570.05n

.meas tran vdout1_223ck1560 FIND v(dout1_223) AT=1570.05n

.meas tran vdout1_224ck1560 FIND v(dout1_224) AT=1570.05n

.meas tran vdout1_225ck1560 FIND v(dout1_225) AT=1570.05n

.meas tran vdout1_226ck1560 FIND v(dout1_226) AT=1570.05n

.meas tran vdout1_227ck1560 FIND v(dout1_227) AT=1570.05n

.meas tran vdout1_228ck1560 FIND v(dout1_228) AT=1570.05n

.meas tran vdout1_229ck1560 FIND v(dout1_229) AT=1570.05n

.meas tran vdout1_230ck1560 FIND v(dout1_230) AT=1570.05n

.meas tran vdout1_231ck1560 FIND v(dout1_231) AT=1570.05n

.meas tran vdout1_232ck1560 FIND v(dout1_232) AT=1570.05n

.meas tran vdout1_233ck1560 FIND v(dout1_233) AT=1570.05n

.meas tran vdout1_234ck1560 FIND v(dout1_234) AT=1570.05n

.meas tran vdout1_235ck1560 FIND v(dout1_235) AT=1570.05n

.meas tran vdout1_236ck1560 FIND v(dout1_236) AT=1570.05n

.meas tran vdout1_237ck1560 FIND v(dout1_237) AT=1570.05n

.meas tran vdout1_238ck1560 FIND v(dout1_238) AT=1570.05n

.meas tran vdout1_239ck1560 FIND v(dout1_239) AT=1570.05n

.meas tran vdout1_240ck1560 FIND v(dout1_240) AT=1570.05n

.meas tran vdout1_241ck1560 FIND v(dout1_241) AT=1570.05n

.meas tran vdout1_242ck1560 FIND v(dout1_242) AT=1570.05n

.meas tran vdout1_243ck1560 FIND v(dout1_243) AT=1570.05n

.meas tran vdout1_244ck1560 FIND v(dout1_244) AT=1570.05n

.meas tran vdout1_245ck1560 FIND v(dout1_245) AT=1570.05n

.meas tran vdout1_246ck1560 FIND v(dout1_246) AT=1570.05n

.meas tran vdout1_247ck1560 FIND v(dout1_247) AT=1570.05n

.meas tran vdout1_248ck1560 FIND v(dout1_248) AT=1570.05n

.meas tran vdout1_249ck1560 FIND v(dout1_249) AT=1570.05n

.meas tran vdout1_250ck1560 FIND v(dout1_250) AT=1570.05n

.meas tran vdout1_251ck1560 FIND v(dout1_251) AT=1570.05n

.meas tran vdout1_252ck1560 FIND v(dout1_252) AT=1570.05n

.meas tran vdout1_253ck1560 FIND v(dout1_253) AT=1570.05n

.meas tran vdout1_254ck1560 FIND v(dout1_254) AT=1570.05n

.meas tran vdout1_255ck1560 FIND v(dout1_255) AT=1570.05n

.meas tran vdout1_256ck1560 FIND v(dout1_256) AT=1570.05n

.meas tran vdout1_0ck1580 FIND v(dout1_0) AT=1590.05n

.meas tran vdout1_1ck1580 FIND v(dout1_1) AT=1590.05n

.meas tran vdout1_2ck1580 FIND v(dout1_2) AT=1590.05n

.meas tran vdout1_3ck1580 FIND v(dout1_3) AT=1590.05n

.meas tran vdout1_4ck1580 FIND v(dout1_4) AT=1590.05n

.meas tran vdout1_5ck1580 FIND v(dout1_5) AT=1590.05n

.meas tran vdout1_6ck1580 FIND v(dout1_6) AT=1590.05n

.meas tran vdout1_7ck1580 FIND v(dout1_7) AT=1590.05n

.meas tran vdout1_8ck1580 FIND v(dout1_8) AT=1590.05n

.meas tran vdout1_9ck1580 FIND v(dout1_9) AT=1590.05n

.meas tran vdout1_10ck1580 FIND v(dout1_10) AT=1590.05n

.meas tran vdout1_11ck1580 FIND v(dout1_11) AT=1590.05n

.meas tran vdout1_12ck1580 FIND v(dout1_12) AT=1590.05n

.meas tran vdout1_13ck1580 FIND v(dout1_13) AT=1590.05n

.meas tran vdout1_14ck1580 FIND v(dout1_14) AT=1590.05n

.meas tran vdout1_15ck1580 FIND v(dout1_15) AT=1590.05n

.meas tran vdout1_16ck1580 FIND v(dout1_16) AT=1590.05n

.meas tran vdout1_17ck1580 FIND v(dout1_17) AT=1590.05n

.meas tran vdout1_18ck1580 FIND v(dout1_18) AT=1590.05n

.meas tran vdout1_19ck1580 FIND v(dout1_19) AT=1590.05n

.meas tran vdout1_20ck1580 FIND v(dout1_20) AT=1590.05n

.meas tran vdout1_21ck1580 FIND v(dout1_21) AT=1590.05n

.meas tran vdout1_22ck1580 FIND v(dout1_22) AT=1590.05n

.meas tran vdout1_23ck1580 FIND v(dout1_23) AT=1590.05n

.meas tran vdout1_24ck1580 FIND v(dout1_24) AT=1590.05n

.meas tran vdout1_25ck1580 FIND v(dout1_25) AT=1590.05n

.meas tran vdout1_26ck1580 FIND v(dout1_26) AT=1590.05n

.meas tran vdout1_27ck1580 FIND v(dout1_27) AT=1590.05n

.meas tran vdout1_28ck1580 FIND v(dout1_28) AT=1590.05n

.meas tran vdout1_29ck1580 FIND v(dout1_29) AT=1590.05n

.meas tran vdout1_30ck1580 FIND v(dout1_30) AT=1590.05n

.meas tran vdout1_31ck1580 FIND v(dout1_31) AT=1590.05n

.meas tran vdout1_32ck1580 FIND v(dout1_32) AT=1590.05n

.meas tran vdout1_33ck1580 FIND v(dout1_33) AT=1590.05n

.meas tran vdout1_34ck1580 FIND v(dout1_34) AT=1590.05n

.meas tran vdout1_35ck1580 FIND v(dout1_35) AT=1590.05n

.meas tran vdout1_36ck1580 FIND v(dout1_36) AT=1590.05n

.meas tran vdout1_37ck1580 FIND v(dout1_37) AT=1590.05n

.meas tran vdout1_38ck1580 FIND v(dout1_38) AT=1590.05n

.meas tran vdout1_39ck1580 FIND v(dout1_39) AT=1590.05n

.meas tran vdout1_40ck1580 FIND v(dout1_40) AT=1590.05n

.meas tran vdout1_41ck1580 FIND v(dout1_41) AT=1590.05n

.meas tran vdout1_42ck1580 FIND v(dout1_42) AT=1590.05n

.meas tran vdout1_43ck1580 FIND v(dout1_43) AT=1590.05n

.meas tran vdout1_44ck1580 FIND v(dout1_44) AT=1590.05n

.meas tran vdout1_45ck1580 FIND v(dout1_45) AT=1590.05n

.meas tran vdout1_46ck1580 FIND v(dout1_46) AT=1590.05n

.meas tran vdout1_47ck1580 FIND v(dout1_47) AT=1590.05n

.meas tran vdout1_48ck1580 FIND v(dout1_48) AT=1590.05n

.meas tran vdout1_49ck1580 FIND v(dout1_49) AT=1590.05n

.meas tran vdout1_50ck1580 FIND v(dout1_50) AT=1590.05n

.meas tran vdout1_51ck1580 FIND v(dout1_51) AT=1590.05n

.meas tran vdout1_52ck1580 FIND v(dout1_52) AT=1590.05n

.meas tran vdout1_53ck1580 FIND v(dout1_53) AT=1590.05n

.meas tran vdout1_54ck1580 FIND v(dout1_54) AT=1590.05n

.meas tran vdout1_55ck1580 FIND v(dout1_55) AT=1590.05n

.meas tran vdout1_56ck1580 FIND v(dout1_56) AT=1590.05n

.meas tran vdout1_57ck1580 FIND v(dout1_57) AT=1590.05n

.meas tran vdout1_58ck1580 FIND v(dout1_58) AT=1590.05n

.meas tran vdout1_59ck1580 FIND v(dout1_59) AT=1590.05n

.meas tran vdout1_60ck1580 FIND v(dout1_60) AT=1590.05n

.meas tran vdout1_61ck1580 FIND v(dout1_61) AT=1590.05n

.meas tran vdout1_62ck1580 FIND v(dout1_62) AT=1590.05n

.meas tran vdout1_63ck1580 FIND v(dout1_63) AT=1590.05n

.meas tran vdout1_64ck1580 FIND v(dout1_64) AT=1590.05n

.meas tran vdout1_65ck1580 FIND v(dout1_65) AT=1590.05n

.meas tran vdout1_66ck1580 FIND v(dout1_66) AT=1590.05n

.meas tran vdout1_67ck1580 FIND v(dout1_67) AT=1590.05n

.meas tran vdout1_68ck1580 FIND v(dout1_68) AT=1590.05n

.meas tran vdout1_69ck1580 FIND v(dout1_69) AT=1590.05n

.meas tran vdout1_70ck1580 FIND v(dout1_70) AT=1590.05n

.meas tran vdout1_71ck1580 FIND v(dout1_71) AT=1590.05n

.meas tran vdout1_72ck1580 FIND v(dout1_72) AT=1590.05n

.meas tran vdout1_73ck1580 FIND v(dout1_73) AT=1590.05n

.meas tran vdout1_74ck1580 FIND v(dout1_74) AT=1590.05n

.meas tran vdout1_75ck1580 FIND v(dout1_75) AT=1590.05n

.meas tran vdout1_76ck1580 FIND v(dout1_76) AT=1590.05n

.meas tran vdout1_77ck1580 FIND v(dout1_77) AT=1590.05n

.meas tran vdout1_78ck1580 FIND v(dout1_78) AT=1590.05n

.meas tran vdout1_79ck1580 FIND v(dout1_79) AT=1590.05n

.meas tran vdout1_80ck1580 FIND v(dout1_80) AT=1590.05n

.meas tran vdout1_81ck1580 FIND v(dout1_81) AT=1590.05n

.meas tran vdout1_82ck1580 FIND v(dout1_82) AT=1590.05n

.meas tran vdout1_83ck1580 FIND v(dout1_83) AT=1590.05n

.meas tran vdout1_84ck1580 FIND v(dout1_84) AT=1590.05n

.meas tran vdout1_85ck1580 FIND v(dout1_85) AT=1590.05n

.meas tran vdout1_86ck1580 FIND v(dout1_86) AT=1590.05n

.meas tran vdout1_87ck1580 FIND v(dout1_87) AT=1590.05n

.meas tran vdout1_88ck1580 FIND v(dout1_88) AT=1590.05n

.meas tran vdout1_89ck1580 FIND v(dout1_89) AT=1590.05n

.meas tran vdout1_90ck1580 FIND v(dout1_90) AT=1590.05n

.meas tran vdout1_91ck1580 FIND v(dout1_91) AT=1590.05n

.meas tran vdout1_92ck1580 FIND v(dout1_92) AT=1590.05n

.meas tran vdout1_93ck1580 FIND v(dout1_93) AT=1590.05n

.meas tran vdout1_94ck1580 FIND v(dout1_94) AT=1590.05n

.meas tran vdout1_95ck1580 FIND v(dout1_95) AT=1590.05n

.meas tran vdout1_96ck1580 FIND v(dout1_96) AT=1590.05n

.meas tran vdout1_97ck1580 FIND v(dout1_97) AT=1590.05n

.meas tran vdout1_98ck1580 FIND v(dout1_98) AT=1590.05n

.meas tran vdout1_99ck1580 FIND v(dout1_99) AT=1590.05n

.meas tran vdout1_100ck1580 FIND v(dout1_100) AT=1590.05n

.meas tran vdout1_101ck1580 FIND v(dout1_101) AT=1590.05n

.meas tran vdout1_102ck1580 FIND v(dout1_102) AT=1590.05n

.meas tran vdout1_103ck1580 FIND v(dout1_103) AT=1590.05n

.meas tran vdout1_104ck1580 FIND v(dout1_104) AT=1590.05n

.meas tran vdout1_105ck1580 FIND v(dout1_105) AT=1590.05n

.meas tran vdout1_106ck1580 FIND v(dout1_106) AT=1590.05n

.meas tran vdout1_107ck1580 FIND v(dout1_107) AT=1590.05n

.meas tran vdout1_108ck1580 FIND v(dout1_108) AT=1590.05n

.meas tran vdout1_109ck1580 FIND v(dout1_109) AT=1590.05n

.meas tran vdout1_110ck1580 FIND v(dout1_110) AT=1590.05n

.meas tran vdout1_111ck1580 FIND v(dout1_111) AT=1590.05n

.meas tran vdout1_112ck1580 FIND v(dout1_112) AT=1590.05n

.meas tran vdout1_113ck1580 FIND v(dout1_113) AT=1590.05n

.meas tran vdout1_114ck1580 FIND v(dout1_114) AT=1590.05n

.meas tran vdout1_115ck1580 FIND v(dout1_115) AT=1590.05n

.meas tran vdout1_116ck1580 FIND v(dout1_116) AT=1590.05n

.meas tran vdout1_117ck1580 FIND v(dout1_117) AT=1590.05n

.meas tran vdout1_118ck1580 FIND v(dout1_118) AT=1590.05n

.meas tran vdout1_119ck1580 FIND v(dout1_119) AT=1590.05n

.meas tran vdout1_120ck1580 FIND v(dout1_120) AT=1590.05n

.meas tran vdout1_121ck1580 FIND v(dout1_121) AT=1590.05n

.meas tran vdout1_122ck1580 FIND v(dout1_122) AT=1590.05n

.meas tran vdout1_123ck1580 FIND v(dout1_123) AT=1590.05n

.meas tran vdout1_124ck1580 FIND v(dout1_124) AT=1590.05n

.meas tran vdout1_125ck1580 FIND v(dout1_125) AT=1590.05n

.meas tran vdout1_126ck1580 FIND v(dout1_126) AT=1590.05n

.meas tran vdout1_127ck1580 FIND v(dout1_127) AT=1590.05n

.meas tran vdout1_128ck1580 FIND v(dout1_128) AT=1590.05n

.meas tran vdout1_129ck1580 FIND v(dout1_129) AT=1590.05n

.meas tran vdout1_130ck1580 FIND v(dout1_130) AT=1590.05n

.meas tran vdout1_131ck1580 FIND v(dout1_131) AT=1590.05n

.meas tran vdout1_132ck1580 FIND v(dout1_132) AT=1590.05n

.meas tran vdout1_133ck1580 FIND v(dout1_133) AT=1590.05n

.meas tran vdout1_134ck1580 FIND v(dout1_134) AT=1590.05n

.meas tran vdout1_135ck1580 FIND v(dout1_135) AT=1590.05n

.meas tran vdout1_136ck1580 FIND v(dout1_136) AT=1590.05n

.meas tran vdout1_137ck1580 FIND v(dout1_137) AT=1590.05n

.meas tran vdout1_138ck1580 FIND v(dout1_138) AT=1590.05n

.meas tran vdout1_139ck1580 FIND v(dout1_139) AT=1590.05n

.meas tran vdout1_140ck1580 FIND v(dout1_140) AT=1590.05n

.meas tran vdout1_141ck1580 FIND v(dout1_141) AT=1590.05n

.meas tran vdout1_142ck1580 FIND v(dout1_142) AT=1590.05n

.meas tran vdout1_143ck1580 FIND v(dout1_143) AT=1590.05n

.meas tran vdout1_144ck1580 FIND v(dout1_144) AT=1590.05n

.meas tran vdout1_145ck1580 FIND v(dout1_145) AT=1590.05n

.meas tran vdout1_146ck1580 FIND v(dout1_146) AT=1590.05n

.meas tran vdout1_147ck1580 FIND v(dout1_147) AT=1590.05n

.meas tran vdout1_148ck1580 FIND v(dout1_148) AT=1590.05n

.meas tran vdout1_149ck1580 FIND v(dout1_149) AT=1590.05n

.meas tran vdout1_150ck1580 FIND v(dout1_150) AT=1590.05n

.meas tran vdout1_151ck1580 FIND v(dout1_151) AT=1590.05n

.meas tran vdout1_152ck1580 FIND v(dout1_152) AT=1590.05n

.meas tran vdout1_153ck1580 FIND v(dout1_153) AT=1590.05n

.meas tran vdout1_154ck1580 FIND v(dout1_154) AT=1590.05n

.meas tran vdout1_155ck1580 FIND v(dout1_155) AT=1590.05n

.meas tran vdout1_156ck1580 FIND v(dout1_156) AT=1590.05n

.meas tran vdout1_157ck1580 FIND v(dout1_157) AT=1590.05n

.meas tran vdout1_158ck1580 FIND v(dout1_158) AT=1590.05n

.meas tran vdout1_159ck1580 FIND v(dout1_159) AT=1590.05n

.meas tran vdout1_160ck1580 FIND v(dout1_160) AT=1590.05n

.meas tran vdout1_161ck1580 FIND v(dout1_161) AT=1590.05n

.meas tran vdout1_162ck1580 FIND v(dout1_162) AT=1590.05n

.meas tran vdout1_163ck1580 FIND v(dout1_163) AT=1590.05n

.meas tran vdout1_164ck1580 FIND v(dout1_164) AT=1590.05n

.meas tran vdout1_165ck1580 FIND v(dout1_165) AT=1590.05n

.meas tran vdout1_166ck1580 FIND v(dout1_166) AT=1590.05n

.meas tran vdout1_167ck1580 FIND v(dout1_167) AT=1590.05n

.meas tran vdout1_168ck1580 FIND v(dout1_168) AT=1590.05n

.meas tran vdout1_169ck1580 FIND v(dout1_169) AT=1590.05n

.meas tran vdout1_170ck1580 FIND v(dout1_170) AT=1590.05n

.meas tran vdout1_171ck1580 FIND v(dout1_171) AT=1590.05n

.meas tran vdout1_172ck1580 FIND v(dout1_172) AT=1590.05n

.meas tran vdout1_173ck1580 FIND v(dout1_173) AT=1590.05n

.meas tran vdout1_174ck1580 FIND v(dout1_174) AT=1590.05n

.meas tran vdout1_175ck1580 FIND v(dout1_175) AT=1590.05n

.meas tran vdout1_176ck1580 FIND v(dout1_176) AT=1590.05n

.meas tran vdout1_177ck1580 FIND v(dout1_177) AT=1590.05n

.meas tran vdout1_178ck1580 FIND v(dout1_178) AT=1590.05n

.meas tran vdout1_179ck1580 FIND v(dout1_179) AT=1590.05n

.meas tran vdout1_180ck1580 FIND v(dout1_180) AT=1590.05n

.meas tran vdout1_181ck1580 FIND v(dout1_181) AT=1590.05n

.meas tran vdout1_182ck1580 FIND v(dout1_182) AT=1590.05n

.meas tran vdout1_183ck1580 FIND v(dout1_183) AT=1590.05n

.meas tran vdout1_184ck1580 FIND v(dout1_184) AT=1590.05n

.meas tran vdout1_185ck1580 FIND v(dout1_185) AT=1590.05n

.meas tran vdout1_186ck1580 FIND v(dout1_186) AT=1590.05n

.meas tran vdout1_187ck1580 FIND v(dout1_187) AT=1590.05n

.meas tran vdout1_188ck1580 FIND v(dout1_188) AT=1590.05n

.meas tran vdout1_189ck1580 FIND v(dout1_189) AT=1590.05n

.meas tran vdout1_190ck1580 FIND v(dout1_190) AT=1590.05n

.meas tran vdout1_191ck1580 FIND v(dout1_191) AT=1590.05n

.meas tran vdout1_192ck1580 FIND v(dout1_192) AT=1590.05n

.meas tran vdout1_193ck1580 FIND v(dout1_193) AT=1590.05n

.meas tran vdout1_194ck1580 FIND v(dout1_194) AT=1590.05n

.meas tran vdout1_195ck1580 FIND v(dout1_195) AT=1590.05n

.meas tran vdout1_196ck1580 FIND v(dout1_196) AT=1590.05n

.meas tran vdout1_197ck1580 FIND v(dout1_197) AT=1590.05n

.meas tran vdout1_198ck1580 FIND v(dout1_198) AT=1590.05n

.meas tran vdout1_199ck1580 FIND v(dout1_199) AT=1590.05n

.meas tran vdout1_200ck1580 FIND v(dout1_200) AT=1590.05n

.meas tran vdout1_201ck1580 FIND v(dout1_201) AT=1590.05n

.meas tran vdout1_202ck1580 FIND v(dout1_202) AT=1590.05n

.meas tran vdout1_203ck1580 FIND v(dout1_203) AT=1590.05n

.meas tran vdout1_204ck1580 FIND v(dout1_204) AT=1590.05n

.meas tran vdout1_205ck1580 FIND v(dout1_205) AT=1590.05n

.meas tran vdout1_206ck1580 FIND v(dout1_206) AT=1590.05n

.meas tran vdout1_207ck1580 FIND v(dout1_207) AT=1590.05n

.meas tran vdout1_208ck1580 FIND v(dout1_208) AT=1590.05n

.meas tran vdout1_209ck1580 FIND v(dout1_209) AT=1590.05n

.meas tran vdout1_210ck1580 FIND v(dout1_210) AT=1590.05n

.meas tran vdout1_211ck1580 FIND v(dout1_211) AT=1590.05n

.meas tran vdout1_212ck1580 FIND v(dout1_212) AT=1590.05n

.meas tran vdout1_213ck1580 FIND v(dout1_213) AT=1590.05n

.meas tran vdout1_214ck1580 FIND v(dout1_214) AT=1590.05n

.meas tran vdout1_215ck1580 FIND v(dout1_215) AT=1590.05n

.meas tran vdout1_216ck1580 FIND v(dout1_216) AT=1590.05n

.meas tran vdout1_217ck1580 FIND v(dout1_217) AT=1590.05n

.meas tran vdout1_218ck1580 FIND v(dout1_218) AT=1590.05n

.meas tran vdout1_219ck1580 FIND v(dout1_219) AT=1590.05n

.meas tran vdout1_220ck1580 FIND v(dout1_220) AT=1590.05n

.meas tran vdout1_221ck1580 FIND v(dout1_221) AT=1590.05n

.meas tran vdout1_222ck1580 FIND v(dout1_222) AT=1590.05n

.meas tran vdout1_223ck1580 FIND v(dout1_223) AT=1590.05n

.meas tran vdout1_224ck1580 FIND v(dout1_224) AT=1590.05n

.meas tran vdout1_225ck1580 FIND v(dout1_225) AT=1590.05n

.meas tran vdout1_226ck1580 FIND v(dout1_226) AT=1590.05n

.meas tran vdout1_227ck1580 FIND v(dout1_227) AT=1590.05n

.meas tran vdout1_228ck1580 FIND v(dout1_228) AT=1590.05n

.meas tran vdout1_229ck1580 FIND v(dout1_229) AT=1590.05n

.meas tran vdout1_230ck1580 FIND v(dout1_230) AT=1590.05n

.meas tran vdout1_231ck1580 FIND v(dout1_231) AT=1590.05n

.meas tran vdout1_232ck1580 FIND v(dout1_232) AT=1590.05n

.meas tran vdout1_233ck1580 FIND v(dout1_233) AT=1590.05n

.meas tran vdout1_234ck1580 FIND v(dout1_234) AT=1590.05n

.meas tran vdout1_235ck1580 FIND v(dout1_235) AT=1590.05n

.meas tran vdout1_236ck1580 FIND v(dout1_236) AT=1590.05n

.meas tran vdout1_237ck1580 FIND v(dout1_237) AT=1590.05n

.meas tran vdout1_238ck1580 FIND v(dout1_238) AT=1590.05n

.meas tran vdout1_239ck1580 FIND v(dout1_239) AT=1590.05n

.meas tran vdout1_240ck1580 FIND v(dout1_240) AT=1590.05n

.meas tran vdout1_241ck1580 FIND v(dout1_241) AT=1590.05n

.meas tran vdout1_242ck1580 FIND v(dout1_242) AT=1590.05n

.meas tran vdout1_243ck1580 FIND v(dout1_243) AT=1590.05n

.meas tran vdout1_244ck1580 FIND v(dout1_244) AT=1590.05n

.meas tran vdout1_245ck1580 FIND v(dout1_245) AT=1590.05n

.meas tran vdout1_246ck1580 FIND v(dout1_246) AT=1590.05n

.meas tran vdout1_247ck1580 FIND v(dout1_247) AT=1590.05n

.meas tran vdout1_248ck1580 FIND v(dout1_248) AT=1590.05n

.meas tran vdout1_249ck1580 FIND v(dout1_249) AT=1590.05n

.meas tran vdout1_250ck1580 FIND v(dout1_250) AT=1590.05n

.meas tran vdout1_251ck1580 FIND v(dout1_251) AT=1590.05n

.meas tran vdout1_252ck1580 FIND v(dout1_252) AT=1590.05n

.meas tran vdout1_253ck1580 FIND v(dout1_253) AT=1590.05n

.meas tran vdout1_254ck1580 FIND v(dout1_254) AT=1590.05n

.meas tran vdout1_255ck1580 FIND v(dout1_255) AT=1590.05n

.meas tran vdout1_256ck1580 FIND v(dout1_256) AT=1590.05n

.meas tran vdout1_0ck1640 FIND v(dout1_0) AT=1650.05n

.meas tran vdout1_1ck1640 FIND v(dout1_1) AT=1650.05n

.meas tran vdout1_2ck1640 FIND v(dout1_2) AT=1650.05n

.meas tran vdout1_3ck1640 FIND v(dout1_3) AT=1650.05n

.meas tran vdout1_4ck1640 FIND v(dout1_4) AT=1650.05n

.meas tran vdout1_5ck1640 FIND v(dout1_5) AT=1650.05n

.meas tran vdout1_6ck1640 FIND v(dout1_6) AT=1650.05n

.meas tran vdout1_7ck1640 FIND v(dout1_7) AT=1650.05n

.meas tran vdout1_8ck1640 FIND v(dout1_8) AT=1650.05n

.meas tran vdout1_9ck1640 FIND v(dout1_9) AT=1650.05n

.meas tran vdout1_10ck1640 FIND v(dout1_10) AT=1650.05n

.meas tran vdout1_11ck1640 FIND v(dout1_11) AT=1650.05n

.meas tran vdout1_12ck1640 FIND v(dout1_12) AT=1650.05n

.meas tran vdout1_13ck1640 FIND v(dout1_13) AT=1650.05n

.meas tran vdout1_14ck1640 FIND v(dout1_14) AT=1650.05n

.meas tran vdout1_15ck1640 FIND v(dout1_15) AT=1650.05n

.meas tran vdout1_16ck1640 FIND v(dout1_16) AT=1650.05n

.meas tran vdout1_17ck1640 FIND v(dout1_17) AT=1650.05n

.meas tran vdout1_18ck1640 FIND v(dout1_18) AT=1650.05n

.meas tran vdout1_19ck1640 FIND v(dout1_19) AT=1650.05n

.meas tran vdout1_20ck1640 FIND v(dout1_20) AT=1650.05n

.meas tran vdout1_21ck1640 FIND v(dout1_21) AT=1650.05n

.meas tran vdout1_22ck1640 FIND v(dout1_22) AT=1650.05n

.meas tran vdout1_23ck1640 FIND v(dout1_23) AT=1650.05n

.meas tran vdout1_24ck1640 FIND v(dout1_24) AT=1650.05n

.meas tran vdout1_25ck1640 FIND v(dout1_25) AT=1650.05n

.meas tran vdout1_26ck1640 FIND v(dout1_26) AT=1650.05n

.meas tran vdout1_27ck1640 FIND v(dout1_27) AT=1650.05n

.meas tran vdout1_28ck1640 FIND v(dout1_28) AT=1650.05n

.meas tran vdout1_29ck1640 FIND v(dout1_29) AT=1650.05n

.meas tran vdout1_30ck1640 FIND v(dout1_30) AT=1650.05n

.meas tran vdout1_31ck1640 FIND v(dout1_31) AT=1650.05n

.meas tran vdout1_32ck1640 FIND v(dout1_32) AT=1650.05n

.meas tran vdout1_33ck1640 FIND v(dout1_33) AT=1650.05n

.meas tran vdout1_34ck1640 FIND v(dout1_34) AT=1650.05n

.meas tran vdout1_35ck1640 FIND v(dout1_35) AT=1650.05n

.meas tran vdout1_36ck1640 FIND v(dout1_36) AT=1650.05n

.meas tran vdout1_37ck1640 FIND v(dout1_37) AT=1650.05n

.meas tran vdout1_38ck1640 FIND v(dout1_38) AT=1650.05n

.meas tran vdout1_39ck1640 FIND v(dout1_39) AT=1650.05n

.meas tran vdout1_40ck1640 FIND v(dout1_40) AT=1650.05n

.meas tran vdout1_41ck1640 FIND v(dout1_41) AT=1650.05n

.meas tran vdout1_42ck1640 FIND v(dout1_42) AT=1650.05n

.meas tran vdout1_43ck1640 FIND v(dout1_43) AT=1650.05n

.meas tran vdout1_44ck1640 FIND v(dout1_44) AT=1650.05n

.meas tran vdout1_45ck1640 FIND v(dout1_45) AT=1650.05n

.meas tran vdout1_46ck1640 FIND v(dout1_46) AT=1650.05n

.meas tran vdout1_47ck1640 FIND v(dout1_47) AT=1650.05n

.meas tran vdout1_48ck1640 FIND v(dout1_48) AT=1650.05n

.meas tran vdout1_49ck1640 FIND v(dout1_49) AT=1650.05n

.meas tran vdout1_50ck1640 FIND v(dout1_50) AT=1650.05n

.meas tran vdout1_51ck1640 FIND v(dout1_51) AT=1650.05n

.meas tran vdout1_52ck1640 FIND v(dout1_52) AT=1650.05n

.meas tran vdout1_53ck1640 FIND v(dout1_53) AT=1650.05n

.meas tran vdout1_54ck1640 FIND v(dout1_54) AT=1650.05n

.meas tran vdout1_55ck1640 FIND v(dout1_55) AT=1650.05n

.meas tran vdout1_56ck1640 FIND v(dout1_56) AT=1650.05n

.meas tran vdout1_57ck1640 FIND v(dout1_57) AT=1650.05n

.meas tran vdout1_58ck1640 FIND v(dout1_58) AT=1650.05n

.meas tran vdout1_59ck1640 FIND v(dout1_59) AT=1650.05n

.meas tran vdout1_60ck1640 FIND v(dout1_60) AT=1650.05n

.meas tran vdout1_61ck1640 FIND v(dout1_61) AT=1650.05n

.meas tran vdout1_62ck1640 FIND v(dout1_62) AT=1650.05n

.meas tran vdout1_63ck1640 FIND v(dout1_63) AT=1650.05n

.meas tran vdout1_64ck1640 FIND v(dout1_64) AT=1650.05n

.meas tran vdout1_65ck1640 FIND v(dout1_65) AT=1650.05n

.meas tran vdout1_66ck1640 FIND v(dout1_66) AT=1650.05n

.meas tran vdout1_67ck1640 FIND v(dout1_67) AT=1650.05n

.meas tran vdout1_68ck1640 FIND v(dout1_68) AT=1650.05n

.meas tran vdout1_69ck1640 FIND v(dout1_69) AT=1650.05n

.meas tran vdout1_70ck1640 FIND v(dout1_70) AT=1650.05n

.meas tran vdout1_71ck1640 FIND v(dout1_71) AT=1650.05n

.meas tran vdout1_72ck1640 FIND v(dout1_72) AT=1650.05n

.meas tran vdout1_73ck1640 FIND v(dout1_73) AT=1650.05n

.meas tran vdout1_74ck1640 FIND v(dout1_74) AT=1650.05n

.meas tran vdout1_75ck1640 FIND v(dout1_75) AT=1650.05n

.meas tran vdout1_76ck1640 FIND v(dout1_76) AT=1650.05n

.meas tran vdout1_77ck1640 FIND v(dout1_77) AT=1650.05n

.meas tran vdout1_78ck1640 FIND v(dout1_78) AT=1650.05n

.meas tran vdout1_79ck1640 FIND v(dout1_79) AT=1650.05n

.meas tran vdout1_80ck1640 FIND v(dout1_80) AT=1650.05n

.meas tran vdout1_81ck1640 FIND v(dout1_81) AT=1650.05n

.meas tran vdout1_82ck1640 FIND v(dout1_82) AT=1650.05n

.meas tran vdout1_83ck1640 FIND v(dout1_83) AT=1650.05n

.meas tran vdout1_84ck1640 FIND v(dout1_84) AT=1650.05n

.meas tran vdout1_85ck1640 FIND v(dout1_85) AT=1650.05n

.meas tran vdout1_86ck1640 FIND v(dout1_86) AT=1650.05n

.meas tran vdout1_87ck1640 FIND v(dout1_87) AT=1650.05n

.meas tran vdout1_88ck1640 FIND v(dout1_88) AT=1650.05n

.meas tran vdout1_89ck1640 FIND v(dout1_89) AT=1650.05n

.meas tran vdout1_90ck1640 FIND v(dout1_90) AT=1650.05n

.meas tran vdout1_91ck1640 FIND v(dout1_91) AT=1650.05n

.meas tran vdout1_92ck1640 FIND v(dout1_92) AT=1650.05n

.meas tran vdout1_93ck1640 FIND v(dout1_93) AT=1650.05n

.meas tran vdout1_94ck1640 FIND v(dout1_94) AT=1650.05n

.meas tran vdout1_95ck1640 FIND v(dout1_95) AT=1650.05n

.meas tran vdout1_96ck1640 FIND v(dout1_96) AT=1650.05n

.meas tran vdout1_97ck1640 FIND v(dout1_97) AT=1650.05n

.meas tran vdout1_98ck1640 FIND v(dout1_98) AT=1650.05n

.meas tran vdout1_99ck1640 FIND v(dout1_99) AT=1650.05n

.meas tran vdout1_100ck1640 FIND v(dout1_100) AT=1650.05n

.meas tran vdout1_101ck1640 FIND v(dout1_101) AT=1650.05n

.meas tran vdout1_102ck1640 FIND v(dout1_102) AT=1650.05n

.meas tran vdout1_103ck1640 FIND v(dout1_103) AT=1650.05n

.meas tran vdout1_104ck1640 FIND v(dout1_104) AT=1650.05n

.meas tran vdout1_105ck1640 FIND v(dout1_105) AT=1650.05n

.meas tran vdout1_106ck1640 FIND v(dout1_106) AT=1650.05n

.meas tran vdout1_107ck1640 FIND v(dout1_107) AT=1650.05n

.meas tran vdout1_108ck1640 FIND v(dout1_108) AT=1650.05n

.meas tran vdout1_109ck1640 FIND v(dout1_109) AT=1650.05n

.meas tran vdout1_110ck1640 FIND v(dout1_110) AT=1650.05n

.meas tran vdout1_111ck1640 FIND v(dout1_111) AT=1650.05n

.meas tran vdout1_112ck1640 FIND v(dout1_112) AT=1650.05n

.meas tran vdout1_113ck1640 FIND v(dout1_113) AT=1650.05n

.meas tran vdout1_114ck1640 FIND v(dout1_114) AT=1650.05n

.meas tran vdout1_115ck1640 FIND v(dout1_115) AT=1650.05n

.meas tran vdout1_116ck1640 FIND v(dout1_116) AT=1650.05n

.meas tran vdout1_117ck1640 FIND v(dout1_117) AT=1650.05n

.meas tran vdout1_118ck1640 FIND v(dout1_118) AT=1650.05n

.meas tran vdout1_119ck1640 FIND v(dout1_119) AT=1650.05n

.meas tran vdout1_120ck1640 FIND v(dout1_120) AT=1650.05n

.meas tran vdout1_121ck1640 FIND v(dout1_121) AT=1650.05n

.meas tran vdout1_122ck1640 FIND v(dout1_122) AT=1650.05n

.meas tran vdout1_123ck1640 FIND v(dout1_123) AT=1650.05n

.meas tran vdout1_124ck1640 FIND v(dout1_124) AT=1650.05n

.meas tran vdout1_125ck1640 FIND v(dout1_125) AT=1650.05n

.meas tran vdout1_126ck1640 FIND v(dout1_126) AT=1650.05n

.meas tran vdout1_127ck1640 FIND v(dout1_127) AT=1650.05n

.meas tran vdout1_128ck1640 FIND v(dout1_128) AT=1650.05n

.meas tran vdout1_129ck1640 FIND v(dout1_129) AT=1650.05n

.meas tran vdout1_130ck1640 FIND v(dout1_130) AT=1650.05n

.meas tran vdout1_131ck1640 FIND v(dout1_131) AT=1650.05n

.meas tran vdout1_132ck1640 FIND v(dout1_132) AT=1650.05n

.meas tran vdout1_133ck1640 FIND v(dout1_133) AT=1650.05n

.meas tran vdout1_134ck1640 FIND v(dout1_134) AT=1650.05n

.meas tran vdout1_135ck1640 FIND v(dout1_135) AT=1650.05n

.meas tran vdout1_136ck1640 FIND v(dout1_136) AT=1650.05n

.meas tran vdout1_137ck1640 FIND v(dout1_137) AT=1650.05n

.meas tran vdout1_138ck1640 FIND v(dout1_138) AT=1650.05n

.meas tran vdout1_139ck1640 FIND v(dout1_139) AT=1650.05n

.meas tran vdout1_140ck1640 FIND v(dout1_140) AT=1650.05n

.meas tran vdout1_141ck1640 FIND v(dout1_141) AT=1650.05n

.meas tran vdout1_142ck1640 FIND v(dout1_142) AT=1650.05n

.meas tran vdout1_143ck1640 FIND v(dout1_143) AT=1650.05n

.meas tran vdout1_144ck1640 FIND v(dout1_144) AT=1650.05n

.meas tran vdout1_145ck1640 FIND v(dout1_145) AT=1650.05n

.meas tran vdout1_146ck1640 FIND v(dout1_146) AT=1650.05n

.meas tran vdout1_147ck1640 FIND v(dout1_147) AT=1650.05n

.meas tran vdout1_148ck1640 FIND v(dout1_148) AT=1650.05n

.meas tran vdout1_149ck1640 FIND v(dout1_149) AT=1650.05n

.meas tran vdout1_150ck1640 FIND v(dout1_150) AT=1650.05n

.meas tran vdout1_151ck1640 FIND v(dout1_151) AT=1650.05n

.meas tran vdout1_152ck1640 FIND v(dout1_152) AT=1650.05n

.meas tran vdout1_153ck1640 FIND v(dout1_153) AT=1650.05n

.meas tran vdout1_154ck1640 FIND v(dout1_154) AT=1650.05n

.meas tran vdout1_155ck1640 FIND v(dout1_155) AT=1650.05n

.meas tran vdout1_156ck1640 FIND v(dout1_156) AT=1650.05n

.meas tran vdout1_157ck1640 FIND v(dout1_157) AT=1650.05n

.meas tran vdout1_158ck1640 FIND v(dout1_158) AT=1650.05n

.meas tran vdout1_159ck1640 FIND v(dout1_159) AT=1650.05n

.meas tran vdout1_160ck1640 FIND v(dout1_160) AT=1650.05n

.meas tran vdout1_161ck1640 FIND v(dout1_161) AT=1650.05n

.meas tran vdout1_162ck1640 FIND v(dout1_162) AT=1650.05n

.meas tran vdout1_163ck1640 FIND v(dout1_163) AT=1650.05n

.meas tran vdout1_164ck1640 FIND v(dout1_164) AT=1650.05n

.meas tran vdout1_165ck1640 FIND v(dout1_165) AT=1650.05n

.meas tran vdout1_166ck1640 FIND v(dout1_166) AT=1650.05n

.meas tran vdout1_167ck1640 FIND v(dout1_167) AT=1650.05n

.meas tran vdout1_168ck1640 FIND v(dout1_168) AT=1650.05n

.meas tran vdout1_169ck1640 FIND v(dout1_169) AT=1650.05n

.meas tran vdout1_170ck1640 FIND v(dout1_170) AT=1650.05n

.meas tran vdout1_171ck1640 FIND v(dout1_171) AT=1650.05n

.meas tran vdout1_172ck1640 FIND v(dout1_172) AT=1650.05n

.meas tran vdout1_173ck1640 FIND v(dout1_173) AT=1650.05n

.meas tran vdout1_174ck1640 FIND v(dout1_174) AT=1650.05n

.meas tran vdout1_175ck1640 FIND v(dout1_175) AT=1650.05n

.meas tran vdout1_176ck1640 FIND v(dout1_176) AT=1650.05n

.meas tran vdout1_177ck1640 FIND v(dout1_177) AT=1650.05n

.meas tran vdout1_178ck1640 FIND v(dout1_178) AT=1650.05n

.meas tran vdout1_179ck1640 FIND v(dout1_179) AT=1650.05n

.meas tran vdout1_180ck1640 FIND v(dout1_180) AT=1650.05n

.meas tran vdout1_181ck1640 FIND v(dout1_181) AT=1650.05n

.meas tran vdout1_182ck1640 FIND v(dout1_182) AT=1650.05n

.meas tran vdout1_183ck1640 FIND v(dout1_183) AT=1650.05n

.meas tran vdout1_184ck1640 FIND v(dout1_184) AT=1650.05n

.meas tran vdout1_185ck1640 FIND v(dout1_185) AT=1650.05n

.meas tran vdout1_186ck1640 FIND v(dout1_186) AT=1650.05n

.meas tran vdout1_187ck1640 FIND v(dout1_187) AT=1650.05n

.meas tran vdout1_188ck1640 FIND v(dout1_188) AT=1650.05n

.meas tran vdout1_189ck1640 FIND v(dout1_189) AT=1650.05n

.meas tran vdout1_190ck1640 FIND v(dout1_190) AT=1650.05n

.meas tran vdout1_191ck1640 FIND v(dout1_191) AT=1650.05n

.meas tran vdout1_192ck1640 FIND v(dout1_192) AT=1650.05n

.meas tran vdout1_193ck1640 FIND v(dout1_193) AT=1650.05n

.meas tran vdout1_194ck1640 FIND v(dout1_194) AT=1650.05n

.meas tran vdout1_195ck1640 FIND v(dout1_195) AT=1650.05n

.meas tran vdout1_196ck1640 FIND v(dout1_196) AT=1650.05n

.meas tran vdout1_197ck1640 FIND v(dout1_197) AT=1650.05n

.meas tran vdout1_198ck1640 FIND v(dout1_198) AT=1650.05n

.meas tran vdout1_199ck1640 FIND v(dout1_199) AT=1650.05n

.meas tran vdout1_200ck1640 FIND v(dout1_200) AT=1650.05n

.meas tran vdout1_201ck1640 FIND v(dout1_201) AT=1650.05n

.meas tran vdout1_202ck1640 FIND v(dout1_202) AT=1650.05n

.meas tran vdout1_203ck1640 FIND v(dout1_203) AT=1650.05n

.meas tran vdout1_204ck1640 FIND v(dout1_204) AT=1650.05n

.meas tran vdout1_205ck1640 FIND v(dout1_205) AT=1650.05n

.meas tran vdout1_206ck1640 FIND v(dout1_206) AT=1650.05n

.meas tran vdout1_207ck1640 FIND v(dout1_207) AT=1650.05n

.meas tran vdout1_208ck1640 FIND v(dout1_208) AT=1650.05n

.meas tran vdout1_209ck1640 FIND v(dout1_209) AT=1650.05n

.meas tran vdout1_210ck1640 FIND v(dout1_210) AT=1650.05n

.meas tran vdout1_211ck1640 FIND v(dout1_211) AT=1650.05n

.meas tran vdout1_212ck1640 FIND v(dout1_212) AT=1650.05n

.meas tran vdout1_213ck1640 FIND v(dout1_213) AT=1650.05n

.meas tran vdout1_214ck1640 FIND v(dout1_214) AT=1650.05n

.meas tran vdout1_215ck1640 FIND v(dout1_215) AT=1650.05n

.meas tran vdout1_216ck1640 FIND v(dout1_216) AT=1650.05n

.meas tran vdout1_217ck1640 FIND v(dout1_217) AT=1650.05n

.meas tran vdout1_218ck1640 FIND v(dout1_218) AT=1650.05n

.meas tran vdout1_219ck1640 FIND v(dout1_219) AT=1650.05n

.meas tran vdout1_220ck1640 FIND v(dout1_220) AT=1650.05n

.meas tran vdout1_221ck1640 FIND v(dout1_221) AT=1650.05n

.meas tran vdout1_222ck1640 FIND v(dout1_222) AT=1650.05n

.meas tran vdout1_223ck1640 FIND v(dout1_223) AT=1650.05n

.meas tran vdout1_224ck1640 FIND v(dout1_224) AT=1650.05n

.meas tran vdout1_225ck1640 FIND v(dout1_225) AT=1650.05n

.meas tran vdout1_226ck1640 FIND v(dout1_226) AT=1650.05n

.meas tran vdout1_227ck1640 FIND v(dout1_227) AT=1650.05n

.meas tran vdout1_228ck1640 FIND v(dout1_228) AT=1650.05n

.meas tran vdout1_229ck1640 FIND v(dout1_229) AT=1650.05n

.meas tran vdout1_230ck1640 FIND v(dout1_230) AT=1650.05n

.meas tran vdout1_231ck1640 FIND v(dout1_231) AT=1650.05n

.meas tran vdout1_232ck1640 FIND v(dout1_232) AT=1650.05n

.meas tran vdout1_233ck1640 FIND v(dout1_233) AT=1650.05n

.meas tran vdout1_234ck1640 FIND v(dout1_234) AT=1650.05n

.meas tran vdout1_235ck1640 FIND v(dout1_235) AT=1650.05n

.meas tran vdout1_236ck1640 FIND v(dout1_236) AT=1650.05n

.meas tran vdout1_237ck1640 FIND v(dout1_237) AT=1650.05n

.meas tran vdout1_238ck1640 FIND v(dout1_238) AT=1650.05n

.meas tran vdout1_239ck1640 FIND v(dout1_239) AT=1650.05n

.meas tran vdout1_240ck1640 FIND v(dout1_240) AT=1650.05n

.meas tran vdout1_241ck1640 FIND v(dout1_241) AT=1650.05n

.meas tran vdout1_242ck1640 FIND v(dout1_242) AT=1650.05n

.meas tran vdout1_243ck1640 FIND v(dout1_243) AT=1650.05n

.meas tran vdout1_244ck1640 FIND v(dout1_244) AT=1650.05n

.meas tran vdout1_245ck1640 FIND v(dout1_245) AT=1650.05n

.meas tran vdout1_246ck1640 FIND v(dout1_246) AT=1650.05n

.meas tran vdout1_247ck1640 FIND v(dout1_247) AT=1650.05n

.meas tran vdout1_248ck1640 FIND v(dout1_248) AT=1650.05n

.meas tran vdout1_249ck1640 FIND v(dout1_249) AT=1650.05n

.meas tran vdout1_250ck1640 FIND v(dout1_250) AT=1650.05n

.meas tran vdout1_251ck1640 FIND v(dout1_251) AT=1650.05n

.meas tran vdout1_252ck1640 FIND v(dout1_252) AT=1650.05n

.meas tran vdout1_253ck1640 FIND v(dout1_253) AT=1650.05n

.meas tran vdout1_254ck1640 FIND v(dout1_254) AT=1650.05n

.meas tran vdout1_255ck1640 FIND v(dout1_255) AT=1650.05n

.meas tran vdout1_256ck1640 FIND v(dout1_256) AT=1650.05n

.meas tran vdout1_0ck1650 FIND v(dout1_0) AT=1660.05n

.meas tran vdout1_1ck1650 FIND v(dout1_1) AT=1660.05n

.meas tran vdout1_2ck1650 FIND v(dout1_2) AT=1660.05n

.meas tran vdout1_3ck1650 FIND v(dout1_3) AT=1660.05n

.meas tran vdout1_4ck1650 FIND v(dout1_4) AT=1660.05n

.meas tran vdout1_5ck1650 FIND v(dout1_5) AT=1660.05n

.meas tran vdout1_6ck1650 FIND v(dout1_6) AT=1660.05n

.meas tran vdout1_7ck1650 FIND v(dout1_7) AT=1660.05n

.meas tran vdout1_8ck1650 FIND v(dout1_8) AT=1660.05n

.meas tran vdout1_9ck1650 FIND v(dout1_9) AT=1660.05n

.meas tran vdout1_10ck1650 FIND v(dout1_10) AT=1660.05n

.meas tran vdout1_11ck1650 FIND v(dout1_11) AT=1660.05n

.meas tran vdout1_12ck1650 FIND v(dout1_12) AT=1660.05n

.meas tran vdout1_13ck1650 FIND v(dout1_13) AT=1660.05n

.meas tran vdout1_14ck1650 FIND v(dout1_14) AT=1660.05n

.meas tran vdout1_15ck1650 FIND v(dout1_15) AT=1660.05n

.meas tran vdout1_16ck1650 FIND v(dout1_16) AT=1660.05n

.meas tran vdout1_17ck1650 FIND v(dout1_17) AT=1660.05n

.meas tran vdout1_18ck1650 FIND v(dout1_18) AT=1660.05n

.meas tran vdout1_19ck1650 FIND v(dout1_19) AT=1660.05n

.meas tran vdout1_20ck1650 FIND v(dout1_20) AT=1660.05n

.meas tran vdout1_21ck1650 FIND v(dout1_21) AT=1660.05n

.meas tran vdout1_22ck1650 FIND v(dout1_22) AT=1660.05n

.meas tran vdout1_23ck1650 FIND v(dout1_23) AT=1660.05n

.meas tran vdout1_24ck1650 FIND v(dout1_24) AT=1660.05n

.meas tran vdout1_25ck1650 FIND v(dout1_25) AT=1660.05n

.meas tran vdout1_26ck1650 FIND v(dout1_26) AT=1660.05n

.meas tran vdout1_27ck1650 FIND v(dout1_27) AT=1660.05n

.meas tran vdout1_28ck1650 FIND v(dout1_28) AT=1660.05n

.meas tran vdout1_29ck1650 FIND v(dout1_29) AT=1660.05n

.meas tran vdout1_30ck1650 FIND v(dout1_30) AT=1660.05n

.meas tran vdout1_31ck1650 FIND v(dout1_31) AT=1660.05n

.meas tran vdout1_32ck1650 FIND v(dout1_32) AT=1660.05n

.meas tran vdout1_33ck1650 FIND v(dout1_33) AT=1660.05n

.meas tran vdout1_34ck1650 FIND v(dout1_34) AT=1660.05n

.meas tran vdout1_35ck1650 FIND v(dout1_35) AT=1660.05n

.meas tran vdout1_36ck1650 FIND v(dout1_36) AT=1660.05n

.meas tran vdout1_37ck1650 FIND v(dout1_37) AT=1660.05n

.meas tran vdout1_38ck1650 FIND v(dout1_38) AT=1660.05n

.meas tran vdout1_39ck1650 FIND v(dout1_39) AT=1660.05n

.meas tran vdout1_40ck1650 FIND v(dout1_40) AT=1660.05n

.meas tran vdout1_41ck1650 FIND v(dout1_41) AT=1660.05n

.meas tran vdout1_42ck1650 FIND v(dout1_42) AT=1660.05n

.meas tran vdout1_43ck1650 FIND v(dout1_43) AT=1660.05n

.meas tran vdout1_44ck1650 FIND v(dout1_44) AT=1660.05n

.meas tran vdout1_45ck1650 FIND v(dout1_45) AT=1660.05n

.meas tran vdout1_46ck1650 FIND v(dout1_46) AT=1660.05n

.meas tran vdout1_47ck1650 FIND v(dout1_47) AT=1660.05n

.meas tran vdout1_48ck1650 FIND v(dout1_48) AT=1660.05n

.meas tran vdout1_49ck1650 FIND v(dout1_49) AT=1660.05n

.meas tran vdout1_50ck1650 FIND v(dout1_50) AT=1660.05n

.meas tran vdout1_51ck1650 FIND v(dout1_51) AT=1660.05n

.meas tran vdout1_52ck1650 FIND v(dout1_52) AT=1660.05n

.meas tran vdout1_53ck1650 FIND v(dout1_53) AT=1660.05n

.meas tran vdout1_54ck1650 FIND v(dout1_54) AT=1660.05n

.meas tran vdout1_55ck1650 FIND v(dout1_55) AT=1660.05n

.meas tran vdout1_56ck1650 FIND v(dout1_56) AT=1660.05n

.meas tran vdout1_57ck1650 FIND v(dout1_57) AT=1660.05n

.meas tran vdout1_58ck1650 FIND v(dout1_58) AT=1660.05n

.meas tran vdout1_59ck1650 FIND v(dout1_59) AT=1660.05n

.meas tran vdout1_60ck1650 FIND v(dout1_60) AT=1660.05n

.meas tran vdout1_61ck1650 FIND v(dout1_61) AT=1660.05n

.meas tran vdout1_62ck1650 FIND v(dout1_62) AT=1660.05n

.meas tran vdout1_63ck1650 FIND v(dout1_63) AT=1660.05n

.meas tran vdout1_64ck1650 FIND v(dout1_64) AT=1660.05n

.meas tran vdout1_65ck1650 FIND v(dout1_65) AT=1660.05n

.meas tran vdout1_66ck1650 FIND v(dout1_66) AT=1660.05n

.meas tran vdout1_67ck1650 FIND v(dout1_67) AT=1660.05n

.meas tran vdout1_68ck1650 FIND v(dout1_68) AT=1660.05n

.meas tran vdout1_69ck1650 FIND v(dout1_69) AT=1660.05n

.meas tran vdout1_70ck1650 FIND v(dout1_70) AT=1660.05n

.meas tran vdout1_71ck1650 FIND v(dout1_71) AT=1660.05n

.meas tran vdout1_72ck1650 FIND v(dout1_72) AT=1660.05n

.meas tran vdout1_73ck1650 FIND v(dout1_73) AT=1660.05n

.meas tran vdout1_74ck1650 FIND v(dout1_74) AT=1660.05n

.meas tran vdout1_75ck1650 FIND v(dout1_75) AT=1660.05n

.meas tran vdout1_76ck1650 FIND v(dout1_76) AT=1660.05n

.meas tran vdout1_77ck1650 FIND v(dout1_77) AT=1660.05n

.meas tran vdout1_78ck1650 FIND v(dout1_78) AT=1660.05n

.meas tran vdout1_79ck1650 FIND v(dout1_79) AT=1660.05n

.meas tran vdout1_80ck1650 FIND v(dout1_80) AT=1660.05n

.meas tran vdout1_81ck1650 FIND v(dout1_81) AT=1660.05n

.meas tran vdout1_82ck1650 FIND v(dout1_82) AT=1660.05n

.meas tran vdout1_83ck1650 FIND v(dout1_83) AT=1660.05n

.meas tran vdout1_84ck1650 FIND v(dout1_84) AT=1660.05n

.meas tran vdout1_85ck1650 FIND v(dout1_85) AT=1660.05n

.meas tran vdout1_86ck1650 FIND v(dout1_86) AT=1660.05n

.meas tran vdout1_87ck1650 FIND v(dout1_87) AT=1660.05n

.meas tran vdout1_88ck1650 FIND v(dout1_88) AT=1660.05n

.meas tran vdout1_89ck1650 FIND v(dout1_89) AT=1660.05n

.meas tran vdout1_90ck1650 FIND v(dout1_90) AT=1660.05n

.meas tran vdout1_91ck1650 FIND v(dout1_91) AT=1660.05n

.meas tran vdout1_92ck1650 FIND v(dout1_92) AT=1660.05n

.meas tran vdout1_93ck1650 FIND v(dout1_93) AT=1660.05n

.meas tran vdout1_94ck1650 FIND v(dout1_94) AT=1660.05n

.meas tran vdout1_95ck1650 FIND v(dout1_95) AT=1660.05n

.meas tran vdout1_96ck1650 FIND v(dout1_96) AT=1660.05n

.meas tran vdout1_97ck1650 FIND v(dout1_97) AT=1660.05n

.meas tran vdout1_98ck1650 FIND v(dout1_98) AT=1660.05n

.meas tran vdout1_99ck1650 FIND v(dout1_99) AT=1660.05n

.meas tran vdout1_100ck1650 FIND v(dout1_100) AT=1660.05n

.meas tran vdout1_101ck1650 FIND v(dout1_101) AT=1660.05n

.meas tran vdout1_102ck1650 FIND v(dout1_102) AT=1660.05n

.meas tran vdout1_103ck1650 FIND v(dout1_103) AT=1660.05n

.meas tran vdout1_104ck1650 FIND v(dout1_104) AT=1660.05n

.meas tran vdout1_105ck1650 FIND v(dout1_105) AT=1660.05n

.meas tran vdout1_106ck1650 FIND v(dout1_106) AT=1660.05n

.meas tran vdout1_107ck1650 FIND v(dout1_107) AT=1660.05n

.meas tran vdout1_108ck1650 FIND v(dout1_108) AT=1660.05n

.meas tran vdout1_109ck1650 FIND v(dout1_109) AT=1660.05n

.meas tran vdout1_110ck1650 FIND v(dout1_110) AT=1660.05n

.meas tran vdout1_111ck1650 FIND v(dout1_111) AT=1660.05n

.meas tran vdout1_112ck1650 FIND v(dout1_112) AT=1660.05n

.meas tran vdout1_113ck1650 FIND v(dout1_113) AT=1660.05n

.meas tran vdout1_114ck1650 FIND v(dout1_114) AT=1660.05n

.meas tran vdout1_115ck1650 FIND v(dout1_115) AT=1660.05n

.meas tran vdout1_116ck1650 FIND v(dout1_116) AT=1660.05n

.meas tran vdout1_117ck1650 FIND v(dout1_117) AT=1660.05n

.meas tran vdout1_118ck1650 FIND v(dout1_118) AT=1660.05n

.meas tran vdout1_119ck1650 FIND v(dout1_119) AT=1660.05n

.meas tran vdout1_120ck1650 FIND v(dout1_120) AT=1660.05n

.meas tran vdout1_121ck1650 FIND v(dout1_121) AT=1660.05n

.meas tran vdout1_122ck1650 FIND v(dout1_122) AT=1660.05n

.meas tran vdout1_123ck1650 FIND v(dout1_123) AT=1660.05n

.meas tran vdout1_124ck1650 FIND v(dout1_124) AT=1660.05n

.meas tran vdout1_125ck1650 FIND v(dout1_125) AT=1660.05n

.meas tran vdout1_126ck1650 FIND v(dout1_126) AT=1660.05n

.meas tran vdout1_127ck1650 FIND v(dout1_127) AT=1660.05n

.meas tran vdout1_128ck1650 FIND v(dout1_128) AT=1660.05n

.meas tran vdout1_129ck1650 FIND v(dout1_129) AT=1660.05n

.meas tran vdout1_130ck1650 FIND v(dout1_130) AT=1660.05n

.meas tran vdout1_131ck1650 FIND v(dout1_131) AT=1660.05n

.meas tran vdout1_132ck1650 FIND v(dout1_132) AT=1660.05n

.meas tran vdout1_133ck1650 FIND v(dout1_133) AT=1660.05n

.meas tran vdout1_134ck1650 FIND v(dout1_134) AT=1660.05n

.meas tran vdout1_135ck1650 FIND v(dout1_135) AT=1660.05n

.meas tran vdout1_136ck1650 FIND v(dout1_136) AT=1660.05n

.meas tran vdout1_137ck1650 FIND v(dout1_137) AT=1660.05n

.meas tran vdout1_138ck1650 FIND v(dout1_138) AT=1660.05n

.meas tran vdout1_139ck1650 FIND v(dout1_139) AT=1660.05n

.meas tran vdout1_140ck1650 FIND v(dout1_140) AT=1660.05n

.meas tran vdout1_141ck1650 FIND v(dout1_141) AT=1660.05n

.meas tran vdout1_142ck1650 FIND v(dout1_142) AT=1660.05n

.meas tran vdout1_143ck1650 FIND v(dout1_143) AT=1660.05n

.meas tran vdout1_144ck1650 FIND v(dout1_144) AT=1660.05n

.meas tran vdout1_145ck1650 FIND v(dout1_145) AT=1660.05n

.meas tran vdout1_146ck1650 FIND v(dout1_146) AT=1660.05n

.meas tran vdout1_147ck1650 FIND v(dout1_147) AT=1660.05n

.meas tran vdout1_148ck1650 FIND v(dout1_148) AT=1660.05n

.meas tran vdout1_149ck1650 FIND v(dout1_149) AT=1660.05n

.meas tran vdout1_150ck1650 FIND v(dout1_150) AT=1660.05n

.meas tran vdout1_151ck1650 FIND v(dout1_151) AT=1660.05n

.meas tran vdout1_152ck1650 FIND v(dout1_152) AT=1660.05n

.meas tran vdout1_153ck1650 FIND v(dout1_153) AT=1660.05n

.meas tran vdout1_154ck1650 FIND v(dout1_154) AT=1660.05n

.meas tran vdout1_155ck1650 FIND v(dout1_155) AT=1660.05n

.meas tran vdout1_156ck1650 FIND v(dout1_156) AT=1660.05n

.meas tran vdout1_157ck1650 FIND v(dout1_157) AT=1660.05n

.meas tran vdout1_158ck1650 FIND v(dout1_158) AT=1660.05n

.meas tran vdout1_159ck1650 FIND v(dout1_159) AT=1660.05n

.meas tran vdout1_160ck1650 FIND v(dout1_160) AT=1660.05n

.meas tran vdout1_161ck1650 FIND v(dout1_161) AT=1660.05n

.meas tran vdout1_162ck1650 FIND v(dout1_162) AT=1660.05n

.meas tran vdout1_163ck1650 FIND v(dout1_163) AT=1660.05n

.meas tran vdout1_164ck1650 FIND v(dout1_164) AT=1660.05n

.meas tran vdout1_165ck1650 FIND v(dout1_165) AT=1660.05n

.meas tran vdout1_166ck1650 FIND v(dout1_166) AT=1660.05n

.meas tran vdout1_167ck1650 FIND v(dout1_167) AT=1660.05n

.meas tran vdout1_168ck1650 FIND v(dout1_168) AT=1660.05n

.meas tran vdout1_169ck1650 FIND v(dout1_169) AT=1660.05n

.meas tran vdout1_170ck1650 FIND v(dout1_170) AT=1660.05n

.meas tran vdout1_171ck1650 FIND v(dout1_171) AT=1660.05n

.meas tran vdout1_172ck1650 FIND v(dout1_172) AT=1660.05n

.meas tran vdout1_173ck1650 FIND v(dout1_173) AT=1660.05n

.meas tran vdout1_174ck1650 FIND v(dout1_174) AT=1660.05n

.meas tran vdout1_175ck1650 FIND v(dout1_175) AT=1660.05n

.meas tran vdout1_176ck1650 FIND v(dout1_176) AT=1660.05n

.meas tran vdout1_177ck1650 FIND v(dout1_177) AT=1660.05n

.meas tran vdout1_178ck1650 FIND v(dout1_178) AT=1660.05n

.meas tran vdout1_179ck1650 FIND v(dout1_179) AT=1660.05n

.meas tran vdout1_180ck1650 FIND v(dout1_180) AT=1660.05n

.meas tran vdout1_181ck1650 FIND v(dout1_181) AT=1660.05n

.meas tran vdout1_182ck1650 FIND v(dout1_182) AT=1660.05n

.meas tran vdout1_183ck1650 FIND v(dout1_183) AT=1660.05n

.meas tran vdout1_184ck1650 FIND v(dout1_184) AT=1660.05n

.meas tran vdout1_185ck1650 FIND v(dout1_185) AT=1660.05n

.meas tran vdout1_186ck1650 FIND v(dout1_186) AT=1660.05n

.meas tran vdout1_187ck1650 FIND v(dout1_187) AT=1660.05n

.meas tran vdout1_188ck1650 FIND v(dout1_188) AT=1660.05n

.meas tran vdout1_189ck1650 FIND v(dout1_189) AT=1660.05n

.meas tran vdout1_190ck1650 FIND v(dout1_190) AT=1660.05n

.meas tran vdout1_191ck1650 FIND v(dout1_191) AT=1660.05n

.meas tran vdout1_192ck1650 FIND v(dout1_192) AT=1660.05n

.meas tran vdout1_193ck1650 FIND v(dout1_193) AT=1660.05n

.meas tran vdout1_194ck1650 FIND v(dout1_194) AT=1660.05n

.meas tran vdout1_195ck1650 FIND v(dout1_195) AT=1660.05n

.meas tran vdout1_196ck1650 FIND v(dout1_196) AT=1660.05n

.meas tran vdout1_197ck1650 FIND v(dout1_197) AT=1660.05n

.meas tran vdout1_198ck1650 FIND v(dout1_198) AT=1660.05n

.meas tran vdout1_199ck1650 FIND v(dout1_199) AT=1660.05n

.meas tran vdout1_200ck1650 FIND v(dout1_200) AT=1660.05n

.meas tran vdout1_201ck1650 FIND v(dout1_201) AT=1660.05n

.meas tran vdout1_202ck1650 FIND v(dout1_202) AT=1660.05n

.meas tran vdout1_203ck1650 FIND v(dout1_203) AT=1660.05n

.meas tran vdout1_204ck1650 FIND v(dout1_204) AT=1660.05n

.meas tran vdout1_205ck1650 FIND v(dout1_205) AT=1660.05n

.meas tran vdout1_206ck1650 FIND v(dout1_206) AT=1660.05n

.meas tran vdout1_207ck1650 FIND v(dout1_207) AT=1660.05n

.meas tran vdout1_208ck1650 FIND v(dout1_208) AT=1660.05n

.meas tran vdout1_209ck1650 FIND v(dout1_209) AT=1660.05n

.meas tran vdout1_210ck1650 FIND v(dout1_210) AT=1660.05n

.meas tran vdout1_211ck1650 FIND v(dout1_211) AT=1660.05n

.meas tran vdout1_212ck1650 FIND v(dout1_212) AT=1660.05n

.meas tran vdout1_213ck1650 FIND v(dout1_213) AT=1660.05n

.meas tran vdout1_214ck1650 FIND v(dout1_214) AT=1660.05n

.meas tran vdout1_215ck1650 FIND v(dout1_215) AT=1660.05n

.meas tran vdout1_216ck1650 FIND v(dout1_216) AT=1660.05n

.meas tran vdout1_217ck1650 FIND v(dout1_217) AT=1660.05n

.meas tran vdout1_218ck1650 FIND v(dout1_218) AT=1660.05n

.meas tran vdout1_219ck1650 FIND v(dout1_219) AT=1660.05n

.meas tran vdout1_220ck1650 FIND v(dout1_220) AT=1660.05n

.meas tran vdout1_221ck1650 FIND v(dout1_221) AT=1660.05n

.meas tran vdout1_222ck1650 FIND v(dout1_222) AT=1660.05n

.meas tran vdout1_223ck1650 FIND v(dout1_223) AT=1660.05n

.meas tran vdout1_224ck1650 FIND v(dout1_224) AT=1660.05n

.meas tran vdout1_225ck1650 FIND v(dout1_225) AT=1660.05n

.meas tran vdout1_226ck1650 FIND v(dout1_226) AT=1660.05n

.meas tran vdout1_227ck1650 FIND v(dout1_227) AT=1660.05n

.meas tran vdout1_228ck1650 FIND v(dout1_228) AT=1660.05n

.meas tran vdout1_229ck1650 FIND v(dout1_229) AT=1660.05n

.meas tran vdout1_230ck1650 FIND v(dout1_230) AT=1660.05n

.meas tran vdout1_231ck1650 FIND v(dout1_231) AT=1660.05n

.meas tran vdout1_232ck1650 FIND v(dout1_232) AT=1660.05n

.meas tran vdout1_233ck1650 FIND v(dout1_233) AT=1660.05n

.meas tran vdout1_234ck1650 FIND v(dout1_234) AT=1660.05n

.meas tran vdout1_235ck1650 FIND v(dout1_235) AT=1660.05n

.meas tran vdout1_236ck1650 FIND v(dout1_236) AT=1660.05n

.meas tran vdout1_237ck1650 FIND v(dout1_237) AT=1660.05n

.meas tran vdout1_238ck1650 FIND v(dout1_238) AT=1660.05n

.meas tran vdout1_239ck1650 FIND v(dout1_239) AT=1660.05n

.meas tran vdout1_240ck1650 FIND v(dout1_240) AT=1660.05n

.meas tran vdout1_241ck1650 FIND v(dout1_241) AT=1660.05n

.meas tran vdout1_242ck1650 FIND v(dout1_242) AT=1660.05n

.meas tran vdout1_243ck1650 FIND v(dout1_243) AT=1660.05n

.meas tran vdout1_244ck1650 FIND v(dout1_244) AT=1660.05n

.meas tran vdout1_245ck1650 FIND v(dout1_245) AT=1660.05n

.meas tran vdout1_246ck1650 FIND v(dout1_246) AT=1660.05n

.meas tran vdout1_247ck1650 FIND v(dout1_247) AT=1660.05n

.meas tran vdout1_248ck1650 FIND v(dout1_248) AT=1660.05n

.meas tran vdout1_249ck1650 FIND v(dout1_249) AT=1660.05n

.meas tran vdout1_250ck1650 FIND v(dout1_250) AT=1660.05n

.meas tran vdout1_251ck1650 FIND v(dout1_251) AT=1660.05n

.meas tran vdout1_252ck1650 FIND v(dout1_252) AT=1660.05n

.meas tran vdout1_253ck1650 FIND v(dout1_253) AT=1660.05n

.meas tran vdout1_254ck1650 FIND v(dout1_254) AT=1660.05n

.meas tran vdout1_255ck1650 FIND v(dout1_255) AT=1660.05n

.meas tran vdout1_256ck1650 FIND v(dout1_256) AT=1660.05n

.meas tran vdout1_0ck1660 FIND v(dout1_0) AT=1670.05n

.meas tran vdout1_1ck1660 FIND v(dout1_1) AT=1670.05n

.meas tran vdout1_2ck1660 FIND v(dout1_2) AT=1670.05n

.meas tran vdout1_3ck1660 FIND v(dout1_3) AT=1670.05n

.meas tran vdout1_4ck1660 FIND v(dout1_4) AT=1670.05n

.meas tran vdout1_5ck1660 FIND v(dout1_5) AT=1670.05n

.meas tran vdout1_6ck1660 FIND v(dout1_6) AT=1670.05n

.meas tran vdout1_7ck1660 FIND v(dout1_7) AT=1670.05n

.meas tran vdout1_8ck1660 FIND v(dout1_8) AT=1670.05n

.meas tran vdout1_9ck1660 FIND v(dout1_9) AT=1670.05n

.meas tran vdout1_10ck1660 FIND v(dout1_10) AT=1670.05n

.meas tran vdout1_11ck1660 FIND v(dout1_11) AT=1670.05n

.meas tran vdout1_12ck1660 FIND v(dout1_12) AT=1670.05n

.meas tran vdout1_13ck1660 FIND v(dout1_13) AT=1670.05n

.meas tran vdout1_14ck1660 FIND v(dout1_14) AT=1670.05n

.meas tran vdout1_15ck1660 FIND v(dout1_15) AT=1670.05n

.meas tran vdout1_16ck1660 FIND v(dout1_16) AT=1670.05n

.meas tran vdout1_17ck1660 FIND v(dout1_17) AT=1670.05n

.meas tran vdout1_18ck1660 FIND v(dout1_18) AT=1670.05n

.meas tran vdout1_19ck1660 FIND v(dout1_19) AT=1670.05n

.meas tran vdout1_20ck1660 FIND v(dout1_20) AT=1670.05n

.meas tran vdout1_21ck1660 FIND v(dout1_21) AT=1670.05n

.meas tran vdout1_22ck1660 FIND v(dout1_22) AT=1670.05n

.meas tran vdout1_23ck1660 FIND v(dout1_23) AT=1670.05n

.meas tran vdout1_24ck1660 FIND v(dout1_24) AT=1670.05n

.meas tran vdout1_25ck1660 FIND v(dout1_25) AT=1670.05n

.meas tran vdout1_26ck1660 FIND v(dout1_26) AT=1670.05n

.meas tran vdout1_27ck1660 FIND v(dout1_27) AT=1670.05n

.meas tran vdout1_28ck1660 FIND v(dout1_28) AT=1670.05n

.meas tran vdout1_29ck1660 FIND v(dout1_29) AT=1670.05n

.meas tran vdout1_30ck1660 FIND v(dout1_30) AT=1670.05n

.meas tran vdout1_31ck1660 FIND v(dout1_31) AT=1670.05n

.meas tran vdout1_32ck1660 FIND v(dout1_32) AT=1670.05n

.meas tran vdout1_33ck1660 FIND v(dout1_33) AT=1670.05n

.meas tran vdout1_34ck1660 FIND v(dout1_34) AT=1670.05n

.meas tran vdout1_35ck1660 FIND v(dout1_35) AT=1670.05n

.meas tran vdout1_36ck1660 FIND v(dout1_36) AT=1670.05n

.meas tran vdout1_37ck1660 FIND v(dout1_37) AT=1670.05n

.meas tran vdout1_38ck1660 FIND v(dout1_38) AT=1670.05n

.meas tran vdout1_39ck1660 FIND v(dout1_39) AT=1670.05n

.meas tran vdout1_40ck1660 FIND v(dout1_40) AT=1670.05n

.meas tran vdout1_41ck1660 FIND v(dout1_41) AT=1670.05n

.meas tran vdout1_42ck1660 FIND v(dout1_42) AT=1670.05n

.meas tran vdout1_43ck1660 FIND v(dout1_43) AT=1670.05n

.meas tran vdout1_44ck1660 FIND v(dout1_44) AT=1670.05n

.meas tran vdout1_45ck1660 FIND v(dout1_45) AT=1670.05n

.meas tran vdout1_46ck1660 FIND v(dout1_46) AT=1670.05n

.meas tran vdout1_47ck1660 FIND v(dout1_47) AT=1670.05n

.meas tran vdout1_48ck1660 FIND v(dout1_48) AT=1670.05n

.meas tran vdout1_49ck1660 FIND v(dout1_49) AT=1670.05n

.meas tran vdout1_50ck1660 FIND v(dout1_50) AT=1670.05n

.meas tran vdout1_51ck1660 FIND v(dout1_51) AT=1670.05n

.meas tran vdout1_52ck1660 FIND v(dout1_52) AT=1670.05n

.meas tran vdout1_53ck1660 FIND v(dout1_53) AT=1670.05n

.meas tran vdout1_54ck1660 FIND v(dout1_54) AT=1670.05n

.meas tran vdout1_55ck1660 FIND v(dout1_55) AT=1670.05n

.meas tran vdout1_56ck1660 FIND v(dout1_56) AT=1670.05n

.meas tran vdout1_57ck1660 FIND v(dout1_57) AT=1670.05n

.meas tran vdout1_58ck1660 FIND v(dout1_58) AT=1670.05n

.meas tran vdout1_59ck1660 FIND v(dout1_59) AT=1670.05n

.meas tran vdout1_60ck1660 FIND v(dout1_60) AT=1670.05n

.meas tran vdout1_61ck1660 FIND v(dout1_61) AT=1670.05n

.meas tran vdout1_62ck1660 FIND v(dout1_62) AT=1670.05n

.meas tran vdout1_63ck1660 FIND v(dout1_63) AT=1670.05n

.meas tran vdout1_64ck1660 FIND v(dout1_64) AT=1670.05n

.meas tran vdout1_65ck1660 FIND v(dout1_65) AT=1670.05n

.meas tran vdout1_66ck1660 FIND v(dout1_66) AT=1670.05n

.meas tran vdout1_67ck1660 FIND v(dout1_67) AT=1670.05n

.meas tran vdout1_68ck1660 FIND v(dout1_68) AT=1670.05n

.meas tran vdout1_69ck1660 FIND v(dout1_69) AT=1670.05n

.meas tran vdout1_70ck1660 FIND v(dout1_70) AT=1670.05n

.meas tran vdout1_71ck1660 FIND v(dout1_71) AT=1670.05n

.meas tran vdout1_72ck1660 FIND v(dout1_72) AT=1670.05n

.meas tran vdout1_73ck1660 FIND v(dout1_73) AT=1670.05n

.meas tran vdout1_74ck1660 FIND v(dout1_74) AT=1670.05n

.meas tran vdout1_75ck1660 FIND v(dout1_75) AT=1670.05n

.meas tran vdout1_76ck1660 FIND v(dout1_76) AT=1670.05n

.meas tran vdout1_77ck1660 FIND v(dout1_77) AT=1670.05n

.meas tran vdout1_78ck1660 FIND v(dout1_78) AT=1670.05n

.meas tran vdout1_79ck1660 FIND v(dout1_79) AT=1670.05n

.meas tran vdout1_80ck1660 FIND v(dout1_80) AT=1670.05n

.meas tran vdout1_81ck1660 FIND v(dout1_81) AT=1670.05n

.meas tran vdout1_82ck1660 FIND v(dout1_82) AT=1670.05n

.meas tran vdout1_83ck1660 FIND v(dout1_83) AT=1670.05n

.meas tran vdout1_84ck1660 FIND v(dout1_84) AT=1670.05n

.meas tran vdout1_85ck1660 FIND v(dout1_85) AT=1670.05n

.meas tran vdout1_86ck1660 FIND v(dout1_86) AT=1670.05n

.meas tran vdout1_87ck1660 FIND v(dout1_87) AT=1670.05n

.meas tran vdout1_88ck1660 FIND v(dout1_88) AT=1670.05n

.meas tran vdout1_89ck1660 FIND v(dout1_89) AT=1670.05n

.meas tran vdout1_90ck1660 FIND v(dout1_90) AT=1670.05n

.meas tran vdout1_91ck1660 FIND v(dout1_91) AT=1670.05n

.meas tran vdout1_92ck1660 FIND v(dout1_92) AT=1670.05n

.meas tran vdout1_93ck1660 FIND v(dout1_93) AT=1670.05n

.meas tran vdout1_94ck1660 FIND v(dout1_94) AT=1670.05n

.meas tran vdout1_95ck1660 FIND v(dout1_95) AT=1670.05n

.meas tran vdout1_96ck1660 FIND v(dout1_96) AT=1670.05n

.meas tran vdout1_97ck1660 FIND v(dout1_97) AT=1670.05n

.meas tran vdout1_98ck1660 FIND v(dout1_98) AT=1670.05n

.meas tran vdout1_99ck1660 FIND v(dout1_99) AT=1670.05n

.meas tran vdout1_100ck1660 FIND v(dout1_100) AT=1670.05n

.meas tran vdout1_101ck1660 FIND v(dout1_101) AT=1670.05n

.meas tran vdout1_102ck1660 FIND v(dout1_102) AT=1670.05n

.meas tran vdout1_103ck1660 FIND v(dout1_103) AT=1670.05n

.meas tran vdout1_104ck1660 FIND v(dout1_104) AT=1670.05n

.meas tran vdout1_105ck1660 FIND v(dout1_105) AT=1670.05n

.meas tran vdout1_106ck1660 FIND v(dout1_106) AT=1670.05n

.meas tran vdout1_107ck1660 FIND v(dout1_107) AT=1670.05n

.meas tran vdout1_108ck1660 FIND v(dout1_108) AT=1670.05n

.meas tran vdout1_109ck1660 FIND v(dout1_109) AT=1670.05n

.meas tran vdout1_110ck1660 FIND v(dout1_110) AT=1670.05n

.meas tran vdout1_111ck1660 FIND v(dout1_111) AT=1670.05n

.meas tran vdout1_112ck1660 FIND v(dout1_112) AT=1670.05n

.meas tran vdout1_113ck1660 FIND v(dout1_113) AT=1670.05n

.meas tran vdout1_114ck1660 FIND v(dout1_114) AT=1670.05n

.meas tran vdout1_115ck1660 FIND v(dout1_115) AT=1670.05n

.meas tran vdout1_116ck1660 FIND v(dout1_116) AT=1670.05n

.meas tran vdout1_117ck1660 FIND v(dout1_117) AT=1670.05n

.meas tran vdout1_118ck1660 FIND v(dout1_118) AT=1670.05n

.meas tran vdout1_119ck1660 FIND v(dout1_119) AT=1670.05n

.meas tran vdout1_120ck1660 FIND v(dout1_120) AT=1670.05n

.meas tran vdout1_121ck1660 FIND v(dout1_121) AT=1670.05n

.meas tran vdout1_122ck1660 FIND v(dout1_122) AT=1670.05n

.meas tran vdout1_123ck1660 FIND v(dout1_123) AT=1670.05n

.meas tran vdout1_124ck1660 FIND v(dout1_124) AT=1670.05n

.meas tran vdout1_125ck1660 FIND v(dout1_125) AT=1670.05n

.meas tran vdout1_126ck1660 FIND v(dout1_126) AT=1670.05n

.meas tran vdout1_127ck1660 FIND v(dout1_127) AT=1670.05n

.meas tran vdout1_128ck1660 FIND v(dout1_128) AT=1670.05n

.meas tran vdout1_129ck1660 FIND v(dout1_129) AT=1670.05n

.meas tran vdout1_130ck1660 FIND v(dout1_130) AT=1670.05n

.meas tran vdout1_131ck1660 FIND v(dout1_131) AT=1670.05n

.meas tran vdout1_132ck1660 FIND v(dout1_132) AT=1670.05n

.meas tran vdout1_133ck1660 FIND v(dout1_133) AT=1670.05n

.meas tran vdout1_134ck1660 FIND v(dout1_134) AT=1670.05n

.meas tran vdout1_135ck1660 FIND v(dout1_135) AT=1670.05n

.meas tran vdout1_136ck1660 FIND v(dout1_136) AT=1670.05n

.meas tran vdout1_137ck1660 FIND v(dout1_137) AT=1670.05n

.meas tran vdout1_138ck1660 FIND v(dout1_138) AT=1670.05n

.meas tran vdout1_139ck1660 FIND v(dout1_139) AT=1670.05n

.meas tran vdout1_140ck1660 FIND v(dout1_140) AT=1670.05n

.meas tran vdout1_141ck1660 FIND v(dout1_141) AT=1670.05n

.meas tran vdout1_142ck1660 FIND v(dout1_142) AT=1670.05n

.meas tran vdout1_143ck1660 FIND v(dout1_143) AT=1670.05n

.meas tran vdout1_144ck1660 FIND v(dout1_144) AT=1670.05n

.meas tran vdout1_145ck1660 FIND v(dout1_145) AT=1670.05n

.meas tran vdout1_146ck1660 FIND v(dout1_146) AT=1670.05n

.meas tran vdout1_147ck1660 FIND v(dout1_147) AT=1670.05n

.meas tran vdout1_148ck1660 FIND v(dout1_148) AT=1670.05n

.meas tran vdout1_149ck1660 FIND v(dout1_149) AT=1670.05n

.meas tran vdout1_150ck1660 FIND v(dout1_150) AT=1670.05n

.meas tran vdout1_151ck1660 FIND v(dout1_151) AT=1670.05n

.meas tran vdout1_152ck1660 FIND v(dout1_152) AT=1670.05n

.meas tran vdout1_153ck1660 FIND v(dout1_153) AT=1670.05n

.meas tran vdout1_154ck1660 FIND v(dout1_154) AT=1670.05n

.meas tran vdout1_155ck1660 FIND v(dout1_155) AT=1670.05n

.meas tran vdout1_156ck1660 FIND v(dout1_156) AT=1670.05n

.meas tran vdout1_157ck1660 FIND v(dout1_157) AT=1670.05n

.meas tran vdout1_158ck1660 FIND v(dout1_158) AT=1670.05n

.meas tran vdout1_159ck1660 FIND v(dout1_159) AT=1670.05n

.meas tran vdout1_160ck1660 FIND v(dout1_160) AT=1670.05n

.meas tran vdout1_161ck1660 FIND v(dout1_161) AT=1670.05n

.meas tran vdout1_162ck1660 FIND v(dout1_162) AT=1670.05n

.meas tran vdout1_163ck1660 FIND v(dout1_163) AT=1670.05n

.meas tran vdout1_164ck1660 FIND v(dout1_164) AT=1670.05n

.meas tran vdout1_165ck1660 FIND v(dout1_165) AT=1670.05n

.meas tran vdout1_166ck1660 FIND v(dout1_166) AT=1670.05n

.meas tran vdout1_167ck1660 FIND v(dout1_167) AT=1670.05n

.meas tran vdout1_168ck1660 FIND v(dout1_168) AT=1670.05n

.meas tran vdout1_169ck1660 FIND v(dout1_169) AT=1670.05n

.meas tran vdout1_170ck1660 FIND v(dout1_170) AT=1670.05n

.meas tran vdout1_171ck1660 FIND v(dout1_171) AT=1670.05n

.meas tran vdout1_172ck1660 FIND v(dout1_172) AT=1670.05n

.meas tran vdout1_173ck1660 FIND v(dout1_173) AT=1670.05n

.meas tran vdout1_174ck1660 FIND v(dout1_174) AT=1670.05n

.meas tran vdout1_175ck1660 FIND v(dout1_175) AT=1670.05n

.meas tran vdout1_176ck1660 FIND v(dout1_176) AT=1670.05n

.meas tran vdout1_177ck1660 FIND v(dout1_177) AT=1670.05n

.meas tran vdout1_178ck1660 FIND v(dout1_178) AT=1670.05n

.meas tran vdout1_179ck1660 FIND v(dout1_179) AT=1670.05n

.meas tran vdout1_180ck1660 FIND v(dout1_180) AT=1670.05n

.meas tran vdout1_181ck1660 FIND v(dout1_181) AT=1670.05n

.meas tran vdout1_182ck1660 FIND v(dout1_182) AT=1670.05n

.meas tran vdout1_183ck1660 FIND v(dout1_183) AT=1670.05n

.meas tran vdout1_184ck1660 FIND v(dout1_184) AT=1670.05n

.meas tran vdout1_185ck1660 FIND v(dout1_185) AT=1670.05n

.meas tran vdout1_186ck1660 FIND v(dout1_186) AT=1670.05n

.meas tran vdout1_187ck1660 FIND v(dout1_187) AT=1670.05n

.meas tran vdout1_188ck1660 FIND v(dout1_188) AT=1670.05n

.meas tran vdout1_189ck1660 FIND v(dout1_189) AT=1670.05n

.meas tran vdout1_190ck1660 FIND v(dout1_190) AT=1670.05n

.meas tran vdout1_191ck1660 FIND v(dout1_191) AT=1670.05n

.meas tran vdout1_192ck1660 FIND v(dout1_192) AT=1670.05n

.meas tran vdout1_193ck1660 FIND v(dout1_193) AT=1670.05n

.meas tran vdout1_194ck1660 FIND v(dout1_194) AT=1670.05n

.meas tran vdout1_195ck1660 FIND v(dout1_195) AT=1670.05n

.meas tran vdout1_196ck1660 FIND v(dout1_196) AT=1670.05n

.meas tran vdout1_197ck1660 FIND v(dout1_197) AT=1670.05n

.meas tran vdout1_198ck1660 FIND v(dout1_198) AT=1670.05n

.meas tran vdout1_199ck1660 FIND v(dout1_199) AT=1670.05n

.meas tran vdout1_200ck1660 FIND v(dout1_200) AT=1670.05n

.meas tran vdout1_201ck1660 FIND v(dout1_201) AT=1670.05n

.meas tran vdout1_202ck1660 FIND v(dout1_202) AT=1670.05n

.meas tran vdout1_203ck1660 FIND v(dout1_203) AT=1670.05n

.meas tran vdout1_204ck1660 FIND v(dout1_204) AT=1670.05n

.meas tran vdout1_205ck1660 FIND v(dout1_205) AT=1670.05n

.meas tran vdout1_206ck1660 FIND v(dout1_206) AT=1670.05n

.meas tran vdout1_207ck1660 FIND v(dout1_207) AT=1670.05n

.meas tran vdout1_208ck1660 FIND v(dout1_208) AT=1670.05n

.meas tran vdout1_209ck1660 FIND v(dout1_209) AT=1670.05n

.meas tran vdout1_210ck1660 FIND v(dout1_210) AT=1670.05n

.meas tran vdout1_211ck1660 FIND v(dout1_211) AT=1670.05n

.meas tran vdout1_212ck1660 FIND v(dout1_212) AT=1670.05n

.meas tran vdout1_213ck1660 FIND v(dout1_213) AT=1670.05n

.meas tran vdout1_214ck1660 FIND v(dout1_214) AT=1670.05n

.meas tran vdout1_215ck1660 FIND v(dout1_215) AT=1670.05n

.meas tran vdout1_216ck1660 FIND v(dout1_216) AT=1670.05n

.meas tran vdout1_217ck1660 FIND v(dout1_217) AT=1670.05n

.meas tran vdout1_218ck1660 FIND v(dout1_218) AT=1670.05n

.meas tran vdout1_219ck1660 FIND v(dout1_219) AT=1670.05n

.meas tran vdout1_220ck1660 FIND v(dout1_220) AT=1670.05n

.meas tran vdout1_221ck1660 FIND v(dout1_221) AT=1670.05n

.meas tran vdout1_222ck1660 FIND v(dout1_222) AT=1670.05n

.meas tran vdout1_223ck1660 FIND v(dout1_223) AT=1670.05n

.meas tran vdout1_224ck1660 FIND v(dout1_224) AT=1670.05n

.meas tran vdout1_225ck1660 FIND v(dout1_225) AT=1670.05n

.meas tran vdout1_226ck1660 FIND v(dout1_226) AT=1670.05n

.meas tran vdout1_227ck1660 FIND v(dout1_227) AT=1670.05n

.meas tran vdout1_228ck1660 FIND v(dout1_228) AT=1670.05n

.meas tran vdout1_229ck1660 FIND v(dout1_229) AT=1670.05n

.meas tran vdout1_230ck1660 FIND v(dout1_230) AT=1670.05n

.meas tran vdout1_231ck1660 FIND v(dout1_231) AT=1670.05n

.meas tran vdout1_232ck1660 FIND v(dout1_232) AT=1670.05n

.meas tran vdout1_233ck1660 FIND v(dout1_233) AT=1670.05n

.meas tran vdout1_234ck1660 FIND v(dout1_234) AT=1670.05n

.meas tran vdout1_235ck1660 FIND v(dout1_235) AT=1670.05n

.meas tran vdout1_236ck1660 FIND v(dout1_236) AT=1670.05n

.meas tran vdout1_237ck1660 FIND v(dout1_237) AT=1670.05n

.meas tran vdout1_238ck1660 FIND v(dout1_238) AT=1670.05n

.meas tran vdout1_239ck1660 FIND v(dout1_239) AT=1670.05n

.meas tran vdout1_240ck1660 FIND v(dout1_240) AT=1670.05n

.meas tran vdout1_241ck1660 FIND v(dout1_241) AT=1670.05n

.meas tran vdout1_242ck1660 FIND v(dout1_242) AT=1670.05n

.meas tran vdout1_243ck1660 FIND v(dout1_243) AT=1670.05n

.meas tran vdout1_244ck1660 FIND v(dout1_244) AT=1670.05n

.meas tran vdout1_245ck1660 FIND v(dout1_245) AT=1670.05n

.meas tran vdout1_246ck1660 FIND v(dout1_246) AT=1670.05n

.meas tran vdout1_247ck1660 FIND v(dout1_247) AT=1670.05n

.meas tran vdout1_248ck1660 FIND v(dout1_248) AT=1670.05n

.meas tran vdout1_249ck1660 FIND v(dout1_249) AT=1670.05n

.meas tran vdout1_250ck1660 FIND v(dout1_250) AT=1670.05n

.meas tran vdout1_251ck1660 FIND v(dout1_251) AT=1670.05n

.meas tran vdout1_252ck1660 FIND v(dout1_252) AT=1670.05n

.meas tran vdout1_253ck1660 FIND v(dout1_253) AT=1670.05n

.meas tran vdout1_254ck1660 FIND v(dout1_254) AT=1670.05n

.meas tran vdout1_255ck1660 FIND v(dout1_255) AT=1670.05n

.meas tran vdout1_256ck1660 FIND v(dout1_256) AT=1670.05n

.meas tran vdout1_0ck1700 FIND v(dout1_0) AT=1710.05n

.meas tran vdout1_1ck1700 FIND v(dout1_1) AT=1710.05n

.meas tran vdout1_2ck1700 FIND v(dout1_2) AT=1710.05n

.meas tran vdout1_3ck1700 FIND v(dout1_3) AT=1710.05n

.meas tran vdout1_4ck1700 FIND v(dout1_4) AT=1710.05n

.meas tran vdout1_5ck1700 FIND v(dout1_5) AT=1710.05n

.meas tran vdout1_6ck1700 FIND v(dout1_6) AT=1710.05n

.meas tran vdout1_7ck1700 FIND v(dout1_7) AT=1710.05n

.meas tran vdout1_8ck1700 FIND v(dout1_8) AT=1710.05n

.meas tran vdout1_9ck1700 FIND v(dout1_9) AT=1710.05n

.meas tran vdout1_10ck1700 FIND v(dout1_10) AT=1710.05n

.meas tran vdout1_11ck1700 FIND v(dout1_11) AT=1710.05n

.meas tran vdout1_12ck1700 FIND v(dout1_12) AT=1710.05n

.meas tran vdout1_13ck1700 FIND v(dout1_13) AT=1710.05n

.meas tran vdout1_14ck1700 FIND v(dout1_14) AT=1710.05n

.meas tran vdout1_15ck1700 FIND v(dout1_15) AT=1710.05n

.meas tran vdout1_16ck1700 FIND v(dout1_16) AT=1710.05n

.meas tran vdout1_17ck1700 FIND v(dout1_17) AT=1710.05n

.meas tran vdout1_18ck1700 FIND v(dout1_18) AT=1710.05n

.meas tran vdout1_19ck1700 FIND v(dout1_19) AT=1710.05n

.meas tran vdout1_20ck1700 FIND v(dout1_20) AT=1710.05n

.meas tran vdout1_21ck1700 FIND v(dout1_21) AT=1710.05n

.meas tran vdout1_22ck1700 FIND v(dout1_22) AT=1710.05n

.meas tran vdout1_23ck1700 FIND v(dout1_23) AT=1710.05n

.meas tran vdout1_24ck1700 FIND v(dout1_24) AT=1710.05n

.meas tran vdout1_25ck1700 FIND v(dout1_25) AT=1710.05n

.meas tran vdout1_26ck1700 FIND v(dout1_26) AT=1710.05n

.meas tran vdout1_27ck1700 FIND v(dout1_27) AT=1710.05n

.meas tran vdout1_28ck1700 FIND v(dout1_28) AT=1710.05n

.meas tran vdout1_29ck1700 FIND v(dout1_29) AT=1710.05n

.meas tran vdout1_30ck1700 FIND v(dout1_30) AT=1710.05n

.meas tran vdout1_31ck1700 FIND v(dout1_31) AT=1710.05n

.meas tran vdout1_32ck1700 FIND v(dout1_32) AT=1710.05n

.meas tran vdout1_33ck1700 FIND v(dout1_33) AT=1710.05n

.meas tran vdout1_34ck1700 FIND v(dout1_34) AT=1710.05n

.meas tran vdout1_35ck1700 FIND v(dout1_35) AT=1710.05n

.meas tran vdout1_36ck1700 FIND v(dout1_36) AT=1710.05n

.meas tran vdout1_37ck1700 FIND v(dout1_37) AT=1710.05n

.meas tran vdout1_38ck1700 FIND v(dout1_38) AT=1710.05n

.meas tran vdout1_39ck1700 FIND v(dout1_39) AT=1710.05n

.meas tran vdout1_40ck1700 FIND v(dout1_40) AT=1710.05n

.meas tran vdout1_41ck1700 FIND v(dout1_41) AT=1710.05n

.meas tran vdout1_42ck1700 FIND v(dout1_42) AT=1710.05n

.meas tran vdout1_43ck1700 FIND v(dout1_43) AT=1710.05n

.meas tran vdout1_44ck1700 FIND v(dout1_44) AT=1710.05n

.meas tran vdout1_45ck1700 FIND v(dout1_45) AT=1710.05n

.meas tran vdout1_46ck1700 FIND v(dout1_46) AT=1710.05n

.meas tran vdout1_47ck1700 FIND v(dout1_47) AT=1710.05n

.meas tran vdout1_48ck1700 FIND v(dout1_48) AT=1710.05n

.meas tran vdout1_49ck1700 FIND v(dout1_49) AT=1710.05n

.meas tran vdout1_50ck1700 FIND v(dout1_50) AT=1710.05n

.meas tran vdout1_51ck1700 FIND v(dout1_51) AT=1710.05n

.meas tran vdout1_52ck1700 FIND v(dout1_52) AT=1710.05n

.meas tran vdout1_53ck1700 FIND v(dout1_53) AT=1710.05n

.meas tran vdout1_54ck1700 FIND v(dout1_54) AT=1710.05n

.meas tran vdout1_55ck1700 FIND v(dout1_55) AT=1710.05n

.meas tran vdout1_56ck1700 FIND v(dout1_56) AT=1710.05n

.meas tran vdout1_57ck1700 FIND v(dout1_57) AT=1710.05n

.meas tran vdout1_58ck1700 FIND v(dout1_58) AT=1710.05n

.meas tran vdout1_59ck1700 FIND v(dout1_59) AT=1710.05n

.meas tran vdout1_60ck1700 FIND v(dout1_60) AT=1710.05n

.meas tran vdout1_61ck1700 FIND v(dout1_61) AT=1710.05n

.meas tran vdout1_62ck1700 FIND v(dout1_62) AT=1710.05n

.meas tran vdout1_63ck1700 FIND v(dout1_63) AT=1710.05n

.meas tran vdout1_64ck1700 FIND v(dout1_64) AT=1710.05n

.meas tran vdout1_65ck1700 FIND v(dout1_65) AT=1710.05n

.meas tran vdout1_66ck1700 FIND v(dout1_66) AT=1710.05n

.meas tran vdout1_67ck1700 FIND v(dout1_67) AT=1710.05n

.meas tran vdout1_68ck1700 FIND v(dout1_68) AT=1710.05n

.meas tran vdout1_69ck1700 FIND v(dout1_69) AT=1710.05n

.meas tran vdout1_70ck1700 FIND v(dout1_70) AT=1710.05n

.meas tran vdout1_71ck1700 FIND v(dout1_71) AT=1710.05n

.meas tran vdout1_72ck1700 FIND v(dout1_72) AT=1710.05n

.meas tran vdout1_73ck1700 FIND v(dout1_73) AT=1710.05n

.meas tran vdout1_74ck1700 FIND v(dout1_74) AT=1710.05n

.meas tran vdout1_75ck1700 FIND v(dout1_75) AT=1710.05n

.meas tran vdout1_76ck1700 FIND v(dout1_76) AT=1710.05n

.meas tran vdout1_77ck1700 FIND v(dout1_77) AT=1710.05n

.meas tran vdout1_78ck1700 FIND v(dout1_78) AT=1710.05n

.meas tran vdout1_79ck1700 FIND v(dout1_79) AT=1710.05n

.meas tran vdout1_80ck1700 FIND v(dout1_80) AT=1710.05n

.meas tran vdout1_81ck1700 FIND v(dout1_81) AT=1710.05n

.meas tran vdout1_82ck1700 FIND v(dout1_82) AT=1710.05n

.meas tran vdout1_83ck1700 FIND v(dout1_83) AT=1710.05n

.meas tran vdout1_84ck1700 FIND v(dout1_84) AT=1710.05n

.meas tran vdout1_85ck1700 FIND v(dout1_85) AT=1710.05n

.meas tran vdout1_86ck1700 FIND v(dout1_86) AT=1710.05n

.meas tran vdout1_87ck1700 FIND v(dout1_87) AT=1710.05n

.meas tran vdout1_88ck1700 FIND v(dout1_88) AT=1710.05n

.meas tran vdout1_89ck1700 FIND v(dout1_89) AT=1710.05n

.meas tran vdout1_90ck1700 FIND v(dout1_90) AT=1710.05n

.meas tran vdout1_91ck1700 FIND v(dout1_91) AT=1710.05n

.meas tran vdout1_92ck1700 FIND v(dout1_92) AT=1710.05n

.meas tran vdout1_93ck1700 FIND v(dout1_93) AT=1710.05n

.meas tran vdout1_94ck1700 FIND v(dout1_94) AT=1710.05n

.meas tran vdout1_95ck1700 FIND v(dout1_95) AT=1710.05n

.meas tran vdout1_96ck1700 FIND v(dout1_96) AT=1710.05n

.meas tran vdout1_97ck1700 FIND v(dout1_97) AT=1710.05n

.meas tran vdout1_98ck1700 FIND v(dout1_98) AT=1710.05n

.meas tran vdout1_99ck1700 FIND v(dout1_99) AT=1710.05n

.meas tran vdout1_100ck1700 FIND v(dout1_100) AT=1710.05n

.meas tran vdout1_101ck1700 FIND v(dout1_101) AT=1710.05n

.meas tran vdout1_102ck1700 FIND v(dout1_102) AT=1710.05n

.meas tran vdout1_103ck1700 FIND v(dout1_103) AT=1710.05n

.meas tran vdout1_104ck1700 FIND v(dout1_104) AT=1710.05n

.meas tran vdout1_105ck1700 FIND v(dout1_105) AT=1710.05n

.meas tran vdout1_106ck1700 FIND v(dout1_106) AT=1710.05n

.meas tran vdout1_107ck1700 FIND v(dout1_107) AT=1710.05n

.meas tran vdout1_108ck1700 FIND v(dout1_108) AT=1710.05n

.meas tran vdout1_109ck1700 FIND v(dout1_109) AT=1710.05n

.meas tran vdout1_110ck1700 FIND v(dout1_110) AT=1710.05n

.meas tran vdout1_111ck1700 FIND v(dout1_111) AT=1710.05n

.meas tran vdout1_112ck1700 FIND v(dout1_112) AT=1710.05n

.meas tran vdout1_113ck1700 FIND v(dout1_113) AT=1710.05n

.meas tran vdout1_114ck1700 FIND v(dout1_114) AT=1710.05n

.meas tran vdout1_115ck1700 FIND v(dout1_115) AT=1710.05n

.meas tran vdout1_116ck1700 FIND v(dout1_116) AT=1710.05n

.meas tran vdout1_117ck1700 FIND v(dout1_117) AT=1710.05n

.meas tran vdout1_118ck1700 FIND v(dout1_118) AT=1710.05n

.meas tran vdout1_119ck1700 FIND v(dout1_119) AT=1710.05n

.meas tran vdout1_120ck1700 FIND v(dout1_120) AT=1710.05n

.meas tran vdout1_121ck1700 FIND v(dout1_121) AT=1710.05n

.meas tran vdout1_122ck1700 FIND v(dout1_122) AT=1710.05n

.meas tran vdout1_123ck1700 FIND v(dout1_123) AT=1710.05n

.meas tran vdout1_124ck1700 FIND v(dout1_124) AT=1710.05n

.meas tran vdout1_125ck1700 FIND v(dout1_125) AT=1710.05n

.meas tran vdout1_126ck1700 FIND v(dout1_126) AT=1710.05n

.meas tran vdout1_127ck1700 FIND v(dout1_127) AT=1710.05n

.meas tran vdout1_128ck1700 FIND v(dout1_128) AT=1710.05n

.meas tran vdout1_129ck1700 FIND v(dout1_129) AT=1710.05n

.meas tran vdout1_130ck1700 FIND v(dout1_130) AT=1710.05n

.meas tran vdout1_131ck1700 FIND v(dout1_131) AT=1710.05n

.meas tran vdout1_132ck1700 FIND v(dout1_132) AT=1710.05n

.meas tran vdout1_133ck1700 FIND v(dout1_133) AT=1710.05n

.meas tran vdout1_134ck1700 FIND v(dout1_134) AT=1710.05n

.meas tran vdout1_135ck1700 FIND v(dout1_135) AT=1710.05n

.meas tran vdout1_136ck1700 FIND v(dout1_136) AT=1710.05n

.meas tran vdout1_137ck1700 FIND v(dout1_137) AT=1710.05n

.meas tran vdout1_138ck1700 FIND v(dout1_138) AT=1710.05n

.meas tran vdout1_139ck1700 FIND v(dout1_139) AT=1710.05n

.meas tran vdout1_140ck1700 FIND v(dout1_140) AT=1710.05n

.meas tran vdout1_141ck1700 FIND v(dout1_141) AT=1710.05n

.meas tran vdout1_142ck1700 FIND v(dout1_142) AT=1710.05n

.meas tran vdout1_143ck1700 FIND v(dout1_143) AT=1710.05n

.meas tran vdout1_144ck1700 FIND v(dout1_144) AT=1710.05n

.meas tran vdout1_145ck1700 FIND v(dout1_145) AT=1710.05n

.meas tran vdout1_146ck1700 FIND v(dout1_146) AT=1710.05n

.meas tran vdout1_147ck1700 FIND v(dout1_147) AT=1710.05n

.meas tran vdout1_148ck1700 FIND v(dout1_148) AT=1710.05n

.meas tran vdout1_149ck1700 FIND v(dout1_149) AT=1710.05n

.meas tran vdout1_150ck1700 FIND v(dout1_150) AT=1710.05n

.meas tran vdout1_151ck1700 FIND v(dout1_151) AT=1710.05n

.meas tran vdout1_152ck1700 FIND v(dout1_152) AT=1710.05n

.meas tran vdout1_153ck1700 FIND v(dout1_153) AT=1710.05n

.meas tran vdout1_154ck1700 FIND v(dout1_154) AT=1710.05n

.meas tran vdout1_155ck1700 FIND v(dout1_155) AT=1710.05n

.meas tran vdout1_156ck1700 FIND v(dout1_156) AT=1710.05n

.meas tran vdout1_157ck1700 FIND v(dout1_157) AT=1710.05n

.meas tran vdout1_158ck1700 FIND v(dout1_158) AT=1710.05n

.meas tran vdout1_159ck1700 FIND v(dout1_159) AT=1710.05n

.meas tran vdout1_160ck1700 FIND v(dout1_160) AT=1710.05n

.meas tran vdout1_161ck1700 FIND v(dout1_161) AT=1710.05n

.meas tran vdout1_162ck1700 FIND v(dout1_162) AT=1710.05n

.meas tran vdout1_163ck1700 FIND v(dout1_163) AT=1710.05n

.meas tran vdout1_164ck1700 FIND v(dout1_164) AT=1710.05n

.meas tran vdout1_165ck1700 FIND v(dout1_165) AT=1710.05n

.meas tran vdout1_166ck1700 FIND v(dout1_166) AT=1710.05n

.meas tran vdout1_167ck1700 FIND v(dout1_167) AT=1710.05n

.meas tran vdout1_168ck1700 FIND v(dout1_168) AT=1710.05n

.meas tran vdout1_169ck1700 FIND v(dout1_169) AT=1710.05n

.meas tran vdout1_170ck1700 FIND v(dout1_170) AT=1710.05n

.meas tran vdout1_171ck1700 FIND v(dout1_171) AT=1710.05n

.meas tran vdout1_172ck1700 FIND v(dout1_172) AT=1710.05n

.meas tran vdout1_173ck1700 FIND v(dout1_173) AT=1710.05n

.meas tran vdout1_174ck1700 FIND v(dout1_174) AT=1710.05n

.meas tran vdout1_175ck1700 FIND v(dout1_175) AT=1710.05n

.meas tran vdout1_176ck1700 FIND v(dout1_176) AT=1710.05n

.meas tran vdout1_177ck1700 FIND v(dout1_177) AT=1710.05n

.meas tran vdout1_178ck1700 FIND v(dout1_178) AT=1710.05n

.meas tran vdout1_179ck1700 FIND v(dout1_179) AT=1710.05n

.meas tran vdout1_180ck1700 FIND v(dout1_180) AT=1710.05n

.meas tran vdout1_181ck1700 FIND v(dout1_181) AT=1710.05n

.meas tran vdout1_182ck1700 FIND v(dout1_182) AT=1710.05n

.meas tran vdout1_183ck1700 FIND v(dout1_183) AT=1710.05n

.meas tran vdout1_184ck1700 FIND v(dout1_184) AT=1710.05n

.meas tran vdout1_185ck1700 FIND v(dout1_185) AT=1710.05n

.meas tran vdout1_186ck1700 FIND v(dout1_186) AT=1710.05n

.meas tran vdout1_187ck1700 FIND v(dout1_187) AT=1710.05n

.meas tran vdout1_188ck1700 FIND v(dout1_188) AT=1710.05n

.meas tran vdout1_189ck1700 FIND v(dout1_189) AT=1710.05n

.meas tran vdout1_190ck1700 FIND v(dout1_190) AT=1710.05n

.meas tran vdout1_191ck1700 FIND v(dout1_191) AT=1710.05n

.meas tran vdout1_192ck1700 FIND v(dout1_192) AT=1710.05n

.meas tran vdout1_193ck1700 FIND v(dout1_193) AT=1710.05n

.meas tran vdout1_194ck1700 FIND v(dout1_194) AT=1710.05n

.meas tran vdout1_195ck1700 FIND v(dout1_195) AT=1710.05n

.meas tran vdout1_196ck1700 FIND v(dout1_196) AT=1710.05n

.meas tran vdout1_197ck1700 FIND v(dout1_197) AT=1710.05n

.meas tran vdout1_198ck1700 FIND v(dout1_198) AT=1710.05n

.meas tran vdout1_199ck1700 FIND v(dout1_199) AT=1710.05n

.meas tran vdout1_200ck1700 FIND v(dout1_200) AT=1710.05n

.meas tran vdout1_201ck1700 FIND v(dout1_201) AT=1710.05n

.meas tran vdout1_202ck1700 FIND v(dout1_202) AT=1710.05n

.meas tran vdout1_203ck1700 FIND v(dout1_203) AT=1710.05n

.meas tran vdout1_204ck1700 FIND v(dout1_204) AT=1710.05n

.meas tran vdout1_205ck1700 FIND v(dout1_205) AT=1710.05n

.meas tran vdout1_206ck1700 FIND v(dout1_206) AT=1710.05n

.meas tran vdout1_207ck1700 FIND v(dout1_207) AT=1710.05n

.meas tran vdout1_208ck1700 FIND v(dout1_208) AT=1710.05n

.meas tran vdout1_209ck1700 FIND v(dout1_209) AT=1710.05n

.meas tran vdout1_210ck1700 FIND v(dout1_210) AT=1710.05n

.meas tran vdout1_211ck1700 FIND v(dout1_211) AT=1710.05n

.meas tran vdout1_212ck1700 FIND v(dout1_212) AT=1710.05n

.meas tran vdout1_213ck1700 FIND v(dout1_213) AT=1710.05n

.meas tran vdout1_214ck1700 FIND v(dout1_214) AT=1710.05n

.meas tran vdout1_215ck1700 FIND v(dout1_215) AT=1710.05n

.meas tran vdout1_216ck1700 FIND v(dout1_216) AT=1710.05n

.meas tran vdout1_217ck1700 FIND v(dout1_217) AT=1710.05n

.meas tran vdout1_218ck1700 FIND v(dout1_218) AT=1710.05n

.meas tran vdout1_219ck1700 FIND v(dout1_219) AT=1710.05n

.meas tran vdout1_220ck1700 FIND v(dout1_220) AT=1710.05n

.meas tran vdout1_221ck1700 FIND v(dout1_221) AT=1710.05n

.meas tran vdout1_222ck1700 FIND v(dout1_222) AT=1710.05n

.meas tran vdout1_223ck1700 FIND v(dout1_223) AT=1710.05n

.meas tran vdout1_224ck1700 FIND v(dout1_224) AT=1710.05n

.meas tran vdout1_225ck1700 FIND v(dout1_225) AT=1710.05n

.meas tran vdout1_226ck1700 FIND v(dout1_226) AT=1710.05n

.meas tran vdout1_227ck1700 FIND v(dout1_227) AT=1710.05n

.meas tran vdout1_228ck1700 FIND v(dout1_228) AT=1710.05n

.meas tran vdout1_229ck1700 FIND v(dout1_229) AT=1710.05n

.meas tran vdout1_230ck1700 FIND v(dout1_230) AT=1710.05n

.meas tran vdout1_231ck1700 FIND v(dout1_231) AT=1710.05n

.meas tran vdout1_232ck1700 FIND v(dout1_232) AT=1710.05n

.meas tran vdout1_233ck1700 FIND v(dout1_233) AT=1710.05n

.meas tran vdout1_234ck1700 FIND v(dout1_234) AT=1710.05n

.meas tran vdout1_235ck1700 FIND v(dout1_235) AT=1710.05n

.meas tran vdout1_236ck1700 FIND v(dout1_236) AT=1710.05n

.meas tran vdout1_237ck1700 FIND v(dout1_237) AT=1710.05n

.meas tran vdout1_238ck1700 FIND v(dout1_238) AT=1710.05n

.meas tran vdout1_239ck1700 FIND v(dout1_239) AT=1710.05n

.meas tran vdout1_240ck1700 FIND v(dout1_240) AT=1710.05n

.meas tran vdout1_241ck1700 FIND v(dout1_241) AT=1710.05n

.meas tran vdout1_242ck1700 FIND v(dout1_242) AT=1710.05n

.meas tran vdout1_243ck1700 FIND v(dout1_243) AT=1710.05n

.meas tran vdout1_244ck1700 FIND v(dout1_244) AT=1710.05n

.meas tran vdout1_245ck1700 FIND v(dout1_245) AT=1710.05n

.meas tran vdout1_246ck1700 FIND v(dout1_246) AT=1710.05n

.meas tran vdout1_247ck1700 FIND v(dout1_247) AT=1710.05n

.meas tran vdout1_248ck1700 FIND v(dout1_248) AT=1710.05n

.meas tran vdout1_249ck1700 FIND v(dout1_249) AT=1710.05n

.meas tran vdout1_250ck1700 FIND v(dout1_250) AT=1710.05n

.meas tran vdout1_251ck1700 FIND v(dout1_251) AT=1710.05n

.meas tran vdout1_252ck1700 FIND v(dout1_252) AT=1710.05n

.meas tran vdout1_253ck1700 FIND v(dout1_253) AT=1710.05n

.meas tran vdout1_254ck1700 FIND v(dout1_254) AT=1710.05n

.meas tran vdout1_255ck1700 FIND v(dout1_255) AT=1710.05n

.meas tran vdout1_256ck1700 FIND v(dout1_256) AT=1710.05n

.meas tran vdout1_0ck1710 FIND v(dout1_0) AT=1720.05n

.meas tran vdout1_1ck1710 FIND v(dout1_1) AT=1720.05n

.meas tran vdout1_2ck1710 FIND v(dout1_2) AT=1720.05n

.meas tran vdout1_3ck1710 FIND v(dout1_3) AT=1720.05n

.meas tran vdout1_4ck1710 FIND v(dout1_4) AT=1720.05n

.meas tran vdout1_5ck1710 FIND v(dout1_5) AT=1720.05n

.meas tran vdout1_6ck1710 FIND v(dout1_6) AT=1720.05n

.meas tran vdout1_7ck1710 FIND v(dout1_7) AT=1720.05n

.meas tran vdout1_8ck1710 FIND v(dout1_8) AT=1720.05n

.meas tran vdout1_9ck1710 FIND v(dout1_9) AT=1720.05n

.meas tran vdout1_10ck1710 FIND v(dout1_10) AT=1720.05n

.meas tran vdout1_11ck1710 FIND v(dout1_11) AT=1720.05n

.meas tran vdout1_12ck1710 FIND v(dout1_12) AT=1720.05n

.meas tran vdout1_13ck1710 FIND v(dout1_13) AT=1720.05n

.meas tran vdout1_14ck1710 FIND v(dout1_14) AT=1720.05n

.meas tran vdout1_15ck1710 FIND v(dout1_15) AT=1720.05n

.meas tran vdout1_16ck1710 FIND v(dout1_16) AT=1720.05n

.meas tran vdout1_17ck1710 FIND v(dout1_17) AT=1720.05n

.meas tran vdout1_18ck1710 FIND v(dout1_18) AT=1720.05n

.meas tran vdout1_19ck1710 FIND v(dout1_19) AT=1720.05n

.meas tran vdout1_20ck1710 FIND v(dout1_20) AT=1720.05n

.meas tran vdout1_21ck1710 FIND v(dout1_21) AT=1720.05n

.meas tran vdout1_22ck1710 FIND v(dout1_22) AT=1720.05n

.meas tran vdout1_23ck1710 FIND v(dout1_23) AT=1720.05n

.meas tran vdout1_24ck1710 FIND v(dout1_24) AT=1720.05n

.meas tran vdout1_25ck1710 FIND v(dout1_25) AT=1720.05n

.meas tran vdout1_26ck1710 FIND v(dout1_26) AT=1720.05n

.meas tran vdout1_27ck1710 FIND v(dout1_27) AT=1720.05n

.meas tran vdout1_28ck1710 FIND v(dout1_28) AT=1720.05n

.meas tran vdout1_29ck1710 FIND v(dout1_29) AT=1720.05n

.meas tran vdout1_30ck1710 FIND v(dout1_30) AT=1720.05n

.meas tran vdout1_31ck1710 FIND v(dout1_31) AT=1720.05n

.meas tran vdout1_32ck1710 FIND v(dout1_32) AT=1720.05n

.meas tran vdout1_33ck1710 FIND v(dout1_33) AT=1720.05n

.meas tran vdout1_34ck1710 FIND v(dout1_34) AT=1720.05n

.meas tran vdout1_35ck1710 FIND v(dout1_35) AT=1720.05n

.meas tran vdout1_36ck1710 FIND v(dout1_36) AT=1720.05n

.meas tran vdout1_37ck1710 FIND v(dout1_37) AT=1720.05n

.meas tran vdout1_38ck1710 FIND v(dout1_38) AT=1720.05n

.meas tran vdout1_39ck1710 FIND v(dout1_39) AT=1720.05n

.meas tran vdout1_40ck1710 FIND v(dout1_40) AT=1720.05n

.meas tran vdout1_41ck1710 FIND v(dout1_41) AT=1720.05n

.meas tran vdout1_42ck1710 FIND v(dout1_42) AT=1720.05n

.meas tran vdout1_43ck1710 FIND v(dout1_43) AT=1720.05n

.meas tran vdout1_44ck1710 FIND v(dout1_44) AT=1720.05n

.meas tran vdout1_45ck1710 FIND v(dout1_45) AT=1720.05n

.meas tran vdout1_46ck1710 FIND v(dout1_46) AT=1720.05n

.meas tran vdout1_47ck1710 FIND v(dout1_47) AT=1720.05n

.meas tran vdout1_48ck1710 FIND v(dout1_48) AT=1720.05n

.meas tran vdout1_49ck1710 FIND v(dout1_49) AT=1720.05n

.meas tran vdout1_50ck1710 FIND v(dout1_50) AT=1720.05n

.meas tran vdout1_51ck1710 FIND v(dout1_51) AT=1720.05n

.meas tran vdout1_52ck1710 FIND v(dout1_52) AT=1720.05n

.meas tran vdout1_53ck1710 FIND v(dout1_53) AT=1720.05n

.meas tran vdout1_54ck1710 FIND v(dout1_54) AT=1720.05n

.meas tran vdout1_55ck1710 FIND v(dout1_55) AT=1720.05n

.meas tran vdout1_56ck1710 FIND v(dout1_56) AT=1720.05n

.meas tran vdout1_57ck1710 FIND v(dout1_57) AT=1720.05n

.meas tran vdout1_58ck1710 FIND v(dout1_58) AT=1720.05n

.meas tran vdout1_59ck1710 FIND v(dout1_59) AT=1720.05n

.meas tran vdout1_60ck1710 FIND v(dout1_60) AT=1720.05n

.meas tran vdout1_61ck1710 FIND v(dout1_61) AT=1720.05n

.meas tran vdout1_62ck1710 FIND v(dout1_62) AT=1720.05n

.meas tran vdout1_63ck1710 FIND v(dout1_63) AT=1720.05n

.meas tran vdout1_64ck1710 FIND v(dout1_64) AT=1720.05n

.meas tran vdout1_65ck1710 FIND v(dout1_65) AT=1720.05n

.meas tran vdout1_66ck1710 FIND v(dout1_66) AT=1720.05n

.meas tran vdout1_67ck1710 FIND v(dout1_67) AT=1720.05n

.meas tran vdout1_68ck1710 FIND v(dout1_68) AT=1720.05n

.meas tran vdout1_69ck1710 FIND v(dout1_69) AT=1720.05n

.meas tran vdout1_70ck1710 FIND v(dout1_70) AT=1720.05n

.meas tran vdout1_71ck1710 FIND v(dout1_71) AT=1720.05n

.meas tran vdout1_72ck1710 FIND v(dout1_72) AT=1720.05n

.meas tran vdout1_73ck1710 FIND v(dout1_73) AT=1720.05n

.meas tran vdout1_74ck1710 FIND v(dout1_74) AT=1720.05n

.meas tran vdout1_75ck1710 FIND v(dout1_75) AT=1720.05n

.meas tran vdout1_76ck1710 FIND v(dout1_76) AT=1720.05n

.meas tran vdout1_77ck1710 FIND v(dout1_77) AT=1720.05n

.meas tran vdout1_78ck1710 FIND v(dout1_78) AT=1720.05n

.meas tran vdout1_79ck1710 FIND v(dout1_79) AT=1720.05n

.meas tran vdout1_80ck1710 FIND v(dout1_80) AT=1720.05n

.meas tran vdout1_81ck1710 FIND v(dout1_81) AT=1720.05n

.meas tran vdout1_82ck1710 FIND v(dout1_82) AT=1720.05n

.meas tran vdout1_83ck1710 FIND v(dout1_83) AT=1720.05n

.meas tran vdout1_84ck1710 FIND v(dout1_84) AT=1720.05n

.meas tran vdout1_85ck1710 FIND v(dout1_85) AT=1720.05n

.meas tran vdout1_86ck1710 FIND v(dout1_86) AT=1720.05n

.meas tran vdout1_87ck1710 FIND v(dout1_87) AT=1720.05n

.meas tran vdout1_88ck1710 FIND v(dout1_88) AT=1720.05n

.meas tran vdout1_89ck1710 FIND v(dout1_89) AT=1720.05n

.meas tran vdout1_90ck1710 FIND v(dout1_90) AT=1720.05n

.meas tran vdout1_91ck1710 FIND v(dout1_91) AT=1720.05n

.meas tran vdout1_92ck1710 FIND v(dout1_92) AT=1720.05n

.meas tran vdout1_93ck1710 FIND v(dout1_93) AT=1720.05n

.meas tran vdout1_94ck1710 FIND v(dout1_94) AT=1720.05n

.meas tran vdout1_95ck1710 FIND v(dout1_95) AT=1720.05n

.meas tran vdout1_96ck1710 FIND v(dout1_96) AT=1720.05n

.meas tran vdout1_97ck1710 FIND v(dout1_97) AT=1720.05n

.meas tran vdout1_98ck1710 FIND v(dout1_98) AT=1720.05n

.meas tran vdout1_99ck1710 FIND v(dout1_99) AT=1720.05n

.meas tran vdout1_100ck1710 FIND v(dout1_100) AT=1720.05n

.meas tran vdout1_101ck1710 FIND v(dout1_101) AT=1720.05n

.meas tran vdout1_102ck1710 FIND v(dout1_102) AT=1720.05n

.meas tran vdout1_103ck1710 FIND v(dout1_103) AT=1720.05n

.meas tran vdout1_104ck1710 FIND v(dout1_104) AT=1720.05n

.meas tran vdout1_105ck1710 FIND v(dout1_105) AT=1720.05n

.meas tran vdout1_106ck1710 FIND v(dout1_106) AT=1720.05n

.meas tran vdout1_107ck1710 FIND v(dout1_107) AT=1720.05n

.meas tran vdout1_108ck1710 FIND v(dout1_108) AT=1720.05n

.meas tran vdout1_109ck1710 FIND v(dout1_109) AT=1720.05n

.meas tran vdout1_110ck1710 FIND v(dout1_110) AT=1720.05n

.meas tran vdout1_111ck1710 FIND v(dout1_111) AT=1720.05n

.meas tran vdout1_112ck1710 FIND v(dout1_112) AT=1720.05n

.meas tran vdout1_113ck1710 FIND v(dout1_113) AT=1720.05n

.meas tran vdout1_114ck1710 FIND v(dout1_114) AT=1720.05n

.meas tran vdout1_115ck1710 FIND v(dout1_115) AT=1720.05n

.meas tran vdout1_116ck1710 FIND v(dout1_116) AT=1720.05n

.meas tran vdout1_117ck1710 FIND v(dout1_117) AT=1720.05n

.meas tran vdout1_118ck1710 FIND v(dout1_118) AT=1720.05n

.meas tran vdout1_119ck1710 FIND v(dout1_119) AT=1720.05n

.meas tran vdout1_120ck1710 FIND v(dout1_120) AT=1720.05n

.meas tran vdout1_121ck1710 FIND v(dout1_121) AT=1720.05n

.meas tran vdout1_122ck1710 FIND v(dout1_122) AT=1720.05n

.meas tran vdout1_123ck1710 FIND v(dout1_123) AT=1720.05n

.meas tran vdout1_124ck1710 FIND v(dout1_124) AT=1720.05n

.meas tran vdout1_125ck1710 FIND v(dout1_125) AT=1720.05n

.meas tran vdout1_126ck1710 FIND v(dout1_126) AT=1720.05n

.meas tran vdout1_127ck1710 FIND v(dout1_127) AT=1720.05n

.meas tran vdout1_128ck1710 FIND v(dout1_128) AT=1720.05n

.meas tran vdout1_129ck1710 FIND v(dout1_129) AT=1720.05n

.meas tran vdout1_130ck1710 FIND v(dout1_130) AT=1720.05n

.meas tran vdout1_131ck1710 FIND v(dout1_131) AT=1720.05n

.meas tran vdout1_132ck1710 FIND v(dout1_132) AT=1720.05n

.meas tran vdout1_133ck1710 FIND v(dout1_133) AT=1720.05n

.meas tran vdout1_134ck1710 FIND v(dout1_134) AT=1720.05n

.meas tran vdout1_135ck1710 FIND v(dout1_135) AT=1720.05n

.meas tran vdout1_136ck1710 FIND v(dout1_136) AT=1720.05n

.meas tran vdout1_137ck1710 FIND v(dout1_137) AT=1720.05n

.meas tran vdout1_138ck1710 FIND v(dout1_138) AT=1720.05n

.meas tran vdout1_139ck1710 FIND v(dout1_139) AT=1720.05n

.meas tran vdout1_140ck1710 FIND v(dout1_140) AT=1720.05n

.meas tran vdout1_141ck1710 FIND v(dout1_141) AT=1720.05n

.meas tran vdout1_142ck1710 FIND v(dout1_142) AT=1720.05n

.meas tran vdout1_143ck1710 FIND v(dout1_143) AT=1720.05n

.meas tran vdout1_144ck1710 FIND v(dout1_144) AT=1720.05n

.meas tran vdout1_145ck1710 FIND v(dout1_145) AT=1720.05n

.meas tran vdout1_146ck1710 FIND v(dout1_146) AT=1720.05n

.meas tran vdout1_147ck1710 FIND v(dout1_147) AT=1720.05n

.meas tran vdout1_148ck1710 FIND v(dout1_148) AT=1720.05n

.meas tran vdout1_149ck1710 FIND v(dout1_149) AT=1720.05n

.meas tran vdout1_150ck1710 FIND v(dout1_150) AT=1720.05n

.meas tran vdout1_151ck1710 FIND v(dout1_151) AT=1720.05n

.meas tran vdout1_152ck1710 FIND v(dout1_152) AT=1720.05n

.meas tran vdout1_153ck1710 FIND v(dout1_153) AT=1720.05n

.meas tran vdout1_154ck1710 FIND v(dout1_154) AT=1720.05n

.meas tran vdout1_155ck1710 FIND v(dout1_155) AT=1720.05n

.meas tran vdout1_156ck1710 FIND v(dout1_156) AT=1720.05n

.meas tran vdout1_157ck1710 FIND v(dout1_157) AT=1720.05n

.meas tran vdout1_158ck1710 FIND v(dout1_158) AT=1720.05n

.meas tran vdout1_159ck1710 FIND v(dout1_159) AT=1720.05n

.meas tran vdout1_160ck1710 FIND v(dout1_160) AT=1720.05n

.meas tran vdout1_161ck1710 FIND v(dout1_161) AT=1720.05n

.meas tran vdout1_162ck1710 FIND v(dout1_162) AT=1720.05n

.meas tran vdout1_163ck1710 FIND v(dout1_163) AT=1720.05n

.meas tran vdout1_164ck1710 FIND v(dout1_164) AT=1720.05n

.meas tran vdout1_165ck1710 FIND v(dout1_165) AT=1720.05n

.meas tran vdout1_166ck1710 FIND v(dout1_166) AT=1720.05n

.meas tran vdout1_167ck1710 FIND v(dout1_167) AT=1720.05n

.meas tran vdout1_168ck1710 FIND v(dout1_168) AT=1720.05n

.meas tran vdout1_169ck1710 FIND v(dout1_169) AT=1720.05n

.meas tran vdout1_170ck1710 FIND v(dout1_170) AT=1720.05n

.meas tran vdout1_171ck1710 FIND v(dout1_171) AT=1720.05n

.meas tran vdout1_172ck1710 FIND v(dout1_172) AT=1720.05n

.meas tran vdout1_173ck1710 FIND v(dout1_173) AT=1720.05n

.meas tran vdout1_174ck1710 FIND v(dout1_174) AT=1720.05n

.meas tran vdout1_175ck1710 FIND v(dout1_175) AT=1720.05n

.meas tran vdout1_176ck1710 FIND v(dout1_176) AT=1720.05n

.meas tran vdout1_177ck1710 FIND v(dout1_177) AT=1720.05n

.meas tran vdout1_178ck1710 FIND v(dout1_178) AT=1720.05n

.meas tran vdout1_179ck1710 FIND v(dout1_179) AT=1720.05n

.meas tran vdout1_180ck1710 FIND v(dout1_180) AT=1720.05n

.meas tran vdout1_181ck1710 FIND v(dout1_181) AT=1720.05n

.meas tran vdout1_182ck1710 FIND v(dout1_182) AT=1720.05n

.meas tran vdout1_183ck1710 FIND v(dout1_183) AT=1720.05n

.meas tran vdout1_184ck1710 FIND v(dout1_184) AT=1720.05n

.meas tran vdout1_185ck1710 FIND v(dout1_185) AT=1720.05n

.meas tran vdout1_186ck1710 FIND v(dout1_186) AT=1720.05n

.meas tran vdout1_187ck1710 FIND v(dout1_187) AT=1720.05n

.meas tran vdout1_188ck1710 FIND v(dout1_188) AT=1720.05n

.meas tran vdout1_189ck1710 FIND v(dout1_189) AT=1720.05n

.meas tran vdout1_190ck1710 FIND v(dout1_190) AT=1720.05n

.meas tran vdout1_191ck1710 FIND v(dout1_191) AT=1720.05n

.meas tran vdout1_192ck1710 FIND v(dout1_192) AT=1720.05n

.meas tran vdout1_193ck1710 FIND v(dout1_193) AT=1720.05n

.meas tran vdout1_194ck1710 FIND v(dout1_194) AT=1720.05n

.meas tran vdout1_195ck1710 FIND v(dout1_195) AT=1720.05n

.meas tran vdout1_196ck1710 FIND v(dout1_196) AT=1720.05n

.meas tran vdout1_197ck1710 FIND v(dout1_197) AT=1720.05n

.meas tran vdout1_198ck1710 FIND v(dout1_198) AT=1720.05n

.meas tran vdout1_199ck1710 FIND v(dout1_199) AT=1720.05n

.meas tran vdout1_200ck1710 FIND v(dout1_200) AT=1720.05n

.meas tran vdout1_201ck1710 FIND v(dout1_201) AT=1720.05n

.meas tran vdout1_202ck1710 FIND v(dout1_202) AT=1720.05n

.meas tran vdout1_203ck1710 FIND v(dout1_203) AT=1720.05n

.meas tran vdout1_204ck1710 FIND v(dout1_204) AT=1720.05n

.meas tran vdout1_205ck1710 FIND v(dout1_205) AT=1720.05n

.meas tran vdout1_206ck1710 FIND v(dout1_206) AT=1720.05n

.meas tran vdout1_207ck1710 FIND v(dout1_207) AT=1720.05n

.meas tran vdout1_208ck1710 FIND v(dout1_208) AT=1720.05n

.meas tran vdout1_209ck1710 FIND v(dout1_209) AT=1720.05n

.meas tran vdout1_210ck1710 FIND v(dout1_210) AT=1720.05n

.meas tran vdout1_211ck1710 FIND v(dout1_211) AT=1720.05n

.meas tran vdout1_212ck1710 FIND v(dout1_212) AT=1720.05n

.meas tran vdout1_213ck1710 FIND v(dout1_213) AT=1720.05n

.meas tran vdout1_214ck1710 FIND v(dout1_214) AT=1720.05n

.meas tran vdout1_215ck1710 FIND v(dout1_215) AT=1720.05n

.meas tran vdout1_216ck1710 FIND v(dout1_216) AT=1720.05n

.meas tran vdout1_217ck1710 FIND v(dout1_217) AT=1720.05n

.meas tran vdout1_218ck1710 FIND v(dout1_218) AT=1720.05n

.meas tran vdout1_219ck1710 FIND v(dout1_219) AT=1720.05n

.meas tran vdout1_220ck1710 FIND v(dout1_220) AT=1720.05n

.meas tran vdout1_221ck1710 FIND v(dout1_221) AT=1720.05n

.meas tran vdout1_222ck1710 FIND v(dout1_222) AT=1720.05n

.meas tran vdout1_223ck1710 FIND v(dout1_223) AT=1720.05n

.meas tran vdout1_224ck1710 FIND v(dout1_224) AT=1720.05n

.meas tran vdout1_225ck1710 FIND v(dout1_225) AT=1720.05n

.meas tran vdout1_226ck1710 FIND v(dout1_226) AT=1720.05n

.meas tran vdout1_227ck1710 FIND v(dout1_227) AT=1720.05n

.meas tran vdout1_228ck1710 FIND v(dout1_228) AT=1720.05n

.meas tran vdout1_229ck1710 FIND v(dout1_229) AT=1720.05n

.meas tran vdout1_230ck1710 FIND v(dout1_230) AT=1720.05n

.meas tran vdout1_231ck1710 FIND v(dout1_231) AT=1720.05n

.meas tran vdout1_232ck1710 FIND v(dout1_232) AT=1720.05n

.meas tran vdout1_233ck1710 FIND v(dout1_233) AT=1720.05n

.meas tran vdout1_234ck1710 FIND v(dout1_234) AT=1720.05n

.meas tran vdout1_235ck1710 FIND v(dout1_235) AT=1720.05n

.meas tran vdout1_236ck1710 FIND v(dout1_236) AT=1720.05n

.meas tran vdout1_237ck1710 FIND v(dout1_237) AT=1720.05n

.meas tran vdout1_238ck1710 FIND v(dout1_238) AT=1720.05n

.meas tran vdout1_239ck1710 FIND v(dout1_239) AT=1720.05n

.meas tran vdout1_240ck1710 FIND v(dout1_240) AT=1720.05n

.meas tran vdout1_241ck1710 FIND v(dout1_241) AT=1720.05n

.meas tran vdout1_242ck1710 FIND v(dout1_242) AT=1720.05n

.meas tran vdout1_243ck1710 FIND v(dout1_243) AT=1720.05n

.meas tran vdout1_244ck1710 FIND v(dout1_244) AT=1720.05n

.meas tran vdout1_245ck1710 FIND v(dout1_245) AT=1720.05n

.meas tran vdout1_246ck1710 FIND v(dout1_246) AT=1720.05n

.meas tran vdout1_247ck1710 FIND v(dout1_247) AT=1720.05n

.meas tran vdout1_248ck1710 FIND v(dout1_248) AT=1720.05n

.meas tran vdout1_249ck1710 FIND v(dout1_249) AT=1720.05n

.meas tran vdout1_250ck1710 FIND v(dout1_250) AT=1720.05n

.meas tran vdout1_251ck1710 FIND v(dout1_251) AT=1720.05n

.meas tran vdout1_252ck1710 FIND v(dout1_252) AT=1720.05n

.meas tran vdout1_253ck1710 FIND v(dout1_253) AT=1720.05n

.meas tran vdout1_254ck1710 FIND v(dout1_254) AT=1720.05n

.meas tran vdout1_255ck1710 FIND v(dout1_255) AT=1720.05n

.meas tran vdout1_256ck1710 FIND v(dout1_256) AT=1720.05n

.meas tran vdout1_0ck1740 FIND v(dout1_0) AT=1750.05n

.meas tran vdout1_1ck1740 FIND v(dout1_1) AT=1750.05n

.meas tran vdout1_2ck1740 FIND v(dout1_2) AT=1750.05n

.meas tran vdout1_3ck1740 FIND v(dout1_3) AT=1750.05n

.meas tran vdout1_4ck1740 FIND v(dout1_4) AT=1750.05n

.meas tran vdout1_5ck1740 FIND v(dout1_5) AT=1750.05n

.meas tran vdout1_6ck1740 FIND v(dout1_6) AT=1750.05n

.meas tran vdout1_7ck1740 FIND v(dout1_7) AT=1750.05n

.meas tran vdout1_8ck1740 FIND v(dout1_8) AT=1750.05n

.meas tran vdout1_9ck1740 FIND v(dout1_9) AT=1750.05n

.meas tran vdout1_10ck1740 FIND v(dout1_10) AT=1750.05n

.meas tran vdout1_11ck1740 FIND v(dout1_11) AT=1750.05n

.meas tran vdout1_12ck1740 FIND v(dout1_12) AT=1750.05n

.meas tran vdout1_13ck1740 FIND v(dout1_13) AT=1750.05n

.meas tran vdout1_14ck1740 FIND v(dout1_14) AT=1750.05n

.meas tran vdout1_15ck1740 FIND v(dout1_15) AT=1750.05n

.meas tran vdout1_16ck1740 FIND v(dout1_16) AT=1750.05n

.meas tran vdout1_17ck1740 FIND v(dout1_17) AT=1750.05n

.meas tran vdout1_18ck1740 FIND v(dout1_18) AT=1750.05n

.meas tran vdout1_19ck1740 FIND v(dout1_19) AT=1750.05n

.meas tran vdout1_20ck1740 FIND v(dout1_20) AT=1750.05n

.meas tran vdout1_21ck1740 FIND v(dout1_21) AT=1750.05n

.meas tran vdout1_22ck1740 FIND v(dout1_22) AT=1750.05n

.meas tran vdout1_23ck1740 FIND v(dout1_23) AT=1750.05n

.meas tran vdout1_24ck1740 FIND v(dout1_24) AT=1750.05n

.meas tran vdout1_25ck1740 FIND v(dout1_25) AT=1750.05n

.meas tran vdout1_26ck1740 FIND v(dout1_26) AT=1750.05n

.meas tran vdout1_27ck1740 FIND v(dout1_27) AT=1750.05n

.meas tran vdout1_28ck1740 FIND v(dout1_28) AT=1750.05n

.meas tran vdout1_29ck1740 FIND v(dout1_29) AT=1750.05n

.meas tran vdout1_30ck1740 FIND v(dout1_30) AT=1750.05n

.meas tran vdout1_31ck1740 FIND v(dout1_31) AT=1750.05n

.meas tran vdout1_32ck1740 FIND v(dout1_32) AT=1750.05n

.meas tran vdout1_33ck1740 FIND v(dout1_33) AT=1750.05n

.meas tran vdout1_34ck1740 FIND v(dout1_34) AT=1750.05n

.meas tran vdout1_35ck1740 FIND v(dout1_35) AT=1750.05n

.meas tran vdout1_36ck1740 FIND v(dout1_36) AT=1750.05n

.meas tran vdout1_37ck1740 FIND v(dout1_37) AT=1750.05n

.meas tran vdout1_38ck1740 FIND v(dout1_38) AT=1750.05n

.meas tran vdout1_39ck1740 FIND v(dout1_39) AT=1750.05n

.meas tran vdout1_40ck1740 FIND v(dout1_40) AT=1750.05n

.meas tran vdout1_41ck1740 FIND v(dout1_41) AT=1750.05n

.meas tran vdout1_42ck1740 FIND v(dout1_42) AT=1750.05n

.meas tran vdout1_43ck1740 FIND v(dout1_43) AT=1750.05n

.meas tran vdout1_44ck1740 FIND v(dout1_44) AT=1750.05n

.meas tran vdout1_45ck1740 FIND v(dout1_45) AT=1750.05n

.meas tran vdout1_46ck1740 FIND v(dout1_46) AT=1750.05n

.meas tran vdout1_47ck1740 FIND v(dout1_47) AT=1750.05n

.meas tran vdout1_48ck1740 FIND v(dout1_48) AT=1750.05n

.meas tran vdout1_49ck1740 FIND v(dout1_49) AT=1750.05n

.meas tran vdout1_50ck1740 FIND v(dout1_50) AT=1750.05n

.meas tran vdout1_51ck1740 FIND v(dout1_51) AT=1750.05n

.meas tran vdout1_52ck1740 FIND v(dout1_52) AT=1750.05n

.meas tran vdout1_53ck1740 FIND v(dout1_53) AT=1750.05n

.meas tran vdout1_54ck1740 FIND v(dout1_54) AT=1750.05n

.meas tran vdout1_55ck1740 FIND v(dout1_55) AT=1750.05n

.meas tran vdout1_56ck1740 FIND v(dout1_56) AT=1750.05n

.meas tran vdout1_57ck1740 FIND v(dout1_57) AT=1750.05n

.meas tran vdout1_58ck1740 FIND v(dout1_58) AT=1750.05n

.meas tran vdout1_59ck1740 FIND v(dout1_59) AT=1750.05n

.meas tran vdout1_60ck1740 FIND v(dout1_60) AT=1750.05n

.meas tran vdout1_61ck1740 FIND v(dout1_61) AT=1750.05n

.meas tran vdout1_62ck1740 FIND v(dout1_62) AT=1750.05n

.meas tran vdout1_63ck1740 FIND v(dout1_63) AT=1750.05n

.meas tran vdout1_64ck1740 FIND v(dout1_64) AT=1750.05n

.meas tran vdout1_65ck1740 FIND v(dout1_65) AT=1750.05n

.meas tran vdout1_66ck1740 FIND v(dout1_66) AT=1750.05n

.meas tran vdout1_67ck1740 FIND v(dout1_67) AT=1750.05n

.meas tran vdout1_68ck1740 FIND v(dout1_68) AT=1750.05n

.meas tran vdout1_69ck1740 FIND v(dout1_69) AT=1750.05n

.meas tran vdout1_70ck1740 FIND v(dout1_70) AT=1750.05n

.meas tran vdout1_71ck1740 FIND v(dout1_71) AT=1750.05n

.meas tran vdout1_72ck1740 FIND v(dout1_72) AT=1750.05n

.meas tran vdout1_73ck1740 FIND v(dout1_73) AT=1750.05n

.meas tran vdout1_74ck1740 FIND v(dout1_74) AT=1750.05n

.meas tran vdout1_75ck1740 FIND v(dout1_75) AT=1750.05n

.meas tran vdout1_76ck1740 FIND v(dout1_76) AT=1750.05n

.meas tran vdout1_77ck1740 FIND v(dout1_77) AT=1750.05n

.meas tran vdout1_78ck1740 FIND v(dout1_78) AT=1750.05n

.meas tran vdout1_79ck1740 FIND v(dout1_79) AT=1750.05n

.meas tran vdout1_80ck1740 FIND v(dout1_80) AT=1750.05n

.meas tran vdout1_81ck1740 FIND v(dout1_81) AT=1750.05n

.meas tran vdout1_82ck1740 FIND v(dout1_82) AT=1750.05n

.meas tran vdout1_83ck1740 FIND v(dout1_83) AT=1750.05n

.meas tran vdout1_84ck1740 FIND v(dout1_84) AT=1750.05n

.meas tran vdout1_85ck1740 FIND v(dout1_85) AT=1750.05n

.meas tran vdout1_86ck1740 FIND v(dout1_86) AT=1750.05n

.meas tran vdout1_87ck1740 FIND v(dout1_87) AT=1750.05n

.meas tran vdout1_88ck1740 FIND v(dout1_88) AT=1750.05n

.meas tran vdout1_89ck1740 FIND v(dout1_89) AT=1750.05n

.meas tran vdout1_90ck1740 FIND v(dout1_90) AT=1750.05n

.meas tran vdout1_91ck1740 FIND v(dout1_91) AT=1750.05n

.meas tran vdout1_92ck1740 FIND v(dout1_92) AT=1750.05n

.meas tran vdout1_93ck1740 FIND v(dout1_93) AT=1750.05n

.meas tran vdout1_94ck1740 FIND v(dout1_94) AT=1750.05n

.meas tran vdout1_95ck1740 FIND v(dout1_95) AT=1750.05n

.meas tran vdout1_96ck1740 FIND v(dout1_96) AT=1750.05n

.meas tran vdout1_97ck1740 FIND v(dout1_97) AT=1750.05n

.meas tran vdout1_98ck1740 FIND v(dout1_98) AT=1750.05n

.meas tran vdout1_99ck1740 FIND v(dout1_99) AT=1750.05n

.meas tran vdout1_100ck1740 FIND v(dout1_100) AT=1750.05n

.meas tran vdout1_101ck1740 FIND v(dout1_101) AT=1750.05n

.meas tran vdout1_102ck1740 FIND v(dout1_102) AT=1750.05n

.meas tran vdout1_103ck1740 FIND v(dout1_103) AT=1750.05n

.meas tran vdout1_104ck1740 FIND v(dout1_104) AT=1750.05n

.meas tran vdout1_105ck1740 FIND v(dout1_105) AT=1750.05n

.meas tran vdout1_106ck1740 FIND v(dout1_106) AT=1750.05n

.meas tran vdout1_107ck1740 FIND v(dout1_107) AT=1750.05n

.meas tran vdout1_108ck1740 FIND v(dout1_108) AT=1750.05n

.meas tran vdout1_109ck1740 FIND v(dout1_109) AT=1750.05n

.meas tran vdout1_110ck1740 FIND v(dout1_110) AT=1750.05n

.meas tran vdout1_111ck1740 FIND v(dout1_111) AT=1750.05n

.meas tran vdout1_112ck1740 FIND v(dout1_112) AT=1750.05n

.meas tran vdout1_113ck1740 FIND v(dout1_113) AT=1750.05n

.meas tran vdout1_114ck1740 FIND v(dout1_114) AT=1750.05n

.meas tran vdout1_115ck1740 FIND v(dout1_115) AT=1750.05n

.meas tran vdout1_116ck1740 FIND v(dout1_116) AT=1750.05n

.meas tran vdout1_117ck1740 FIND v(dout1_117) AT=1750.05n

.meas tran vdout1_118ck1740 FIND v(dout1_118) AT=1750.05n

.meas tran vdout1_119ck1740 FIND v(dout1_119) AT=1750.05n

.meas tran vdout1_120ck1740 FIND v(dout1_120) AT=1750.05n

.meas tran vdout1_121ck1740 FIND v(dout1_121) AT=1750.05n

.meas tran vdout1_122ck1740 FIND v(dout1_122) AT=1750.05n

.meas tran vdout1_123ck1740 FIND v(dout1_123) AT=1750.05n

.meas tran vdout1_124ck1740 FIND v(dout1_124) AT=1750.05n

.meas tran vdout1_125ck1740 FIND v(dout1_125) AT=1750.05n

.meas tran vdout1_126ck1740 FIND v(dout1_126) AT=1750.05n

.meas tran vdout1_127ck1740 FIND v(dout1_127) AT=1750.05n

.meas tran vdout1_128ck1740 FIND v(dout1_128) AT=1750.05n

.meas tran vdout1_129ck1740 FIND v(dout1_129) AT=1750.05n

.meas tran vdout1_130ck1740 FIND v(dout1_130) AT=1750.05n

.meas tran vdout1_131ck1740 FIND v(dout1_131) AT=1750.05n

.meas tran vdout1_132ck1740 FIND v(dout1_132) AT=1750.05n

.meas tran vdout1_133ck1740 FIND v(dout1_133) AT=1750.05n

.meas tran vdout1_134ck1740 FIND v(dout1_134) AT=1750.05n

.meas tran vdout1_135ck1740 FIND v(dout1_135) AT=1750.05n

.meas tran vdout1_136ck1740 FIND v(dout1_136) AT=1750.05n

.meas tran vdout1_137ck1740 FIND v(dout1_137) AT=1750.05n

.meas tran vdout1_138ck1740 FIND v(dout1_138) AT=1750.05n

.meas tran vdout1_139ck1740 FIND v(dout1_139) AT=1750.05n

.meas tran vdout1_140ck1740 FIND v(dout1_140) AT=1750.05n

.meas tran vdout1_141ck1740 FIND v(dout1_141) AT=1750.05n

.meas tran vdout1_142ck1740 FIND v(dout1_142) AT=1750.05n

.meas tran vdout1_143ck1740 FIND v(dout1_143) AT=1750.05n

.meas tran vdout1_144ck1740 FIND v(dout1_144) AT=1750.05n

.meas tran vdout1_145ck1740 FIND v(dout1_145) AT=1750.05n

.meas tran vdout1_146ck1740 FIND v(dout1_146) AT=1750.05n

.meas tran vdout1_147ck1740 FIND v(dout1_147) AT=1750.05n

.meas tran vdout1_148ck1740 FIND v(dout1_148) AT=1750.05n

.meas tran vdout1_149ck1740 FIND v(dout1_149) AT=1750.05n

.meas tran vdout1_150ck1740 FIND v(dout1_150) AT=1750.05n

.meas tran vdout1_151ck1740 FIND v(dout1_151) AT=1750.05n

.meas tran vdout1_152ck1740 FIND v(dout1_152) AT=1750.05n

.meas tran vdout1_153ck1740 FIND v(dout1_153) AT=1750.05n

.meas tran vdout1_154ck1740 FIND v(dout1_154) AT=1750.05n

.meas tran vdout1_155ck1740 FIND v(dout1_155) AT=1750.05n

.meas tran vdout1_156ck1740 FIND v(dout1_156) AT=1750.05n

.meas tran vdout1_157ck1740 FIND v(dout1_157) AT=1750.05n

.meas tran vdout1_158ck1740 FIND v(dout1_158) AT=1750.05n

.meas tran vdout1_159ck1740 FIND v(dout1_159) AT=1750.05n

.meas tran vdout1_160ck1740 FIND v(dout1_160) AT=1750.05n

.meas tran vdout1_161ck1740 FIND v(dout1_161) AT=1750.05n

.meas tran vdout1_162ck1740 FIND v(dout1_162) AT=1750.05n

.meas tran vdout1_163ck1740 FIND v(dout1_163) AT=1750.05n

.meas tran vdout1_164ck1740 FIND v(dout1_164) AT=1750.05n

.meas tran vdout1_165ck1740 FIND v(dout1_165) AT=1750.05n

.meas tran vdout1_166ck1740 FIND v(dout1_166) AT=1750.05n

.meas tran vdout1_167ck1740 FIND v(dout1_167) AT=1750.05n

.meas tran vdout1_168ck1740 FIND v(dout1_168) AT=1750.05n

.meas tran vdout1_169ck1740 FIND v(dout1_169) AT=1750.05n

.meas tran vdout1_170ck1740 FIND v(dout1_170) AT=1750.05n

.meas tran vdout1_171ck1740 FIND v(dout1_171) AT=1750.05n

.meas tran vdout1_172ck1740 FIND v(dout1_172) AT=1750.05n

.meas tran vdout1_173ck1740 FIND v(dout1_173) AT=1750.05n

.meas tran vdout1_174ck1740 FIND v(dout1_174) AT=1750.05n

.meas tran vdout1_175ck1740 FIND v(dout1_175) AT=1750.05n

.meas tran vdout1_176ck1740 FIND v(dout1_176) AT=1750.05n

.meas tran vdout1_177ck1740 FIND v(dout1_177) AT=1750.05n

.meas tran vdout1_178ck1740 FIND v(dout1_178) AT=1750.05n

.meas tran vdout1_179ck1740 FIND v(dout1_179) AT=1750.05n

.meas tran vdout1_180ck1740 FIND v(dout1_180) AT=1750.05n

.meas tran vdout1_181ck1740 FIND v(dout1_181) AT=1750.05n

.meas tran vdout1_182ck1740 FIND v(dout1_182) AT=1750.05n

.meas tran vdout1_183ck1740 FIND v(dout1_183) AT=1750.05n

.meas tran vdout1_184ck1740 FIND v(dout1_184) AT=1750.05n

.meas tran vdout1_185ck1740 FIND v(dout1_185) AT=1750.05n

.meas tran vdout1_186ck1740 FIND v(dout1_186) AT=1750.05n

.meas tran vdout1_187ck1740 FIND v(dout1_187) AT=1750.05n

.meas tran vdout1_188ck1740 FIND v(dout1_188) AT=1750.05n

.meas tran vdout1_189ck1740 FIND v(dout1_189) AT=1750.05n

.meas tran vdout1_190ck1740 FIND v(dout1_190) AT=1750.05n

.meas tran vdout1_191ck1740 FIND v(dout1_191) AT=1750.05n

.meas tran vdout1_192ck1740 FIND v(dout1_192) AT=1750.05n

.meas tran vdout1_193ck1740 FIND v(dout1_193) AT=1750.05n

.meas tran vdout1_194ck1740 FIND v(dout1_194) AT=1750.05n

.meas tran vdout1_195ck1740 FIND v(dout1_195) AT=1750.05n

.meas tran vdout1_196ck1740 FIND v(dout1_196) AT=1750.05n

.meas tran vdout1_197ck1740 FIND v(dout1_197) AT=1750.05n

.meas tran vdout1_198ck1740 FIND v(dout1_198) AT=1750.05n

.meas tran vdout1_199ck1740 FIND v(dout1_199) AT=1750.05n

.meas tran vdout1_200ck1740 FIND v(dout1_200) AT=1750.05n

.meas tran vdout1_201ck1740 FIND v(dout1_201) AT=1750.05n

.meas tran vdout1_202ck1740 FIND v(dout1_202) AT=1750.05n

.meas tran vdout1_203ck1740 FIND v(dout1_203) AT=1750.05n

.meas tran vdout1_204ck1740 FIND v(dout1_204) AT=1750.05n

.meas tran vdout1_205ck1740 FIND v(dout1_205) AT=1750.05n

.meas tran vdout1_206ck1740 FIND v(dout1_206) AT=1750.05n

.meas tran vdout1_207ck1740 FIND v(dout1_207) AT=1750.05n

.meas tran vdout1_208ck1740 FIND v(dout1_208) AT=1750.05n

.meas tran vdout1_209ck1740 FIND v(dout1_209) AT=1750.05n

.meas tran vdout1_210ck1740 FIND v(dout1_210) AT=1750.05n

.meas tran vdout1_211ck1740 FIND v(dout1_211) AT=1750.05n

.meas tran vdout1_212ck1740 FIND v(dout1_212) AT=1750.05n

.meas tran vdout1_213ck1740 FIND v(dout1_213) AT=1750.05n

.meas tran vdout1_214ck1740 FIND v(dout1_214) AT=1750.05n

.meas tran vdout1_215ck1740 FIND v(dout1_215) AT=1750.05n

.meas tran vdout1_216ck1740 FIND v(dout1_216) AT=1750.05n

.meas tran vdout1_217ck1740 FIND v(dout1_217) AT=1750.05n

.meas tran vdout1_218ck1740 FIND v(dout1_218) AT=1750.05n

.meas tran vdout1_219ck1740 FIND v(dout1_219) AT=1750.05n

.meas tran vdout1_220ck1740 FIND v(dout1_220) AT=1750.05n

.meas tran vdout1_221ck1740 FIND v(dout1_221) AT=1750.05n

.meas tran vdout1_222ck1740 FIND v(dout1_222) AT=1750.05n

.meas tran vdout1_223ck1740 FIND v(dout1_223) AT=1750.05n

.meas tran vdout1_224ck1740 FIND v(dout1_224) AT=1750.05n

.meas tran vdout1_225ck1740 FIND v(dout1_225) AT=1750.05n

.meas tran vdout1_226ck1740 FIND v(dout1_226) AT=1750.05n

.meas tran vdout1_227ck1740 FIND v(dout1_227) AT=1750.05n

.meas tran vdout1_228ck1740 FIND v(dout1_228) AT=1750.05n

.meas tran vdout1_229ck1740 FIND v(dout1_229) AT=1750.05n

.meas tran vdout1_230ck1740 FIND v(dout1_230) AT=1750.05n

.meas tran vdout1_231ck1740 FIND v(dout1_231) AT=1750.05n

.meas tran vdout1_232ck1740 FIND v(dout1_232) AT=1750.05n

.meas tran vdout1_233ck1740 FIND v(dout1_233) AT=1750.05n

.meas tran vdout1_234ck1740 FIND v(dout1_234) AT=1750.05n

.meas tran vdout1_235ck1740 FIND v(dout1_235) AT=1750.05n

.meas tran vdout1_236ck1740 FIND v(dout1_236) AT=1750.05n

.meas tran vdout1_237ck1740 FIND v(dout1_237) AT=1750.05n

.meas tran vdout1_238ck1740 FIND v(dout1_238) AT=1750.05n

.meas tran vdout1_239ck1740 FIND v(dout1_239) AT=1750.05n

.meas tran vdout1_240ck1740 FIND v(dout1_240) AT=1750.05n

.meas tran vdout1_241ck1740 FIND v(dout1_241) AT=1750.05n

.meas tran vdout1_242ck1740 FIND v(dout1_242) AT=1750.05n

.meas tran vdout1_243ck1740 FIND v(dout1_243) AT=1750.05n

.meas tran vdout1_244ck1740 FIND v(dout1_244) AT=1750.05n

.meas tran vdout1_245ck1740 FIND v(dout1_245) AT=1750.05n

.meas tran vdout1_246ck1740 FIND v(dout1_246) AT=1750.05n

.meas tran vdout1_247ck1740 FIND v(dout1_247) AT=1750.05n

.meas tran vdout1_248ck1740 FIND v(dout1_248) AT=1750.05n

.meas tran vdout1_249ck1740 FIND v(dout1_249) AT=1750.05n

.meas tran vdout1_250ck1740 FIND v(dout1_250) AT=1750.05n

.meas tran vdout1_251ck1740 FIND v(dout1_251) AT=1750.05n

.meas tran vdout1_252ck1740 FIND v(dout1_252) AT=1750.05n

.meas tran vdout1_253ck1740 FIND v(dout1_253) AT=1750.05n

.meas tran vdout1_254ck1740 FIND v(dout1_254) AT=1750.05n

.meas tran vdout1_255ck1740 FIND v(dout1_255) AT=1750.05n

.meas tran vdout1_256ck1740 FIND v(dout1_256) AT=1750.05n

.meas tran vdout1_0ck1760 FIND v(dout1_0) AT=1770.05n

.meas tran vdout1_1ck1760 FIND v(dout1_1) AT=1770.05n

.meas tran vdout1_2ck1760 FIND v(dout1_2) AT=1770.05n

.meas tran vdout1_3ck1760 FIND v(dout1_3) AT=1770.05n

.meas tran vdout1_4ck1760 FIND v(dout1_4) AT=1770.05n

.meas tran vdout1_5ck1760 FIND v(dout1_5) AT=1770.05n

.meas tran vdout1_6ck1760 FIND v(dout1_6) AT=1770.05n

.meas tran vdout1_7ck1760 FIND v(dout1_7) AT=1770.05n

.meas tran vdout1_8ck1760 FIND v(dout1_8) AT=1770.05n

.meas tran vdout1_9ck1760 FIND v(dout1_9) AT=1770.05n

.meas tran vdout1_10ck1760 FIND v(dout1_10) AT=1770.05n

.meas tran vdout1_11ck1760 FIND v(dout1_11) AT=1770.05n

.meas tran vdout1_12ck1760 FIND v(dout1_12) AT=1770.05n

.meas tran vdout1_13ck1760 FIND v(dout1_13) AT=1770.05n

.meas tran vdout1_14ck1760 FIND v(dout1_14) AT=1770.05n

.meas tran vdout1_15ck1760 FIND v(dout1_15) AT=1770.05n

.meas tran vdout1_16ck1760 FIND v(dout1_16) AT=1770.05n

.meas tran vdout1_17ck1760 FIND v(dout1_17) AT=1770.05n

.meas tran vdout1_18ck1760 FIND v(dout1_18) AT=1770.05n

.meas tran vdout1_19ck1760 FIND v(dout1_19) AT=1770.05n

.meas tran vdout1_20ck1760 FIND v(dout1_20) AT=1770.05n

.meas tran vdout1_21ck1760 FIND v(dout1_21) AT=1770.05n

.meas tran vdout1_22ck1760 FIND v(dout1_22) AT=1770.05n

.meas tran vdout1_23ck1760 FIND v(dout1_23) AT=1770.05n

.meas tran vdout1_24ck1760 FIND v(dout1_24) AT=1770.05n

.meas tran vdout1_25ck1760 FIND v(dout1_25) AT=1770.05n

.meas tran vdout1_26ck1760 FIND v(dout1_26) AT=1770.05n

.meas tran vdout1_27ck1760 FIND v(dout1_27) AT=1770.05n

.meas tran vdout1_28ck1760 FIND v(dout1_28) AT=1770.05n

.meas tran vdout1_29ck1760 FIND v(dout1_29) AT=1770.05n

.meas tran vdout1_30ck1760 FIND v(dout1_30) AT=1770.05n

.meas tran vdout1_31ck1760 FIND v(dout1_31) AT=1770.05n

.meas tran vdout1_32ck1760 FIND v(dout1_32) AT=1770.05n

.meas tran vdout1_33ck1760 FIND v(dout1_33) AT=1770.05n

.meas tran vdout1_34ck1760 FIND v(dout1_34) AT=1770.05n

.meas tran vdout1_35ck1760 FIND v(dout1_35) AT=1770.05n

.meas tran vdout1_36ck1760 FIND v(dout1_36) AT=1770.05n

.meas tran vdout1_37ck1760 FIND v(dout1_37) AT=1770.05n

.meas tran vdout1_38ck1760 FIND v(dout1_38) AT=1770.05n

.meas tran vdout1_39ck1760 FIND v(dout1_39) AT=1770.05n

.meas tran vdout1_40ck1760 FIND v(dout1_40) AT=1770.05n

.meas tran vdout1_41ck1760 FIND v(dout1_41) AT=1770.05n

.meas tran vdout1_42ck1760 FIND v(dout1_42) AT=1770.05n

.meas tran vdout1_43ck1760 FIND v(dout1_43) AT=1770.05n

.meas tran vdout1_44ck1760 FIND v(dout1_44) AT=1770.05n

.meas tran vdout1_45ck1760 FIND v(dout1_45) AT=1770.05n

.meas tran vdout1_46ck1760 FIND v(dout1_46) AT=1770.05n

.meas tran vdout1_47ck1760 FIND v(dout1_47) AT=1770.05n

.meas tran vdout1_48ck1760 FIND v(dout1_48) AT=1770.05n

.meas tran vdout1_49ck1760 FIND v(dout1_49) AT=1770.05n

.meas tran vdout1_50ck1760 FIND v(dout1_50) AT=1770.05n

.meas tran vdout1_51ck1760 FIND v(dout1_51) AT=1770.05n

.meas tran vdout1_52ck1760 FIND v(dout1_52) AT=1770.05n

.meas tran vdout1_53ck1760 FIND v(dout1_53) AT=1770.05n

.meas tran vdout1_54ck1760 FIND v(dout1_54) AT=1770.05n

.meas tran vdout1_55ck1760 FIND v(dout1_55) AT=1770.05n

.meas tran vdout1_56ck1760 FIND v(dout1_56) AT=1770.05n

.meas tran vdout1_57ck1760 FIND v(dout1_57) AT=1770.05n

.meas tran vdout1_58ck1760 FIND v(dout1_58) AT=1770.05n

.meas tran vdout1_59ck1760 FIND v(dout1_59) AT=1770.05n

.meas tran vdout1_60ck1760 FIND v(dout1_60) AT=1770.05n

.meas tran vdout1_61ck1760 FIND v(dout1_61) AT=1770.05n

.meas tran vdout1_62ck1760 FIND v(dout1_62) AT=1770.05n

.meas tran vdout1_63ck1760 FIND v(dout1_63) AT=1770.05n

.meas tran vdout1_64ck1760 FIND v(dout1_64) AT=1770.05n

.meas tran vdout1_65ck1760 FIND v(dout1_65) AT=1770.05n

.meas tran vdout1_66ck1760 FIND v(dout1_66) AT=1770.05n

.meas tran vdout1_67ck1760 FIND v(dout1_67) AT=1770.05n

.meas tran vdout1_68ck1760 FIND v(dout1_68) AT=1770.05n

.meas tran vdout1_69ck1760 FIND v(dout1_69) AT=1770.05n

.meas tran vdout1_70ck1760 FIND v(dout1_70) AT=1770.05n

.meas tran vdout1_71ck1760 FIND v(dout1_71) AT=1770.05n

.meas tran vdout1_72ck1760 FIND v(dout1_72) AT=1770.05n

.meas tran vdout1_73ck1760 FIND v(dout1_73) AT=1770.05n

.meas tran vdout1_74ck1760 FIND v(dout1_74) AT=1770.05n

.meas tran vdout1_75ck1760 FIND v(dout1_75) AT=1770.05n

.meas tran vdout1_76ck1760 FIND v(dout1_76) AT=1770.05n

.meas tran vdout1_77ck1760 FIND v(dout1_77) AT=1770.05n

.meas tran vdout1_78ck1760 FIND v(dout1_78) AT=1770.05n

.meas tran vdout1_79ck1760 FIND v(dout1_79) AT=1770.05n

.meas tran vdout1_80ck1760 FIND v(dout1_80) AT=1770.05n

.meas tran vdout1_81ck1760 FIND v(dout1_81) AT=1770.05n

.meas tran vdout1_82ck1760 FIND v(dout1_82) AT=1770.05n

.meas tran vdout1_83ck1760 FIND v(dout1_83) AT=1770.05n

.meas tran vdout1_84ck1760 FIND v(dout1_84) AT=1770.05n

.meas tran vdout1_85ck1760 FIND v(dout1_85) AT=1770.05n

.meas tran vdout1_86ck1760 FIND v(dout1_86) AT=1770.05n

.meas tran vdout1_87ck1760 FIND v(dout1_87) AT=1770.05n

.meas tran vdout1_88ck1760 FIND v(dout1_88) AT=1770.05n

.meas tran vdout1_89ck1760 FIND v(dout1_89) AT=1770.05n

.meas tran vdout1_90ck1760 FIND v(dout1_90) AT=1770.05n

.meas tran vdout1_91ck1760 FIND v(dout1_91) AT=1770.05n

.meas tran vdout1_92ck1760 FIND v(dout1_92) AT=1770.05n

.meas tran vdout1_93ck1760 FIND v(dout1_93) AT=1770.05n

.meas tran vdout1_94ck1760 FIND v(dout1_94) AT=1770.05n

.meas tran vdout1_95ck1760 FIND v(dout1_95) AT=1770.05n

.meas tran vdout1_96ck1760 FIND v(dout1_96) AT=1770.05n

.meas tran vdout1_97ck1760 FIND v(dout1_97) AT=1770.05n

.meas tran vdout1_98ck1760 FIND v(dout1_98) AT=1770.05n

.meas tran vdout1_99ck1760 FIND v(dout1_99) AT=1770.05n

.meas tran vdout1_100ck1760 FIND v(dout1_100) AT=1770.05n

.meas tran vdout1_101ck1760 FIND v(dout1_101) AT=1770.05n

.meas tran vdout1_102ck1760 FIND v(dout1_102) AT=1770.05n

.meas tran vdout1_103ck1760 FIND v(dout1_103) AT=1770.05n

.meas tran vdout1_104ck1760 FIND v(dout1_104) AT=1770.05n

.meas tran vdout1_105ck1760 FIND v(dout1_105) AT=1770.05n

.meas tran vdout1_106ck1760 FIND v(dout1_106) AT=1770.05n

.meas tran vdout1_107ck1760 FIND v(dout1_107) AT=1770.05n

.meas tran vdout1_108ck1760 FIND v(dout1_108) AT=1770.05n

.meas tran vdout1_109ck1760 FIND v(dout1_109) AT=1770.05n

.meas tran vdout1_110ck1760 FIND v(dout1_110) AT=1770.05n

.meas tran vdout1_111ck1760 FIND v(dout1_111) AT=1770.05n

.meas tran vdout1_112ck1760 FIND v(dout1_112) AT=1770.05n

.meas tran vdout1_113ck1760 FIND v(dout1_113) AT=1770.05n

.meas tran vdout1_114ck1760 FIND v(dout1_114) AT=1770.05n

.meas tran vdout1_115ck1760 FIND v(dout1_115) AT=1770.05n

.meas tran vdout1_116ck1760 FIND v(dout1_116) AT=1770.05n

.meas tran vdout1_117ck1760 FIND v(dout1_117) AT=1770.05n

.meas tran vdout1_118ck1760 FIND v(dout1_118) AT=1770.05n

.meas tran vdout1_119ck1760 FIND v(dout1_119) AT=1770.05n

.meas tran vdout1_120ck1760 FIND v(dout1_120) AT=1770.05n

.meas tran vdout1_121ck1760 FIND v(dout1_121) AT=1770.05n

.meas tran vdout1_122ck1760 FIND v(dout1_122) AT=1770.05n

.meas tran vdout1_123ck1760 FIND v(dout1_123) AT=1770.05n

.meas tran vdout1_124ck1760 FIND v(dout1_124) AT=1770.05n

.meas tran vdout1_125ck1760 FIND v(dout1_125) AT=1770.05n

.meas tran vdout1_126ck1760 FIND v(dout1_126) AT=1770.05n

.meas tran vdout1_127ck1760 FIND v(dout1_127) AT=1770.05n

.meas tran vdout1_128ck1760 FIND v(dout1_128) AT=1770.05n

.meas tran vdout1_129ck1760 FIND v(dout1_129) AT=1770.05n

.meas tran vdout1_130ck1760 FIND v(dout1_130) AT=1770.05n

.meas tran vdout1_131ck1760 FIND v(dout1_131) AT=1770.05n

.meas tran vdout1_132ck1760 FIND v(dout1_132) AT=1770.05n

.meas tran vdout1_133ck1760 FIND v(dout1_133) AT=1770.05n

.meas tran vdout1_134ck1760 FIND v(dout1_134) AT=1770.05n

.meas tran vdout1_135ck1760 FIND v(dout1_135) AT=1770.05n

.meas tran vdout1_136ck1760 FIND v(dout1_136) AT=1770.05n

.meas tran vdout1_137ck1760 FIND v(dout1_137) AT=1770.05n

.meas tran vdout1_138ck1760 FIND v(dout1_138) AT=1770.05n

.meas tran vdout1_139ck1760 FIND v(dout1_139) AT=1770.05n

.meas tran vdout1_140ck1760 FIND v(dout1_140) AT=1770.05n

.meas tran vdout1_141ck1760 FIND v(dout1_141) AT=1770.05n

.meas tran vdout1_142ck1760 FIND v(dout1_142) AT=1770.05n

.meas tran vdout1_143ck1760 FIND v(dout1_143) AT=1770.05n

.meas tran vdout1_144ck1760 FIND v(dout1_144) AT=1770.05n

.meas tran vdout1_145ck1760 FIND v(dout1_145) AT=1770.05n

.meas tran vdout1_146ck1760 FIND v(dout1_146) AT=1770.05n

.meas tran vdout1_147ck1760 FIND v(dout1_147) AT=1770.05n

.meas tran vdout1_148ck1760 FIND v(dout1_148) AT=1770.05n

.meas tran vdout1_149ck1760 FIND v(dout1_149) AT=1770.05n

.meas tran vdout1_150ck1760 FIND v(dout1_150) AT=1770.05n

.meas tran vdout1_151ck1760 FIND v(dout1_151) AT=1770.05n

.meas tran vdout1_152ck1760 FIND v(dout1_152) AT=1770.05n

.meas tran vdout1_153ck1760 FIND v(dout1_153) AT=1770.05n

.meas tran vdout1_154ck1760 FIND v(dout1_154) AT=1770.05n

.meas tran vdout1_155ck1760 FIND v(dout1_155) AT=1770.05n

.meas tran vdout1_156ck1760 FIND v(dout1_156) AT=1770.05n

.meas tran vdout1_157ck1760 FIND v(dout1_157) AT=1770.05n

.meas tran vdout1_158ck1760 FIND v(dout1_158) AT=1770.05n

.meas tran vdout1_159ck1760 FIND v(dout1_159) AT=1770.05n

.meas tran vdout1_160ck1760 FIND v(dout1_160) AT=1770.05n

.meas tran vdout1_161ck1760 FIND v(dout1_161) AT=1770.05n

.meas tran vdout1_162ck1760 FIND v(dout1_162) AT=1770.05n

.meas tran vdout1_163ck1760 FIND v(dout1_163) AT=1770.05n

.meas tran vdout1_164ck1760 FIND v(dout1_164) AT=1770.05n

.meas tran vdout1_165ck1760 FIND v(dout1_165) AT=1770.05n

.meas tran vdout1_166ck1760 FIND v(dout1_166) AT=1770.05n

.meas tran vdout1_167ck1760 FIND v(dout1_167) AT=1770.05n

.meas tran vdout1_168ck1760 FIND v(dout1_168) AT=1770.05n

.meas tran vdout1_169ck1760 FIND v(dout1_169) AT=1770.05n

.meas tran vdout1_170ck1760 FIND v(dout1_170) AT=1770.05n

.meas tran vdout1_171ck1760 FIND v(dout1_171) AT=1770.05n

.meas tran vdout1_172ck1760 FIND v(dout1_172) AT=1770.05n

.meas tran vdout1_173ck1760 FIND v(dout1_173) AT=1770.05n

.meas tran vdout1_174ck1760 FIND v(dout1_174) AT=1770.05n

.meas tran vdout1_175ck1760 FIND v(dout1_175) AT=1770.05n

.meas tran vdout1_176ck1760 FIND v(dout1_176) AT=1770.05n

.meas tran vdout1_177ck1760 FIND v(dout1_177) AT=1770.05n

.meas tran vdout1_178ck1760 FIND v(dout1_178) AT=1770.05n

.meas tran vdout1_179ck1760 FIND v(dout1_179) AT=1770.05n

.meas tran vdout1_180ck1760 FIND v(dout1_180) AT=1770.05n

.meas tran vdout1_181ck1760 FIND v(dout1_181) AT=1770.05n

.meas tran vdout1_182ck1760 FIND v(dout1_182) AT=1770.05n

.meas tran vdout1_183ck1760 FIND v(dout1_183) AT=1770.05n

.meas tran vdout1_184ck1760 FIND v(dout1_184) AT=1770.05n

.meas tran vdout1_185ck1760 FIND v(dout1_185) AT=1770.05n

.meas tran vdout1_186ck1760 FIND v(dout1_186) AT=1770.05n

.meas tran vdout1_187ck1760 FIND v(dout1_187) AT=1770.05n

.meas tran vdout1_188ck1760 FIND v(dout1_188) AT=1770.05n

.meas tran vdout1_189ck1760 FIND v(dout1_189) AT=1770.05n

.meas tran vdout1_190ck1760 FIND v(dout1_190) AT=1770.05n

.meas tran vdout1_191ck1760 FIND v(dout1_191) AT=1770.05n

.meas tran vdout1_192ck1760 FIND v(dout1_192) AT=1770.05n

.meas tran vdout1_193ck1760 FIND v(dout1_193) AT=1770.05n

.meas tran vdout1_194ck1760 FIND v(dout1_194) AT=1770.05n

.meas tran vdout1_195ck1760 FIND v(dout1_195) AT=1770.05n

.meas tran vdout1_196ck1760 FIND v(dout1_196) AT=1770.05n

.meas tran vdout1_197ck1760 FIND v(dout1_197) AT=1770.05n

.meas tran vdout1_198ck1760 FIND v(dout1_198) AT=1770.05n

.meas tran vdout1_199ck1760 FIND v(dout1_199) AT=1770.05n

.meas tran vdout1_200ck1760 FIND v(dout1_200) AT=1770.05n

.meas tran vdout1_201ck1760 FIND v(dout1_201) AT=1770.05n

.meas tran vdout1_202ck1760 FIND v(dout1_202) AT=1770.05n

.meas tran vdout1_203ck1760 FIND v(dout1_203) AT=1770.05n

.meas tran vdout1_204ck1760 FIND v(dout1_204) AT=1770.05n

.meas tran vdout1_205ck1760 FIND v(dout1_205) AT=1770.05n

.meas tran vdout1_206ck1760 FIND v(dout1_206) AT=1770.05n

.meas tran vdout1_207ck1760 FIND v(dout1_207) AT=1770.05n

.meas tran vdout1_208ck1760 FIND v(dout1_208) AT=1770.05n

.meas tran vdout1_209ck1760 FIND v(dout1_209) AT=1770.05n

.meas tran vdout1_210ck1760 FIND v(dout1_210) AT=1770.05n

.meas tran vdout1_211ck1760 FIND v(dout1_211) AT=1770.05n

.meas tran vdout1_212ck1760 FIND v(dout1_212) AT=1770.05n

.meas tran vdout1_213ck1760 FIND v(dout1_213) AT=1770.05n

.meas tran vdout1_214ck1760 FIND v(dout1_214) AT=1770.05n

.meas tran vdout1_215ck1760 FIND v(dout1_215) AT=1770.05n

.meas tran vdout1_216ck1760 FIND v(dout1_216) AT=1770.05n

.meas tran vdout1_217ck1760 FIND v(dout1_217) AT=1770.05n

.meas tran vdout1_218ck1760 FIND v(dout1_218) AT=1770.05n

.meas tran vdout1_219ck1760 FIND v(dout1_219) AT=1770.05n

.meas tran vdout1_220ck1760 FIND v(dout1_220) AT=1770.05n

.meas tran vdout1_221ck1760 FIND v(dout1_221) AT=1770.05n

.meas tran vdout1_222ck1760 FIND v(dout1_222) AT=1770.05n

.meas tran vdout1_223ck1760 FIND v(dout1_223) AT=1770.05n

.meas tran vdout1_224ck1760 FIND v(dout1_224) AT=1770.05n

.meas tran vdout1_225ck1760 FIND v(dout1_225) AT=1770.05n

.meas tran vdout1_226ck1760 FIND v(dout1_226) AT=1770.05n

.meas tran vdout1_227ck1760 FIND v(dout1_227) AT=1770.05n

.meas tran vdout1_228ck1760 FIND v(dout1_228) AT=1770.05n

.meas tran vdout1_229ck1760 FIND v(dout1_229) AT=1770.05n

.meas tran vdout1_230ck1760 FIND v(dout1_230) AT=1770.05n

.meas tran vdout1_231ck1760 FIND v(dout1_231) AT=1770.05n

.meas tran vdout1_232ck1760 FIND v(dout1_232) AT=1770.05n

.meas tran vdout1_233ck1760 FIND v(dout1_233) AT=1770.05n

.meas tran vdout1_234ck1760 FIND v(dout1_234) AT=1770.05n

.meas tran vdout1_235ck1760 FIND v(dout1_235) AT=1770.05n

.meas tran vdout1_236ck1760 FIND v(dout1_236) AT=1770.05n

.meas tran vdout1_237ck1760 FIND v(dout1_237) AT=1770.05n

.meas tran vdout1_238ck1760 FIND v(dout1_238) AT=1770.05n

.meas tran vdout1_239ck1760 FIND v(dout1_239) AT=1770.05n

.meas tran vdout1_240ck1760 FIND v(dout1_240) AT=1770.05n

.meas tran vdout1_241ck1760 FIND v(dout1_241) AT=1770.05n

.meas tran vdout1_242ck1760 FIND v(dout1_242) AT=1770.05n

.meas tran vdout1_243ck1760 FIND v(dout1_243) AT=1770.05n

.meas tran vdout1_244ck1760 FIND v(dout1_244) AT=1770.05n

.meas tran vdout1_245ck1760 FIND v(dout1_245) AT=1770.05n

.meas tran vdout1_246ck1760 FIND v(dout1_246) AT=1770.05n

.meas tran vdout1_247ck1760 FIND v(dout1_247) AT=1770.05n

.meas tran vdout1_248ck1760 FIND v(dout1_248) AT=1770.05n

.meas tran vdout1_249ck1760 FIND v(dout1_249) AT=1770.05n

.meas tran vdout1_250ck1760 FIND v(dout1_250) AT=1770.05n

.meas tran vdout1_251ck1760 FIND v(dout1_251) AT=1770.05n

.meas tran vdout1_252ck1760 FIND v(dout1_252) AT=1770.05n

.meas tran vdout1_253ck1760 FIND v(dout1_253) AT=1770.05n

.meas tran vdout1_254ck1760 FIND v(dout1_254) AT=1770.05n

.meas tran vdout1_255ck1760 FIND v(dout1_255) AT=1770.05n

.meas tran vdout1_256ck1760 FIND v(dout1_256) AT=1770.05n

.meas tran vdout1_0ck1810 FIND v(dout1_0) AT=1820.05n

.meas tran vdout1_1ck1810 FIND v(dout1_1) AT=1820.05n

.meas tran vdout1_2ck1810 FIND v(dout1_2) AT=1820.05n

.meas tran vdout1_3ck1810 FIND v(dout1_3) AT=1820.05n

.meas tran vdout1_4ck1810 FIND v(dout1_4) AT=1820.05n

.meas tran vdout1_5ck1810 FIND v(dout1_5) AT=1820.05n

.meas tran vdout1_6ck1810 FIND v(dout1_6) AT=1820.05n

.meas tran vdout1_7ck1810 FIND v(dout1_7) AT=1820.05n

.meas tran vdout1_8ck1810 FIND v(dout1_8) AT=1820.05n

.meas tran vdout1_9ck1810 FIND v(dout1_9) AT=1820.05n

.meas tran vdout1_10ck1810 FIND v(dout1_10) AT=1820.05n

.meas tran vdout1_11ck1810 FIND v(dout1_11) AT=1820.05n

.meas tran vdout1_12ck1810 FIND v(dout1_12) AT=1820.05n

.meas tran vdout1_13ck1810 FIND v(dout1_13) AT=1820.05n

.meas tran vdout1_14ck1810 FIND v(dout1_14) AT=1820.05n

.meas tran vdout1_15ck1810 FIND v(dout1_15) AT=1820.05n

.meas tran vdout1_16ck1810 FIND v(dout1_16) AT=1820.05n

.meas tran vdout1_17ck1810 FIND v(dout1_17) AT=1820.05n

.meas tran vdout1_18ck1810 FIND v(dout1_18) AT=1820.05n

.meas tran vdout1_19ck1810 FIND v(dout1_19) AT=1820.05n

.meas tran vdout1_20ck1810 FIND v(dout1_20) AT=1820.05n

.meas tran vdout1_21ck1810 FIND v(dout1_21) AT=1820.05n

.meas tran vdout1_22ck1810 FIND v(dout1_22) AT=1820.05n

.meas tran vdout1_23ck1810 FIND v(dout1_23) AT=1820.05n

.meas tran vdout1_24ck1810 FIND v(dout1_24) AT=1820.05n

.meas tran vdout1_25ck1810 FIND v(dout1_25) AT=1820.05n

.meas tran vdout1_26ck1810 FIND v(dout1_26) AT=1820.05n

.meas tran vdout1_27ck1810 FIND v(dout1_27) AT=1820.05n

.meas tran vdout1_28ck1810 FIND v(dout1_28) AT=1820.05n

.meas tran vdout1_29ck1810 FIND v(dout1_29) AT=1820.05n

.meas tran vdout1_30ck1810 FIND v(dout1_30) AT=1820.05n

.meas tran vdout1_31ck1810 FIND v(dout1_31) AT=1820.05n

.meas tran vdout1_32ck1810 FIND v(dout1_32) AT=1820.05n

.meas tran vdout1_33ck1810 FIND v(dout1_33) AT=1820.05n

.meas tran vdout1_34ck1810 FIND v(dout1_34) AT=1820.05n

.meas tran vdout1_35ck1810 FIND v(dout1_35) AT=1820.05n

.meas tran vdout1_36ck1810 FIND v(dout1_36) AT=1820.05n

.meas tran vdout1_37ck1810 FIND v(dout1_37) AT=1820.05n

.meas tran vdout1_38ck1810 FIND v(dout1_38) AT=1820.05n

.meas tran vdout1_39ck1810 FIND v(dout1_39) AT=1820.05n

.meas tran vdout1_40ck1810 FIND v(dout1_40) AT=1820.05n

.meas tran vdout1_41ck1810 FIND v(dout1_41) AT=1820.05n

.meas tran vdout1_42ck1810 FIND v(dout1_42) AT=1820.05n

.meas tran vdout1_43ck1810 FIND v(dout1_43) AT=1820.05n

.meas tran vdout1_44ck1810 FIND v(dout1_44) AT=1820.05n

.meas tran vdout1_45ck1810 FIND v(dout1_45) AT=1820.05n

.meas tran vdout1_46ck1810 FIND v(dout1_46) AT=1820.05n

.meas tran vdout1_47ck1810 FIND v(dout1_47) AT=1820.05n

.meas tran vdout1_48ck1810 FIND v(dout1_48) AT=1820.05n

.meas tran vdout1_49ck1810 FIND v(dout1_49) AT=1820.05n

.meas tran vdout1_50ck1810 FIND v(dout1_50) AT=1820.05n

.meas tran vdout1_51ck1810 FIND v(dout1_51) AT=1820.05n

.meas tran vdout1_52ck1810 FIND v(dout1_52) AT=1820.05n

.meas tran vdout1_53ck1810 FIND v(dout1_53) AT=1820.05n

.meas tran vdout1_54ck1810 FIND v(dout1_54) AT=1820.05n

.meas tran vdout1_55ck1810 FIND v(dout1_55) AT=1820.05n

.meas tran vdout1_56ck1810 FIND v(dout1_56) AT=1820.05n

.meas tran vdout1_57ck1810 FIND v(dout1_57) AT=1820.05n

.meas tran vdout1_58ck1810 FIND v(dout1_58) AT=1820.05n

.meas tran vdout1_59ck1810 FIND v(dout1_59) AT=1820.05n

.meas tran vdout1_60ck1810 FIND v(dout1_60) AT=1820.05n

.meas tran vdout1_61ck1810 FIND v(dout1_61) AT=1820.05n

.meas tran vdout1_62ck1810 FIND v(dout1_62) AT=1820.05n

.meas tran vdout1_63ck1810 FIND v(dout1_63) AT=1820.05n

.meas tran vdout1_64ck1810 FIND v(dout1_64) AT=1820.05n

.meas tran vdout1_65ck1810 FIND v(dout1_65) AT=1820.05n

.meas tran vdout1_66ck1810 FIND v(dout1_66) AT=1820.05n

.meas tran vdout1_67ck1810 FIND v(dout1_67) AT=1820.05n

.meas tran vdout1_68ck1810 FIND v(dout1_68) AT=1820.05n

.meas tran vdout1_69ck1810 FIND v(dout1_69) AT=1820.05n

.meas tran vdout1_70ck1810 FIND v(dout1_70) AT=1820.05n

.meas tran vdout1_71ck1810 FIND v(dout1_71) AT=1820.05n

.meas tran vdout1_72ck1810 FIND v(dout1_72) AT=1820.05n

.meas tran vdout1_73ck1810 FIND v(dout1_73) AT=1820.05n

.meas tran vdout1_74ck1810 FIND v(dout1_74) AT=1820.05n

.meas tran vdout1_75ck1810 FIND v(dout1_75) AT=1820.05n

.meas tran vdout1_76ck1810 FIND v(dout1_76) AT=1820.05n

.meas tran vdout1_77ck1810 FIND v(dout1_77) AT=1820.05n

.meas tran vdout1_78ck1810 FIND v(dout1_78) AT=1820.05n

.meas tran vdout1_79ck1810 FIND v(dout1_79) AT=1820.05n

.meas tran vdout1_80ck1810 FIND v(dout1_80) AT=1820.05n

.meas tran vdout1_81ck1810 FIND v(dout1_81) AT=1820.05n

.meas tran vdout1_82ck1810 FIND v(dout1_82) AT=1820.05n

.meas tran vdout1_83ck1810 FIND v(dout1_83) AT=1820.05n

.meas tran vdout1_84ck1810 FIND v(dout1_84) AT=1820.05n

.meas tran vdout1_85ck1810 FIND v(dout1_85) AT=1820.05n

.meas tran vdout1_86ck1810 FIND v(dout1_86) AT=1820.05n

.meas tran vdout1_87ck1810 FIND v(dout1_87) AT=1820.05n

.meas tran vdout1_88ck1810 FIND v(dout1_88) AT=1820.05n

.meas tran vdout1_89ck1810 FIND v(dout1_89) AT=1820.05n

.meas tran vdout1_90ck1810 FIND v(dout1_90) AT=1820.05n

.meas tran vdout1_91ck1810 FIND v(dout1_91) AT=1820.05n

.meas tran vdout1_92ck1810 FIND v(dout1_92) AT=1820.05n

.meas tran vdout1_93ck1810 FIND v(dout1_93) AT=1820.05n

.meas tran vdout1_94ck1810 FIND v(dout1_94) AT=1820.05n

.meas tran vdout1_95ck1810 FIND v(dout1_95) AT=1820.05n

.meas tran vdout1_96ck1810 FIND v(dout1_96) AT=1820.05n

.meas tran vdout1_97ck1810 FIND v(dout1_97) AT=1820.05n

.meas tran vdout1_98ck1810 FIND v(dout1_98) AT=1820.05n

.meas tran vdout1_99ck1810 FIND v(dout1_99) AT=1820.05n

.meas tran vdout1_100ck1810 FIND v(dout1_100) AT=1820.05n

.meas tran vdout1_101ck1810 FIND v(dout1_101) AT=1820.05n

.meas tran vdout1_102ck1810 FIND v(dout1_102) AT=1820.05n

.meas tran vdout1_103ck1810 FIND v(dout1_103) AT=1820.05n

.meas tran vdout1_104ck1810 FIND v(dout1_104) AT=1820.05n

.meas tran vdout1_105ck1810 FIND v(dout1_105) AT=1820.05n

.meas tran vdout1_106ck1810 FIND v(dout1_106) AT=1820.05n

.meas tran vdout1_107ck1810 FIND v(dout1_107) AT=1820.05n

.meas tran vdout1_108ck1810 FIND v(dout1_108) AT=1820.05n

.meas tran vdout1_109ck1810 FIND v(dout1_109) AT=1820.05n

.meas tran vdout1_110ck1810 FIND v(dout1_110) AT=1820.05n

.meas tran vdout1_111ck1810 FIND v(dout1_111) AT=1820.05n

.meas tran vdout1_112ck1810 FIND v(dout1_112) AT=1820.05n

.meas tran vdout1_113ck1810 FIND v(dout1_113) AT=1820.05n

.meas tran vdout1_114ck1810 FIND v(dout1_114) AT=1820.05n

.meas tran vdout1_115ck1810 FIND v(dout1_115) AT=1820.05n

.meas tran vdout1_116ck1810 FIND v(dout1_116) AT=1820.05n

.meas tran vdout1_117ck1810 FIND v(dout1_117) AT=1820.05n

.meas tran vdout1_118ck1810 FIND v(dout1_118) AT=1820.05n

.meas tran vdout1_119ck1810 FIND v(dout1_119) AT=1820.05n

.meas tran vdout1_120ck1810 FIND v(dout1_120) AT=1820.05n

.meas tran vdout1_121ck1810 FIND v(dout1_121) AT=1820.05n

.meas tran vdout1_122ck1810 FIND v(dout1_122) AT=1820.05n

.meas tran vdout1_123ck1810 FIND v(dout1_123) AT=1820.05n

.meas tran vdout1_124ck1810 FIND v(dout1_124) AT=1820.05n

.meas tran vdout1_125ck1810 FIND v(dout1_125) AT=1820.05n

.meas tran vdout1_126ck1810 FIND v(dout1_126) AT=1820.05n

.meas tran vdout1_127ck1810 FIND v(dout1_127) AT=1820.05n

.meas tran vdout1_128ck1810 FIND v(dout1_128) AT=1820.05n

.meas tran vdout1_129ck1810 FIND v(dout1_129) AT=1820.05n

.meas tran vdout1_130ck1810 FIND v(dout1_130) AT=1820.05n

.meas tran vdout1_131ck1810 FIND v(dout1_131) AT=1820.05n

.meas tran vdout1_132ck1810 FIND v(dout1_132) AT=1820.05n

.meas tran vdout1_133ck1810 FIND v(dout1_133) AT=1820.05n

.meas tran vdout1_134ck1810 FIND v(dout1_134) AT=1820.05n

.meas tran vdout1_135ck1810 FIND v(dout1_135) AT=1820.05n

.meas tran vdout1_136ck1810 FIND v(dout1_136) AT=1820.05n

.meas tran vdout1_137ck1810 FIND v(dout1_137) AT=1820.05n

.meas tran vdout1_138ck1810 FIND v(dout1_138) AT=1820.05n

.meas tran vdout1_139ck1810 FIND v(dout1_139) AT=1820.05n

.meas tran vdout1_140ck1810 FIND v(dout1_140) AT=1820.05n

.meas tran vdout1_141ck1810 FIND v(dout1_141) AT=1820.05n

.meas tran vdout1_142ck1810 FIND v(dout1_142) AT=1820.05n

.meas tran vdout1_143ck1810 FIND v(dout1_143) AT=1820.05n

.meas tran vdout1_144ck1810 FIND v(dout1_144) AT=1820.05n

.meas tran vdout1_145ck1810 FIND v(dout1_145) AT=1820.05n

.meas tran vdout1_146ck1810 FIND v(dout1_146) AT=1820.05n

.meas tran vdout1_147ck1810 FIND v(dout1_147) AT=1820.05n

.meas tran vdout1_148ck1810 FIND v(dout1_148) AT=1820.05n

.meas tran vdout1_149ck1810 FIND v(dout1_149) AT=1820.05n

.meas tran vdout1_150ck1810 FIND v(dout1_150) AT=1820.05n

.meas tran vdout1_151ck1810 FIND v(dout1_151) AT=1820.05n

.meas tran vdout1_152ck1810 FIND v(dout1_152) AT=1820.05n

.meas tran vdout1_153ck1810 FIND v(dout1_153) AT=1820.05n

.meas tran vdout1_154ck1810 FIND v(dout1_154) AT=1820.05n

.meas tran vdout1_155ck1810 FIND v(dout1_155) AT=1820.05n

.meas tran vdout1_156ck1810 FIND v(dout1_156) AT=1820.05n

.meas tran vdout1_157ck1810 FIND v(dout1_157) AT=1820.05n

.meas tran vdout1_158ck1810 FIND v(dout1_158) AT=1820.05n

.meas tran vdout1_159ck1810 FIND v(dout1_159) AT=1820.05n

.meas tran vdout1_160ck1810 FIND v(dout1_160) AT=1820.05n

.meas tran vdout1_161ck1810 FIND v(dout1_161) AT=1820.05n

.meas tran vdout1_162ck1810 FIND v(dout1_162) AT=1820.05n

.meas tran vdout1_163ck1810 FIND v(dout1_163) AT=1820.05n

.meas tran vdout1_164ck1810 FIND v(dout1_164) AT=1820.05n

.meas tran vdout1_165ck1810 FIND v(dout1_165) AT=1820.05n

.meas tran vdout1_166ck1810 FIND v(dout1_166) AT=1820.05n

.meas tran vdout1_167ck1810 FIND v(dout1_167) AT=1820.05n

.meas tran vdout1_168ck1810 FIND v(dout1_168) AT=1820.05n

.meas tran vdout1_169ck1810 FIND v(dout1_169) AT=1820.05n

.meas tran vdout1_170ck1810 FIND v(dout1_170) AT=1820.05n

.meas tran vdout1_171ck1810 FIND v(dout1_171) AT=1820.05n

.meas tran vdout1_172ck1810 FIND v(dout1_172) AT=1820.05n

.meas tran vdout1_173ck1810 FIND v(dout1_173) AT=1820.05n

.meas tran vdout1_174ck1810 FIND v(dout1_174) AT=1820.05n

.meas tran vdout1_175ck1810 FIND v(dout1_175) AT=1820.05n

.meas tran vdout1_176ck1810 FIND v(dout1_176) AT=1820.05n

.meas tran vdout1_177ck1810 FIND v(dout1_177) AT=1820.05n

.meas tran vdout1_178ck1810 FIND v(dout1_178) AT=1820.05n

.meas tran vdout1_179ck1810 FIND v(dout1_179) AT=1820.05n

.meas tran vdout1_180ck1810 FIND v(dout1_180) AT=1820.05n

.meas tran vdout1_181ck1810 FIND v(dout1_181) AT=1820.05n

.meas tran vdout1_182ck1810 FIND v(dout1_182) AT=1820.05n

.meas tran vdout1_183ck1810 FIND v(dout1_183) AT=1820.05n

.meas tran vdout1_184ck1810 FIND v(dout1_184) AT=1820.05n

.meas tran vdout1_185ck1810 FIND v(dout1_185) AT=1820.05n

.meas tran vdout1_186ck1810 FIND v(dout1_186) AT=1820.05n

.meas tran vdout1_187ck1810 FIND v(dout1_187) AT=1820.05n

.meas tran vdout1_188ck1810 FIND v(dout1_188) AT=1820.05n

.meas tran vdout1_189ck1810 FIND v(dout1_189) AT=1820.05n

.meas tran vdout1_190ck1810 FIND v(dout1_190) AT=1820.05n

.meas tran vdout1_191ck1810 FIND v(dout1_191) AT=1820.05n

.meas tran vdout1_192ck1810 FIND v(dout1_192) AT=1820.05n

.meas tran vdout1_193ck1810 FIND v(dout1_193) AT=1820.05n

.meas tran vdout1_194ck1810 FIND v(dout1_194) AT=1820.05n

.meas tran vdout1_195ck1810 FIND v(dout1_195) AT=1820.05n

.meas tran vdout1_196ck1810 FIND v(dout1_196) AT=1820.05n

.meas tran vdout1_197ck1810 FIND v(dout1_197) AT=1820.05n

.meas tran vdout1_198ck1810 FIND v(dout1_198) AT=1820.05n

.meas tran vdout1_199ck1810 FIND v(dout1_199) AT=1820.05n

.meas tran vdout1_200ck1810 FIND v(dout1_200) AT=1820.05n

.meas tran vdout1_201ck1810 FIND v(dout1_201) AT=1820.05n

.meas tran vdout1_202ck1810 FIND v(dout1_202) AT=1820.05n

.meas tran vdout1_203ck1810 FIND v(dout1_203) AT=1820.05n

.meas tran vdout1_204ck1810 FIND v(dout1_204) AT=1820.05n

.meas tran vdout1_205ck1810 FIND v(dout1_205) AT=1820.05n

.meas tran vdout1_206ck1810 FIND v(dout1_206) AT=1820.05n

.meas tran vdout1_207ck1810 FIND v(dout1_207) AT=1820.05n

.meas tran vdout1_208ck1810 FIND v(dout1_208) AT=1820.05n

.meas tran vdout1_209ck1810 FIND v(dout1_209) AT=1820.05n

.meas tran vdout1_210ck1810 FIND v(dout1_210) AT=1820.05n

.meas tran vdout1_211ck1810 FIND v(dout1_211) AT=1820.05n

.meas tran vdout1_212ck1810 FIND v(dout1_212) AT=1820.05n

.meas tran vdout1_213ck1810 FIND v(dout1_213) AT=1820.05n

.meas tran vdout1_214ck1810 FIND v(dout1_214) AT=1820.05n

.meas tran vdout1_215ck1810 FIND v(dout1_215) AT=1820.05n

.meas tran vdout1_216ck1810 FIND v(dout1_216) AT=1820.05n

.meas tran vdout1_217ck1810 FIND v(dout1_217) AT=1820.05n

.meas tran vdout1_218ck1810 FIND v(dout1_218) AT=1820.05n

.meas tran vdout1_219ck1810 FIND v(dout1_219) AT=1820.05n

.meas tran vdout1_220ck1810 FIND v(dout1_220) AT=1820.05n

.meas tran vdout1_221ck1810 FIND v(dout1_221) AT=1820.05n

.meas tran vdout1_222ck1810 FIND v(dout1_222) AT=1820.05n

.meas tran vdout1_223ck1810 FIND v(dout1_223) AT=1820.05n

.meas tran vdout1_224ck1810 FIND v(dout1_224) AT=1820.05n

.meas tran vdout1_225ck1810 FIND v(dout1_225) AT=1820.05n

.meas tran vdout1_226ck1810 FIND v(dout1_226) AT=1820.05n

.meas tran vdout1_227ck1810 FIND v(dout1_227) AT=1820.05n

.meas tran vdout1_228ck1810 FIND v(dout1_228) AT=1820.05n

.meas tran vdout1_229ck1810 FIND v(dout1_229) AT=1820.05n

.meas tran vdout1_230ck1810 FIND v(dout1_230) AT=1820.05n

.meas tran vdout1_231ck1810 FIND v(dout1_231) AT=1820.05n

.meas tran vdout1_232ck1810 FIND v(dout1_232) AT=1820.05n

.meas tran vdout1_233ck1810 FIND v(dout1_233) AT=1820.05n

.meas tran vdout1_234ck1810 FIND v(dout1_234) AT=1820.05n

.meas tran vdout1_235ck1810 FIND v(dout1_235) AT=1820.05n

.meas tran vdout1_236ck1810 FIND v(dout1_236) AT=1820.05n

.meas tran vdout1_237ck1810 FIND v(dout1_237) AT=1820.05n

.meas tran vdout1_238ck1810 FIND v(dout1_238) AT=1820.05n

.meas tran vdout1_239ck1810 FIND v(dout1_239) AT=1820.05n

.meas tran vdout1_240ck1810 FIND v(dout1_240) AT=1820.05n

.meas tran vdout1_241ck1810 FIND v(dout1_241) AT=1820.05n

.meas tran vdout1_242ck1810 FIND v(dout1_242) AT=1820.05n

.meas tran vdout1_243ck1810 FIND v(dout1_243) AT=1820.05n

.meas tran vdout1_244ck1810 FIND v(dout1_244) AT=1820.05n

.meas tran vdout1_245ck1810 FIND v(dout1_245) AT=1820.05n

.meas tran vdout1_246ck1810 FIND v(dout1_246) AT=1820.05n

.meas tran vdout1_247ck1810 FIND v(dout1_247) AT=1820.05n

.meas tran vdout1_248ck1810 FIND v(dout1_248) AT=1820.05n

.meas tran vdout1_249ck1810 FIND v(dout1_249) AT=1820.05n

.meas tran vdout1_250ck1810 FIND v(dout1_250) AT=1820.05n

.meas tran vdout1_251ck1810 FIND v(dout1_251) AT=1820.05n

.meas tran vdout1_252ck1810 FIND v(dout1_252) AT=1820.05n

.meas tran vdout1_253ck1810 FIND v(dout1_253) AT=1820.05n

.meas tran vdout1_254ck1810 FIND v(dout1_254) AT=1820.05n

.meas tran vdout1_255ck1810 FIND v(dout1_255) AT=1820.05n

.meas tran vdout1_256ck1810 FIND v(dout1_256) AT=1820.05n

.meas tran vdout1_0ck1830 FIND v(dout1_0) AT=1840.05n

.meas tran vdout1_1ck1830 FIND v(dout1_1) AT=1840.05n

.meas tran vdout1_2ck1830 FIND v(dout1_2) AT=1840.05n

.meas tran vdout1_3ck1830 FIND v(dout1_3) AT=1840.05n

.meas tran vdout1_4ck1830 FIND v(dout1_4) AT=1840.05n

.meas tran vdout1_5ck1830 FIND v(dout1_5) AT=1840.05n

.meas tran vdout1_6ck1830 FIND v(dout1_6) AT=1840.05n

.meas tran vdout1_7ck1830 FIND v(dout1_7) AT=1840.05n

.meas tran vdout1_8ck1830 FIND v(dout1_8) AT=1840.05n

.meas tran vdout1_9ck1830 FIND v(dout1_9) AT=1840.05n

.meas tran vdout1_10ck1830 FIND v(dout1_10) AT=1840.05n

.meas tran vdout1_11ck1830 FIND v(dout1_11) AT=1840.05n

.meas tran vdout1_12ck1830 FIND v(dout1_12) AT=1840.05n

.meas tran vdout1_13ck1830 FIND v(dout1_13) AT=1840.05n

.meas tran vdout1_14ck1830 FIND v(dout1_14) AT=1840.05n

.meas tran vdout1_15ck1830 FIND v(dout1_15) AT=1840.05n

.meas tran vdout1_16ck1830 FIND v(dout1_16) AT=1840.05n

.meas tran vdout1_17ck1830 FIND v(dout1_17) AT=1840.05n

.meas tran vdout1_18ck1830 FIND v(dout1_18) AT=1840.05n

.meas tran vdout1_19ck1830 FIND v(dout1_19) AT=1840.05n

.meas tran vdout1_20ck1830 FIND v(dout1_20) AT=1840.05n

.meas tran vdout1_21ck1830 FIND v(dout1_21) AT=1840.05n

.meas tran vdout1_22ck1830 FIND v(dout1_22) AT=1840.05n

.meas tran vdout1_23ck1830 FIND v(dout1_23) AT=1840.05n

.meas tran vdout1_24ck1830 FIND v(dout1_24) AT=1840.05n

.meas tran vdout1_25ck1830 FIND v(dout1_25) AT=1840.05n

.meas tran vdout1_26ck1830 FIND v(dout1_26) AT=1840.05n

.meas tran vdout1_27ck1830 FIND v(dout1_27) AT=1840.05n

.meas tran vdout1_28ck1830 FIND v(dout1_28) AT=1840.05n

.meas tran vdout1_29ck1830 FIND v(dout1_29) AT=1840.05n

.meas tran vdout1_30ck1830 FIND v(dout1_30) AT=1840.05n

.meas tran vdout1_31ck1830 FIND v(dout1_31) AT=1840.05n

.meas tran vdout1_32ck1830 FIND v(dout1_32) AT=1840.05n

.meas tran vdout1_33ck1830 FIND v(dout1_33) AT=1840.05n

.meas tran vdout1_34ck1830 FIND v(dout1_34) AT=1840.05n

.meas tran vdout1_35ck1830 FIND v(dout1_35) AT=1840.05n

.meas tran vdout1_36ck1830 FIND v(dout1_36) AT=1840.05n

.meas tran vdout1_37ck1830 FIND v(dout1_37) AT=1840.05n

.meas tran vdout1_38ck1830 FIND v(dout1_38) AT=1840.05n

.meas tran vdout1_39ck1830 FIND v(dout1_39) AT=1840.05n

.meas tran vdout1_40ck1830 FIND v(dout1_40) AT=1840.05n

.meas tran vdout1_41ck1830 FIND v(dout1_41) AT=1840.05n

.meas tran vdout1_42ck1830 FIND v(dout1_42) AT=1840.05n

.meas tran vdout1_43ck1830 FIND v(dout1_43) AT=1840.05n

.meas tran vdout1_44ck1830 FIND v(dout1_44) AT=1840.05n

.meas tran vdout1_45ck1830 FIND v(dout1_45) AT=1840.05n

.meas tran vdout1_46ck1830 FIND v(dout1_46) AT=1840.05n

.meas tran vdout1_47ck1830 FIND v(dout1_47) AT=1840.05n

.meas tran vdout1_48ck1830 FIND v(dout1_48) AT=1840.05n

.meas tran vdout1_49ck1830 FIND v(dout1_49) AT=1840.05n

.meas tran vdout1_50ck1830 FIND v(dout1_50) AT=1840.05n

.meas tran vdout1_51ck1830 FIND v(dout1_51) AT=1840.05n

.meas tran vdout1_52ck1830 FIND v(dout1_52) AT=1840.05n

.meas tran vdout1_53ck1830 FIND v(dout1_53) AT=1840.05n

.meas tran vdout1_54ck1830 FIND v(dout1_54) AT=1840.05n

.meas tran vdout1_55ck1830 FIND v(dout1_55) AT=1840.05n

.meas tran vdout1_56ck1830 FIND v(dout1_56) AT=1840.05n

.meas tran vdout1_57ck1830 FIND v(dout1_57) AT=1840.05n

.meas tran vdout1_58ck1830 FIND v(dout1_58) AT=1840.05n

.meas tran vdout1_59ck1830 FIND v(dout1_59) AT=1840.05n

.meas tran vdout1_60ck1830 FIND v(dout1_60) AT=1840.05n

.meas tran vdout1_61ck1830 FIND v(dout1_61) AT=1840.05n

.meas tran vdout1_62ck1830 FIND v(dout1_62) AT=1840.05n

.meas tran vdout1_63ck1830 FIND v(dout1_63) AT=1840.05n

.meas tran vdout1_64ck1830 FIND v(dout1_64) AT=1840.05n

.meas tran vdout1_65ck1830 FIND v(dout1_65) AT=1840.05n

.meas tran vdout1_66ck1830 FIND v(dout1_66) AT=1840.05n

.meas tran vdout1_67ck1830 FIND v(dout1_67) AT=1840.05n

.meas tran vdout1_68ck1830 FIND v(dout1_68) AT=1840.05n

.meas tran vdout1_69ck1830 FIND v(dout1_69) AT=1840.05n

.meas tran vdout1_70ck1830 FIND v(dout1_70) AT=1840.05n

.meas tran vdout1_71ck1830 FIND v(dout1_71) AT=1840.05n

.meas tran vdout1_72ck1830 FIND v(dout1_72) AT=1840.05n

.meas tran vdout1_73ck1830 FIND v(dout1_73) AT=1840.05n

.meas tran vdout1_74ck1830 FIND v(dout1_74) AT=1840.05n

.meas tran vdout1_75ck1830 FIND v(dout1_75) AT=1840.05n

.meas tran vdout1_76ck1830 FIND v(dout1_76) AT=1840.05n

.meas tran vdout1_77ck1830 FIND v(dout1_77) AT=1840.05n

.meas tran vdout1_78ck1830 FIND v(dout1_78) AT=1840.05n

.meas tran vdout1_79ck1830 FIND v(dout1_79) AT=1840.05n

.meas tran vdout1_80ck1830 FIND v(dout1_80) AT=1840.05n

.meas tran vdout1_81ck1830 FIND v(dout1_81) AT=1840.05n

.meas tran vdout1_82ck1830 FIND v(dout1_82) AT=1840.05n

.meas tran vdout1_83ck1830 FIND v(dout1_83) AT=1840.05n

.meas tran vdout1_84ck1830 FIND v(dout1_84) AT=1840.05n

.meas tran vdout1_85ck1830 FIND v(dout1_85) AT=1840.05n

.meas tran vdout1_86ck1830 FIND v(dout1_86) AT=1840.05n

.meas tran vdout1_87ck1830 FIND v(dout1_87) AT=1840.05n

.meas tran vdout1_88ck1830 FIND v(dout1_88) AT=1840.05n

.meas tran vdout1_89ck1830 FIND v(dout1_89) AT=1840.05n

.meas tran vdout1_90ck1830 FIND v(dout1_90) AT=1840.05n

.meas tran vdout1_91ck1830 FIND v(dout1_91) AT=1840.05n

.meas tran vdout1_92ck1830 FIND v(dout1_92) AT=1840.05n

.meas tran vdout1_93ck1830 FIND v(dout1_93) AT=1840.05n

.meas tran vdout1_94ck1830 FIND v(dout1_94) AT=1840.05n

.meas tran vdout1_95ck1830 FIND v(dout1_95) AT=1840.05n

.meas tran vdout1_96ck1830 FIND v(dout1_96) AT=1840.05n

.meas tran vdout1_97ck1830 FIND v(dout1_97) AT=1840.05n

.meas tran vdout1_98ck1830 FIND v(dout1_98) AT=1840.05n

.meas tran vdout1_99ck1830 FIND v(dout1_99) AT=1840.05n

.meas tran vdout1_100ck1830 FIND v(dout1_100) AT=1840.05n

.meas tran vdout1_101ck1830 FIND v(dout1_101) AT=1840.05n

.meas tran vdout1_102ck1830 FIND v(dout1_102) AT=1840.05n

.meas tran vdout1_103ck1830 FIND v(dout1_103) AT=1840.05n

.meas tran vdout1_104ck1830 FIND v(dout1_104) AT=1840.05n

.meas tran vdout1_105ck1830 FIND v(dout1_105) AT=1840.05n

.meas tran vdout1_106ck1830 FIND v(dout1_106) AT=1840.05n

.meas tran vdout1_107ck1830 FIND v(dout1_107) AT=1840.05n

.meas tran vdout1_108ck1830 FIND v(dout1_108) AT=1840.05n

.meas tran vdout1_109ck1830 FIND v(dout1_109) AT=1840.05n

.meas tran vdout1_110ck1830 FIND v(dout1_110) AT=1840.05n

.meas tran vdout1_111ck1830 FIND v(dout1_111) AT=1840.05n

.meas tran vdout1_112ck1830 FIND v(dout1_112) AT=1840.05n

.meas tran vdout1_113ck1830 FIND v(dout1_113) AT=1840.05n

.meas tran vdout1_114ck1830 FIND v(dout1_114) AT=1840.05n

.meas tran vdout1_115ck1830 FIND v(dout1_115) AT=1840.05n

.meas tran vdout1_116ck1830 FIND v(dout1_116) AT=1840.05n

.meas tran vdout1_117ck1830 FIND v(dout1_117) AT=1840.05n

.meas tran vdout1_118ck1830 FIND v(dout1_118) AT=1840.05n

.meas tran vdout1_119ck1830 FIND v(dout1_119) AT=1840.05n

.meas tran vdout1_120ck1830 FIND v(dout1_120) AT=1840.05n

.meas tran vdout1_121ck1830 FIND v(dout1_121) AT=1840.05n

.meas tran vdout1_122ck1830 FIND v(dout1_122) AT=1840.05n

.meas tran vdout1_123ck1830 FIND v(dout1_123) AT=1840.05n

.meas tran vdout1_124ck1830 FIND v(dout1_124) AT=1840.05n

.meas tran vdout1_125ck1830 FIND v(dout1_125) AT=1840.05n

.meas tran vdout1_126ck1830 FIND v(dout1_126) AT=1840.05n

.meas tran vdout1_127ck1830 FIND v(dout1_127) AT=1840.05n

.meas tran vdout1_128ck1830 FIND v(dout1_128) AT=1840.05n

.meas tran vdout1_129ck1830 FIND v(dout1_129) AT=1840.05n

.meas tran vdout1_130ck1830 FIND v(dout1_130) AT=1840.05n

.meas tran vdout1_131ck1830 FIND v(dout1_131) AT=1840.05n

.meas tran vdout1_132ck1830 FIND v(dout1_132) AT=1840.05n

.meas tran vdout1_133ck1830 FIND v(dout1_133) AT=1840.05n

.meas tran vdout1_134ck1830 FIND v(dout1_134) AT=1840.05n

.meas tran vdout1_135ck1830 FIND v(dout1_135) AT=1840.05n

.meas tran vdout1_136ck1830 FIND v(dout1_136) AT=1840.05n

.meas tran vdout1_137ck1830 FIND v(dout1_137) AT=1840.05n

.meas tran vdout1_138ck1830 FIND v(dout1_138) AT=1840.05n

.meas tran vdout1_139ck1830 FIND v(dout1_139) AT=1840.05n

.meas tran vdout1_140ck1830 FIND v(dout1_140) AT=1840.05n

.meas tran vdout1_141ck1830 FIND v(dout1_141) AT=1840.05n

.meas tran vdout1_142ck1830 FIND v(dout1_142) AT=1840.05n

.meas tran vdout1_143ck1830 FIND v(dout1_143) AT=1840.05n

.meas tran vdout1_144ck1830 FIND v(dout1_144) AT=1840.05n

.meas tran vdout1_145ck1830 FIND v(dout1_145) AT=1840.05n

.meas tran vdout1_146ck1830 FIND v(dout1_146) AT=1840.05n

.meas tran vdout1_147ck1830 FIND v(dout1_147) AT=1840.05n

.meas tran vdout1_148ck1830 FIND v(dout1_148) AT=1840.05n

.meas tran vdout1_149ck1830 FIND v(dout1_149) AT=1840.05n

.meas tran vdout1_150ck1830 FIND v(dout1_150) AT=1840.05n

.meas tran vdout1_151ck1830 FIND v(dout1_151) AT=1840.05n

.meas tran vdout1_152ck1830 FIND v(dout1_152) AT=1840.05n

.meas tran vdout1_153ck1830 FIND v(dout1_153) AT=1840.05n

.meas tran vdout1_154ck1830 FIND v(dout1_154) AT=1840.05n

.meas tran vdout1_155ck1830 FIND v(dout1_155) AT=1840.05n

.meas tran vdout1_156ck1830 FIND v(dout1_156) AT=1840.05n

.meas tran vdout1_157ck1830 FIND v(dout1_157) AT=1840.05n

.meas tran vdout1_158ck1830 FIND v(dout1_158) AT=1840.05n

.meas tran vdout1_159ck1830 FIND v(dout1_159) AT=1840.05n

.meas tran vdout1_160ck1830 FIND v(dout1_160) AT=1840.05n

.meas tran vdout1_161ck1830 FIND v(dout1_161) AT=1840.05n

.meas tran vdout1_162ck1830 FIND v(dout1_162) AT=1840.05n

.meas tran vdout1_163ck1830 FIND v(dout1_163) AT=1840.05n

.meas tran vdout1_164ck1830 FIND v(dout1_164) AT=1840.05n

.meas tran vdout1_165ck1830 FIND v(dout1_165) AT=1840.05n

.meas tran vdout1_166ck1830 FIND v(dout1_166) AT=1840.05n

.meas tran vdout1_167ck1830 FIND v(dout1_167) AT=1840.05n

.meas tran vdout1_168ck1830 FIND v(dout1_168) AT=1840.05n

.meas tran vdout1_169ck1830 FIND v(dout1_169) AT=1840.05n

.meas tran vdout1_170ck1830 FIND v(dout1_170) AT=1840.05n

.meas tran vdout1_171ck1830 FIND v(dout1_171) AT=1840.05n

.meas tran vdout1_172ck1830 FIND v(dout1_172) AT=1840.05n

.meas tran vdout1_173ck1830 FIND v(dout1_173) AT=1840.05n

.meas tran vdout1_174ck1830 FIND v(dout1_174) AT=1840.05n

.meas tran vdout1_175ck1830 FIND v(dout1_175) AT=1840.05n

.meas tran vdout1_176ck1830 FIND v(dout1_176) AT=1840.05n

.meas tran vdout1_177ck1830 FIND v(dout1_177) AT=1840.05n

.meas tran vdout1_178ck1830 FIND v(dout1_178) AT=1840.05n

.meas tran vdout1_179ck1830 FIND v(dout1_179) AT=1840.05n

.meas tran vdout1_180ck1830 FIND v(dout1_180) AT=1840.05n

.meas tran vdout1_181ck1830 FIND v(dout1_181) AT=1840.05n

.meas tran vdout1_182ck1830 FIND v(dout1_182) AT=1840.05n

.meas tran vdout1_183ck1830 FIND v(dout1_183) AT=1840.05n

.meas tran vdout1_184ck1830 FIND v(dout1_184) AT=1840.05n

.meas tran vdout1_185ck1830 FIND v(dout1_185) AT=1840.05n

.meas tran vdout1_186ck1830 FIND v(dout1_186) AT=1840.05n

.meas tran vdout1_187ck1830 FIND v(dout1_187) AT=1840.05n

.meas tran vdout1_188ck1830 FIND v(dout1_188) AT=1840.05n

.meas tran vdout1_189ck1830 FIND v(dout1_189) AT=1840.05n

.meas tran vdout1_190ck1830 FIND v(dout1_190) AT=1840.05n

.meas tran vdout1_191ck1830 FIND v(dout1_191) AT=1840.05n

.meas tran vdout1_192ck1830 FIND v(dout1_192) AT=1840.05n

.meas tran vdout1_193ck1830 FIND v(dout1_193) AT=1840.05n

.meas tran vdout1_194ck1830 FIND v(dout1_194) AT=1840.05n

.meas tran vdout1_195ck1830 FIND v(dout1_195) AT=1840.05n

.meas tran vdout1_196ck1830 FIND v(dout1_196) AT=1840.05n

.meas tran vdout1_197ck1830 FIND v(dout1_197) AT=1840.05n

.meas tran vdout1_198ck1830 FIND v(dout1_198) AT=1840.05n

.meas tran vdout1_199ck1830 FIND v(dout1_199) AT=1840.05n

.meas tran vdout1_200ck1830 FIND v(dout1_200) AT=1840.05n

.meas tran vdout1_201ck1830 FIND v(dout1_201) AT=1840.05n

.meas tran vdout1_202ck1830 FIND v(dout1_202) AT=1840.05n

.meas tran vdout1_203ck1830 FIND v(dout1_203) AT=1840.05n

.meas tran vdout1_204ck1830 FIND v(dout1_204) AT=1840.05n

.meas tran vdout1_205ck1830 FIND v(dout1_205) AT=1840.05n

.meas tran vdout1_206ck1830 FIND v(dout1_206) AT=1840.05n

.meas tran vdout1_207ck1830 FIND v(dout1_207) AT=1840.05n

.meas tran vdout1_208ck1830 FIND v(dout1_208) AT=1840.05n

.meas tran vdout1_209ck1830 FIND v(dout1_209) AT=1840.05n

.meas tran vdout1_210ck1830 FIND v(dout1_210) AT=1840.05n

.meas tran vdout1_211ck1830 FIND v(dout1_211) AT=1840.05n

.meas tran vdout1_212ck1830 FIND v(dout1_212) AT=1840.05n

.meas tran vdout1_213ck1830 FIND v(dout1_213) AT=1840.05n

.meas tran vdout1_214ck1830 FIND v(dout1_214) AT=1840.05n

.meas tran vdout1_215ck1830 FIND v(dout1_215) AT=1840.05n

.meas tran vdout1_216ck1830 FIND v(dout1_216) AT=1840.05n

.meas tran vdout1_217ck1830 FIND v(dout1_217) AT=1840.05n

.meas tran vdout1_218ck1830 FIND v(dout1_218) AT=1840.05n

.meas tran vdout1_219ck1830 FIND v(dout1_219) AT=1840.05n

.meas tran vdout1_220ck1830 FIND v(dout1_220) AT=1840.05n

.meas tran vdout1_221ck1830 FIND v(dout1_221) AT=1840.05n

.meas tran vdout1_222ck1830 FIND v(dout1_222) AT=1840.05n

.meas tran vdout1_223ck1830 FIND v(dout1_223) AT=1840.05n

.meas tran vdout1_224ck1830 FIND v(dout1_224) AT=1840.05n

.meas tran vdout1_225ck1830 FIND v(dout1_225) AT=1840.05n

.meas tran vdout1_226ck1830 FIND v(dout1_226) AT=1840.05n

.meas tran vdout1_227ck1830 FIND v(dout1_227) AT=1840.05n

.meas tran vdout1_228ck1830 FIND v(dout1_228) AT=1840.05n

.meas tran vdout1_229ck1830 FIND v(dout1_229) AT=1840.05n

.meas tran vdout1_230ck1830 FIND v(dout1_230) AT=1840.05n

.meas tran vdout1_231ck1830 FIND v(dout1_231) AT=1840.05n

.meas tran vdout1_232ck1830 FIND v(dout1_232) AT=1840.05n

.meas tran vdout1_233ck1830 FIND v(dout1_233) AT=1840.05n

.meas tran vdout1_234ck1830 FIND v(dout1_234) AT=1840.05n

.meas tran vdout1_235ck1830 FIND v(dout1_235) AT=1840.05n

.meas tran vdout1_236ck1830 FIND v(dout1_236) AT=1840.05n

.meas tran vdout1_237ck1830 FIND v(dout1_237) AT=1840.05n

.meas tran vdout1_238ck1830 FIND v(dout1_238) AT=1840.05n

.meas tran vdout1_239ck1830 FIND v(dout1_239) AT=1840.05n

.meas tran vdout1_240ck1830 FIND v(dout1_240) AT=1840.05n

.meas tran vdout1_241ck1830 FIND v(dout1_241) AT=1840.05n

.meas tran vdout1_242ck1830 FIND v(dout1_242) AT=1840.05n

.meas tran vdout1_243ck1830 FIND v(dout1_243) AT=1840.05n

.meas tran vdout1_244ck1830 FIND v(dout1_244) AT=1840.05n

.meas tran vdout1_245ck1830 FIND v(dout1_245) AT=1840.05n

.meas tran vdout1_246ck1830 FIND v(dout1_246) AT=1840.05n

.meas tran vdout1_247ck1830 FIND v(dout1_247) AT=1840.05n

.meas tran vdout1_248ck1830 FIND v(dout1_248) AT=1840.05n

.meas tran vdout1_249ck1830 FIND v(dout1_249) AT=1840.05n

.meas tran vdout1_250ck1830 FIND v(dout1_250) AT=1840.05n

.meas tran vdout1_251ck1830 FIND v(dout1_251) AT=1840.05n

.meas tran vdout1_252ck1830 FIND v(dout1_252) AT=1840.05n

.meas tran vdout1_253ck1830 FIND v(dout1_253) AT=1840.05n

.meas tran vdout1_254ck1830 FIND v(dout1_254) AT=1840.05n

.meas tran vdout1_255ck1830 FIND v(dout1_255) AT=1840.05n

.meas tran vdout1_256ck1830 FIND v(dout1_256) AT=1840.05n

.meas tran vdout1_0ck1840 FIND v(dout1_0) AT=1850.05n

.meas tran vdout1_1ck1840 FIND v(dout1_1) AT=1850.05n

.meas tran vdout1_2ck1840 FIND v(dout1_2) AT=1850.05n

.meas tran vdout1_3ck1840 FIND v(dout1_3) AT=1850.05n

.meas tran vdout1_4ck1840 FIND v(dout1_4) AT=1850.05n

.meas tran vdout1_5ck1840 FIND v(dout1_5) AT=1850.05n

.meas tran vdout1_6ck1840 FIND v(dout1_6) AT=1850.05n

.meas tran vdout1_7ck1840 FIND v(dout1_7) AT=1850.05n

.meas tran vdout1_8ck1840 FIND v(dout1_8) AT=1850.05n

.meas tran vdout1_9ck1840 FIND v(dout1_9) AT=1850.05n

.meas tran vdout1_10ck1840 FIND v(dout1_10) AT=1850.05n

.meas tran vdout1_11ck1840 FIND v(dout1_11) AT=1850.05n

.meas tran vdout1_12ck1840 FIND v(dout1_12) AT=1850.05n

.meas tran vdout1_13ck1840 FIND v(dout1_13) AT=1850.05n

.meas tran vdout1_14ck1840 FIND v(dout1_14) AT=1850.05n

.meas tran vdout1_15ck1840 FIND v(dout1_15) AT=1850.05n

.meas tran vdout1_16ck1840 FIND v(dout1_16) AT=1850.05n

.meas tran vdout1_17ck1840 FIND v(dout1_17) AT=1850.05n

.meas tran vdout1_18ck1840 FIND v(dout1_18) AT=1850.05n

.meas tran vdout1_19ck1840 FIND v(dout1_19) AT=1850.05n

.meas tran vdout1_20ck1840 FIND v(dout1_20) AT=1850.05n

.meas tran vdout1_21ck1840 FIND v(dout1_21) AT=1850.05n

.meas tran vdout1_22ck1840 FIND v(dout1_22) AT=1850.05n

.meas tran vdout1_23ck1840 FIND v(dout1_23) AT=1850.05n

.meas tran vdout1_24ck1840 FIND v(dout1_24) AT=1850.05n

.meas tran vdout1_25ck1840 FIND v(dout1_25) AT=1850.05n

.meas tran vdout1_26ck1840 FIND v(dout1_26) AT=1850.05n

.meas tran vdout1_27ck1840 FIND v(dout1_27) AT=1850.05n

.meas tran vdout1_28ck1840 FIND v(dout1_28) AT=1850.05n

.meas tran vdout1_29ck1840 FIND v(dout1_29) AT=1850.05n

.meas tran vdout1_30ck1840 FIND v(dout1_30) AT=1850.05n

.meas tran vdout1_31ck1840 FIND v(dout1_31) AT=1850.05n

.meas tran vdout1_32ck1840 FIND v(dout1_32) AT=1850.05n

.meas tran vdout1_33ck1840 FIND v(dout1_33) AT=1850.05n

.meas tran vdout1_34ck1840 FIND v(dout1_34) AT=1850.05n

.meas tran vdout1_35ck1840 FIND v(dout1_35) AT=1850.05n

.meas tran vdout1_36ck1840 FIND v(dout1_36) AT=1850.05n

.meas tran vdout1_37ck1840 FIND v(dout1_37) AT=1850.05n

.meas tran vdout1_38ck1840 FIND v(dout1_38) AT=1850.05n

.meas tran vdout1_39ck1840 FIND v(dout1_39) AT=1850.05n

.meas tran vdout1_40ck1840 FIND v(dout1_40) AT=1850.05n

.meas tran vdout1_41ck1840 FIND v(dout1_41) AT=1850.05n

.meas tran vdout1_42ck1840 FIND v(dout1_42) AT=1850.05n

.meas tran vdout1_43ck1840 FIND v(dout1_43) AT=1850.05n

.meas tran vdout1_44ck1840 FIND v(dout1_44) AT=1850.05n

.meas tran vdout1_45ck1840 FIND v(dout1_45) AT=1850.05n

.meas tran vdout1_46ck1840 FIND v(dout1_46) AT=1850.05n

.meas tran vdout1_47ck1840 FIND v(dout1_47) AT=1850.05n

.meas tran vdout1_48ck1840 FIND v(dout1_48) AT=1850.05n

.meas tran vdout1_49ck1840 FIND v(dout1_49) AT=1850.05n

.meas tran vdout1_50ck1840 FIND v(dout1_50) AT=1850.05n

.meas tran vdout1_51ck1840 FIND v(dout1_51) AT=1850.05n

.meas tran vdout1_52ck1840 FIND v(dout1_52) AT=1850.05n

.meas tran vdout1_53ck1840 FIND v(dout1_53) AT=1850.05n

.meas tran vdout1_54ck1840 FIND v(dout1_54) AT=1850.05n

.meas tran vdout1_55ck1840 FIND v(dout1_55) AT=1850.05n

.meas tran vdout1_56ck1840 FIND v(dout1_56) AT=1850.05n

.meas tran vdout1_57ck1840 FIND v(dout1_57) AT=1850.05n

.meas tran vdout1_58ck1840 FIND v(dout1_58) AT=1850.05n

.meas tran vdout1_59ck1840 FIND v(dout1_59) AT=1850.05n

.meas tran vdout1_60ck1840 FIND v(dout1_60) AT=1850.05n

.meas tran vdout1_61ck1840 FIND v(dout1_61) AT=1850.05n

.meas tran vdout1_62ck1840 FIND v(dout1_62) AT=1850.05n

.meas tran vdout1_63ck1840 FIND v(dout1_63) AT=1850.05n

.meas tran vdout1_64ck1840 FIND v(dout1_64) AT=1850.05n

.meas tran vdout1_65ck1840 FIND v(dout1_65) AT=1850.05n

.meas tran vdout1_66ck1840 FIND v(dout1_66) AT=1850.05n

.meas tran vdout1_67ck1840 FIND v(dout1_67) AT=1850.05n

.meas tran vdout1_68ck1840 FIND v(dout1_68) AT=1850.05n

.meas tran vdout1_69ck1840 FIND v(dout1_69) AT=1850.05n

.meas tran vdout1_70ck1840 FIND v(dout1_70) AT=1850.05n

.meas tran vdout1_71ck1840 FIND v(dout1_71) AT=1850.05n

.meas tran vdout1_72ck1840 FIND v(dout1_72) AT=1850.05n

.meas tran vdout1_73ck1840 FIND v(dout1_73) AT=1850.05n

.meas tran vdout1_74ck1840 FIND v(dout1_74) AT=1850.05n

.meas tran vdout1_75ck1840 FIND v(dout1_75) AT=1850.05n

.meas tran vdout1_76ck1840 FIND v(dout1_76) AT=1850.05n

.meas tran vdout1_77ck1840 FIND v(dout1_77) AT=1850.05n

.meas tran vdout1_78ck1840 FIND v(dout1_78) AT=1850.05n

.meas tran vdout1_79ck1840 FIND v(dout1_79) AT=1850.05n

.meas tran vdout1_80ck1840 FIND v(dout1_80) AT=1850.05n

.meas tran vdout1_81ck1840 FIND v(dout1_81) AT=1850.05n

.meas tran vdout1_82ck1840 FIND v(dout1_82) AT=1850.05n

.meas tran vdout1_83ck1840 FIND v(dout1_83) AT=1850.05n

.meas tran vdout1_84ck1840 FIND v(dout1_84) AT=1850.05n

.meas tran vdout1_85ck1840 FIND v(dout1_85) AT=1850.05n

.meas tran vdout1_86ck1840 FIND v(dout1_86) AT=1850.05n

.meas tran vdout1_87ck1840 FIND v(dout1_87) AT=1850.05n

.meas tran vdout1_88ck1840 FIND v(dout1_88) AT=1850.05n

.meas tran vdout1_89ck1840 FIND v(dout1_89) AT=1850.05n

.meas tran vdout1_90ck1840 FIND v(dout1_90) AT=1850.05n

.meas tran vdout1_91ck1840 FIND v(dout1_91) AT=1850.05n

.meas tran vdout1_92ck1840 FIND v(dout1_92) AT=1850.05n

.meas tran vdout1_93ck1840 FIND v(dout1_93) AT=1850.05n

.meas tran vdout1_94ck1840 FIND v(dout1_94) AT=1850.05n

.meas tran vdout1_95ck1840 FIND v(dout1_95) AT=1850.05n

.meas tran vdout1_96ck1840 FIND v(dout1_96) AT=1850.05n

.meas tran vdout1_97ck1840 FIND v(dout1_97) AT=1850.05n

.meas tran vdout1_98ck1840 FIND v(dout1_98) AT=1850.05n

.meas tran vdout1_99ck1840 FIND v(dout1_99) AT=1850.05n

.meas tran vdout1_100ck1840 FIND v(dout1_100) AT=1850.05n

.meas tran vdout1_101ck1840 FIND v(dout1_101) AT=1850.05n

.meas tran vdout1_102ck1840 FIND v(dout1_102) AT=1850.05n

.meas tran vdout1_103ck1840 FIND v(dout1_103) AT=1850.05n

.meas tran vdout1_104ck1840 FIND v(dout1_104) AT=1850.05n

.meas tran vdout1_105ck1840 FIND v(dout1_105) AT=1850.05n

.meas tran vdout1_106ck1840 FIND v(dout1_106) AT=1850.05n

.meas tran vdout1_107ck1840 FIND v(dout1_107) AT=1850.05n

.meas tran vdout1_108ck1840 FIND v(dout1_108) AT=1850.05n

.meas tran vdout1_109ck1840 FIND v(dout1_109) AT=1850.05n

.meas tran vdout1_110ck1840 FIND v(dout1_110) AT=1850.05n

.meas tran vdout1_111ck1840 FIND v(dout1_111) AT=1850.05n

.meas tran vdout1_112ck1840 FIND v(dout1_112) AT=1850.05n

.meas tran vdout1_113ck1840 FIND v(dout1_113) AT=1850.05n

.meas tran vdout1_114ck1840 FIND v(dout1_114) AT=1850.05n

.meas tran vdout1_115ck1840 FIND v(dout1_115) AT=1850.05n

.meas tran vdout1_116ck1840 FIND v(dout1_116) AT=1850.05n

.meas tran vdout1_117ck1840 FIND v(dout1_117) AT=1850.05n

.meas tran vdout1_118ck1840 FIND v(dout1_118) AT=1850.05n

.meas tran vdout1_119ck1840 FIND v(dout1_119) AT=1850.05n

.meas tran vdout1_120ck1840 FIND v(dout1_120) AT=1850.05n

.meas tran vdout1_121ck1840 FIND v(dout1_121) AT=1850.05n

.meas tran vdout1_122ck1840 FIND v(dout1_122) AT=1850.05n

.meas tran vdout1_123ck1840 FIND v(dout1_123) AT=1850.05n

.meas tran vdout1_124ck1840 FIND v(dout1_124) AT=1850.05n

.meas tran vdout1_125ck1840 FIND v(dout1_125) AT=1850.05n

.meas tran vdout1_126ck1840 FIND v(dout1_126) AT=1850.05n

.meas tran vdout1_127ck1840 FIND v(dout1_127) AT=1850.05n

.meas tran vdout1_128ck1840 FIND v(dout1_128) AT=1850.05n

.meas tran vdout1_129ck1840 FIND v(dout1_129) AT=1850.05n

.meas tran vdout1_130ck1840 FIND v(dout1_130) AT=1850.05n

.meas tran vdout1_131ck1840 FIND v(dout1_131) AT=1850.05n

.meas tran vdout1_132ck1840 FIND v(dout1_132) AT=1850.05n

.meas tran vdout1_133ck1840 FIND v(dout1_133) AT=1850.05n

.meas tran vdout1_134ck1840 FIND v(dout1_134) AT=1850.05n

.meas tran vdout1_135ck1840 FIND v(dout1_135) AT=1850.05n

.meas tran vdout1_136ck1840 FIND v(dout1_136) AT=1850.05n

.meas tran vdout1_137ck1840 FIND v(dout1_137) AT=1850.05n

.meas tran vdout1_138ck1840 FIND v(dout1_138) AT=1850.05n

.meas tran vdout1_139ck1840 FIND v(dout1_139) AT=1850.05n

.meas tran vdout1_140ck1840 FIND v(dout1_140) AT=1850.05n

.meas tran vdout1_141ck1840 FIND v(dout1_141) AT=1850.05n

.meas tran vdout1_142ck1840 FIND v(dout1_142) AT=1850.05n

.meas tran vdout1_143ck1840 FIND v(dout1_143) AT=1850.05n

.meas tran vdout1_144ck1840 FIND v(dout1_144) AT=1850.05n

.meas tran vdout1_145ck1840 FIND v(dout1_145) AT=1850.05n

.meas tran vdout1_146ck1840 FIND v(dout1_146) AT=1850.05n

.meas tran vdout1_147ck1840 FIND v(dout1_147) AT=1850.05n

.meas tran vdout1_148ck1840 FIND v(dout1_148) AT=1850.05n

.meas tran vdout1_149ck1840 FIND v(dout1_149) AT=1850.05n

.meas tran vdout1_150ck1840 FIND v(dout1_150) AT=1850.05n

.meas tran vdout1_151ck1840 FIND v(dout1_151) AT=1850.05n

.meas tran vdout1_152ck1840 FIND v(dout1_152) AT=1850.05n

.meas tran vdout1_153ck1840 FIND v(dout1_153) AT=1850.05n

.meas tran vdout1_154ck1840 FIND v(dout1_154) AT=1850.05n

.meas tran vdout1_155ck1840 FIND v(dout1_155) AT=1850.05n

.meas tran vdout1_156ck1840 FIND v(dout1_156) AT=1850.05n

.meas tran vdout1_157ck1840 FIND v(dout1_157) AT=1850.05n

.meas tran vdout1_158ck1840 FIND v(dout1_158) AT=1850.05n

.meas tran vdout1_159ck1840 FIND v(dout1_159) AT=1850.05n

.meas tran vdout1_160ck1840 FIND v(dout1_160) AT=1850.05n

.meas tran vdout1_161ck1840 FIND v(dout1_161) AT=1850.05n

.meas tran vdout1_162ck1840 FIND v(dout1_162) AT=1850.05n

.meas tran vdout1_163ck1840 FIND v(dout1_163) AT=1850.05n

.meas tran vdout1_164ck1840 FIND v(dout1_164) AT=1850.05n

.meas tran vdout1_165ck1840 FIND v(dout1_165) AT=1850.05n

.meas tran vdout1_166ck1840 FIND v(dout1_166) AT=1850.05n

.meas tran vdout1_167ck1840 FIND v(dout1_167) AT=1850.05n

.meas tran vdout1_168ck1840 FIND v(dout1_168) AT=1850.05n

.meas tran vdout1_169ck1840 FIND v(dout1_169) AT=1850.05n

.meas tran vdout1_170ck1840 FIND v(dout1_170) AT=1850.05n

.meas tran vdout1_171ck1840 FIND v(dout1_171) AT=1850.05n

.meas tran vdout1_172ck1840 FIND v(dout1_172) AT=1850.05n

.meas tran vdout1_173ck1840 FIND v(dout1_173) AT=1850.05n

.meas tran vdout1_174ck1840 FIND v(dout1_174) AT=1850.05n

.meas tran vdout1_175ck1840 FIND v(dout1_175) AT=1850.05n

.meas tran vdout1_176ck1840 FIND v(dout1_176) AT=1850.05n

.meas tran vdout1_177ck1840 FIND v(dout1_177) AT=1850.05n

.meas tran vdout1_178ck1840 FIND v(dout1_178) AT=1850.05n

.meas tran vdout1_179ck1840 FIND v(dout1_179) AT=1850.05n

.meas tran vdout1_180ck1840 FIND v(dout1_180) AT=1850.05n

.meas tran vdout1_181ck1840 FIND v(dout1_181) AT=1850.05n

.meas tran vdout1_182ck1840 FIND v(dout1_182) AT=1850.05n

.meas tran vdout1_183ck1840 FIND v(dout1_183) AT=1850.05n

.meas tran vdout1_184ck1840 FIND v(dout1_184) AT=1850.05n

.meas tran vdout1_185ck1840 FIND v(dout1_185) AT=1850.05n

.meas tran vdout1_186ck1840 FIND v(dout1_186) AT=1850.05n

.meas tran vdout1_187ck1840 FIND v(dout1_187) AT=1850.05n

.meas tran vdout1_188ck1840 FIND v(dout1_188) AT=1850.05n

.meas tran vdout1_189ck1840 FIND v(dout1_189) AT=1850.05n

.meas tran vdout1_190ck1840 FIND v(dout1_190) AT=1850.05n

.meas tran vdout1_191ck1840 FIND v(dout1_191) AT=1850.05n

.meas tran vdout1_192ck1840 FIND v(dout1_192) AT=1850.05n

.meas tran vdout1_193ck1840 FIND v(dout1_193) AT=1850.05n

.meas tran vdout1_194ck1840 FIND v(dout1_194) AT=1850.05n

.meas tran vdout1_195ck1840 FIND v(dout1_195) AT=1850.05n

.meas tran vdout1_196ck1840 FIND v(dout1_196) AT=1850.05n

.meas tran vdout1_197ck1840 FIND v(dout1_197) AT=1850.05n

.meas tran vdout1_198ck1840 FIND v(dout1_198) AT=1850.05n

.meas tran vdout1_199ck1840 FIND v(dout1_199) AT=1850.05n

.meas tran vdout1_200ck1840 FIND v(dout1_200) AT=1850.05n

.meas tran vdout1_201ck1840 FIND v(dout1_201) AT=1850.05n

.meas tran vdout1_202ck1840 FIND v(dout1_202) AT=1850.05n

.meas tran vdout1_203ck1840 FIND v(dout1_203) AT=1850.05n

.meas tran vdout1_204ck1840 FIND v(dout1_204) AT=1850.05n

.meas tran vdout1_205ck1840 FIND v(dout1_205) AT=1850.05n

.meas tran vdout1_206ck1840 FIND v(dout1_206) AT=1850.05n

.meas tran vdout1_207ck1840 FIND v(dout1_207) AT=1850.05n

.meas tran vdout1_208ck1840 FIND v(dout1_208) AT=1850.05n

.meas tran vdout1_209ck1840 FIND v(dout1_209) AT=1850.05n

.meas tran vdout1_210ck1840 FIND v(dout1_210) AT=1850.05n

.meas tran vdout1_211ck1840 FIND v(dout1_211) AT=1850.05n

.meas tran vdout1_212ck1840 FIND v(dout1_212) AT=1850.05n

.meas tran vdout1_213ck1840 FIND v(dout1_213) AT=1850.05n

.meas tran vdout1_214ck1840 FIND v(dout1_214) AT=1850.05n

.meas tran vdout1_215ck1840 FIND v(dout1_215) AT=1850.05n

.meas tran vdout1_216ck1840 FIND v(dout1_216) AT=1850.05n

.meas tran vdout1_217ck1840 FIND v(dout1_217) AT=1850.05n

.meas tran vdout1_218ck1840 FIND v(dout1_218) AT=1850.05n

.meas tran vdout1_219ck1840 FIND v(dout1_219) AT=1850.05n

.meas tran vdout1_220ck1840 FIND v(dout1_220) AT=1850.05n

.meas tran vdout1_221ck1840 FIND v(dout1_221) AT=1850.05n

.meas tran vdout1_222ck1840 FIND v(dout1_222) AT=1850.05n

.meas tran vdout1_223ck1840 FIND v(dout1_223) AT=1850.05n

.meas tran vdout1_224ck1840 FIND v(dout1_224) AT=1850.05n

.meas tran vdout1_225ck1840 FIND v(dout1_225) AT=1850.05n

.meas tran vdout1_226ck1840 FIND v(dout1_226) AT=1850.05n

.meas tran vdout1_227ck1840 FIND v(dout1_227) AT=1850.05n

.meas tran vdout1_228ck1840 FIND v(dout1_228) AT=1850.05n

.meas tran vdout1_229ck1840 FIND v(dout1_229) AT=1850.05n

.meas tran vdout1_230ck1840 FIND v(dout1_230) AT=1850.05n

.meas tran vdout1_231ck1840 FIND v(dout1_231) AT=1850.05n

.meas tran vdout1_232ck1840 FIND v(dout1_232) AT=1850.05n

.meas tran vdout1_233ck1840 FIND v(dout1_233) AT=1850.05n

.meas tran vdout1_234ck1840 FIND v(dout1_234) AT=1850.05n

.meas tran vdout1_235ck1840 FIND v(dout1_235) AT=1850.05n

.meas tran vdout1_236ck1840 FIND v(dout1_236) AT=1850.05n

.meas tran vdout1_237ck1840 FIND v(dout1_237) AT=1850.05n

.meas tran vdout1_238ck1840 FIND v(dout1_238) AT=1850.05n

.meas tran vdout1_239ck1840 FIND v(dout1_239) AT=1850.05n

.meas tran vdout1_240ck1840 FIND v(dout1_240) AT=1850.05n

.meas tran vdout1_241ck1840 FIND v(dout1_241) AT=1850.05n

.meas tran vdout1_242ck1840 FIND v(dout1_242) AT=1850.05n

.meas tran vdout1_243ck1840 FIND v(dout1_243) AT=1850.05n

.meas tran vdout1_244ck1840 FIND v(dout1_244) AT=1850.05n

.meas tran vdout1_245ck1840 FIND v(dout1_245) AT=1850.05n

.meas tran vdout1_246ck1840 FIND v(dout1_246) AT=1850.05n

.meas tran vdout1_247ck1840 FIND v(dout1_247) AT=1850.05n

.meas tran vdout1_248ck1840 FIND v(dout1_248) AT=1850.05n

.meas tran vdout1_249ck1840 FIND v(dout1_249) AT=1850.05n

.meas tran vdout1_250ck1840 FIND v(dout1_250) AT=1850.05n

.meas tran vdout1_251ck1840 FIND v(dout1_251) AT=1850.05n

.meas tran vdout1_252ck1840 FIND v(dout1_252) AT=1850.05n

.meas tran vdout1_253ck1840 FIND v(dout1_253) AT=1850.05n

.meas tran vdout1_254ck1840 FIND v(dout1_254) AT=1850.05n

.meas tran vdout1_255ck1840 FIND v(dout1_255) AT=1850.05n

.meas tran vdout1_256ck1840 FIND v(dout1_256) AT=1850.05n

.meas tran vdout1_0ck1900 FIND v(dout1_0) AT=1910.05n

.meas tran vdout1_1ck1900 FIND v(dout1_1) AT=1910.05n

.meas tran vdout1_2ck1900 FIND v(dout1_2) AT=1910.05n

.meas tran vdout1_3ck1900 FIND v(dout1_3) AT=1910.05n

.meas tran vdout1_4ck1900 FIND v(dout1_4) AT=1910.05n

.meas tran vdout1_5ck1900 FIND v(dout1_5) AT=1910.05n

.meas tran vdout1_6ck1900 FIND v(dout1_6) AT=1910.05n

.meas tran vdout1_7ck1900 FIND v(dout1_7) AT=1910.05n

.meas tran vdout1_8ck1900 FIND v(dout1_8) AT=1910.05n

.meas tran vdout1_9ck1900 FIND v(dout1_9) AT=1910.05n

.meas tran vdout1_10ck1900 FIND v(dout1_10) AT=1910.05n

.meas tran vdout1_11ck1900 FIND v(dout1_11) AT=1910.05n

.meas tran vdout1_12ck1900 FIND v(dout1_12) AT=1910.05n

.meas tran vdout1_13ck1900 FIND v(dout1_13) AT=1910.05n

.meas tran vdout1_14ck1900 FIND v(dout1_14) AT=1910.05n

.meas tran vdout1_15ck1900 FIND v(dout1_15) AT=1910.05n

.meas tran vdout1_16ck1900 FIND v(dout1_16) AT=1910.05n

.meas tran vdout1_17ck1900 FIND v(dout1_17) AT=1910.05n

.meas tran vdout1_18ck1900 FIND v(dout1_18) AT=1910.05n

.meas tran vdout1_19ck1900 FIND v(dout1_19) AT=1910.05n

.meas tran vdout1_20ck1900 FIND v(dout1_20) AT=1910.05n

.meas tran vdout1_21ck1900 FIND v(dout1_21) AT=1910.05n

.meas tran vdout1_22ck1900 FIND v(dout1_22) AT=1910.05n

.meas tran vdout1_23ck1900 FIND v(dout1_23) AT=1910.05n

.meas tran vdout1_24ck1900 FIND v(dout1_24) AT=1910.05n

.meas tran vdout1_25ck1900 FIND v(dout1_25) AT=1910.05n

.meas tran vdout1_26ck1900 FIND v(dout1_26) AT=1910.05n

.meas tran vdout1_27ck1900 FIND v(dout1_27) AT=1910.05n

.meas tran vdout1_28ck1900 FIND v(dout1_28) AT=1910.05n

.meas tran vdout1_29ck1900 FIND v(dout1_29) AT=1910.05n

.meas tran vdout1_30ck1900 FIND v(dout1_30) AT=1910.05n

.meas tran vdout1_31ck1900 FIND v(dout1_31) AT=1910.05n

.meas tran vdout1_32ck1900 FIND v(dout1_32) AT=1910.05n

.meas tran vdout1_33ck1900 FIND v(dout1_33) AT=1910.05n

.meas tran vdout1_34ck1900 FIND v(dout1_34) AT=1910.05n

.meas tran vdout1_35ck1900 FIND v(dout1_35) AT=1910.05n

.meas tran vdout1_36ck1900 FIND v(dout1_36) AT=1910.05n

.meas tran vdout1_37ck1900 FIND v(dout1_37) AT=1910.05n

.meas tran vdout1_38ck1900 FIND v(dout1_38) AT=1910.05n

.meas tran vdout1_39ck1900 FIND v(dout1_39) AT=1910.05n

.meas tran vdout1_40ck1900 FIND v(dout1_40) AT=1910.05n

.meas tran vdout1_41ck1900 FIND v(dout1_41) AT=1910.05n

.meas tran vdout1_42ck1900 FIND v(dout1_42) AT=1910.05n

.meas tran vdout1_43ck1900 FIND v(dout1_43) AT=1910.05n

.meas tran vdout1_44ck1900 FIND v(dout1_44) AT=1910.05n

.meas tran vdout1_45ck1900 FIND v(dout1_45) AT=1910.05n

.meas tran vdout1_46ck1900 FIND v(dout1_46) AT=1910.05n

.meas tran vdout1_47ck1900 FIND v(dout1_47) AT=1910.05n

.meas tran vdout1_48ck1900 FIND v(dout1_48) AT=1910.05n

.meas tran vdout1_49ck1900 FIND v(dout1_49) AT=1910.05n

.meas tran vdout1_50ck1900 FIND v(dout1_50) AT=1910.05n

.meas tran vdout1_51ck1900 FIND v(dout1_51) AT=1910.05n

.meas tran vdout1_52ck1900 FIND v(dout1_52) AT=1910.05n

.meas tran vdout1_53ck1900 FIND v(dout1_53) AT=1910.05n

.meas tran vdout1_54ck1900 FIND v(dout1_54) AT=1910.05n

.meas tran vdout1_55ck1900 FIND v(dout1_55) AT=1910.05n

.meas tran vdout1_56ck1900 FIND v(dout1_56) AT=1910.05n

.meas tran vdout1_57ck1900 FIND v(dout1_57) AT=1910.05n

.meas tran vdout1_58ck1900 FIND v(dout1_58) AT=1910.05n

.meas tran vdout1_59ck1900 FIND v(dout1_59) AT=1910.05n

.meas tran vdout1_60ck1900 FIND v(dout1_60) AT=1910.05n

.meas tran vdout1_61ck1900 FIND v(dout1_61) AT=1910.05n

.meas tran vdout1_62ck1900 FIND v(dout1_62) AT=1910.05n

.meas tran vdout1_63ck1900 FIND v(dout1_63) AT=1910.05n

.meas tran vdout1_64ck1900 FIND v(dout1_64) AT=1910.05n

.meas tran vdout1_65ck1900 FIND v(dout1_65) AT=1910.05n

.meas tran vdout1_66ck1900 FIND v(dout1_66) AT=1910.05n

.meas tran vdout1_67ck1900 FIND v(dout1_67) AT=1910.05n

.meas tran vdout1_68ck1900 FIND v(dout1_68) AT=1910.05n

.meas tran vdout1_69ck1900 FIND v(dout1_69) AT=1910.05n

.meas tran vdout1_70ck1900 FIND v(dout1_70) AT=1910.05n

.meas tran vdout1_71ck1900 FIND v(dout1_71) AT=1910.05n

.meas tran vdout1_72ck1900 FIND v(dout1_72) AT=1910.05n

.meas tran vdout1_73ck1900 FIND v(dout1_73) AT=1910.05n

.meas tran vdout1_74ck1900 FIND v(dout1_74) AT=1910.05n

.meas tran vdout1_75ck1900 FIND v(dout1_75) AT=1910.05n

.meas tran vdout1_76ck1900 FIND v(dout1_76) AT=1910.05n

.meas tran vdout1_77ck1900 FIND v(dout1_77) AT=1910.05n

.meas tran vdout1_78ck1900 FIND v(dout1_78) AT=1910.05n

.meas tran vdout1_79ck1900 FIND v(dout1_79) AT=1910.05n

.meas tran vdout1_80ck1900 FIND v(dout1_80) AT=1910.05n

.meas tran vdout1_81ck1900 FIND v(dout1_81) AT=1910.05n

.meas tran vdout1_82ck1900 FIND v(dout1_82) AT=1910.05n

.meas tran vdout1_83ck1900 FIND v(dout1_83) AT=1910.05n

.meas tran vdout1_84ck1900 FIND v(dout1_84) AT=1910.05n

.meas tran vdout1_85ck1900 FIND v(dout1_85) AT=1910.05n

.meas tran vdout1_86ck1900 FIND v(dout1_86) AT=1910.05n

.meas tran vdout1_87ck1900 FIND v(dout1_87) AT=1910.05n

.meas tran vdout1_88ck1900 FIND v(dout1_88) AT=1910.05n

.meas tran vdout1_89ck1900 FIND v(dout1_89) AT=1910.05n

.meas tran vdout1_90ck1900 FIND v(dout1_90) AT=1910.05n

.meas tran vdout1_91ck1900 FIND v(dout1_91) AT=1910.05n

.meas tran vdout1_92ck1900 FIND v(dout1_92) AT=1910.05n

.meas tran vdout1_93ck1900 FIND v(dout1_93) AT=1910.05n

.meas tran vdout1_94ck1900 FIND v(dout1_94) AT=1910.05n

.meas tran vdout1_95ck1900 FIND v(dout1_95) AT=1910.05n

.meas tran vdout1_96ck1900 FIND v(dout1_96) AT=1910.05n

.meas tran vdout1_97ck1900 FIND v(dout1_97) AT=1910.05n

.meas tran vdout1_98ck1900 FIND v(dout1_98) AT=1910.05n

.meas tran vdout1_99ck1900 FIND v(dout1_99) AT=1910.05n

.meas tran vdout1_100ck1900 FIND v(dout1_100) AT=1910.05n

.meas tran vdout1_101ck1900 FIND v(dout1_101) AT=1910.05n

.meas tran vdout1_102ck1900 FIND v(dout1_102) AT=1910.05n

.meas tran vdout1_103ck1900 FIND v(dout1_103) AT=1910.05n

.meas tran vdout1_104ck1900 FIND v(dout1_104) AT=1910.05n

.meas tran vdout1_105ck1900 FIND v(dout1_105) AT=1910.05n

.meas tran vdout1_106ck1900 FIND v(dout1_106) AT=1910.05n

.meas tran vdout1_107ck1900 FIND v(dout1_107) AT=1910.05n

.meas tran vdout1_108ck1900 FIND v(dout1_108) AT=1910.05n

.meas tran vdout1_109ck1900 FIND v(dout1_109) AT=1910.05n

.meas tran vdout1_110ck1900 FIND v(dout1_110) AT=1910.05n

.meas tran vdout1_111ck1900 FIND v(dout1_111) AT=1910.05n

.meas tran vdout1_112ck1900 FIND v(dout1_112) AT=1910.05n

.meas tran vdout1_113ck1900 FIND v(dout1_113) AT=1910.05n

.meas tran vdout1_114ck1900 FIND v(dout1_114) AT=1910.05n

.meas tran vdout1_115ck1900 FIND v(dout1_115) AT=1910.05n

.meas tran vdout1_116ck1900 FIND v(dout1_116) AT=1910.05n

.meas tran vdout1_117ck1900 FIND v(dout1_117) AT=1910.05n

.meas tran vdout1_118ck1900 FIND v(dout1_118) AT=1910.05n

.meas tran vdout1_119ck1900 FIND v(dout1_119) AT=1910.05n

.meas tran vdout1_120ck1900 FIND v(dout1_120) AT=1910.05n

.meas tran vdout1_121ck1900 FIND v(dout1_121) AT=1910.05n

.meas tran vdout1_122ck1900 FIND v(dout1_122) AT=1910.05n

.meas tran vdout1_123ck1900 FIND v(dout1_123) AT=1910.05n

.meas tran vdout1_124ck1900 FIND v(dout1_124) AT=1910.05n

.meas tran vdout1_125ck1900 FIND v(dout1_125) AT=1910.05n

.meas tran vdout1_126ck1900 FIND v(dout1_126) AT=1910.05n

.meas tran vdout1_127ck1900 FIND v(dout1_127) AT=1910.05n

.meas tran vdout1_128ck1900 FIND v(dout1_128) AT=1910.05n

.meas tran vdout1_129ck1900 FIND v(dout1_129) AT=1910.05n

.meas tran vdout1_130ck1900 FIND v(dout1_130) AT=1910.05n

.meas tran vdout1_131ck1900 FIND v(dout1_131) AT=1910.05n

.meas tran vdout1_132ck1900 FIND v(dout1_132) AT=1910.05n

.meas tran vdout1_133ck1900 FIND v(dout1_133) AT=1910.05n

.meas tran vdout1_134ck1900 FIND v(dout1_134) AT=1910.05n

.meas tran vdout1_135ck1900 FIND v(dout1_135) AT=1910.05n

.meas tran vdout1_136ck1900 FIND v(dout1_136) AT=1910.05n

.meas tran vdout1_137ck1900 FIND v(dout1_137) AT=1910.05n

.meas tran vdout1_138ck1900 FIND v(dout1_138) AT=1910.05n

.meas tran vdout1_139ck1900 FIND v(dout1_139) AT=1910.05n

.meas tran vdout1_140ck1900 FIND v(dout1_140) AT=1910.05n

.meas tran vdout1_141ck1900 FIND v(dout1_141) AT=1910.05n

.meas tran vdout1_142ck1900 FIND v(dout1_142) AT=1910.05n

.meas tran vdout1_143ck1900 FIND v(dout1_143) AT=1910.05n

.meas tran vdout1_144ck1900 FIND v(dout1_144) AT=1910.05n

.meas tran vdout1_145ck1900 FIND v(dout1_145) AT=1910.05n

.meas tran vdout1_146ck1900 FIND v(dout1_146) AT=1910.05n

.meas tran vdout1_147ck1900 FIND v(dout1_147) AT=1910.05n

.meas tran vdout1_148ck1900 FIND v(dout1_148) AT=1910.05n

.meas tran vdout1_149ck1900 FIND v(dout1_149) AT=1910.05n

.meas tran vdout1_150ck1900 FIND v(dout1_150) AT=1910.05n

.meas tran vdout1_151ck1900 FIND v(dout1_151) AT=1910.05n

.meas tran vdout1_152ck1900 FIND v(dout1_152) AT=1910.05n

.meas tran vdout1_153ck1900 FIND v(dout1_153) AT=1910.05n

.meas tran vdout1_154ck1900 FIND v(dout1_154) AT=1910.05n

.meas tran vdout1_155ck1900 FIND v(dout1_155) AT=1910.05n

.meas tran vdout1_156ck1900 FIND v(dout1_156) AT=1910.05n

.meas tran vdout1_157ck1900 FIND v(dout1_157) AT=1910.05n

.meas tran vdout1_158ck1900 FIND v(dout1_158) AT=1910.05n

.meas tran vdout1_159ck1900 FIND v(dout1_159) AT=1910.05n

.meas tran vdout1_160ck1900 FIND v(dout1_160) AT=1910.05n

.meas tran vdout1_161ck1900 FIND v(dout1_161) AT=1910.05n

.meas tran vdout1_162ck1900 FIND v(dout1_162) AT=1910.05n

.meas tran vdout1_163ck1900 FIND v(dout1_163) AT=1910.05n

.meas tran vdout1_164ck1900 FIND v(dout1_164) AT=1910.05n

.meas tran vdout1_165ck1900 FIND v(dout1_165) AT=1910.05n

.meas tran vdout1_166ck1900 FIND v(dout1_166) AT=1910.05n

.meas tran vdout1_167ck1900 FIND v(dout1_167) AT=1910.05n

.meas tran vdout1_168ck1900 FIND v(dout1_168) AT=1910.05n

.meas tran vdout1_169ck1900 FIND v(dout1_169) AT=1910.05n

.meas tran vdout1_170ck1900 FIND v(dout1_170) AT=1910.05n

.meas tran vdout1_171ck1900 FIND v(dout1_171) AT=1910.05n

.meas tran vdout1_172ck1900 FIND v(dout1_172) AT=1910.05n

.meas tran vdout1_173ck1900 FIND v(dout1_173) AT=1910.05n

.meas tran vdout1_174ck1900 FIND v(dout1_174) AT=1910.05n

.meas tran vdout1_175ck1900 FIND v(dout1_175) AT=1910.05n

.meas tran vdout1_176ck1900 FIND v(dout1_176) AT=1910.05n

.meas tran vdout1_177ck1900 FIND v(dout1_177) AT=1910.05n

.meas tran vdout1_178ck1900 FIND v(dout1_178) AT=1910.05n

.meas tran vdout1_179ck1900 FIND v(dout1_179) AT=1910.05n

.meas tran vdout1_180ck1900 FIND v(dout1_180) AT=1910.05n

.meas tran vdout1_181ck1900 FIND v(dout1_181) AT=1910.05n

.meas tran vdout1_182ck1900 FIND v(dout1_182) AT=1910.05n

.meas tran vdout1_183ck1900 FIND v(dout1_183) AT=1910.05n

.meas tran vdout1_184ck1900 FIND v(dout1_184) AT=1910.05n

.meas tran vdout1_185ck1900 FIND v(dout1_185) AT=1910.05n

.meas tran vdout1_186ck1900 FIND v(dout1_186) AT=1910.05n

.meas tran vdout1_187ck1900 FIND v(dout1_187) AT=1910.05n

.meas tran vdout1_188ck1900 FIND v(dout1_188) AT=1910.05n

.meas tran vdout1_189ck1900 FIND v(dout1_189) AT=1910.05n

.meas tran vdout1_190ck1900 FIND v(dout1_190) AT=1910.05n

.meas tran vdout1_191ck1900 FIND v(dout1_191) AT=1910.05n

.meas tran vdout1_192ck1900 FIND v(dout1_192) AT=1910.05n

.meas tran vdout1_193ck1900 FIND v(dout1_193) AT=1910.05n

.meas tran vdout1_194ck1900 FIND v(dout1_194) AT=1910.05n

.meas tran vdout1_195ck1900 FIND v(dout1_195) AT=1910.05n

.meas tran vdout1_196ck1900 FIND v(dout1_196) AT=1910.05n

.meas tran vdout1_197ck1900 FIND v(dout1_197) AT=1910.05n

.meas tran vdout1_198ck1900 FIND v(dout1_198) AT=1910.05n

.meas tran vdout1_199ck1900 FIND v(dout1_199) AT=1910.05n

.meas tran vdout1_200ck1900 FIND v(dout1_200) AT=1910.05n

.meas tran vdout1_201ck1900 FIND v(dout1_201) AT=1910.05n

.meas tran vdout1_202ck1900 FIND v(dout1_202) AT=1910.05n

.meas tran vdout1_203ck1900 FIND v(dout1_203) AT=1910.05n

.meas tran vdout1_204ck1900 FIND v(dout1_204) AT=1910.05n

.meas tran vdout1_205ck1900 FIND v(dout1_205) AT=1910.05n

.meas tran vdout1_206ck1900 FIND v(dout1_206) AT=1910.05n

.meas tran vdout1_207ck1900 FIND v(dout1_207) AT=1910.05n

.meas tran vdout1_208ck1900 FIND v(dout1_208) AT=1910.05n

.meas tran vdout1_209ck1900 FIND v(dout1_209) AT=1910.05n

.meas tran vdout1_210ck1900 FIND v(dout1_210) AT=1910.05n

.meas tran vdout1_211ck1900 FIND v(dout1_211) AT=1910.05n

.meas tran vdout1_212ck1900 FIND v(dout1_212) AT=1910.05n

.meas tran vdout1_213ck1900 FIND v(dout1_213) AT=1910.05n

.meas tran vdout1_214ck1900 FIND v(dout1_214) AT=1910.05n

.meas tran vdout1_215ck1900 FIND v(dout1_215) AT=1910.05n

.meas tran vdout1_216ck1900 FIND v(dout1_216) AT=1910.05n

.meas tran vdout1_217ck1900 FIND v(dout1_217) AT=1910.05n

.meas tran vdout1_218ck1900 FIND v(dout1_218) AT=1910.05n

.meas tran vdout1_219ck1900 FIND v(dout1_219) AT=1910.05n

.meas tran vdout1_220ck1900 FIND v(dout1_220) AT=1910.05n

.meas tran vdout1_221ck1900 FIND v(dout1_221) AT=1910.05n

.meas tran vdout1_222ck1900 FIND v(dout1_222) AT=1910.05n

.meas tran vdout1_223ck1900 FIND v(dout1_223) AT=1910.05n

.meas tran vdout1_224ck1900 FIND v(dout1_224) AT=1910.05n

.meas tran vdout1_225ck1900 FIND v(dout1_225) AT=1910.05n

.meas tran vdout1_226ck1900 FIND v(dout1_226) AT=1910.05n

.meas tran vdout1_227ck1900 FIND v(dout1_227) AT=1910.05n

.meas tran vdout1_228ck1900 FIND v(dout1_228) AT=1910.05n

.meas tran vdout1_229ck1900 FIND v(dout1_229) AT=1910.05n

.meas tran vdout1_230ck1900 FIND v(dout1_230) AT=1910.05n

.meas tran vdout1_231ck1900 FIND v(dout1_231) AT=1910.05n

.meas tran vdout1_232ck1900 FIND v(dout1_232) AT=1910.05n

.meas tran vdout1_233ck1900 FIND v(dout1_233) AT=1910.05n

.meas tran vdout1_234ck1900 FIND v(dout1_234) AT=1910.05n

.meas tran vdout1_235ck1900 FIND v(dout1_235) AT=1910.05n

.meas tran vdout1_236ck1900 FIND v(dout1_236) AT=1910.05n

.meas tran vdout1_237ck1900 FIND v(dout1_237) AT=1910.05n

.meas tran vdout1_238ck1900 FIND v(dout1_238) AT=1910.05n

.meas tran vdout1_239ck1900 FIND v(dout1_239) AT=1910.05n

.meas tran vdout1_240ck1900 FIND v(dout1_240) AT=1910.05n

.meas tran vdout1_241ck1900 FIND v(dout1_241) AT=1910.05n

.meas tran vdout1_242ck1900 FIND v(dout1_242) AT=1910.05n

.meas tran vdout1_243ck1900 FIND v(dout1_243) AT=1910.05n

.meas tran vdout1_244ck1900 FIND v(dout1_244) AT=1910.05n

.meas tran vdout1_245ck1900 FIND v(dout1_245) AT=1910.05n

.meas tran vdout1_246ck1900 FIND v(dout1_246) AT=1910.05n

.meas tran vdout1_247ck1900 FIND v(dout1_247) AT=1910.05n

.meas tran vdout1_248ck1900 FIND v(dout1_248) AT=1910.05n

.meas tran vdout1_249ck1900 FIND v(dout1_249) AT=1910.05n

.meas tran vdout1_250ck1900 FIND v(dout1_250) AT=1910.05n

.meas tran vdout1_251ck1900 FIND v(dout1_251) AT=1910.05n

.meas tran vdout1_252ck1900 FIND v(dout1_252) AT=1910.05n

.meas tran vdout1_253ck1900 FIND v(dout1_253) AT=1910.05n

.meas tran vdout1_254ck1900 FIND v(dout1_254) AT=1910.05n

.meas tran vdout1_255ck1900 FIND v(dout1_255) AT=1910.05n

.meas tran vdout1_256ck1900 FIND v(dout1_256) AT=1910.05n

.meas tran vdout1_0ck1910 FIND v(dout1_0) AT=1920.05n

.meas tran vdout1_1ck1910 FIND v(dout1_1) AT=1920.05n

.meas tran vdout1_2ck1910 FIND v(dout1_2) AT=1920.05n

.meas tran vdout1_3ck1910 FIND v(dout1_3) AT=1920.05n

.meas tran vdout1_4ck1910 FIND v(dout1_4) AT=1920.05n

.meas tran vdout1_5ck1910 FIND v(dout1_5) AT=1920.05n

.meas tran vdout1_6ck1910 FIND v(dout1_6) AT=1920.05n

.meas tran vdout1_7ck1910 FIND v(dout1_7) AT=1920.05n

.meas tran vdout1_8ck1910 FIND v(dout1_8) AT=1920.05n

.meas tran vdout1_9ck1910 FIND v(dout1_9) AT=1920.05n

.meas tran vdout1_10ck1910 FIND v(dout1_10) AT=1920.05n

.meas tran vdout1_11ck1910 FIND v(dout1_11) AT=1920.05n

.meas tran vdout1_12ck1910 FIND v(dout1_12) AT=1920.05n

.meas tran vdout1_13ck1910 FIND v(dout1_13) AT=1920.05n

.meas tran vdout1_14ck1910 FIND v(dout1_14) AT=1920.05n

.meas tran vdout1_15ck1910 FIND v(dout1_15) AT=1920.05n

.meas tran vdout1_16ck1910 FIND v(dout1_16) AT=1920.05n

.meas tran vdout1_17ck1910 FIND v(dout1_17) AT=1920.05n

.meas tran vdout1_18ck1910 FIND v(dout1_18) AT=1920.05n

.meas tran vdout1_19ck1910 FIND v(dout1_19) AT=1920.05n

.meas tran vdout1_20ck1910 FIND v(dout1_20) AT=1920.05n

.meas tran vdout1_21ck1910 FIND v(dout1_21) AT=1920.05n

.meas tran vdout1_22ck1910 FIND v(dout1_22) AT=1920.05n

.meas tran vdout1_23ck1910 FIND v(dout1_23) AT=1920.05n

.meas tran vdout1_24ck1910 FIND v(dout1_24) AT=1920.05n

.meas tran vdout1_25ck1910 FIND v(dout1_25) AT=1920.05n

.meas tran vdout1_26ck1910 FIND v(dout1_26) AT=1920.05n

.meas tran vdout1_27ck1910 FIND v(dout1_27) AT=1920.05n

.meas tran vdout1_28ck1910 FIND v(dout1_28) AT=1920.05n

.meas tran vdout1_29ck1910 FIND v(dout1_29) AT=1920.05n

.meas tran vdout1_30ck1910 FIND v(dout1_30) AT=1920.05n

.meas tran vdout1_31ck1910 FIND v(dout1_31) AT=1920.05n

.meas tran vdout1_32ck1910 FIND v(dout1_32) AT=1920.05n

.meas tran vdout1_33ck1910 FIND v(dout1_33) AT=1920.05n

.meas tran vdout1_34ck1910 FIND v(dout1_34) AT=1920.05n

.meas tran vdout1_35ck1910 FIND v(dout1_35) AT=1920.05n

.meas tran vdout1_36ck1910 FIND v(dout1_36) AT=1920.05n

.meas tran vdout1_37ck1910 FIND v(dout1_37) AT=1920.05n

.meas tran vdout1_38ck1910 FIND v(dout1_38) AT=1920.05n

.meas tran vdout1_39ck1910 FIND v(dout1_39) AT=1920.05n

.meas tran vdout1_40ck1910 FIND v(dout1_40) AT=1920.05n

.meas tran vdout1_41ck1910 FIND v(dout1_41) AT=1920.05n

.meas tran vdout1_42ck1910 FIND v(dout1_42) AT=1920.05n

.meas tran vdout1_43ck1910 FIND v(dout1_43) AT=1920.05n

.meas tran vdout1_44ck1910 FIND v(dout1_44) AT=1920.05n

.meas tran vdout1_45ck1910 FIND v(dout1_45) AT=1920.05n

.meas tran vdout1_46ck1910 FIND v(dout1_46) AT=1920.05n

.meas tran vdout1_47ck1910 FIND v(dout1_47) AT=1920.05n

.meas tran vdout1_48ck1910 FIND v(dout1_48) AT=1920.05n

.meas tran vdout1_49ck1910 FIND v(dout1_49) AT=1920.05n

.meas tran vdout1_50ck1910 FIND v(dout1_50) AT=1920.05n

.meas tran vdout1_51ck1910 FIND v(dout1_51) AT=1920.05n

.meas tran vdout1_52ck1910 FIND v(dout1_52) AT=1920.05n

.meas tran vdout1_53ck1910 FIND v(dout1_53) AT=1920.05n

.meas tran vdout1_54ck1910 FIND v(dout1_54) AT=1920.05n

.meas tran vdout1_55ck1910 FIND v(dout1_55) AT=1920.05n

.meas tran vdout1_56ck1910 FIND v(dout1_56) AT=1920.05n

.meas tran vdout1_57ck1910 FIND v(dout1_57) AT=1920.05n

.meas tran vdout1_58ck1910 FIND v(dout1_58) AT=1920.05n

.meas tran vdout1_59ck1910 FIND v(dout1_59) AT=1920.05n

.meas tran vdout1_60ck1910 FIND v(dout1_60) AT=1920.05n

.meas tran vdout1_61ck1910 FIND v(dout1_61) AT=1920.05n

.meas tran vdout1_62ck1910 FIND v(dout1_62) AT=1920.05n

.meas tran vdout1_63ck1910 FIND v(dout1_63) AT=1920.05n

.meas tran vdout1_64ck1910 FIND v(dout1_64) AT=1920.05n

.meas tran vdout1_65ck1910 FIND v(dout1_65) AT=1920.05n

.meas tran vdout1_66ck1910 FIND v(dout1_66) AT=1920.05n

.meas tran vdout1_67ck1910 FIND v(dout1_67) AT=1920.05n

.meas tran vdout1_68ck1910 FIND v(dout1_68) AT=1920.05n

.meas tran vdout1_69ck1910 FIND v(dout1_69) AT=1920.05n

.meas tran vdout1_70ck1910 FIND v(dout1_70) AT=1920.05n

.meas tran vdout1_71ck1910 FIND v(dout1_71) AT=1920.05n

.meas tran vdout1_72ck1910 FIND v(dout1_72) AT=1920.05n

.meas tran vdout1_73ck1910 FIND v(dout1_73) AT=1920.05n

.meas tran vdout1_74ck1910 FIND v(dout1_74) AT=1920.05n

.meas tran vdout1_75ck1910 FIND v(dout1_75) AT=1920.05n

.meas tran vdout1_76ck1910 FIND v(dout1_76) AT=1920.05n

.meas tran vdout1_77ck1910 FIND v(dout1_77) AT=1920.05n

.meas tran vdout1_78ck1910 FIND v(dout1_78) AT=1920.05n

.meas tran vdout1_79ck1910 FIND v(dout1_79) AT=1920.05n

.meas tran vdout1_80ck1910 FIND v(dout1_80) AT=1920.05n

.meas tran vdout1_81ck1910 FIND v(dout1_81) AT=1920.05n

.meas tran vdout1_82ck1910 FIND v(dout1_82) AT=1920.05n

.meas tran vdout1_83ck1910 FIND v(dout1_83) AT=1920.05n

.meas tran vdout1_84ck1910 FIND v(dout1_84) AT=1920.05n

.meas tran vdout1_85ck1910 FIND v(dout1_85) AT=1920.05n

.meas tran vdout1_86ck1910 FIND v(dout1_86) AT=1920.05n

.meas tran vdout1_87ck1910 FIND v(dout1_87) AT=1920.05n

.meas tran vdout1_88ck1910 FIND v(dout1_88) AT=1920.05n

.meas tran vdout1_89ck1910 FIND v(dout1_89) AT=1920.05n

.meas tran vdout1_90ck1910 FIND v(dout1_90) AT=1920.05n

.meas tran vdout1_91ck1910 FIND v(dout1_91) AT=1920.05n

.meas tran vdout1_92ck1910 FIND v(dout1_92) AT=1920.05n

.meas tran vdout1_93ck1910 FIND v(dout1_93) AT=1920.05n

.meas tran vdout1_94ck1910 FIND v(dout1_94) AT=1920.05n

.meas tran vdout1_95ck1910 FIND v(dout1_95) AT=1920.05n

.meas tran vdout1_96ck1910 FIND v(dout1_96) AT=1920.05n

.meas tran vdout1_97ck1910 FIND v(dout1_97) AT=1920.05n

.meas tran vdout1_98ck1910 FIND v(dout1_98) AT=1920.05n

.meas tran vdout1_99ck1910 FIND v(dout1_99) AT=1920.05n

.meas tran vdout1_100ck1910 FIND v(dout1_100) AT=1920.05n

.meas tran vdout1_101ck1910 FIND v(dout1_101) AT=1920.05n

.meas tran vdout1_102ck1910 FIND v(dout1_102) AT=1920.05n

.meas tran vdout1_103ck1910 FIND v(dout1_103) AT=1920.05n

.meas tran vdout1_104ck1910 FIND v(dout1_104) AT=1920.05n

.meas tran vdout1_105ck1910 FIND v(dout1_105) AT=1920.05n

.meas tran vdout1_106ck1910 FIND v(dout1_106) AT=1920.05n

.meas tran vdout1_107ck1910 FIND v(dout1_107) AT=1920.05n

.meas tran vdout1_108ck1910 FIND v(dout1_108) AT=1920.05n

.meas tran vdout1_109ck1910 FIND v(dout1_109) AT=1920.05n

.meas tran vdout1_110ck1910 FIND v(dout1_110) AT=1920.05n

.meas tran vdout1_111ck1910 FIND v(dout1_111) AT=1920.05n

.meas tran vdout1_112ck1910 FIND v(dout1_112) AT=1920.05n

.meas tran vdout1_113ck1910 FIND v(dout1_113) AT=1920.05n

.meas tran vdout1_114ck1910 FIND v(dout1_114) AT=1920.05n

.meas tran vdout1_115ck1910 FIND v(dout1_115) AT=1920.05n

.meas tran vdout1_116ck1910 FIND v(dout1_116) AT=1920.05n

.meas tran vdout1_117ck1910 FIND v(dout1_117) AT=1920.05n

.meas tran vdout1_118ck1910 FIND v(dout1_118) AT=1920.05n

.meas tran vdout1_119ck1910 FIND v(dout1_119) AT=1920.05n

.meas tran vdout1_120ck1910 FIND v(dout1_120) AT=1920.05n

.meas tran vdout1_121ck1910 FIND v(dout1_121) AT=1920.05n

.meas tran vdout1_122ck1910 FIND v(dout1_122) AT=1920.05n

.meas tran vdout1_123ck1910 FIND v(dout1_123) AT=1920.05n

.meas tran vdout1_124ck1910 FIND v(dout1_124) AT=1920.05n

.meas tran vdout1_125ck1910 FIND v(dout1_125) AT=1920.05n

.meas tran vdout1_126ck1910 FIND v(dout1_126) AT=1920.05n

.meas tran vdout1_127ck1910 FIND v(dout1_127) AT=1920.05n

.meas tran vdout1_128ck1910 FIND v(dout1_128) AT=1920.05n

.meas tran vdout1_129ck1910 FIND v(dout1_129) AT=1920.05n

.meas tran vdout1_130ck1910 FIND v(dout1_130) AT=1920.05n

.meas tran vdout1_131ck1910 FIND v(dout1_131) AT=1920.05n

.meas tran vdout1_132ck1910 FIND v(dout1_132) AT=1920.05n

.meas tran vdout1_133ck1910 FIND v(dout1_133) AT=1920.05n

.meas tran vdout1_134ck1910 FIND v(dout1_134) AT=1920.05n

.meas tran vdout1_135ck1910 FIND v(dout1_135) AT=1920.05n

.meas tran vdout1_136ck1910 FIND v(dout1_136) AT=1920.05n

.meas tran vdout1_137ck1910 FIND v(dout1_137) AT=1920.05n

.meas tran vdout1_138ck1910 FIND v(dout1_138) AT=1920.05n

.meas tran vdout1_139ck1910 FIND v(dout1_139) AT=1920.05n

.meas tran vdout1_140ck1910 FIND v(dout1_140) AT=1920.05n

.meas tran vdout1_141ck1910 FIND v(dout1_141) AT=1920.05n

.meas tran vdout1_142ck1910 FIND v(dout1_142) AT=1920.05n

.meas tran vdout1_143ck1910 FIND v(dout1_143) AT=1920.05n

.meas tran vdout1_144ck1910 FIND v(dout1_144) AT=1920.05n

.meas tran vdout1_145ck1910 FIND v(dout1_145) AT=1920.05n

.meas tran vdout1_146ck1910 FIND v(dout1_146) AT=1920.05n

.meas tran vdout1_147ck1910 FIND v(dout1_147) AT=1920.05n

.meas tran vdout1_148ck1910 FIND v(dout1_148) AT=1920.05n

.meas tran vdout1_149ck1910 FIND v(dout1_149) AT=1920.05n

.meas tran vdout1_150ck1910 FIND v(dout1_150) AT=1920.05n

.meas tran vdout1_151ck1910 FIND v(dout1_151) AT=1920.05n

.meas tran vdout1_152ck1910 FIND v(dout1_152) AT=1920.05n

.meas tran vdout1_153ck1910 FIND v(dout1_153) AT=1920.05n

.meas tran vdout1_154ck1910 FIND v(dout1_154) AT=1920.05n

.meas tran vdout1_155ck1910 FIND v(dout1_155) AT=1920.05n

.meas tran vdout1_156ck1910 FIND v(dout1_156) AT=1920.05n

.meas tran vdout1_157ck1910 FIND v(dout1_157) AT=1920.05n

.meas tran vdout1_158ck1910 FIND v(dout1_158) AT=1920.05n

.meas tran vdout1_159ck1910 FIND v(dout1_159) AT=1920.05n

.meas tran vdout1_160ck1910 FIND v(dout1_160) AT=1920.05n

.meas tran vdout1_161ck1910 FIND v(dout1_161) AT=1920.05n

.meas tran vdout1_162ck1910 FIND v(dout1_162) AT=1920.05n

.meas tran vdout1_163ck1910 FIND v(dout1_163) AT=1920.05n

.meas tran vdout1_164ck1910 FIND v(dout1_164) AT=1920.05n

.meas tran vdout1_165ck1910 FIND v(dout1_165) AT=1920.05n

.meas tran vdout1_166ck1910 FIND v(dout1_166) AT=1920.05n

.meas tran vdout1_167ck1910 FIND v(dout1_167) AT=1920.05n

.meas tran vdout1_168ck1910 FIND v(dout1_168) AT=1920.05n

.meas tran vdout1_169ck1910 FIND v(dout1_169) AT=1920.05n

.meas tran vdout1_170ck1910 FIND v(dout1_170) AT=1920.05n

.meas tran vdout1_171ck1910 FIND v(dout1_171) AT=1920.05n

.meas tran vdout1_172ck1910 FIND v(dout1_172) AT=1920.05n

.meas tran vdout1_173ck1910 FIND v(dout1_173) AT=1920.05n

.meas tran vdout1_174ck1910 FIND v(dout1_174) AT=1920.05n

.meas tran vdout1_175ck1910 FIND v(dout1_175) AT=1920.05n

.meas tran vdout1_176ck1910 FIND v(dout1_176) AT=1920.05n

.meas tran vdout1_177ck1910 FIND v(dout1_177) AT=1920.05n

.meas tran vdout1_178ck1910 FIND v(dout1_178) AT=1920.05n

.meas tran vdout1_179ck1910 FIND v(dout1_179) AT=1920.05n

.meas tran vdout1_180ck1910 FIND v(dout1_180) AT=1920.05n

.meas tran vdout1_181ck1910 FIND v(dout1_181) AT=1920.05n

.meas tran vdout1_182ck1910 FIND v(dout1_182) AT=1920.05n

.meas tran vdout1_183ck1910 FIND v(dout1_183) AT=1920.05n

.meas tran vdout1_184ck1910 FIND v(dout1_184) AT=1920.05n

.meas tran vdout1_185ck1910 FIND v(dout1_185) AT=1920.05n

.meas tran vdout1_186ck1910 FIND v(dout1_186) AT=1920.05n

.meas tran vdout1_187ck1910 FIND v(dout1_187) AT=1920.05n

.meas tran vdout1_188ck1910 FIND v(dout1_188) AT=1920.05n

.meas tran vdout1_189ck1910 FIND v(dout1_189) AT=1920.05n

.meas tran vdout1_190ck1910 FIND v(dout1_190) AT=1920.05n

.meas tran vdout1_191ck1910 FIND v(dout1_191) AT=1920.05n

.meas tran vdout1_192ck1910 FIND v(dout1_192) AT=1920.05n

.meas tran vdout1_193ck1910 FIND v(dout1_193) AT=1920.05n

.meas tran vdout1_194ck1910 FIND v(dout1_194) AT=1920.05n

.meas tran vdout1_195ck1910 FIND v(dout1_195) AT=1920.05n

.meas tran vdout1_196ck1910 FIND v(dout1_196) AT=1920.05n

.meas tran vdout1_197ck1910 FIND v(dout1_197) AT=1920.05n

.meas tran vdout1_198ck1910 FIND v(dout1_198) AT=1920.05n

.meas tran vdout1_199ck1910 FIND v(dout1_199) AT=1920.05n

.meas tran vdout1_200ck1910 FIND v(dout1_200) AT=1920.05n

.meas tran vdout1_201ck1910 FIND v(dout1_201) AT=1920.05n

.meas tran vdout1_202ck1910 FIND v(dout1_202) AT=1920.05n

.meas tran vdout1_203ck1910 FIND v(dout1_203) AT=1920.05n

.meas tran vdout1_204ck1910 FIND v(dout1_204) AT=1920.05n

.meas tran vdout1_205ck1910 FIND v(dout1_205) AT=1920.05n

.meas tran vdout1_206ck1910 FIND v(dout1_206) AT=1920.05n

.meas tran vdout1_207ck1910 FIND v(dout1_207) AT=1920.05n

.meas tran vdout1_208ck1910 FIND v(dout1_208) AT=1920.05n

.meas tran vdout1_209ck1910 FIND v(dout1_209) AT=1920.05n

.meas tran vdout1_210ck1910 FIND v(dout1_210) AT=1920.05n

.meas tran vdout1_211ck1910 FIND v(dout1_211) AT=1920.05n

.meas tran vdout1_212ck1910 FIND v(dout1_212) AT=1920.05n

.meas tran vdout1_213ck1910 FIND v(dout1_213) AT=1920.05n

.meas tran vdout1_214ck1910 FIND v(dout1_214) AT=1920.05n

.meas tran vdout1_215ck1910 FIND v(dout1_215) AT=1920.05n

.meas tran vdout1_216ck1910 FIND v(dout1_216) AT=1920.05n

.meas tran vdout1_217ck1910 FIND v(dout1_217) AT=1920.05n

.meas tran vdout1_218ck1910 FIND v(dout1_218) AT=1920.05n

.meas tran vdout1_219ck1910 FIND v(dout1_219) AT=1920.05n

.meas tran vdout1_220ck1910 FIND v(dout1_220) AT=1920.05n

.meas tran vdout1_221ck1910 FIND v(dout1_221) AT=1920.05n

.meas tran vdout1_222ck1910 FIND v(dout1_222) AT=1920.05n

.meas tran vdout1_223ck1910 FIND v(dout1_223) AT=1920.05n

.meas tran vdout1_224ck1910 FIND v(dout1_224) AT=1920.05n

.meas tran vdout1_225ck1910 FIND v(dout1_225) AT=1920.05n

.meas tran vdout1_226ck1910 FIND v(dout1_226) AT=1920.05n

.meas tran vdout1_227ck1910 FIND v(dout1_227) AT=1920.05n

.meas tran vdout1_228ck1910 FIND v(dout1_228) AT=1920.05n

.meas tran vdout1_229ck1910 FIND v(dout1_229) AT=1920.05n

.meas tran vdout1_230ck1910 FIND v(dout1_230) AT=1920.05n

.meas tran vdout1_231ck1910 FIND v(dout1_231) AT=1920.05n

.meas tran vdout1_232ck1910 FIND v(dout1_232) AT=1920.05n

.meas tran vdout1_233ck1910 FIND v(dout1_233) AT=1920.05n

.meas tran vdout1_234ck1910 FIND v(dout1_234) AT=1920.05n

.meas tran vdout1_235ck1910 FIND v(dout1_235) AT=1920.05n

.meas tran vdout1_236ck1910 FIND v(dout1_236) AT=1920.05n

.meas tran vdout1_237ck1910 FIND v(dout1_237) AT=1920.05n

.meas tran vdout1_238ck1910 FIND v(dout1_238) AT=1920.05n

.meas tran vdout1_239ck1910 FIND v(dout1_239) AT=1920.05n

.meas tran vdout1_240ck1910 FIND v(dout1_240) AT=1920.05n

.meas tran vdout1_241ck1910 FIND v(dout1_241) AT=1920.05n

.meas tran vdout1_242ck1910 FIND v(dout1_242) AT=1920.05n

.meas tran vdout1_243ck1910 FIND v(dout1_243) AT=1920.05n

.meas tran vdout1_244ck1910 FIND v(dout1_244) AT=1920.05n

.meas tran vdout1_245ck1910 FIND v(dout1_245) AT=1920.05n

.meas tran vdout1_246ck1910 FIND v(dout1_246) AT=1920.05n

.meas tran vdout1_247ck1910 FIND v(dout1_247) AT=1920.05n

.meas tran vdout1_248ck1910 FIND v(dout1_248) AT=1920.05n

.meas tran vdout1_249ck1910 FIND v(dout1_249) AT=1920.05n

.meas tran vdout1_250ck1910 FIND v(dout1_250) AT=1920.05n

.meas tran vdout1_251ck1910 FIND v(dout1_251) AT=1920.05n

.meas tran vdout1_252ck1910 FIND v(dout1_252) AT=1920.05n

.meas tran vdout1_253ck1910 FIND v(dout1_253) AT=1920.05n

.meas tran vdout1_254ck1910 FIND v(dout1_254) AT=1920.05n

.meas tran vdout1_255ck1910 FIND v(dout1_255) AT=1920.05n

.meas tran vdout1_256ck1910 FIND v(dout1_256) AT=1920.05n

.meas tran vdout1_0ck1930 FIND v(dout1_0) AT=1940.05n

.meas tran vdout1_1ck1930 FIND v(dout1_1) AT=1940.05n

.meas tran vdout1_2ck1930 FIND v(dout1_2) AT=1940.05n

.meas tran vdout1_3ck1930 FIND v(dout1_3) AT=1940.05n

.meas tran vdout1_4ck1930 FIND v(dout1_4) AT=1940.05n

.meas tran vdout1_5ck1930 FIND v(dout1_5) AT=1940.05n

.meas tran vdout1_6ck1930 FIND v(dout1_6) AT=1940.05n

.meas tran vdout1_7ck1930 FIND v(dout1_7) AT=1940.05n

.meas tran vdout1_8ck1930 FIND v(dout1_8) AT=1940.05n

.meas tran vdout1_9ck1930 FIND v(dout1_9) AT=1940.05n

.meas tran vdout1_10ck1930 FIND v(dout1_10) AT=1940.05n

.meas tran vdout1_11ck1930 FIND v(dout1_11) AT=1940.05n

.meas tran vdout1_12ck1930 FIND v(dout1_12) AT=1940.05n

.meas tran vdout1_13ck1930 FIND v(dout1_13) AT=1940.05n

.meas tran vdout1_14ck1930 FIND v(dout1_14) AT=1940.05n

.meas tran vdout1_15ck1930 FIND v(dout1_15) AT=1940.05n

.meas tran vdout1_16ck1930 FIND v(dout1_16) AT=1940.05n

.meas tran vdout1_17ck1930 FIND v(dout1_17) AT=1940.05n

.meas tran vdout1_18ck1930 FIND v(dout1_18) AT=1940.05n

.meas tran vdout1_19ck1930 FIND v(dout1_19) AT=1940.05n

.meas tran vdout1_20ck1930 FIND v(dout1_20) AT=1940.05n

.meas tran vdout1_21ck1930 FIND v(dout1_21) AT=1940.05n

.meas tran vdout1_22ck1930 FIND v(dout1_22) AT=1940.05n

.meas tran vdout1_23ck1930 FIND v(dout1_23) AT=1940.05n

.meas tran vdout1_24ck1930 FIND v(dout1_24) AT=1940.05n

.meas tran vdout1_25ck1930 FIND v(dout1_25) AT=1940.05n

.meas tran vdout1_26ck1930 FIND v(dout1_26) AT=1940.05n

.meas tran vdout1_27ck1930 FIND v(dout1_27) AT=1940.05n

.meas tran vdout1_28ck1930 FIND v(dout1_28) AT=1940.05n

.meas tran vdout1_29ck1930 FIND v(dout1_29) AT=1940.05n

.meas tran vdout1_30ck1930 FIND v(dout1_30) AT=1940.05n

.meas tran vdout1_31ck1930 FIND v(dout1_31) AT=1940.05n

.meas tran vdout1_32ck1930 FIND v(dout1_32) AT=1940.05n

.meas tran vdout1_33ck1930 FIND v(dout1_33) AT=1940.05n

.meas tran vdout1_34ck1930 FIND v(dout1_34) AT=1940.05n

.meas tran vdout1_35ck1930 FIND v(dout1_35) AT=1940.05n

.meas tran vdout1_36ck1930 FIND v(dout1_36) AT=1940.05n

.meas tran vdout1_37ck1930 FIND v(dout1_37) AT=1940.05n

.meas tran vdout1_38ck1930 FIND v(dout1_38) AT=1940.05n

.meas tran vdout1_39ck1930 FIND v(dout1_39) AT=1940.05n

.meas tran vdout1_40ck1930 FIND v(dout1_40) AT=1940.05n

.meas tran vdout1_41ck1930 FIND v(dout1_41) AT=1940.05n

.meas tran vdout1_42ck1930 FIND v(dout1_42) AT=1940.05n

.meas tran vdout1_43ck1930 FIND v(dout1_43) AT=1940.05n

.meas tran vdout1_44ck1930 FIND v(dout1_44) AT=1940.05n

.meas tran vdout1_45ck1930 FIND v(dout1_45) AT=1940.05n

.meas tran vdout1_46ck1930 FIND v(dout1_46) AT=1940.05n

.meas tran vdout1_47ck1930 FIND v(dout1_47) AT=1940.05n

.meas tran vdout1_48ck1930 FIND v(dout1_48) AT=1940.05n

.meas tran vdout1_49ck1930 FIND v(dout1_49) AT=1940.05n

.meas tran vdout1_50ck1930 FIND v(dout1_50) AT=1940.05n

.meas tran vdout1_51ck1930 FIND v(dout1_51) AT=1940.05n

.meas tran vdout1_52ck1930 FIND v(dout1_52) AT=1940.05n

.meas tran vdout1_53ck1930 FIND v(dout1_53) AT=1940.05n

.meas tran vdout1_54ck1930 FIND v(dout1_54) AT=1940.05n

.meas tran vdout1_55ck1930 FIND v(dout1_55) AT=1940.05n

.meas tran vdout1_56ck1930 FIND v(dout1_56) AT=1940.05n

.meas tran vdout1_57ck1930 FIND v(dout1_57) AT=1940.05n

.meas tran vdout1_58ck1930 FIND v(dout1_58) AT=1940.05n

.meas tran vdout1_59ck1930 FIND v(dout1_59) AT=1940.05n

.meas tran vdout1_60ck1930 FIND v(dout1_60) AT=1940.05n

.meas tran vdout1_61ck1930 FIND v(dout1_61) AT=1940.05n

.meas tran vdout1_62ck1930 FIND v(dout1_62) AT=1940.05n

.meas tran vdout1_63ck1930 FIND v(dout1_63) AT=1940.05n

.meas tran vdout1_64ck1930 FIND v(dout1_64) AT=1940.05n

.meas tran vdout1_65ck1930 FIND v(dout1_65) AT=1940.05n

.meas tran vdout1_66ck1930 FIND v(dout1_66) AT=1940.05n

.meas tran vdout1_67ck1930 FIND v(dout1_67) AT=1940.05n

.meas tran vdout1_68ck1930 FIND v(dout1_68) AT=1940.05n

.meas tran vdout1_69ck1930 FIND v(dout1_69) AT=1940.05n

.meas tran vdout1_70ck1930 FIND v(dout1_70) AT=1940.05n

.meas tran vdout1_71ck1930 FIND v(dout1_71) AT=1940.05n

.meas tran vdout1_72ck1930 FIND v(dout1_72) AT=1940.05n

.meas tran vdout1_73ck1930 FIND v(dout1_73) AT=1940.05n

.meas tran vdout1_74ck1930 FIND v(dout1_74) AT=1940.05n

.meas tran vdout1_75ck1930 FIND v(dout1_75) AT=1940.05n

.meas tran vdout1_76ck1930 FIND v(dout1_76) AT=1940.05n

.meas tran vdout1_77ck1930 FIND v(dout1_77) AT=1940.05n

.meas tran vdout1_78ck1930 FIND v(dout1_78) AT=1940.05n

.meas tran vdout1_79ck1930 FIND v(dout1_79) AT=1940.05n

.meas tran vdout1_80ck1930 FIND v(dout1_80) AT=1940.05n

.meas tran vdout1_81ck1930 FIND v(dout1_81) AT=1940.05n

.meas tran vdout1_82ck1930 FIND v(dout1_82) AT=1940.05n

.meas tran vdout1_83ck1930 FIND v(dout1_83) AT=1940.05n

.meas tran vdout1_84ck1930 FIND v(dout1_84) AT=1940.05n

.meas tran vdout1_85ck1930 FIND v(dout1_85) AT=1940.05n

.meas tran vdout1_86ck1930 FIND v(dout1_86) AT=1940.05n

.meas tran vdout1_87ck1930 FIND v(dout1_87) AT=1940.05n

.meas tran vdout1_88ck1930 FIND v(dout1_88) AT=1940.05n

.meas tran vdout1_89ck1930 FIND v(dout1_89) AT=1940.05n

.meas tran vdout1_90ck1930 FIND v(dout1_90) AT=1940.05n

.meas tran vdout1_91ck1930 FIND v(dout1_91) AT=1940.05n

.meas tran vdout1_92ck1930 FIND v(dout1_92) AT=1940.05n

.meas tran vdout1_93ck1930 FIND v(dout1_93) AT=1940.05n

.meas tran vdout1_94ck1930 FIND v(dout1_94) AT=1940.05n

.meas tran vdout1_95ck1930 FIND v(dout1_95) AT=1940.05n

.meas tran vdout1_96ck1930 FIND v(dout1_96) AT=1940.05n

.meas tran vdout1_97ck1930 FIND v(dout1_97) AT=1940.05n

.meas tran vdout1_98ck1930 FIND v(dout1_98) AT=1940.05n

.meas tran vdout1_99ck1930 FIND v(dout1_99) AT=1940.05n

.meas tran vdout1_100ck1930 FIND v(dout1_100) AT=1940.05n

.meas tran vdout1_101ck1930 FIND v(dout1_101) AT=1940.05n

.meas tran vdout1_102ck1930 FIND v(dout1_102) AT=1940.05n

.meas tran vdout1_103ck1930 FIND v(dout1_103) AT=1940.05n

.meas tran vdout1_104ck1930 FIND v(dout1_104) AT=1940.05n

.meas tran vdout1_105ck1930 FIND v(dout1_105) AT=1940.05n

.meas tran vdout1_106ck1930 FIND v(dout1_106) AT=1940.05n

.meas tran vdout1_107ck1930 FIND v(dout1_107) AT=1940.05n

.meas tran vdout1_108ck1930 FIND v(dout1_108) AT=1940.05n

.meas tran vdout1_109ck1930 FIND v(dout1_109) AT=1940.05n

.meas tran vdout1_110ck1930 FIND v(dout1_110) AT=1940.05n

.meas tran vdout1_111ck1930 FIND v(dout1_111) AT=1940.05n

.meas tran vdout1_112ck1930 FIND v(dout1_112) AT=1940.05n

.meas tran vdout1_113ck1930 FIND v(dout1_113) AT=1940.05n

.meas tran vdout1_114ck1930 FIND v(dout1_114) AT=1940.05n

.meas tran vdout1_115ck1930 FIND v(dout1_115) AT=1940.05n

.meas tran vdout1_116ck1930 FIND v(dout1_116) AT=1940.05n

.meas tran vdout1_117ck1930 FIND v(dout1_117) AT=1940.05n

.meas tran vdout1_118ck1930 FIND v(dout1_118) AT=1940.05n

.meas tran vdout1_119ck1930 FIND v(dout1_119) AT=1940.05n

.meas tran vdout1_120ck1930 FIND v(dout1_120) AT=1940.05n

.meas tran vdout1_121ck1930 FIND v(dout1_121) AT=1940.05n

.meas tran vdout1_122ck1930 FIND v(dout1_122) AT=1940.05n

.meas tran vdout1_123ck1930 FIND v(dout1_123) AT=1940.05n

.meas tran vdout1_124ck1930 FIND v(dout1_124) AT=1940.05n

.meas tran vdout1_125ck1930 FIND v(dout1_125) AT=1940.05n

.meas tran vdout1_126ck1930 FIND v(dout1_126) AT=1940.05n

.meas tran vdout1_127ck1930 FIND v(dout1_127) AT=1940.05n

.meas tran vdout1_128ck1930 FIND v(dout1_128) AT=1940.05n

.meas tran vdout1_129ck1930 FIND v(dout1_129) AT=1940.05n

.meas tran vdout1_130ck1930 FIND v(dout1_130) AT=1940.05n

.meas tran vdout1_131ck1930 FIND v(dout1_131) AT=1940.05n

.meas tran vdout1_132ck1930 FIND v(dout1_132) AT=1940.05n

.meas tran vdout1_133ck1930 FIND v(dout1_133) AT=1940.05n

.meas tran vdout1_134ck1930 FIND v(dout1_134) AT=1940.05n

.meas tran vdout1_135ck1930 FIND v(dout1_135) AT=1940.05n

.meas tran vdout1_136ck1930 FIND v(dout1_136) AT=1940.05n

.meas tran vdout1_137ck1930 FIND v(dout1_137) AT=1940.05n

.meas tran vdout1_138ck1930 FIND v(dout1_138) AT=1940.05n

.meas tran vdout1_139ck1930 FIND v(dout1_139) AT=1940.05n

.meas tran vdout1_140ck1930 FIND v(dout1_140) AT=1940.05n

.meas tran vdout1_141ck1930 FIND v(dout1_141) AT=1940.05n

.meas tran vdout1_142ck1930 FIND v(dout1_142) AT=1940.05n

.meas tran vdout1_143ck1930 FIND v(dout1_143) AT=1940.05n

.meas tran vdout1_144ck1930 FIND v(dout1_144) AT=1940.05n

.meas tran vdout1_145ck1930 FIND v(dout1_145) AT=1940.05n

.meas tran vdout1_146ck1930 FIND v(dout1_146) AT=1940.05n

.meas tran vdout1_147ck1930 FIND v(dout1_147) AT=1940.05n

.meas tran vdout1_148ck1930 FIND v(dout1_148) AT=1940.05n

.meas tran vdout1_149ck1930 FIND v(dout1_149) AT=1940.05n

.meas tran vdout1_150ck1930 FIND v(dout1_150) AT=1940.05n

.meas tran vdout1_151ck1930 FIND v(dout1_151) AT=1940.05n

.meas tran vdout1_152ck1930 FIND v(dout1_152) AT=1940.05n

.meas tran vdout1_153ck1930 FIND v(dout1_153) AT=1940.05n

.meas tran vdout1_154ck1930 FIND v(dout1_154) AT=1940.05n

.meas tran vdout1_155ck1930 FIND v(dout1_155) AT=1940.05n

.meas tran vdout1_156ck1930 FIND v(dout1_156) AT=1940.05n

.meas tran vdout1_157ck1930 FIND v(dout1_157) AT=1940.05n

.meas tran vdout1_158ck1930 FIND v(dout1_158) AT=1940.05n

.meas tran vdout1_159ck1930 FIND v(dout1_159) AT=1940.05n

.meas tran vdout1_160ck1930 FIND v(dout1_160) AT=1940.05n

.meas tran vdout1_161ck1930 FIND v(dout1_161) AT=1940.05n

.meas tran vdout1_162ck1930 FIND v(dout1_162) AT=1940.05n

.meas tran vdout1_163ck1930 FIND v(dout1_163) AT=1940.05n

.meas tran vdout1_164ck1930 FIND v(dout1_164) AT=1940.05n

.meas tran vdout1_165ck1930 FIND v(dout1_165) AT=1940.05n

.meas tran vdout1_166ck1930 FIND v(dout1_166) AT=1940.05n

.meas tran vdout1_167ck1930 FIND v(dout1_167) AT=1940.05n

.meas tran vdout1_168ck1930 FIND v(dout1_168) AT=1940.05n

.meas tran vdout1_169ck1930 FIND v(dout1_169) AT=1940.05n

.meas tran vdout1_170ck1930 FIND v(dout1_170) AT=1940.05n

.meas tran vdout1_171ck1930 FIND v(dout1_171) AT=1940.05n

.meas tran vdout1_172ck1930 FIND v(dout1_172) AT=1940.05n

.meas tran vdout1_173ck1930 FIND v(dout1_173) AT=1940.05n

.meas tran vdout1_174ck1930 FIND v(dout1_174) AT=1940.05n

.meas tran vdout1_175ck1930 FIND v(dout1_175) AT=1940.05n

.meas tran vdout1_176ck1930 FIND v(dout1_176) AT=1940.05n

.meas tran vdout1_177ck1930 FIND v(dout1_177) AT=1940.05n

.meas tran vdout1_178ck1930 FIND v(dout1_178) AT=1940.05n

.meas tran vdout1_179ck1930 FIND v(dout1_179) AT=1940.05n

.meas tran vdout1_180ck1930 FIND v(dout1_180) AT=1940.05n

.meas tran vdout1_181ck1930 FIND v(dout1_181) AT=1940.05n

.meas tran vdout1_182ck1930 FIND v(dout1_182) AT=1940.05n

.meas tran vdout1_183ck1930 FIND v(dout1_183) AT=1940.05n

.meas tran vdout1_184ck1930 FIND v(dout1_184) AT=1940.05n

.meas tran vdout1_185ck1930 FIND v(dout1_185) AT=1940.05n

.meas tran vdout1_186ck1930 FIND v(dout1_186) AT=1940.05n

.meas tran vdout1_187ck1930 FIND v(dout1_187) AT=1940.05n

.meas tran vdout1_188ck1930 FIND v(dout1_188) AT=1940.05n

.meas tran vdout1_189ck1930 FIND v(dout1_189) AT=1940.05n

.meas tran vdout1_190ck1930 FIND v(dout1_190) AT=1940.05n

.meas tran vdout1_191ck1930 FIND v(dout1_191) AT=1940.05n

.meas tran vdout1_192ck1930 FIND v(dout1_192) AT=1940.05n

.meas tran vdout1_193ck1930 FIND v(dout1_193) AT=1940.05n

.meas tran vdout1_194ck1930 FIND v(dout1_194) AT=1940.05n

.meas tran vdout1_195ck1930 FIND v(dout1_195) AT=1940.05n

.meas tran vdout1_196ck1930 FIND v(dout1_196) AT=1940.05n

.meas tran vdout1_197ck1930 FIND v(dout1_197) AT=1940.05n

.meas tran vdout1_198ck1930 FIND v(dout1_198) AT=1940.05n

.meas tran vdout1_199ck1930 FIND v(dout1_199) AT=1940.05n

.meas tran vdout1_200ck1930 FIND v(dout1_200) AT=1940.05n

.meas tran vdout1_201ck1930 FIND v(dout1_201) AT=1940.05n

.meas tran vdout1_202ck1930 FIND v(dout1_202) AT=1940.05n

.meas tran vdout1_203ck1930 FIND v(dout1_203) AT=1940.05n

.meas tran vdout1_204ck1930 FIND v(dout1_204) AT=1940.05n

.meas tran vdout1_205ck1930 FIND v(dout1_205) AT=1940.05n

.meas tran vdout1_206ck1930 FIND v(dout1_206) AT=1940.05n

.meas tran vdout1_207ck1930 FIND v(dout1_207) AT=1940.05n

.meas tran vdout1_208ck1930 FIND v(dout1_208) AT=1940.05n

.meas tran vdout1_209ck1930 FIND v(dout1_209) AT=1940.05n

.meas tran vdout1_210ck1930 FIND v(dout1_210) AT=1940.05n

.meas tran vdout1_211ck1930 FIND v(dout1_211) AT=1940.05n

.meas tran vdout1_212ck1930 FIND v(dout1_212) AT=1940.05n

.meas tran vdout1_213ck1930 FIND v(dout1_213) AT=1940.05n

.meas tran vdout1_214ck1930 FIND v(dout1_214) AT=1940.05n

.meas tran vdout1_215ck1930 FIND v(dout1_215) AT=1940.05n

.meas tran vdout1_216ck1930 FIND v(dout1_216) AT=1940.05n

.meas tran vdout1_217ck1930 FIND v(dout1_217) AT=1940.05n

.meas tran vdout1_218ck1930 FIND v(dout1_218) AT=1940.05n

.meas tran vdout1_219ck1930 FIND v(dout1_219) AT=1940.05n

.meas tran vdout1_220ck1930 FIND v(dout1_220) AT=1940.05n

.meas tran vdout1_221ck1930 FIND v(dout1_221) AT=1940.05n

.meas tran vdout1_222ck1930 FIND v(dout1_222) AT=1940.05n

.meas tran vdout1_223ck1930 FIND v(dout1_223) AT=1940.05n

.meas tran vdout1_224ck1930 FIND v(dout1_224) AT=1940.05n

.meas tran vdout1_225ck1930 FIND v(dout1_225) AT=1940.05n

.meas tran vdout1_226ck1930 FIND v(dout1_226) AT=1940.05n

.meas tran vdout1_227ck1930 FIND v(dout1_227) AT=1940.05n

.meas tran vdout1_228ck1930 FIND v(dout1_228) AT=1940.05n

.meas tran vdout1_229ck1930 FIND v(dout1_229) AT=1940.05n

.meas tran vdout1_230ck1930 FIND v(dout1_230) AT=1940.05n

.meas tran vdout1_231ck1930 FIND v(dout1_231) AT=1940.05n

.meas tran vdout1_232ck1930 FIND v(dout1_232) AT=1940.05n

.meas tran vdout1_233ck1930 FIND v(dout1_233) AT=1940.05n

.meas tran vdout1_234ck1930 FIND v(dout1_234) AT=1940.05n

.meas tran vdout1_235ck1930 FIND v(dout1_235) AT=1940.05n

.meas tran vdout1_236ck1930 FIND v(dout1_236) AT=1940.05n

.meas tran vdout1_237ck1930 FIND v(dout1_237) AT=1940.05n

.meas tran vdout1_238ck1930 FIND v(dout1_238) AT=1940.05n

.meas tran vdout1_239ck1930 FIND v(dout1_239) AT=1940.05n

.meas tran vdout1_240ck1930 FIND v(dout1_240) AT=1940.05n

.meas tran vdout1_241ck1930 FIND v(dout1_241) AT=1940.05n

.meas tran vdout1_242ck1930 FIND v(dout1_242) AT=1940.05n

.meas tran vdout1_243ck1930 FIND v(dout1_243) AT=1940.05n

.meas tran vdout1_244ck1930 FIND v(dout1_244) AT=1940.05n

.meas tran vdout1_245ck1930 FIND v(dout1_245) AT=1940.05n

.meas tran vdout1_246ck1930 FIND v(dout1_246) AT=1940.05n

.meas tran vdout1_247ck1930 FIND v(dout1_247) AT=1940.05n

.meas tran vdout1_248ck1930 FIND v(dout1_248) AT=1940.05n

.meas tran vdout1_249ck1930 FIND v(dout1_249) AT=1940.05n

.meas tran vdout1_250ck1930 FIND v(dout1_250) AT=1940.05n

.meas tran vdout1_251ck1930 FIND v(dout1_251) AT=1940.05n

.meas tran vdout1_252ck1930 FIND v(dout1_252) AT=1940.05n

.meas tran vdout1_253ck1930 FIND v(dout1_253) AT=1940.05n

.meas tran vdout1_254ck1930 FIND v(dout1_254) AT=1940.05n

.meas tran vdout1_255ck1930 FIND v(dout1_255) AT=1940.05n

.meas tran vdout1_256ck1930 FIND v(dout1_256) AT=1940.05n

.meas tran vdout1_0ck1940 FIND v(dout1_0) AT=1950.05n

.meas tran vdout1_1ck1940 FIND v(dout1_1) AT=1950.05n

.meas tran vdout1_2ck1940 FIND v(dout1_2) AT=1950.05n

.meas tran vdout1_3ck1940 FIND v(dout1_3) AT=1950.05n

.meas tran vdout1_4ck1940 FIND v(dout1_4) AT=1950.05n

.meas tran vdout1_5ck1940 FIND v(dout1_5) AT=1950.05n

.meas tran vdout1_6ck1940 FIND v(dout1_6) AT=1950.05n

.meas tran vdout1_7ck1940 FIND v(dout1_7) AT=1950.05n

.meas tran vdout1_8ck1940 FIND v(dout1_8) AT=1950.05n

.meas tran vdout1_9ck1940 FIND v(dout1_9) AT=1950.05n

.meas tran vdout1_10ck1940 FIND v(dout1_10) AT=1950.05n

.meas tran vdout1_11ck1940 FIND v(dout1_11) AT=1950.05n

.meas tran vdout1_12ck1940 FIND v(dout1_12) AT=1950.05n

.meas tran vdout1_13ck1940 FIND v(dout1_13) AT=1950.05n

.meas tran vdout1_14ck1940 FIND v(dout1_14) AT=1950.05n

.meas tran vdout1_15ck1940 FIND v(dout1_15) AT=1950.05n

.meas tran vdout1_16ck1940 FIND v(dout1_16) AT=1950.05n

.meas tran vdout1_17ck1940 FIND v(dout1_17) AT=1950.05n

.meas tran vdout1_18ck1940 FIND v(dout1_18) AT=1950.05n

.meas tran vdout1_19ck1940 FIND v(dout1_19) AT=1950.05n

.meas tran vdout1_20ck1940 FIND v(dout1_20) AT=1950.05n

.meas tran vdout1_21ck1940 FIND v(dout1_21) AT=1950.05n

.meas tran vdout1_22ck1940 FIND v(dout1_22) AT=1950.05n

.meas tran vdout1_23ck1940 FIND v(dout1_23) AT=1950.05n

.meas tran vdout1_24ck1940 FIND v(dout1_24) AT=1950.05n

.meas tran vdout1_25ck1940 FIND v(dout1_25) AT=1950.05n

.meas tran vdout1_26ck1940 FIND v(dout1_26) AT=1950.05n

.meas tran vdout1_27ck1940 FIND v(dout1_27) AT=1950.05n

.meas tran vdout1_28ck1940 FIND v(dout1_28) AT=1950.05n

.meas tran vdout1_29ck1940 FIND v(dout1_29) AT=1950.05n

.meas tran vdout1_30ck1940 FIND v(dout1_30) AT=1950.05n

.meas tran vdout1_31ck1940 FIND v(dout1_31) AT=1950.05n

.meas tran vdout1_32ck1940 FIND v(dout1_32) AT=1950.05n

.meas tran vdout1_33ck1940 FIND v(dout1_33) AT=1950.05n

.meas tran vdout1_34ck1940 FIND v(dout1_34) AT=1950.05n

.meas tran vdout1_35ck1940 FIND v(dout1_35) AT=1950.05n

.meas tran vdout1_36ck1940 FIND v(dout1_36) AT=1950.05n

.meas tran vdout1_37ck1940 FIND v(dout1_37) AT=1950.05n

.meas tran vdout1_38ck1940 FIND v(dout1_38) AT=1950.05n

.meas tran vdout1_39ck1940 FIND v(dout1_39) AT=1950.05n

.meas tran vdout1_40ck1940 FIND v(dout1_40) AT=1950.05n

.meas tran vdout1_41ck1940 FIND v(dout1_41) AT=1950.05n

.meas tran vdout1_42ck1940 FIND v(dout1_42) AT=1950.05n

.meas tran vdout1_43ck1940 FIND v(dout1_43) AT=1950.05n

.meas tran vdout1_44ck1940 FIND v(dout1_44) AT=1950.05n

.meas tran vdout1_45ck1940 FIND v(dout1_45) AT=1950.05n

.meas tran vdout1_46ck1940 FIND v(dout1_46) AT=1950.05n

.meas tran vdout1_47ck1940 FIND v(dout1_47) AT=1950.05n

.meas tran vdout1_48ck1940 FIND v(dout1_48) AT=1950.05n

.meas tran vdout1_49ck1940 FIND v(dout1_49) AT=1950.05n

.meas tran vdout1_50ck1940 FIND v(dout1_50) AT=1950.05n

.meas tran vdout1_51ck1940 FIND v(dout1_51) AT=1950.05n

.meas tran vdout1_52ck1940 FIND v(dout1_52) AT=1950.05n

.meas tran vdout1_53ck1940 FIND v(dout1_53) AT=1950.05n

.meas tran vdout1_54ck1940 FIND v(dout1_54) AT=1950.05n

.meas tran vdout1_55ck1940 FIND v(dout1_55) AT=1950.05n

.meas tran vdout1_56ck1940 FIND v(dout1_56) AT=1950.05n

.meas tran vdout1_57ck1940 FIND v(dout1_57) AT=1950.05n

.meas tran vdout1_58ck1940 FIND v(dout1_58) AT=1950.05n

.meas tran vdout1_59ck1940 FIND v(dout1_59) AT=1950.05n

.meas tran vdout1_60ck1940 FIND v(dout1_60) AT=1950.05n

.meas tran vdout1_61ck1940 FIND v(dout1_61) AT=1950.05n

.meas tran vdout1_62ck1940 FIND v(dout1_62) AT=1950.05n

.meas tran vdout1_63ck1940 FIND v(dout1_63) AT=1950.05n

.meas tran vdout1_64ck1940 FIND v(dout1_64) AT=1950.05n

.meas tran vdout1_65ck1940 FIND v(dout1_65) AT=1950.05n

.meas tran vdout1_66ck1940 FIND v(dout1_66) AT=1950.05n

.meas tran vdout1_67ck1940 FIND v(dout1_67) AT=1950.05n

.meas tran vdout1_68ck1940 FIND v(dout1_68) AT=1950.05n

.meas tran vdout1_69ck1940 FIND v(dout1_69) AT=1950.05n

.meas tran vdout1_70ck1940 FIND v(dout1_70) AT=1950.05n

.meas tran vdout1_71ck1940 FIND v(dout1_71) AT=1950.05n

.meas tran vdout1_72ck1940 FIND v(dout1_72) AT=1950.05n

.meas tran vdout1_73ck1940 FIND v(dout1_73) AT=1950.05n

.meas tran vdout1_74ck1940 FIND v(dout1_74) AT=1950.05n

.meas tran vdout1_75ck1940 FIND v(dout1_75) AT=1950.05n

.meas tran vdout1_76ck1940 FIND v(dout1_76) AT=1950.05n

.meas tran vdout1_77ck1940 FIND v(dout1_77) AT=1950.05n

.meas tran vdout1_78ck1940 FIND v(dout1_78) AT=1950.05n

.meas tran vdout1_79ck1940 FIND v(dout1_79) AT=1950.05n

.meas tran vdout1_80ck1940 FIND v(dout1_80) AT=1950.05n

.meas tran vdout1_81ck1940 FIND v(dout1_81) AT=1950.05n

.meas tran vdout1_82ck1940 FIND v(dout1_82) AT=1950.05n

.meas tran vdout1_83ck1940 FIND v(dout1_83) AT=1950.05n

.meas tran vdout1_84ck1940 FIND v(dout1_84) AT=1950.05n

.meas tran vdout1_85ck1940 FIND v(dout1_85) AT=1950.05n

.meas tran vdout1_86ck1940 FIND v(dout1_86) AT=1950.05n

.meas tran vdout1_87ck1940 FIND v(dout1_87) AT=1950.05n

.meas tran vdout1_88ck1940 FIND v(dout1_88) AT=1950.05n

.meas tran vdout1_89ck1940 FIND v(dout1_89) AT=1950.05n

.meas tran vdout1_90ck1940 FIND v(dout1_90) AT=1950.05n

.meas tran vdout1_91ck1940 FIND v(dout1_91) AT=1950.05n

.meas tran vdout1_92ck1940 FIND v(dout1_92) AT=1950.05n

.meas tran vdout1_93ck1940 FIND v(dout1_93) AT=1950.05n

.meas tran vdout1_94ck1940 FIND v(dout1_94) AT=1950.05n

.meas tran vdout1_95ck1940 FIND v(dout1_95) AT=1950.05n

.meas tran vdout1_96ck1940 FIND v(dout1_96) AT=1950.05n

.meas tran vdout1_97ck1940 FIND v(dout1_97) AT=1950.05n

.meas tran vdout1_98ck1940 FIND v(dout1_98) AT=1950.05n

.meas tran vdout1_99ck1940 FIND v(dout1_99) AT=1950.05n

.meas tran vdout1_100ck1940 FIND v(dout1_100) AT=1950.05n

.meas tran vdout1_101ck1940 FIND v(dout1_101) AT=1950.05n

.meas tran vdout1_102ck1940 FIND v(dout1_102) AT=1950.05n

.meas tran vdout1_103ck1940 FIND v(dout1_103) AT=1950.05n

.meas tran vdout1_104ck1940 FIND v(dout1_104) AT=1950.05n

.meas tran vdout1_105ck1940 FIND v(dout1_105) AT=1950.05n

.meas tran vdout1_106ck1940 FIND v(dout1_106) AT=1950.05n

.meas tran vdout1_107ck1940 FIND v(dout1_107) AT=1950.05n

.meas tran vdout1_108ck1940 FIND v(dout1_108) AT=1950.05n

.meas tran vdout1_109ck1940 FIND v(dout1_109) AT=1950.05n

.meas tran vdout1_110ck1940 FIND v(dout1_110) AT=1950.05n

.meas tran vdout1_111ck1940 FIND v(dout1_111) AT=1950.05n

.meas tran vdout1_112ck1940 FIND v(dout1_112) AT=1950.05n

.meas tran vdout1_113ck1940 FIND v(dout1_113) AT=1950.05n

.meas tran vdout1_114ck1940 FIND v(dout1_114) AT=1950.05n

.meas tran vdout1_115ck1940 FIND v(dout1_115) AT=1950.05n

.meas tran vdout1_116ck1940 FIND v(dout1_116) AT=1950.05n

.meas tran vdout1_117ck1940 FIND v(dout1_117) AT=1950.05n

.meas tran vdout1_118ck1940 FIND v(dout1_118) AT=1950.05n

.meas tran vdout1_119ck1940 FIND v(dout1_119) AT=1950.05n

.meas tran vdout1_120ck1940 FIND v(dout1_120) AT=1950.05n

.meas tran vdout1_121ck1940 FIND v(dout1_121) AT=1950.05n

.meas tran vdout1_122ck1940 FIND v(dout1_122) AT=1950.05n

.meas tran vdout1_123ck1940 FIND v(dout1_123) AT=1950.05n

.meas tran vdout1_124ck1940 FIND v(dout1_124) AT=1950.05n

.meas tran vdout1_125ck1940 FIND v(dout1_125) AT=1950.05n

.meas tran vdout1_126ck1940 FIND v(dout1_126) AT=1950.05n

.meas tran vdout1_127ck1940 FIND v(dout1_127) AT=1950.05n

.meas tran vdout1_128ck1940 FIND v(dout1_128) AT=1950.05n

.meas tran vdout1_129ck1940 FIND v(dout1_129) AT=1950.05n

.meas tran vdout1_130ck1940 FIND v(dout1_130) AT=1950.05n

.meas tran vdout1_131ck1940 FIND v(dout1_131) AT=1950.05n

.meas tran vdout1_132ck1940 FIND v(dout1_132) AT=1950.05n

.meas tran vdout1_133ck1940 FIND v(dout1_133) AT=1950.05n

.meas tran vdout1_134ck1940 FIND v(dout1_134) AT=1950.05n

.meas tran vdout1_135ck1940 FIND v(dout1_135) AT=1950.05n

.meas tran vdout1_136ck1940 FIND v(dout1_136) AT=1950.05n

.meas tran vdout1_137ck1940 FIND v(dout1_137) AT=1950.05n

.meas tran vdout1_138ck1940 FIND v(dout1_138) AT=1950.05n

.meas tran vdout1_139ck1940 FIND v(dout1_139) AT=1950.05n

.meas tran vdout1_140ck1940 FIND v(dout1_140) AT=1950.05n

.meas tran vdout1_141ck1940 FIND v(dout1_141) AT=1950.05n

.meas tran vdout1_142ck1940 FIND v(dout1_142) AT=1950.05n

.meas tran vdout1_143ck1940 FIND v(dout1_143) AT=1950.05n

.meas tran vdout1_144ck1940 FIND v(dout1_144) AT=1950.05n

.meas tran vdout1_145ck1940 FIND v(dout1_145) AT=1950.05n

.meas tran vdout1_146ck1940 FIND v(dout1_146) AT=1950.05n

.meas tran vdout1_147ck1940 FIND v(dout1_147) AT=1950.05n

.meas tran vdout1_148ck1940 FIND v(dout1_148) AT=1950.05n

.meas tran vdout1_149ck1940 FIND v(dout1_149) AT=1950.05n

.meas tran vdout1_150ck1940 FIND v(dout1_150) AT=1950.05n

.meas tran vdout1_151ck1940 FIND v(dout1_151) AT=1950.05n

.meas tran vdout1_152ck1940 FIND v(dout1_152) AT=1950.05n

.meas tran vdout1_153ck1940 FIND v(dout1_153) AT=1950.05n

.meas tran vdout1_154ck1940 FIND v(dout1_154) AT=1950.05n

.meas tran vdout1_155ck1940 FIND v(dout1_155) AT=1950.05n

.meas tran vdout1_156ck1940 FIND v(dout1_156) AT=1950.05n

.meas tran vdout1_157ck1940 FIND v(dout1_157) AT=1950.05n

.meas tran vdout1_158ck1940 FIND v(dout1_158) AT=1950.05n

.meas tran vdout1_159ck1940 FIND v(dout1_159) AT=1950.05n

.meas tran vdout1_160ck1940 FIND v(dout1_160) AT=1950.05n

.meas tran vdout1_161ck1940 FIND v(dout1_161) AT=1950.05n

.meas tran vdout1_162ck1940 FIND v(dout1_162) AT=1950.05n

.meas tran vdout1_163ck1940 FIND v(dout1_163) AT=1950.05n

.meas tran vdout1_164ck1940 FIND v(dout1_164) AT=1950.05n

.meas tran vdout1_165ck1940 FIND v(dout1_165) AT=1950.05n

.meas tran vdout1_166ck1940 FIND v(dout1_166) AT=1950.05n

.meas tran vdout1_167ck1940 FIND v(dout1_167) AT=1950.05n

.meas tran vdout1_168ck1940 FIND v(dout1_168) AT=1950.05n

.meas tran vdout1_169ck1940 FIND v(dout1_169) AT=1950.05n

.meas tran vdout1_170ck1940 FIND v(dout1_170) AT=1950.05n

.meas tran vdout1_171ck1940 FIND v(dout1_171) AT=1950.05n

.meas tran vdout1_172ck1940 FIND v(dout1_172) AT=1950.05n

.meas tran vdout1_173ck1940 FIND v(dout1_173) AT=1950.05n

.meas tran vdout1_174ck1940 FIND v(dout1_174) AT=1950.05n

.meas tran vdout1_175ck1940 FIND v(dout1_175) AT=1950.05n

.meas tran vdout1_176ck1940 FIND v(dout1_176) AT=1950.05n

.meas tran vdout1_177ck1940 FIND v(dout1_177) AT=1950.05n

.meas tran vdout1_178ck1940 FIND v(dout1_178) AT=1950.05n

.meas tran vdout1_179ck1940 FIND v(dout1_179) AT=1950.05n

.meas tran vdout1_180ck1940 FIND v(dout1_180) AT=1950.05n

.meas tran vdout1_181ck1940 FIND v(dout1_181) AT=1950.05n

.meas tran vdout1_182ck1940 FIND v(dout1_182) AT=1950.05n

.meas tran vdout1_183ck1940 FIND v(dout1_183) AT=1950.05n

.meas tran vdout1_184ck1940 FIND v(dout1_184) AT=1950.05n

.meas tran vdout1_185ck1940 FIND v(dout1_185) AT=1950.05n

.meas tran vdout1_186ck1940 FIND v(dout1_186) AT=1950.05n

.meas tran vdout1_187ck1940 FIND v(dout1_187) AT=1950.05n

.meas tran vdout1_188ck1940 FIND v(dout1_188) AT=1950.05n

.meas tran vdout1_189ck1940 FIND v(dout1_189) AT=1950.05n

.meas tran vdout1_190ck1940 FIND v(dout1_190) AT=1950.05n

.meas tran vdout1_191ck1940 FIND v(dout1_191) AT=1950.05n

.meas tran vdout1_192ck1940 FIND v(dout1_192) AT=1950.05n

.meas tran vdout1_193ck1940 FIND v(dout1_193) AT=1950.05n

.meas tran vdout1_194ck1940 FIND v(dout1_194) AT=1950.05n

.meas tran vdout1_195ck1940 FIND v(dout1_195) AT=1950.05n

.meas tran vdout1_196ck1940 FIND v(dout1_196) AT=1950.05n

.meas tran vdout1_197ck1940 FIND v(dout1_197) AT=1950.05n

.meas tran vdout1_198ck1940 FIND v(dout1_198) AT=1950.05n

.meas tran vdout1_199ck1940 FIND v(dout1_199) AT=1950.05n

.meas tran vdout1_200ck1940 FIND v(dout1_200) AT=1950.05n

.meas tran vdout1_201ck1940 FIND v(dout1_201) AT=1950.05n

.meas tran vdout1_202ck1940 FIND v(dout1_202) AT=1950.05n

.meas tran vdout1_203ck1940 FIND v(dout1_203) AT=1950.05n

.meas tran vdout1_204ck1940 FIND v(dout1_204) AT=1950.05n

.meas tran vdout1_205ck1940 FIND v(dout1_205) AT=1950.05n

.meas tran vdout1_206ck1940 FIND v(dout1_206) AT=1950.05n

.meas tran vdout1_207ck1940 FIND v(dout1_207) AT=1950.05n

.meas tran vdout1_208ck1940 FIND v(dout1_208) AT=1950.05n

.meas tran vdout1_209ck1940 FIND v(dout1_209) AT=1950.05n

.meas tran vdout1_210ck1940 FIND v(dout1_210) AT=1950.05n

.meas tran vdout1_211ck1940 FIND v(dout1_211) AT=1950.05n

.meas tran vdout1_212ck1940 FIND v(dout1_212) AT=1950.05n

.meas tran vdout1_213ck1940 FIND v(dout1_213) AT=1950.05n

.meas tran vdout1_214ck1940 FIND v(dout1_214) AT=1950.05n

.meas tran vdout1_215ck1940 FIND v(dout1_215) AT=1950.05n

.meas tran vdout1_216ck1940 FIND v(dout1_216) AT=1950.05n

.meas tran vdout1_217ck1940 FIND v(dout1_217) AT=1950.05n

.meas tran vdout1_218ck1940 FIND v(dout1_218) AT=1950.05n

.meas tran vdout1_219ck1940 FIND v(dout1_219) AT=1950.05n

.meas tran vdout1_220ck1940 FIND v(dout1_220) AT=1950.05n

.meas tran vdout1_221ck1940 FIND v(dout1_221) AT=1950.05n

.meas tran vdout1_222ck1940 FIND v(dout1_222) AT=1950.05n

.meas tran vdout1_223ck1940 FIND v(dout1_223) AT=1950.05n

.meas tran vdout1_224ck1940 FIND v(dout1_224) AT=1950.05n

.meas tran vdout1_225ck1940 FIND v(dout1_225) AT=1950.05n

.meas tran vdout1_226ck1940 FIND v(dout1_226) AT=1950.05n

.meas tran vdout1_227ck1940 FIND v(dout1_227) AT=1950.05n

.meas tran vdout1_228ck1940 FIND v(dout1_228) AT=1950.05n

.meas tran vdout1_229ck1940 FIND v(dout1_229) AT=1950.05n

.meas tran vdout1_230ck1940 FIND v(dout1_230) AT=1950.05n

.meas tran vdout1_231ck1940 FIND v(dout1_231) AT=1950.05n

.meas tran vdout1_232ck1940 FIND v(dout1_232) AT=1950.05n

.meas tran vdout1_233ck1940 FIND v(dout1_233) AT=1950.05n

.meas tran vdout1_234ck1940 FIND v(dout1_234) AT=1950.05n

.meas tran vdout1_235ck1940 FIND v(dout1_235) AT=1950.05n

.meas tran vdout1_236ck1940 FIND v(dout1_236) AT=1950.05n

.meas tran vdout1_237ck1940 FIND v(dout1_237) AT=1950.05n

.meas tran vdout1_238ck1940 FIND v(dout1_238) AT=1950.05n

.meas tran vdout1_239ck1940 FIND v(dout1_239) AT=1950.05n

.meas tran vdout1_240ck1940 FIND v(dout1_240) AT=1950.05n

.meas tran vdout1_241ck1940 FIND v(dout1_241) AT=1950.05n

.meas tran vdout1_242ck1940 FIND v(dout1_242) AT=1950.05n

.meas tran vdout1_243ck1940 FIND v(dout1_243) AT=1950.05n

.meas tran vdout1_244ck1940 FIND v(dout1_244) AT=1950.05n

.meas tran vdout1_245ck1940 FIND v(dout1_245) AT=1950.05n

.meas tran vdout1_246ck1940 FIND v(dout1_246) AT=1950.05n

.meas tran vdout1_247ck1940 FIND v(dout1_247) AT=1950.05n

.meas tran vdout1_248ck1940 FIND v(dout1_248) AT=1950.05n

.meas tran vdout1_249ck1940 FIND v(dout1_249) AT=1950.05n

.meas tran vdout1_250ck1940 FIND v(dout1_250) AT=1950.05n

.meas tran vdout1_251ck1940 FIND v(dout1_251) AT=1950.05n

.meas tran vdout1_252ck1940 FIND v(dout1_252) AT=1950.05n

.meas tran vdout1_253ck1940 FIND v(dout1_253) AT=1950.05n

.meas tran vdout1_254ck1940 FIND v(dout1_254) AT=1950.05n

.meas tran vdout1_255ck1940 FIND v(dout1_255) AT=1950.05n

.meas tran vdout1_256ck1940 FIND v(dout1_256) AT=1950.05n

.meas tran vdout1_0ck1960 FIND v(dout1_0) AT=1970.05n

.meas tran vdout1_1ck1960 FIND v(dout1_1) AT=1970.05n

.meas tran vdout1_2ck1960 FIND v(dout1_2) AT=1970.05n

.meas tran vdout1_3ck1960 FIND v(dout1_3) AT=1970.05n

.meas tran vdout1_4ck1960 FIND v(dout1_4) AT=1970.05n

.meas tran vdout1_5ck1960 FIND v(dout1_5) AT=1970.05n

.meas tran vdout1_6ck1960 FIND v(dout1_6) AT=1970.05n

.meas tran vdout1_7ck1960 FIND v(dout1_7) AT=1970.05n

.meas tran vdout1_8ck1960 FIND v(dout1_8) AT=1970.05n

.meas tran vdout1_9ck1960 FIND v(dout1_9) AT=1970.05n

.meas tran vdout1_10ck1960 FIND v(dout1_10) AT=1970.05n

.meas tran vdout1_11ck1960 FIND v(dout1_11) AT=1970.05n

.meas tran vdout1_12ck1960 FIND v(dout1_12) AT=1970.05n

.meas tran vdout1_13ck1960 FIND v(dout1_13) AT=1970.05n

.meas tran vdout1_14ck1960 FIND v(dout1_14) AT=1970.05n

.meas tran vdout1_15ck1960 FIND v(dout1_15) AT=1970.05n

.meas tran vdout1_16ck1960 FIND v(dout1_16) AT=1970.05n

.meas tran vdout1_17ck1960 FIND v(dout1_17) AT=1970.05n

.meas tran vdout1_18ck1960 FIND v(dout1_18) AT=1970.05n

.meas tran vdout1_19ck1960 FIND v(dout1_19) AT=1970.05n

.meas tran vdout1_20ck1960 FIND v(dout1_20) AT=1970.05n

.meas tran vdout1_21ck1960 FIND v(dout1_21) AT=1970.05n

.meas tran vdout1_22ck1960 FIND v(dout1_22) AT=1970.05n

.meas tran vdout1_23ck1960 FIND v(dout1_23) AT=1970.05n

.meas tran vdout1_24ck1960 FIND v(dout1_24) AT=1970.05n

.meas tran vdout1_25ck1960 FIND v(dout1_25) AT=1970.05n

.meas tran vdout1_26ck1960 FIND v(dout1_26) AT=1970.05n

.meas tran vdout1_27ck1960 FIND v(dout1_27) AT=1970.05n

.meas tran vdout1_28ck1960 FIND v(dout1_28) AT=1970.05n

.meas tran vdout1_29ck1960 FIND v(dout1_29) AT=1970.05n

.meas tran vdout1_30ck1960 FIND v(dout1_30) AT=1970.05n

.meas tran vdout1_31ck1960 FIND v(dout1_31) AT=1970.05n

.meas tran vdout1_32ck1960 FIND v(dout1_32) AT=1970.05n

.meas tran vdout1_33ck1960 FIND v(dout1_33) AT=1970.05n

.meas tran vdout1_34ck1960 FIND v(dout1_34) AT=1970.05n

.meas tran vdout1_35ck1960 FIND v(dout1_35) AT=1970.05n

.meas tran vdout1_36ck1960 FIND v(dout1_36) AT=1970.05n

.meas tran vdout1_37ck1960 FIND v(dout1_37) AT=1970.05n

.meas tran vdout1_38ck1960 FIND v(dout1_38) AT=1970.05n

.meas tran vdout1_39ck1960 FIND v(dout1_39) AT=1970.05n

.meas tran vdout1_40ck1960 FIND v(dout1_40) AT=1970.05n

.meas tran vdout1_41ck1960 FIND v(dout1_41) AT=1970.05n

.meas tran vdout1_42ck1960 FIND v(dout1_42) AT=1970.05n

.meas tran vdout1_43ck1960 FIND v(dout1_43) AT=1970.05n

.meas tran vdout1_44ck1960 FIND v(dout1_44) AT=1970.05n

.meas tran vdout1_45ck1960 FIND v(dout1_45) AT=1970.05n

.meas tran vdout1_46ck1960 FIND v(dout1_46) AT=1970.05n

.meas tran vdout1_47ck1960 FIND v(dout1_47) AT=1970.05n

.meas tran vdout1_48ck1960 FIND v(dout1_48) AT=1970.05n

.meas tran vdout1_49ck1960 FIND v(dout1_49) AT=1970.05n

.meas tran vdout1_50ck1960 FIND v(dout1_50) AT=1970.05n

.meas tran vdout1_51ck1960 FIND v(dout1_51) AT=1970.05n

.meas tran vdout1_52ck1960 FIND v(dout1_52) AT=1970.05n

.meas tran vdout1_53ck1960 FIND v(dout1_53) AT=1970.05n

.meas tran vdout1_54ck1960 FIND v(dout1_54) AT=1970.05n

.meas tran vdout1_55ck1960 FIND v(dout1_55) AT=1970.05n

.meas tran vdout1_56ck1960 FIND v(dout1_56) AT=1970.05n

.meas tran vdout1_57ck1960 FIND v(dout1_57) AT=1970.05n

.meas tran vdout1_58ck1960 FIND v(dout1_58) AT=1970.05n

.meas tran vdout1_59ck1960 FIND v(dout1_59) AT=1970.05n

.meas tran vdout1_60ck1960 FIND v(dout1_60) AT=1970.05n

.meas tran vdout1_61ck1960 FIND v(dout1_61) AT=1970.05n

.meas tran vdout1_62ck1960 FIND v(dout1_62) AT=1970.05n

.meas tran vdout1_63ck1960 FIND v(dout1_63) AT=1970.05n

.meas tran vdout1_64ck1960 FIND v(dout1_64) AT=1970.05n

.meas tran vdout1_65ck1960 FIND v(dout1_65) AT=1970.05n

.meas tran vdout1_66ck1960 FIND v(dout1_66) AT=1970.05n

.meas tran vdout1_67ck1960 FIND v(dout1_67) AT=1970.05n

.meas tran vdout1_68ck1960 FIND v(dout1_68) AT=1970.05n

.meas tran vdout1_69ck1960 FIND v(dout1_69) AT=1970.05n

.meas tran vdout1_70ck1960 FIND v(dout1_70) AT=1970.05n

.meas tran vdout1_71ck1960 FIND v(dout1_71) AT=1970.05n

.meas tran vdout1_72ck1960 FIND v(dout1_72) AT=1970.05n

.meas tran vdout1_73ck1960 FIND v(dout1_73) AT=1970.05n

.meas tran vdout1_74ck1960 FIND v(dout1_74) AT=1970.05n

.meas tran vdout1_75ck1960 FIND v(dout1_75) AT=1970.05n

.meas tran vdout1_76ck1960 FIND v(dout1_76) AT=1970.05n

.meas tran vdout1_77ck1960 FIND v(dout1_77) AT=1970.05n

.meas tran vdout1_78ck1960 FIND v(dout1_78) AT=1970.05n

.meas tran vdout1_79ck1960 FIND v(dout1_79) AT=1970.05n

.meas tran vdout1_80ck1960 FIND v(dout1_80) AT=1970.05n

.meas tran vdout1_81ck1960 FIND v(dout1_81) AT=1970.05n

.meas tran vdout1_82ck1960 FIND v(dout1_82) AT=1970.05n

.meas tran vdout1_83ck1960 FIND v(dout1_83) AT=1970.05n

.meas tran vdout1_84ck1960 FIND v(dout1_84) AT=1970.05n

.meas tran vdout1_85ck1960 FIND v(dout1_85) AT=1970.05n

.meas tran vdout1_86ck1960 FIND v(dout1_86) AT=1970.05n

.meas tran vdout1_87ck1960 FIND v(dout1_87) AT=1970.05n

.meas tran vdout1_88ck1960 FIND v(dout1_88) AT=1970.05n

.meas tran vdout1_89ck1960 FIND v(dout1_89) AT=1970.05n

.meas tran vdout1_90ck1960 FIND v(dout1_90) AT=1970.05n

.meas tran vdout1_91ck1960 FIND v(dout1_91) AT=1970.05n

.meas tran vdout1_92ck1960 FIND v(dout1_92) AT=1970.05n

.meas tran vdout1_93ck1960 FIND v(dout1_93) AT=1970.05n

.meas tran vdout1_94ck1960 FIND v(dout1_94) AT=1970.05n

.meas tran vdout1_95ck1960 FIND v(dout1_95) AT=1970.05n

.meas tran vdout1_96ck1960 FIND v(dout1_96) AT=1970.05n

.meas tran vdout1_97ck1960 FIND v(dout1_97) AT=1970.05n

.meas tran vdout1_98ck1960 FIND v(dout1_98) AT=1970.05n

.meas tran vdout1_99ck1960 FIND v(dout1_99) AT=1970.05n

.meas tran vdout1_100ck1960 FIND v(dout1_100) AT=1970.05n

.meas tran vdout1_101ck1960 FIND v(dout1_101) AT=1970.05n

.meas tran vdout1_102ck1960 FIND v(dout1_102) AT=1970.05n

.meas tran vdout1_103ck1960 FIND v(dout1_103) AT=1970.05n

.meas tran vdout1_104ck1960 FIND v(dout1_104) AT=1970.05n

.meas tran vdout1_105ck1960 FIND v(dout1_105) AT=1970.05n

.meas tran vdout1_106ck1960 FIND v(dout1_106) AT=1970.05n

.meas tran vdout1_107ck1960 FIND v(dout1_107) AT=1970.05n

.meas tran vdout1_108ck1960 FIND v(dout1_108) AT=1970.05n

.meas tran vdout1_109ck1960 FIND v(dout1_109) AT=1970.05n

.meas tran vdout1_110ck1960 FIND v(dout1_110) AT=1970.05n

.meas tran vdout1_111ck1960 FIND v(dout1_111) AT=1970.05n

.meas tran vdout1_112ck1960 FIND v(dout1_112) AT=1970.05n

.meas tran vdout1_113ck1960 FIND v(dout1_113) AT=1970.05n

.meas tran vdout1_114ck1960 FIND v(dout1_114) AT=1970.05n

.meas tran vdout1_115ck1960 FIND v(dout1_115) AT=1970.05n

.meas tran vdout1_116ck1960 FIND v(dout1_116) AT=1970.05n

.meas tran vdout1_117ck1960 FIND v(dout1_117) AT=1970.05n

.meas tran vdout1_118ck1960 FIND v(dout1_118) AT=1970.05n

.meas tran vdout1_119ck1960 FIND v(dout1_119) AT=1970.05n

.meas tran vdout1_120ck1960 FIND v(dout1_120) AT=1970.05n

.meas tran vdout1_121ck1960 FIND v(dout1_121) AT=1970.05n

.meas tran vdout1_122ck1960 FIND v(dout1_122) AT=1970.05n

.meas tran vdout1_123ck1960 FIND v(dout1_123) AT=1970.05n

.meas tran vdout1_124ck1960 FIND v(dout1_124) AT=1970.05n

.meas tran vdout1_125ck1960 FIND v(dout1_125) AT=1970.05n

.meas tran vdout1_126ck1960 FIND v(dout1_126) AT=1970.05n

.meas tran vdout1_127ck1960 FIND v(dout1_127) AT=1970.05n

.meas tran vdout1_128ck1960 FIND v(dout1_128) AT=1970.05n

.meas tran vdout1_129ck1960 FIND v(dout1_129) AT=1970.05n

.meas tran vdout1_130ck1960 FIND v(dout1_130) AT=1970.05n

.meas tran vdout1_131ck1960 FIND v(dout1_131) AT=1970.05n

.meas tran vdout1_132ck1960 FIND v(dout1_132) AT=1970.05n

.meas tran vdout1_133ck1960 FIND v(dout1_133) AT=1970.05n

.meas tran vdout1_134ck1960 FIND v(dout1_134) AT=1970.05n

.meas tran vdout1_135ck1960 FIND v(dout1_135) AT=1970.05n

.meas tran vdout1_136ck1960 FIND v(dout1_136) AT=1970.05n

.meas tran vdout1_137ck1960 FIND v(dout1_137) AT=1970.05n

.meas tran vdout1_138ck1960 FIND v(dout1_138) AT=1970.05n

.meas tran vdout1_139ck1960 FIND v(dout1_139) AT=1970.05n

.meas tran vdout1_140ck1960 FIND v(dout1_140) AT=1970.05n

.meas tran vdout1_141ck1960 FIND v(dout1_141) AT=1970.05n

.meas tran vdout1_142ck1960 FIND v(dout1_142) AT=1970.05n

.meas tran vdout1_143ck1960 FIND v(dout1_143) AT=1970.05n

.meas tran vdout1_144ck1960 FIND v(dout1_144) AT=1970.05n

.meas tran vdout1_145ck1960 FIND v(dout1_145) AT=1970.05n

.meas tran vdout1_146ck1960 FIND v(dout1_146) AT=1970.05n

.meas tran vdout1_147ck1960 FIND v(dout1_147) AT=1970.05n

.meas tran vdout1_148ck1960 FIND v(dout1_148) AT=1970.05n

.meas tran vdout1_149ck1960 FIND v(dout1_149) AT=1970.05n

.meas tran vdout1_150ck1960 FIND v(dout1_150) AT=1970.05n

.meas tran vdout1_151ck1960 FIND v(dout1_151) AT=1970.05n

.meas tran vdout1_152ck1960 FIND v(dout1_152) AT=1970.05n

.meas tran vdout1_153ck1960 FIND v(dout1_153) AT=1970.05n

.meas tran vdout1_154ck1960 FIND v(dout1_154) AT=1970.05n

.meas tran vdout1_155ck1960 FIND v(dout1_155) AT=1970.05n

.meas tran vdout1_156ck1960 FIND v(dout1_156) AT=1970.05n

.meas tran vdout1_157ck1960 FIND v(dout1_157) AT=1970.05n

.meas tran vdout1_158ck1960 FIND v(dout1_158) AT=1970.05n

.meas tran vdout1_159ck1960 FIND v(dout1_159) AT=1970.05n

.meas tran vdout1_160ck1960 FIND v(dout1_160) AT=1970.05n

.meas tran vdout1_161ck1960 FIND v(dout1_161) AT=1970.05n

.meas tran vdout1_162ck1960 FIND v(dout1_162) AT=1970.05n

.meas tran vdout1_163ck1960 FIND v(dout1_163) AT=1970.05n

.meas tran vdout1_164ck1960 FIND v(dout1_164) AT=1970.05n

.meas tran vdout1_165ck1960 FIND v(dout1_165) AT=1970.05n

.meas tran vdout1_166ck1960 FIND v(dout1_166) AT=1970.05n

.meas tran vdout1_167ck1960 FIND v(dout1_167) AT=1970.05n

.meas tran vdout1_168ck1960 FIND v(dout1_168) AT=1970.05n

.meas tran vdout1_169ck1960 FIND v(dout1_169) AT=1970.05n

.meas tran vdout1_170ck1960 FIND v(dout1_170) AT=1970.05n

.meas tran vdout1_171ck1960 FIND v(dout1_171) AT=1970.05n

.meas tran vdout1_172ck1960 FIND v(dout1_172) AT=1970.05n

.meas tran vdout1_173ck1960 FIND v(dout1_173) AT=1970.05n

.meas tran vdout1_174ck1960 FIND v(dout1_174) AT=1970.05n

.meas tran vdout1_175ck1960 FIND v(dout1_175) AT=1970.05n

.meas tran vdout1_176ck1960 FIND v(dout1_176) AT=1970.05n

.meas tran vdout1_177ck1960 FIND v(dout1_177) AT=1970.05n

.meas tran vdout1_178ck1960 FIND v(dout1_178) AT=1970.05n

.meas tran vdout1_179ck1960 FIND v(dout1_179) AT=1970.05n

.meas tran vdout1_180ck1960 FIND v(dout1_180) AT=1970.05n

.meas tran vdout1_181ck1960 FIND v(dout1_181) AT=1970.05n

.meas tran vdout1_182ck1960 FIND v(dout1_182) AT=1970.05n

.meas tran vdout1_183ck1960 FIND v(dout1_183) AT=1970.05n

.meas tran vdout1_184ck1960 FIND v(dout1_184) AT=1970.05n

.meas tran vdout1_185ck1960 FIND v(dout1_185) AT=1970.05n

.meas tran vdout1_186ck1960 FIND v(dout1_186) AT=1970.05n

.meas tran vdout1_187ck1960 FIND v(dout1_187) AT=1970.05n

.meas tran vdout1_188ck1960 FIND v(dout1_188) AT=1970.05n

.meas tran vdout1_189ck1960 FIND v(dout1_189) AT=1970.05n

.meas tran vdout1_190ck1960 FIND v(dout1_190) AT=1970.05n

.meas tran vdout1_191ck1960 FIND v(dout1_191) AT=1970.05n

.meas tran vdout1_192ck1960 FIND v(dout1_192) AT=1970.05n

.meas tran vdout1_193ck1960 FIND v(dout1_193) AT=1970.05n

.meas tran vdout1_194ck1960 FIND v(dout1_194) AT=1970.05n

.meas tran vdout1_195ck1960 FIND v(dout1_195) AT=1970.05n

.meas tran vdout1_196ck1960 FIND v(dout1_196) AT=1970.05n

.meas tran vdout1_197ck1960 FIND v(dout1_197) AT=1970.05n

.meas tran vdout1_198ck1960 FIND v(dout1_198) AT=1970.05n

.meas tran vdout1_199ck1960 FIND v(dout1_199) AT=1970.05n

.meas tran vdout1_200ck1960 FIND v(dout1_200) AT=1970.05n

.meas tran vdout1_201ck1960 FIND v(dout1_201) AT=1970.05n

.meas tran vdout1_202ck1960 FIND v(dout1_202) AT=1970.05n

.meas tran vdout1_203ck1960 FIND v(dout1_203) AT=1970.05n

.meas tran vdout1_204ck1960 FIND v(dout1_204) AT=1970.05n

.meas tran vdout1_205ck1960 FIND v(dout1_205) AT=1970.05n

.meas tran vdout1_206ck1960 FIND v(dout1_206) AT=1970.05n

.meas tran vdout1_207ck1960 FIND v(dout1_207) AT=1970.05n

.meas tran vdout1_208ck1960 FIND v(dout1_208) AT=1970.05n

.meas tran vdout1_209ck1960 FIND v(dout1_209) AT=1970.05n

.meas tran vdout1_210ck1960 FIND v(dout1_210) AT=1970.05n

.meas tran vdout1_211ck1960 FIND v(dout1_211) AT=1970.05n

.meas tran vdout1_212ck1960 FIND v(dout1_212) AT=1970.05n

.meas tran vdout1_213ck1960 FIND v(dout1_213) AT=1970.05n

.meas tran vdout1_214ck1960 FIND v(dout1_214) AT=1970.05n

.meas tran vdout1_215ck1960 FIND v(dout1_215) AT=1970.05n

.meas tran vdout1_216ck1960 FIND v(dout1_216) AT=1970.05n

.meas tran vdout1_217ck1960 FIND v(dout1_217) AT=1970.05n

.meas tran vdout1_218ck1960 FIND v(dout1_218) AT=1970.05n

.meas tran vdout1_219ck1960 FIND v(dout1_219) AT=1970.05n

.meas tran vdout1_220ck1960 FIND v(dout1_220) AT=1970.05n

.meas tran vdout1_221ck1960 FIND v(dout1_221) AT=1970.05n

.meas tran vdout1_222ck1960 FIND v(dout1_222) AT=1970.05n

.meas tran vdout1_223ck1960 FIND v(dout1_223) AT=1970.05n

.meas tran vdout1_224ck1960 FIND v(dout1_224) AT=1970.05n

.meas tran vdout1_225ck1960 FIND v(dout1_225) AT=1970.05n

.meas tran vdout1_226ck1960 FIND v(dout1_226) AT=1970.05n

.meas tran vdout1_227ck1960 FIND v(dout1_227) AT=1970.05n

.meas tran vdout1_228ck1960 FIND v(dout1_228) AT=1970.05n

.meas tran vdout1_229ck1960 FIND v(dout1_229) AT=1970.05n

.meas tran vdout1_230ck1960 FIND v(dout1_230) AT=1970.05n

.meas tran vdout1_231ck1960 FIND v(dout1_231) AT=1970.05n

.meas tran vdout1_232ck1960 FIND v(dout1_232) AT=1970.05n

.meas tran vdout1_233ck1960 FIND v(dout1_233) AT=1970.05n

.meas tran vdout1_234ck1960 FIND v(dout1_234) AT=1970.05n

.meas tran vdout1_235ck1960 FIND v(dout1_235) AT=1970.05n

.meas tran vdout1_236ck1960 FIND v(dout1_236) AT=1970.05n

.meas tran vdout1_237ck1960 FIND v(dout1_237) AT=1970.05n

.meas tran vdout1_238ck1960 FIND v(dout1_238) AT=1970.05n

.meas tran vdout1_239ck1960 FIND v(dout1_239) AT=1970.05n

.meas tran vdout1_240ck1960 FIND v(dout1_240) AT=1970.05n

.meas tran vdout1_241ck1960 FIND v(dout1_241) AT=1970.05n

.meas tran vdout1_242ck1960 FIND v(dout1_242) AT=1970.05n

.meas tran vdout1_243ck1960 FIND v(dout1_243) AT=1970.05n

.meas tran vdout1_244ck1960 FIND v(dout1_244) AT=1970.05n

.meas tran vdout1_245ck1960 FIND v(dout1_245) AT=1970.05n

.meas tran vdout1_246ck1960 FIND v(dout1_246) AT=1970.05n

.meas tran vdout1_247ck1960 FIND v(dout1_247) AT=1970.05n

.meas tran vdout1_248ck1960 FIND v(dout1_248) AT=1970.05n

.meas tran vdout1_249ck1960 FIND v(dout1_249) AT=1970.05n

.meas tran vdout1_250ck1960 FIND v(dout1_250) AT=1970.05n

.meas tran vdout1_251ck1960 FIND v(dout1_251) AT=1970.05n

.meas tran vdout1_252ck1960 FIND v(dout1_252) AT=1970.05n

.meas tran vdout1_253ck1960 FIND v(dout1_253) AT=1970.05n

.meas tran vdout1_254ck1960 FIND v(dout1_254) AT=1970.05n

.meas tran vdout1_255ck1960 FIND v(dout1_255) AT=1970.05n

.meas tran vdout1_256ck1960 FIND v(dout1_256) AT=1970.05n

.meas tran vdout1_0ck1970 FIND v(dout1_0) AT=1980.05n

.meas tran vdout1_1ck1970 FIND v(dout1_1) AT=1980.05n

.meas tran vdout1_2ck1970 FIND v(dout1_2) AT=1980.05n

.meas tran vdout1_3ck1970 FIND v(dout1_3) AT=1980.05n

.meas tran vdout1_4ck1970 FIND v(dout1_4) AT=1980.05n

.meas tran vdout1_5ck1970 FIND v(dout1_5) AT=1980.05n

.meas tran vdout1_6ck1970 FIND v(dout1_6) AT=1980.05n

.meas tran vdout1_7ck1970 FIND v(dout1_7) AT=1980.05n

.meas tran vdout1_8ck1970 FIND v(dout1_8) AT=1980.05n

.meas tran vdout1_9ck1970 FIND v(dout1_9) AT=1980.05n

.meas tran vdout1_10ck1970 FIND v(dout1_10) AT=1980.05n

.meas tran vdout1_11ck1970 FIND v(dout1_11) AT=1980.05n

.meas tran vdout1_12ck1970 FIND v(dout1_12) AT=1980.05n

.meas tran vdout1_13ck1970 FIND v(dout1_13) AT=1980.05n

.meas tran vdout1_14ck1970 FIND v(dout1_14) AT=1980.05n

.meas tran vdout1_15ck1970 FIND v(dout1_15) AT=1980.05n

.meas tran vdout1_16ck1970 FIND v(dout1_16) AT=1980.05n

.meas tran vdout1_17ck1970 FIND v(dout1_17) AT=1980.05n

.meas tran vdout1_18ck1970 FIND v(dout1_18) AT=1980.05n

.meas tran vdout1_19ck1970 FIND v(dout1_19) AT=1980.05n

.meas tran vdout1_20ck1970 FIND v(dout1_20) AT=1980.05n

.meas tran vdout1_21ck1970 FIND v(dout1_21) AT=1980.05n

.meas tran vdout1_22ck1970 FIND v(dout1_22) AT=1980.05n

.meas tran vdout1_23ck1970 FIND v(dout1_23) AT=1980.05n

.meas tran vdout1_24ck1970 FIND v(dout1_24) AT=1980.05n

.meas tran vdout1_25ck1970 FIND v(dout1_25) AT=1980.05n

.meas tran vdout1_26ck1970 FIND v(dout1_26) AT=1980.05n

.meas tran vdout1_27ck1970 FIND v(dout1_27) AT=1980.05n

.meas tran vdout1_28ck1970 FIND v(dout1_28) AT=1980.05n

.meas tran vdout1_29ck1970 FIND v(dout1_29) AT=1980.05n

.meas tran vdout1_30ck1970 FIND v(dout1_30) AT=1980.05n

.meas tran vdout1_31ck1970 FIND v(dout1_31) AT=1980.05n

.meas tran vdout1_32ck1970 FIND v(dout1_32) AT=1980.05n

.meas tran vdout1_33ck1970 FIND v(dout1_33) AT=1980.05n

.meas tran vdout1_34ck1970 FIND v(dout1_34) AT=1980.05n

.meas tran vdout1_35ck1970 FIND v(dout1_35) AT=1980.05n

.meas tran vdout1_36ck1970 FIND v(dout1_36) AT=1980.05n

.meas tran vdout1_37ck1970 FIND v(dout1_37) AT=1980.05n

.meas tran vdout1_38ck1970 FIND v(dout1_38) AT=1980.05n

.meas tran vdout1_39ck1970 FIND v(dout1_39) AT=1980.05n

.meas tran vdout1_40ck1970 FIND v(dout1_40) AT=1980.05n

.meas tran vdout1_41ck1970 FIND v(dout1_41) AT=1980.05n

.meas tran vdout1_42ck1970 FIND v(dout1_42) AT=1980.05n

.meas tran vdout1_43ck1970 FIND v(dout1_43) AT=1980.05n

.meas tran vdout1_44ck1970 FIND v(dout1_44) AT=1980.05n

.meas tran vdout1_45ck1970 FIND v(dout1_45) AT=1980.05n

.meas tran vdout1_46ck1970 FIND v(dout1_46) AT=1980.05n

.meas tran vdout1_47ck1970 FIND v(dout1_47) AT=1980.05n

.meas tran vdout1_48ck1970 FIND v(dout1_48) AT=1980.05n

.meas tran vdout1_49ck1970 FIND v(dout1_49) AT=1980.05n

.meas tran vdout1_50ck1970 FIND v(dout1_50) AT=1980.05n

.meas tran vdout1_51ck1970 FIND v(dout1_51) AT=1980.05n

.meas tran vdout1_52ck1970 FIND v(dout1_52) AT=1980.05n

.meas tran vdout1_53ck1970 FIND v(dout1_53) AT=1980.05n

.meas tran vdout1_54ck1970 FIND v(dout1_54) AT=1980.05n

.meas tran vdout1_55ck1970 FIND v(dout1_55) AT=1980.05n

.meas tran vdout1_56ck1970 FIND v(dout1_56) AT=1980.05n

.meas tran vdout1_57ck1970 FIND v(dout1_57) AT=1980.05n

.meas tran vdout1_58ck1970 FIND v(dout1_58) AT=1980.05n

.meas tran vdout1_59ck1970 FIND v(dout1_59) AT=1980.05n

.meas tran vdout1_60ck1970 FIND v(dout1_60) AT=1980.05n

.meas tran vdout1_61ck1970 FIND v(dout1_61) AT=1980.05n

.meas tran vdout1_62ck1970 FIND v(dout1_62) AT=1980.05n

.meas tran vdout1_63ck1970 FIND v(dout1_63) AT=1980.05n

.meas tran vdout1_64ck1970 FIND v(dout1_64) AT=1980.05n

.meas tran vdout1_65ck1970 FIND v(dout1_65) AT=1980.05n

.meas tran vdout1_66ck1970 FIND v(dout1_66) AT=1980.05n

.meas tran vdout1_67ck1970 FIND v(dout1_67) AT=1980.05n

.meas tran vdout1_68ck1970 FIND v(dout1_68) AT=1980.05n

.meas tran vdout1_69ck1970 FIND v(dout1_69) AT=1980.05n

.meas tran vdout1_70ck1970 FIND v(dout1_70) AT=1980.05n

.meas tran vdout1_71ck1970 FIND v(dout1_71) AT=1980.05n

.meas tran vdout1_72ck1970 FIND v(dout1_72) AT=1980.05n

.meas tran vdout1_73ck1970 FIND v(dout1_73) AT=1980.05n

.meas tran vdout1_74ck1970 FIND v(dout1_74) AT=1980.05n

.meas tran vdout1_75ck1970 FIND v(dout1_75) AT=1980.05n

.meas tran vdout1_76ck1970 FIND v(dout1_76) AT=1980.05n

.meas tran vdout1_77ck1970 FIND v(dout1_77) AT=1980.05n

.meas tran vdout1_78ck1970 FIND v(dout1_78) AT=1980.05n

.meas tran vdout1_79ck1970 FIND v(dout1_79) AT=1980.05n

.meas tran vdout1_80ck1970 FIND v(dout1_80) AT=1980.05n

.meas tran vdout1_81ck1970 FIND v(dout1_81) AT=1980.05n

.meas tran vdout1_82ck1970 FIND v(dout1_82) AT=1980.05n

.meas tran vdout1_83ck1970 FIND v(dout1_83) AT=1980.05n

.meas tran vdout1_84ck1970 FIND v(dout1_84) AT=1980.05n

.meas tran vdout1_85ck1970 FIND v(dout1_85) AT=1980.05n

.meas tran vdout1_86ck1970 FIND v(dout1_86) AT=1980.05n

.meas tran vdout1_87ck1970 FIND v(dout1_87) AT=1980.05n

.meas tran vdout1_88ck1970 FIND v(dout1_88) AT=1980.05n

.meas tran vdout1_89ck1970 FIND v(dout1_89) AT=1980.05n

.meas tran vdout1_90ck1970 FIND v(dout1_90) AT=1980.05n

.meas tran vdout1_91ck1970 FIND v(dout1_91) AT=1980.05n

.meas tran vdout1_92ck1970 FIND v(dout1_92) AT=1980.05n

.meas tran vdout1_93ck1970 FIND v(dout1_93) AT=1980.05n

.meas tran vdout1_94ck1970 FIND v(dout1_94) AT=1980.05n

.meas tran vdout1_95ck1970 FIND v(dout1_95) AT=1980.05n

.meas tran vdout1_96ck1970 FIND v(dout1_96) AT=1980.05n

.meas tran vdout1_97ck1970 FIND v(dout1_97) AT=1980.05n

.meas tran vdout1_98ck1970 FIND v(dout1_98) AT=1980.05n

.meas tran vdout1_99ck1970 FIND v(dout1_99) AT=1980.05n

.meas tran vdout1_100ck1970 FIND v(dout1_100) AT=1980.05n

.meas tran vdout1_101ck1970 FIND v(dout1_101) AT=1980.05n

.meas tran vdout1_102ck1970 FIND v(dout1_102) AT=1980.05n

.meas tran vdout1_103ck1970 FIND v(dout1_103) AT=1980.05n

.meas tran vdout1_104ck1970 FIND v(dout1_104) AT=1980.05n

.meas tran vdout1_105ck1970 FIND v(dout1_105) AT=1980.05n

.meas tran vdout1_106ck1970 FIND v(dout1_106) AT=1980.05n

.meas tran vdout1_107ck1970 FIND v(dout1_107) AT=1980.05n

.meas tran vdout1_108ck1970 FIND v(dout1_108) AT=1980.05n

.meas tran vdout1_109ck1970 FIND v(dout1_109) AT=1980.05n

.meas tran vdout1_110ck1970 FIND v(dout1_110) AT=1980.05n

.meas tran vdout1_111ck1970 FIND v(dout1_111) AT=1980.05n

.meas tran vdout1_112ck1970 FIND v(dout1_112) AT=1980.05n

.meas tran vdout1_113ck1970 FIND v(dout1_113) AT=1980.05n

.meas tran vdout1_114ck1970 FIND v(dout1_114) AT=1980.05n

.meas tran vdout1_115ck1970 FIND v(dout1_115) AT=1980.05n

.meas tran vdout1_116ck1970 FIND v(dout1_116) AT=1980.05n

.meas tran vdout1_117ck1970 FIND v(dout1_117) AT=1980.05n

.meas tran vdout1_118ck1970 FIND v(dout1_118) AT=1980.05n

.meas tran vdout1_119ck1970 FIND v(dout1_119) AT=1980.05n

.meas tran vdout1_120ck1970 FIND v(dout1_120) AT=1980.05n

.meas tran vdout1_121ck1970 FIND v(dout1_121) AT=1980.05n

.meas tran vdout1_122ck1970 FIND v(dout1_122) AT=1980.05n

.meas tran vdout1_123ck1970 FIND v(dout1_123) AT=1980.05n

.meas tran vdout1_124ck1970 FIND v(dout1_124) AT=1980.05n

.meas tran vdout1_125ck1970 FIND v(dout1_125) AT=1980.05n

.meas tran vdout1_126ck1970 FIND v(dout1_126) AT=1980.05n

.meas tran vdout1_127ck1970 FIND v(dout1_127) AT=1980.05n

.meas tran vdout1_128ck1970 FIND v(dout1_128) AT=1980.05n

.meas tran vdout1_129ck1970 FIND v(dout1_129) AT=1980.05n

.meas tran vdout1_130ck1970 FIND v(dout1_130) AT=1980.05n

.meas tran vdout1_131ck1970 FIND v(dout1_131) AT=1980.05n

.meas tran vdout1_132ck1970 FIND v(dout1_132) AT=1980.05n

.meas tran vdout1_133ck1970 FIND v(dout1_133) AT=1980.05n

.meas tran vdout1_134ck1970 FIND v(dout1_134) AT=1980.05n

.meas tran vdout1_135ck1970 FIND v(dout1_135) AT=1980.05n

.meas tran vdout1_136ck1970 FIND v(dout1_136) AT=1980.05n

.meas tran vdout1_137ck1970 FIND v(dout1_137) AT=1980.05n

.meas tran vdout1_138ck1970 FIND v(dout1_138) AT=1980.05n

.meas tran vdout1_139ck1970 FIND v(dout1_139) AT=1980.05n

.meas tran vdout1_140ck1970 FIND v(dout1_140) AT=1980.05n

.meas tran vdout1_141ck1970 FIND v(dout1_141) AT=1980.05n

.meas tran vdout1_142ck1970 FIND v(dout1_142) AT=1980.05n

.meas tran vdout1_143ck1970 FIND v(dout1_143) AT=1980.05n

.meas tran vdout1_144ck1970 FIND v(dout1_144) AT=1980.05n

.meas tran vdout1_145ck1970 FIND v(dout1_145) AT=1980.05n

.meas tran vdout1_146ck1970 FIND v(dout1_146) AT=1980.05n

.meas tran vdout1_147ck1970 FIND v(dout1_147) AT=1980.05n

.meas tran vdout1_148ck1970 FIND v(dout1_148) AT=1980.05n

.meas tran vdout1_149ck1970 FIND v(dout1_149) AT=1980.05n

.meas tran vdout1_150ck1970 FIND v(dout1_150) AT=1980.05n

.meas tran vdout1_151ck1970 FIND v(dout1_151) AT=1980.05n

.meas tran vdout1_152ck1970 FIND v(dout1_152) AT=1980.05n

.meas tran vdout1_153ck1970 FIND v(dout1_153) AT=1980.05n

.meas tran vdout1_154ck1970 FIND v(dout1_154) AT=1980.05n

.meas tran vdout1_155ck1970 FIND v(dout1_155) AT=1980.05n

.meas tran vdout1_156ck1970 FIND v(dout1_156) AT=1980.05n

.meas tran vdout1_157ck1970 FIND v(dout1_157) AT=1980.05n

.meas tran vdout1_158ck1970 FIND v(dout1_158) AT=1980.05n

.meas tran vdout1_159ck1970 FIND v(dout1_159) AT=1980.05n

.meas tran vdout1_160ck1970 FIND v(dout1_160) AT=1980.05n

.meas tran vdout1_161ck1970 FIND v(dout1_161) AT=1980.05n

.meas tran vdout1_162ck1970 FIND v(dout1_162) AT=1980.05n

.meas tran vdout1_163ck1970 FIND v(dout1_163) AT=1980.05n

.meas tran vdout1_164ck1970 FIND v(dout1_164) AT=1980.05n

.meas tran vdout1_165ck1970 FIND v(dout1_165) AT=1980.05n

.meas tran vdout1_166ck1970 FIND v(dout1_166) AT=1980.05n

.meas tran vdout1_167ck1970 FIND v(dout1_167) AT=1980.05n

.meas tran vdout1_168ck1970 FIND v(dout1_168) AT=1980.05n

.meas tran vdout1_169ck1970 FIND v(dout1_169) AT=1980.05n

.meas tran vdout1_170ck1970 FIND v(dout1_170) AT=1980.05n

.meas tran vdout1_171ck1970 FIND v(dout1_171) AT=1980.05n

.meas tran vdout1_172ck1970 FIND v(dout1_172) AT=1980.05n

.meas tran vdout1_173ck1970 FIND v(dout1_173) AT=1980.05n

.meas tran vdout1_174ck1970 FIND v(dout1_174) AT=1980.05n

.meas tran vdout1_175ck1970 FIND v(dout1_175) AT=1980.05n

.meas tran vdout1_176ck1970 FIND v(dout1_176) AT=1980.05n

.meas tran vdout1_177ck1970 FIND v(dout1_177) AT=1980.05n

.meas tran vdout1_178ck1970 FIND v(dout1_178) AT=1980.05n

.meas tran vdout1_179ck1970 FIND v(dout1_179) AT=1980.05n

.meas tran vdout1_180ck1970 FIND v(dout1_180) AT=1980.05n

.meas tran vdout1_181ck1970 FIND v(dout1_181) AT=1980.05n

.meas tran vdout1_182ck1970 FIND v(dout1_182) AT=1980.05n

.meas tran vdout1_183ck1970 FIND v(dout1_183) AT=1980.05n

.meas tran vdout1_184ck1970 FIND v(dout1_184) AT=1980.05n

.meas tran vdout1_185ck1970 FIND v(dout1_185) AT=1980.05n

.meas tran vdout1_186ck1970 FIND v(dout1_186) AT=1980.05n

.meas tran vdout1_187ck1970 FIND v(dout1_187) AT=1980.05n

.meas tran vdout1_188ck1970 FIND v(dout1_188) AT=1980.05n

.meas tran vdout1_189ck1970 FIND v(dout1_189) AT=1980.05n

.meas tran vdout1_190ck1970 FIND v(dout1_190) AT=1980.05n

.meas tran vdout1_191ck1970 FIND v(dout1_191) AT=1980.05n

.meas tran vdout1_192ck1970 FIND v(dout1_192) AT=1980.05n

.meas tran vdout1_193ck1970 FIND v(dout1_193) AT=1980.05n

.meas tran vdout1_194ck1970 FIND v(dout1_194) AT=1980.05n

.meas tran vdout1_195ck1970 FIND v(dout1_195) AT=1980.05n

.meas tran vdout1_196ck1970 FIND v(dout1_196) AT=1980.05n

.meas tran vdout1_197ck1970 FIND v(dout1_197) AT=1980.05n

.meas tran vdout1_198ck1970 FIND v(dout1_198) AT=1980.05n

.meas tran vdout1_199ck1970 FIND v(dout1_199) AT=1980.05n

.meas tran vdout1_200ck1970 FIND v(dout1_200) AT=1980.05n

.meas tran vdout1_201ck1970 FIND v(dout1_201) AT=1980.05n

.meas tran vdout1_202ck1970 FIND v(dout1_202) AT=1980.05n

.meas tran vdout1_203ck1970 FIND v(dout1_203) AT=1980.05n

.meas tran vdout1_204ck1970 FIND v(dout1_204) AT=1980.05n

.meas tran vdout1_205ck1970 FIND v(dout1_205) AT=1980.05n

.meas tran vdout1_206ck1970 FIND v(dout1_206) AT=1980.05n

.meas tran vdout1_207ck1970 FIND v(dout1_207) AT=1980.05n

.meas tran vdout1_208ck1970 FIND v(dout1_208) AT=1980.05n

.meas tran vdout1_209ck1970 FIND v(dout1_209) AT=1980.05n

.meas tran vdout1_210ck1970 FIND v(dout1_210) AT=1980.05n

.meas tran vdout1_211ck1970 FIND v(dout1_211) AT=1980.05n

.meas tran vdout1_212ck1970 FIND v(dout1_212) AT=1980.05n

.meas tran vdout1_213ck1970 FIND v(dout1_213) AT=1980.05n

.meas tran vdout1_214ck1970 FIND v(dout1_214) AT=1980.05n

.meas tran vdout1_215ck1970 FIND v(dout1_215) AT=1980.05n

.meas tran vdout1_216ck1970 FIND v(dout1_216) AT=1980.05n

.meas tran vdout1_217ck1970 FIND v(dout1_217) AT=1980.05n

.meas tran vdout1_218ck1970 FIND v(dout1_218) AT=1980.05n

.meas tran vdout1_219ck1970 FIND v(dout1_219) AT=1980.05n

.meas tran vdout1_220ck1970 FIND v(dout1_220) AT=1980.05n

.meas tran vdout1_221ck1970 FIND v(dout1_221) AT=1980.05n

.meas tran vdout1_222ck1970 FIND v(dout1_222) AT=1980.05n

.meas tran vdout1_223ck1970 FIND v(dout1_223) AT=1980.05n

.meas tran vdout1_224ck1970 FIND v(dout1_224) AT=1980.05n

.meas tran vdout1_225ck1970 FIND v(dout1_225) AT=1980.05n

.meas tran vdout1_226ck1970 FIND v(dout1_226) AT=1980.05n

.meas tran vdout1_227ck1970 FIND v(dout1_227) AT=1980.05n

.meas tran vdout1_228ck1970 FIND v(dout1_228) AT=1980.05n

.meas tran vdout1_229ck1970 FIND v(dout1_229) AT=1980.05n

.meas tran vdout1_230ck1970 FIND v(dout1_230) AT=1980.05n

.meas tran vdout1_231ck1970 FIND v(dout1_231) AT=1980.05n

.meas tran vdout1_232ck1970 FIND v(dout1_232) AT=1980.05n

.meas tran vdout1_233ck1970 FIND v(dout1_233) AT=1980.05n

.meas tran vdout1_234ck1970 FIND v(dout1_234) AT=1980.05n

.meas tran vdout1_235ck1970 FIND v(dout1_235) AT=1980.05n

.meas tran vdout1_236ck1970 FIND v(dout1_236) AT=1980.05n

.meas tran vdout1_237ck1970 FIND v(dout1_237) AT=1980.05n

.meas tran vdout1_238ck1970 FIND v(dout1_238) AT=1980.05n

.meas tran vdout1_239ck1970 FIND v(dout1_239) AT=1980.05n

.meas tran vdout1_240ck1970 FIND v(dout1_240) AT=1980.05n

.meas tran vdout1_241ck1970 FIND v(dout1_241) AT=1980.05n

.meas tran vdout1_242ck1970 FIND v(dout1_242) AT=1980.05n

.meas tran vdout1_243ck1970 FIND v(dout1_243) AT=1980.05n

.meas tran vdout1_244ck1970 FIND v(dout1_244) AT=1980.05n

.meas tran vdout1_245ck1970 FIND v(dout1_245) AT=1980.05n

.meas tran vdout1_246ck1970 FIND v(dout1_246) AT=1980.05n

.meas tran vdout1_247ck1970 FIND v(dout1_247) AT=1980.05n

.meas tran vdout1_248ck1970 FIND v(dout1_248) AT=1980.05n

.meas tran vdout1_249ck1970 FIND v(dout1_249) AT=1980.05n

.meas tran vdout1_250ck1970 FIND v(dout1_250) AT=1980.05n

.meas tran vdout1_251ck1970 FIND v(dout1_251) AT=1980.05n

.meas tran vdout1_252ck1970 FIND v(dout1_252) AT=1980.05n

.meas tran vdout1_253ck1970 FIND v(dout1_253) AT=1980.05n

.meas tran vdout1_254ck1970 FIND v(dout1_254) AT=1980.05n

.meas tran vdout1_255ck1970 FIND v(dout1_255) AT=1980.05n

.meas tran vdout1_256ck1970 FIND v(dout1_256) AT=1980.05n

.meas tran vdout1_0ck1990 FIND v(dout1_0) AT=2000.05n

.meas tran vdout1_1ck1990 FIND v(dout1_1) AT=2000.05n

.meas tran vdout1_2ck1990 FIND v(dout1_2) AT=2000.05n

.meas tran vdout1_3ck1990 FIND v(dout1_3) AT=2000.05n

.meas tran vdout1_4ck1990 FIND v(dout1_4) AT=2000.05n

.meas tran vdout1_5ck1990 FIND v(dout1_5) AT=2000.05n

.meas tran vdout1_6ck1990 FIND v(dout1_6) AT=2000.05n

.meas tran vdout1_7ck1990 FIND v(dout1_7) AT=2000.05n

.meas tran vdout1_8ck1990 FIND v(dout1_8) AT=2000.05n

.meas tran vdout1_9ck1990 FIND v(dout1_9) AT=2000.05n

.meas tran vdout1_10ck1990 FIND v(dout1_10) AT=2000.05n

.meas tran vdout1_11ck1990 FIND v(dout1_11) AT=2000.05n

.meas tran vdout1_12ck1990 FIND v(dout1_12) AT=2000.05n

.meas tran vdout1_13ck1990 FIND v(dout1_13) AT=2000.05n

.meas tran vdout1_14ck1990 FIND v(dout1_14) AT=2000.05n

.meas tran vdout1_15ck1990 FIND v(dout1_15) AT=2000.05n

.meas tran vdout1_16ck1990 FIND v(dout1_16) AT=2000.05n

.meas tran vdout1_17ck1990 FIND v(dout1_17) AT=2000.05n

.meas tran vdout1_18ck1990 FIND v(dout1_18) AT=2000.05n

.meas tran vdout1_19ck1990 FIND v(dout1_19) AT=2000.05n

.meas tran vdout1_20ck1990 FIND v(dout1_20) AT=2000.05n

.meas tran vdout1_21ck1990 FIND v(dout1_21) AT=2000.05n

.meas tran vdout1_22ck1990 FIND v(dout1_22) AT=2000.05n

.meas tran vdout1_23ck1990 FIND v(dout1_23) AT=2000.05n

.meas tran vdout1_24ck1990 FIND v(dout1_24) AT=2000.05n

.meas tran vdout1_25ck1990 FIND v(dout1_25) AT=2000.05n

.meas tran vdout1_26ck1990 FIND v(dout1_26) AT=2000.05n

.meas tran vdout1_27ck1990 FIND v(dout1_27) AT=2000.05n

.meas tran vdout1_28ck1990 FIND v(dout1_28) AT=2000.05n

.meas tran vdout1_29ck1990 FIND v(dout1_29) AT=2000.05n

.meas tran vdout1_30ck1990 FIND v(dout1_30) AT=2000.05n

.meas tran vdout1_31ck1990 FIND v(dout1_31) AT=2000.05n

.meas tran vdout1_32ck1990 FIND v(dout1_32) AT=2000.05n

.meas tran vdout1_33ck1990 FIND v(dout1_33) AT=2000.05n

.meas tran vdout1_34ck1990 FIND v(dout1_34) AT=2000.05n

.meas tran vdout1_35ck1990 FIND v(dout1_35) AT=2000.05n

.meas tran vdout1_36ck1990 FIND v(dout1_36) AT=2000.05n

.meas tran vdout1_37ck1990 FIND v(dout1_37) AT=2000.05n

.meas tran vdout1_38ck1990 FIND v(dout1_38) AT=2000.05n

.meas tran vdout1_39ck1990 FIND v(dout1_39) AT=2000.05n

.meas tran vdout1_40ck1990 FIND v(dout1_40) AT=2000.05n

.meas tran vdout1_41ck1990 FIND v(dout1_41) AT=2000.05n

.meas tran vdout1_42ck1990 FIND v(dout1_42) AT=2000.05n

.meas tran vdout1_43ck1990 FIND v(dout1_43) AT=2000.05n

.meas tran vdout1_44ck1990 FIND v(dout1_44) AT=2000.05n

.meas tran vdout1_45ck1990 FIND v(dout1_45) AT=2000.05n

.meas tran vdout1_46ck1990 FIND v(dout1_46) AT=2000.05n

.meas tran vdout1_47ck1990 FIND v(dout1_47) AT=2000.05n

.meas tran vdout1_48ck1990 FIND v(dout1_48) AT=2000.05n

.meas tran vdout1_49ck1990 FIND v(dout1_49) AT=2000.05n

.meas tran vdout1_50ck1990 FIND v(dout1_50) AT=2000.05n

.meas tran vdout1_51ck1990 FIND v(dout1_51) AT=2000.05n

.meas tran vdout1_52ck1990 FIND v(dout1_52) AT=2000.05n

.meas tran vdout1_53ck1990 FIND v(dout1_53) AT=2000.05n

.meas tran vdout1_54ck1990 FIND v(dout1_54) AT=2000.05n

.meas tran vdout1_55ck1990 FIND v(dout1_55) AT=2000.05n

.meas tran vdout1_56ck1990 FIND v(dout1_56) AT=2000.05n

.meas tran vdout1_57ck1990 FIND v(dout1_57) AT=2000.05n

.meas tran vdout1_58ck1990 FIND v(dout1_58) AT=2000.05n

.meas tran vdout1_59ck1990 FIND v(dout1_59) AT=2000.05n

.meas tran vdout1_60ck1990 FIND v(dout1_60) AT=2000.05n

.meas tran vdout1_61ck1990 FIND v(dout1_61) AT=2000.05n

.meas tran vdout1_62ck1990 FIND v(dout1_62) AT=2000.05n

.meas tran vdout1_63ck1990 FIND v(dout1_63) AT=2000.05n

.meas tran vdout1_64ck1990 FIND v(dout1_64) AT=2000.05n

.meas tran vdout1_65ck1990 FIND v(dout1_65) AT=2000.05n

.meas tran vdout1_66ck1990 FIND v(dout1_66) AT=2000.05n

.meas tran vdout1_67ck1990 FIND v(dout1_67) AT=2000.05n

.meas tran vdout1_68ck1990 FIND v(dout1_68) AT=2000.05n

.meas tran vdout1_69ck1990 FIND v(dout1_69) AT=2000.05n

.meas tran vdout1_70ck1990 FIND v(dout1_70) AT=2000.05n

.meas tran vdout1_71ck1990 FIND v(dout1_71) AT=2000.05n

.meas tran vdout1_72ck1990 FIND v(dout1_72) AT=2000.05n

.meas tran vdout1_73ck1990 FIND v(dout1_73) AT=2000.05n

.meas tran vdout1_74ck1990 FIND v(dout1_74) AT=2000.05n

.meas tran vdout1_75ck1990 FIND v(dout1_75) AT=2000.05n

.meas tran vdout1_76ck1990 FIND v(dout1_76) AT=2000.05n

.meas tran vdout1_77ck1990 FIND v(dout1_77) AT=2000.05n

.meas tran vdout1_78ck1990 FIND v(dout1_78) AT=2000.05n

.meas tran vdout1_79ck1990 FIND v(dout1_79) AT=2000.05n

.meas tran vdout1_80ck1990 FIND v(dout1_80) AT=2000.05n

.meas tran vdout1_81ck1990 FIND v(dout1_81) AT=2000.05n

.meas tran vdout1_82ck1990 FIND v(dout1_82) AT=2000.05n

.meas tran vdout1_83ck1990 FIND v(dout1_83) AT=2000.05n

.meas tran vdout1_84ck1990 FIND v(dout1_84) AT=2000.05n

.meas tran vdout1_85ck1990 FIND v(dout1_85) AT=2000.05n

.meas tran vdout1_86ck1990 FIND v(dout1_86) AT=2000.05n

.meas tran vdout1_87ck1990 FIND v(dout1_87) AT=2000.05n

.meas tran vdout1_88ck1990 FIND v(dout1_88) AT=2000.05n

.meas tran vdout1_89ck1990 FIND v(dout1_89) AT=2000.05n

.meas tran vdout1_90ck1990 FIND v(dout1_90) AT=2000.05n

.meas tran vdout1_91ck1990 FIND v(dout1_91) AT=2000.05n

.meas tran vdout1_92ck1990 FIND v(dout1_92) AT=2000.05n

.meas tran vdout1_93ck1990 FIND v(dout1_93) AT=2000.05n

.meas tran vdout1_94ck1990 FIND v(dout1_94) AT=2000.05n

.meas tran vdout1_95ck1990 FIND v(dout1_95) AT=2000.05n

.meas tran vdout1_96ck1990 FIND v(dout1_96) AT=2000.05n

.meas tran vdout1_97ck1990 FIND v(dout1_97) AT=2000.05n

.meas tran vdout1_98ck1990 FIND v(dout1_98) AT=2000.05n

.meas tran vdout1_99ck1990 FIND v(dout1_99) AT=2000.05n

.meas tran vdout1_100ck1990 FIND v(dout1_100) AT=2000.05n

.meas tran vdout1_101ck1990 FIND v(dout1_101) AT=2000.05n

.meas tran vdout1_102ck1990 FIND v(dout1_102) AT=2000.05n

.meas tran vdout1_103ck1990 FIND v(dout1_103) AT=2000.05n

.meas tran vdout1_104ck1990 FIND v(dout1_104) AT=2000.05n

.meas tran vdout1_105ck1990 FIND v(dout1_105) AT=2000.05n

.meas tran vdout1_106ck1990 FIND v(dout1_106) AT=2000.05n

.meas tran vdout1_107ck1990 FIND v(dout1_107) AT=2000.05n

.meas tran vdout1_108ck1990 FIND v(dout1_108) AT=2000.05n

.meas tran vdout1_109ck1990 FIND v(dout1_109) AT=2000.05n

.meas tran vdout1_110ck1990 FIND v(dout1_110) AT=2000.05n

.meas tran vdout1_111ck1990 FIND v(dout1_111) AT=2000.05n

.meas tran vdout1_112ck1990 FIND v(dout1_112) AT=2000.05n

.meas tran vdout1_113ck1990 FIND v(dout1_113) AT=2000.05n

.meas tran vdout1_114ck1990 FIND v(dout1_114) AT=2000.05n

.meas tran vdout1_115ck1990 FIND v(dout1_115) AT=2000.05n

.meas tran vdout1_116ck1990 FIND v(dout1_116) AT=2000.05n

.meas tran vdout1_117ck1990 FIND v(dout1_117) AT=2000.05n

.meas tran vdout1_118ck1990 FIND v(dout1_118) AT=2000.05n

.meas tran vdout1_119ck1990 FIND v(dout1_119) AT=2000.05n

.meas tran vdout1_120ck1990 FIND v(dout1_120) AT=2000.05n

.meas tran vdout1_121ck1990 FIND v(dout1_121) AT=2000.05n

.meas tran vdout1_122ck1990 FIND v(dout1_122) AT=2000.05n

.meas tran vdout1_123ck1990 FIND v(dout1_123) AT=2000.05n

.meas tran vdout1_124ck1990 FIND v(dout1_124) AT=2000.05n

.meas tran vdout1_125ck1990 FIND v(dout1_125) AT=2000.05n

.meas tran vdout1_126ck1990 FIND v(dout1_126) AT=2000.05n

.meas tran vdout1_127ck1990 FIND v(dout1_127) AT=2000.05n

.meas tran vdout1_128ck1990 FIND v(dout1_128) AT=2000.05n

.meas tran vdout1_129ck1990 FIND v(dout1_129) AT=2000.05n

.meas tran vdout1_130ck1990 FIND v(dout1_130) AT=2000.05n

.meas tran vdout1_131ck1990 FIND v(dout1_131) AT=2000.05n

.meas tran vdout1_132ck1990 FIND v(dout1_132) AT=2000.05n

.meas tran vdout1_133ck1990 FIND v(dout1_133) AT=2000.05n

.meas tran vdout1_134ck1990 FIND v(dout1_134) AT=2000.05n

.meas tran vdout1_135ck1990 FIND v(dout1_135) AT=2000.05n

.meas tran vdout1_136ck1990 FIND v(dout1_136) AT=2000.05n

.meas tran vdout1_137ck1990 FIND v(dout1_137) AT=2000.05n

.meas tran vdout1_138ck1990 FIND v(dout1_138) AT=2000.05n

.meas tran vdout1_139ck1990 FIND v(dout1_139) AT=2000.05n

.meas tran vdout1_140ck1990 FIND v(dout1_140) AT=2000.05n

.meas tran vdout1_141ck1990 FIND v(dout1_141) AT=2000.05n

.meas tran vdout1_142ck1990 FIND v(dout1_142) AT=2000.05n

.meas tran vdout1_143ck1990 FIND v(dout1_143) AT=2000.05n

.meas tran vdout1_144ck1990 FIND v(dout1_144) AT=2000.05n

.meas tran vdout1_145ck1990 FIND v(dout1_145) AT=2000.05n

.meas tran vdout1_146ck1990 FIND v(dout1_146) AT=2000.05n

.meas tran vdout1_147ck1990 FIND v(dout1_147) AT=2000.05n

.meas tran vdout1_148ck1990 FIND v(dout1_148) AT=2000.05n

.meas tran vdout1_149ck1990 FIND v(dout1_149) AT=2000.05n

.meas tran vdout1_150ck1990 FIND v(dout1_150) AT=2000.05n

.meas tran vdout1_151ck1990 FIND v(dout1_151) AT=2000.05n

.meas tran vdout1_152ck1990 FIND v(dout1_152) AT=2000.05n

.meas tran vdout1_153ck1990 FIND v(dout1_153) AT=2000.05n

.meas tran vdout1_154ck1990 FIND v(dout1_154) AT=2000.05n

.meas tran vdout1_155ck1990 FIND v(dout1_155) AT=2000.05n

.meas tran vdout1_156ck1990 FIND v(dout1_156) AT=2000.05n

.meas tran vdout1_157ck1990 FIND v(dout1_157) AT=2000.05n

.meas tran vdout1_158ck1990 FIND v(dout1_158) AT=2000.05n

.meas tran vdout1_159ck1990 FIND v(dout1_159) AT=2000.05n

.meas tran vdout1_160ck1990 FIND v(dout1_160) AT=2000.05n

.meas tran vdout1_161ck1990 FIND v(dout1_161) AT=2000.05n

.meas tran vdout1_162ck1990 FIND v(dout1_162) AT=2000.05n

.meas tran vdout1_163ck1990 FIND v(dout1_163) AT=2000.05n

.meas tran vdout1_164ck1990 FIND v(dout1_164) AT=2000.05n

.meas tran vdout1_165ck1990 FIND v(dout1_165) AT=2000.05n

.meas tran vdout1_166ck1990 FIND v(dout1_166) AT=2000.05n

.meas tran vdout1_167ck1990 FIND v(dout1_167) AT=2000.05n

.meas tran vdout1_168ck1990 FIND v(dout1_168) AT=2000.05n

.meas tran vdout1_169ck1990 FIND v(dout1_169) AT=2000.05n

.meas tran vdout1_170ck1990 FIND v(dout1_170) AT=2000.05n

.meas tran vdout1_171ck1990 FIND v(dout1_171) AT=2000.05n

.meas tran vdout1_172ck1990 FIND v(dout1_172) AT=2000.05n

.meas tran vdout1_173ck1990 FIND v(dout1_173) AT=2000.05n

.meas tran vdout1_174ck1990 FIND v(dout1_174) AT=2000.05n

.meas tran vdout1_175ck1990 FIND v(dout1_175) AT=2000.05n

.meas tran vdout1_176ck1990 FIND v(dout1_176) AT=2000.05n

.meas tran vdout1_177ck1990 FIND v(dout1_177) AT=2000.05n

.meas tran vdout1_178ck1990 FIND v(dout1_178) AT=2000.05n

.meas tran vdout1_179ck1990 FIND v(dout1_179) AT=2000.05n

.meas tran vdout1_180ck1990 FIND v(dout1_180) AT=2000.05n

.meas tran vdout1_181ck1990 FIND v(dout1_181) AT=2000.05n

.meas tran vdout1_182ck1990 FIND v(dout1_182) AT=2000.05n

.meas tran vdout1_183ck1990 FIND v(dout1_183) AT=2000.05n

.meas tran vdout1_184ck1990 FIND v(dout1_184) AT=2000.05n

.meas tran vdout1_185ck1990 FIND v(dout1_185) AT=2000.05n

.meas tran vdout1_186ck1990 FIND v(dout1_186) AT=2000.05n

.meas tran vdout1_187ck1990 FIND v(dout1_187) AT=2000.05n

.meas tran vdout1_188ck1990 FIND v(dout1_188) AT=2000.05n

.meas tran vdout1_189ck1990 FIND v(dout1_189) AT=2000.05n

.meas tran vdout1_190ck1990 FIND v(dout1_190) AT=2000.05n

.meas tran vdout1_191ck1990 FIND v(dout1_191) AT=2000.05n

.meas tran vdout1_192ck1990 FIND v(dout1_192) AT=2000.05n

.meas tran vdout1_193ck1990 FIND v(dout1_193) AT=2000.05n

.meas tran vdout1_194ck1990 FIND v(dout1_194) AT=2000.05n

.meas tran vdout1_195ck1990 FIND v(dout1_195) AT=2000.05n

.meas tran vdout1_196ck1990 FIND v(dout1_196) AT=2000.05n

.meas tran vdout1_197ck1990 FIND v(dout1_197) AT=2000.05n

.meas tran vdout1_198ck1990 FIND v(dout1_198) AT=2000.05n

.meas tran vdout1_199ck1990 FIND v(dout1_199) AT=2000.05n

.meas tran vdout1_200ck1990 FIND v(dout1_200) AT=2000.05n

.meas tran vdout1_201ck1990 FIND v(dout1_201) AT=2000.05n

.meas tran vdout1_202ck1990 FIND v(dout1_202) AT=2000.05n

.meas tran vdout1_203ck1990 FIND v(dout1_203) AT=2000.05n

.meas tran vdout1_204ck1990 FIND v(dout1_204) AT=2000.05n

.meas tran vdout1_205ck1990 FIND v(dout1_205) AT=2000.05n

.meas tran vdout1_206ck1990 FIND v(dout1_206) AT=2000.05n

.meas tran vdout1_207ck1990 FIND v(dout1_207) AT=2000.05n

.meas tran vdout1_208ck1990 FIND v(dout1_208) AT=2000.05n

.meas tran vdout1_209ck1990 FIND v(dout1_209) AT=2000.05n

.meas tran vdout1_210ck1990 FIND v(dout1_210) AT=2000.05n

.meas tran vdout1_211ck1990 FIND v(dout1_211) AT=2000.05n

.meas tran vdout1_212ck1990 FIND v(dout1_212) AT=2000.05n

.meas tran vdout1_213ck1990 FIND v(dout1_213) AT=2000.05n

.meas tran vdout1_214ck1990 FIND v(dout1_214) AT=2000.05n

.meas tran vdout1_215ck1990 FIND v(dout1_215) AT=2000.05n

.meas tran vdout1_216ck1990 FIND v(dout1_216) AT=2000.05n

.meas tran vdout1_217ck1990 FIND v(dout1_217) AT=2000.05n

.meas tran vdout1_218ck1990 FIND v(dout1_218) AT=2000.05n

.meas tran vdout1_219ck1990 FIND v(dout1_219) AT=2000.05n

.meas tran vdout1_220ck1990 FIND v(dout1_220) AT=2000.05n

.meas tran vdout1_221ck1990 FIND v(dout1_221) AT=2000.05n

.meas tran vdout1_222ck1990 FIND v(dout1_222) AT=2000.05n

.meas tran vdout1_223ck1990 FIND v(dout1_223) AT=2000.05n

.meas tran vdout1_224ck1990 FIND v(dout1_224) AT=2000.05n

.meas tran vdout1_225ck1990 FIND v(dout1_225) AT=2000.05n

.meas tran vdout1_226ck1990 FIND v(dout1_226) AT=2000.05n

.meas tran vdout1_227ck1990 FIND v(dout1_227) AT=2000.05n

.meas tran vdout1_228ck1990 FIND v(dout1_228) AT=2000.05n

.meas tran vdout1_229ck1990 FIND v(dout1_229) AT=2000.05n

.meas tran vdout1_230ck1990 FIND v(dout1_230) AT=2000.05n

.meas tran vdout1_231ck1990 FIND v(dout1_231) AT=2000.05n

.meas tran vdout1_232ck1990 FIND v(dout1_232) AT=2000.05n

.meas tran vdout1_233ck1990 FIND v(dout1_233) AT=2000.05n

.meas tran vdout1_234ck1990 FIND v(dout1_234) AT=2000.05n

.meas tran vdout1_235ck1990 FIND v(dout1_235) AT=2000.05n

.meas tran vdout1_236ck1990 FIND v(dout1_236) AT=2000.05n

.meas tran vdout1_237ck1990 FIND v(dout1_237) AT=2000.05n

.meas tran vdout1_238ck1990 FIND v(dout1_238) AT=2000.05n

.meas tran vdout1_239ck1990 FIND v(dout1_239) AT=2000.05n

.meas tran vdout1_240ck1990 FIND v(dout1_240) AT=2000.05n

.meas tran vdout1_241ck1990 FIND v(dout1_241) AT=2000.05n

.meas tran vdout1_242ck1990 FIND v(dout1_242) AT=2000.05n

.meas tran vdout1_243ck1990 FIND v(dout1_243) AT=2000.05n

.meas tran vdout1_244ck1990 FIND v(dout1_244) AT=2000.05n

.meas tran vdout1_245ck1990 FIND v(dout1_245) AT=2000.05n

.meas tran vdout1_246ck1990 FIND v(dout1_246) AT=2000.05n

.meas tran vdout1_247ck1990 FIND v(dout1_247) AT=2000.05n

.meas tran vdout1_248ck1990 FIND v(dout1_248) AT=2000.05n

.meas tran vdout1_249ck1990 FIND v(dout1_249) AT=2000.05n

.meas tran vdout1_250ck1990 FIND v(dout1_250) AT=2000.05n

.meas tran vdout1_251ck1990 FIND v(dout1_251) AT=2000.05n

.meas tran vdout1_252ck1990 FIND v(dout1_252) AT=2000.05n

.meas tran vdout1_253ck1990 FIND v(dout1_253) AT=2000.05n

.meas tran vdout1_254ck1990 FIND v(dout1_254) AT=2000.05n

.meas tran vdout1_255ck1990 FIND v(dout1_255) AT=2000.05n

.meas tran vdout1_256ck1990 FIND v(dout1_256) AT=2000.05n
