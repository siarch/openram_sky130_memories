.meas tran vdout0_0ck40 FIND v(dout0_0) AT=50.05n

.meas tran vdout0_1ck40 FIND v(dout0_1) AT=50.05n

.meas tran vdout0_2ck40 FIND v(dout0_2) AT=50.05n

.meas tran vdout0_3ck40 FIND v(dout0_3) AT=50.05n

.meas tran vdout0_4ck40 FIND v(dout0_4) AT=50.05n

.meas tran vdout0_5ck40 FIND v(dout0_5) AT=50.05n

.meas tran vdout0_6ck40 FIND v(dout0_6) AT=50.05n

.meas tran vdout0_7ck40 FIND v(dout0_7) AT=50.05n

.meas tran vdout0_8ck40 FIND v(dout0_8) AT=50.05n

.meas tran vdout0_9ck40 FIND v(dout0_9) AT=50.05n

.meas tran vdout0_10ck40 FIND v(dout0_10) AT=50.05n

.meas tran vdout0_11ck40 FIND v(dout0_11) AT=50.05n

.meas tran vdout0_12ck40 FIND v(dout0_12) AT=50.05n

.meas tran vdout0_13ck40 FIND v(dout0_13) AT=50.05n

.meas tran vdout0_14ck40 FIND v(dout0_14) AT=50.05n

.meas tran vdout0_15ck40 FIND v(dout0_15) AT=50.05n

.meas tran vdout0_16ck40 FIND v(dout0_16) AT=50.05n

.meas tran vdout0_17ck40 FIND v(dout0_17) AT=50.05n

.meas tran vdout0_18ck40 FIND v(dout0_18) AT=50.05n

.meas tran vdout0_19ck40 FIND v(dout0_19) AT=50.05n

.meas tran vdout0_20ck40 FIND v(dout0_20) AT=50.05n

.meas tran vdout0_21ck40 FIND v(dout0_21) AT=50.05n

.meas tran vdout0_22ck40 FIND v(dout0_22) AT=50.05n

.meas tran vdout0_23ck40 FIND v(dout0_23) AT=50.05n

.meas tran vdout0_24ck40 FIND v(dout0_24) AT=50.05n

.meas tran vdout0_25ck40 FIND v(dout0_25) AT=50.05n

.meas tran vdout0_26ck40 FIND v(dout0_26) AT=50.05n

.meas tran vdout0_27ck40 FIND v(dout0_27) AT=50.05n

.meas tran vdout0_28ck40 FIND v(dout0_28) AT=50.05n

.meas tran vdout0_29ck40 FIND v(dout0_29) AT=50.05n

.meas tran vdout0_30ck40 FIND v(dout0_30) AT=50.05n

.meas tran vdout0_31ck40 FIND v(dout0_31) AT=50.05n

.meas tran vdout0_32ck40 FIND v(dout0_32) AT=50.05n

.meas tran vdout0_0ck120 FIND v(dout0_0) AT=130.05n

.meas tran vdout0_1ck120 FIND v(dout0_1) AT=130.05n

.meas tran vdout0_2ck120 FIND v(dout0_2) AT=130.05n

.meas tran vdout0_3ck120 FIND v(dout0_3) AT=130.05n

.meas tran vdout0_4ck120 FIND v(dout0_4) AT=130.05n

.meas tran vdout0_5ck120 FIND v(dout0_5) AT=130.05n

.meas tran vdout0_6ck120 FIND v(dout0_6) AT=130.05n

.meas tran vdout0_7ck120 FIND v(dout0_7) AT=130.05n

.meas tran vdout0_8ck120 FIND v(dout0_8) AT=130.05n

.meas tran vdout0_9ck120 FIND v(dout0_9) AT=130.05n

.meas tran vdout0_10ck120 FIND v(dout0_10) AT=130.05n

.meas tran vdout0_11ck120 FIND v(dout0_11) AT=130.05n

.meas tran vdout0_12ck120 FIND v(dout0_12) AT=130.05n

.meas tran vdout0_13ck120 FIND v(dout0_13) AT=130.05n

.meas tran vdout0_14ck120 FIND v(dout0_14) AT=130.05n

.meas tran vdout0_15ck120 FIND v(dout0_15) AT=130.05n

.meas tran vdout0_16ck120 FIND v(dout0_16) AT=130.05n

.meas tran vdout0_17ck120 FIND v(dout0_17) AT=130.05n

.meas tran vdout0_18ck120 FIND v(dout0_18) AT=130.05n

.meas tran vdout0_19ck120 FIND v(dout0_19) AT=130.05n

.meas tran vdout0_20ck120 FIND v(dout0_20) AT=130.05n

.meas tran vdout0_21ck120 FIND v(dout0_21) AT=130.05n

.meas tran vdout0_22ck120 FIND v(dout0_22) AT=130.05n

.meas tran vdout0_23ck120 FIND v(dout0_23) AT=130.05n

.meas tran vdout0_24ck120 FIND v(dout0_24) AT=130.05n

.meas tran vdout0_25ck120 FIND v(dout0_25) AT=130.05n

.meas tran vdout0_26ck120 FIND v(dout0_26) AT=130.05n

.meas tran vdout0_27ck120 FIND v(dout0_27) AT=130.05n

.meas tran vdout0_28ck120 FIND v(dout0_28) AT=130.05n

.meas tran vdout0_29ck120 FIND v(dout0_29) AT=130.05n

.meas tran vdout0_30ck120 FIND v(dout0_30) AT=130.05n

.meas tran vdout0_31ck120 FIND v(dout0_31) AT=130.05n

.meas tran vdout0_32ck120 FIND v(dout0_32) AT=130.05n

.meas tran vdout0_0ck140 FIND v(dout0_0) AT=150.05n

.meas tran vdout0_1ck140 FIND v(dout0_1) AT=150.05n

.meas tran vdout0_2ck140 FIND v(dout0_2) AT=150.05n

.meas tran vdout0_3ck140 FIND v(dout0_3) AT=150.05n

.meas tran vdout0_4ck140 FIND v(dout0_4) AT=150.05n

.meas tran vdout0_5ck140 FIND v(dout0_5) AT=150.05n

.meas tran vdout0_6ck140 FIND v(dout0_6) AT=150.05n

.meas tran vdout0_7ck140 FIND v(dout0_7) AT=150.05n

.meas tran vdout0_8ck140 FIND v(dout0_8) AT=150.05n

.meas tran vdout0_9ck140 FIND v(dout0_9) AT=150.05n

.meas tran vdout0_10ck140 FIND v(dout0_10) AT=150.05n

.meas tran vdout0_11ck140 FIND v(dout0_11) AT=150.05n

.meas tran vdout0_12ck140 FIND v(dout0_12) AT=150.05n

.meas tran vdout0_13ck140 FIND v(dout0_13) AT=150.05n

.meas tran vdout0_14ck140 FIND v(dout0_14) AT=150.05n

.meas tran vdout0_15ck140 FIND v(dout0_15) AT=150.05n

.meas tran vdout0_16ck140 FIND v(dout0_16) AT=150.05n

.meas tran vdout0_17ck140 FIND v(dout0_17) AT=150.05n

.meas tran vdout0_18ck140 FIND v(dout0_18) AT=150.05n

.meas tran vdout0_19ck140 FIND v(dout0_19) AT=150.05n

.meas tran vdout0_20ck140 FIND v(dout0_20) AT=150.05n

.meas tran vdout0_21ck140 FIND v(dout0_21) AT=150.05n

.meas tran vdout0_22ck140 FIND v(dout0_22) AT=150.05n

.meas tran vdout0_23ck140 FIND v(dout0_23) AT=150.05n

.meas tran vdout0_24ck140 FIND v(dout0_24) AT=150.05n

.meas tran vdout0_25ck140 FIND v(dout0_25) AT=150.05n

.meas tran vdout0_26ck140 FIND v(dout0_26) AT=150.05n

.meas tran vdout0_27ck140 FIND v(dout0_27) AT=150.05n

.meas tran vdout0_28ck140 FIND v(dout0_28) AT=150.05n

.meas tran vdout0_29ck140 FIND v(dout0_29) AT=150.05n

.meas tran vdout0_30ck140 FIND v(dout0_30) AT=150.05n

.meas tran vdout0_31ck140 FIND v(dout0_31) AT=150.05n

.meas tran vdout0_32ck140 FIND v(dout0_32) AT=150.05n

.meas tran vdout0_0ck180 FIND v(dout0_0) AT=190.05n

.meas tran vdout0_1ck180 FIND v(dout0_1) AT=190.05n

.meas tran vdout0_2ck180 FIND v(dout0_2) AT=190.05n

.meas tran vdout0_3ck180 FIND v(dout0_3) AT=190.05n

.meas tran vdout0_4ck180 FIND v(dout0_4) AT=190.05n

.meas tran vdout0_5ck180 FIND v(dout0_5) AT=190.05n

.meas tran vdout0_6ck180 FIND v(dout0_6) AT=190.05n

.meas tran vdout0_7ck180 FIND v(dout0_7) AT=190.05n

.meas tran vdout0_8ck180 FIND v(dout0_8) AT=190.05n

.meas tran vdout0_9ck180 FIND v(dout0_9) AT=190.05n

.meas tran vdout0_10ck180 FIND v(dout0_10) AT=190.05n

.meas tran vdout0_11ck180 FIND v(dout0_11) AT=190.05n

.meas tran vdout0_12ck180 FIND v(dout0_12) AT=190.05n

.meas tran vdout0_13ck180 FIND v(dout0_13) AT=190.05n

.meas tran vdout0_14ck180 FIND v(dout0_14) AT=190.05n

.meas tran vdout0_15ck180 FIND v(dout0_15) AT=190.05n

.meas tran vdout0_16ck180 FIND v(dout0_16) AT=190.05n

.meas tran vdout0_17ck180 FIND v(dout0_17) AT=190.05n

.meas tran vdout0_18ck180 FIND v(dout0_18) AT=190.05n

.meas tran vdout0_19ck180 FIND v(dout0_19) AT=190.05n

.meas tran vdout0_20ck180 FIND v(dout0_20) AT=190.05n

.meas tran vdout0_21ck180 FIND v(dout0_21) AT=190.05n

.meas tran vdout0_22ck180 FIND v(dout0_22) AT=190.05n

.meas tran vdout0_23ck180 FIND v(dout0_23) AT=190.05n

.meas tran vdout0_24ck180 FIND v(dout0_24) AT=190.05n

.meas tran vdout0_25ck180 FIND v(dout0_25) AT=190.05n

.meas tran vdout0_26ck180 FIND v(dout0_26) AT=190.05n

.meas tran vdout0_27ck180 FIND v(dout0_27) AT=190.05n

.meas tran vdout0_28ck180 FIND v(dout0_28) AT=190.05n

.meas tran vdout0_29ck180 FIND v(dout0_29) AT=190.05n

.meas tran vdout0_30ck180 FIND v(dout0_30) AT=190.05n

.meas tran vdout0_31ck180 FIND v(dout0_31) AT=190.05n

.meas tran vdout0_32ck180 FIND v(dout0_32) AT=190.05n

.meas tran vdout0_0ck200 FIND v(dout0_0) AT=210.05n

.meas tran vdout0_1ck200 FIND v(dout0_1) AT=210.05n

.meas tran vdout0_2ck200 FIND v(dout0_2) AT=210.05n

.meas tran vdout0_3ck200 FIND v(dout0_3) AT=210.05n

.meas tran vdout0_4ck200 FIND v(dout0_4) AT=210.05n

.meas tran vdout0_5ck200 FIND v(dout0_5) AT=210.05n

.meas tran vdout0_6ck200 FIND v(dout0_6) AT=210.05n

.meas tran vdout0_7ck200 FIND v(dout0_7) AT=210.05n

.meas tran vdout0_8ck200 FIND v(dout0_8) AT=210.05n

.meas tran vdout0_9ck200 FIND v(dout0_9) AT=210.05n

.meas tran vdout0_10ck200 FIND v(dout0_10) AT=210.05n

.meas tran vdout0_11ck200 FIND v(dout0_11) AT=210.05n

.meas tran vdout0_12ck200 FIND v(dout0_12) AT=210.05n

.meas tran vdout0_13ck200 FIND v(dout0_13) AT=210.05n

.meas tran vdout0_14ck200 FIND v(dout0_14) AT=210.05n

.meas tran vdout0_15ck200 FIND v(dout0_15) AT=210.05n

.meas tran vdout0_16ck200 FIND v(dout0_16) AT=210.05n

.meas tran vdout0_17ck200 FIND v(dout0_17) AT=210.05n

.meas tran vdout0_18ck200 FIND v(dout0_18) AT=210.05n

.meas tran vdout0_19ck200 FIND v(dout0_19) AT=210.05n

.meas tran vdout0_20ck200 FIND v(dout0_20) AT=210.05n

.meas tran vdout0_21ck200 FIND v(dout0_21) AT=210.05n

.meas tran vdout0_22ck200 FIND v(dout0_22) AT=210.05n

.meas tran vdout0_23ck200 FIND v(dout0_23) AT=210.05n

.meas tran vdout0_24ck200 FIND v(dout0_24) AT=210.05n

.meas tran vdout0_25ck200 FIND v(dout0_25) AT=210.05n

.meas tran vdout0_26ck200 FIND v(dout0_26) AT=210.05n

.meas tran vdout0_27ck200 FIND v(dout0_27) AT=210.05n

.meas tran vdout0_28ck200 FIND v(dout0_28) AT=210.05n

.meas tran vdout0_29ck200 FIND v(dout0_29) AT=210.05n

.meas tran vdout0_30ck200 FIND v(dout0_30) AT=210.05n

.meas tran vdout0_31ck200 FIND v(dout0_31) AT=210.05n

.meas tran vdout0_32ck200 FIND v(dout0_32) AT=210.05n

.meas tran vdout0_0ck270 FIND v(dout0_0) AT=280.05n

.meas tran vdout0_1ck270 FIND v(dout0_1) AT=280.05n

.meas tran vdout0_2ck270 FIND v(dout0_2) AT=280.05n

.meas tran vdout0_3ck270 FIND v(dout0_3) AT=280.05n

.meas tran vdout0_4ck270 FIND v(dout0_4) AT=280.05n

.meas tran vdout0_5ck270 FIND v(dout0_5) AT=280.05n

.meas tran vdout0_6ck270 FIND v(dout0_6) AT=280.05n

.meas tran vdout0_7ck270 FIND v(dout0_7) AT=280.05n

.meas tran vdout0_8ck270 FIND v(dout0_8) AT=280.05n

.meas tran vdout0_9ck270 FIND v(dout0_9) AT=280.05n

.meas tran vdout0_10ck270 FIND v(dout0_10) AT=280.05n

.meas tran vdout0_11ck270 FIND v(dout0_11) AT=280.05n

.meas tran vdout0_12ck270 FIND v(dout0_12) AT=280.05n

.meas tran vdout0_13ck270 FIND v(dout0_13) AT=280.05n

.meas tran vdout0_14ck270 FIND v(dout0_14) AT=280.05n

.meas tran vdout0_15ck270 FIND v(dout0_15) AT=280.05n

.meas tran vdout0_16ck270 FIND v(dout0_16) AT=280.05n

.meas tran vdout0_17ck270 FIND v(dout0_17) AT=280.05n

.meas tran vdout0_18ck270 FIND v(dout0_18) AT=280.05n

.meas tran vdout0_19ck270 FIND v(dout0_19) AT=280.05n

.meas tran vdout0_20ck270 FIND v(dout0_20) AT=280.05n

.meas tran vdout0_21ck270 FIND v(dout0_21) AT=280.05n

.meas tran vdout0_22ck270 FIND v(dout0_22) AT=280.05n

.meas tran vdout0_23ck270 FIND v(dout0_23) AT=280.05n

.meas tran vdout0_24ck270 FIND v(dout0_24) AT=280.05n

.meas tran vdout0_25ck270 FIND v(dout0_25) AT=280.05n

.meas tran vdout0_26ck270 FIND v(dout0_26) AT=280.05n

.meas tran vdout0_27ck270 FIND v(dout0_27) AT=280.05n

.meas tran vdout0_28ck270 FIND v(dout0_28) AT=280.05n

.meas tran vdout0_29ck270 FIND v(dout0_29) AT=280.05n

.meas tran vdout0_30ck270 FIND v(dout0_30) AT=280.05n

.meas tran vdout0_31ck270 FIND v(dout0_31) AT=280.05n

.meas tran vdout0_32ck270 FIND v(dout0_32) AT=280.05n

.meas tran vdout0_0ck300 FIND v(dout0_0) AT=310.05n

.meas tran vdout0_1ck300 FIND v(dout0_1) AT=310.05n

.meas tran vdout0_2ck300 FIND v(dout0_2) AT=310.05n

.meas tran vdout0_3ck300 FIND v(dout0_3) AT=310.05n

.meas tran vdout0_4ck300 FIND v(dout0_4) AT=310.05n

.meas tran vdout0_5ck300 FIND v(dout0_5) AT=310.05n

.meas tran vdout0_6ck300 FIND v(dout0_6) AT=310.05n

.meas tran vdout0_7ck300 FIND v(dout0_7) AT=310.05n

.meas tran vdout0_8ck300 FIND v(dout0_8) AT=310.05n

.meas tran vdout0_9ck300 FIND v(dout0_9) AT=310.05n

.meas tran vdout0_10ck300 FIND v(dout0_10) AT=310.05n

.meas tran vdout0_11ck300 FIND v(dout0_11) AT=310.05n

.meas tran vdout0_12ck300 FIND v(dout0_12) AT=310.05n

.meas tran vdout0_13ck300 FIND v(dout0_13) AT=310.05n

.meas tran vdout0_14ck300 FIND v(dout0_14) AT=310.05n

.meas tran vdout0_15ck300 FIND v(dout0_15) AT=310.05n

.meas tran vdout0_16ck300 FIND v(dout0_16) AT=310.05n

.meas tran vdout0_17ck300 FIND v(dout0_17) AT=310.05n

.meas tran vdout0_18ck300 FIND v(dout0_18) AT=310.05n

.meas tran vdout0_19ck300 FIND v(dout0_19) AT=310.05n

.meas tran vdout0_20ck300 FIND v(dout0_20) AT=310.05n

.meas tran vdout0_21ck300 FIND v(dout0_21) AT=310.05n

.meas tran vdout0_22ck300 FIND v(dout0_22) AT=310.05n

.meas tran vdout0_23ck300 FIND v(dout0_23) AT=310.05n

.meas tran vdout0_24ck300 FIND v(dout0_24) AT=310.05n

.meas tran vdout0_25ck300 FIND v(dout0_25) AT=310.05n

.meas tran vdout0_26ck300 FIND v(dout0_26) AT=310.05n

.meas tran vdout0_27ck300 FIND v(dout0_27) AT=310.05n

.meas tran vdout0_28ck300 FIND v(dout0_28) AT=310.05n

.meas tran vdout0_29ck300 FIND v(dout0_29) AT=310.05n

.meas tran vdout0_30ck300 FIND v(dout0_30) AT=310.05n

.meas tran vdout0_31ck300 FIND v(dout0_31) AT=310.05n

.meas tran vdout0_32ck300 FIND v(dout0_32) AT=310.05n

.meas tran vdout0_0ck330 FIND v(dout0_0) AT=340.05n

.meas tran vdout0_1ck330 FIND v(dout0_1) AT=340.05n

.meas tran vdout0_2ck330 FIND v(dout0_2) AT=340.05n

.meas tran vdout0_3ck330 FIND v(dout0_3) AT=340.05n

.meas tran vdout0_4ck330 FIND v(dout0_4) AT=340.05n

.meas tran vdout0_5ck330 FIND v(dout0_5) AT=340.05n

.meas tran vdout0_6ck330 FIND v(dout0_6) AT=340.05n

.meas tran vdout0_7ck330 FIND v(dout0_7) AT=340.05n

.meas tran vdout0_8ck330 FIND v(dout0_8) AT=340.05n

.meas tran vdout0_9ck330 FIND v(dout0_9) AT=340.05n

.meas tran vdout0_10ck330 FIND v(dout0_10) AT=340.05n

.meas tran vdout0_11ck330 FIND v(dout0_11) AT=340.05n

.meas tran vdout0_12ck330 FIND v(dout0_12) AT=340.05n

.meas tran vdout0_13ck330 FIND v(dout0_13) AT=340.05n

.meas tran vdout0_14ck330 FIND v(dout0_14) AT=340.05n

.meas tran vdout0_15ck330 FIND v(dout0_15) AT=340.05n

.meas tran vdout0_16ck330 FIND v(dout0_16) AT=340.05n

.meas tran vdout0_17ck330 FIND v(dout0_17) AT=340.05n

.meas tran vdout0_18ck330 FIND v(dout0_18) AT=340.05n

.meas tran vdout0_19ck330 FIND v(dout0_19) AT=340.05n

.meas tran vdout0_20ck330 FIND v(dout0_20) AT=340.05n

.meas tran vdout0_21ck330 FIND v(dout0_21) AT=340.05n

.meas tran vdout0_22ck330 FIND v(dout0_22) AT=340.05n

.meas tran vdout0_23ck330 FIND v(dout0_23) AT=340.05n

.meas tran vdout0_24ck330 FIND v(dout0_24) AT=340.05n

.meas tran vdout0_25ck330 FIND v(dout0_25) AT=340.05n

.meas tran vdout0_26ck330 FIND v(dout0_26) AT=340.05n

.meas tran vdout0_27ck330 FIND v(dout0_27) AT=340.05n

.meas tran vdout0_28ck330 FIND v(dout0_28) AT=340.05n

.meas tran vdout0_29ck330 FIND v(dout0_29) AT=340.05n

.meas tran vdout0_30ck330 FIND v(dout0_30) AT=340.05n

.meas tran vdout0_31ck330 FIND v(dout0_31) AT=340.05n

.meas tran vdout0_32ck330 FIND v(dout0_32) AT=340.05n

.meas tran vdout0_0ck360 FIND v(dout0_0) AT=370.05n

.meas tran vdout0_1ck360 FIND v(dout0_1) AT=370.05n

.meas tran vdout0_2ck360 FIND v(dout0_2) AT=370.05n

.meas tran vdout0_3ck360 FIND v(dout0_3) AT=370.05n

.meas tran vdout0_4ck360 FIND v(dout0_4) AT=370.05n

.meas tran vdout0_5ck360 FIND v(dout0_5) AT=370.05n

.meas tran vdout0_6ck360 FIND v(dout0_6) AT=370.05n

.meas tran vdout0_7ck360 FIND v(dout0_7) AT=370.05n

.meas tran vdout0_8ck360 FIND v(dout0_8) AT=370.05n

.meas tran vdout0_9ck360 FIND v(dout0_9) AT=370.05n

.meas tran vdout0_10ck360 FIND v(dout0_10) AT=370.05n

.meas tran vdout0_11ck360 FIND v(dout0_11) AT=370.05n

.meas tran vdout0_12ck360 FIND v(dout0_12) AT=370.05n

.meas tran vdout0_13ck360 FIND v(dout0_13) AT=370.05n

.meas tran vdout0_14ck360 FIND v(dout0_14) AT=370.05n

.meas tran vdout0_15ck360 FIND v(dout0_15) AT=370.05n

.meas tran vdout0_16ck360 FIND v(dout0_16) AT=370.05n

.meas tran vdout0_17ck360 FIND v(dout0_17) AT=370.05n

.meas tran vdout0_18ck360 FIND v(dout0_18) AT=370.05n

.meas tran vdout0_19ck360 FIND v(dout0_19) AT=370.05n

.meas tran vdout0_20ck360 FIND v(dout0_20) AT=370.05n

.meas tran vdout0_21ck360 FIND v(dout0_21) AT=370.05n

.meas tran vdout0_22ck360 FIND v(dout0_22) AT=370.05n

.meas tran vdout0_23ck360 FIND v(dout0_23) AT=370.05n

.meas tran vdout0_24ck360 FIND v(dout0_24) AT=370.05n

.meas tran vdout0_25ck360 FIND v(dout0_25) AT=370.05n

.meas tran vdout0_26ck360 FIND v(dout0_26) AT=370.05n

.meas tran vdout0_27ck360 FIND v(dout0_27) AT=370.05n

.meas tran vdout0_28ck360 FIND v(dout0_28) AT=370.05n

.meas tran vdout0_29ck360 FIND v(dout0_29) AT=370.05n

.meas tran vdout0_30ck360 FIND v(dout0_30) AT=370.05n

.meas tran vdout0_31ck360 FIND v(dout0_31) AT=370.05n

.meas tran vdout0_32ck360 FIND v(dout0_32) AT=370.05n

.meas tran vdout0_0ck370 FIND v(dout0_0) AT=380.05n

.meas tran vdout0_1ck370 FIND v(dout0_1) AT=380.05n

.meas tran vdout0_2ck370 FIND v(dout0_2) AT=380.05n

.meas tran vdout0_3ck370 FIND v(dout0_3) AT=380.05n

.meas tran vdout0_4ck370 FIND v(dout0_4) AT=380.05n

.meas tran vdout0_5ck370 FIND v(dout0_5) AT=380.05n

.meas tran vdout0_6ck370 FIND v(dout0_6) AT=380.05n

.meas tran vdout0_7ck370 FIND v(dout0_7) AT=380.05n

.meas tran vdout0_8ck370 FIND v(dout0_8) AT=380.05n

.meas tran vdout0_9ck370 FIND v(dout0_9) AT=380.05n

.meas tran vdout0_10ck370 FIND v(dout0_10) AT=380.05n

.meas tran vdout0_11ck370 FIND v(dout0_11) AT=380.05n

.meas tran vdout0_12ck370 FIND v(dout0_12) AT=380.05n

.meas tran vdout0_13ck370 FIND v(dout0_13) AT=380.05n

.meas tran vdout0_14ck370 FIND v(dout0_14) AT=380.05n

.meas tran vdout0_15ck370 FIND v(dout0_15) AT=380.05n

.meas tran vdout0_16ck370 FIND v(dout0_16) AT=380.05n

.meas tran vdout0_17ck370 FIND v(dout0_17) AT=380.05n

.meas tran vdout0_18ck370 FIND v(dout0_18) AT=380.05n

.meas tran vdout0_19ck370 FIND v(dout0_19) AT=380.05n

.meas tran vdout0_20ck370 FIND v(dout0_20) AT=380.05n

.meas tran vdout0_21ck370 FIND v(dout0_21) AT=380.05n

.meas tran vdout0_22ck370 FIND v(dout0_22) AT=380.05n

.meas tran vdout0_23ck370 FIND v(dout0_23) AT=380.05n

.meas tran vdout0_24ck370 FIND v(dout0_24) AT=380.05n

.meas tran vdout0_25ck370 FIND v(dout0_25) AT=380.05n

.meas tran vdout0_26ck370 FIND v(dout0_26) AT=380.05n

.meas tran vdout0_27ck370 FIND v(dout0_27) AT=380.05n

.meas tran vdout0_28ck370 FIND v(dout0_28) AT=380.05n

.meas tran vdout0_29ck370 FIND v(dout0_29) AT=380.05n

.meas tran vdout0_30ck370 FIND v(dout0_30) AT=380.05n

.meas tran vdout0_31ck370 FIND v(dout0_31) AT=380.05n

.meas tran vdout0_32ck370 FIND v(dout0_32) AT=380.05n

.meas tran vdout0_0ck390 FIND v(dout0_0) AT=400.05n

.meas tran vdout0_1ck390 FIND v(dout0_1) AT=400.05n

.meas tran vdout0_2ck390 FIND v(dout0_2) AT=400.05n

.meas tran vdout0_3ck390 FIND v(dout0_3) AT=400.05n

.meas tran vdout0_4ck390 FIND v(dout0_4) AT=400.05n

.meas tran vdout0_5ck390 FIND v(dout0_5) AT=400.05n

.meas tran vdout0_6ck390 FIND v(dout0_6) AT=400.05n

.meas tran vdout0_7ck390 FIND v(dout0_7) AT=400.05n

.meas tran vdout0_8ck390 FIND v(dout0_8) AT=400.05n

.meas tran vdout0_9ck390 FIND v(dout0_9) AT=400.05n

.meas tran vdout0_10ck390 FIND v(dout0_10) AT=400.05n

.meas tran vdout0_11ck390 FIND v(dout0_11) AT=400.05n

.meas tran vdout0_12ck390 FIND v(dout0_12) AT=400.05n

.meas tran vdout0_13ck390 FIND v(dout0_13) AT=400.05n

.meas tran vdout0_14ck390 FIND v(dout0_14) AT=400.05n

.meas tran vdout0_15ck390 FIND v(dout0_15) AT=400.05n

.meas tran vdout0_16ck390 FIND v(dout0_16) AT=400.05n

.meas tran vdout0_17ck390 FIND v(dout0_17) AT=400.05n

.meas tran vdout0_18ck390 FIND v(dout0_18) AT=400.05n

.meas tran vdout0_19ck390 FIND v(dout0_19) AT=400.05n

.meas tran vdout0_20ck390 FIND v(dout0_20) AT=400.05n

.meas tran vdout0_21ck390 FIND v(dout0_21) AT=400.05n

.meas tran vdout0_22ck390 FIND v(dout0_22) AT=400.05n

.meas tran vdout0_23ck390 FIND v(dout0_23) AT=400.05n

.meas tran vdout0_24ck390 FIND v(dout0_24) AT=400.05n

.meas tran vdout0_25ck390 FIND v(dout0_25) AT=400.05n

.meas tran vdout0_26ck390 FIND v(dout0_26) AT=400.05n

.meas tran vdout0_27ck390 FIND v(dout0_27) AT=400.05n

.meas tran vdout0_28ck390 FIND v(dout0_28) AT=400.05n

.meas tran vdout0_29ck390 FIND v(dout0_29) AT=400.05n

.meas tran vdout0_30ck390 FIND v(dout0_30) AT=400.05n

.meas tran vdout0_31ck390 FIND v(dout0_31) AT=400.05n

.meas tran vdout0_32ck390 FIND v(dout0_32) AT=400.05n

.meas tran vdout0_0ck400 FIND v(dout0_0) AT=410.05n

.meas tran vdout0_1ck400 FIND v(dout0_1) AT=410.05n

.meas tran vdout0_2ck400 FIND v(dout0_2) AT=410.05n

.meas tran vdout0_3ck400 FIND v(dout0_3) AT=410.05n

.meas tran vdout0_4ck400 FIND v(dout0_4) AT=410.05n

.meas tran vdout0_5ck400 FIND v(dout0_5) AT=410.05n

.meas tran vdout0_6ck400 FIND v(dout0_6) AT=410.05n

.meas tran vdout0_7ck400 FIND v(dout0_7) AT=410.05n

.meas tran vdout0_8ck400 FIND v(dout0_8) AT=410.05n

.meas tran vdout0_9ck400 FIND v(dout0_9) AT=410.05n

.meas tran vdout0_10ck400 FIND v(dout0_10) AT=410.05n

.meas tran vdout0_11ck400 FIND v(dout0_11) AT=410.05n

.meas tran vdout0_12ck400 FIND v(dout0_12) AT=410.05n

.meas tran vdout0_13ck400 FIND v(dout0_13) AT=410.05n

.meas tran vdout0_14ck400 FIND v(dout0_14) AT=410.05n

.meas tran vdout0_15ck400 FIND v(dout0_15) AT=410.05n

.meas tran vdout0_16ck400 FIND v(dout0_16) AT=410.05n

.meas tran vdout0_17ck400 FIND v(dout0_17) AT=410.05n

.meas tran vdout0_18ck400 FIND v(dout0_18) AT=410.05n

.meas tran vdout0_19ck400 FIND v(dout0_19) AT=410.05n

.meas tran vdout0_20ck400 FIND v(dout0_20) AT=410.05n

.meas tran vdout0_21ck400 FIND v(dout0_21) AT=410.05n

.meas tran vdout0_22ck400 FIND v(dout0_22) AT=410.05n

.meas tran vdout0_23ck400 FIND v(dout0_23) AT=410.05n

.meas tran vdout0_24ck400 FIND v(dout0_24) AT=410.05n

.meas tran vdout0_25ck400 FIND v(dout0_25) AT=410.05n

.meas tran vdout0_26ck400 FIND v(dout0_26) AT=410.05n

.meas tran vdout0_27ck400 FIND v(dout0_27) AT=410.05n

.meas tran vdout0_28ck400 FIND v(dout0_28) AT=410.05n

.meas tran vdout0_29ck400 FIND v(dout0_29) AT=410.05n

.meas tran vdout0_30ck400 FIND v(dout0_30) AT=410.05n

.meas tran vdout0_31ck400 FIND v(dout0_31) AT=410.05n

.meas tran vdout0_32ck400 FIND v(dout0_32) AT=410.05n

.meas tran vdout0_0ck410 FIND v(dout0_0) AT=420.05n

.meas tran vdout0_1ck410 FIND v(dout0_1) AT=420.05n

.meas tran vdout0_2ck410 FIND v(dout0_2) AT=420.05n

.meas tran vdout0_3ck410 FIND v(dout0_3) AT=420.05n

.meas tran vdout0_4ck410 FIND v(dout0_4) AT=420.05n

.meas tran vdout0_5ck410 FIND v(dout0_5) AT=420.05n

.meas tran vdout0_6ck410 FIND v(dout0_6) AT=420.05n

.meas tran vdout0_7ck410 FIND v(dout0_7) AT=420.05n

.meas tran vdout0_8ck410 FIND v(dout0_8) AT=420.05n

.meas tran vdout0_9ck410 FIND v(dout0_9) AT=420.05n

.meas tran vdout0_10ck410 FIND v(dout0_10) AT=420.05n

.meas tran vdout0_11ck410 FIND v(dout0_11) AT=420.05n

.meas tran vdout0_12ck410 FIND v(dout0_12) AT=420.05n

.meas tran vdout0_13ck410 FIND v(dout0_13) AT=420.05n

.meas tran vdout0_14ck410 FIND v(dout0_14) AT=420.05n

.meas tran vdout0_15ck410 FIND v(dout0_15) AT=420.05n

.meas tran vdout0_16ck410 FIND v(dout0_16) AT=420.05n

.meas tran vdout0_17ck410 FIND v(dout0_17) AT=420.05n

.meas tran vdout0_18ck410 FIND v(dout0_18) AT=420.05n

.meas tran vdout0_19ck410 FIND v(dout0_19) AT=420.05n

.meas tran vdout0_20ck410 FIND v(dout0_20) AT=420.05n

.meas tran vdout0_21ck410 FIND v(dout0_21) AT=420.05n

.meas tran vdout0_22ck410 FIND v(dout0_22) AT=420.05n

.meas tran vdout0_23ck410 FIND v(dout0_23) AT=420.05n

.meas tran vdout0_24ck410 FIND v(dout0_24) AT=420.05n

.meas tran vdout0_25ck410 FIND v(dout0_25) AT=420.05n

.meas tran vdout0_26ck410 FIND v(dout0_26) AT=420.05n

.meas tran vdout0_27ck410 FIND v(dout0_27) AT=420.05n

.meas tran vdout0_28ck410 FIND v(dout0_28) AT=420.05n

.meas tran vdout0_29ck410 FIND v(dout0_29) AT=420.05n

.meas tran vdout0_30ck410 FIND v(dout0_30) AT=420.05n

.meas tran vdout0_31ck410 FIND v(dout0_31) AT=420.05n

.meas tran vdout0_32ck410 FIND v(dout0_32) AT=420.05n

.meas tran vdout0_0ck460 FIND v(dout0_0) AT=470.05n

.meas tran vdout0_1ck460 FIND v(dout0_1) AT=470.05n

.meas tran vdout0_2ck460 FIND v(dout0_2) AT=470.05n

.meas tran vdout0_3ck460 FIND v(dout0_3) AT=470.05n

.meas tran vdout0_4ck460 FIND v(dout0_4) AT=470.05n

.meas tran vdout0_5ck460 FIND v(dout0_5) AT=470.05n

.meas tran vdout0_6ck460 FIND v(dout0_6) AT=470.05n

.meas tran vdout0_7ck460 FIND v(dout0_7) AT=470.05n

.meas tran vdout0_8ck460 FIND v(dout0_8) AT=470.05n

.meas tran vdout0_9ck460 FIND v(dout0_9) AT=470.05n

.meas tran vdout0_10ck460 FIND v(dout0_10) AT=470.05n

.meas tran vdout0_11ck460 FIND v(dout0_11) AT=470.05n

.meas tran vdout0_12ck460 FIND v(dout0_12) AT=470.05n

.meas tran vdout0_13ck460 FIND v(dout0_13) AT=470.05n

.meas tran vdout0_14ck460 FIND v(dout0_14) AT=470.05n

.meas tran vdout0_15ck460 FIND v(dout0_15) AT=470.05n

.meas tran vdout0_16ck460 FIND v(dout0_16) AT=470.05n

.meas tran vdout0_17ck460 FIND v(dout0_17) AT=470.05n

.meas tran vdout0_18ck460 FIND v(dout0_18) AT=470.05n

.meas tran vdout0_19ck460 FIND v(dout0_19) AT=470.05n

.meas tran vdout0_20ck460 FIND v(dout0_20) AT=470.05n

.meas tran vdout0_21ck460 FIND v(dout0_21) AT=470.05n

.meas tran vdout0_22ck460 FIND v(dout0_22) AT=470.05n

.meas tran vdout0_23ck460 FIND v(dout0_23) AT=470.05n

.meas tran vdout0_24ck460 FIND v(dout0_24) AT=470.05n

.meas tran vdout0_25ck460 FIND v(dout0_25) AT=470.05n

.meas tran vdout0_26ck460 FIND v(dout0_26) AT=470.05n

.meas tran vdout0_27ck460 FIND v(dout0_27) AT=470.05n

.meas tran vdout0_28ck460 FIND v(dout0_28) AT=470.05n

.meas tran vdout0_29ck460 FIND v(dout0_29) AT=470.05n

.meas tran vdout0_30ck460 FIND v(dout0_30) AT=470.05n

.meas tran vdout0_31ck460 FIND v(dout0_31) AT=470.05n

.meas tran vdout0_32ck460 FIND v(dout0_32) AT=470.05n

.meas tran vdout0_0ck470 FIND v(dout0_0) AT=480.05n

.meas tran vdout0_1ck470 FIND v(dout0_1) AT=480.05n

.meas tran vdout0_2ck470 FIND v(dout0_2) AT=480.05n

.meas tran vdout0_3ck470 FIND v(dout0_3) AT=480.05n

.meas tran vdout0_4ck470 FIND v(dout0_4) AT=480.05n

.meas tran vdout0_5ck470 FIND v(dout0_5) AT=480.05n

.meas tran vdout0_6ck470 FIND v(dout0_6) AT=480.05n

.meas tran vdout0_7ck470 FIND v(dout0_7) AT=480.05n

.meas tran vdout0_8ck470 FIND v(dout0_8) AT=480.05n

.meas tran vdout0_9ck470 FIND v(dout0_9) AT=480.05n

.meas tran vdout0_10ck470 FIND v(dout0_10) AT=480.05n

.meas tran vdout0_11ck470 FIND v(dout0_11) AT=480.05n

.meas tran vdout0_12ck470 FIND v(dout0_12) AT=480.05n

.meas tran vdout0_13ck470 FIND v(dout0_13) AT=480.05n

.meas tran vdout0_14ck470 FIND v(dout0_14) AT=480.05n

.meas tran vdout0_15ck470 FIND v(dout0_15) AT=480.05n

.meas tran vdout0_16ck470 FIND v(dout0_16) AT=480.05n

.meas tran vdout0_17ck470 FIND v(dout0_17) AT=480.05n

.meas tran vdout0_18ck470 FIND v(dout0_18) AT=480.05n

.meas tran vdout0_19ck470 FIND v(dout0_19) AT=480.05n

.meas tran vdout0_20ck470 FIND v(dout0_20) AT=480.05n

.meas tran vdout0_21ck470 FIND v(dout0_21) AT=480.05n

.meas tran vdout0_22ck470 FIND v(dout0_22) AT=480.05n

.meas tran vdout0_23ck470 FIND v(dout0_23) AT=480.05n

.meas tran vdout0_24ck470 FIND v(dout0_24) AT=480.05n

.meas tran vdout0_25ck470 FIND v(dout0_25) AT=480.05n

.meas tran vdout0_26ck470 FIND v(dout0_26) AT=480.05n

.meas tran vdout0_27ck470 FIND v(dout0_27) AT=480.05n

.meas tran vdout0_28ck470 FIND v(dout0_28) AT=480.05n

.meas tran vdout0_29ck470 FIND v(dout0_29) AT=480.05n

.meas tran vdout0_30ck470 FIND v(dout0_30) AT=480.05n

.meas tran vdout0_31ck470 FIND v(dout0_31) AT=480.05n

.meas tran vdout0_32ck470 FIND v(dout0_32) AT=480.05n

.meas tran vdout0_0ck480 FIND v(dout0_0) AT=490.05n

.meas tran vdout0_1ck480 FIND v(dout0_1) AT=490.05n

.meas tran vdout0_2ck480 FIND v(dout0_2) AT=490.05n

.meas tran vdout0_3ck480 FIND v(dout0_3) AT=490.05n

.meas tran vdout0_4ck480 FIND v(dout0_4) AT=490.05n

.meas tran vdout0_5ck480 FIND v(dout0_5) AT=490.05n

.meas tran vdout0_6ck480 FIND v(dout0_6) AT=490.05n

.meas tran vdout0_7ck480 FIND v(dout0_7) AT=490.05n

.meas tran vdout0_8ck480 FIND v(dout0_8) AT=490.05n

.meas tran vdout0_9ck480 FIND v(dout0_9) AT=490.05n

.meas tran vdout0_10ck480 FIND v(dout0_10) AT=490.05n

.meas tran vdout0_11ck480 FIND v(dout0_11) AT=490.05n

.meas tran vdout0_12ck480 FIND v(dout0_12) AT=490.05n

.meas tran vdout0_13ck480 FIND v(dout0_13) AT=490.05n

.meas tran vdout0_14ck480 FIND v(dout0_14) AT=490.05n

.meas tran vdout0_15ck480 FIND v(dout0_15) AT=490.05n

.meas tran vdout0_16ck480 FIND v(dout0_16) AT=490.05n

.meas tran vdout0_17ck480 FIND v(dout0_17) AT=490.05n

.meas tran vdout0_18ck480 FIND v(dout0_18) AT=490.05n

.meas tran vdout0_19ck480 FIND v(dout0_19) AT=490.05n

.meas tran vdout0_20ck480 FIND v(dout0_20) AT=490.05n

.meas tran vdout0_21ck480 FIND v(dout0_21) AT=490.05n

.meas tran vdout0_22ck480 FIND v(dout0_22) AT=490.05n

.meas tran vdout0_23ck480 FIND v(dout0_23) AT=490.05n

.meas tran vdout0_24ck480 FIND v(dout0_24) AT=490.05n

.meas tran vdout0_25ck480 FIND v(dout0_25) AT=490.05n

.meas tran vdout0_26ck480 FIND v(dout0_26) AT=490.05n

.meas tran vdout0_27ck480 FIND v(dout0_27) AT=490.05n

.meas tran vdout0_28ck480 FIND v(dout0_28) AT=490.05n

.meas tran vdout0_29ck480 FIND v(dout0_29) AT=490.05n

.meas tran vdout0_30ck480 FIND v(dout0_30) AT=490.05n

.meas tran vdout0_31ck480 FIND v(dout0_31) AT=490.05n

.meas tran vdout0_32ck480 FIND v(dout0_32) AT=490.05n

.meas tran vdout0_0ck540 FIND v(dout0_0) AT=550.05n

.meas tran vdout0_1ck540 FIND v(dout0_1) AT=550.05n

.meas tran vdout0_2ck540 FIND v(dout0_2) AT=550.05n

.meas tran vdout0_3ck540 FIND v(dout0_3) AT=550.05n

.meas tran vdout0_4ck540 FIND v(dout0_4) AT=550.05n

.meas tran vdout0_5ck540 FIND v(dout0_5) AT=550.05n

.meas tran vdout0_6ck540 FIND v(dout0_6) AT=550.05n

.meas tran vdout0_7ck540 FIND v(dout0_7) AT=550.05n

.meas tran vdout0_8ck540 FIND v(dout0_8) AT=550.05n

.meas tran vdout0_9ck540 FIND v(dout0_9) AT=550.05n

.meas tran vdout0_10ck540 FIND v(dout0_10) AT=550.05n

.meas tran vdout0_11ck540 FIND v(dout0_11) AT=550.05n

.meas tran vdout0_12ck540 FIND v(dout0_12) AT=550.05n

.meas tran vdout0_13ck540 FIND v(dout0_13) AT=550.05n

.meas tran vdout0_14ck540 FIND v(dout0_14) AT=550.05n

.meas tran vdout0_15ck540 FIND v(dout0_15) AT=550.05n

.meas tran vdout0_16ck540 FIND v(dout0_16) AT=550.05n

.meas tran vdout0_17ck540 FIND v(dout0_17) AT=550.05n

.meas tran vdout0_18ck540 FIND v(dout0_18) AT=550.05n

.meas tran vdout0_19ck540 FIND v(dout0_19) AT=550.05n

.meas tran vdout0_20ck540 FIND v(dout0_20) AT=550.05n

.meas tran vdout0_21ck540 FIND v(dout0_21) AT=550.05n

.meas tran vdout0_22ck540 FIND v(dout0_22) AT=550.05n

.meas tran vdout0_23ck540 FIND v(dout0_23) AT=550.05n

.meas tran vdout0_24ck540 FIND v(dout0_24) AT=550.05n

.meas tran vdout0_25ck540 FIND v(dout0_25) AT=550.05n

.meas tran vdout0_26ck540 FIND v(dout0_26) AT=550.05n

.meas tran vdout0_27ck540 FIND v(dout0_27) AT=550.05n

.meas tran vdout0_28ck540 FIND v(dout0_28) AT=550.05n

.meas tran vdout0_29ck540 FIND v(dout0_29) AT=550.05n

.meas tran vdout0_30ck540 FIND v(dout0_30) AT=550.05n

.meas tran vdout0_31ck540 FIND v(dout0_31) AT=550.05n

.meas tran vdout0_32ck540 FIND v(dout0_32) AT=550.05n

.meas tran vdout0_0ck560 FIND v(dout0_0) AT=570.05n

.meas tran vdout0_1ck560 FIND v(dout0_1) AT=570.05n

.meas tran vdout0_2ck560 FIND v(dout0_2) AT=570.05n

.meas tran vdout0_3ck560 FIND v(dout0_3) AT=570.05n

.meas tran vdout0_4ck560 FIND v(dout0_4) AT=570.05n

.meas tran vdout0_5ck560 FIND v(dout0_5) AT=570.05n

.meas tran vdout0_6ck560 FIND v(dout0_6) AT=570.05n

.meas tran vdout0_7ck560 FIND v(dout0_7) AT=570.05n

.meas tran vdout0_8ck560 FIND v(dout0_8) AT=570.05n

.meas tran vdout0_9ck560 FIND v(dout0_9) AT=570.05n

.meas tran vdout0_10ck560 FIND v(dout0_10) AT=570.05n

.meas tran vdout0_11ck560 FIND v(dout0_11) AT=570.05n

.meas tran vdout0_12ck560 FIND v(dout0_12) AT=570.05n

.meas tran vdout0_13ck560 FIND v(dout0_13) AT=570.05n

.meas tran vdout0_14ck560 FIND v(dout0_14) AT=570.05n

.meas tran vdout0_15ck560 FIND v(dout0_15) AT=570.05n

.meas tran vdout0_16ck560 FIND v(dout0_16) AT=570.05n

.meas tran vdout0_17ck560 FIND v(dout0_17) AT=570.05n

.meas tran vdout0_18ck560 FIND v(dout0_18) AT=570.05n

.meas tran vdout0_19ck560 FIND v(dout0_19) AT=570.05n

.meas tran vdout0_20ck560 FIND v(dout0_20) AT=570.05n

.meas tran vdout0_21ck560 FIND v(dout0_21) AT=570.05n

.meas tran vdout0_22ck560 FIND v(dout0_22) AT=570.05n

.meas tran vdout0_23ck560 FIND v(dout0_23) AT=570.05n

.meas tran vdout0_24ck560 FIND v(dout0_24) AT=570.05n

.meas tran vdout0_25ck560 FIND v(dout0_25) AT=570.05n

.meas tran vdout0_26ck560 FIND v(dout0_26) AT=570.05n

.meas tran vdout0_27ck560 FIND v(dout0_27) AT=570.05n

.meas tran vdout0_28ck560 FIND v(dout0_28) AT=570.05n

.meas tran vdout0_29ck560 FIND v(dout0_29) AT=570.05n

.meas tran vdout0_30ck560 FIND v(dout0_30) AT=570.05n

.meas tran vdout0_31ck560 FIND v(dout0_31) AT=570.05n

.meas tran vdout0_32ck560 FIND v(dout0_32) AT=570.05n

.meas tran vdout0_0ck600 FIND v(dout0_0) AT=610.05n

.meas tran vdout0_1ck600 FIND v(dout0_1) AT=610.05n

.meas tran vdout0_2ck600 FIND v(dout0_2) AT=610.05n

.meas tran vdout0_3ck600 FIND v(dout0_3) AT=610.05n

.meas tran vdout0_4ck600 FIND v(dout0_4) AT=610.05n

.meas tran vdout0_5ck600 FIND v(dout0_5) AT=610.05n

.meas tran vdout0_6ck600 FIND v(dout0_6) AT=610.05n

.meas tran vdout0_7ck600 FIND v(dout0_7) AT=610.05n

.meas tran vdout0_8ck600 FIND v(dout0_8) AT=610.05n

.meas tran vdout0_9ck600 FIND v(dout0_9) AT=610.05n

.meas tran vdout0_10ck600 FIND v(dout0_10) AT=610.05n

.meas tran vdout0_11ck600 FIND v(dout0_11) AT=610.05n

.meas tran vdout0_12ck600 FIND v(dout0_12) AT=610.05n

.meas tran vdout0_13ck600 FIND v(dout0_13) AT=610.05n

.meas tran vdout0_14ck600 FIND v(dout0_14) AT=610.05n

.meas tran vdout0_15ck600 FIND v(dout0_15) AT=610.05n

.meas tran vdout0_16ck600 FIND v(dout0_16) AT=610.05n

.meas tran vdout0_17ck600 FIND v(dout0_17) AT=610.05n

.meas tran vdout0_18ck600 FIND v(dout0_18) AT=610.05n

.meas tran vdout0_19ck600 FIND v(dout0_19) AT=610.05n

.meas tran vdout0_20ck600 FIND v(dout0_20) AT=610.05n

.meas tran vdout0_21ck600 FIND v(dout0_21) AT=610.05n

.meas tran vdout0_22ck600 FIND v(dout0_22) AT=610.05n

.meas tran vdout0_23ck600 FIND v(dout0_23) AT=610.05n

.meas tran vdout0_24ck600 FIND v(dout0_24) AT=610.05n

.meas tran vdout0_25ck600 FIND v(dout0_25) AT=610.05n

.meas tran vdout0_26ck600 FIND v(dout0_26) AT=610.05n

.meas tran vdout0_27ck600 FIND v(dout0_27) AT=610.05n

.meas tran vdout0_28ck600 FIND v(dout0_28) AT=610.05n

.meas tran vdout0_29ck600 FIND v(dout0_29) AT=610.05n

.meas tran vdout0_30ck600 FIND v(dout0_30) AT=610.05n

.meas tran vdout0_31ck600 FIND v(dout0_31) AT=610.05n

.meas tran vdout0_32ck600 FIND v(dout0_32) AT=610.05n

.meas tran vdout0_0ck690 FIND v(dout0_0) AT=700.05n

.meas tran vdout0_1ck690 FIND v(dout0_1) AT=700.05n

.meas tran vdout0_2ck690 FIND v(dout0_2) AT=700.05n

.meas tran vdout0_3ck690 FIND v(dout0_3) AT=700.05n

.meas tran vdout0_4ck690 FIND v(dout0_4) AT=700.05n

.meas tran vdout0_5ck690 FIND v(dout0_5) AT=700.05n

.meas tran vdout0_6ck690 FIND v(dout0_6) AT=700.05n

.meas tran vdout0_7ck690 FIND v(dout0_7) AT=700.05n

.meas tran vdout0_8ck690 FIND v(dout0_8) AT=700.05n

.meas tran vdout0_9ck690 FIND v(dout0_9) AT=700.05n

.meas tran vdout0_10ck690 FIND v(dout0_10) AT=700.05n

.meas tran vdout0_11ck690 FIND v(dout0_11) AT=700.05n

.meas tran vdout0_12ck690 FIND v(dout0_12) AT=700.05n

.meas tran vdout0_13ck690 FIND v(dout0_13) AT=700.05n

.meas tran vdout0_14ck690 FIND v(dout0_14) AT=700.05n

.meas tran vdout0_15ck690 FIND v(dout0_15) AT=700.05n

.meas tran vdout0_16ck690 FIND v(dout0_16) AT=700.05n

.meas tran vdout0_17ck690 FIND v(dout0_17) AT=700.05n

.meas tran vdout0_18ck690 FIND v(dout0_18) AT=700.05n

.meas tran vdout0_19ck690 FIND v(dout0_19) AT=700.05n

.meas tran vdout0_20ck690 FIND v(dout0_20) AT=700.05n

.meas tran vdout0_21ck690 FIND v(dout0_21) AT=700.05n

.meas tran vdout0_22ck690 FIND v(dout0_22) AT=700.05n

.meas tran vdout0_23ck690 FIND v(dout0_23) AT=700.05n

.meas tran vdout0_24ck690 FIND v(dout0_24) AT=700.05n

.meas tran vdout0_25ck690 FIND v(dout0_25) AT=700.05n

.meas tran vdout0_26ck690 FIND v(dout0_26) AT=700.05n

.meas tran vdout0_27ck690 FIND v(dout0_27) AT=700.05n

.meas tran vdout0_28ck690 FIND v(dout0_28) AT=700.05n

.meas tran vdout0_29ck690 FIND v(dout0_29) AT=700.05n

.meas tran vdout0_30ck690 FIND v(dout0_30) AT=700.05n

.meas tran vdout0_31ck690 FIND v(dout0_31) AT=700.05n

.meas tran vdout0_32ck690 FIND v(dout0_32) AT=700.05n

.meas tran vdout0_0ck740 FIND v(dout0_0) AT=750.05n

.meas tran vdout0_1ck740 FIND v(dout0_1) AT=750.05n

.meas tran vdout0_2ck740 FIND v(dout0_2) AT=750.05n

.meas tran vdout0_3ck740 FIND v(dout0_3) AT=750.05n

.meas tran vdout0_4ck740 FIND v(dout0_4) AT=750.05n

.meas tran vdout0_5ck740 FIND v(dout0_5) AT=750.05n

.meas tran vdout0_6ck740 FIND v(dout0_6) AT=750.05n

.meas tran vdout0_7ck740 FIND v(dout0_7) AT=750.05n

.meas tran vdout0_8ck740 FIND v(dout0_8) AT=750.05n

.meas tran vdout0_9ck740 FIND v(dout0_9) AT=750.05n

.meas tran vdout0_10ck740 FIND v(dout0_10) AT=750.05n

.meas tran vdout0_11ck740 FIND v(dout0_11) AT=750.05n

.meas tran vdout0_12ck740 FIND v(dout0_12) AT=750.05n

.meas tran vdout0_13ck740 FIND v(dout0_13) AT=750.05n

.meas tran vdout0_14ck740 FIND v(dout0_14) AT=750.05n

.meas tran vdout0_15ck740 FIND v(dout0_15) AT=750.05n

.meas tran vdout0_16ck740 FIND v(dout0_16) AT=750.05n

.meas tran vdout0_17ck740 FIND v(dout0_17) AT=750.05n

.meas tran vdout0_18ck740 FIND v(dout0_18) AT=750.05n

.meas tran vdout0_19ck740 FIND v(dout0_19) AT=750.05n

.meas tran vdout0_20ck740 FIND v(dout0_20) AT=750.05n

.meas tran vdout0_21ck740 FIND v(dout0_21) AT=750.05n

.meas tran vdout0_22ck740 FIND v(dout0_22) AT=750.05n

.meas tran vdout0_23ck740 FIND v(dout0_23) AT=750.05n

.meas tran vdout0_24ck740 FIND v(dout0_24) AT=750.05n

.meas tran vdout0_25ck740 FIND v(dout0_25) AT=750.05n

.meas tran vdout0_26ck740 FIND v(dout0_26) AT=750.05n

.meas tran vdout0_27ck740 FIND v(dout0_27) AT=750.05n

.meas tran vdout0_28ck740 FIND v(dout0_28) AT=750.05n

.meas tran vdout0_29ck740 FIND v(dout0_29) AT=750.05n

.meas tran vdout0_30ck740 FIND v(dout0_30) AT=750.05n

.meas tran vdout0_31ck740 FIND v(dout0_31) AT=750.05n

.meas tran vdout0_32ck740 FIND v(dout0_32) AT=750.05n

.meas tran vdout0_0ck750 FIND v(dout0_0) AT=760.05n

.meas tran vdout0_1ck750 FIND v(dout0_1) AT=760.05n

.meas tran vdout0_2ck750 FIND v(dout0_2) AT=760.05n

.meas tran vdout0_3ck750 FIND v(dout0_3) AT=760.05n

.meas tran vdout0_4ck750 FIND v(dout0_4) AT=760.05n

.meas tran vdout0_5ck750 FIND v(dout0_5) AT=760.05n

.meas tran vdout0_6ck750 FIND v(dout0_6) AT=760.05n

.meas tran vdout0_7ck750 FIND v(dout0_7) AT=760.05n

.meas tran vdout0_8ck750 FIND v(dout0_8) AT=760.05n

.meas tran vdout0_9ck750 FIND v(dout0_9) AT=760.05n

.meas tran vdout0_10ck750 FIND v(dout0_10) AT=760.05n

.meas tran vdout0_11ck750 FIND v(dout0_11) AT=760.05n

.meas tran vdout0_12ck750 FIND v(dout0_12) AT=760.05n

.meas tran vdout0_13ck750 FIND v(dout0_13) AT=760.05n

.meas tran vdout0_14ck750 FIND v(dout0_14) AT=760.05n

.meas tran vdout0_15ck750 FIND v(dout0_15) AT=760.05n

.meas tran vdout0_16ck750 FIND v(dout0_16) AT=760.05n

.meas tran vdout0_17ck750 FIND v(dout0_17) AT=760.05n

.meas tran vdout0_18ck750 FIND v(dout0_18) AT=760.05n

.meas tran vdout0_19ck750 FIND v(dout0_19) AT=760.05n

.meas tran vdout0_20ck750 FIND v(dout0_20) AT=760.05n

.meas tran vdout0_21ck750 FIND v(dout0_21) AT=760.05n

.meas tran vdout0_22ck750 FIND v(dout0_22) AT=760.05n

.meas tran vdout0_23ck750 FIND v(dout0_23) AT=760.05n

.meas tran vdout0_24ck750 FIND v(dout0_24) AT=760.05n

.meas tran vdout0_25ck750 FIND v(dout0_25) AT=760.05n

.meas tran vdout0_26ck750 FIND v(dout0_26) AT=760.05n

.meas tran vdout0_27ck750 FIND v(dout0_27) AT=760.05n

.meas tran vdout0_28ck750 FIND v(dout0_28) AT=760.05n

.meas tran vdout0_29ck750 FIND v(dout0_29) AT=760.05n

.meas tran vdout0_30ck750 FIND v(dout0_30) AT=760.05n

.meas tran vdout0_31ck750 FIND v(dout0_31) AT=760.05n

.meas tran vdout0_32ck750 FIND v(dout0_32) AT=760.05n

.meas tran vdout0_0ck790 FIND v(dout0_0) AT=800.05n

.meas tran vdout0_1ck790 FIND v(dout0_1) AT=800.05n

.meas tran vdout0_2ck790 FIND v(dout0_2) AT=800.05n

.meas tran vdout0_3ck790 FIND v(dout0_3) AT=800.05n

.meas tran vdout0_4ck790 FIND v(dout0_4) AT=800.05n

.meas tran vdout0_5ck790 FIND v(dout0_5) AT=800.05n

.meas tran vdout0_6ck790 FIND v(dout0_6) AT=800.05n

.meas tran vdout0_7ck790 FIND v(dout0_7) AT=800.05n

.meas tran vdout0_8ck790 FIND v(dout0_8) AT=800.05n

.meas tran vdout0_9ck790 FIND v(dout0_9) AT=800.05n

.meas tran vdout0_10ck790 FIND v(dout0_10) AT=800.05n

.meas tran vdout0_11ck790 FIND v(dout0_11) AT=800.05n

.meas tran vdout0_12ck790 FIND v(dout0_12) AT=800.05n

.meas tran vdout0_13ck790 FIND v(dout0_13) AT=800.05n

.meas tran vdout0_14ck790 FIND v(dout0_14) AT=800.05n

.meas tran vdout0_15ck790 FIND v(dout0_15) AT=800.05n

.meas tran vdout0_16ck790 FIND v(dout0_16) AT=800.05n

.meas tran vdout0_17ck790 FIND v(dout0_17) AT=800.05n

.meas tran vdout0_18ck790 FIND v(dout0_18) AT=800.05n

.meas tran vdout0_19ck790 FIND v(dout0_19) AT=800.05n

.meas tran vdout0_20ck790 FIND v(dout0_20) AT=800.05n

.meas tran vdout0_21ck790 FIND v(dout0_21) AT=800.05n

.meas tran vdout0_22ck790 FIND v(dout0_22) AT=800.05n

.meas tran vdout0_23ck790 FIND v(dout0_23) AT=800.05n

.meas tran vdout0_24ck790 FIND v(dout0_24) AT=800.05n

.meas tran vdout0_25ck790 FIND v(dout0_25) AT=800.05n

.meas tran vdout0_26ck790 FIND v(dout0_26) AT=800.05n

.meas tran vdout0_27ck790 FIND v(dout0_27) AT=800.05n

.meas tran vdout0_28ck790 FIND v(dout0_28) AT=800.05n

.meas tran vdout0_29ck790 FIND v(dout0_29) AT=800.05n

.meas tran vdout0_30ck790 FIND v(dout0_30) AT=800.05n

.meas tran vdout0_31ck790 FIND v(dout0_31) AT=800.05n

.meas tran vdout0_32ck790 FIND v(dout0_32) AT=800.05n

.meas tran vdout0_0ck820 FIND v(dout0_0) AT=830.05n

.meas tran vdout0_1ck820 FIND v(dout0_1) AT=830.05n

.meas tran vdout0_2ck820 FIND v(dout0_2) AT=830.05n

.meas tran vdout0_3ck820 FIND v(dout0_3) AT=830.05n

.meas tran vdout0_4ck820 FIND v(dout0_4) AT=830.05n

.meas tran vdout0_5ck820 FIND v(dout0_5) AT=830.05n

.meas tran vdout0_6ck820 FIND v(dout0_6) AT=830.05n

.meas tran vdout0_7ck820 FIND v(dout0_7) AT=830.05n

.meas tran vdout0_8ck820 FIND v(dout0_8) AT=830.05n

.meas tran vdout0_9ck820 FIND v(dout0_9) AT=830.05n

.meas tran vdout0_10ck820 FIND v(dout0_10) AT=830.05n

.meas tran vdout0_11ck820 FIND v(dout0_11) AT=830.05n

.meas tran vdout0_12ck820 FIND v(dout0_12) AT=830.05n

.meas tran vdout0_13ck820 FIND v(dout0_13) AT=830.05n

.meas tran vdout0_14ck820 FIND v(dout0_14) AT=830.05n

.meas tran vdout0_15ck820 FIND v(dout0_15) AT=830.05n

.meas tran vdout0_16ck820 FIND v(dout0_16) AT=830.05n

.meas tran vdout0_17ck820 FIND v(dout0_17) AT=830.05n

.meas tran vdout0_18ck820 FIND v(dout0_18) AT=830.05n

.meas tran vdout0_19ck820 FIND v(dout0_19) AT=830.05n

.meas tran vdout0_20ck820 FIND v(dout0_20) AT=830.05n

.meas tran vdout0_21ck820 FIND v(dout0_21) AT=830.05n

.meas tran vdout0_22ck820 FIND v(dout0_22) AT=830.05n

.meas tran vdout0_23ck820 FIND v(dout0_23) AT=830.05n

.meas tran vdout0_24ck820 FIND v(dout0_24) AT=830.05n

.meas tran vdout0_25ck820 FIND v(dout0_25) AT=830.05n

.meas tran vdout0_26ck820 FIND v(dout0_26) AT=830.05n

.meas tran vdout0_27ck820 FIND v(dout0_27) AT=830.05n

.meas tran vdout0_28ck820 FIND v(dout0_28) AT=830.05n

.meas tran vdout0_29ck820 FIND v(dout0_29) AT=830.05n

.meas tran vdout0_30ck820 FIND v(dout0_30) AT=830.05n

.meas tran vdout0_31ck820 FIND v(dout0_31) AT=830.05n

.meas tran vdout0_32ck820 FIND v(dout0_32) AT=830.05n

.meas tran vdout0_0ck840 FIND v(dout0_0) AT=850.05n

.meas tran vdout0_1ck840 FIND v(dout0_1) AT=850.05n

.meas tran vdout0_2ck840 FIND v(dout0_2) AT=850.05n

.meas tran vdout0_3ck840 FIND v(dout0_3) AT=850.05n

.meas tran vdout0_4ck840 FIND v(dout0_4) AT=850.05n

.meas tran vdout0_5ck840 FIND v(dout0_5) AT=850.05n

.meas tran vdout0_6ck840 FIND v(dout0_6) AT=850.05n

.meas tran vdout0_7ck840 FIND v(dout0_7) AT=850.05n

.meas tran vdout0_8ck840 FIND v(dout0_8) AT=850.05n

.meas tran vdout0_9ck840 FIND v(dout0_9) AT=850.05n

.meas tran vdout0_10ck840 FIND v(dout0_10) AT=850.05n

.meas tran vdout0_11ck840 FIND v(dout0_11) AT=850.05n

.meas tran vdout0_12ck840 FIND v(dout0_12) AT=850.05n

.meas tran vdout0_13ck840 FIND v(dout0_13) AT=850.05n

.meas tran vdout0_14ck840 FIND v(dout0_14) AT=850.05n

.meas tran vdout0_15ck840 FIND v(dout0_15) AT=850.05n

.meas tran vdout0_16ck840 FIND v(dout0_16) AT=850.05n

.meas tran vdout0_17ck840 FIND v(dout0_17) AT=850.05n

.meas tran vdout0_18ck840 FIND v(dout0_18) AT=850.05n

.meas tran vdout0_19ck840 FIND v(dout0_19) AT=850.05n

.meas tran vdout0_20ck840 FIND v(dout0_20) AT=850.05n

.meas tran vdout0_21ck840 FIND v(dout0_21) AT=850.05n

.meas tran vdout0_22ck840 FIND v(dout0_22) AT=850.05n

.meas tran vdout0_23ck840 FIND v(dout0_23) AT=850.05n

.meas tran vdout0_24ck840 FIND v(dout0_24) AT=850.05n

.meas tran vdout0_25ck840 FIND v(dout0_25) AT=850.05n

.meas tran vdout0_26ck840 FIND v(dout0_26) AT=850.05n

.meas tran vdout0_27ck840 FIND v(dout0_27) AT=850.05n

.meas tran vdout0_28ck840 FIND v(dout0_28) AT=850.05n

.meas tran vdout0_29ck840 FIND v(dout0_29) AT=850.05n

.meas tran vdout0_30ck840 FIND v(dout0_30) AT=850.05n

.meas tran vdout0_31ck840 FIND v(dout0_31) AT=850.05n

.meas tran vdout0_32ck840 FIND v(dout0_32) AT=850.05n

.meas tran vdout0_0ck890 FIND v(dout0_0) AT=900.05n

.meas tran vdout0_1ck890 FIND v(dout0_1) AT=900.05n

.meas tran vdout0_2ck890 FIND v(dout0_2) AT=900.05n

.meas tran vdout0_3ck890 FIND v(dout0_3) AT=900.05n

.meas tran vdout0_4ck890 FIND v(dout0_4) AT=900.05n

.meas tran vdout0_5ck890 FIND v(dout0_5) AT=900.05n

.meas tran vdout0_6ck890 FIND v(dout0_6) AT=900.05n

.meas tran vdout0_7ck890 FIND v(dout0_7) AT=900.05n

.meas tran vdout0_8ck890 FIND v(dout0_8) AT=900.05n

.meas tran vdout0_9ck890 FIND v(dout0_9) AT=900.05n

.meas tran vdout0_10ck890 FIND v(dout0_10) AT=900.05n

.meas tran vdout0_11ck890 FIND v(dout0_11) AT=900.05n

.meas tran vdout0_12ck890 FIND v(dout0_12) AT=900.05n

.meas tran vdout0_13ck890 FIND v(dout0_13) AT=900.05n

.meas tran vdout0_14ck890 FIND v(dout0_14) AT=900.05n

.meas tran vdout0_15ck890 FIND v(dout0_15) AT=900.05n

.meas tran vdout0_16ck890 FIND v(dout0_16) AT=900.05n

.meas tran vdout0_17ck890 FIND v(dout0_17) AT=900.05n

.meas tran vdout0_18ck890 FIND v(dout0_18) AT=900.05n

.meas tran vdout0_19ck890 FIND v(dout0_19) AT=900.05n

.meas tran vdout0_20ck890 FIND v(dout0_20) AT=900.05n

.meas tran vdout0_21ck890 FIND v(dout0_21) AT=900.05n

.meas tran vdout0_22ck890 FIND v(dout0_22) AT=900.05n

.meas tran vdout0_23ck890 FIND v(dout0_23) AT=900.05n

.meas tran vdout0_24ck890 FIND v(dout0_24) AT=900.05n

.meas tran vdout0_25ck890 FIND v(dout0_25) AT=900.05n

.meas tran vdout0_26ck890 FIND v(dout0_26) AT=900.05n

.meas tran vdout0_27ck890 FIND v(dout0_27) AT=900.05n

.meas tran vdout0_28ck890 FIND v(dout0_28) AT=900.05n

.meas tran vdout0_29ck890 FIND v(dout0_29) AT=900.05n

.meas tran vdout0_30ck890 FIND v(dout0_30) AT=900.05n

.meas tran vdout0_31ck890 FIND v(dout0_31) AT=900.05n

.meas tran vdout0_32ck890 FIND v(dout0_32) AT=900.05n

.meas tran vdout0_0ck900 FIND v(dout0_0) AT=910.05n

.meas tran vdout0_1ck900 FIND v(dout0_1) AT=910.05n

.meas tran vdout0_2ck900 FIND v(dout0_2) AT=910.05n

.meas tran vdout0_3ck900 FIND v(dout0_3) AT=910.05n

.meas tran vdout0_4ck900 FIND v(dout0_4) AT=910.05n

.meas tran vdout0_5ck900 FIND v(dout0_5) AT=910.05n

.meas tran vdout0_6ck900 FIND v(dout0_6) AT=910.05n

.meas tran vdout0_7ck900 FIND v(dout0_7) AT=910.05n

.meas tran vdout0_8ck900 FIND v(dout0_8) AT=910.05n

.meas tran vdout0_9ck900 FIND v(dout0_9) AT=910.05n

.meas tran vdout0_10ck900 FIND v(dout0_10) AT=910.05n

.meas tran vdout0_11ck900 FIND v(dout0_11) AT=910.05n

.meas tran vdout0_12ck900 FIND v(dout0_12) AT=910.05n

.meas tran vdout0_13ck900 FIND v(dout0_13) AT=910.05n

.meas tran vdout0_14ck900 FIND v(dout0_14) AT=910.05n

.meas tran vdout0_15ck900 FIND v(dout0_15) AT=910.05n

.meas tran vdout0_16ck900 FIND v(dout0_16) AT=910.05n

.meas tran vdout0_17ck900 FIND v(dout0_17) AT=910.05n

.meas tran vdout0_18ck900 FIND v(dout0_18) AT=910.05n

.meas tran vdout0_19ck900 FIND v(dout0_19) AT=910.05n

.meas tran vdout0_20ck900 FIND v(dout0_20) AT=910.05n

.meas tran vdout0_21ck900 FIND v(dout0_21) AT=910.05n

.meas tran vdout0_22ck900 FIND v(dout0_22) AT=910.05n

.meas tran vdout0_23ck900 FIND v(dout0_23) AT=910.05n

.meas tran vdout0_24ck900 FIND v(dout0_24) AT=910.05n

.meas tran vdout0_25ck900 FIND v(dout0_25) AT=910.05n

.meas tran vdout0_26ck900 FIND v(dout0_26) AT=910.05n

.meas tran vdout0_27ck900 FIND v(dout0_27) AT=910.05n

.meas tran vdout0_28ck900 FIND v(dout0_28) AT=910.05n

.meas tran vdout0_29ck900 FIND v(dout0_29) AT=910.05n

.meas tran vdout0_30ck900 FIND v(dout0_30) AT=910.05n

.meas tran vdout0_31ck900 FIND v(dout0_31) AT=910.05n

.meas tran vdout0_32ck900 FIND v(dout0_32) AT=910.05n

.meas tran vdout0_0ck950 FIND v(dout0_0) AT=960.05n

.meas tran vdout0_1ck950 FIND v(dout0_1) AT=960.05n

.meas tran vdout0_2ck950 FIND v(dout0_2) AT=960.05n

.meas tran vdout0_3ck950 FIND v(dout0_3) AT=960.05n

.meas tran vdout0_4ck950 FIND v(dout0_4) AT=960.05n

.meas tran vdout0_5ck950 FIND v(dout0_5) AT=960.05n

.meas tran vdout0_6ck950 FIND v(dout0_6) AT=960.05n

.meas tran vdout0_7ck950 FIND v(dout0_7) AT=960.05n

.meas tran vdout0_8ck950 FIND v(dout0_8) AT=960.05n

.meas tran vdout0_9ck950 FIND v(dout0_9) AT=960.05n

.meas tran vdout0_10ck950 FIND v(dout0_10) AT=960.05n

.meas tran vdout0_11ck950 FIND v(dout0_11) AT=960.05n

.meas tran vdout0_12ck950 FIND v(dout0_12) AT=960.05n

.meas tran vdout0_13ck950 FIND v(dout0_13) AT=960.05n

.meas tran vdout0_14ck950 FIND v(dout0_14) AT=960.05n

.meas tran vdout0_15ck950 FIND v(dout0_15) AT=960.05n

.meas tran vdout0_16ck950 FIND v(dout0_16) AT=960.05n

.meas tran vdout0_17ck950 FIND v(dout0_17) AT=960.05n

.meas tran vdout0_18ck950 FIND v(dout0_18) AT=960.05n

.meas tran vdout0_19ck950 FIND v(dout0_19) AT=960.05n

.meas tran vdout0_20ck950 FIND v(dout0_20) AT=960.05n

.meas tran vdout0_21ck950 FIND v(dout0_21) AT=960.05n

.meas tran vdout0_22ck950 FIND v(dout0_22) AT=960.05n

.meas tran vdout0_23ck950 FIND v(dout0_23) AT=960.05n

.meas tran vdout0_24ck950 FIND v(dout0_24) AT=960.05n

.meas tran vdout0_25ck950 FIND v(dout0_25) AT=960.05n

.meas tran vdout0_26ck950 FIND v(dout0_26) AT=960.05n

.meas tran vdout0_27ck950 FIND v(dout0_27) AT=960.05n

.meas tran vdout0_28ck950 FIND v(dout0_28) AT=960.05n

.meas tran vdout0_29ck950 FIND v(dout0_29) AT=960.05n

.meas tran vdout0_30ck950 FIND v(dout0_30) AT=960.05n

.meas tran vdout0_31ck950 FIND v(dout0_31) AT=960.05n

.meas tran vdout0_32ck950 FIND v(dout0_32) AT=960.05n

.meas tran vdout0_0ck1010 FIND v(dout0_0) AT=1020.05n

.meas tran vdout0_1ck1010 FIND v(dout0_1) AT=1020.05n

.meas tran vdout0_2ck1010 FIND v(dout0_2) AT=1020.05n

.meas tran vdout0_3ck1010 FIND v(dout0_3) AT=1020.05n

.meas tran vdout0_4ck1010 FIND v(dout0_4) AT=1020.05n

.meas tran vdout0_5ck1010 FIND v(dout0_5) AT=1020.05n

.meas tran vdout0_6ck1010 FIND v(dout0_6) AT=1020.05n

.meas tran vdout0_7ck1010 FIND v(dout0_7) AT=1020.05n

.meas tran vdout0_8ck1010 FIND v(dout0_8) AT=1020.05n

.meas tran vdout0_9ck1010 FIND v(dout0_9) AT=1020.05n

.meas tran vdout0_10ck1010 FIND v(dout0_10) AT=1020.05n

.meas tran vdout0_11ck1010 FIND v(dout0_11) AT=1020.05n

.meas tran vdout0_12ck1010 FIND v(dout0_12) AT=1020.05n

.meas tran vdout0_13ck1010 FIND v(dout0_13) AT=1020.05n

.meas tran vdout0_14ck1010 FIND v(dout0_14) AT=1020.05n

.meas tran vdout0_15ck1010 FIND v(dout0_15) AT=1020.05n

.meas tran vdout0_16ck1010 FIND v(dout0_16) AT=1020.05n

.meas tran vdout0_17ck1010 FIND v(dout0_17) AT=1020.05n

.meas tran vdout0_18ck1010 FIND v(dout0_18) AT=1020.05n

.meas tran vdout0_19ck1010 FIND v(dout0_19) AT=1020.05n

.meas tran vdout0_20ck1010 FIND v(dout0_20) AT=1020.05n

.meas tran vdout0_21ck1010 FIND v(dout0_21) AT=1020.05n

.meas tran vdout0_22ck1010 FIND v(dout0_22) AT=1020.05n

.meas tran vdout0_23ck1010 FIND v(dout0_23) AT=1020.05n

.meas tran vdout0_24ck1010 FIND v(dout0_24) AT=1020.05n

.meas tran vdout0_25ck1010 FIND v(dout0_25) AT=1020.05n

.meas tran vdout0_26ck1010 FIND v(dout0_26) AT=1020.05n

.meas tran vdout0_27ck1010 FIND v(dout0_27) AT=1020.05n

.meas tran vdout0_28ck1010 FIND v(dout0_28) AT=1020.05n

.meas tran vdout0_29ck1010 FIND v(dout0_29) AT=1020.05n

.meas tran vdout0_30ck1010 FIND v(dout0_30) AT=1020.05n

.meas tran vdout0_31ck1010 FIND v(dout0_31) AT=1020.05n

.meas tran vdout0_32ck1010 FIND v(dout0_32) AT=1020.05n

.meas tran vdout0_0ck1030 FIND v(dout0_0) AT=1040.05n

.meas tran vdout0_1ck1030 FIND v(dout0_1) AT=1040.05n

.meas tran vdout0_2ck1030 FIND v(dout0_2) AT=1040.05n

.meas tran vdout0_3ck1030 FIND v(dout0_3) AT=1040.05n

.meas tran vdout0_4ck1030 FIND v(dout0_4) AT=1040.05n

.meas tran vdout0_5ck1030 FIND v(dout0_5) AT=1040.05n

.meas tran vdout0_6ck1030 FIND v(dout0_6) AT=1040.05n

.meas tran vdout0_7ck1030 FIND v(dout0_7) AT=1040.05n

.meas tran vdout0_8ck1030 FIND v(dout0_8) AT=1040.05n

.meas tran vdout0_9ck1030 FIND v(dout0_9) AT=1040.05n

.meas tran vdout0_10ck1030 FIND v(dout0_10) AT=1040.05n

.meas tran vdout0_11ck1030 FIND v(dout0_11) AT=1040.05n

.meas tran vdout0_12ck1030 FIND v(dout0_12) AT=1040.05n

.meas tran vdout0_13ck1030 FIND v(dout0_13) AT=1040.05n

.meas tran vdout0_14ck1030 FIND v(dout0_14) AT=1040.05n

.meas tran vdout0_15ck1030 FIND v(dout0_15) AT=1040.05n

.meas tran vdout0_16ck1030 FIND v(dout0_16) AT=1040.05n

.meas tran vdout0_17ck1030 FIND v(dout0_17) AT=1040.05n

.meas tran vdout0_18ck1030 FIND v(dout0_18) AT=1040.05n

.meas tran vdout0_19ck1030 FIND v(dout0_19) AT=1040.05n

.meas tran vdout0_20ck1030 FIND v(dout0_20) AT=1040.05n

.meas tran vdout0_21ck1030 FIND v(dout0_21) AT=1040.05n

.meas tran vdout0_22ck1030 FIND v(dout0_22) AT=1040.05n

.meas tran vdout0_23ck1030 FIND v(dout0_23) AT=1040.05n

.meas tran vdout0_24ck1030 FIND v(dout0_24) AT=1040.05n

.meas tran vdout0_25ck1030 FIND v(dout0_25) AT=1040.05n

.meas tran vdout0_26ck1030 FIND v(dout0_26) AT=1040.05n

.meas tran vdout0_27ck1030 FIND v(dout0_27) AT=1040.05n

.meas tran vdout0_28ck1030 FIND v(dout0_28) AT=1040.05n

.meas tran vdout0_29ck1030 FIND v(dout0_29) AT=1040.05n

.meas tran vdout0_30ck1030 FIND v(dout0_30) AT=1040.05n

.meas tran vdout0_31ck1030 FIND v(dout0_31) AT=1040.05n

.meas tran vdout0_32ck1030 FIND v(dout0_32) AT=1040.05n

.meas tran vdout0_0ck1040 FIND v(dout0_0) AT=1050.05n

.meas tran vdout0_1ck1040 FIND v(dout0_1) AT=1050.05n

.meas tran vdout0_2ck1040 FIND v(dout0_2) AT=1050.05n

.meas tran vdout0_3ck1040 FIND v(dout0_3) AT=1050.05n

.meas tran vdout0_4ck1040 FIND v(dout0_4) AT=1050.05n

.meas tran vdout0_5ck1040 FIND v(dout0_5) AT=1050.05n

.meas tran vdout0_6ck1040 FIND v(dout0_6) AT=1050.05n

.meas tran vdout0_7ck1040 FIND v(dout0_7) AT=1050.05n

.meas tran vdout0_8ck1040 FIND v(dout0_8) AT=1050.05n

.meas tran vdout0_9ck1040 FIND v(dout0_9) AT=1050.05n

.meas tran vdout0_10ck1040 FIND v(dout0_10) AT=1050.05n

.meas tran vdout0_11ck1040 FIND v(dout0_11) AT=1050.05n

.meas tran vdout0_12ck1040 FIND v(dout0_12) AT=1050.05n

.meas tran vdout0_13ck1040 FIND v(dout0_13) AT=1050.05n

.meas tran vdout0_14ck1040 FIND v(dout0_14) AT=1050.05n

.meas tran vdout0_15ck1040 FIND v(dout0_15) AT=1050.05n

.meas tran vdout0_16ck1040 FIND v(dout0_16) AT=1050.05n

.meas tran vdout0_17ck1040 FIND v(dout0_17) AT=1050.05n

.meas tran vdout0_18ck1040 FIND v(dout0_18) AT=1050.05n

.meas tran vdout0_19ck1040 FIND v(dout0_19) AT=1050.05n

.meas tran vdout0_20ck1040 FIND v(dout0_20) AT=1050.05n

.meas tran vdout0_21ck1040 FIND v(dout0_21) AT=1050.05n

.meas tran vdout0_22ck1040 FIND v(dout0_22) AT=1050.05n

.meas tran vdout0_23ck1040 FIND v(dout0_23) AT=1050.05n

.meas tran vdout0_24ck1040 FIND v(dout0_24) AT=1050.05n

.meas tran vdout0_25ck1040 FIND v(dout0_25) AT=1050.05n

.meas tran vdout0_26ck1040 FIND v(dout0_26) AT=1050.05n

.meas tran vdout0_27ck1040 FIND v(dout0_27) AT=1050.05n

.meas tran vdout0_28ck1040 FIND v(dout0_28) AT=1050.05n

.meas tran vdout0_29ck1040 FIND v(dout0_29) AT=1050.05n

.meas tran vdout0_30ck1040 FIND v(dout0_30) AT=1050.05n

.meas tran vdout0_31ck1040 FIND v(dout0_31) AT=1050.05n

.meas tran vdout0_32ck1040 FIND v(dout0_32) AT=1050.05n

.meas tran vdout0_0ck1130 FIND v(dout0_0) AT=1140.05n

.meas tran vdout0_1ck1130 FIND v(dout0_1) AT=1140.05n

.meas tran vdout0_2ck1130 FIND v(dout0_2) AT=1140.05n

.meas tran vdout0_3ck1130 FIND v(dout0_3) AT=1140.05n

.meas tran vdout0_4ck1130 FIND v(dout0_4) AT=1140.05n

.meas tran vdout0_5ck1130 FIND v(dout0_5) AT=1140.05n

.meas tran vdout0_6ck1130 FIND v(dout0_6) AT=1140.05n

.meas tran vdout0_7ck1130 FIND v(dout0_7) AT=1140.05n

.meas tran vdout0_8ck1130 FIND v(dout0_8) AT=1140.05n

.meas tran vdout0_9ck1130 FIND v(dout0_9) AT=1140.05n

.meas tran vdout0_10ck1130 FIND v(dout0_10) AT=1140.05n

.meas tran vdout0_11ck1130 FIND v(dout0_11) AT=1140.05n

.meas tran vdout0_12ck1130 FIND v(dout0_12) AT=1140.05n

.meas tran vdout0_13ck1130 FIND v(dout0_13) AT=1140.05n

.meas tran vdout0_14ck1130 FIND v(dout0_14) AT=1140.05n

.meas tran vdout0_15ck1130 FIND v(dout0_15) AT=1140.05n

.meas tran vdout0_16ck1130 FIND v(dout0_16) AT=1140.05n

.meas tran vdout0_17ck1130 FIND v(dout0_17) AT=1140.05n

.meas tran vdout0_18ck1130 FIND v(dout0_18) AT=1140.05n

.meas tran vdout0_19ck1130 FIND v(dout0_19) AT=1140.05n

.meas tran vdout0_20ck1130 FIND v(dout0_20) AT=1140.05n

.meas tran vdout0_21ck1130 FIND v(dout0_21) AT=1140.05n

.meas tran vdout0_22ck1130 FIND v(dout0_22) AT=1140.05n

.meas tran vdout0_23ck1130 FIND v(dout0_23) AT=1140.05n

.meas tran vdout0_24ck1130 FIND v(dout0_24) AT=1140.05n

.meas tran vdout0_25ck1130 FIND v(dout0_25) AT=1140.05n

.meas tran vdout0_26ck1130 FIND v(dout0_26) AT=1140.05n

.meas tran vdout0_27ck1130 FIND v(dout0_27) AT=1140.05n

.meas tran vdout0_28ck1130 FIND v(dout0_28) AT=1140.05n

.meas tran vdout0_29ck1130 FIND v(dout0_29) AT=1140.05n

.meas tran vdout0_30ck1130 FIND v(dout0_30) AT=1140.05n

.meas tran vdout0_31ck1130 FIND v(dout0_31) AT=1140.05n

.meas tran vdout0_32ck1130 FIND v(dout0_32) AT=1140.05n

.meas tran vdout0_0ck1140 FIND v(dout0_0) AT=1150.05n

.meas tran vdout0_1ck1140 FIND v(dout0_1) AT=1150.05n

.meas tran vdout0_2ck1140 FIND v(dout0_2) AT=1150.05n

.meas tran vdout0_3ck1140 FIND v(dout0_3) AT=1150.05n

.meas tran vdout0_4ck1140 FIND v(dout0_4) AT=1150.05n

.meas tran vdout0_5ck1140 FIND v(dout0_5) AT=1150.05n

.meas tran vdout0_6ck1140 FIND v(dout0_6) AT=1150.05n

.meas tran vdout0_7ck1140 FIND v(dout0_7) AT=1150.05n

.meas tran vdout0_8ck1140 FIND v(dout0_8) AT=1150.05n

.meas tran vdout0_9ck1140 FIND v(dout0_9) AT=1150.05n

.meas tran vdout0_10ck1140 FIND v(dout0_10) AT=1150.05n

.meas tran vdout0_11ck1140 FIND v(dout0_11) AT=1150.05n

.meas tran vdout0_12ck1140 FIND v(dout0_12) AT=1150.05n

.meas tran vdout0_13ck1140 FIND v(dout0_13) AT=1150.05n

.meas tran vdout0_14ck1140 FIND v(dout0_14) AT=1150.05n

.meas tran vdout0_15ck1140 FIND v(dout0_15) AT=1150.05n

.meas tran vdout0_16ck1140 FIND v(dout0_16) AT=1150.05n

.meas tran vdout0_17ck1140 FIND v(dout0_17) AT=1150.05n

.meas tran vdout0_18ck1140 FIND v(dout0_18) AT=1150.05n

.meas tran vdout0_19ck1140 FIND v(dout0_19) AT=1150.05n

.meas tran vdout0_20ck1140 FIND v(dout0_20) AT=1150.05n

.meas tran vdout0_21ck1140 FIND v(dout0_21) AT=1150.05n

.meas tran vdout0_22ck1140 FIND v(dout0_22) AT=1150.05n

.meas tran vdout0_23ck1140 FIND v(dout0_23) AT=1150.05n

.meas tran vdout0_24ck1140 FIND v(dout0_24) AT=1150.05n

.meas tran vdout0_25ck1140 FIND v(dout0_25) AT=1150.05n

.meas tran vdout0_26ck1140 FIND v(dout0_26) AT=1150.05n

.meas tran vdout0_27ck1140 FIND v(dout0_27) AT=1150.05n

.meas tran vdout0_28ck1140 FIND v(dout0_28) AT=1150.05n

.meas tran vdout0_29ck1140 FIND v(dout0_29) AT=1150.05n

.meas tran vdout0_30ck1140 FIND v(dout0_30) AT=1150.05n

.meas tran vdout0_31ck1140 FIND v(dout0_31) AT=1150.05n

.meas tran vdout0_32ck1140 FIND v(dout0_32) AT=1150.05n

.meas tran vdout0_0ck1150 FIND v(dout0_0) AT=1160.05n

.meas tran vdout0_1ck1150 FIND v(dout0_1) AT=1160.05n

.meas tran vdout0_2ck1150 FIND v(dout0_2) AT=1160.05n

.meas tran vdout0_3ck1150 FIND v(dout0_3) AT=1160.05n

.meas tran vdout0_4ck1150 FIND v(dout0_4) AT=1160.05n

.meas tran vdout0_5ck1150 FIND v(dout0_5) AT=1160.05n

.meas tran vdout0_6ck1150 FIND v(dout0_6) AT=1160.05n

.meas tran vdout0_7ck1150 FIND v(dout0_7) AT=1160.05n

.meas tran vdout0_8ck1150 FIND v(dout0_8) AT=1160.05n

.meas tran vdout0_9ck1150 FIND v(dout0_9) AT=1160.05n

.meas tran vdout0_10ck1150 FIND v(dout0_10) AT=1160.05n

.meas tran vdout0_11ck1150 FIND v(dout0_11) AT=1160.05n

.meas tran vdout0_12ck1150 FIND v(dout0_12) AT=1160.05n

.meas tran vdout0_13ck1150 FIND v(dout0_13) AT=1160.05n

.meas tran vdout0_14ck1150 FIND v(dout0_14) AT=1160.05n

.meas tran vdout0_15ck1150 FIND v(dout0_15) AT=1160.05n

.meas tran vdout0_16ck1150 FIND v(dout0_16) AT=1160.05n

.meas tran vdout0_17ck1150 FIND v(dout0_17) AT=1160.05n

.meas tran vdout0_18ck1150 FIND v(dout0_18) AT=1160.05n

.meas tran vdout0_19ck1150 FIND v(dout0_19) AT=1160.05n

.meas tran vdout0_20ck1150 FIND v(dout0_20) AT=1160.05n

.meas tran vdout0_21ck1150 FIND v(dout0_21) AT=1160.05n

.meas tran vdout0_22ck1150 FIND v(dout0_22) AT=1160.05n

.meas tran vdout0_23ck1150 FIND v(dout0_23) AT=1160.05n

.meas tran vdout0_24ck1150 FIND v(dout0_24) AT=1160.05n

.meas tran vdout0_25ck1150 FIND v(dout0_25) AT=1160.05n

.meas tran vdout0_26ck1150 FIND v(dout0_26) AT=1160.05n

.meas tran vdout0_27ck1150 FIND v(dout0_27) AT=1160.05n

.meas tran vdout0_28ck1150 FIND v(dout0_28) AT=1160.05n

.meas tran vdout0_29ck1150 FIND v(dout0_29) AT=1160.05n

.meas tran vdout0_30ck1150 FIND v(dout0_30) AT=1160.05n

.meas tran vdout0_31ck1150 FIND v(dout0_31) AT=1160.05n

.meas tran vdout0_32ck1150 FIND v(dout0_32) AT=1160.05n

.meas tran vdout0_0ck1160 FIND v(dout0_0) AT=1170.05n

.meas tran vdout0_1ck1160 FIND v(dout0_1) AT=1170.05n

.meas tran vdout0_2ck1160 FIND v(dout0_2) AT=1170.05n

.meas tran vdout0_3ck1160 FIND v(dout0_3) AT=1170.05n

.meas tran vdout0_4ck1160 FIND v(dout0_4) AT=1170.05n

.meas tran vdout0_5ck1160 FIND v(dout0_5) AT=1170.05n

.meas tran vdout0_6ck1160 FIND v(dout0_6) AT=1170.05n

.meas tran vdout0_7ck1160 FIND v(dout0_7) AT=1170.05n

.meas tran vdout0_8ck1160 FIND v(dout0_8) AT=1170.05n

.meas tran vdout0_9ck1160 FIND v(dout0_9) AT=1170.05n

.meas tran vdout0_10ck1160 FIND v(dout0_10) AT=1170.05n

.meas tran vdout0_11ck1160 FIND v(dout0_11) AT=1170.05n

.meas tran vdout0_12ck1160 FIND v(dout0_12) AT=1170.05n

.meas tran vdout0_13ck1160 FIND v(dout0_13) AT=1170.05n

.meas tran vdout0_14ck1160 FIND v(dout0_14) AT=1170.05n

.meas tran vdout0_15ck1160 FIND v(dout0_15) AT=1170.05n

.meas tran vdout0_16ck1160 FIND v(dout0_16) AT=1170.05n

.meas tran vdout0_17ck1160 FIND v(dout0_17) AT=1170.05n

.meas tran vdout0_18ck1160 FIND v(dout0_18) AT=1170.05n

.meas tran vdout0_19ck1160 FIND v(dout0_19) AT=1170.05n

.meas tran vdout0_20ck1160 FIND v(dout0_20) AT=1170.05n

.meas tran vdout0_21ck1160 FIND v(dout0_21) AT=1170.05n

.meas tran vdout0_22ck1160 FIND v(dout0_22) AT=1170.05n

.meas tran vdout0_23ck1160 FIND v(dout0_23) AT=1170.05n

.meas tran vdout0_24ck1160 FIND v(dout0_24) AT=1170.05n

.meas tran vdout0_25ck1160 FIND v(dout0_25) AT=1170.05n

.meas tran vdout0_26ck1160 FIND v(dout0_26) AT=1170.05n

.meas tran vdout0_27ck1160 FIND v(dout0_27) AT=1170.05n

.meas tran vdout0_28ck1160 FIND v(dout0_28) AT=1170.05n

.meas tran vdout0_29ck1160 FIND v(dout0_29) AT=1170.05n

.meas tran vdout0_30ck1160 FIND v(dout0_30) AT=1170.05n

.meas tran vdout0_31ck1160 FIND v(dout0_31) AT=1170.05n

.meas tran vdout0_32ck1160 FIND v(dout0_32) AT=1170.05n

.meas tran vdout0_0ck1180 FIND v(dout0_0) AT=1190.05n

.meas tran vdout0_1ck1180 FIND v(dout0_1) AT=1190.05n

.meas tran vdout0_2ck1180 FIND v(dout0_2) AT=1190.05n

.meas tran vdout0_3ck1180 FIND v(dout0_3) AT=1190.05n

.meas tran vdout0_4ck1180 FIND v(dout0_4) AT=1190.05n

.meas tran vdout0_5ck1180 FIND v(dout0_5) AT=1190.05n

.meas tran vdout0_6ck1180 FIND v(dout0_6) AT=1190.05n

.meas tran vdout0_7ck1180 FIND v(dout0_7) AT=1190.05n

.meas tran vdout0_8ck1180 FIND v(dout0_8) AT=1190.05n

.meas tran vdout0_9ck1180 FIND v(dout0_9) AT=1190.05n

.meas tran vdout0_10ck1180 FIND v(dout0_10) AT=1190.05n

.meas tran vdout0_11ck1180 FIND v(dout0_11) AT=1190.05n

.meas tran vdout0_12ck1180 FIND v(dout0_12) AT=1190.05n

.meas tran vdout0_13ck1180 FIND v(dout0_13) AT=1190.05n

.meas tran vdout0_14ck1180 FIND v(dout0_14) AT=1190.05n

.meas tran vdout0_15ck1180 FIND v(dout0_15) AT=1190.05n

.meas tran vdout0_16ck1180 FIND v(dout0_16) AT=1190.05n

.meas tran vdout0_17ck1180 FIND v(dout0_17) AT=1190.05n

.meas tran vdout0_18ck1180 FIND v(dout0_18) AT=1190.05n

.meas tran vdout0_19ck1180 FIND v(dout0_19) AT=1190.05n

.meas tran vdout0_20ck1180 FIND v(dout0_20) AT=1190.05n

.meas tran vdout0_21ck1180 FIND v(dout0_21) AT=1190.05n

.meas tran vdout0_22ck1180 FIND v(dout0_22) AT=1190.05n

.meas tran vdout0_23ck1180 FIND v(dout0_23) AT=1190.05n

.meas tran vdout0_24ck1180 FIND v(dout0_24) AT=1190.05n

.meas tran vdout0_25ck1180 FIND v(dout0_25) AT=1190.05n

.meas tran vdout0_26ck1180 FIND v(dout0_26) AT=1190.05n

.meas tran vdout0_27ck1180 FIND v(dout0_27) AT=1190.05n

.meas tran vdout0_28ck1180 FIND v(dout0_28) AT=1190.05n

.meas tran vdout0_29ck1180 FIND v(dout0_29) AT=1190.05n

.meas tran vdout0_30ck1180 FIND v(dout0_30) AT=1190.05n

.meas tran vdout0_31ck1180 FIND v(dout0_31) AT=1190.05n

.meas tran vdout0_32ck1180 FIND v(dout0_32) AT=1190.05n

.meas tran vdout0_0ck1200 FIND v(dout0_0) AT=1210.05n

.meas tran vdout0_1ck1200 FIND v(dout0_1) AT=1210.05n

.meas tran vdout0_2ck1200 FIND v(dout0_2) AT=1210.05n

.meas tran vdout0_3ck1200 FIND v(dout0_3) AT=1210.05n

.meas tran vdout0_4ck1200 FIND v(dout0_4) AT=1210.05n

.meas tran vdout0_5ck1200 FIND v(dout0_5) AT=1210.05n

.meas tran vdout0_6ck1200 FIND v(dout0_6) AT=1210.05n

.meas tran vdout0_7ck1200 FIND v(dout0_7) AT=1210.05n

.meas tran vdout0_8ck1200 FIND v(dout0_8) AT=1210.05n

.meas tran vdout0_9ck1200 FIND v(dout0_9) AT=1210.05n

.meas tran vdout0_10ck1200 FIND v(dout0_10) AT=1210.05n

.meas tran vdout0_11ck1200 FIND v(dout0_11) AT=1210.05n

.meas tran vdout0_12ck1200 FIND v(dout0_12) AT=1210.05n

.meas tran vdout0_13ck1200 FIND v(dout0_13) AT=1210.05n

.meas tran vdout0_14ck1200 FIND v(dout0_14) AT=1210.05n

.meas tran vdout0_15ck1200 FIND v(dout0_15) AT=1210.05n

.meas tran vdout0_16ck1200 FIND v(dout0_16) AT=1210.05n

.meas tran vdout0_17ck1200 FIND v(dout0_17) AT=1210.05n

.meas tran vdout0_18ck1200 FIND v(dout0_18) AT=1210.05n

.meas tran vdout0_19ck1200 FIND v(dout0_19) AT=1210.05n

.meas tran vdout0_20ck1200 FIND v(dout0_20) AT=1210.05n

.meas tran vdout0_21ck1200 FIND v(dout0_21) AT=1210.05n

.meas tran vdout0_22ck1200 FIND v(dout0_22) AT=1210.05n

.meas tran vdout0_23ck1200 FIND v(dout0_23) AT=1210.05n

.meas tran vdout0_24ck1200 FIND v(dout0_24) AT=1210.05n

.meas tran vdout0_25ck1200 FIND v(dout0_25) AT=1210.05n

.meas tran vdout0_26ck1200 FIND v(dout0_26) AT=1210.05n

.meas tran vdout0_27ck1200 FIND v(dout0_27) AT=1210.05n

.meas tran vdout0_28ck1200 FIND v(dout0_28) AT=1210.05n

.meas tran vdout0_29ck1200 FIND v(dout0_29) AT=1210.05n

.meas tran vdout0_30ck1200 FIND v(dout0_30) AT=1210.05n

.meas tran vdout0_31ck1200 FIND v(dout0_31) AT=1210.05n

.meas tran vdout0_32ck1200 FIND v(dout0_32) AT=1210.05n

.meas tran vdout0_0ck1220 FIND v(dout0_0) AT=1230.05n

.meas tran vdout0_1ck1220 FIND v(dout0_1) AT=1230.05n

.meas tran vdout0_2ck1220 FIND v(dout0_2) AT=1230.05n

.meas tran vdout0_3ck1220 FIND v(dout0_3) AT=1230.05n

.meas tran vdout0_4ck1220 FIND v(dout0_4) AT=1230.05n

.meas tran vdout0_5ck1220 FIND v(dout0_5) AT=1230.05n

.meas tran vdout0_6ck1220 FIND v(dout0_6) AT=1230.05n

.meas tran vdout0_7ck1220 FIND v(dout0_7) AT=1230.05n

.meas tran vdout0_8ck1220 FIND v(dout0_8) AT=1230.05n

.meas tran vdout0_9ck1220 FIND v(dout0_9) AT=1230.05n

.meas tran vdout0_10ck1220 FIND v(dout0_10) AT=1230.05n

.meas tran vdout0_11ck1220 FIND v(dout0_11) AT=1230.05n

.meas tran vdout0_12ck1220 FIND v(dout0_12) AT=1230.05n

.meas tran vdout0_13ck1220 FIND v(dout0_13) AT=1230.05n

.meas tran vdout0_14ck1220 FIND v(dout0_14) AT=1230.05n

.meas tran vdout0_15ck1220 FIND v(dout0_15) AT=1230.05n

.meas tran vdout0_16ck1220 FIND v(dout0_16) AT=1230.05n

.meas tran vdout0_17ck1220 FIND v(dout0_17) AT=1230.05n

.meas tran vdout0_18ck1220 FIND v(dout0_18) AT=1230.05n

.meas tran vdout0_19ck1220 FIND v(dout0_19) AT=1230.05n

.meas tran vdout0_20ck1220 FIND v(dout0_20) AT=1230.05n

.meas tran vdout0_21ck1220 FIND v(dout0_21) AT=1230.05n

.meas tran vdout0_22ck1220 FIND v(dout0_22) AT=1230.05n

.meas tran vdout0_23ck1220 FIND v(dout0_23) AT=1230.05n

.meas tran vdout0_24ck1220 FIND v(dout0_24) AT=1230.05n

.meas tran vdout0_25ck1220 FIND v(dout0_25) AT=1230.05n

.meas tran vdout0_26ck1220 FIND v(dout0_26) AT=1230.05n

.meas tran vdout0_27ck1220 FIND v(dout0_27) AT=1230.05n

.meas tran vdout0_28ck1220 FIND v(dout0_28) AT=1230.05n

.meas tran vdout0_29ck1220 FIND v(dout0_29) AT=1230.05n

.meas tran vdout0_30ck1220 FIND v(dout0_30) AT=1230.05n

.meas tran vdout0_31ck1220 FIND v(dout0_31) AT=1230.05n

.meas tran vdout0_32ck1220 FIND v(dout0_32) AT=1230.05n

.meas tran vdout0_0ck1270 FIND v(dout0_0) AT=1280.05n

.meas tran vdout0_1ck1270 FIND v(dout0_1) AT=1280.05n

.meas tran vdout0_2ck1270 FIND v(dout0_2) AT=1280.05n

.meas tran vdout0_3ck1270 FIND v(dout0_3) AT=1280.05n

.meas tran vdout0_4ck1270 FIND v(dout0_4) AT=1280.05n

.meas tran vdout0_5ck1270 FIND v(dout0_5) AT=1280.05n

.meas tran vdout0_6ck1270 FIND v(dout0_6) AT=1280.05n

.meas tran vdout0_7ck1270 FIND v(dout0_7) AT=1280.05n

.meas tran vdout0_8ck1270 FIND v(dout0_8) AT=1280.05n

.meas tran vdout0_9ck1270 FIND v(dout0_9) AT=1280.05n

.meas tran vdout0_10ck1270 FIND v(dout0_10) AT=1280.05n

.meas tran vdout0_11ck1270 FIND v(dout0_11) AT=1280.05n

.meas tran vdout0_12ck1270 FIND v(dout0_12) AT=1280.05n

.meas tran vdout0_13ck1270 FIND v(dout0_13) AT=1280.05n

.meas tran vdout0_14ck1270 FIND v(dout0_14) AT=1280.05n

.meas tran vdout0_15ck1270 FIND v(dout0_15) AT=1280.05n

.meas tran vdout0_16ck1270 FIND v(dout0_16) AT=1280.05n

.meas tran vdout0_17ck1270 FIND v(dout0_17) AT=1280.05n

.meas tran vdout0_18ck1270 FIND v(dout0_18) AT=1280.05n

.meas tran vdout0_19ck1270 FIND v(dout0_19) AT=1280.05n

.meas tran vdout0_20ck1270 FIND v(dout0_20) AT=1280.05n

.meas tran vdout0_21ck1270 FIND v(dout0_21) AT=1280.05n

.meas tran vdout0_22ck1270 FIND v(dout0_22) AT=1280.05n

.meas tran vdout0_23ck1270 FIND v(dout0_23) AT=1280.05n

.meas tran vdout0_24ck1270 FIND v(dout0_24) AT=1280.05n

.meas tran vdout0_25ck1270 FIND v(dout0_25) AT=1280.05n

.meas tran vdout0_26ck1270 FIND v(dout0_26) AT=1280.05n

.meas tran vdout0_27ck1270 FIND v(dout0_27) AT=1280.05n

.meas tran vdout0_28ck1270 FIND v(dout0_28) AT=1280.05n

.meas tran vdout0_29ck1270 FIND v(dout0_29) AT=1280.05n

.meas tran vdout0_30ck1270 FIND v(dout0_30) AT=1280.05n

.meas tran vdout0_31ck1270 FIND v(dout0_31) AT=1280.05n

.meas tran vdout0_32ck1270 FIND v(dout0_32) AT=1280.05n

.meas tran vdout0_0ck1280 FIND v(dout0_0) AT=1290.05n

.meas tran vdout0_1ck1280 FIND v(dout0_1) AT=1290.05n

.meas tran vdout0_2ck1280 FIND v(dout0_2) AT=1290.05n

.meas tran vdout0_3ck1280 FIND v(dout0_3) AT=1290.05n

.meas tran vdout0_4ck1280 FIND v(dout0_4) AT=1290.05n

.meas tran vdout0_5ck1280 FIND v(dout0_5) AT=1290.05n

.meas tran vdout0_6ck1280 FIND v(dout0_6) AT=1290.05n

.meas tran vdout0_7ck1280 FIND v(dout0_7) AT=1290.05n

.meas tran vdout0_8ck1280 FIND v(dout0_8) AT=1290.05n

.meas tran vdout0_9ck1280 FIND v(dout0_9) AT=1290.05n

.meas tran vdout0_10ck1280 FIND v(dout0_10) AT=1290.05n

.meas tran vdout0_11ck1280 FIND v(dout0_11) AT=1290.05n

.meas tran vdout0_12ck1280 FIND v(dout0_12) AT=1290.05n

.meas tran vdout0_13ck1280 FIND v(dout0_13) AT=1290.05n

.meas tran vdout0_14ck1280 FIND v(dout0_14) AT=1290.05n

.meas tran vdout0_15ck1280 FIND v(dout0_15) AT=1290.05n

.meas tran vdout0_16ck1280 FIND v(dout0_16) AT=1290.05n

.meas tran vdout0_17ck1280 FIND v(dout0_17) AT=1290.05n

.meas tran vdout0_18ck1280 FIND v(dout0_18) AT=1290.05n

.meas tran vdout0_19ck1280 FIND v(dout0_19) AT=1290.05n

.meas tran vdout0_20ck1280 FIND v(dout0_20) AT=1290.05n

.meas tran vdout0_21ck1280 FIND v(dout0_21) AT=1290.05n

.meas tran vdout0_22ck1280 FIND v(dout0_22) AT=1290.05n

.meas tran vdout0_23ck1280 FIND v(dout0_23) AT=1290.05n

.meas tran vdout0_24ck1280 FIND v(dout0_24) AT=1290.05n

.meas tran vdout0_25ck1280 FIND v(dout0_25) AT=1290.05n

.meas tran vdout0_26ck1280 FIND v(dout0_26) AT=1290.05n

.meas tran vdout0_27ck1280 FIND v(dout0_27) AT=1290.05n

.meas tran vdout0_28ck1280 FIND v(dout0_28) AT=1290.05n

.meas tran vdout0_29ck1280 FIND v(dout0_29) AT=1290.05n

.meas tran vdout0_30ck1280 FIND v(dout0_30) AT=1290.05n

.meas tran vdout0_31ck1280 FIND v(dout0_31) AT=1290.05n

.meas tran vdout0_32ck1280 FIND v(dout0_32) AT=1290.05n

.meas tran vdout0_0ck1290 FIND v(dout0_0) AT=1300.05n

.meas tran vdout0_1ck1290 FIND v(dout0_1) AT=1300.05n

.meas tran vdout0_2ck1290 FIND v(dout0_2) AT=1300.05n

.meas tran vdout0_3ck1290 FIND v(dout0_3) AT=1300.05n

.meas tran vdout0_4ck1290 FIND v(dout0_4) AT=1300.05n

.meas tran vdout0_5ck1290 FIND v(dout0_5) AT=1300.05n

.meas tran vdout0_6ck1290 FIND v(dout0_6) AT=1300.05n

.meas tran vdout0_7ck1290 FIND v(dout0_7) AT=1300.05n

.meas tran vdout0_8ck1290 FIND v(dout0_8) AT=1300.05n

.meas tran vdout0_9ck1290 FIND v(dout0_9) AT=1300.05n

.meas tran vdout0_10ck1290 FIND v(dout0_10) AT=1300.05n

.meas tran vdout0_11ck1290 FIND v(dout0_11) AT=1300.05n

.meas tran vdout0_12ck1290 FIND v(dout0_12) AT=1300.05n

.meas tran vdout0_13ck1290 FIND v(dout0_13) AT=1300.05n

.meas tran vdout0_14ck1290 FIND v(dout0_14) AT=1300.05n

.meas tran vdout0_15ck1290 FIND v(dout0_15) AT=1300.05n

.meas tran vdout0_16ck1290 FIND v(dout0_16) AT=1300.05n

.meas tran vdout0_17ck1290 FIND v(dout0_17) AT=1300.05n

.meas tran vdout0_18ck1290 FIND v(dout0_18) AT=1300.05n

.meas tran vdout0_19ck1290 FIND v(dout0_19) AT=1300.05n

.meas tran vdout0_20ck1290 FIND v(dout0_20) AT=1300.05n

.meas tran vdout0_21ck1290 FIND v(dout0_21) AT=1300.05n

.meas tran vdout0_22ck1290 FIND v(dout0_22) AT=1300.05n

.meas tran vdout0_23ck1290 FIND v(dout0_23) AT=1300.05n

.meas tran vdout0_24ck1290 FIND v(dout0_24) AT=1300.05n

.meas tran vdout0_25ck1290 FIND v(dout0_25) AT=1300.05n

.meas tran vdout0_26ck1290 FIND v(dout0_26) AT=1300.05n

.meas tran vdout0_27ck1290 FIND v(dout0_27) AT=1300.05n

.meas tran vdout0_28ck1290 FIND v(dout0_28) AT=1300.05n

.meas tran vdout0_29ck1290 FIND v(dout0_29) AT=1300.05n

.meas tran vdout0_30ck1290 FIND v(dout0_30) AT=1300.05n

.meas tran vdout0_31ck1290 FIND v(dout0_31) AT=1300.05n

.meas tran vdout0_32ck1290 FIND v(dout0_32) AT=1300.05n

.meas tran vdout0_0ck1350 FIND v(dout0_0) AT=1360.05n

.meas tran vdout0_1ck1350 FIND v(dout0_1) AT=1360.05n

.meas tran vdout0_2ck1350 FIND v(dout0_2) AT=1360.05n

.meas tran vdout0_3ck1350 FIND v(dout0_3) AT=1360.05n

.meas tran vdout0_4ck1350 FIND v(dout0_4) AT=1360.05n

.meas tran vdout0_5ck1350 FIND v(dout0_5) AT=1360.05n

.meas tran vdout0_6ck1350 FIND v(dout0_6) AT=1360.05n

.meas tran vdout0_7ck1350 FIND v(dout0_7) AT=1360.05n

.meas tran vdout0_8ck1350 FIND v(dout0_8) AT=1360.05n

.meas tran vdout0_9ck1350 FIND v(dout0_9) AT=1360.05n

.meas tran vdout0_10ck1350 FIND v(dout0_10) AT=1360.05n

.meas tran vdout0_11ck1350 FIND v(dout0_11) AT=1360.05n

.meas tran vdout0_12ck1350 FIND v(dout0_12) AT=1360.05n

.meas tran vdout0_13ck1350 FIND v(dout0_13) AT=1360.05n

.meas tran vdout0_14ck1350 FIND v(dout0_14) AT=1360.05n

.meas tran vdout0_15ck1350 FIND v(dout0_15) AT=1360.05n

.meas tran vdout0_16ck1350 FIND v(dout0_16) AT=1360.05n

.meas tran vdout0_17ck1350 FIND v(dout0_17) AT=1360.05n

.meas tran vdout0_18ck1350 FIND v(dout0_18) AT=1360.05n

.meas tran vdout0_19ck1350 FIND v(dout0_19) AT=1360.05n

.meas tran vdout0_20ck1350 FIND v(dout0_20) AT=1360.05n

.meas tran vdout0_21ck1350 FIND v(dout0_21) AT=1360.05n

.meas tran vdout0_22ck1350 FIND v(dout0_22) AT=1360.05n

.meas tran vdout0_23ck1350 FIND v(dout0_23) AT=1360.05n

.meas tran vdout0_24ck1350 FIND v(dout0_24) AT=1360.05n

.meas tran vdout0_25ck1350 FIND v(dout0_25) AT=1360.05n

.meas tran vdout0_26ck1350 FIND v(dout0_26) AT=1360.05n

.meas tran vdout0_27ck1350 FIND v(dout0_27) AT=1360.05n

.meas tran vdout0_28ck1350 FIND v(dout0_28) AT=1360.05n

.meas tran vdout0_29ck1350 FIND v(dout0_29) AT=1360.05n

.meas tran vdout0_30ck1350 FIND v(dout0_30) AT=1360.05n

.meas tran vdout0_31ck1350 FIND v(dout0_31) AT=1360.05n

.meas tran vdout0_32ck1350 FIND v(dout0_32) AT=1360.05n

.meas tran vdout0_0ck1370 FIND v(dout0_0) AT=1380.05n

.meas tran vdout0_1ck1370 FIND v(dout0_1) AT=1380.05n

.meas tran vdout0_2ck1370 FIND v(dout0_2) AT=1380.05n

.meas tran vdout0_3ck1370 FIND v(dout0_3) AT=1380.05n

.meas tran vdout0_4ck1370 FIND v(dout0_4) AT=1380.05n

.meas tran vdout0_5ck1370 FIND v(dout0_5) AT=1380.05n

.meas tran vdout0_6ck1370 FIND v(dout0_6) AT=1380.05n

.meas tran vdout0_7ck1370 FIND v(dout0_7) AT=1380.05n

.meas tran vdout0_8ck1370 FIND v(dout0_8) AT=1380.05n

.meas tran vdout0_9ck1370 FIND v(dout0_9) AT=1380.05n

.meas tran vdout0_10ck1370 FIND v(dout0_10) AT=1380.05n

.meas tran vdout0_11ck1370 FIND v(dout0_11) AT=1380.05n

.meas tran vdout0_12ck1370 FIND v(dout0_12) AT=1380.05n

.meas tran vdout0_13ck1370 FIND v(dout0_13) AT=1380.05n

.meas tran vdout0_14ck1370 FIND v(dout0_14) AT=1380.05n

.meas tran vdout0_15ck1370 FIND v(dout0_15) AT=1380.05n

.meas tran vdout0_16ck1370 FIND v(dout0_16) AT=1380.05n

.meas tran vdout0_17ck1370 FIND v(dout0_17) AT=1380.05n

.meas tran vdout0_18ck1370 FIND v(dout0_18) AT=1380.05n

.meas tran vdout0_19ck1370 FIND v(dout0_19) AT=1380.05n

.meas tran vdout0_20ck1370 FIND v(dout0_20) AT=1380.05n

.meas tran vdout0_21ck1370 FIND v(dout0_21) AT=1380.05n

.meas tran vdout0_22ck1370 FIND v(dout0_22) AT=1380.05n

.meas tran vdout0_23ck1370 FIND v(dout0_23) AT=1380.05n

.meas tran vdout0_24ck1370 FIND v(dout0_24) AT=1380.05n

.meas tran vdout0_25ck1370 FIND v(dout0_25) AT=1380.05n

.meas tran vdout0_26ck1370 FIND v(dout0_26) AT=1380.05n

.meas tran vdout0_27ck1370 FIND v(dout0_27) AT=1380.05n

.meas tran vdout0_28ck1370 FIND v(dout0_28) AT=1380.05n

.meas tran vdout0_29ck1370 FIND v(dout0_29) AT=1380.05n

.meas tran vdout0_30ck1370 FIND v(dout0_30) AT=1380.05n

.meas tran vdout0_31ck1370 FIND v(dout0_31) AT=1380.05n

.meas tran vdout0_32ck1370 FIND v(dout0_32) AT=1380.05n

.meas tran vdout0_0ck1450 FIND v(dout0_0) AT=1460.05n

.meas tran vdout0_1ck1450 FIND v(dout0_1) AT=1460.05n

.meas tran vdout0_2ck1450 FIND v(dout0_2) AT=1460.05n

.meas tran vdout0_3ck1450 FIND v(dout0_3) AT=1460.05n

.meas tran vdout0_4ck1450 FIND v(dout0_4) AT=1460.05n

.meas tran vdout0_5ck1450 FIND v(dout0_5) AT=1460.05n

.meas tran vdout0_6ck1450 FIND v(dout0_6) AT=1460.05n

.meas tran vdout0_7ck1450 FIND v(dout0_7) AT=1460.05n

.meas tran vdout0_8ck1450 FIND v(dout0_8) AT=1460.05n

.meas tran vdout0_9ck1450 FIND v(dout0_9) AT=1460.05n

.meas tran vdout0_10ck1450 FIND v(dout0_10) AT=1460.05n

.meas tran vdout0_11ck1450 FIND v(dout0_11) AT=1460.05n

.meas tran vdout0_12ck1450 FIND v(dout0_12) AT=1460.05n

.meas tran vdout0_13ck1450 FIND v(dout0_13) AT=1460.05n

.meas tran vdout0_14ck1450 FIND v(dout0_14) AT=1460.05n

.meas tran vdout0_15ck1450 FIND v(dout0_15) AT=1460.05n

.meas tran vdout0_16ck1450 FIND v(dout0_16) AT=1460.05n

.meas tran vdout0_17ck1450 FIND v(dout0_17) AT=1460.05n

.meas tran vdout0_18ck1450 FIND v(dout0_18) AT=1460.05n

.meas tran vdout0_19ck1450 FIND v(dout0_19) AT=1460.05n

.meas tran vdout0_20ck1450 FIND v(dout0_20) AT=1460.05n

.meas tran vdout0_21ck1450 FIND v(dout0_21) AT=1460.05n

.meas tran vdout0_22ck1450 FIND v(dout0_22) AT=1460.05n

.meas tran vdout0_23ck1450 FIND v(dout0_23) AT=1460.05n

.meas tran vdout0_24ck1450 FIND v(dout0_24) AT=1460.05n

.meas tran vdout0_25ck1450 FIND v(dout0_25) AT=1460.05n

.meas tran vdout0_26ck1450 FIND v(dout0_26) AT=1460.05n

.meas tran vdout0_27ck1450 FIND v(dout0_27) AT=1460.05n

.meas tran vdout0_28ck1450 FIND v(dout0_28) AT=1460.05n

.meas tran vdout0_29ck1450 FIND v(dout0_29) AT=1460.05n

.meas tran vdout0_30ck1450 FIND v(dout0_30) AT=1460.05n

.meas tran vdout0_31ck1450 FIND v(dout0_31) AT=1460.05n

.meas tran vdout0_32ck1450 FIND v(dout0_32) AT=1460.05n

.meas tran vdout0_0ck1460 FIND v(dout0_0) AT=1470.05n

.meas tran vdout0_1ck1460 FIND v(dout0_1) AT=1470.05n

.meas tran vdout0_2ck1460 FIND v(dout0_2) AT=1470.05n

.meas tran vdout0_3ck1460 FIND v(dout0_3) AT=1470.05n

.meas tran vdout0_4ck1460 FIND v(dout0_4) AT=1470.05n

.meas tran vdout0_5ck1460 FIND v(dout0_5) AT=1470.05n

.meas tran vdout0_6ck1460 FIND v(dout0_6) AT=1470.05n

.meas tran vdout0_7ck1460 FIND v(dout0_7) AT=1470.05n

.meas tran vdout0_8ck1460 FIND v(dout0_8) AT=1470.05n

.meas tran vdout0_9ck1460 FIND v(dout0_9) AT=1470.05n

.meas tran vdout0_10ck1460 FIND v(dout0_10) AT=1470.05n

.meas tran vdout0_11ck1460 FIND v(dout0_11) AT=1470.05n

.meas tran vdout0_12ck1460 FIND v(dout0_12) AT=1470.05n

.meas tran vdout0_13ck1460 FIND v(dout0_13) AT=1470.05n

.meas tran vdout0_14ck1460 FIND v(dout0_14) AT=1470.05n

.meas tran vdout0_15ck1460 FIND v(dout0_15) AT=1470.05n

.meas tran vdout0_16ck1460 FIND v(dout0_16) AT=1470.05n

.meas tran vdout0_17ck1460 FIND v(dout0_17) AT=1470.05n

.meas tran vdout0_18ck1460 FIND v(dout0_18) AT=1470.05n

.meas tran vdout0_19ck1460 FIND v(dout0_19) AT=1470.05n

.meas tran vdout0_20ck1460 FIND v(dout0_20) AT=1470.05n

.meas tran vdout0_21ck1460 FIND v(dout0_21) AT=1470.05n

.meas tran vdout0_22ck1460 FIND v(dout0_22) AT=1470.05n

.meas tran vdout0_23ck1460 FIND v(dout0_23) AT=1470.05n

.meas tran vdout0_24ck1460 FIND v(dout0_24) AT=1470.05n

.meas tran vdout0_25ck1460 FIND v(dout0_25) AT=1470.05n

.meas tran vdout0_26ck1460 FIND v(dout0_26) AT=1470.05n

.meas tran vdout0_27ck1460 FIND v(dout0_27) AT=1470.05n

.meas tran vdout0_28ck1460 FIND v(dout0_28) AT=1470.05n

.meas tran vdout0_29ck1460 FIND v(dout0_29) AT=1470.05n

.meas tran vdout0_30ck1460 FIND v(dout0_30) AT=1470.05n

.meas tran vdout0_31ck1460 FIND v(dout0_31) AT=1470.05n

.meas tran vdout0_32ck1460 FIND v(dout0_32) AT=1470.05n

.meas tran vdout0_0ck1510 FIND v(dout0_0) AT=1520.05n

.meas tran vdout0_1ck1510 FIND v(dout0_1) AT=1520.05n

.meas tran vdout0_2ck1510 FIND v(dout0_2) AT=1520.05n

.meas tran vdout0_3ck1510 FIND v(dout0_3) AT=1520.05n

.meas tran vdout0_4ck1510 FIND v(dout0_4) AT=1520.05n

.meas tran vdout0_5ck1510 FIND v(dout0_5) AT=1520.05n

.meas tran vdout0_6ck1510 FIND v(dout0_6) AT=1520.05n

.meas tran vdout0_7ck1510 FIND v(dout0_7) AT=1520.05n

.meas tran vdout0_8ck1510 FIND v(dout0_8) AT=1520.05n

.meas tran vdout0_9ck1510 FIND v(dout0_9) AT=1520.05n

.meas tran vdout0_10ck1510 FIND v(dout0_10) AT=1520.05n

.meas tran vdout0_11ck1510 FIND v(dout0_11) AT=1520.05n

.meas tran vdout0_12ck1510 FIND v(dout0_12) AT=1520.05n

.meas tran vdout0_13ck1510 FIND v(dout0_13) AT=1520.05n

.meas tran vdout0_14ck1510 FIND v(dout0_14) AT=1520.05n

.meas tran vdout0_15ck1510 FIND v(dout0_15) AT=1520.05n

.meas tran vdout0_16ck1510 FIND v(dout0_16) AT=1520.05n

.meas tran vdout0_17ck1510 FIND v(dout0_17) AT=1520.05n

.meas tran vdout0_18ck1510 FIND v(dout0_18) AT=1520.05n

.meas tran vdout0_19ck1510 FIND v(dout0_19) AT=1520.05n

.meas tran vdout0_20ck1510 FIND v(dout0_20) AT=1520.05n

.meas tran vdout0_21ck1510 FIND v(dout0_21) AT=1520.05n

.meas tran vdout0_22ck1510 FIND v(dout0_22) AT=1520.05n

.meas tran vdout0_23ck1510 FIND v(dout0_23) AT=1520.05n

.meas tran vdout0_24ck1510 FIND v(dout0_24) AT=1520.05n

.meas tran vdout0_25ck1510 FIND v(dout0_25) AT=1520.05n

.meas tran vdout0_26ck1510 FIND v(dout0_26) AT=1520.05n

.meas tran vdout0_27ck1510 FIND v(dout0_27) AT=1520.05n

.meas tran vdout0_28ck1510 FIND v(dout0_28) AT=1520.05n

.meas tran vdout0_29ck1510 FIND v(dout0_29) AT=1520.05n

.meas tran vdout0_30ck1510 FIND v(dout0_30) AT=1520.05n

.meas tran vdout0_31ck1510 FIND v(dout0_31) AT=1520.05n

.meas tran vdout0_32ck1510 FIND v(dout0_32) AT=1520.05n

.meas tran vdout0_0ck1520 FIND v(dout0_0) AT=1530.05n

.meas tran vdout0_1ck1520 FIND v(dout0_1) AT=1530.05n

.meas tran vdout0_2ck1520 FIND v(dout0_2) AT=1530.05n

.meas tran vdout0_3ck1520 FIND v(dout0_3) AT=1530.05n

.meas tran vdout0_4ck1520 FIND v(dout0_4) AT=1530.05n

.meas tran vdout0_5ck1520 FIND v(dout0_5) AT=1530.05n

.meas tran vdout0_6ck1520 FIND v(dout0_6) AT=1530.05n

.meas tran vdout0_7ck1520 FIND v(dout0_7) AT=1530.05n

.meas tran vdout0_8ck1520 FIND v(dout0_8) AT=1530.05n

.meas tran vdout0_9ck1520 FIND v(dout0_9) AT=1530.05n

.meas tran vdout0_10ck1520 FIND v(dout0_10) AT=1530.05n

.meas tran vdout0_11ck1520 FIND v(dout0_11) AT=1530.05n

.meas tran vdout0_12ck1520 FIND v(dout0_12) AT=1530.05n

.meas tran vdout0_13ck1520 FIND v(dout0_13) AT=1530.05n

.meas tran vdout0_14ck1520 FIND v(dout0_14) AT=1530.05n

.meas tran vdout0_15ck1520 FIND v(dout0_15) AT=1530.05n

.meas tran vdout0_16ck1520 FIND v(dout0_16) AT=1530.05n

.meas tran vdout0_17ck1520 FIND v(dout0_17) AT=1530.05n

.meas tran vdout0_18ck1520 FIND v(dout0_18) AT=1530.05n

.meas tran vdout0_19ck1520 FIND v(dout0_19) AT=1530.05n

.meas tran vdout0_20ck1520 FIND v(dout0_20) AT=1530.05n

.meas tran vdout0_21ck1520 FIND v(dout0_21) AT=1530.05n

.meas tran vdout0_22ck1520 FIND v(dout0_22) AT=1530.05n

.meas tran vdout0_23ck1520 FIND v(dout0_23) AT=1530.05n

.meas tran vdout0_24ck1520 FIND v(dout0_24) AT=1530.05n

.meas tran vdout0_25ck1520 FIND v(dout0_25) AT=1530.05n

.meas tran vdout0_26ck1520 FIND v(dout0_26) AT=1530.05n

.meas tran vdout0_27ck1520 FIND v(dout0_27) AT=1530.05n

.meas tran vdout0_28ck1520 FIND v(dout0_28) AT=1530.05n

.meas tran vdout0_29ck1520 FIND v(dout0_29) AT=1530.05n

.meas tran vdout0_30ck1520 FIND v(dout0_30) AT=1530.05n

.meas tran vdout0_31ck1520 FIND v(dout0_31) AT=1530.05n

.meas tran vdout0_32ck1520 FIND v(dout0_32) AT=1530.05n

.meas tran vdout0_0ck1530 FIND v(dout0_0) AT=1540.05n

.meas tran vdout0_1ck1530 FIND v(dout0_1) AT=1540.05n

.meas tran vdout0_2ck1530 FIND v(dout0_2) AT=1540.05n

.meas tran vdout0_3ck1530 FIND v(dout0_3) AT=1540.05n

.meas tran vdout0_4ck1530 FIND v(dout0_4) AT=1540.05n

.meas tran vdout0_5ck1530 FIND v(dout0_5) AT=1540.05n

.meas tran vdout0_6ck1530 FIND v(dout0_6) AT=1540.05n

.meas tran vdout0_7ck1530 FIND v(dout0_7) AT=1540.05n

.meas tran vdout0_8ck1530 FIND v(dout0_8) AT=1540.05n

.meas tran vdout0_9ck1530 FIND v(dout0_9) AT=1540.05n

.meas tran vdout0_10ck1530 FIND v(dout0_10) AT=1540.05n

.meas tran vdout0_11ck1530 FIND v(dout0_11) AT=1540.05n

.meas tran vdout0_12ck1530 FIND v(dout0_12) AT=1540.05n

.meas tran vdout0_13ck1530 FIND v(dout0_13) AT=1540.05n

.meas tran vdout0_14ck1530 FIND v(dout0_14) AT=1540.05n

.meas tran vdout0_15ck1530 FIND v(dout0_15) AT=1540.05n

.meas tran vdout0_16ck1530 FIND v(dout0_16) AT=1540.05n

.meas tran vdout0_17ck1530 FIND v(dout0_17) AT=1540.05n

.meas tran vdout0_18ck1530 FIND v(dout0_18) AT=1540.05n

.meas tran vdout0_19ck1530 FIND v(dout0_19) AT=1540.05n

.meas tran vdout0_20ck1530 FIND v(dout0_20) AT=1540.05n

.meas tran vdout0_21ck1530 FIND v(dout0_21) AT=1540.05n

.meas tran vdout0_22ck1530 FIND v(dout0_22) AT=1540.05n

.meas tran vdout0_23ck1530 FIND v(dout0_23) AT=1540.05n

.meas tran vdout0_24ck1530 FIND v(dout0_24) AT=1540.05n

.meas tran vdout0_25ck1530 FIND v(dout0_25) AT=1540.05n

.meas tran vdout0_26ck1530 FIND v(dout0_26) AT=1540.05n

.meas tran vdout0_27ck1530 FIND v(dout0_27) AT=1540.05n

.meas tran vdout0_28ck1530 FIND v(dout0_28) AT=1540.05n

.meas tran vdout0_29ck1530 FIND v(dout0_29) AT=1540.05n

.meas tran vdout0_30ck1530 FIND v(dout0_30) AT=1540.05n

.meas tran vdout0_31ck1530 FIND v(dout0_31) AT=1540.05n

.meas tran vdout0_32ck1530 FIND v(dout0_32) AT=1540.05n

.meas tran vdout0_0ck1570 FIND v(dout0_0) AT=1580.05n

.meas tran vdout0_1ck1570 FIND v(dout0_1) AT=1580.05n

.meas tran vdout0_2ck1570 FIND v(dout0_2) AT=1580.05n

.meas tran vdout0_3ck1570 FIND v(dout0_3) AT=1580.05n

.meas tran vdout0_4ck1570 FIND v(dout0_4) AT=1580.05n

.meas tran vdout0_5ck1570 FIND v(dout0_5) AT=1580.05n

.meas tran vdout0_6ck1570 FIND v(dout0_6) AT=1580.05n

.meas tran vdout0_7ck1570 FIND v(dout0_7) AT=1580.05n

.meas tran vdout0_8ck1570 FIND v(dout0_8) AT=1580.05n

.meas tran vdout0_9ck1570 FIND v(dout0_9) AT=1580.05n

.meas tran vdout0_10ck1570 FIND v(dout0_10) AT=1580.05n

.meas tran vdout0_11ck1570 FIND v(dout0_11) AT=1580.05n

.meas tran vdout0_12ck1570 FIND v(dout0_12) AT=1580.05n

.meas tran vdout0_13ck1570 FIND v(dout0_13) AT=1580.05n

.meas tran vdout0_14ck1570 FIND v(dout0_14) AT=1580.05n

.meas tran vdout0_15ck1570 FIND v(dout0_15) AT=1580.05n

.meas tran vdout0_16ck1570 FIND v(dout0_16) AT=1580.05n

.meas tran vdout0_17ck1570 FIND v(dout0_17) AT=1580.05n

.meas tran vdout0_18ck1570 FIND v(dout0_18) AT=1580.05n

.meas tran vdout0_19ck1570 FIND v(dout0_19) AT=1580.05n

.meas tran vdout0_20ck1570 FIND v(dout0_20) AT=1580.05n

.meas tran vdout0_21ck1570 FIND v(dout0_21) AT=1580.05n

.meas tran vdout0_22ck1570 FIND v(dout0_22) AT=1580.05n

.meas tran vdout0_23ck1570 FIND v(dout0_23) AT=1580.05n

.meas tran vdout0_24ck1570 FIND v(dout0_24) AT=1580.05n

.meas tran vdout0_25ck1570 FIND v(dout0_25) AT=1580.05n

.meas tran vdout0_26ck1570 FIND v(dout0_26) AT=1580.05n

.meas tran vdout0_27ck1570 FIND v(dout0_27) AT=1580.05n

.meas tran vdout0_28ck1570 FIND v(dout0_28) AT=1580.05n

.meas tran vdout0_29ck1570 FIND v(dout0_29) AT=1580.05n

.meas tran vdout0_30ck1570 FIND v(dout0_30) AT=1580.05n

.meas tran vdout0_31ck1570 FIND v(dout0_31) AT=1580.05n

.meas tran vdout0_32ck1570 FIND v(dout0_32) AT=1580.05n

.meas tran vdout0_0ck1590 FIND v(dout0_0) AT=1600.05n

.meas tran vdout0_1ck1590 FIND v(dout0_1) AT=1600.05n

.meas tran vdout0_2ck1590 FIND v(dout0_2) AT=1600.05n

.meas tran vdout0_3ck1590 FIND v(dout0_3) AT=1600.05n

.meas tran vdout0_4ck1590 FIND v(dout0_4) AT=1600.05n

.meas tran vdout0_5ck1590 FIND v(dout0_5) AT=1600.05n

.meas tran vdout0_6ck1590 FIND v(dout0_6) AT=1600.05n

.meas tran vdout0_7ck1590 FIND v(dout0_7) AT=1600.05n

.meas tran vdout0_8ck1590 FIND v(dout0_8) AT=1600.05n

.meas tran vdout0_9ck1590 FIND v(dout0_9) AT=1600.05n

.meas tran vdout0_10ck1590 FIND v(dout0_10) AT=1600.05n

.meas tran vdout0_11ck1590 FIND v(dout0_11) AT=1600.05n

.meas tran vdout0_12ck1590 FIND v(dout0_12) AT=1600.05n

.meas tran vdout0_13ck1590 FIND v(dout0_13) AT=1600.05n

.meas tran vdout0_14ck1590 FIND v(dout0_14) AT=1600.05n

.meas tran vdout0_15ck1590 FIND v(dout0_15) AT=1600.05n

.meas tran vdout0_16ck1590 FIND v(dout0_16) AT=1600.05n

.meas tran vdout0_17ck1590 FIND v(dout0_17) AT=1600.05n

.meas tran vdout0_18ck1590 FIND v(dout0_18) AT=1600.05n

.meas tran vdout0_19ck1590 FIND v(dout0_19) AT=1600.05n

.meas tran vdout0_20ck1590 FIND v(dout0_20) AT=1600.05n

.meas tran vdout0_21ck1590 FIND v(dout0_21) AT=1600.05n

.meas tran vdout0_22ck1590 FIND v(dout0_22) AT=1600.05n

.meas tran vdout0_23ck1590 FIND v(dout0_23) AT=1600.05n

.meas tran vdout0_24ck1590 FIND v(dout0_24) AT=1600.05n

.meas tran vdout0_25ck1590 FIND v(dout0_25) AT=1600.05n

.meas tran vdout0_26ck1590 FIND v(dout0_26) AT=1600.05n

.meas tran vdout0_27ck1590 FIND v(dout0_27) AT=1600.05n

.meas tran vdout0_28ck1590 FIND v(dout0_28) AT=1600.05n

.meas tran vdout0_29ck1590 FIND v(dout0_29) AT=1600.05n

.meas tran vdout0_30ck1590 FIND v(dout0_30) AT=1600.05n

.meas tran vdout0_31ck1590 FIND v(dout0_31) AT=1600.05n

.meas tran vdout0_32ck1590 FIND v(dout0_32) AT=1600.05n

.meas tran vdout0_0ck1610 FIND v(dout0_0) AT=1620.05n

.meas tran vdout0_1ck1610 FIND v(dout0_1) AT=1620.05n

.meas tran vdout0_2ck1610 FIND v(dout0_2) AT=1620.05n

.meas tran vdout0_3ck1610 FIND v(dout0_3) AT=1620.05n

.meas tran vdout0_4ck1610 FIND v(dout0_4) AT=1620.05n

.meas tran vdout0_5ck1610 FIND v(dout0_5) AT=1620.05n

.meas tran vdout0_6ck1610 FIND v(dout0_6) AT=1620.05n

.meas tran vdout0_7ck1610 FIND v(dout0_7) AT=1620.05n

.meas tran vdout0_8ck1610 FIND v(dout0_8) AT=1620.05n

.meas tran vdout0_9ck1610 FIND v(dout0_9) AT=1620.05n

.meas tran vdout0_10ck1610 FIND v(dout0_10) AT=1620.05n

.meas tran vdout0_11ck1610 FIND v(dout0_11) AT=1620.05n

.meas tran vdout0_12ck1610 FIND v(dout0_12) AT=1620.05n

.meas tran vdout0_13ck1610 FIND v(dout0_13) AT=1620.05n

.meas tran vdout0_14ck1610 FIND v(dout0_14) AT=1620.05n

.meas tran vdout0_15ck1610 FIND v(dout0_15) AT=1620.05n

.meas tran vdout0_16ck1610 FIND v(dout0_16) AT=1620.05n

.meas tran vdout0_17ck1610 FIND v(dout0_17) AT=1620.05n

.meas tran vdout0_18ck1610 FIND v(dout0_18) AT=1620.05n

.meas tran vdout0_19ck1610 FIND v(dout0_19) AT=1620.05n

.meas tran vdout0_20ck1610 FIND v(dout0_20) AT=1620.05n

.meas tran vdout0_21ck1610 FIND v(dout0_21) AT=1620.05n

.meas tran vdout0_22ck1610 FIND v(dout0_22) AT=1620.05n

.meas tran vdout0_23ck1610 FIND v(dout0_23) AT=1620.05n

.meas tran vdout0_24ck1610 FIND v(dout0_24) AT=1620.05n

.meas tran vdout0_25ck1610 FIND v(dout0_25) AT=1620.05n

.meas tran vdout0_26ck1610 FIND v(dout0_26) AT=1620.05n

.meas tran vdout0_27ck1610 FIND v(dout0_27) AT=1620.05n

.meas tran vdout0_28ck1610 FIND v(dout0_28) AT=1620.05n

.meas tran vdout0_29ck1610 FIND v(dout0_29) AT=1620.05n

.meas tran vdout0_30ck1610 FIND v(dout0_30) AT=1620.05n

.meas tran vdout0_31ck1610 FIND v(dout0_31) AT=1620.05n

.meas tran vdout0_32ck1610 FIND v(dout0_32) AT=1620.05n

.meas tran vdout0_0ck1640 FIND v(dout0_0) AT=1650.05n

.meas tran vdout0_1ck1640 FIND v(dout0_1) AT=1650.05n

.meas tran vdout0_2ck1640 FIND v(dout0_2) AT=1650.05n

.meas tran vdout0_3ck1640 FIND v(dout0_3) AT=1650.05n

.meas tran vdout0_4ck1640 FIND v(dout0_4) AT=1650.05n

.meas tran vdout0_5ck1640 FIND v(dout0_5) AT=1650.05n

.meas tran vdout0_6ck1640 FIND v(dout0_6) AT=1650.05n

.meas tran vdout0_7ck1640 FIND v(dout0_7) AT=1650.05n

.meas tran vdout0_8ck1640 FIND v(dout0_8) AT=1650.05n

.meas tran vdout0_9ck1640 FIND v(dout0_9) AT=1650.05n

.meas tran vdout0_10ck1640 FIND v(dout0_10) AT=1650.05n

.meas tran vdout0_11ck1640 FIND v(dout0_11) AT=1650.05n

.meas tran vdout0_12ck1640 FIND v(dout0_12) AT=1650.05n

.meas tran vdout0_13ck1640 FIND v(dout0_13) AT=1650.05n

.meas tran vdout0_14ck1640 FIND v(dout0_14) AT=1650.05n

.meas tran vdout0_15ck1640 FIND v(dout0_15) AT=1650.05n

.meas tran vdout0_16ck1640 FIND v(dout0_16) AT=1650.05n

.meas tran vdout0_17ck1640 FIND v(dout0_17) AT=1650.05n

.meas tran vdout0_18ck1640 FIND v(dout0_18) AT=1650.05n

.meas tran vdout0_19ck1640 FIND v(dout0_19) AT=1650.05n

.meas tran vdout0_20ck1640 FIND v(dout0_20) AT=1650.05n

.meas tran vdout0_21ck1640 FIND v(dout0_21) AT=1650.05n

.meas tran vdout0_22ck1640 FIND v(dout0_22) AT=1650.05n

.meas tran vdout0_23ck1640 FIND v(dout0_23) AT=1650.05n

.meas tran vdout0_24ck1640 FIND v(dout0_24) AT=1650.05n

.meas tran vdout0_25ck1640 FIND v(dout0_25) AT=1650.05n

.meas tran vdout0_26ck1640 FIND v(dout0_26) AT=1650.05n

.meas tran vdout0_27ck1640 FIND v(dout0_27) AT=1650.05n

.meas tran vdout0_28ck1640 FIND v(dout0_28) AT=1650.05n

.meas tran vdout0_29ck1640 FIND v(dout0_29) AT=1650.05n

.meas tran vdout0_30ck1640 FIND v(dout0_30) AT=1650.05n

.meas tran vdout0_31ck1640 FIND v(dout0_31) AT=1650.05n

.meas tran vdout0_32ck1640 FIND v(dout0_32) AT=1650.05n

.meas tran vdout0_0ck1660 FIND v(dout0_0) AT=1670.05n

.meas tran vdout0_1ck1660 FIND v(dout0_1) AT=1670.05n

.meas tran vdout0_2ck1660 FIND v(dout0_2) AT=1670.05n

.meas tran vdout0_3ck1660 FIND v(dout0_3) AT=1670.05n

.meas tran vdout0_4ck1660 FIND v(dout0_4) AT=1670.05n

.meas tran vdout0_5ck1660 FIND v(dout0_5) AT=1670.05n

.meas tran vdout0_6ck1660 FIND v(dout0_6) AT=1670.05n

.meas tran vdout0_7ck1660 FIND v(dout0_7) AT=1670.05n

.meas tran vdout0_8ck1660 FIND v(dout0_8) AT=1670.05n

.meas tran vdout0_9ck1660 FIND v(dout0_9) AT=1670.05n

.meas tran vdout0_10ck1660 FIND v(dout0_10) AT=1670.05n

.meas tran vdout0_11ck1660 FIND v(dout0_11) AT=1670.05n

.meas tran vdout0_12ck1660 FIND v(dout0_12) AT=1670.05n

.meas tran vdout0_13ck1660 FIND v(dout0_13) AT=1670.05n

.meas tran vdout0_14ck1660 FIND v(dout0_14) AT=1670.05n

.meas tran vdout0_15ck1660 FIND v(dout0_15) AT=1670.05n

.meas tran vdout0_16ck1660 FIND v(dout0_16) AT=1670.05n

.meas tran vdout0_17ck1660 FIND v(dout0_17) AT=1670.05n

.meas tran vdout0_18ck1660 FIND v(dout0_18) AT=1670.05n

.meas tran vdout0_19ck1660 FIND v(dout0_19) AT=1670.05n

.meas tran vdout0_20ck1660 FIND v(dout0_20) AT=1670.05n

.meas tran vdout0_21ck1660 FIND v(dout0_21) AT=1670.05n

.meas tran vdout0_22ck1660 FIND v(dout0_22) AT=1670.05n

.meas tran vdout0_23ck1660 FIND v(dout0_23) AT=1670.05n

.meas tran vdout0_24ck1660 FIND v(dout0_24) AT=1670.05n

.meas tran vdout0_25ck1660 FIND v(dout0_25) AT=1670.05n

.meas tran vdout0_26ck1660 FIND v(dout0_26) AT=1670.05n

.meas tran vdout0_27ck1660 FIND v(dout0_27) AT=1670.05n

.meas tran vdout0_28ck1660 FIND v(dout0_28) AT=1670.05n

.meas tran vdout0_29ck1660 FIND v(dout0_29) AT=1670.05n

.meas tran vdout0_30ck1660 FIND v(dout0_30) AT=1670.05n

.meas tran vdout0_31ck1660 FIND v(dout0_31) AT=1670.05n

.meas tran vdout0_32ck1660 FIND v(dout0_32) AT=1670.05n

.meas tran vdout0_0ck1680 FIND v(dout0_0) AT=1690.05n

.meas tran vdout0_1ck1680 FIND v(dout0_1) AT=1690.05n

.meas tran vdout0_2ck1680 FIND v(dout0_2) AT=1690.05n

.meas tran vdout0_3ck1680 FIND v(dout0_3) AT=1690.05n

.meas tran vdout0_4ck1680 FIND v(dout0_4) AT=1690.05n

.meas tran vdout0_5ck1680 FIND v(dout0_5) AT=1690.05n

.meas tran vdout0_6ck1680 FIND v(dout0_6) AT=1690.05n

.meas tran vdout0_7ck1680 FIND v(dout0_7) AT=1690.05n

.meas tran vdout0_8ck1680 FIND v(dout0_8) AT=1690.05n

.meas tran vdout0_9ck1680 FIND v(dout0_9) AT=1690.05n

.meas tran vdout0_10ck1680 FIND v(dout0_10) AT=1690.05n

.meas tran vdout0_11ck1680 FIND v(dout0_11) AT=1690.05n

.meas tran vdout0_12ck1680 FIND v(dout0_12) AT=1690.05n

.meas tran vdout0_13ck1680 FIND v(dout0_13) AT=1690.05n

.meas tran vdout0_14ck1680 FIND v(dout0_14) AT=1690.05n

.meas tran vdout0_15ck1680 FIND v(dout0_15) AT=1690.05n

.meas tran vdout0_16ck1680 FIND v(dout0_16) AT=1690.05n

.meas tran vdout0_17ck1680 FIND v(dout0_17) AT=1690.05n

.meas tran vdout0_18ck1680 FIND v(dout0_18) AT=1690.05n

.meas tran vdout0_19ck1680 FIND v(dout0_19) AT=1690.05n

.meas tran vdout0_20ck1680 FIND v(dout0_20) AT=1690.05n

.meas tran vdout0_21ck1680 FIND v(dout0_21) AT=1690.05n

.meas tran vdout0_22ck1680 FIND v(dout0_22) AT=1690.05n

.meas tran vdout0_23ck1680 FIND v(dout0_23) AT=1690.05n

.meas tran vdout0_24ck1680 FIND v(dout0_24) AT=1690.05n

.meas tran vdout0_25ck1680 FIND v(dout0_25) AT=1690.05n

.meas tran vdout0_26ck1680 FIND v(dout0_26) AT=1690.05n

.meas tran vdout0_27ck1680 FIND v(dout0_27) AT=1690.05n

.meas tran vdout0_28ck1680 FIND v(dout0_28) AT=1690.05n

.meas tran vdout0_29ck1680 FIND v(dout0_29) AT=1690.05n

.meas tran vdout0_30ck1680 FIND v(dout0_30) AT=1690.05n

.meas tran vdout0_31ck1680 FIND v(dout0_31) AT=1690.05n

.meas tran vdout0_32ck1680 FIND v(dout0_32) AT=1690.05n

.meas tran vdout0_0ck1710 FIND v(dout0_0) AT=1720.05n

.meas tran vdout0_1ck1710 FIND v(dout0_1) AT=1720.05n

.meas tran vdout0_2ck1710 FIND v(dout0_2) AT=1720.05n

.meas tran vdout0_3ck1710 FIND v(dout0_3) AT=1720.05n

.meas tran vdout0_4ck1710 FIND v(dout0_4) AT=1720.05n

.meas tran vdout0_5ck1710 FIND v(dout0_5) AT=1720.05n

.meas tran vdout0_6ck1710 FIND v(dout0_6) AT=1720.05n

.meas tran vdout0_7ck1710 FIND v(dout0_7) AT=1720.05n

.meas tran vdout0_8ck1710 FIND v(dout0_8) AT=1720.05n

.meas tran vdout0_9ck1710 FIND v(dout0_9) AT=1720.05n

.meas tran vdout0_10ck1710 FIND v(dout0_10) AT=1720.05n

.meas tran vdout0_11ck1710 FIND v(dout0_11) AT=1720.05n

.meas tran vdout0_12ck1710 FIND v(dout0_12) AT=1720.05n

.meas tran vdout0_13ck1710 FIND v(dout0_13) AT=1720.05n

.meas tran vdout0_14ck1710 FIND v(dout0_14) AT=1720.05n

.meas tran vdout0_15ck1710 FIND v(dout0_15) AT=1720.05n

.meas tran vdout0_16ck1710 FIND v(dout0_16) AT=1720.05n

.meas tran vdout0_17ck1710 FIND v(dout0_17) AT=1720.05n

.meas tran vdout0_18ck1710 FIND v(dout0_18) AT=1720.05n

.meas tran vdout0_19ck1710 FIND v(dout0_19) AT=1720.05n

.meas tran vdout0_20ck1710 FIND v(dout0_20) AT=1720.05n

.meas tran vdout0_21ck1710 FIND v(dout0_21) AT=1720.05n

.meas tran vdout0_22ck1710 FIND v(dout0_22) AT=1720.05n

.meas tran vdout0_23ck1710 FIND v(dout0_23) AT=1720.05n

.meas tran vdout0_24ck1710 FIND v(dout0_24) AT=1720.05n

.meas tran vdout0_25ck1710 FIND v(dout0_25) AT=1720.05n

.meas tran vdout0_26ck1710 FIND v(dout0_26) AT=1720.05n

.meas tran vdout0_27ck1710 FIND v(dout0_27) AT=1720.05n

.meas tran vdout0_28ck1710 FIND v(dout0_28) AT=1720.05n

.meas tran vdout0_29ck1710 FIND v(dout0_29) AT=1720.05n

.meas tran vdout0_30ck1710 FIND v(dout0_30) AT=1720.05n

.meas tran vdout0_31ck1710 FIND v(dout0_31) AT=1720.05n

.meas tran vdout0_32ck1710 FIND v(dout0_32) AT=1720.05n

.meas tran vdout0_0ck1720 FIND v(dout0_0) AT=1730.05n

.meas tran vdout0_1ck1720 FIND v(dout0_1) AT=1730.05n

.meas tran vdout0_2ck1720 FIND v(dout0_2) AT=1730.05n

.meas tran vdout0_3ck1720 FIND v(dout0_3) AT=1730.05n

.meas tran vdout0_4ck1720 FIND v(dout0_4) AT=1730.05n

.meas tran vdout0_5ck1720 FIND v(dout0_5) AT=1730.05n

.meas tran vdout0_6ck1720 FIND v(dout0_6) AT=1730.05n

.meas tran vdout0_7ck1720 FIND v(dout0_7) AT=1730.05n

.meas tran vdout0_8ck1720 FIND v(dout0_8) AT=1730.05n

.meas tran vdout0_9ck1720 FIND v(dout0_9) AT=1730.05n

.meas tran vdout0_10ck1720 FIND v(dout0_10) AT=1730.05n

.meas tran vdout0_11ck1720 FIND v(dout0_11) AT=1730.05n

.meas tran vdout0_12ck1720 FIND v(dout0_12) AT=1730.05n

.meas tran vdout0_13ck1720 FIND v(dout0_13) AT=1730.05n

.meas tran vdout0_14ck1720 FIND v(dout0_14) AT=1730.05n

.meas tran vdout0_15ck1720 FIND v(dout0_15) AT=1730.05n

.meas tran vdout0_16ck1720 FIND v(dout0_16) AT=1730.05n

.meas tran vdout0_17ck1720 FIND v(dout0_17) AT=1730.05n

.meas tran vdout0_18ck1720 FIND v(dout0_18) AT=1730.05n

.meas tran vdout0_19ck1720 FIND v(dout0_19) AT=1730.05n

.meas tran vdout0_20ck1720 FIND v(dout0_20) AT=1730.05n

.meas tran vdout0_21ck1720 FIND v(dout0_21) AT=1730.05n

.meas tran vdout0_22ck1720 FIND v(dout0_22) AT=1730.05n

.meas tran vdout0_23ck1720 FIND v(dout0_23) AT=1730.05n

.meas tran vdout0_24ck1720 FIND v(dout0_24) AT=1730.05n

.meas tran vdout0_25ck1720 FIND v(dout0_25) AT=1730.05n

.meas tran vdout0_26ck1720 FIND v(dout0_26) AT=1730.05n

.meas tran vdout0_27ck1720 FIND v(dout0_27) AT=1730.05n

.meas tran vdout0_28ck1720 FIND v(dout0_28) AT=1730.05n

.meas tran vdout0_29ck1720 FIND v(dout0_29) AT=1730.05n

.meas tran vdout0_30ck1720 FIND v(dout0_30) AT=1730.05n

.meas tran vdout0_31ck1720 FIND v(dout0_31) AT=1730.05n

.meas tran vdout0_32ck1720 FIND v(dout0_32) AT=1730.05n

.meas tran vdout0_0ck1730 FIND v(dout0_0) AT=1740.05n

.meas tran vdout0_1ck1730 FIND v(dout0_1) AT=1740.05n

.meas tran vdout0_2ck1730 FIND v(dout0_2) AT=1740.05n

.meas tran vdout0_3ck1730 FIND v(dout0_3) AT=1740.05n

.meas tran vdout0_4ck1730 FIND v(dout0_4) AT=1740.05n

.meas tran vdout0_5ck1730 FIND v(dout0_5) AT=1740.05n

.meas tran vdout0_6ck1730 FIND v(dout0_6) AT=1740.05n

.meas tran vdout0_7ck1730 FIND v(dout0_7) AT=1740.05n

.meas tran vdout0_8ck1730 FIND v(dout0_8) AT=1740.05n

.meas tran vdout0_9ck1730 FIND v(dout0_9) AT=1740.05n

.meas tran vdout0_10ck1730 FIND v(dout0_10) AT=1740.05n

.meas tran vdout0_11ck1730 FIND v(dout0_11) AT=1740.05n

.meas tran vdout0_12ck1730 FIND v(dout0_12) AT=1740.05n

.meas tran vdout0_13ck1730 FIND v(dout0_13) AT=1740.05n

.meas tran vdout0_14ck1730 FIND v(dout0_14) AT=1740.05n

.meas tran vdout0_15ck1730 FIND v(dout0_15) AT=1740.05n

.meas tran vdout0_16ck1730 FIND v(dout0_16) AT=1740.05n

.meas tran vdout0_17ck1730 FIND v(dout0_17) AT=1740.05n

.meas tran vdout0_18ck1730 FIND v(dout0_18) AT=1740.05n

.meas tran vdout0_19ck1730 FIND v(dout0_19) AT=1740.05n

.meas tran vdout0_20ck1730 FIND v(dout0_20) AT=1740.05n

.meas tran vdout0_21ck1730 FIND v(dout0_21) AT=1740.05n

.meas tran vdout0_22ck1730 FIND v(dout0_22) AT=1740.05n

.meas tran vdout0_23ck1730 FIND v(dout0_23) AT=1740.05n

.meas tran vdout0_24ck1730 FIND v(dout0_24) AT=1740.05n

.meas tran vdout0_25ck1730 FIND v(dout0_25) AT=1740.05n

.meas tran vdout0_26ck1730 FIND v(dout0_26) AT=1740.05n

.meas tran vdout0_27ck1730 FIND v(dout0_27) AT=1740.05n

.meas tran vdout0_28ck1730 FIND v(dout0_28) AT=1740.05n

.meas tran vdout0_29ck1730 FIND v(dout0_29) AT=1740.05n

.meas tran vdout0_30ck1730 FIND v(dout0_30) AT=1740.05n

.meas tran vdout0_31ck1730 FIND v(dout0_31) AT=1740.05n

.meas tran vdout0_32ck1730 FIND v(dout0_32) AT=1740.05n

.meas tran vdout0_0ck1740 FIND v(dout0_0) AT=1750.05n

.meas tran vdout0_1ck1740 FIND v(dout0_1) AT=1750.05n

.meas tran vdout0_2ck1740 FIND v(dout0_2) AT=1750.05n

.meas tran vdout0_3ck1740 FIND v(dout0_3) AT=1750.05n

.meas tran vdout0_4ck1740 FIND v(dout0_4) AT=1750.05n

.meas tran vdout0_5ck1740 FIND v(dout0_5) AT=1750.05n

.meas tran vdout0_6ck1740 FIND v(dout0_6) AT=1750.05n

.meas tran vdout0_7ck1740 FIND v(dout0_7) AT=1750.05n

.meas tran vdout0_8ck1740 FIND v(dout0_8) AT=1750.05n

.meas tran vdout0_9ck1740 FIND v(dout0_9) AT=1750.05n

.meas tran vdout0_10ck1740 FIND v(dout0_10) AT=1750.05n

.meas tran vdout0_11ck1740 FIND v(dout0_11) AT=1750.05n

.meas tran vdout0_12ck1740 FIND v(dout0_12) AT=1750.05n

.meas tran vdout0_13ck1740 FIND v(dout0_13) AT=1750.05n

.meas tran vdout0_14ck1740 FIND v(dout0_14) AT=1750.05n

.meas tran vdout0_15ck1740 FIND v(dout0_15) AT=1750.05n

.meas tran vdout0_16ck1740 FIND v(dout0_16) AT=1750.05n

.meas tran vdout0_17ck1740 FIND v(dout0_17) AT=1750.05n

.meas tran vdout0_18ck1740 FIND v(dout0_18) AT=1750.05n

.meas tran vdout0_19ck1740 FIND v(dout0_19) AT=1750.05n

.meas tran vdout0_20ck1740 FIND v(dout0_20) AT=1750.05n

.meas tran vdout0_21ck1740 FIND v(dout0_21) AT=1750.05n

.meas tran vdout0_22ck1740 FIND v(dout0_22) AT=1750.05n

.meas tran vdout0_23ck1740 FIND v(dout0_23) AT=1750.05n

.meas tran vdout0_24ck1740 FIND v(dout0_24) AT=1750.05n

.meas tran vdout0_25ck1740 FIND v(dout0_25) AT=1750.05n

.meas tran vdout0_26ck1740 FIND v(dout0_26) AT=1750.05n

.meas tran vdout0_27ck1740 FIND v(dout0_27) AT=1750.05n

.meas tran vdout0_28ck1740 FIND v(dout0_28) AT=1750.05n

.meas tran vdout0_29ck1740 FIND v(dout0_29) AT=1750.05n

.meas tran vdout0_30ck1740 FIND v(dout0_30) AT=1750.05n

.meas tran vdout0_31ck1740 FIND v(dout0_31) AT=1750.05n

.meas tran vdout0_32ck1740 FIND v(dout0_32) AT=1750.05n

.meas tran vdout0_0ck1770 FIND v(dout0_0) AT=1780.05n

.meas tran vdout0_1ck1770 FIND v(dout0_1) AT=1780.05n

.meas tran vdout0_2ck1770 FIND v(dout0_2) AT=1780.05n

.meas tran vdout0_3ck1770 FIND v(dout0_3) AT=1780.05n

.meas tran vdout0_4ck1770 FIND v(dout0_4) AT=1780.05n

.meas tran vdout0_5ck1770 FIND v(dout0_5) AT=1780.05n

.meas tran vdout0_6ck1770 FIND v(dout0_6) AT=1780.05n

.meas tran vdout0_7ck1770 FIND v(dout0_7) AT=1780.05n

.meas tran vdout0_8ck1770 FIND v(dout0_8) AT=1780.05n

.meas tran vdout0_9ck1770 FIND v(dout0_9) AT=1780.05n

.meas tran vdout0_10ck1770 FIND v(dout0_10) AT=1780.05n

.meas tran vdout0_11ck1770 FIND v(dout0_11) AT=1780.05n

.meas tran vdout0_12ck1770 FIND v(dout0_12) AT=1780.05n

.meas tran vdout0_13ck1770 FIND v(dout0_13) AT=1780.05n

.meas tran vdout0_14ck1770 FIND v(dout0_14) AT=1780.05n

.meas tran vdout0_15ck1770 FIND v(dout0_15) AT=1780.05n

.meas tran vdout0_16ck1770 FIND v(dout0_16) AT=1780.05n

.meas tran vdout0_17ck1770 FIND v(dout0_17) AT=1780.05n

.meas tran vdout0_18ck1770 FIND v(dout0_18) AT=1780.05n

.meas tran vdout0_19ck1770 FIND v(dout0_19) AT=1780.05n

.meas tran vdout0_20ck1770 FIND v(dout0_20) AT=1780.05n

.meas tran vdout0_21ck1770 FIND v(dout0_21) AT=1780.05n

.meas tran vdout0_22ck1770 FIND v(dout0_22) AT=1780.05n

.meas tran vdout0_23ck1770 FIND v(dout0_23) AT=1780.05n

.meas tran vdout0_24ck1770 FIND v(dout0_24) AT=1780.05n

.meas tran vdout0_25ck1770 FIND v(dout0_25) AT=1780.05n

.meas tran vdout0_26ck1770 FIND v(dout0_26) AT=1780.05n

.meas tran vdout0_27ck1770 FIND v(dout0_27) AT=1780.05n

.meas tran vdout0_28ck1770 FIND v(dout0_28) AT=1780.05n

.meas tran vdout0_29ck1770 FIND v(dout0_29) AT=1780.05n

.meas tran vdout0_30ck1770 FIND v(dout0_30) AT=1780.05n

.meas tran vdout0_31ck1770 FIND v(dout0_31) AT=1780.05n

.meas tran vdout0_32ck1770 FIND v(dout0_32) AT=1780.05n

.meas tran vdout0_0ck1810 FIND v(dout0_0) AT=1820.05n

.meas tran vdout0_1ck1810 FIND v(dout0_1) AT=1820.05n

.meas tran vdout0_2ck1810 FIND v(dout0_2) AT=1820.05n

.meas tran vdout0_3ck1810 FIND v(dout0_3) AT=1820.05n

.meas tran vdout0_4ck1810 FIND v(dout0_4) AT=1820.05n

.meas tran vdout0_5ck1810 FIND v(dout0_5) AT=1820.05n

.meas tran vdout0_6ck1810 FIND v(dout0_6) AT=1820.05n

.meas tran vdout0_7ck1810 FIND v(dout0_7) AT=1820.05n

.meas tran vdout0_8ck1810 FIND v(dout0_8) AT=1820.05n

.meas tran vdout0_9ck1810 FIND v(dout0_9) AT=1820.05n

.meas tran vdout0_10ck1810 FIND v(dout0_10) AT=1820.05n

.meas tran vdout0_11ck1810 FIND v(dout0_11) AT=1820.05n

.meas tran vdout0_12ck1810 FIND v(dout0_12) AT=1820.05n

.meas tran vdout0_13ck1810 FIND v(dout0_13) AT=1820.05n

.meas tran vdout0_14ck1810 FIND v(dout0_14) AT=1820.05n

.meas tran vdout0_15ck1810 FIND v(dout0_15) AT=1820.05n

.meas tran vdout0_16ck1810 FIND v(dout0_16) AT=1820.05n

.meas tran vdout0_17ck1810 FIND v(dout0_17) AT=1820.05n

.meas tran vdout0_18ck1810 FIND v(dout0_18) AT=1820.05n

.meas tran vdout0_19ck1810 FIND v(dout0_19) AT=1820.05n

.meas tran vdout0_20ck1810 FIND v(dout0_20) AT=1820.05n

.meas tran vdout0_21ck1810 FIND v(dout0_21) AT=1820.05n

.meas tran vdout0_22ck1810 FIND v(dout0_22) AT=1820.05n

.meas tran vdout0_23ck1810 FIND v(dout0_23) AT=1820.05n

.meas tran vdout0_24ck1810 FIND v(dout0_24) AT=1820.05n

.meas tran vdout0_25ck1810 FIND v(dout0_25) AT=1820.05n

.meas tran vdout0_26ck1810 FIND v(dout0_26) AT=1820.05n

.meas tran vdout0_27ck1810 FIND v(dout0_27) AT=1820.05n

.meas tran vdout0_28ck1810 FIND v(dout0_28) AT=1820.05n

.meas tran vdout0_29ck1810 FIND v(dout0_29) AT=1820.05n

.meas tran vdout0_30ck1810 FIND v(dout0_30) AT=1820.05n

.meas tran vdout0_31ck1810 FIND v(dout0_31) AT=1820.05n

.meas tran vdout0_32ck1810 FIND v(dout0_32) AT=1820.05n

.meas tran vdout0_0ck1820 FIND v(dout0_0) AT=1830.05n

.meas tran vdout0_1ck1820 FIND v(dout0_1) AT=1830.05n

.meas tran vdout0_2ck1820 FIND v(dout0_2) AT=1830.05n

.meas tran vdout0_3ck1820 FIND v(dout0_3) AT=1830.05n

.meas tran vdout0_4ck1820 FIND v(dout0_4) AT=1830.05n

.meas tran vdout0_5ck1820 FIND v(dout0_5) AT=1830.05n

.meas tran vdout0_6ck1820 FIND v(dout0_6) AT=1830.05n

.meas tran vdout0_7ck1820 FIND v(dout0_7) AT=1830.05n

.meas tran vdout0_8ck1820 FIND v(dout0_8) AT=1830.05n

.meas tran vdout0_9ck1820 FIND v(dout0_9) AT=1830.05n

.meas tran vdout0_10ck1820 FIND v(dout0_10) AT=1830.05n

.meas tran vdout0_11ck1820 FIND v(dout0_11) AT=1830.05n

.meas tran vdout0_12ck1820 FIND v(dout0_12) AT=1830.05n

.meas tran vdout0_13ck1820 FIND v(dout0_13) AT=1830.05n

.meas tran vdout0_14ck1820 FIND v(dout0_14) AT=1830.05n

.meas tran vdout0_15ck1820 FIND v(dout0_15) AT=1830.05n

.meas tran vdout0_16ck1820 FIND v(dout0_16) AT=1830.05n

.meas tran vdout0_17ck1820 FIND v(dout0_17) AT=1830.05n

.meas tran vdout0_18ck1820 FIND v(dout0_18) AT=1830.05n

.meas tran vdout0_19ck1820 FIND v(dout0_19) AT=1830.05n

.meas tran vdout0_20ck1820 FIND v(dout0_20) AT=1830.05n

.meas tran vdout0_21ck1820 FIND v(dout0_21) AT=1830.05n

.meas tran vdout0_22ck1820 FIND v(dout0_22) AT=1830.05n

.meas tran vdout0_23ck1820 FIND v(dout0_23) AT=1830.05n

.meas tran vdout0_24ck1820 FIND v(dout0_24) AT=1830.05n

.meas tran vdout0_25ck1820 FIND v(dout0_25) AT=1830.05n

.meas tran vdout0_26ck1820 FIND v(dout0_26) AT=1830.05n

.meas tran vdout0_27ck1820 FIND v(dout0_27) AT=1830.05n

.meas tran vdout0_28ck1820 FIND v(dout0_28) AT=1830.05n

.meas tran vdout0_29ck1820 FIND v(dout0_29) AT=1830.05n

.meas tran vdout0_30ck1820 FIND v(dout0_30) AT=1830.05n

.meas tran vdout0_31ck1820 FIND v(dout0_31) AT=1830.05n

.meas tran vdout0_32ck1820 FIND v(dout0_32) AT=1830.05n

.meas tran vdout0_0ck1890 FIND v(dout0_0) AT=1900.05n

.meas tran vdout0_1ck1890 FIND v(dout0_1) AT=1900.05n

.meas tran vdout0_2ck1890 FIND v(dout0_2) AT=1900.05n

.meas tran vdout0_3ck1890 FIND v(dout0_3) AT=1900.05n

.meas tran vdout0_4ck1890 FIND v(dout0_4) AT=1900.05n

.meas tran vdout0_5ck1890 FIND v(dout0_5) AT=1900.05n

.meas tran vdout0_6ck1890 FIND v(dout0_6) AT=1900.05n

.meas tran vdout0_7ck1890 FIND v(dout0_7) AT=1900.05n

.meas tran vdout0_8ck1890 FIND v(dout0_8) AT=1900.05n

.meas tran vdout0_9ck1890 FIND v(dout0_9) AT=1900.05n

.meas tran vdout0_10ck1890 FIND v(dout0_10) AT=1900.05n

.meas tran vdout0_11ck1890 FIND v(dout0_11) AT=1900.05n

.meas tran vdout0_12ck1890 FIND v(dout0_12) AT=1900.05n

.meas tran vdout0_13ck1890 FIND v(dout0_13) AT=1900.05n

.meas tran vdout0_14ck1890 FIND v(dout0_14) AT=1900.05n

.meas tran vdout0_15ck1890 FIND v(dout0_15) AT=1900.05n

.meas tran vdout0_16ck1890 FIND v(dout0_16) AT=1900.05n

.meas tran vdout0_17ck1890 FIND v(dout0_17) AT=1900.05n

.meas tran vdout0_18ck1890 FIND v(dout0_18) AT=1900.05n

.meas tran vdout0_19ck1890 FIND v(dout0_19) AT=1900.05n

.meas tran vdout0_20ck1890 FIND v(dout0_20) AT=1900.05n

.meas tran vdout0_21ck1890 FIND v(dout0_21) AT=1900.05n

.meas tran vdout0_22ck1890 FIND v(dout0_22) AT=1900.05n

.meas tran vdout0_23ck1890 FIND v(dout0_23) AT=1900.05n

.meas tran vdout0_24ck1890 FIND v(dout0_24) AT=1900.05n

.meas tran vdout0_25ck1890 FIND v(dout0_25) AT=1900.05n

.meas tran vdout0_26ck1890 FIND v(dout0_26) AT=1900.05n

.meas tran vdout0_27ck1890 FIND v(dout0_27) AT=1900.05n

.meas tran vdout0_28ck1890 FIND v(dout0_28) AT=1900.05n

.meas tran vdout0_29ck1890 FIND v(dout0_29) AT=1900.05n

.meas tran vdout0_30ck1890 FIND v(dout0_30) AT=1900.05n

.meas tran vdout0_31ck1890 FIND v(dout0_31) AT=1900.05n

.meas tran vdout0_32ck1890 FIND v(dout0_32) AT=1900.05n

.meas tran vdout0_0ck1910 FIND v(dout0_0) AT=1920.05n

.meas tran vdout0_1ck1910 FIND v(dout0_1) AT=1920.05n

.meas tran vdout0_2ck1910 FIND v(dout0_2) AT=1920.05n

.meas tran vdout0_3ck1910 FIND v(dout0_3) AT=1920.05n

.meas tran vdout0_4ck1910 FIND v(dout0_4) AT=1920.05n

.meas tran vdout0_5ck1910 FIND v(dout0_5) AT=1920.05n

.meas tran vdout0_6ck1910 FIND v(dout0_6) AT=1920.05n

.meas tran vdout0_7ck1910 FIND v(dout0_7) AT=1920.05n

.meas tran vdout0_8ck1910 FIND v(dout0_8) AT=1920.05n

.meas tran vdout0_9ck1910 FIND v(dout0_9) AT=1920.05n

.meas tran vdout0_10ck1910 FIND v(dout0_10) AT=1920.05n

.meas tran vdout0_11ck1910 FIND v(dout0_11) AT=1920.05n

.meas tran vdout0_12ck1910 FIND v(dout0_12) AT=1920.05n

.meas tran vdout0_13ck1910 FIND v(dout0_13) AT=1920.05n

.meas tran vdout0_14ck1910 FIND v(dout0_14) AT=1920.05n

.meas tran vdout0_15ck1910 FIND v(dout0_15) AT=1920.05n

.meas tran vdout0_16ck1910 FIND v(dout0_16) AT=1920.05n

.meas tran vdout0_17ck1910 FIND v(dout0_17) AT=1920.05n

.meas tran vdout0_18ck1910 FIND v(dout0_18) AT=1920.05n

.meas tran vdout0_19ck1910 FIND v(dout0_19) AT=1920.05n

.meas tran vdout0_20ck1910 FIND v(dout0_20) AT=1920.05n

.meas tran vdout0_21ck1910 FIND v(dout0_21) AT=1920.05n

.meas tran vdout0_22ck1910 FIND v(dout0_22) AT=1920.05n

.meas tran vdout0_23ck1910 FIND v(dout0_23) AT=1920.05n

.meas tran vdout0_24ck1910 FIND v(dout0_24) AT=1920.05n

.meas tran vdout0_25ck1910 FIND v(dout0_25) AT=1920.05n

.meas tran vdout0_26ck1910 FIND v(dout0_26) AT=1920.05n

.meas tran vdout0_27ck1910 FIND v(dout0_27) AT=1920.05n

.meas tran vdout0_28ck1910 FIND v(dout0_28) AT=1920.05n

.meas tran vdout0_29ck1910 FIND v(dout0_29) AT=1920.05n

.meas tran vdout0_30ck1910 FIND v(dout0_30) AT=1920.05n

.meas tran vdout0_31ck1910 FIND v(dout0_31) AT=1920.05n

.meas tran vdout0_32ck1910 FIND v(dout0_32) AT=1920.05n

.meas tran vdout0_0ck1920 FIND v(dout0_0) AT=1930.05n

.meas tran vdout0_1ck1920 FIND v(dout0_1) AT=1930.05n

.meas tran vdout0_2ck1920 FIND v(dout0_2) AT=1930.05n

.meas tran vdout0_3ck1920 FIND v(dout0_3) AT=1930.05n

.meas tran vdout0_4ck1920 FIND v(dout0_4) AT=1930.05n

.meas tran vdout0_5ck1920 FIND v(dout0_5) AT=1930.05n

.meas tran vdout0_6ck1920 FIND v(dout0_6) AT=1930.05n

.meas tran vdout0_7ck1920 FIND v(dout0_7) AT=1930.05n

.meas tran vdout0_8ck1920 FIND v(dout0_8) AT=1930.05n

.meas tran vdout0_9ck1920 FIND v(dout0_9) AT=1930.05n

.meas tran vdout0_10ck1920 FIND v(dout0_10) AT=1930.05n

.meas tran vdout0_11ck1920 FIND v(dout0_11) AT=1930.05n

.meas tran vdout0_12ck1920 FIND v(dout0_12) AT=1930.05n

.meas tran vdout0_13ck1920 FIND v(dout0_13) AT=1930.05n

.meas tran vdout0_14ck1920 FIND v(dout0_14) AT=1930.05n

.meas tran vdout0_15ck1920 FIND v(dout0_15) AT=1930.05n

.meas tran vdout0_16ck1920 FIND v(dout0_16) AT=1930.05n

.meas tran vdout0_17ck1920 FIND v(dout0_17) AT=1930.05n

.meas tran vdout0_18ck1920 FIND v(dout0_18) AT=1930.05n

.meas tran vdout0_19ck1920 FIND v(dout0_19) AT=1930.05n

.meas tran vdout0_20ck1920 FIND v(dout0_20) AT=1930.05n

.meas tran vdout0_21ck1920 FIND v(dout0_21) AT=1930.05n

.meas tran vdout0_22ck1920 FIND v(dout0_22) AT=1930.05n

.meas tran vdout0_23ck1920 FIND v(dout0_23) AT=1930.05n

.meas tran vdout0_24ck1920 FIND v(dout0_24) AT=1930.05n

.meas tran vdout0_25ck1920 FIND v(dout0_25) AT=1930.05n

.meas tran vdout0_26ck1920 FIND v(dout0_26) AT=1930.05n

.meas tran vdout0_27ck1920 FIND v(dout0_27) AT=1930.05n

.meas tran vdout0_28ck1920 FIND v(dout0_28) AT=1930.05n

.meas tran vdout0_29ck1920 FIND v(dout0_29) AT=1930.05n

.meas tran vdout0_30ck1920 FIND v(dout0_30) AT=1930.05n

.meas tran vdout0_31ck1920 FIND v(dout0_31) AT=1930.05n

.meas tran vdout0_32ck1920 FIND v(dout0_32) AT=1930.05n

.meas tran vdout0_0ck1940 FIND v(dout0_0) AT=1950.05n

.meas tran vdout0_1ck1940 FIND v(dout0_1) AT=1950.05n

.meas tran vdout0_2ck1940 FIND v(dout0_2) AT=1950.05n

.meas tran vdout0_3ck1940 FIND v(dout0_3) AT=1950.05n

.meas tran vdout0_4ck1940 FIND v(dout0_4) AT=1950.05n

.meas tran vdout0_5ck1940 FIND v(dout0_5) AT=1950.05n

.meas tran vdout0_6ck1940 FIND v(dout0_6) AT=1950.05n

.meas tran vdout0_7ck1940 FIND v(dout0_7) AT=1950.05n

.meas tran vdout0_8ck1940 FIND v(dout0_8) AT=1950.05n

.meas tran vdout0_9ck1940 FIND v(dout0_9) AT=1950.05n

.meas tran vdout0_10ck1940 FIND v(dout0_10) AT=1950.05n

.meas tran vdout0_11ck1940 FIND v(dout0_11) AT=1950.05n

.meas tran vdout0_12ck1940 FIND v(dout0_12) AT=1950.05n

.meas tran vdout0_13ck1940 FIND v(dout0_13) AT=1950.05n

.meas tran vdout0_14ck1940 FIND v(dout0_14) AT=1950.05n

.meas tran vdout0_15ck1940 FIND v(dout0_15) AT=1950.05n

.meas tran vdout0_16ck1940 FIND v(dout0_16) AT=1950.05n

.meas tran vdout0_17ck1940 FIND v(dout0_17) AT=1950.05n

.meas tran vdout0_18ck1940 FIND v(dout0_18) AT=1950.05n

.meas tran vdout0_19ck1940 FIND v(dout0_19) AT=1950.05n

.meas tran vdout0_20ck1940 FIND v(dout0_20) AT=1950.05n

.meas tran vdout0_21ck1940 FIND v(dout0_21) AT=1950.05n

.meas tran vdout0_22ck1940 FIND v(dout0_22) AT=1950.05n

.meas tran vdout0_23ck1940 FIND v(dout0_23) AT=1950.05n

.meas tran vdout0_24ck1940 FIND v(dout0_24) AT=1950.05n

.meas tran vdout0_25ck1940 FIND v(dout0_25) AT=1950.05n

.meas tran vdout0_26ck1940 FIND v(dout0_26) AT=1950.05n

.meas tran vdout0_27ck1940 FIND v(dout0_27) AT=1950.05n

.meas tran vdout0_28ck1940 FIND v(dout0_28) AT=1950.05n

.meas tran vdout0_29ck1940 FIND v(dout0_29) AT=1950.05n

.meas tran vdout0_30ck1940 FIND v(dout0_30) AT=1950.05n

.meas tran vdout0_31ck1940 FIND v(dout0_31) AT=1950.05n

.meas tran vdout0_32ck1940 FIND v(dout0_32) AT=1950.05n

.meas tran vdout0_0ck1970 FIND v(dout0_0) AT=1980.05n

.meas tran vdout0_1ck1970 FIND v(dout0_1) AT=1980.05n

.meas tran vdout0_2ck1970 FIND v(dout0_2) AT=1980.05n

.meas tran vdout0_3ck1970 FIND v(dout0_3) AT=1980.05n

.meas tran vdout0_4ck1970 FIND v(dout0_4) AT=1980.05n

.meas tran vdout0_5ck1970 FIND v(dout0_5) AT=1980.05n

.meas tran vdout0_6ck1970 FIND v(dout0_6) AT=1980.05n

.meas tran vdout0_7ck1970 FIND v(dout0_7) AT=1980.05n

.meas tran vdout0_8ck1970 FIND v(dout0_8) AT=1980.05n

.meas tran vdout0_9ck1970 FIND v(dout0_9) AT=1980.05n

.meas tran vdout0_10ck1970 FIND v(dout0_10) AT=1980.05n

.meas tran vdout0_11ck1970 FIND v(dout0_11) AT=1980.05n

.meas tran vdout0_12ck1970 FIND v(dout0_12) AT=1980.05n

.meas tran vdout0_13ck1970 FIND v(dout0_13) AT=1980.05n

.meas tran vdout0_14ck1970 FIND v(dout0_14) AT=1980.05n

.meas tran vdout0_15ck1970 FIND v(dout0_15) AT=1980.05n

.meas tran vdout0_16ck1970 FIND v(dout0_16) AT=1980.05n

.meas tran vdout0_17ck1970 FIND v(dout0_17) AT=1980.05n

.meas tran vdout0_18ck1970 FIND v(dout0_18) AT=1980.05n

.meas tran vdout0_19ck1970 FIND v(dout0_19) AT=1980.05n

.meas tran vdout0_20ck1970 FIND v(dout0_20) AT=1980.05n

.meas tran vdout0_21ck1970 FIND v(dout0_21) AT=1980.05n

.meas tran vdout0_22ck1970 FIND v(dout0_22) AT=1980.05n

.meas tran vdout0_23ck1970 FIND v(dout0_23) AT=1980.05n

.meas tran vdout0_24ck1970 FIND v(dout0_24) AT=1980.05n

.meas tran vdout0_25ck1970 FIND v(dout0_25) AT=1980.05n

.meas tran vdout0_26ck1970 FIND v(dout0_26) AT=1980.05n

.meas tran vdout0_27ck1970 FIND v(dout0_27) AT=1980.05n

.meas tran vdout0_28ck1970 FIND v(dout0_28) AT=1980.05n

.meas tran vdout0_29ck1970 FIND v(dout0_29) AT=1980.05n

.meas tran vdout0_30ck1970 FIND v(dout0_30) AT=1980.05n

.meas tran vdout0_31ck1970 FIND v(dout0_31) AT=1980.05n

.meas tran vdout0_32ck1970 FIND v(dout0_32) AT=1980.05n

.meas tran vdout0_0ck1990 FIND v(dout0_0) AT=2000.05n

.meas tran vdout0_1ck1990 FIND v(dout0_1) AT=2000.05n

.meas tran vdout0_2ck1990 FIND v(dout0_2) AT=2000.05n

.meas tran vdout0_3ck1990 FIND v(dout0_3) AT=2000.05n

.meas tran vdout0_4ck1990 FIND v(dout0_4) AT=2000.05n

.meas tran vdout0_5ck1990 FIND v(dout0_5) AT=2000.05n

.meas tran vdout0_6ck1990 FIND v(dout0_6) AT=2000.05n

.meas tran vdout0_7ck1990 FIND v(dout0_7) AT=2000.05n

.meas tran vdout0_8ck1990 FIND v(dout0_8) AT=2000.05n

.meas tran vdout0_9ck1990 FIND v(dout0_9) AT=2000.05n

.meas tran vdout0_10ck1990 FIND v(dout0_10) AT=2000.05n

.meas tran vdout0_11ck1990 FIND v(dout0_11) AT=2000.05n

.meas tran vdout0_12ck1990 FIND v(dout0_12) AT=2000.05n

.meas tran vdout0_13ck1990 FIND v(dout0_13) AT=2000.05n

.meas tran vdout0_14ck1990 FIND v(dout0_14) AT=2000.05n

.meas tran vdout0_15ck1990 FIND v(dout0_15) AT=2000.05n

.meas tran vdout0_16ck1990 FIND v(dout0_16) AT=2000.05n

.meas tran vdout0_17ck1990 FIND v(dout0_17) AT=2000.05n

.meas tran vdout0_18ck1990 FIND v(dout0_18) AT=2000.05n

.meas tran vdout0_19ck1990 FIND v(dout0_19) AT=2000.05n

.meas tran vdout0_20ck1990 FIND v(dout0_20) AT=2000.05n

.meas tran vdout0_21ck1990 FIND v(dout0_21) AT=2000.05n

.meas tran vdout0_22ck1990 FIND v(dout0_22) AT=2000.05n

.meas tran vdout0_23ck1990 FIND v(dout0_23) AT=2000.05n

.meas tran vdout0_24ck1990 FIND v(dout0_24) AT=2000.05n

.meas tran vdout0_25ck1990 FIND v(dout0_25) AT=2000.05n

.meas tran vdout0_26ck1990 FIND v(dout0_26) AT=2000.05n

.meas tran vdout0_27ck1990 FIND v(dout0_27) AT=2000.05n

.meas tran vdout0_28ck1990 FIND v(dout0_28) AT=2000.05n

.meas tran vdout0_29ck1990 FIND v(dout0_29) AT=2000.05n

.meas tran vdout0_30ck1990 FIND v(dout0_30) AT=2000.05n

.meas tran vdout0_31ck1990 FIND v(dout0_31) AT=2000.05n

.meas tran vdout0_32ck1990 FIND v(dout0_32) AT=2000.05n

.meas tran vdout0_0ck2020 FIND v(dout0_0) AT=2030.05n

.meas tran vdout0_1ck2020 FIND v(dout0_1) AT=2030.05n

.meas tran vdout0_2ck2020 FIND v(dout0_2) AT=2030.05n

.meas tran vdout0_3ck2020 FIND v(dout0_3) AT=2030.05n

.meas tran vdout0_4ck2020 FIND v(dout0_4) AT=2030.05n

.meas tran vdout0_5ck2020 FIND v(dout0_5) AT=2030.05n

.meas tran vdout0_6ck2020 FIND v(dout0_6) AT=2030.05n

.meas tran vdout0_7ck2020 FIND v(dout0_7) AT=2030.05n

.meas tran vdout0_8ck2020 FIND v(dout0_8) AT=2030.05n

.meas tran vdout0_9ck2020 FIND v(dout0_9) AT=2030.05n

.meas tran vdout0_10ck2020 FIND v(dout0_10) AT=2030.05n

.meas tran vdout0_11ck2020 FIND v(dout0_11) AT=2030.05n

.meas tran vdout0_12ck2020 FIND v(dout0_12) AT=2030.05n

.meas tran vdout0_13ck2020 FIND v(dout0_13) AT=2030.05n

.meas tran vdout0_14ck2020 FIND v(dout0_14) AT=2030.05n

.meas tran vdout0_15ck2020 FIND v(dout0_15) AT=2030.05n

.meas tran vdout0_16ck2020 FIND v(dout0_16) AT=2030.05n

.meas tran vdout0_17ck2020 FIND v(dout0_17) AT=2030.05n

.meas tran vdout0_18ck2020 FIND v(dout0_18) AT=2030.05n

.meas tran vdout0_19ck2020 FIND v(dout0_19) AT=2030.05n

.meas tran vdout0_20ck2020 FIND v(dout0_20) AT=2030.05n

.meas tran vdout0_21ck2020 FIND v(dout0_21) AT=2030.05n

.meas tran vdout0_22ck2020 FIND v(dout0_22) AT=2030.05n

.meas tran vdout0_23ck2020 FIND v(dout0_23) AT=2030.05n

.meas tran vdout0_24ck2020 FIND v(dout0_24) AT=2030.05n

.meas tran vdout0_25ck2020 FIND v(dout0_25) AT=2030.05n

.meas tran vdout0_26ck2020 FIND v(dout0_26) AT=2030.05n

.meas tran vdout0_27ck2020 FIND v(dout0_27) AT=2030.05n

.meas tran vdout0_28ck2020 FIND v(dout0_28) AT=2030.05n

.meas tran vdout0_29ck2020 FIND v(dout0_29) AT=2030.05n

.meas tran vdout0_30ck2020 FIND v(dout0_30) AT=2030.05n

.meas tran vdout0_31ck2020 FIND v(dout0_31) AT=2030.05n

.meas tran vdout0_32ck2020 FIND v(dout0_32) AT=2030.05n

.meas tran vdout0_0ck2030 FIND v(dout0_0) AT=2040.05n

.meas tran vdout0_1ck2030 FIND v(dout0_1) AT=2040.05n

.meas tran vdout0_2ck2030 FIND v(dout0_2) AT=2040.05n

.meas tran vdout0_3ck2030 FIND v(dout0_3) AT=2040.05n

.meas tran vdout0_4ck2030 FIND v(dout0_4) AT=2040.05n

.meas tran vdout0_5ck2030 FIND v(dout0_5) AT=2040.05n

.meas tran vdout0_6ck2030 FIND v(dout0_6) AT=2040.05n

.meas tran vdout0_7ck2030 FIND v(dout0_7) AT=2040.05n

.meas tran vdout0_8ck2030 FIND v(dout0_8) AT=2040.05n

.meas tran vdout0_9ck2030 FIND v(dout0_9) AT=2040.05n

.meas tran vdout0_10ck2030 FIND v(dout0_10) AT=2040.05n

.meas tran vdout0_11ck2030 FIND v(dout0_11) AT=2040.05n

.meas tran vdout0_12ck2030 FIND v(dout0_12) AT=2040.05n

.meas tran vdout0_13ck2030 FIND v(dout0_13) AT=2040.05n

.meas tran vdout0_14ck2030 FIND v(dout0_14) AT=2040.05n

.meas tran vdout0_15ck2030 FIND v(dout0_15) AT=2040.05n

.meas tran vdout0_16ck2030 FIND v(dout0_16) AT=2040.05n

.meas tran vdout0_17ck2030 FIND v(dout0_17) AT=2040.05n

.meas tran vdout0_18ck2030 FIND v(dout0_18) AT=2040.05n

.meas tran vdout0_19ck2030 FIND v(dout0_19) AT=2040.05n

.meas tran vdout0_20ck2030 FIND v(dout0_20) AT=2040.05n

.meas tran vdout0_21ck2030 FIND v(dout0_21) AT=2040.05n

.meas tran vdout0_22ck2030 FIND v(dout0_22) AT=2040.05n

.meas tran vdout0_23ck2030 FIND v(dout0_23) AT=2040.05n

.meas tran vdout0_24ck2030 FIND v(dout0_24) AT=2040.05n

.meas tran vdout0_25ck2030 FIND v(dout0_25) AT=2040.05n

.meas tran vdout0_26ck2030 FIND v(dout0_26) AT=2040.05n

.meas tran vdout0_27ck2030 FIND v(dout0_27) AT=2040.05n

.meas tran vdout0_28ck2030 FIND v(dout0_28) AT=2040.05n

.meas tran vdout0_29ck2030 FIND v(dout0_29) AT=2040.05n

.meas tran vdout0_30ck2030 FIND v(dout0_30) AT=2040.05n

.meas tran vdout0_31ck2030 FIND v(dout0_31) AT=2040.05n

.meas tran vdout0_32ck2030 FIND v(dout0_32) AT=2040.05n

.meas tran vdout0_0ck2040 FIND v(dout0_0) AT=2050.05n

.meas tran vdout0_1ck2040 FIND v(dout0_1) AT=2050.05n

.meas tran vdout0_2ck2040 FIND v(dout0_2) AT=2050.05n

.meas tran vdout0_3ck2040 FIND v(dout0_3) AT=2050.05n

.meas tran vdout0_4ck2040 FIND v(dout0_4) AT=2050.05n

.meas tran vdout0_5ck2040 FIND v(dout0_5) AT=2050.05n

.meas tran vdout0_6ck2040 FIND v(dout0_6) AT=2050.05n

.meas tran vdout0_7ck2040 FIND v(dout0_7) AT=2050.05n

.meas tran vdout0_8ck2040 FIND v(dout0_8) AT=2050.05n

.meas tran vdout0_9ck2040 FIND v(dout0_9) AT=2050.05n

.meas tran vdout0_10ck2040 FIND v(dout0_10) AT=2050.05n

.meas tran vdout0_11ck2040 FIND v(dout0_11) AT=2050.05n

.meas tran vdout0_12ck2040 FIND v(dout0_12) AT=2050.05n

.meas tran vdout0_13ck2040 FIND v(dout0_13) AT=2050.05n

.meas tran vdout0_14ck2040 FIND v(dout0_14) AT=2050.05n

.meas tran vdout0_15ck2040 FIND v(dout0_15) AT=2050.05n

.meas tran vdout0_16ck2040 FIND v(dout0_16) AT=2050.05n

.meas tran vdout0_17ck2040 FIND v(dout0_17) AT=2050.05n

.meas tran vdout0_18ck2040 FIND v(dout0_18) AT=2050.05n

.meas tran vdout0_19ck2040 FIND v(dout0_19) AT=2050.05n

.meas tran vdout0_20ck2040 FIND v(dout0_20) AT=2050.05n

.meas tran vdout0_21ck2040 FIND v(dout0_21) AT=2050.05n

.meas tran vdout0_22ck2040 FIND v(dout0_22) AT=2050.05n

.meas tran vdout0_23ck2040 FIND v(dout0_23) AT=2050.05n

.meas tran vdout0_24ck2040 FIND v(dout0_24) AT=2050.05n

.meas tran vdout0_25ck2040 FIND v(dout0_25) AT=2050.05n

.meas tran vdout0_26ck2040 FIND v(dout0_26) AT=2050.05n

.meas tran vdout0_27ck2040 FIND v(dout0_27) AT=2050.05n

.meas tran vdout0_28ck2040 FIND v(dout0_28) AT=2050.05n

.meas tran vdout0_29ck2040 FIND v(dout0_29) AT=2050.05n

.meas tran vdout0_30ck2040 FIND v(dout0_30) AT=2050.05n

.meas tran vdout0_31ck2040 FIND v(dout0_31) AT=2050.05n

.meas tran vdout0_32ck2040 FIND v(dout0_32) AT=2050.05n
