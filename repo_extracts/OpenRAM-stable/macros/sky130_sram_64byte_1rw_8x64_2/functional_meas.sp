.meas tran vdout0_0ck40 FIND v(dout0_0) AT=50.05n

.meas tran vdout0_1ck40 FIND v(dout0_1) AT=50.05n

.meas tran vdout0_2ck40 FIND v(dout0_2) AT=50.05n

.meas tran vdout0_3ck40 FIND v(dout0_3) AT=50.05n

.meas tran vdout0_4ck40 FIND v(dout0_4) AT=50.05n

.meas tran vdout0_5ck40 FIND v(dout0_5) AT=50.05n

.meas tran vdout0_6ck40 FIND v(dout0_6) AT=50.05n

.meas tran vdout0_7ck40 FIND v(dout0_7) AT=50.05n

.meas tran vdout0_8ck40 FIND v(dout0_8) AT=50.05n

.meas tran vdout0_0ck50 FIND v(dout0_0) AT=60.05n

.meas tran vdout0_1ck50 FIND v(dout0_1) AT=60.05n

.meas tran vdout0_2ck50 FIND v(dout0_2) AT=60.05n

.meas tran vdout0_3ck50 FIND v(dout0_3) AT=60.05n

.meas tran vdout0_4ck50 FIND v(dout0_4) AT=60.05n

.meas tran vdout0_5ck50 FIND v(dout0_5) AT=60.05n

.meas tran vdout0_6ck50 FIND v(dout0_6) AT=60.05n

.meas tran vdout0_7ck50 FIND v(dout0_7) AT=60.05n

.meas tran vdout0_8ck50 FIND v(dout0_8) AT=60.05n

.meas tran vdout0_0ck70 FIND v(dout0_0) AT=80.05n

.meas tran vdout0_1ck70 FIND v(dout0_1) AT=80.05n

.meas tran vdout0_2ck70 FIND v(dout0_2) AT=80.05n

.meas tran vdout0_3ck70 FIND v(dout0_3) AT=80.05n

.meas tran vdout0_4ck70 FIND v(dout0_4) AT=80.05n

.meas tran vdout0_5ck70 FIND v(dout0_5) AT=80.05n

.meas tran vdout0_6ck70 FIND v(dout0_6) AT=80.05n

.meas tran vdout0_7ck70 FIND v(dout0_7) AT=80.05n

.meas tran vdout0_8ck70 FIND v(dout0_8) AT=80.05n

.meas tran vdout0_0ck90 FIND v(dout0_0) AT=100.05n

.meas tran vdout0_1ck90 FIND v(dout0_1) AT=100.05n

.meas tran vdout0_2ck90 FIND v(dout0_2) AT=100.05n

.meas tran vdout0_3ck90 FIND v(dout0_3) AT=100.05n

.meas tran vdout0_4ck90 FIND v(dout0_4) AT=100.05n

.meas tran vdout0_5ck90 FIND v(dout0_5) AT=100.05n

.meas tran vdout0_6ck90 FIND v(dout0_6) AT=100.05n

.meas tran vdout0_7ck90 FIND v(dout0_7) AT=100.05n

.meas tran vdout0_8ck90 FIND v(dout0_8) AT=100.05n

.meas tran vdout0_0ck130 FIND v(dout0_0) AT=140.05n

.meas tran vdout0_1ck130 FIND v(dout0_1) AT=140.05n

.meas tran vdout0_2ck130 FIND v(dout0_2) AT=140.05n

.meas tran vdout0_3ck130 FIND v(dout0_3) AT=140.05n

.meas tran vdout0_4ck130 FIND v(dout0_4) AT=140.05n

.meas tran vdout0_5ck130 FIND v(dout0_5) AT=140.05n

.meas tran vdout0_6ck130 FIND v(dout0_6) AT=140.05n

.meas tran vdout0_7ck130 FIND v(dout0_7) AT=140.05n

.meas tran vdout0_8ck130 FIND v(dout0_8) AT=140.05n

.meas tran vdout0_0ck150 FIND v(dout0_0) AT=160.05n

.meas tran vdout0_1ck150 FIND v(dout0_1) AT=160.05n

.meas tran vdout0_2ck150 FIND v(dout0_2) AT=160.05n

.meas tran vdout0_3ck150 FIND v(dout0_3) AT=160.05n

.meas tran vdout0_4ck150 FIND v(dout0_4) AT=160.05n

.meas tran vdout0_5ck150 FIND v(dout0_5) AT=160.05n

.meas tran vdout0_6ck150 FIND v(dout0_6) AT=160.05n

.meas tran vdout0_7ck150 FIND v(dout0_7) AT=160.05n

.meas tran vdout0_8ck150 FIND v(dout0_8) AT=160.05n

.meas tran vdout0_0ck170 FIND v(dout0_0) AT=180.05n

.meas tran vdout0_1ck170 FIND v(dout0_1) AT=180.05n

.meas tran vdout0_2ck170 FIND v(dout0_2) AT=180.05n

.meas tran vdout0_3ck170 FIND v(dout0_3) AT=180.05n

.meas tran vdout0_4ck170 FIND v(dout0_4) AT=180.05n

.meas tran vdout0_5ck170 FIND v(dout0_5) AT=180.05n

.meas tran vdout0_6ck170 FIND v(dout0_6) AT=180.05n

.meas tran vdout0_7ck170 FIND v(dout0_7) AT=180.05n

.meas tran vdout0_8ck170 FIND v(dout0_8) AT=180.05n

.meas tran vdout0_0ck180 FIND v(dout0_0) AT=190.05n

.meas tran vdout0_1ck180 FIND v(dout0_1) AT=190.05n

.meas tran vdout0_2ck180 FIND v(dout0_2) AT=190.05n

.meas tran vdout0_3ck180 FIND v(dout0_3) AT=190.05n

.meas tran vdout0_4ck180 FIND v(dout0_4) AT=190.05n

.meas tran vdout0_5ck180 FIND v(dout0_5) AT=190.05n

.meas tran vdout0_6ck180 FIND v(dout0_6) AT=190.05n

.meas tran vdout0_7ck180 FIND v(dout0_7) AT=190.05n

.meas tran vdout0_8ck180 FIND v(dout0_8) AT=190.05n

.meas tran vdout0_0ck190 FIND v(dout0_0) AT=200.05n

.meas tran vdout0_1ck190 FIND v(dout0_1) AT=200.05n

.meas tran vdout0_2ck190 FIND v(dout0_2) AT=200.05n

.meas tran vdout0_3ck190 FIND v(dout0_3) AT=200.05n

.meas tran vdout0_4ck190 FIND v(dout0_4) AT=200.05n

.meas tran vdout0_5ck190 FIND v(dout0_5) AT=200.05n

.meas tran vdout0_6ck190 FIND v(dout0_6) AT=200.05n

.meas tran vdout0_7ck190 FIND v(dout0_7) AT=200.05n

.meas tran vdout0_8ck190 FIND v(dout0_8) AT=200.05n

.meas tran vdout0_0ck200 FIND v(dout0_0) AT=210.05n

.meas tran vdout0_1ck200 FIND v(dout0_1) AT=210.05n

.meas tran vdout0_2ck200 FIND v(dout0_2) AT=210.05n

.meas tran vdout0_3ck200 FIND v(dout0_3) AT=210.05n

.meas tran vdout0_4ck200 FIND v(dout0_4) AT=210.05n

.meas tran vdout0_5ck200 FIND v(dout0_5) AT=210.05n

.meas tran vdout0_6ck200 FIND v(dout0_6) AT=210.05n

.meas tran vdout0_7ck200 FIND v(dout0_7) AT=210.05n

.meas tran vdout0_8ck200 FIND v(dout0_8) AT=210.05n

.meas tran vdout0_0ck210 FIND v(dout0_0) AT=220.05n

.meas tran vdout0_1ck210 FIND v(dout0_1) AT=220.05n

.meas tran vdout0_2ck210 FIND v(dout0_2) AT=220.05n

.meas tran vdout0_3ck210 FIND v(dout0_3) AT=220.05n

.meas tran vdout0_4ck210 FIND v(dout0_4) AT=220.05n

.meas tran vdout0_5ck210 FIND v(dout0_5) AT=220.05n

.meas tran vdout0_6ck210 FIND v(dout0_6) AT=220.05n

.meas tran vdout0_7ck210 FIND v(dout0_7) AT=220.05n

.meas tran vdout0_8ck210 FIND v(dout0_8) AT=220.05n

.meas tran vdout0_0ck250 FIND v(dout0_0) AT=260.05n

.meas tran vdout0_1ck250 FIND v(dout0_1) AT=260.05n

.meas tran vdout0_2ck250 FIND v(dout0_2) AT=260.05n

.meas tran vdout0_3ck250 FIND v(dout0_3) AT=260.05n

.meas tran vdout0_4ck250 FIND v(dout0_4) AT=260.05n

.meas tran vdout0_5ck250 FIND v(dout0_5) AT=260.05n

.meas tran vdout0_6ck250 FIND v(dout0_6) AT=260.05n

.meas tran vdout0_7ck250 FIND v(dout0_7) AT=260.05n

.meas tran vdout0_8ck250 FIND v(dout0_8) AT=260.05n

.meas tran vdout0_0ck270 FIND v(dout0_0) AT=280.05n

.meas tran vdout0_1ck270 FIND v(dout0_1) AT=280.05n

.meas tran vdout0_2ck270 FIND v(dout0_2) AT=280.05n

.meas tran vdout0_3ck270 FIND v(dout0_3) AT=280.05n

.meas tran vdout0_4ck270 FIND v(dout0_4) AT=280.05n

.meas tran vdout0_5ck270 FIND v(dout0_5) AT=280.05n

.meas tran vdout0_6ck270 FIND v(dout0_6) AT=280.05n

.meas tran vdout0_7ck270 FIND v(dout0_7) AT=280.05n

.meas tran vdout0_8ck270 FIND v(dout0_8) AT=280.05n

.meas tran vdout0_0ck280 FIND v(dout0_0) AT=290.05n

.meas tran vdout0_1ck280 FIND v(dout0_1) AT=290.05n

.meas tran vdout0_2ck280 FIND v(dout0_2) AT=290.05n

.meas tran vdout0_3ck280 FIND v(dout0_3) AT=290.05n

.meas tran vdout0_4ck280 FIND v(dout0_4) AT=290.05n

.meas tran vdout0_5ck280 FIND v(dout0_5) AT=290.05n

.meas tran vdout0_6ck280 FIND v(dout0_6) AT=290.05n

.meas tran vdout0_7ck280 FIND v(dout0_7) AT=290.05n

.meas tran vdout0_8ck280 FIND v(dout0_8) AT=290.05n

.meas tran vdout0_0ck290 FIND v(dout0_0) AT=300.05n

.meas tran vdout0_1ck290 FIND v(dout0_1) AT=300.05n

.meas tran vdout0_2ck290 FIND v(dout0_2) AT=300.05n

.meas tran vdout0_3ck290 FIND v(dout0_3) AT=300.05n

.meas tran vdout0_4ck290 FIND v(dout0_4) AT=300.05n

.meas tran vdout0_5ck290 FIND v(dout0_5) AT=300.05n

.meas tran vdout0_6ck290 FIND v(dout0_6) AT=300.05n

.meas tran vdout0_7ck290 FIND v(dout0_7) AT=300.05n

.meas tran vdout0_8ck290 FIND v(dout0_8) AT=300.05n

.meas tran vdout0_0ck320 FIND v(dout0_0) AT=330.05n

.meas tran vdout0_1ck320 FIND v(dout0_1) AT=330.05n

.meas tran vdout0_2ck320 FIND v(dout0_2) AT=330.05n

.meas tran vdout0_3ck320 FIND v(dout0_3) AT=330.05n

.meas tran vdout0_4ck320 FIND v(dout0_4) AT=330.05n

.meas tran vdout0_5ck320 FIND v(dout0_5) AT=330.05n

.meas tran vdout0_6ck320 FIND v(dout0_6) AT=330.05n

.meas tran vdout0_7ck320 FIND v(dout0_7) AT=330.05n

.meas tran vdout0_8ck320 FIND v(dout0_8) AT=330.05n

.meas tran vdout0_0ck430 FIND v(dout0_0) AT=440.05n

.meas tran vdout0_1ck430 FIND v(dout0_1) AT=440.05n

.meas tran vdout0_2ck430 FIND v(dout0_2) AT=440.05n

.meas tran vdout0_3ck430 FIND v(dout0_3) AT=440.05n

.meas tran vdout0_4ck430 FIND v(dout0_4) AT=440.05n

.meas tran vdout0_5ck430 FIND v(dout0_5) AT=440.05n

.meas tran vdout0_6ck430 FIND v(dout0_6) AT=440.05n

.meas tran vdout0_7ck430 FIND v(dout0_7) AT=440.05n

.meas tran vdout0_8ck430 FIND v(dout0_8) AT=440.05n

.meas tran vdout0_0ck480 FIND v(dout0_0) AT=490.05n

.meas tran vdout0_1ck480 FIND v(dout0_1) AT=490.05n

.meas tran vdout0_2ck480 FIND v(dout0_2) AT=490.05n

.meas tran vdout0_3ck480 FIND v(dout0_3) AT=490.05n

.meas tran vdout0_4ck480 FIND v(dout0_4) AT=490.05n

.meas tran vdout0_5ck480 FIND v(dout0_5) AT=490.05n

.meas tran vdout0_6ck480 FIND v(dout0_6) AT=490.05n

.meas tran vdout0_7ck480 FIND v(dout0_7) AT=490.05n

.meas tran vdout0_8ck480 FIND v(dout0_8) AT=490.05n

.meas tran vdout0_0ck490 FIND v(dout0_0) AT=500.05n

.meas tran vdout0_1ck490 FIND v(dout0_1) AT=500.05n

.meas tran vdout0_2ck490 FIND v(dout0_2) AT=500.05n

.meas tran vdout0_3ck490 FIND v(dout0_3) AT=500.05n

.meas tran vdout0_4ck490 FIND v(dout0_4) AT=500.05n

.meas tran vdout0_5ck490 FIND v(dout0_5) AT=500.05n

.meas tran vdout0_6ck490 FIND v(dout0_6) AT=500.05n

.meas tran vdout0_7ck490 FIND v(dout0_7) AT=500.05n

.meas tran vdout0_8ck490 FIND v(dout0_8) AT=500.05n

.meas tran vdout0_0ck500 FIND v(dout0_0) AT=510.05n

.meas tran vdout0_1ck500 FIND v(dout0_1) AT=510.05n

.meas tran vdout0_2ck500 FIND v(dout0_2) AT=510.05n

.meas tran vdout0_3ck500 FIND v(dout0_3) AT=510.05n

.meas tran vdout0_4ck500 FIND v(dout0_4) AT=510.05n

.meas tran vdout0_5ck500 FIND v(dout0_5) AT=510.05n

.meas tran vdout0_6ck500 FIND v(dout0_6) AT=510.05n

.meas tran vdout0_7ck500 FIND v(dout0_7) AT=510.05n

.meas tran vdout0_8ck500 FIND v(dout0_8) AT=510.05n

.meas tran vdout0_0ck520 FIND v(dout0_0) AT=530.05n

.meas tran vdout0_1ck520 FIND v(dout0_1) AT=530.05n

.meas tran vdout0_2ck520 FIND v(dout0_2) AT=530.05n

.meas tran vdout0_3ck520 FIND v(dout0_3) AT=530.05n

.meas tran vdout0_4ck520 FIND v(dout0_4) AT=530.05n

.meas tran vdout0_5ck520 FIND v(dout0_5) AT=530.05n

.meas tran vdout0_6ck520 FIND v(dout0_6) AT=530.05n

.meas tran vdout0_7ck520 FIND v(dout0_7) AT=530.05n

.meas tran vdout0_8ck520 FIND v(dout0_8) AT=530.05n

.meas tran vdout0_0ck540 FIND v(dout0_0) AT=550.05n

.meas tran vdout0_1ck540 FIND v(dout0_1) AT=550.05n

.meas tran vdout0_2ck540 FIND v(dout0_2) AT=550.05n

.meas tran vdout0_3ck540 FIND v(dout0_3) AT=550.05n

.meas tran vdout0_4ck540 FIND v(dout0_4) AT=550.05n

.meas tran vdout0_5ck540 FIND v(dout0_5) AT=550.05n

.meas tran vdout0_6ck540 FIND v(dout0_6) AT=550.05n

.meas tran vdout0_7ck540 FIND v(dout0_7) AT=550.05n

.meas tran vdout0_8ck540 FIND v(dout0_8) AT=550.05n

.meas tran vdout0_0ck550 FIND v(dout0_0) AT=560.05n

.meas tran vdout0_1ck550 FIND v(dout0_1) AT=560.05n

.meas tran vdout0_2ck550 FIND v(dout0_2) AT=560.05n

.meas tran vdout0_3ck550 FIND v(dout0_3) AT=560.05n

.meas tran vdout0_4ck550 FIND v(dout0_4) AT=560.05n

.meas tran vdout0_5ck550 FIND v(dout0_5) AT=560.05n

.meas tran vdout0_6ck550 FIND v(dout0_6) AT=560.05n

.meas tran vdout0_7ck550 FIND v(dout0_7) AT=560.05n

.meas tran vdout0_8ck550 FIND v(dout0_8) AT=560.05n

.meas tran vdout0_0ck560 FIND v(dout0_0) AT=570.05n

.meas tran vdout0_1ck560 FIND v(dout0_1) AT=570.05n

.meas tran vdout0_2ck560 FIND v(dout0_2) AT=570.05n

.meas tran vdout0_3ck560 FIND v(dout0_3) AT=570.05n

.meas tran vdout0_4ck560 FIND v(dout0_4) AT=570.05n

.meas tran vdout0_5ck560 FIND v(dout0_5) AT=570.05n

.meas tran vdout0_6ck560 FIND v(dout0_6) AT=570.05n

.meas tran vdout0_7ck560 FIND v(dout0_7) AT=570.05n

.meas tran vdout0_8ck560 FIND v(dout0_8) AT=570.05n

.meas tran vdout0_0ck580 FIND v(dout0_0) AT=590.05n

.meas tran vdout0_1ck580 FIND v(dout0_1) AT=590.05n

.meas tran vdout0_2ck580 FIND v(dout0_2) AT=590.05n

.meas tran vdout0_3ck580 FIND v(dout0_3) AT=590.05n

.meas tran vdout0_4ck580 FIND v(dout0_4) AT=590.05n

.meas tran vdout0_5ck580 FIND v(dout0_5) AT=590.05n

.meas tran vdout0_6ck580 FIND v(dout0_6) AT=590.05n

.meas tran vdout0_7ck580 FIND v(dout0_7) AT=590.05n

.meas tran vdout0_8ck580 FIND v(dout0_8) AT=590.05n

.meas tran vdout0_0ck590 FIND v(dout0_0) AT=600.05n

.meas tran vdout0_1ck590 FIND v(dout0_1) AT=600.05n

.meas tran vdout0_2ck590 FIND v(dout0_2) AT=600.05n

.meas tran vdout0_3ck590 FIND v(dout0_3) AT=600.05n

.meas tran vdout0_4ck590 FIND v(dout0_4) AT=600.05n

.meas tran vdout0_5ck590 FIND v(dout0_5) AT=600.05n

.meas tran vdout0_6ck590 FIND v(dout0_6) AT=600.05n

.meas tran vdout0_7ck590 FIND v(dout0_7) AT=600.05n

.meas tran vdout0_8ck590 FIND v(dout0_8) AT=600.05n

.meas tran vdout0_0ck610 FIND v(dout0_0) AT=620.05n

.meas tran vdout0_1ck610 FIND v(dout0_1) AT=620.05n

.meas tran vdout0_2ck610 FIND v(dout0_2) AT=620.05n

.meas tran vdout0_3ck610 FIND v(dout0_3) AT=620.05n

.meas tran vdout0_4ck610 FIND v(dout0_4) AT=620.05n

.meas tran vdout0_5ck610 FIND v(dout0_5) AT=620.05n

.meas tran vdout0_6ck610 FIND v(dout0_6) AT=620.05n

.meas tran vdout0_7ck610 FIND v(dout0_7) AT=620.05n

.meas tran vdout0_8ck610 FIND v(dout0_8) AT=620.05n

.meas tran vdout0_0ck620 FIND v(dout0_0) AT=630.05n

.meas tran vdout0_1ck620 FIND v(dout0_1) AT=630.05n

.meas tran vdout0_2ck620 FIND v(dout0_2) AT=630.05n

.meas tran vdout0_3ck620 FIND v(dout0_3) AT=630.05n

.meas tran vdout0_4ck620 FIND v(dout0_4) AT=630.05n

.meas tran vdout0_5ck620 FIND v(dout0_5) AT=630.05n

.meas tran vdout0_6ck620 FIND v(dout0_6) AT=630.05n

.meas tran vdout0_7ck620 FIND v(dout0_7) AT=630.05n

.meas tran vdout0_8ck620 FIND v(dout0_8) AT=630.05n

.meas tran vdout0_0ck640 FIND v(dout0_0) AT=650.05n

.meas tran vdout0_1ck640 FIND v(dout0_1) AT=650.05n

.meas tran vdout0_2ck640 FIND v(dout0_2) AT=650.05n

.meas tran vdout0_3ck640 FIND v(dout0_3) AT=650.05n

.meas tran vdout0_4ck640 FIND v(dout0_4) AT=650.05n

.meas tran vdout0_5ck640 FIND v(dout0_5) AT=650.05n

.meas tran vdout0_6ck640 FIND v(dout0_6) AT=650.05n

.meas tran vdout0_7ck640 FIND v(dout0_7) AT=650.05n

.meas tran vdout0_8ck640 FIND v(dout0_8) AT=650.05n

.meas tran vdout0_0ck670 FIND v(dout0_0) AT=680.05n

.meas tran vdout0_1ck670 FIND v(dout0_1) AT=680.05n

.meas tran vdout0_2ck670 FIND v(dout0_2) AT=680.05n

.meas tran vdout0_3ck670 FIND v(dout0_3) AT=680.05n

.meas tran vdout0_4ck670 FIND v(dout0_4) AT=680.05n

.meas tran vdout0_5ck670 FIND v(dout0_5) AT=680.05n

.meas tran vdout0_6ck670 FIND v(dout0_6) AT=680.05n

.meas tran vdout0_7ck670 FIND v(dout0_7) AT=680.05n

.meas tran vdout0_8ck670 FIND v(dout0_8) AT=680.05n

.meas tran vdout0_0ck680 FIND v(dout0_0) AT=690.05n

.meas tran vdout0_1ck680 FIND v(dout0_1) AT=690.05n

.meas tran vdout0_2ck680 FIND v(dout0_2) AT=690.05n

.meas tran vdout0_3ck680 FIND v(dout0_3) AT=690.05n

.meas tran vdout0_4ck680 FIND v(dout0_4) AT=690.05n

.meas tran vdout0_5ck680 FIND v(dout0_5) AT=690.05n

.meas tran vdout0_6ck680 FIND v(dout0_6) AT=690.05n

.meas tran vdout0_7ck680 FIND v(dout0_7) AT=690.05n

.meas tran vdout0_8ck680 FIND v(dout0_8) AT=690.05n

.meas tran vdout0_0ck760 FIND v(dout0_0) AT=770.05n

.meas tran vdout0_1ck760 FIND v(dout0_1) AT=770.05n

.meas tran vdout0_2ck760 FIND v(dout0_2) AT=770.05n

.meas tran vdout0_3ck760 FIND v(dout0_3) AT=770.05n

.meas tran vdout0_4ck760 FIND v(dout0_4) AT=770.05n

.meas tran vdout0_5ck760 FIND v(dout0_5) AT=770.05n

.meas tran vdout0_6ck760 FIND v(dout0_6) AT=770.05n

.meas tran vdout0_7ck760 FIND v(dout0_7) AT=770.05n

.meas tran vdout0_8ck760 FIND v(dout0_8) AT=770.05n

.meas tran vdout0_0ck780 FIND v(dout0_0) AT=790.05n

.meas tran vdout0_1ck780 FIND v(dout0_1) AT=790.05n

.meas tran vdout0_2ck780 FIND v(dout0_2) AT=790.05n

.meas tran vdout0_3ck780 FIND v(dout0_3) AT=790.05n

.meas tran vdout0_4ck780 FIND v(dout0_4) AT=790.05n

.meas tran vdout0_5ck780 FIND v(dout0_5) AT=790.05n

.meas tran vdout0_6ck780 FIND v(dout0_6) AT=790.05n

.meas tran vdout0_7ck780 FIND v(dout0_7) AT=790.05n

.meas tran vdout0_8ck780 FIND v(dout0_8) AT=790.05n

.meas tran vdout0_0ck820 FIND v(dout0_0) AT=830.05n

.meas tran vdout0_1ck820 FIND v(dout0_1) AT=830.05n

.meas tran vdout0_2ck820 FIND v(dout0_2) AT=830.05n

.meas tran vdout0_3ck820 FIND v(dout0_3) AT=830.05n

.meas tran vdout0_4ck820 FIND v(dout0_4) AT=830.05n

.meas tran vdout0_5ck820 FIND v(dout0_5) AT=830.05n

.meas tran vdout0_6ck820 FIND v(dout0_6) AT=830.05n

.meas tran vdout0_7ck820 FIND v(dout0_7) AT=830.05n

.meas tran vdout0_8ck820 FIND v(dout0_8) AT=830.05n

.meas tran vdout0_0ck830 FIND v(dout0_0) AT=840.05n

.meas tran vdout0_1ck830 FIND v(dout0_1) AT=840.05n

.meas tran vdout0_2ck830 FIND v(dout0_2) AT=840.05n

.meas tran vdout0_3ck830 FIND v(dout0_3) AT=840.05n

.meas tran vdout0_4ck830 FIND v(dout0_4) AT=840.05n

.meas tran vdout0_5ck830 FIND v(dout0_5) AT=840.05n

.meas tran vdout0_6ck830 FIND v(dout0_6) AT=840.05n

.meas tran vdout0_7ck830 FIND v(dout0_7) AT=840.05n

.meas tran vdout0_8ck830 FIND v(dout0_8) AT=840.05n

.meas tran vdout0_0ck850 FIND v(dout0_0) AT=860.05n

.meas tran vdout0_1ck850 FIND v(dout0_1) AT=860.05n

.meas tran vdout0_2ck850 FIND v(dout0_2) AT=860.05n

.meas tran vdout0_3ck850 FIND v(dout0_3) AT=860.05n

.meas tran vdout0_4ck850 FIND v(dout0_4) AT=860.05n

.meas tran vdout0_5ck850 FIND v(dout0_5) AT=860.05n

.meas tran vdout0_6ck850 FIND v(dout0_6) AT=860.05n

.meas tran vdout0_7ck850 FIND v(dout0_7) AT=860.05n

.meas tran vdout0_8ck850 FIND v(dout0_8) AT=860.05n

.meas tran vdout0_0ck900 FIND v(dout0_0) AT=910.05n

.meas tran vdout0_1ck900 FIND v(dout0_1) AT=910.05n

.meas tran vdout0_2ck900 FIND v(dout0_2) AT=910.05n

.meas tran vdout0_3ck900 FIND v(dout0_3) AT=910.05n

.meas tran vdout0_4ck900 FIND v(dout0_4) AT=910.05n

.meas tran vdout0_5ck900 FIND v(dout0_5) AT=910.05n

.meas tran vdout0_6ck900 FIND v(dout0_6) AT=910.05n

.meas tran vdout0_7ck900 FIND v(dout0_7) AT=910.05n

.meas tran vdout0_8ck900 FIND v(dout0_8) AT=910.05n

.meas tran vdout0_0ck910 FIND v(dout0_0) AT=920.05n

.meas tran vdout0_1ck910 FIND v(dout0_1) AT=920.05n

.meas tran vdout0_2ck910 FIND v(dout0_2) AT=920.05n

.meas tran vdout0_3ck910 FIND v(dout0_3) AT=920.05n

.meas tran vdout0_4ck910 FIND v(dout0_4) AT=920.05n

.meas tran vdout0_5ck910 FIND v(dout0_5) AT=920.05n

.meas tran vdout0_6ck910 FIND v(dout0_6) AT=920.05n

.meas tran vdout0_7ck910 FIND v(dout0_7) AT=920.05n

.meas tran vdout0_8ck910 FIND v(dout0_8) AT=920.05n

.meas tran vdout0_0ck920 FIND v(dout0_0) AT=930.05n

.meas tran vdout0_1ck920 FIND v(dout0_1) AT=930.05n

.meas tran vdout0_2ck920 FIND v(dout0_2) AT=930.05n

.meas tran vdout0_3ck920 FIND v(dout0_3) AT=930.05n

.meas tran vdout0_4ck920 FIND v(dout0_4) AT=930.05n

.meas tran vdout0_5ck920 FIND v(dout0_5) AT=930.05n

.meas tran vdout0_6ck920 FIND v(dout0_6) AT=930.05n

.meas tran vdout0_7ck920 FIND v(dout0_7) AT=930.05n

.meas tran vdout0_8ck920 FIND v(dout0_8) AT=930.05n

.meas tran vdout0_0ck940 FIND v(dout0_0) AT=950.05n

.meas tran vdout0_1ck940 FIND v(dout0_1) AT=950.05n

.meas tran vdout0_2ck940 FIND v(dout0_2) AT=950.05n

.meas tran vdout0_3ck940 FIND v(dout0_3) AT=950.05n

.meas tran vdout0_4ck940 FIND v(dout0_4) AT=950.05n

.meas tran vdout0_5ck940 FIND v(dout0_5) AT=950.05n

.meas tran vdout0_6ck940 FIND v(dout0_6) AT=950.05n

.meas tran vdout0_7ck940 FIND v(dout0_7) AT=950.05n

.meas tran vdout0_8ck940 FIND v(dout0_8) AT=950.05n

.meas tran vdout0_0ck960 FIND v(dout0_0) AT=970.05n

.meas tran vdout0_1ck960 FIND v(dout0_1) AT=970.05n

.meas tran vdout0_2ck960 FIND v(dout0_2) AT=970.05n

.meas tran vdout0_3ck960 FIND v(dout0_3) AT=970.05n

.meas tran vdout0_4ck960 FIND v(dout0_4) AT=970.05n

.meas tran vdout0_5ck960 FIND v(dout0_5) AT=970.05n

.meas tran vdout0_6ck960 FIND v(dout0_6) AT=970.05n

.meas tran vdout0_7ck960 FIND v(dout0_7) AT=970.05n

.meas tran vdout0_8ck960 FIND v(dout0_8) AT=970.05n

.meas tran vdout0_0ck1020 FIND v(dout0_0) AT=1030.05n

.meas tran vdout0_1ck1020 FIND v(dout0_1) AT=1030.05n

.meas tran vdout0_2ck1020 FIND v(dout0_2) AT=1030.05n

.meas tran vdout0_3ck1020 FIND v(dout0_3) AT=1030.05n

.meas tran vdout0_4ck1020 FIND v(dout0_4) AT=1030.05n

.meas tran vdout0_5ck1020 FIND v(dout0_5) AT=1030.05n

.meas tran vdout0_6ck1020 FIND v(dout0_6) AT=1030.05n

.meas tran vdout0_7ck1020 FIND v(dout0_7) AT=1030.05n

.meas tran vdout0_8ck1020 FIND v(dout0_8) AT=1030.05n

.meas tran vdout0_0ck1040 FIND v(dout0_0) AT=1050.05n

.meas tran vdout0_1ck1040 FIND v(dout0_1) AT=1050.05n

.meas tran vdout0_2ck1040 FIND v(dout0_2) AT=1050.05n

.meas tran vdout0_3ck1040 FIND v(dout0_3) AT=1050.05n

.meas tran vdout0_4ck1040 FIND v(dout0_4) AT=1050.05n

.meas tran vdout0_5ck1040 FIND v(dout0_5) AT=1050.05n

.meas tran vdout0_6ck1040 FIND v(dout0_6) AT=1050.05n

.meas tran vdout0_7ck1040 FIND v(dout0_7) AT=1050.05n

.meas tran vdout0_8ck1040 FIND v(dout0_8) AT=1050.05n

.meas tran vdout0_0ck1050 FIND v(dout0_0) AT=1060.05n

.meas tran vdout0_1ck1050 FIND v(dout0_1) AT=1060.05n

.meas tran vdout0_2ck1050 FIND v(dout0_2) AT=1060.05n

.meas tran vdout0_3ck1050 FIND v(dout0_3) AT=1060.05n

.meas tran vdout0_4ck1050 FIND v(dout0_4) AT=1060.05n

.meas tran vdout0_5ck1050 FIND v(dout0_5) AT=1060.05n

.meas tran vdout0_6ck1050 FIND v(dout0_6) AT=1060.05n

.meas tran vdout0_7ck1050 FIND v(dout0_7) AT=1060.05n

.meas tran vdout0_8ck1050 FIND v(dout0_8) AT=1060.05n

.meas tran vdout0_0ck1060 FIND v(dout0_0) AT=1070.05n

.meas tran vdout0_1ck1060 FIND v(dout0_1) AT=1070.05n

.meas tran vdout0_2ck1060 FIND v(dout0_2) AT=1070.05n

.meas tran vdout0_3ck1060 FIND v(dout0_3) AT=1070.05n

.meas tran vdout0_4ck1060 FIND v(dout0_4) AT=1070.05n

.meas tran vdout0_5ck1060 FIND v(dout0_5) AT=1070.05n

.meas tran vdout0_6ck1060 FIND v(dout0_6) AT=1070.05n

.meas tran vdout0_7ck1060 FIND v(dout0_7) AT=1070.05n

.meas tran vdout0_8ck1060 FIND v(dout0_8) AT=1070.05n

.meas tran vdout0_0ck1100 FIND v(dout0_0) AT=1110.05n

.meas tran vdout0_1ck1100 FIND v(dout0_1) AT=1110.05n

.meas tran vdout0_2ck1100 FIND v(dout0_2) AT=1110.05n

.meas tran vdout0_3ck1100 FIND v(dout0_3) AT=1110.05n

.meas tran vdout0_4ck1100 FIND v(dout0_4) AT=1110.05n

.meas tran vdout0_5ck1100 FIND v(dout0_5) AT=1110.05n

.meas tran vdout0_6ck1100 FIND v(dout0_6) AT=1110.05n

.meas tran vdout0_7ck1100 FIND v(dout0_7) AT=1110.05n

.meas tran vdout0_8ck1100 FIND v(dout0_8) AT=1110.05n

.meas tran vdout0_0ck1130 FIND v(dout0_0) AT=1140.05n

.meas tran vdout0_1ck1130 FIND v(dout0_1) AT=1140.05n

.meas tran vdout0_2ck1130 FIND v(dout0_2) AT=1140.05n

.meas tran vdout0_3ck1130 FIND v(dout0_3) AT=1140.05n

.meas tran vdout0_4ck1130 FIND v(dout0_4) AT=1140.05n

.meas tran vdout0_5ck1130 FIND v(dout0_5) AT=1140.05n

.meas tran vdout0_6ck1130 FIND v(dout0_6) AT=1140.05n

.meas tran vdout0_7ck1130 FIND v(dout0_7) AT=1140.05n

.meas tran vdout0_8ck1130 FIND v(dout0_8) AT=1140.05n

.meas tran vdout0_0ck1150 FIND v(dout0_0) AT=1160.05n

.meas tran vdout0_1ck1150 FIND v(dout0_1) AT=1160.05n

.meas tran vdout0_2ck1150 FIND v(dout0_2) AT=1160.05n

.meas tran vdout0_3ck1150 FIND v(dout0_3) AT=1160.05n

.meas tran vdout0_4ck1150 FIND v(dout0_4) AT=1160.05n

.meas tran vdout0_5ck1150 FIND v(dout0_5) AT=1160.05n

.meas tran vdout0_6ck1150 FIND v(dout0_6) AT=1160.05n

.meas tran vdout0_7ck1150 FIND v(dout0_7) AT=1160.05n

.meas tran vdout0_8ck1150 FIND v(dout0_8) AT=1160.05n

.meas tran vdout0_0ck1200 FIND v(dout0_0) AT=1210.05n

.meas tran vdout0_1ck1200 FIND v(dout0_1) AT=1210.05n

.meas tran vdout0_2ck1200 FIND v(dout0_2) AT=1210.05n

.meas tran vdout0_3ck1200 FIND v(dout0_3) AT=1210.05n

.meas tran vdout0_4ck1200 FIND v(dout0_4) AT=1210.05n

.meas tran vdout0_5ck1200 FIND v(dout0_5) AT=1210.05n

.meas tran vdout0_6ck1200 FIND v(dout0_6) AT=1210.05n

.meas tran vdout0_7ck1200 FIND v(dout0_7) AT=1210.05n

.meas tran vdout0_8ck1200 FIND v(dout0_8) AT=1210.05n

.meas tran vdout0_0ck1230 FIND v(dout0_0) AT=1240.05n

.meas tran vdout0_1ck1230 FIND v(dout0_1) AT=1240.05n

.meas tran vdout0_2ck1230 FIND v(dout0_2) AT=1240.05n

.meas tran vdout0_3ck1230 FIND v(dout0_3) AT=1240.05n

.meas tran vdout0_4ck1230 FIND v(dout0_4) AT=1240.05n

.meas tran vdout0_5ck1230 FIND v(dout0_5) AT=1240.05n

.meas tran vdout0_6ck1230 FIND v(dout0_6) AT=1240.05n

.meas tran vdout0_7ck1230 FIND v(dout0_7) AT=1240.05n

.meas tran vdout0_8ck1230 FIND v(dout0_8) AT=1240.05n

.meas tran vdout0_0ck1240 FIND v(dout0_0) AT=1250.05n

.meas tran vdout0_1ck1240 FIND v(dout0_1) AT=1250.05n

.meas tran vdout0_2ck1240 FIND v(dout0_2) AT=1250.05n

.meas tran vdout0_3ck1240 FIND v(dout0_3) AT=1250.05n

.meas tran vdout0_4ck1240 FIND v(dout0_4) AT=1250.05n

.meas tran vdout0_5ck1240 FIND v(dout0_5) AT=1250.05n

.meas tran vdout0_6ck1240 FIND v(dout0_6) AT=1250.05n

.meas tran vdout0_7ck1240 FIND v(dout0_7) AT=1250.05n

.meas tran vdout0_8ck1240 FIND v(dout0_8) AT=1250.05n

.meas tran vdout0_0ck1250 FIND v(dout0_0) AT=1260.05n

.meas tran vdout0_1ck1250 FIND v(dout0_1) AT=1260.05n

.meas tran vdout0_2ck1250 FIND v(dout0_2) AT=1260.05n

.meas tran vdout0_3ck1250 FIND v(dout0_3) AT=1260.05n

.meas tran vdout0_4ck1250 FIND v(dout0_4) AT=1260.05n

.meas tran vdout0_5ck1250 FIND v(dout0_5) AT=1260.05n

.meas tran vdout0_6ck1250 FIND v(dout0_6) AT=1260.05n

.meas tran vdout0_7ck1250 FIND v(dout0_7) AT=1260.05n

.meas tran vdout0_8ck1250 FIND v(dout0_8) AT=1260.05n

.meas tran vdout0_0ck1270 FIND v(dout0_0) AT=1280.05n

.meas tran vdout0_1ck1270 FIND v(dout0_1) AT=1280.05n

.meas tran vdout0_2ck1270 FIND v(dout0_2) AT=1280.05n

.meas tran vdout0_3ck1270 FIND v(dout0_3) AT=1280.05n

.meas tran vdout0_4ck1270 FIND v(dout0_4) AT=1280.05n

.meas tran vdout0_5ck1270 FIND v(dout0_5) AT=1280.05n

.meas tran vdout0_6ck1270 FIND v(dout0_6) AT=1280.05n

.meas tran vdout0_7ck1270 FIND v(dout0_7) AT=1280.05n

.meas tran vdout0_8ck1270 FIND v(dout0_8) AT=1280.05n

.meas tran vdout0_0ck1290 FIND v(dout0_0) AT=1300.05n

.meas tran vdout0_1ck1290 FIND v(dout0_1) AT=1300.05n

.meas tran vdout0_2ck1290 FIND v(dout0_2) AT=1300.05n

.meas tran vdout0_3ck1290 FIND v(dout0_3) AT=1300.05n

.meas tran vdout0_4ck1290 FIND v(dout0_4) AT=1300.05n

.meas tran vdout0_5ck1290 FIND v(dout0_5) AT=1300.05n

.meas tran vdout0_6ck1290 FIND v(dout0_6) AT=1300.05n

.meas tran vdout0_7ck1290 FIND v(dout0_7) AT=1300.05n

.meas tran vdout0_8ck1290 FIND v(dout0_8) AT=1300.05n

.meas tran vdout0_0ck1300 FIND v(dout0_0) AT=1310.05n

.meas tran vdout0_1ck1300 FIND v(dout0_1) AT=1310.05n

.meas tran vdout0_2ck1300 FIND v(dout0_2) AT=1310.05n

.meas tran vdout0_3ck1300 FIND v(dout0_3) AT=1310.05n

.meas tran vdout0_4ck1300 FIND v(dout0_4) AT=1310.05n

.meas tran vdout0_5ck1300 FIND v(dout0_5) AT=1310.05n

.meas tran vdout0_6ck1300 FIND v(dout0_6) AT=1310.05n

.meas tran vdout0_7ck1300 FIND v(dout0_7) AT=1310.05n

.meas tran vdout0_8ck1300 FIND v(dout0_8) AT=1310.05n

.meas tran vdout0_0ck1360 FIND v(dout0_0) AT=1370.05n

.meas tran vdout0_1ck1360 FIND v(dout0_1) AT=1370.05n

.meas tran vdout0_2ck1360 FIND v(dout0_2) AT=1370.05n

.meas tran vdout0_3ck1360 FIND v(dout0_3) AT=1370.05n

.meas tran vdout0_4ck1360 FIND v(dout0_4) AT=1370.05n

.meas tran vdout0_5ck1360 FIND v(dout0_5) AT=1370.05n

.meas tran vdout0_6ck1360 FIND v(dout0_6) AT=1370.05n

.meas tran vdout0_7ck1360 FIND v(dout0_7) AT=1370.05n

.meas tran vdout0_8ck1360 FIND v(dout0_8) AT=1370.05n

.meas tran vdout0_0ck1370 FIND v(dout0_0) AT=1380.05n

.meas tran vdout0_1ck1370 FIND v(dout0_1) AT=1380.05n

.meas tran vdout0_2ck1370 FIND v(dout0_2) AT=1380.05n

.meas tran vdout0_3ck1370 FIND v(dout0_3) AT=1380.05n

.meas tran vdout0_4ck1370 FIND v(dout0_4) AT=1380.05n

.meas tran vdout0_5ck1370 FIND v(dout0_5) AT=1380.05n

.meas tran vdout0_6ck1370 FIND v(dout0_6) AT=1380.05n

.meas tran vdout0_7ck1370 FIND v(dout0_7) AT=1380.05n

.meas tran vdout0_8ck1370 FIND v(dout0_8) AT=1380.05n

.meas tran vdout0_0ck1380 FIND v(dout0_0) AT=1390.05n

.meas tran vdout0_1ck1380 FIND v(dout0_1) AT=1390.05n

.meas tran vdout0_2ck1380 FIND v(dout0_2) AT=1390.05n

.meas tran vdout0_3ck1380 FIND v(dout0_3) AT=1390.05n

.meas tran vdout0_4ck1380 FIND v(dout0_4) AT=1390.05n

.meas tran vdout0_5ck1380 FIND v(dout0_5) AT=1390.05n

.meas tran vdout0_6ck1380 FIND v(dout0_6) AT=1390.05n

.meas tran vdout0_7ck1380 FIND v(dout0_7) AT=1390.05n

.meas tran vdout0_8ck1380 FIND v(dout0_8) AT=1390.05n

.meas tran vdout0_0ck1410 FIND v(dout0_0) AT=1420.05n

.meas tran vdout0_1ck1410 FIND v(dout0_1) AT=1420.05n

.meas tran vdout0_2ck1410 FIND v(dout0_2) AT=1420.05n

.meas tran vdout0_3ck1410 FIND v(dout0_3) AT=1420.05n

.meas tran vdout0_4ck1410 FIND v(dout0_4) AT=1420.05n

.meas tran vdout0_5ck1410 FIND v(dout0_5) AT=1420.05n

.meas tran vdout0_6ck1410 FIND v(dout0_6) AT=1420.05n

.meas tran vdout0_7ck1410 FIND v(dout0_7) AT=1420.05n

.meas tran vdout0_8ck1410 FIND v(dout0_8) AT=1420.05n

.meas tran vdout0_0ck1430 FIND v(dout0_0) AT=1440.05n

.meas tran vdout0_1ck1430 FIND v(dout0_1) AT=1440.05n

.meas tran vdout0_2ck1430 FIND v(dout0_2) AT=1440.05n

.meas tran vdout0_3ck1430 FIND v(dout0_3) AT=1440.05n

.meas tran vdout0_4ck1430 FIND v(dout0_4) AT=1440.05n

.meas tran vdout0_5ck1430 FIND v(dout0_5) AT=1440.05n

.meas tran vdout0_6ck1430 FIND v(dout0_6) AT=1440.05n

.meas tran vdout0_7ck1430 FIND v(dout0_7) AT=1440.05n

.meas tran vdout0_8ck1430 FIND v(dout0_8) AT=1440.05n

.meas tran vdout0_0ck1500 FIND v(dout0_0) AT=1510.05n

.meas tran vdout0_1ck1500 FIND v(dout0_1) AT=1510.05n

.meas tran vdout0_2ck1500 FIND v(dout0_2) AT=1510.05n

.meas tran vdout0_3ck1500 FIND v(dout0_3) AT=1510.05n

.meas tran vdout0_4ck1500 FIND v(dout0_4) AT=1510.05n

.meas tran vdout0_5ck1500 FIND v(dout0_5) AT=1510.05n

.meas tran vdout0_6ck1500 FIND v(dout0_6) AT=1510.05n

.meas tran vdout0_7ck1500 FIND v(dout0_7) AT=1510.05n

.meas tran vdout0_8ck1500 FIND v(dout0_8) AT=1510.05n

.meas tran vdout0_0ck1510 FIND v(dout0_0) AT=1520.05n

.meas tran vdout0_1ck1510 FIND v(dout0_1) AT=1520.05n

.meas tran vdout0_2ck1510 FIND v(dout0_2) AT=1520.05n

.meas tran vdout0_3ck1510 FIND v(dout0_3) AT=1520.05n

.meas tran vdout0_4ck1510 FIND v(dout0_4) AT=1520.05n

.meas tran vdout0_5ck1510 FIND v(dout0_5) AT=1520.05n

.meas tran vdout0_6ck1510 FIND v(dout0_6) AT=1520.05n

.meas tran vdout0_7ck1510 FIND v(dout0_7) AT=1520.05n

.meas tran vdout0_8ck1510 FIND v(dout0_8) AT=1520.05n

.meas tran vdout0_0ck1520 FIND v(dout0_0) AT=1530.05n

.meas tran vdout0_1ck1520 FIND v(dout0_1) AT=1530.05n

.meas tran vdout0_2ck1520 FIND v(dout0_2) AT=1530.05n

.meas tran vdout0_3ck1520 FIND v(dout0_3) AT=1530.05n

.meas tran vdout0_4ck1520 FIND v(dout0_4) AT=1530.05n

.meas tran vdout0_5ck1520 FIND v(dout0_5) AT=1530.05n

.meas tran vdout0_6ck1520 FIND v(dout0_6) AT=1530.05n

.meas tran vdout0_7ck1520 FIND v(dout0_7) AT=1530.05n

.meas tran vdout0_8ck1520 FIND v(dout0_8) AT=1530.05n

.meas tran vdout0_0ck1540 FIND v(dout0_0) AT=1550.05n

.meas tran vdout0_1ck1540 FIND v(dout0_1) AT=1550.05n

.meas tran vdout0_2ck1540 FIND v(dout0_2) AT=1550.05n

.meas tran vdout0_3ck1540 FIND v(dout0_3) AT=1550.05n

.meas tran vdout0_4ck1540 FIND v(dout0_4) AT=1550.05n

.meas tran vdout0_5ck1540 FIND v(dout0_5) AT=1550.05n

.meas tran vdout0_6ck1540 FIND v(dout0_6) AT=1550.05n

.meas tran vdout0_7ck1540 FIND v(dout0_7) AT=1550.05n

.meas tran vdout0_8ck1540 FIND v(dout0_8) AT=1550.05n

.meas tran vdout0_0ck1550 FIND v(dout0_0) AT=1560.05n

.meas tran vdout0_1ck1550 FIND v(dout0_1) AT=1560.05n

.meas tran vdout0_2ck1550 FIND v(dout0_2) AT=1560.05n

.meas tran vdout0_3ck1550 FIND v(dout0_3) AT=1560.05n

.meas tran vdout0_4ck1550 FIND v(dout0_4) AT=1560.05n

.meas tran vdout0_5ck1550 FIND v(dout0_5) AT=1560.05n

.meas tran vdout0_6ck1550 FIND v(dout0_6) AT=1560.05n

.meas tran vdout0_7ck1550 FIND v(dout0_7) AT=1560.05n

.meas tran vdout0_8ck1550 FIND v(dout0_8) AT=1560.05n

.meas tran vdout0_0ck1610 FIND v(dout0_0) AT=1620.05n

.meas tran vdout0_1ck1610 FIND v(dout0_1) AT=1620.05n

.meas tran vdout0_2ck1610 FIND v(dout0_2) AT=1620.05n

.meas tran vdout0_3ck1610 FIND v(dout0_3) AT=1620.05n

.meas tran vdout0_4ck1610 FIND v(dout0_4) AT=1620.05n

.meas tran vdout0_5ck1610 FIND v(dout0_5) AT=1620.05n

.meas tran vdout0_6ck1610 FIND v(dout0_6) AT=1620.05n

.meas tran vdout0_7ck1610 FIND v(dout0_7) AT=1620.05n

.meas tran vdout0_8ck1610 FIND v(dout0_8) AT=1620.05n

.meas tran vdout0_0ck1620 FIND v(dout0_0) AT=1630.05n

.meas tran vdout0_1ck1620 FIND v(dout0_1) AT=1630.05n

.meas tran vdout0_2ck1620 FIND v(dout0_2) AT=1630.05n

.meas tran vdout0_3ck1620 FIND v(dout0_3) AT=1630.05n

.meas tran vdout0_4ck1620 FIND v(dout0_4) AT=1630.05n

.meas tran vdout0_5ck1620 FIND v(dout0_5) AT=1630.05n

.meas tran vdout0_6ck1620 FIND v(dout0_6) AT=1630.05n

.meas tran vdout0_7ck1620 FIND v(dout0_7) AT=1630.05n

.meas tran vdout0_8ck1620 FIND v(dout0_8) AT=1630.05n

.meas tran vdout0_0ck1630 FIND v(dout0_0) AT=1640.05n

.meas tran vdout0_1ck1630 FIND v(dout0_1) AT=1640.05n

.meas tran vdout0_2ck1630 FIND v(dout0_2) AT=1640.05n

.meas tran vdout0_3ck1630 FIND v(dout0_3) AT=1640.05n

.meas tran vdout0_4ck1630 FIND v(dout0_4) AT=1640.05n

.meas tran vdout0_5ck1630 FIND v(dout0_5) AT=1640.05n

.meas tran vdout0_6ck1630 FIND v(dout0_6) AT=1640.05n

.meas tran vdout0_7ck1630 FIND v(dout0_7) AT=1640.05n

.meas tran vdout0_8ck1630 FIND v(dout0_8) AT=1640.05n

.meas tran vdout0_0ck1640 FIND v(dout0_0) AT=1650.05n

.meas tran vdout0_1ck1640 FIND v(dout0_1) AT=1650.05n

.meas tran vdout0_2ck1640 FIND v(dout0_2) AT=1650.05n

.meas tran vdout0_3ck1640 FIND v(dout0_3) AT=1650.05n

.meas tran vdout0_4ck1640 FIND v(dout0_4) AT=1650.05n

.meas tran vdout0_5ck1640 FIND v(dout0_5) AT=1650.05n

.meas tran vdout0_6ck1640 FIND v(dout0_6) AT=1650.05n

.meas tran vdout0_7ck1640 FIND v(dout0_7) AT=1650.05n

.meas tran vdout0_8ck1640 FIND v(dout0_8) AT=1650.05n

.meas tran vdout0_0ck1660 FIND v(dout0_0) AT=1670.05n

.meas tran vdout0_1ck1660 FIND v(dout0_1) AT=1670.05n

.meas tran vdout0_2ck1660 FIND v(dout0_2) AT=1670.05n

.meas tran vdout0_3ck1660 FIND v(dout0_3) AT=1670.05n

.meas tran vdout0_4ck1660 FIND v(dout0_4) AT=1670.05n

.meas tran vdout0_5ck1660 FIND v(dout0_5) AT=1670.05n

.meas tran vdout0_6ck1660 FIND v(dout0_6) AT=1670.05n

.meas tran vdout0_7ck1660 FIND v(dout0_7) AT=1670.05n

.meas tran vdout0_8ck1660 FIND v(dout0_8) AT=1670.05n

.meas tran vdout0_0ck1670 FIND v(dout0_0) AT=1680.05n

.meas tran vdout0_1ck1670 FIND v(dout0_1) AT=1680.05n

.meas tran vdout0_2ck1670 FIND v(dout0_2) AT=1680.05n

.meas tran vdout0_3ck1670 FIND v(dout0_3) AT=1680.05n

.meas tran vdout0_4ck1670 FIND v(dout0_4) AT=1680.05n

.meas tran vdout0_5ck1670 FIND v(dout0_5) AT=1680.05n

.meas tran vdout0_6ck1670 FIND v(dout0_6) AT=1680.05n

.meas tran vdout0_7ck1670 FIND v(dout0_7) AT=1680.05n

.meas tran vdout0_8ck1670 FIND v(dout0_8) AT=1680.05n

.meas tran vdout0_0ck1700 FIND v(dout0_0) AT=1710.05n

.meas tran vdout0_1ck1700 FIND v(dout0_1) AT=1710.05n

.meas tran vdout0_2ck1700 FIND v(dout0_2) AT=1710.05n

.meas tran vdout0_3ck1700 FIND v(dout0_3) AT=1710.05n

.meas tran vdout0_4ck1700 FIND v(dout0_4) AT=1710.05n

.meas tran vdout0_5ck1700 FIND v(dout0_5) AT=1710.05n

.meas tran vdout0_6ck1700 FIND v(dout0_6) AT=1710.05n

.meas tran vdout0_7ck1700 FIND v(dout0_7) AT=1710.05n

.meas tran vdout0_8ck1700 FIND v(dout0_8) AT=1710.05n

.meas tran vdout0_0ck1720 FIND v(dout0_0) AT=1730.05n

.meas tran vdout0_1ck1720 FIND v(dout0_1) AT=1730.05n

.meas tran vdout0_2ck1720 FIND v(dout0_2) AT=1730.05n

.meas tran vdout0_3ck1720 FIND v(dout0_3) AT=1730.05n

.meas tran vdout0_4ck1720 FIND v(dout0_4) AT=1730.05n

.meas tran vdout0_5ck1720 FIND v(dout0_5) AT=1730.05n

.meas tran vdout0_6ck1720 FIND v(dout0_6) AT=1730.05n

.meas tran vdout0_7ck1720 FIND v(dout0_7) AT=1730.05n

.meas tran vdout0_8ck1720 FIND v(dout0_8) AT=1730.05n

.meas tran vdout0_0ck1730 FIND v(dout0_0) AT=1740.05n

.meas tran vdout0_1ck1730 FIND v(dout0_1) AT=1740.05n

.meas tran vdout0_2ck1730 FIND v(dout0_2) AT=1740.05n

.meas tran vdout0_3ck1730 FIND v(dout0_3) AT=1740.05n

.meas tran vdout0_4ck1730 FIND v(dout0_4) AT=1740.05n

.meas tran vdout0_5ck1730 FIND v(dout0_5) AT=1740.05n

.meas tran vdout0_6ck1730 FIND v(dout0_6) AT=1740.05n

.meas tran vdout0_7ck1730 FIND v(dout0_7) AT=1740.05n

.meas tran vdout0_8ck1730 FIND v(dout0_8) AT=1740.05n

.meas tran vdout0_0ck1750 FIND v(dout0_0) AT=1760.05n

.meas tran vdout0_1ck1750 FIND v(dout0_1) AT=1760.05n

.meas tran vdout0_2ck1750 FIND v(dout0_2) AT=1760.05n

.meas tran vdout0_3ck1750 FIND v(dout0_3) AT=1760.05n

.meas tran vdout0_4ck1750 FIND v(dout0_4) AT=1760.05n

.meas tran vdout0_5ck1750 FIND v(dout0_5) AT=1760.05n

.meas tran vdout0_6ck1750 FIND v(dout0_6) AT=1760.05n

.meas tran vdout0_7ck1750 FIND v(dout0_7) AT=1760.05n

.meas tran vdout0_8ck1750 FIND v(dout0_8) AT=1760.05n

.meas tran vdout0_0ck1780 FIND v(dout0_0) AT=1790.05n

.meas tran vdout0_1ck1780 FIND v(dout0_1) AT=1790.05n

.meas tran vdout0_2ck1780 FIND v(dout0_2) AT=1790.05n

.meas tran vdout0_3ck1780 FIND v(dout0_3) AT=1790.05n

.meas tran vdout0_4ck1780 FIND v(dout0_4) AT=1790.05n

.meas tran vdout0_5ck1780 FIND v(dout0_5) AT=1790.05n

.meas tran vdout0_6ck1780 FIND v(dout0_6) AT=1790.05n

.meas tran vdout0_7ck1780 FIND v(dout0_7) AT=1790.05n

.meas tran vdout0_8ck1780 FIND v(dout0_8) AT=1790.05n

.meas tran vdout0_0ck1940 FIND v(dout0_0) AT=1950.05n

.meas tran vdout0_1ck1940 FIND v(dout0_1) AT=1950.05n

.meas tran vdout0_2ck1940 FIND v(dout0_2) AT=1950.05n

.meas tran vdout0_3ck1940 FIND v(dout0_3) AT=1950.05n

.meas tran vdout0_4ck1940 FIND v(dout0_4) AT=1950.05n

.meas tran vdout0_5ck1940 FIND v(dout0_5) AT=1950.05n

.meas tran vdout0_6ck1940 FIND v(dout0_6) AT=1950.05n

.meas tran vdout0_7ck1940 FIND v(dout0_7) AT=1950.05n

.meas tran vdout0_8ck1940 FIND v(dout0_8) AT=1950.05n

.meas tran vdout0_0ck1950 FIND v(dout0_0) AT=1960.05n

.meas tran vdout0_1ck1950 FIND v(dout0_1) AT=1960.05n

.meas tran vdout0_2ck1950 FIND v(dout0_2) AT=1960.05n

.meas tran vdout0_3ck1950 FIND v(dout0_3) AT=1960.05n

.meas tran vdout0_4ck1950 FIND v(dout0_4) AT=1960.05n

.meas tran vdout0_5ck1950 FIND v(dout0_5) AT=1960.05n

.meas tran vdout0_6ck1950 FIND v(dout0_6) AT=1960.05n

.meas tran vdout0_7ck1950 FIND v(dout0_7) AT=1960.05n

.meas tran vdout0_8ck1950 FIND v(dout0_8) AT=1960.05n

.meas tran vdout0_0ck1960 FIND v(dout0_0) AT=1970.05n

.meas tran vdout0_1ck1960 FIND v(dout0_1) AT=1970.05n

.meas tran vdout0_2ck1960 FIND v(dout0_2) AT=1970.05n

.meas tran vdout0_3ck1960 FIND v(dout0_3) AT=1970.05n

.meas tran vdout0_4ck1960 FIND v(dout0_4) AT=1970.05n

.meas tran vdout0_5ck1960 FIND v(dout0_5) AT=1970.05n

.meas tran vdout0_6ck1960 FIND v(dout0_6) AT=1970.05n

.meas tran vdout0_7ck1960 FIND v(dout0_7) AT=1970.05n

.meas tran vdout0_8ck1960 FIND v(dout0_8) AT=1970.05n

.meas tran vdout0_0ck1980 FIND v(dout0_0) AT=1990.05n

.meas tran vdout0_1ck1980 FIND v(dout0_1) AT=1990.05n

.meas tran vdout0_2ck1980 FIND v(dout0_2) AT=1990.05n

.meas tran vdout0_3ck1980 FIND v(dout0_3) AT=1990.05n

.meas tran vdout0_4ck1980 FIND v(dout0_4) AT=1990.05n

.meas tran vdout0_5ck1980 FIND v(dout0_5) AT=1990.05n

.meas tran vdout0_6ck1980 FIND v(dout0_6) AT=1990.05n

.meas tran vdout0_7ck1980 FIND v(dout0_7) AT=1990.05n

.meas tran vdout0_8ck1980 FIND v(dout0_8) AT=1990.05n

.meas tran vdout0_0ck2010 FIND v(dout0_0) AT=2020.05n

.meas tran vdout0_1ck2010 FIND v(dout0_1) AT=2020.05n

.meas tran vdout0_2ck2010 FIND v(dout0_2) AT=2020.05n

.meas tran vdout0_3ck2010 FIND v(dout0_3) AT=2020.05n

.meas tran vdout0_4ck2010 FIND v(dout0_4) AT=2020.05n

.meas tran vdout0_5ck2010 FIND v(dout0_5) AT=2020.05n

.meas tran vdout0_6ck2010 FIND v(dout0_6) AT=2020.05n

.meas tran vdout0_7ck2010 FIND v(dout0_7) AT=2020.05n

.meas tran vdout0_8ck2010 FIND v(dout0_8) AT=2020.05n

.meas tran vdout0_0ck2020 FIND v(dout0_0) AT=2030.05n

.meas tran vdout0_1ck2020 FIND v(dout0_1) AT=2030.05n

.meas tran vdout0_2ck2020 FIND v(dout0_2) AT=2030.05n

.meas tran vdout0_3ck2020 FIND v(dout0_3) AT=2030.05n

.meas tran vdout0_4ck2020 FIND v(dout0_4) AT=2030.05n

.meas tran vdout0_5ck2020 FIND v(dout0_5) AT=2030.05n

.meas tran vdout0_6ck2020 FIND v(dout0_6) AT=2030.05n

.meas tran vdout0_7ck2020 FIND v(dout0_7) AT=2030.05n

.meas tran vdout0_8ck2020 FIND v(dout0_8) AT=2030.05n

.meas tran vdout0_0ck2030 FIND v(dout0_0) AT=2040.05n

.meas tran vdout0_1ck2030 FIND v(dout0_1) AT=2040.05n

.meas tran vdout0_2ck2030 FIND v(dout0_2) AT=2040.05n

.meas tran vdout0_3ck2030 FIND v(dout0_3) AT=2040.05n

.meas tran vdout0_4ck2030 FIND v(dout0_4) AT=2040.05n

.meas tran vdout0_5ck2030 FIND v(dout0_5) AT=2040.05n

.meas tran vdout0_6ck2030 FIND v(dout0_6) AT=2040.05n

.meas tran vdout0_7ck2030 FIND v(dout0_7) AT=2040.05n

.meas tran vdout0_8ck2030 FIND v(dout0_8) AT=2040.05n
