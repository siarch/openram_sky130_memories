.meas tran vdout0_0ck40 FIND v(dout0_0) AT=50.05n

.meas tran vdout0_1ck40 FIND v(dout0_1) AT=50.05n

.meas tran vdout0_2ck40 FIND v(dout0_2) AT=50.05n

.meas tran vdout0_3ck40 FIND v(dout0_3) AT=50.05n

.meas tran vdout0_4ck40 FIND v(dout0_4) AT=50.05n

.meas tran vdout0_5ck40 FIND v(dout0_5) AT=50.05n

.meas tran vdout0_6ck40 FIND v(dout0_6) AT=50.05n

.meas tran vdout0_7ck40 FIND v(dout0_7) AT=50.05n

.meas tran vdout0_8ck40 FIND v(dout0_8) AT=50.05n

.meas tran vdout0_0ck70 FIND v(dout0_0) AT=80.05n

.meas tran vdout0_1ck70 FIND v(dout0_1) AT=80.05n

.meas tran vdout0_2ck70 FIND v(dout0_2) AT=80.05n

.meas tran vdout0_3ck70 FIND v(dout0_3) AT=80.05n

.meas tran vdout0_4ck70 FIND v(dout0_4) AT=80.05n

.meas tran vdout0_5ck70 FIND v(dout0_5) AT=80.05n

.meas tran vdout0_6ck70 FIND v(dout0_6) AT=80.05n

.meas tran vdout0_7ck70 FIND v(dout0_7) AT=80.05n

.meas tran vdout0_8ck70 FIND v(dout0_8) AT=80.05n

.meas tran vdout0_0ck80 FIND v(dout0_0) AT=90.05n

.meas tran vdout0_1ck80 FIND v(dout0_1) AT=90.05n

.meas tran vdout0_2ck80 FIND v(dout0_2) AT=90.05n

.meas tran vdout0_3ck80 FIND v(dout0_3) AT=90.05n

.meas tran vdout0_4ck80 FIND v(dout0_4) AT=90.05n

.meas tran vdout0_5ck80 FIND v(dout0_5) AT=90.05n

.meas tran vdout0_6ck80 FIND v(dout0_6) AT=90.05n

.meas tran vdout0_7ck80 FIND v(dout0_7) AT=90.05n

.meas tran vdout0_8ck80 FIND v(dout0_8) AT=90.05n

.meas tran vdout0_0ck90 FIND v(dout0_0) AT=100.05n

.meas tran vdout0_1ck90 FIND v(dout0_1) AT=100.05n

.meas tran vdout0_2ck90 FIND v(dout0_2) AT=100.05n

.meas tran vdout0_3ck90 FIND v(dout0_3) AT=100.05n

.meas tran vdout0_4ck90 FIND v(dout0_4) AT=100.05n

.meas tran vdout0_5ck90 FIND v(dout0_5) AT=100.05n

.meas tran vdout0_6ck90 FIND v(dout0_6) AT=100.05n

.meas tran vdout0_7ck90 FIND v(dout0_7) AT=100.05n

.meas tran vdout0_8ck90 FIND v(dout0_8) AT=100.05n

.meas tran vdout0_0ck100 FIND v(dout0_0) AT=110.05n

.meas tran vdout0_1ck100 FIND v(dout0_1) AT=110.05n

.meas tran vdout0_2ck100 FIND v(dout0_2) AT=110.05n

.meas tran vdout0_3ck100 FIND v(dout0_3) AT=110.05n

.meas tran vdout0_4ck100 FIND v(dout0_4) AT=110.05n

.meas tran vdout0_5ck100 FIND v(dout0_5) AT=110.05n

.meas tran vdout0_6ck100 FIND v(dout0_6) AT=110.05n

.meas tran vdout0_7ck100 FIND v(dout0_7) AT=110.05n

.meas tran vdout0_8ck100 FIND v(dout0_8) AT=110.05n

.meas tran vdout0_0ck110 FIND v(dout0_0) AT=120.05n

.meas tran vdout0_1ck110 FIND v(dout0_1) AT=120.05n

.meas tran vdout0_2ck110 FIND v(dout0_2) AT=120.05n

.meas tran vdout0_3ck110 FIND v(dout0_3) AT=120.05n

.meas tran vdout0_4ck110 FIND v(dout0_4) AT=120.05n

.meas tran vdout0_5ck110 FIND v(dout0_5) AT=120.05n

.meas tran vdout0_6ck110 FIND v(dout0_6) AT=120.05n

.meas tran vdout0_7ck110 FIND v(dout0_7) AT=120.05n

.meas tran vdout0_8ck110 FIND v(dout0_8) AT=120.05n

.meas tran vdout0_0ck120 FIND v(dout0_0) AT=130.05n

.meas tran vdout0_1ck120 FIND v(dout0_1) AT=130.05n

.meas tran vdout0_2ck120 FIND v(dout0_2) AT=130.05n

.meas tran vdout0_3ck120 FIND v(dout0_3) AT=130.05n

.meas tran vdout0_4ck120 FIND v(dout0_4) AT=130.05n

.meas tran vdout0_5ck120 FIND v(dout0_5) AT=130.05n

.meas tran vdout0_6ck120 FIND v(dout0_6) AT=130.05n

.meas tran vdout0_7ck120 FIND v(dout0_7) AT=130.05n

.meas tran vdout0_8ck120 FIND v(dout0_8) AT=130.05n

.meas tran vdout0_0ck130 FIND v(dout0_0) AT=140.05n

.meas tran vdout0_1ck130 FIND v(dout0_1) AT=140.05n

.meas tran vdout0_2ck130 FIND v(dout0_2) AT=140.05n

.meas tran vdout0_3ck130 FIND v(dout0_3) AT=140.05n

.meas tran vdout0_4ck130 FIND v(dout0_4) AT=140.05n

.meas tran vdout0_5ck130 FIND v(dout0_5) AT=140.05n

.meas tran vdout0_6ck130 FIND v(dout0_6) AT=140.05n

.meas tran vdout0_7ck130 FIND v(dout0_7) AT=140.05n

.meas tran vdout0_8ck130 FIND v(dout0_8) AT=140.05n

.meas tran vdout0_0ck160 FIND v(dout0_0) AT=170.05n

.meas tran vdout0_1ck160 FIND v(dout0_1) AT=170.05n

.meas tran vdout0_2ck160 FIND v(dout0_2) AT=170.05n

.meas tran vdout0_3ck160 FIND v(dout0_3) AT=170.05n

.meas tran vdout0_4ck160 FIND v(dout0_4) AT=170.05n

.meas tran vdout0_5ck160 FIND v(dout0_5) AT=170.05n

.meas tran vdout0_6ck160 FIND v(dout0_6) AT=170.05n

.meas tran vdout0_7ck160 FIND v(dout0_7) AT=170.05n

.meas tran vdout0_8ck160 FIND v(dout0_8) AT=170.05n

.meas tran vdout0_0ck190 FIND v(dout0_0) AT=200.05n

.meas tran vdout0_1ck190 FIND v(dout0_1) AT=200.05n

.meas tran vdout0_2ck190 FIND v(dout0_2) AT=200.05n

.meas tran vdout0_3ck190 FIND v(dout0_3) AT=200.05n

.meas tran vdout0_4ck190 FIND v(dout0_4) AT=200.05n

.meas tran vdout0_5ck190 FIND v(dout0_5) AT=200.05n

.meas tran vdout0_6ck190 FIND v(dout0_6) AT=200.05n

.meas tran vdout0_7ck190 FIND v(dout0_7) AT=200.05n

.meas tran vdout0_8ck190 FIND v(dout0_8) AT=200.05n

.meas tran vdout0_0ck220 FIND v(dout0_0) AT=230.05n

.meas tran vdout0_1ck220 FIND v(dout0_1) AT=230.05n

.meas tran vdout0_2ck220 FIND v(dout0_2) AT=230.05n

.meas tran vdout0_3ck220 FIND v(dout0_3) AT=230.05n

.meas tran vdout0_4ck220 FIND v(dout0_4) AT=230.05n

.meas tran vdout0_5ck220 FIND v(dout0_5) AT=230.05n

.meas tran vdout0_6ck220 FIND v(dout0_6) AT=230.05n

.meas tran vdout0_7ck220 FIND v(dout0_7) AT=230.05n

.meas tran vdout0_8ck220 FIND v(dout0_8) AT=230.05n

.meas tran vdout0_0ck230 FIND v(dout0_0) AT=240.05n

.meas tran vdout0_1ck230 FIND v(dout0_1) AT=240.05n

.meas tran vdout0_2ck230 FIND v(dout0_2) AT=240.05n

.meas tran vdout0_3ck230 FIND v(dout0_3) AT=240.05n

.meas tran vdout0_4ck230 FIND v(dout0_4) AT=240.05n

.meas tran vdout0_5ck230 FIND v(dout0_5) AT=240.05n

.meas tran vdout0_6ck230 FIND v(dout0_6) AT=240.05n

.meas tran vdout0_7ck230 FIND v(dout0_7) AT=240.05n

.meas tran vdout0_8ck230 FIND v(dout0_8) AT=240.05n

.meas tran vdout0_0ck260 FIND v(dout0_0) AT=270.05n

.meas tran vdout0_1ck260 FIND v(dout0_1) AT=270.05n

.meas tran vdout0_2ck260 FIND v(dout0_2) AT=270.05n

.meas tran vdout0_3ck260 FIND v(dout0_3) AT=270.05n

.meas tran vdout0_4ck260 FIND v(dout0_4) AT=270.05n

.meas tran vdout0_5ck260 FIND v(dout0_5) AT=270.05n

.meas tran vdout0_6ck260 FIND v(dout0_6) AT=270.05n

.meas tran vdout0_7ck260 FIND v(dout0_7) AT=270.05n

.meas tran vdout0_8ck260 FIND v(dout0_8) AT=270.05n

.meas tran vdout0_0ck280 FIND v(dout0_0) AT=290.05n

.meas tran vdout0_1ck280 FIND v(dout0_1) AT=290.05n

.meas tran vdout0_2ck280 FIND v(dout0_2) AT=290.05n

.meas tran vdout0_3ck280 FIND v(dout0_3) AT=290.05n

.meas tran vdout0_4ck280 FIND v(dout0_4) AT=290.05n

.meas tran vdout0_5ck280 FIND v(dout0_5) AT=290.05n

.meas tran vdout0_6ck280 FIND v(dout0_6) AT=290.05n

.meas tran vdout0_7ck280 FIND v(dout0_7) AT=290.05n

.meas tran vdout0_8ck280 FIND v(dout0_8) AT=290.05n

.meas tran vdout0_0ck290 FIND v(dout0_0) AT=300.05n

.meas tran vdout0_1ck290 FIND v(dout0_1) AT=300.05n

.meas tran vdout0_2ck290 FIND v(dout0_2) AT=300.05n

.meas tran vdout0_3ck290 FIND v(dout0_3) AT=300.05n

.meas tran vdout0_4ck290 FIND v(dout0_4) AT=300.05n

.meas tran vdout0_5ck290 FIND v(dout0_5) AT=300.05n

.meas tran vdout0_6ck290 FIND v(dout0_6) AT=300.05n

.meas tran vdout0_7ck290 FIND v(dout0_7) AT=300.05n

.meas tran vdout0_8ck290 FIND v(dout0_8) AT=300.05n

.meas tran vdout0_0ck310 FIND v(dout0_0) AT=320.05n

.meas tran vdout0_1ck310 FIND v(dout0_1) AT=320.05n

.meas tran vdout0_2ck310 FIND v(dout0_2) AT=320.05n

.meas tran vdout0_3ck310 FIND v(dout0_3) AT=320.05n

.meas tran vdout0_4ck310 FIND v(dout0_4) AT=320.05n

.meas tran vdout0_5ck310 FIND v(dout0_5) AT=320.05n

.meas tran vdout0_6ck310 FIND v(dout0_6) AT=320.05n

.meas tran vdout0_7ck310 FIND v(dout0_7) AT=320.05n

.meas tran vdout0_8ck310 FIND v(dout0_8) AT=320.05n

.meas tran vdout0_0ck330 FIND v(dout0_0) AT=340.05n

.meas tran vdout0_1ck330 FIND v(dout0_1) AT=340.05n

.meas tran vdout0_2ck330 FIND v(dout0_2) AT=340.05n

.meas tran vdout0_3ck330 FIND v(dout0_3) AT=340.05n

.meas tran vdout0_4ck330 FIND v(dout0_4) AT=340.05n

.meas tran vdout0_5ck330 FIND v(dout0_5) AT=340.05n

.meas tran vdout0_6ck330 FIND v(dout0_6) AT=340.05n

.meas tran vdout0_7ck330 FIND v(dout0_7) AT=340.05n

.meas tran vdout0_8ck330 FIND v(dout0_8) AT=340.05n

.meas tran vdout0_0ck350 FIND v(dout0_0) AT=360.05n

.meas tran vdout0_1ck350 FIND v(dout0_1) AT=360.05n

.meas tran vdout0_2ck350 FIND v(dout0_2) AT=360.05n

.meas tran vdout0_3ck350 FIND v(dout0_3) AT=360.05n

.meas tran vdout0_4ck350 FIND v(dout0_4) AT=360.05n

.meas tran vdout0_5ck350 FIND v(dout0_5) AT=360.05n

.meas tran vdout0_6ck350 FIND v(dout0_6) AT=360.05n

.meas tran vdout0_7ck350 FIND v(dout0_7) AT=360.05n

.meas tran vdout0_8ck350 FIND v(dout0_8) AT=360.05n

.meas tran vdout0_0ck390 FIND v(dout0_0) AT=400.05n

.meas tran vdout0_1ck390 FIND v(dout0_1) AT=400.05n

.meas tran vdout0_2ck390 FIND v(dout0_2) AT=400.05n

.meas tran vdout0_3ck390 FIND v(dout0_3) AT=400.05n

.meas tran vdout0_4ck390 FIND v(dout0_4) AT=400.05n

.meas tran vdout0_5ck390 FIND v(dout0_5) AT=400.05n

.meas tran vdout0_6ck390 FIND v(dout0_6) AT=400.05n

.meas tran vdout0_7ck390 FIND v(dout0_7) AT=400.05n

.meas tran vdout0_8ck390 FIND v(dout0_8) AT=400.05n

.meas tran vdout0_0ck400 FIND v(dout0_0) AT=410.05n

.meas tran vdout0_1ck400 FIND v(dout0_1) AT=410.05n

.meas tran vdout0_2ck400 FIND v(dout0_2) AT=410.05n

.meas tran vdout0_3ck400 FIND v(dout0_3) AT=410.05n

.meas tran vdout0_4ck400 FIND v(dout0_4) AT=410.05n

.meas tran vdout0_5ck400 FIND v(dout0_5) AT=410.05n

.meas tran vdout0_6ck400 FIND v(dout0_6) AT=410.05n

.meas tran vdout0_7ck400 FIND v(dout0_7) AT=410.05n

.meas tran vdout0_8ck400 FIND v(dout0_8) AT=410.05n

.meas tran vdout0_0ck410 FIND v(dout0_0) AT=420.05n

.meas tran vdout0_1ck410 FIND v(dout0_1) AT=420.05n

.meas tran vdout0_2ck410 FIND v(dout0_2) AT=420.05n

.meas tran vdout0_3ck410 FIND v(dout0_3) AT=420.05n

.meas tran vdout0_4ck410 FIND v(dout0_4) AT=420.05n

.meas tran vdout0_5ck410 FIND v(dout0_5) AT=420.05n

.meas tran vdout0_6ck410 FIND v(dout0_6) AT=420.05n

.meas tran vdout0_7ck410 FIND v(dout0_7) AT=420.05n

.meas tran vdout0_8ck410 FIND v(dout0_8) AT=420.05n

.meas tran vdout0_0ck420 FIND v(dout0_0) AT=430.05n

.meas tran vdout0_1ck420 FIND v(dout0_1) AT=430.05n

.meas tran vdout0_2ck420 FIND v(dout0_2) AT=430.05n

.meas tran vdout0_3ck420 FIND v(dout0_3) AT=430.05n

.meas tran vdout0_4ck420 FIND v(dout0_4) AT=430.05n

.meas tran vdout0_5ck420 FIND v(dout0_5) AT=430.05n

.meas tran vdout0_6ck420 FIND v(dout0_6) AT=430.05n

.meas tran vdout0_7ck420 FIND v(dout0_7) AT=430.05n

.meas tran vdout0_8ck420 FIND v(dout0_8) AT=430.05n

.meas tran vdout0_0ck430 FIND v(dout0_0) AT=440.05n

.meas tran vdout0_1ck430 FIND v(dout0_1) AT=440.05n

.meas tran vdout0_2ck430 FIND v(dout0_2) AT=440.05n

.meas tran vdout0_3ck430 FIND v(dout0_3) AT=440.05n

.meas tran vdout0_4ck430 FIND v(dout0_4) AT=440.05n

.meas tran vdout0_5ck430 FIND v(dout0_5) AT=440.05n

.meas tran vdout0_6ck430 FIND v(dout0_6) AT=440.05n

.meas tran vdout0_7ck430 FIND v(dout0_7) AT=440.05n

.meas tran vdout0_8ck430 FIND v(dout0_8) AT=440.05n

.meas tran vdout0_0ck440 FIND v(dout0_0) AT=450.05n

.meas tran vdout0_1ck440 FIND v(dout0_1) AT=450.05n

.meas tran vdout0_2ck440 FIND v(dout0_2) AT=450.05n

.meas tran vdout0_3ck440 FIND v(dout0_3) AT=450.05n

.meas tran vdout0_4ck440 FIND v(dout0_4) AT=450.05n

.meas tran vdout0_5ck440 FIND v(dout0_5) AT=450.05n

.meas tran vdout0_6ck440 FIND v(dout0_6) AT=450.05n

.meas tran vdout0_7ck440 FIND v(dout0_7) AT=450.05n

.meas tran vdout0_8ck440 FIND v(dout0_8) AT=450.05n

.meas tran vdout0_0ck450 FIND v(dout0_0) AT=460.05n

.meas tran vdout0_1ck450 FIND v(dout0_1) AT=460.05n

.meas tran vdout0_2ck450 FIND v(dout0_2) AT=460.05n

.meas tran vdout0_3ck450 FIND v(dout0_3) AT=460.05n

.meas tran vdout0_4ck450 FIND v(dout0_4) AT=460.05n

.meas tran vdout0_5ck450 FIND v(dout0_5) AT=460.05n

.meas tran vdout0_6ck450 FIND v(dout0_6) AT=460.05n

.meas tran vdout0_7ck450 FIND v(dout0_7) AT=460.05n

.meas tran vdout0_8ck450 FIND v(dout0_8) AT=460.05n

.meas tran vdout0_0ck470 FIND v(dout0_0) AT=480.05n

.meas tran vdout0_1ck470 FIND v(dout0_1) AT=480.05n

.meas tran vdout0_2ck470 FIND v(dout0_2) AT=480.05n

.meas tran vdout0_3ck470 FIND v(dout0_3) AT=480.05n

.meas tran vdout0_4ck470 FIND v(dout0_4) AT=480.05n

.meas tran vdout0_5ck470 FIND v(dout0_5) AT=480.05n

.meas tran vdout0_6ck470 FIND v(dout0_6) AT=480.05n

.meas tran vdout0_7ck470 FIND v(dout0_7) AT=480.05n

.meas tran vdout0_8ck470 FIND v(dout0_8) AT=480.05n

.meas tran vdout0_0ck480 FIND v(dout0_0) AT=490.05n

.meas tran vdout0_1ck480 FIND v(dout0_1) AT=490.05n

.meas tran vdout0_2ck480 FIND v(dout0_2) AT=490.05n

.meas tran vdout0_3ck480 FIND v(dout0_3) AT=490.05n

.meas tran vdout0_4ck480 FIND v(dout0_4) AT=490.05n

.meas tran vdout0_5ck480 FIND v(dout0_5) AT=490.05n

.meas tran vdout0_6ck480 FIND v(dout0_6) AT=490.05n

.meas tran vdout0_7ck480 FIND v(dout0_7) AT=490.05n

.meas tran vdout0_8ck480 FIND v(dout0_8) AT=490.05n

.meas tran vdout0_0ck490 FIND v(dout0_0) AT=500.05n

.meas tran vdout0_1ck490 FIND v(dout0_1) AT=500.05n

.meas tran vdout0_2ck490 FIND v(dout0_2) AT=500.05n

.meas tran vdout0_3ck490 FIND v(dout0_3) AT=500.05n

.meas tran vdout0_4ck490 FIND v(dout0_4) AT=500.05n

.meas tran vdout0_5ck490 FIND v(dout0_5) AT=500.05n

.meas tran vdout0_6ck490 FIND v(dout0_6) AT=500.05n

.meas tran vdout0_7ck490 FIND v(dout0_7) AT=500.05n

.meas tran vdout0_8ck490 FIND v(dout0_8) AT=500.05n

.meas tran vdout0_0ck500 FIND v(dout0_0) AT=510.05n

.meas tran vdout0_1ck500 FIND v(dout0_1) AT=510.05n

.meas tran vdout0_2ck500 FIND v(dout0_2) AT=510.05n

.meas tran vdout0_3ck500 FIND v(dout0_3) AT=510.05n

.meas tran vdout0_4ck500 FIND v(dout0_4) AT=510.05n

.meas tran vdout0_5ck500 FIND v(dout0_5) AT=510.05n

.meas tran vdout0_6ck500 FIND v(dout0_6) AT=510.05n

.meas tran vdout0_7ck500 FIND v(dout0_7) AT=510.05n

.meas tran vdout0_8ck500 FIND v(dout0_8) AT=510.05n

.meas tran vdout0_0ck530 FIND v(dout0_0) AT=540.05n

.meas tran vdout0_1ck530 FIND v(dout0_1) AT=540.05n

.meas tran vdout0_2ck530 FIND v(dout0_2) AT=540.05n

.meas tran vdout0_3ck530 FIND v(dout0_3) AT=540.05n

.meas tran vdout0_4ck530 FIND v(dout0_4) AT=540.05n

.meas tran vdout0_5ck530 FIND v(dout0_5) AT=540.05n

.meas tran vdout0_6ck530 FIND v(dout0_6) AT=540.05n

.meas tran vdout0_7ck530 FIND v(dout0_7) AT=540.05n

.meas tran vdout0_8ck530 FIND v(dout0_8) AT=540.05n

.meas tran vdout0_0ck590 FIND v(dout0_0) AT=600.05n

.meas tran vdout0_1ck590 FIND v(dout0_1) AT=600.05n

.meas tran vdout0_2ck590 FIND v(dout0_2) AT=600.05n

.meas tran vdout0_3ck590 FIND v(dout0_3) AT=600.05n

.meas tran vdout0_4ck590 FIND v(dout0_4) AT=600.05n

.meas tran vdout0_5ck590 FIND v(dout0_5) AT=600.05n

.meas tran vdout0_6ck590 FIND v(dout0_6) AT=600.05n

.meas tran vdout0_7ck590 FIND v(dout0_7) AT=600.05n

.meas tran vdout0_8ck590 FIND v(dout0_8) AT=600.05n

.meas tran vdout0_0ck610 FIND v(dout0_0) AT=620.05n

.meas tran vdout0_1ck610 FIND v(dout0_1) AT=620.05n

.meas tran vdout0_2ck610 FIND v(dout0_2) AT=620.05n

.meas tran vdout0_3ck610 FIND v(dout0_3) AT=620.05n

.meas tran vdout0_4ck610 FIND v(dout0_4) AT=620.05n

.meas tran vdout0_5ck610 FIND v(dout0_5) AT=620.05n

.meas tran vdout0_6ck610 FIND v(dout0_6) AT=620.05n

.meas tran vdout0_7ck610 FIND v(dout0_7) AT=620.05n

.meas tran vdout0_8ck610 FIND v(dout0_8) AT=620.05n

.meas tran vdout0_0ck650 FIND v(dout0_0) AT=660.05n

.meas tran vdout0_1ck650 FIND v(dout0_1) AT=660.05n

.meas tran vdout0_2ck650 FIND v(dout0_2) AT=660.05n

.meas tran vdout0_3ck650 FIND v(dout0_3) AT=660.05n

.meas tran vdout0_4ck650 FIND v(dout0_4) AT=660.05n

.meas tran vdout0_5ck650 FIND v(dout0_5) AT=660.05n

.meas tran vdout0_6ck650 FIND v(dout0_6) AT=660.05n

.meas tran vdout0_7ck650 FIND v(dout0_7) AT=660.05n

.meas tran vdout0_8ck650 FIND v(dout0_8) AT=660.05n

.meas tran vdout0_0ck660 FIND v(dout0_0) AT=670.05n

.meas tran vdout0_1ck660 FIND v(dout0_1) AT=670.05n

.meas tran vdout0_2ck660 FIND v(dout0_2) AT=670.05n

.meas tran vdout0_3ck660 FIND v(dout0_3) AT=670.05n

.meas tran vdout0_4ck660 FIND v(dout0_4) AT=670.05n

.meas tran vdout0_5ck660 FIND v(dout0_5) AT=670.05n

.meas tran vdout0_6ck660 FIND v(dout0_6) AT=670.05n

.meas tran vdout0_7ck660 FIND v(dout0_7) AT=670.05n

.meas tran vdout0_8ck660 FIND v(dout0_8) AT=670.05n

.meas tran vdout0_0ck670 FIND v(dout0_0) AT=680.05n

.meas tran vdout0_1ck670 FIND v(dout0_1) AT=680.05n

.meas tran vdout0_2ck670 FIND v(dout0_2) AT=680.05n

.meas tran vdout0_3ck670 FIND v(dout0_3) AT=680.05n

.meas tran vdout0_4ck670 FIND v(dout0_4) AT=680.05n

.meas tran vdout0_5ck670 FIND v(dout0_5) AT=680.05n

.meas tran vdout0_6ck670 FIND v(dout0_6) AT=680.05n

.meas tran vdout0_7ck670 FIND v(dout0_7) AT=680.05n

.meas tran vdout0_8ck670 FIND v(dout0_8) AT=680.05n

.meas tran vdout0_0ck680 FIND v(dout0_0) AT=690.05n

.meas tran vdout0_1ck680 FIND v(dout0_1) AT=690.05n

.meas tran vdout0_2ck680 FIND v(dout0_2) AT=690.05n

.meas tran vdout0_3ck680 FIND v(dout0_3) AT=690.05n

.meas tran vdout0_4ck680 FIND v(dout0_4) AT=690.05n

.meas tran vdout0_5ck680 FIND v(dout0_5) AT=690.05n

.meas tran vdout0_6ck680 FIND v(dout0_6) AT=690.05n

.meas tran vdout0_7ck680 FIND v(dout0_7) AT=690.05n

.meas tran vdout0_8ck680 FIND v(dout0_8) AT=690.05n

.meas tran vdout0_0ck700 FIND v(dout0_0) AT=710.05n

.meas tran vdout0_1ck700 FIND v(dout0_1) AT=710.05n

.meas tran vdout0_2ck700 FIND v(dout0_2) AT=710.05n

.meas tran vdout0_3ck700 FIND v(dout0_3) AT=710.05n

.meas tran vdout0_4ck700 FIND v(dout0_4) AT=710.05n

.meas tran vdout0_5ck700 FIND v(dout0_5) AT=710.05n

.meas tran vdout0_6ck700 FIND v(dout0_6) AT=710.05n

.meas tran vdout0_7ck700 FIND v(dout0_7) AT=710.05n

.meas tran vdout0_8ck700 FIND v(dout0_8) AT=710.05n

.meas tran vdout0_0ck770 FIND v(dout0_0) AT=780.05n

.meas tran vdout0_1ck770 FIND v(dout0_1) AT=780.05n

.meas tran vdout0_2ck770 FIND v(dout0_2) AT=780.05n

.meas tran vdout0_3ck770 FIND v(dout0_3) AT=780.05n

.meas tran vdout0_4ck770 FIND v(dout0_4) AT=780.05n

.meas tran vdout0_5ck770 FIND v(dout0_5) AT=780.05n

.meas tran vdout0_6ck770 FIND v(dout0_6) AT=780.05n

.meas tran vdout0_7ck770 FIND v(dout0_7) AT=780.05n

.meas tran vdout0_8ck770 FIND v(dout0_8) AT=780.05n

.meas tran vdout0_0ck790 FIND v(dout0_0) AT=800.05n

.meas tran vdout0_1ck790 FIND v(dout0_1) AT=800.05n

.meas tran vdout0_2ck790 FIND v(dout0_2) AT=800.05n

.meas tran vdout0_3ck790 FIND v(dout0_3) AT=800.05n

.meas tran vdout0_4ck790 FIND v(dout0_4) AT=800.05n

.meas tran vdout0_5ck790 FIND v(dout0_5) AT=800.05n

.meas tran vdout0_6ck790 FIND v(dout0_6) AT=800.05n

.meas tran vdout0_7ck790 FIND v(dout0_7) AT=800.05n

.meas tran vdout0_8ck790 FIND v(dout0_8) AT=800.05n

.meas tran vdout0_0ck820 FIND v(dout0_0) AT=830.05n

.meas tran vdout0_1ck820 FIND v(dout0_1) AT=830.05n

.meas tran vdout0_2ck820 FIND v(dout0_2) AT=830.05n

.meas tran vdout0_3ck820 FIND v(dout0_3) AT=830.05n

.meas tran vdout0_4ck820 FIND v(dout0_4) AT=830.05n

.meas tran vdout0_5ck820 FIND v(dout0_5) AT=830.05n

.meas tran vdout0_6ck820 FIND v(dout0_6) AT=830.05n

.meas tran vdout0_7ck820 FIND v(dout0_7) AT=830.05n

.meas tran vdout0_8ck820 FIND v(dout0_8) AT=830.05n

.meas tran vdout0_0ck830 FIND v(dout0_0) AT=840.05n

.meas tran vdout0_1ck830 FIND v(dout0_1) AT=840.05n

.meas tran vdout0_2ck830 FIND v(dout0_2) AT=840.05n

.meas tran vdout0_3ck830 FIND v(dout0_3) AT=840.05n

.meas tran vdout0_4ck830 FIND v(dout0_4) AT=840.05n

.meas tran vdout0_5ck830 FIND v(dout0_5) AT=840.05n

.meas tran vdout0_6ck830 FIND v(dout0_6) AT=840.05n

.meas tran vdout0_7ck830 FIND v(dout0_7) AT=840.05n

.meas tran vdout0_8ck830 FIND v(dout0_8) AT=840.05n

.meas tran vdout0_0ck880 FIND v(dout0_0) AT=890.05n

.meas tran vdout0_1ck880 FIND v(dout0_1) AT=890.05n

.meas tran vdout0_2ck880 FIND v(dout0_2) AT=890.05n

.meas tran vdout0_3ck880 FIND v(dout0_3) AT=890.05n

.meas tran vdout0_4ck880 FIND v(dout0_4) AT=890.05n

.meas tran vdout0_5ck880 FIND v(dout0_5) AT=890.05n

.meas tran vdout0_6ck880 FIND v(dout0_6) AT=890.05n

.meas tran vdout0_7ck880 FIND v(dout0_7) AT=890.05n

.meas tran vdout0_8ck880 FIND v(dout0_8) AT=890.05n

.meas tran vdout0_0ck930 FIND v(dout0_0) AT=940.05n

.meas tran vdout0_1ck930 FIND v(dout0_1) AT=940.05n

.meas tran vdout0_2ck930 FIND v(dout0_2) AT=940.05n

.meas tran vdout0_3ck930 FIND v(dout0_3) AT=940.05n

.meas tran vdout0_4ck930 FIND v(dout0_4) AT=940.05n

.meas tran vdout0_5ck930 FIND v(dout0_5) AT=940.05n

.meas tran vdout0_6ck930 FIND v(dout0_6) AT=940.05n

.meas tran vdout0_7ck930 FIND v(dout0_7) AT=940.05n

.meas tran vdout0_8ck930 FIND v(dout0_8) AT=940.05n

.meas tran vdout0_0ck940 FIND v(dout0_0) AT=950.05n

.meas tran vdout0_1ck940 FIND v(dout0_1) AT=950.05n

.meas tran vdout0_2ck940 FIND v(dout0_2) AT=950.05n

.meas tran vdout0_3ck940 FIND v(dout0_3) AT=950.05n

.meas tran vdout0_4ck940 FIND v(dout0_4) AT=950.05n

.meas tran vdout0_5ck940 FIND v(dout0_5) AT=950.05n

.meas tran vdout0_6ck940 FIND v(dout0_6) AT=950.05n

.meas tran vdout0_7ck940 FIND v(dout0_7) AT=950.05n

.meas tran vdout0_8ck940 FIND v(dout0_8) AT=950.05n

.meas tran vdout0_0ck990 FIND v(dout0_0) AT=1000.05n

.meas tran vdout0_1ck990 FIND v(dout0_1) AT=1000.05n

.meas tran vdout0_2ck990 FIND v(dout0_2) AT=1000.05n

.meas tran vdout0_3ck990 FIND v(dout0_3) AT=1000.05n

.meas tran vdout0_4ck990 FIND v(dout0_4) AT=1000.05n

.meas tran vdout0_5ck990 FIND v(dout0_5) AT=1000.05n

.meas tran vdout0_6ck990 FIND v(dout0_6) AT=1000.05n

.meas tran vdout0_7ck990 FIND v(dout0_7) AT=1000.05n

.meas tran vdout0_8ck990 FIND v(dout0_8) AT=1000.05n

.meas tran vdout0_0ck1030 FIND v(dout0_0) AT=1040.05n

.meas tran vdout0_1ck1030 FIND v(dout0_1) AT=1040.05n

.meas tran vdout0_2ck1030 FIND v(dout0_2) AT=1040.05n

.meas tran vdout0_3ck1030 FIND v(dout0_3) AT=1040.05n

.meas tran vdout0_4ck1030 FIND v(dout0_4) AT=1040.05n

.meas tran vdout0_5ck1030 FIND v(dout0_5) AT=1040.05n

.meas tran vdout0_6ck1030 FIND v(dout0_6) AT=1040.05n

.meas tran vdout0_7ck1030 FIND v(dout0_7) AT=1040.05n

.meas tran vdout0_8ck1030 FIND v(dout0_8) AT=1040.05n

.meas tran vdout0_0ck1040 FIND v(dout0_0) AT=1050.05n

.meas tran vdout0_1ck1040 FIND v(dout0_1) AT=1050.05n

.meas tran vdout0_2ck1040 FIND v(dout0_2) AT=1050.05n

.meas tran vdout0_3ck1040 FIND v(dout0_3) AT=1050.05n

.meas tran vdout0_4ck1040 FIND v(dout0_4) AT=1050.05n

.meas tran vdout0_5ck1040 FIND v(dout0_5) AT=1050.05n

.meas tran vdout0_6ck1040 FIND v(dout0_6) AT=1050.05n

.meas tran vdout0_7ck1040 FIND v(dout0_7) AT=1050.05n

.meas tran vdout0_8ck1040 FIND v(dout0_8) AT=1050.05n

.meas tran vdout0_0ck1140 FIND v(dout0_0) AT=1150.05n

.meas tran vdout0_1ck1140 FIND v(dout0_1) AT=1150.05n

.meas tran vdout0_2ck1140 FIND v(dout0_2) AT=1150.05n

.meas tran vdout0_3ck1140 FIND v(dout0_3) AT=1150.05n

.meas tran vdout0_4ck1140 FIND v(dout0_4) AT=1150.05n

.meas tran vdout0_5ck1140 FIND v(dout0_5) AT=1150.05n

.meas tran vdout0_6ck1140 FIND v(dout0_6) AT=1150.05n

.meas tran vdout0_7ck1140 FIND v(dout0_7) AT=1150.05n

.meas tran vdout0_8ck1140 FIND v(dout0_8) AT=1150.05n

.meas tran vdout0_0ck1160 FIND v(dout0_0) AT=1170.05n

.meas tran vdout0_1ck1160 FIND v(dout0_1) AT=1170.05n

.meas tran vdout0_2ck1160 FIND v(dout0_2) AT=1170.05n

.meas tran vdout0_3ck1160 FIND v(dout0_3) AT=1170.05n

.meas tran vdout0_4ck1160 FIND v(dout0_4) AT=1170.05n

.meas tran vdout0_5ck1160 FIND v(dout0_5) AT=1170.05n

.meas tran vdout0_6ck1160 FIND v(dout0_6) AT=1170.05n

.meas tran vdout0_7ck1160 FIND v(dout0_7) AT=1170.05n

.meas tran vdout0_8ck1160 FIND v(dout0_8) AT=1170.05n

.meas tran vdout0_0ck1210 FIND v(dout0_0) AT=1220.05n

.meas tran vdout0_1ck1210 FIND v(dout0_1) AT=1220.05n

.meas tran vdout0_2ck1210 FIND v(dout0_2) AT=1220.05n

.meas tran vdout0_3ck1210 FIND v(dout0_3) AT=1220.05n

.meas tran vdout0_4ck1210 FIND v(dout0_4) AT=1220.05n

.meas tran vdout0_5ck1210 FIND v(dout0_5) AT=1220.05n

.meas tran vdout0_6ck1210 FIND v(dout0_6) AT=1220.05n

.meas tran vdout0_7ck1210 FIND v(dout0_7) AT=1220.05n

.meas tran vdout0_8ck1210 FIND v(dout0_8) AT=1220.05n

.meas tran vdout0_0ck1230 FIND v(dout0_0) AT=1240.05n

.meas tran vdout0_1ck1230 FIND v(dout0_1) AT=1240.05n

.meas tran vdout0_2ck1230 FIND v(dout0_2) AT=1240.05n

.meas tran vdout0_3ck1230 FIND v(dout0_3) AT=1240.05n

.meas tran vdout0_4ck1230 FIND v(dout0_4) AT=1240.05n

.meas tran vdout0_5ck1230 FIND v(dout0_5) AT=1240.05n

.meas tran vdout0_6ck1230 FIND v(dout0_6) AT=1240.05n

.meas tran vdout0_7ck1230 FIND v(dout0_7) AT=1240.05n

.meas tran vdout0_8ck1230 FIND v(dout0_8) AT=1240.05n

.meas tran vdout0_0ck1240 FIND v(dout0_0) AT=1250.05n

.meas tran vdout0_1ck1240 FIND v(dout0_1) AT=1250.05n

.meas tran vdout0_2ck1240 FIND v(dout0_2) AT=1250.05n

.meas tran vdout0_3ck1240 FIND v(dout0_3) AT=1250.05n

.meas tran vdout0_4ck1240 FIND v(dout0_4) AT=1250.05n

.meas tran vdout0_5ck1240 FIND v(dout0_5) AT=1250.05n

.meas tran vdout0_6ck1240 FIND v(dout0_6) AT=1250.05n

.meas tran vdout0_7ck1240 FIND v(dout0_7) AT=1250.05n

.meas tran vdout0_8ck1240 FIND v(dout0_8) AT=1250.05n

.meas tran vdout0_0ck1250 FIND v(dout0_0) AT=1260.05n

.meas tran vdout0_1ck1250 FIND v(dout0_1) AT=1260.05n

.meas tran vdout0_2ck1250 FIND v(dout0_2) AT=1260.05n

.meas tran vdout0_3ck1250 FIND v(dout0_3) AT=1260.05n

.meas tran vdout0_4ck1250 FIND v(dout0_4) AT=1260.05n

.meas tran vdout0_5ck1250 FIND v(dout0_5) AT=1260.05n

.meas tran vdout0_6ck1250 FIND v(dout0_6) AT=1260.05n

.meas tran vdout0_7ck1250 FIND v(dout0_7) AT=1260.05n

.meas tran vdout0_8ck1250 FIND v(dout0_8) AT=1260.05n

.meas tran vdout0_0ck1280 FIND v(dout0_0) AT=1290.05n

.meas tran vdout0_1ck1280 FIND v(dout0_1) AT=1290.05n

.meas tran vdout0_2ck1280 FIND v(dout0_2) AT=1290.05n

.meas tran vdout0_3ck1280 FIND v(dout0_3) AT=1290.05n

.meas tran vdout0_4ck1280 FIND v(dout0_4) AT=1290.05n

.meas tran vdout0_5ck1280 FIND v(dout0_5) AT=1290.05n

.meas tran vdout0_6ck1280 FIND v(dout0_6) AT=1290.05n

.meas tran vdout0_7ck1280 FIND v(dout0_7) AT=1290.05n

.meas tran vdout0_8ck1280 FIND v(dout0_8) AT=1290.05n

.meas tran vdout0_0ck1350 FIND v(dout0_0) AT=1360.05n

.meas tran vdout0_1ck1350 FIND v(dout0_1) AT=1360.05n

.meas tran vdout0_2ck1350 FIND v(dout0_2) AT=1360.05n

.meas tran vdout0_3ck1350 FIND v(dout0_3) AT=1360.05n

.meas tran vdout0_4ck1350 FIND v(dout0_4) AT=1360.05n

.meas tran vdout0_5ck1350 FIND v(dout0_5) AT=1360.05n

.meas tran vdout0_6ck1350 FIND v(dout0_6) AT=1360.05n

.meas tran vdout0_7ck1350 FIND v(dout0_7) AT=1360.05n

.meas tran vdout0_8ck1350 FIND v(dout0_8) AT=1360.05n

.meas tran vdout0_0ck1380 FIND v(dout0_0) AT=1390.05n

.meas tran vdout0_1ck1380 FIND v(dout0_1) AT=1390.05n

.meas tran vdout0_2ck1380 FIND v(dout0_2) AT=1390.05n

.meas tran vdout0_3ck1380 FIND v(dout0_3) AT=1390.05n

.meas tran vdout0_4ck1380 FIND v(dout0_4) AT=1390.05n

.meas tran vdout0_5ck1380 FIND v(dout0_5) AT=1390.05n

.meas tran vdout0_6ck1380 FIND v(dout0_6) AT=1390.05n

.meas tran vdout0_7ck1380 FIND v(dout0_7) AT=1390.05n

.meas tran vdout0_8ck1380 FIND v(dout0_8) AT=1390.05n

.meas tran vdout0_0ck1390 FIND v(dout0_0) AT=1400.05n

.meas tran vdout0_1ck1390 FIND v(dout0_1) AT=1400.05n

.meas tran vdout0_2ck1390 FIND v(dout0_2) AT=1400.05n

.meas tran vdout0_3ck1390 FIND v(dout0_3) AT=1400.05n

.meas tran vdout0_4ck1390 FIND v(dout0_4) AT=1400.05n

.meas tran vdout0_5ck1390 FIND v(dout0_5) AT=1400.05n

.meas tran vdout0_6ck1390 FIND v(dout0_6) AT=1400.05n

.meas tran vdout0_7ck1390 FIND v(dout0_7) AT=1400.05n

.meas tran vdout0_8ck1390 FIND v(dout0_8) AT=1400.05n

.meas tran vdout0_0ck1400 FIND v(dout0_0) AT=1410.05n

.meas tran vdout0_1ck1400 FIND v(dout0_1) AT=1410.05n

.meas tran vdout0_2ck1400 FIND v(dout0_2) AT=1410.05n

.meas tran vdout0_3ck1400 FIND v(dout0_3) AT=1410.05n

.meas tran vdout0_4ck1400 FIND v(dout0_4) AT=1410.05n

.meas tran vdout0_5ck1400 FIND v(dout0_5) AT=1410.05n

.meas tran vdout0_6ck1400 FIND v(dout0_6) AT=1410.05n

.meas tran vdout0_7ck1400 FIND v(dout0_7) AT=1410.05n

.meas tran vdout0_8ck1400 FIND v(dout0_8) AT=1410.05n

.meas tran vdout0_0ck1410 FIND v(dout0_0) AT=1420.05n

.meas tran vdout0_1ck1410 FIND v(dout0_1) AT=1420.05n

.meas tran vdout0_2ck1410 FIND v(dout0_2) AT=1420.05n

.meas tran vdout0_3ck1410 FIND v(dout0_3) AT=1420.05n

.meas tran vdout0_4ck1410 FIND v(dout0_4) AT=1420.05n

.meas tran vdout0_5ck1410 FIND v(dout0_5) AT=1420.05n

.meas tran vdout0_6ck1410 FIND v(dout0_6) AT=1420.05n

.meas tran vdout0_7ck1410 FIND v(dout0_7) AT=1420.05n

.meas tran vdout0_8ck1410 FIND v(dout0_8) AT=1420.05n

.meas tran vdout0_0ck1440 FIND v(dout0_0) AT=1450.05n

.meas tran vdout0_1ck1440 FIND v(dout0_1) AT=1450.05n

.meas tran vdout0_2ck1440 FIND v(dout0_2) AT=1450.05n

.meas tran vdout0_3ck1440 FIND v(dout0_3) AT=1450.05n

.meas tran vdout0_4ck1440 FIND v(dout0_4) AT=1450.05n

.meas tran vdout0_5ck1440 FIND v(dout0_5) AT=1450.05n

.meas tran vdout0_6ck1440 FIND v(dout0_6) AT=1450.05n

.meas tran vdout0_7ck1440 FIND v(dout0_7) AT=1450.05n

.meas tran vdout0_8ck1440 FIND v(dout0_8) AT=1450.05n

.meas tran vdout0_0ck1460 FIND v(dout0_0) AT=1470.05n

.meas tran vdout0_1ck1460 FIND v(dout0_1) AT=1470.05n

.meas tran vdout0_2ck1460 FIND v(dout0_2) AT=1470.05n

.meas tran vdout0_3ck1460 FIND v(dout0_3) AT=1470.05n

.meas tran vdout0_4ck1460 FIND v(dout0_4) AT=1470.05n

.meas tran vdout0_5ck1460 FIND v(dout0_5) AT=1470.05n

.meas tran vdout0_6ck1460 FIND v(dout0_6) AT=1470.05n

.meas tran vdout0_7ck1460 FIND v(dout0_7) AT=1470.05n

.meas tran vdout0_8ck1460 FIND v(dout0_8) AT=1470.05n

.meas tran vdout0_0ck1470 FIND v(dout0_0) AT=1480.05n

.meas tran vdout0_1ck1470 FIND v(dout0_1) AT=1480.05n

.meas tran vdout0_2ck1470 FIND v(dout0_2) AT=1480.05n

.meas tran vdout0_3ck1470 FIND v(dout0_3) AT=1480.05n

.meas tran vdout0_4ck1470 FIND v(dout0_4) AT=1480.05n

.meas tran vdout0_5ck1470 FIND v(dout0_5) AT=1480.05n

.meas tran vdout0_6ck1470 FIND v(dout0_6) AT=1480.05n

.meas tran vdout0_7ck1470 FIND v(dout0_7) AT=1480.05n

.meas tran vdout0_8ck1470 FIND v(dout0_8) AT=1480.05n

.meas tran vdout0_0ck1490 FIND v(dout0_0) AT=1500.05n

.meas tran vdout0_1ck1490 FIND v(dout0_1) AT=1500.05n

.meas tran vdout0_2ck1490 FIND v(dout0_2) AT=1500.05n

.meas tran vdout0_3ck1490 FIND v(dout0_3) AT=1500.05n

.meas tran vdout0_4ck1490 FIND v(dout0_4) AT=1500.05n

.meas tran vdout0_5ck1490 FIND v(dout0_5) AT=1500.05n

.meas tran vdout0_6ck1490 FIND v(dout0_6) AT=1500.05n

.meas tran vdout0_7ck1490 FIND v(dout0_7) AT=1500.05n

.meas tran vdout0_8ck1490 FIND v(dout0_8) AT=1500.05n

.meas tran vdout0_0ck1510 FIND v(dout0_0) AT=1520.05n

.meas tran vdout0_1ck1510 FIND v(dout0_1) AT=1520.05n

.meas tran vdout0_2ck1510 FIND v(dout0_2) AT=1520.05n

.meas tran vdout0_3ck1510 FIND v(dout0_3) AT=1520.05n

.meas tran vdout0_4ck1510 FIND v(dout0_4) AT=1520.05n

.meas tran vdout0_5ck1510 FIND v(dout0_5) AT=1520.05n

.meas tran vdout0_6ck1510 FIND v(dout0_6) AT=1520.05n

.meas tran vdout0_7ck1510 FIND v(dout0_7) AT=1520.05n

.meas tran vdout0_8ck1510 FIND v(dout0_8) AT=1520.05n

.meas tran vdout0_0ck1530 FIND v(dout0_0) AT=1540.05n

.meas tran vdout0_1ck1530 FIND v(dout0_1) AT=1540.05n

.meas tran vdout0_2ck1530 FIND v(dout0_2) AT=1540.05n

.meas tran vdout0_3ck1530 FIND v(dout0_3) AT=1540.05n

.meas tran vdout0_4ck1530 FIND v(dout0_4) AT=1540.05n

.meas tran vdout0_5ck1530 FIND v(dout0_5) AT=1540.05n

.meas tran vdout0_6ck1530 FIND v(dout0_6) AT=1540.05n

.meas tran vdout0_7ck1530 FIND v(dout0_7) AT=1540.05n

.meas tran vdout0_8ck1530 FIND v(dout0_8) AT=1540.05n

.meas tran vdout0_0ck1550 FIND v(dout0_0) AT=1560.05n

.meas tran vdout0_1ck1550 FIND v(dout0_1) AT=1560.05n

.meas tran vdout0_2ck1550 FIND v(dout0_2) AT=1560.05n

.meas tran vdout0_3ck1550 FIND v(dout0_3) AT=1560.05n

.meas tran vdout0_4ck1550 FIND v(dout0_4) AT=1560.05n

.meas tran vdout0_5ck1550 FIND v(dout0_5) AT=1560.05n

.meas tran vdout0_6ck1550 FIND v(dout0_6) AT=1560.05n

.meas tran vdout0_7ck1550 FIND v(dout0_7) AT=1560.05n

.meas tran vdout0_8ck1550 FIND v(dout0_8) AT=1560.05n

.meas tran vdout0_0ck1580 FIND v(dout0_0) AT=1590.05n

.meas tran vdout0_1ck1580 FIND v(dout0_1) AT=1590.05n

.meas tran vdout0_2ck1580 FIND v(dout0_2) AT=1590.05n

.meas tran vdout0_3ck1580 FIND v(dout0_3) AT=1590.05n

.meas tran vdout0_4ck1580 FIND v(dout0_4) AT=1590.05n

.meas tran vdout0_5ck1580 FIND v(dout0_5) AT=1590.05n

.meas tran vdout0_6ck1580 FIND v(dout0_6) AT=1590.05n

.meas tran vdout0_7ck1580 FIND v(dout0_7) AT=1590.05n

.meas tran vdout0_8ck1580 FIND v(dout0_8) AT=1590.05n

.meas tran vdout0_0ck1590 FIND v(dout0_0) AT=1600.05n

.meas tran vdout0_1ck1590 FIND v(dout0_1) AT=1600.05n

.meas tran vdout0_2ck1590 FIND v(dout0_2) AT=1600.05n

.meas tran vdout0_3ck1590 FIND v(dout0_3) AT=1600.05n

.meas tran vdout0_4ck1590 FIND v(dout0_4) AT=1600.05n

.meas tran vdout0_5ck1590 FIND v(dout0_5) AT=1600.05n

.meas tran vdout0_6ck1590 FIND v(dout0_6) AT=1600.05n

.meas tran vdout0_7ck1590 FIND v(dout0_7) AT=1600.05n

.meas tran vdout0_8ck1590 FIND v(dout0_8) AT=1600.05n

.meas tran vdout0_0ck1600 FIND v(dout0_0) AT=1610.05n

.meas tran vdout0_1ck1600 FIND v(dout0_1) AT=1610.05n

.meas tran vdout0_2ck1600 FIND v(dout0_2) AT=1610.05n

.meas tran vdout0_3ck1600 FIND v(dout0_3) AT=1610.05n

.meas tran vdout0_4ck1600 FIND v(dout0_4) AT=1610.05n

.meas tran vdout0_5ck1600 FIND v(dout0_5) AT=1610.05n

.meas tran vdout0_6ck1600 FIND v(dout0_6) AT=1610.05n

.meas tran vdout0_7ck1600 FIND v(dout0_7) AT=1610.05n

.meas tran vdout0_8ck1600 FIND v(dout0_8) AT=1610.05n

.meas tran vdout0_0ck1650 FIND v(dout0_0) AT=1660.05n

.meas tran vdout0_1ck1650 FIND v(dout0_1) AT=1660.05n

.meas tran vdout0_2ck1650 FIND v(dout0_2) AT=1660.05n

.meas tran vdout0_3ck1650 FIND v(dout0_3) AT=1660.05n

.meas tran vdout0_4ck1650 FIND v(dout0_4) AT=1660.05n

.meas tran vdout0_5ck1650 FIND v(dout0_5) AT=1660.05n

.meas tran vdout0_6ck1650 FIND v(dout0_6) AT=1660.05n

.meas tran vdout0_7ck1650 FIND v(dout0_7) AT=1660.05n

.meas tran vdout0_8ck1650 FIND v(dout0_8) AT=1660.05n

.meas tran vdout0_0ck1690 FIND v(dout0_0) AT=1700.05n

.meas tran vdout0_1ck1690 FIND v(dout0_1) AT=1700.05n

.meas tran vdout0_2ck1690 FIND v(dout0_2) AT=1700.05n

.meas tran vdout0_3ck1690 FIND v(dout0_3) AT=1700.05n

.meas tran vdout0_4ck1690 FIND v(dout0_4) AT=1700.05n

.meas tran vdout0_5ck1690 FIND v(dout0_5) AT=1700.05n

.meas tran vdout0_6ck1690 FIND v(dout0_6) AT=1700.05n

.meas tran vdout0_7ck1690 FIND v(dout0_7) AT=1700.05n

.meas tran vdout0_8ck1690 FIND v(dout0_8) AT=1700.05n

.meas tran vdout0_0ck1750 FIND v(dout0_0) AT=1760.05n

.meas tran vdout0_1ck1750 FIND v(dout0_1) AT=1760.05n

.meas tran vdout0_2ck1750 FIND v(dout0_2) AT=1760.05n

.meas tran vdout0_3ck1750 FIND v(dout0_3) AT=1760.05n

.meas tran vdout0_4ck1750 FIND v(dout0_4) AT=1760.05n

.meas tran vdout0_5ck1750 FIND v(dout0_5) AT=1760.05n

.meas tran vdout0_6ck1750 FIND v(dout0_6) AT=1760.05n

.meas tran vdout0_7ck1750 FIND v(dout0_7) AT=1760.05n

.meas tran vdout0_8ck1750 FIND v(dout0_8) AT=1760.05n

.meas tran vdout0_0ck1770 FIND v(dout0_0) AT=1780.05n

.meas tran vdout0_1ck1770 FIND v(dout0_1) AT=1780.05n

.meas tran vdout0_2ck1770 FIND v(dout0_2) AT=1780.05n

.meas tran vdout0_3ck1770 FIND v(dout0_3) AT=1780.05n

.meas tran vdout0_4ck1770 FIND v(dout0_4) AT=1780.05n

.meas tran vdout0_5ck1770 FIND v(dout0_5) AT=1780.05n

.meas tran vdout0_6ck1770 FIND v(dout0_6) AT=1780.05n

.meas tran vdout0_7ck1770 FIND v(dout0_7) AT=1780.05n

.meas tran vdout0_8ck1770 FIND v(dout0_8) AT=1780.05n

.meas tran vdout0_0ck1780 FIND v(dout0_0) AT=1790.05n

.meas tran vdout0_1ck1780 FIND v(dout0_1) AT=1790.05n

.meas tran vdout0_2ck1780 FIND v(dout0_2) AT=1790.05n

.meas tran vdout0_3ck1780 FIND v(dout0_3) AT=1790.05n

.meas tran vdout0_4ck1780 FIND v(dout0_4) AT=1790.05n

.meas tran vdout0_5ck1780 FIND v(dout0_5) AT=1790.05n

.meas tran vdout0_6ck1780 FIND v(dout0_6) AT=1790.05n

.meas tran vdout0_7ck1780 FIND v(dout0_7) AT=1790.05n

.meas tran vdout0_8ck1780 FIND v(dout0_8) AT=1790.05n

.meas tran vdout0_0ck1800 FIND v(dout0_0) AT=1810.05n

.meas tran vdout0_1ck1800 FIND v(dout0_1) AT=1810.05n

.meas tran vdout0_2ck1800 FIND v(dout0_2) AT=1810.05n

.meas tran vdout0_3ck1800 FIND v(dout0_3) AT=1810.05n

.meas tran vdout0_4ck1800 FIND v(dout0_4) AT=1810.05n

.meas tran vdout0_5ck1800 FIND v(dout0_5) AT=1810.05n

.meas tran vdout0_6ck1800 FIND v(dout0_6) AT=1810.05n

.meas tran vdout0_7ck1800 FIND v(dout0_7) AT=1810.05n

.meas tran vdout0_8ck1800 FIND v(dout0_8) AT=1810.05n

.meas tran vdout0_0ck1810 FIND v(dout0_0) AT=1820.05n

.meas tran vdout0_1ck1810 FIND v(dout0_1) AT=1820.05n

.meas tran vdout0_2ck1810 FIND v(dout0_2) AT=1820.05n

.meas tran vdout0_3ck1810 FIND v(dout0_3) AT=1820.05n

.meas tran vdout0_4ck1810 FIND v(dout0_4) AT=1820.05n

.meas tran vdout0_5ck1810 FIND v(dout0_5) AT=1820.05n

.meas tran vdout0_6ck1810 FIND v(dout0_6) AT=1820.05n

.meas tran vdout0_7ck1810 FIND v(dout0_7) AT=1820.05n

.meas tran vdout0_8ck1810 FIND v(dout0_8) AT=1820.05n

.meas tran vdout0_0ck1820 FIND v(dout0_0) AT=1830.05n

.meas tran vdout0_1ck1820 FIND v(dout0_1) AT=1830.05n

.meas tran vdout0_2ck1820 FIND v(dout0_2) AT=1830.05n

.meas tran vdout0_3ck1820 FIND v(dout0_3) AT=1830.05n

.meas tran vdout0_4ck1820 FIND v(dout0_4) AT=1830.05n

.meas tran vdout0_5ck1820 FIND v(dout0_5) AT=1830.05n

.meas tran vdout0_6ck1820 FIND v(dout0_6) AT=1830.05n

.meas tran vdout0_7ck1820 FIND v(dout0_7) AT=1830.05n

.meas tran vdout0_8ck1820 FIND v(dout0_8) AT=1830.05n

.meas tran vdout0_0ck1840 FIND v(dout0_0) AT=1850.05n

.meas tran vdout0_1ck1840 FIND v(dout0_1) AT=1850.05n

.meas tran vdout0_2ck1840 FIND v(dout0_2) AT=1850.05n

.meas tran vdout0_3ck1840 FIND v(dout0_3) AT=1850.05n

.meas tran vdout0_4ck1840 FIND v(dout0_4) AT=1850.05n

.meas tran vdout0_5ck1840 FIND v(dout0_5) AT=1850.05n

.meas tran vdout0_6ck1840 FIND v(dout0_6) AT=1850.05n

.meas tran vdout0_7ck1840 FIND v(dout0_7) AT=1850.05n

.meas tran vdout0_8ck1840 FIND v(dout0_8) AT=1850.05n

.meas tran vdout0_0ck1890 FIND v(dout0_0) AT=1900.05n

.meas tran vdout0_1ck1890 FIND v(dout0_1) AT=1900.05n

.meas tran vdout0_2ck1890 FIND v(dout0_2) AT=1900.05n

.meas tran vdout0_3ck1890 FIND v(dout0_3) AT=1900.05n

.meas tran vdout0_4ck1890 FIND v(dout0_4) AT=1900.05n

.meas tran vdout0_5ck1890 FIND v(dout0_5) AT=1900.05n

.meas tran vdout0_6ck1890 FIND v(dout0_6) AT=1900.05n

.meas tran vdout0_7ck1890 FIND v(dout0_7) AT=1900.05n

.meas tran vdout0_8ck1890 FIND v(dout0_8) AT=1900.05n

.meas tran vdout0_0ck1910 FIND v(dout0_0) AT=1920.05n

.meas tran vdout0_1ck1910 FIND v(dout0_1) AT=1920.05n

.meas tran vdout0_2ck1910 FIND v(dout0_2) AT=1920.05n

.meas tran vdout0_3ck1910 FIND v(dout0_3) AT=1920.05n

.meas tran vdout0_4ck1910 FIND v(dout0_4) AT=1920.05n

.meas tran vdout0_5ck1910 FIND v(dout0_5) AT=1920.05n

.meas tran vdout0_6ck1910 FIND v(dout0_6) AT=1920.05n

.meas tran vdout0_7ck1910 FIND v(dout0_7) AT=1920.05n

.meas tran vdout0_8ck1910 FIND v(dout0_8) AT=1920.05n

.meas tran vdout0_0ck1920 FIND v(dout0_0) AT=1930.05n

.meas tran vdout0_1ck1920 FIND v(dout0_1) AT=1930.05n

.meas tran vdout0_2ck1920 FIND v(dout0_2) AT=1930.05n

.meas tran vdout0_3ck1920 FIND v(dout0_3) AT=1930.05n

.meas tran vdout0_4ck1920 FIND v(dout0_4) AT=1930.05n

.meas tran vdout0_5ck1920 FIND v(dout0_5) AT=1930.05n

.meas tran vdout0_6ck1920 FIND v(dout0_6) AT=1930.05n

.meas tran vdout0_7ck1920 FIND v(dout0_7) AT=1930.05n

.meas tran vdout0_8ck1920 FIND v(dout0_8) AT=1930.05n

.meas tran vdout0_0ck1930 FIND v(dout0_0) AT=1940.05n

.meas tran vdout0_1ck1930 FIND v(dout0_1) AT=1940.05n

.meas tran vdout0_2ck1930 FIND v(dout0_2) AT=1940.05n

.meas tran vdout0_3ck1930 FIND v(dout0_3) AT=1940.05n

.meas tran vdout0_4ck1930 FIND v(dout0_4) AT=1940.05n

.meas tran vdout0_5ck1930 FIND v(dout0_5) AT=1940.05n

.meas tran vdout0_6ck1930 FIND v(dout0_6) AT=1940.05n

.meas tran vdout0_7ck1930 FIND v(dout0_7) AT=1940.05n

.meas tran vdout0_8ck1930 FIND v(dout0_8) AT=1940.05n

.meas tran vdout0_0ck1970 FIND v(dout0_0) AT=1980.05n

.meas tran vdout0_1ck1970 FIND v(dout0_1) AT=1980.05n

.meas tran vdout0_2ck1970 FIND v(dout0_2) AT=1980.05n

.meas tran vdout0_3ck1970 FIND v(dout0_3) AT=1980.05n

.meas tran vdout0_4ck1970 FIND v(dout0_4) AT=1980.05n

.meas tran vdout0_5ck1970 FIND v(dout0_5) AT=1980.05n

.meas tran vdout0_6ck1970 FIND v(dout0_6) AT=1980.05n

.meas tran vdout0_7ck1970 FIND v(dout0_7) AT=1980.05n

.meas tran vdout0_8ck1970 FIND v(dout0_8) AT=1980.05n

.meas tran vdout0_0ck2010 FIND v(dout0_0) AT=2020.05n

.meas tran vdout0_1ck2010 FIND v(dout0_1) AT=2020.05n

.meas tran vdout0_2ck2010 FIND v(dout0_2) AT=2020.05n

.meas tran vdout0_3ck2010 FIND v(dout0_3) AT=2020.05n

.meas tran vdout0_4ck2010 FIND v(dout0_4) AT=2020.05n

.meas tran vdout0_5ck2010 FIND v(dout0_5) AT=2020.05n

.meas tran vdout0_6ck2010 FIND v(dout0_6) AT=2020.05n

.meas tran vdout0_7ck2010 FIND v(dout0_7) AT=2020.05n

.meas tran vdout0_8ck2010 FIND v(dout0_8) AT=2020.05n

.meas tran vdout0_0ck2030 FIND v(dout0_0) AT=2040.05n

.meas tran vdout0_1ck2030 FIND v(dout0_1) AT=2040.05n

.meas tran vdout0_2ck2030 FIND v(dout0_2) AT=2040.05n

.meas tran vdout0_3ck2030 FIND v(dout0_3) AT=2040.05n

.meas tran vdout0_4ck2030 FIND v(dout0_4) AT=2040.05n

.meas tran vdout0_5ck2030 FIND v(dout0_5) AT=2040.05n

.meas tran vdout0_6ck2030 FIND v(dout0_6) AT=2040.05n

.meas tran vdout0_7ck2030 FIND v(dout0_7) AT=2040.05n

.meas tran vdout0_8ck2030 FIND v(dout0_8) AT=2040.05n

.meas tran vdout0_0ck2040 FIND v(dout0_0) AT=2050.05n

.meas tran vdout0_1ck2040 FIND v(dout0_1) AT=2050.05n

.meas tran vdout0_2ck2040 FIND v(dout0_2) AT=2050.05n

.meas tran vdout0_3ck2040 FIND v(dout0_3) AT=2050.05n

.meas tran vdout0_4ck2040 FIND v(dout0_4) AT=2050.05n

.meas tran vdout0_5ck2040 FIND v(dout0_5) AT=2050.05n

.meas tran vdout0_6ck2040 FIND v(dout0_6) AT=2050.05n

.meas tran vdout0_7ck2040 FIND v(dout0_7) AT=2050.05n

.meas tran vdout0_8ck2040 FIND v(dout0_8) AT=2050.05n
