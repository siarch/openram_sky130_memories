.meas tran vdout0_0ck40 FIND v(dout0_0) AT=50.05n

.meas tran vdout0_1ck40 FIND v(dout0_1) AT=50.05n

.meas tran vdout0_2ck40 FIND v(dout0_2) AT=50.05n

.meas tran vdout0_3ck40 FIND v(dout0_3) AT=50.05n

.meas tran vdout0_4ck40 FIND v(dout0_4) AT=50.05n

.meas tran vdout0_5ck40 FIND v(dout0_5) AT=50.05n

.meas tran vdout0_6ck40 FIND v(dout0_6) AT=50.05n

.meas tran vdout0_7ck40 FIND v(dout0_7) AT=50.05n

.meas tran vdout0_8ck40 FIND v(dout0_8) AT=50.05n

.meas tran vdout0_9ck40 FIND v(dout0_9) AT=50.05n

.meas tran vdout0_10ck40 FIND v(dout0_10) AT=50.05n

.meas tran vdout0_11ck40 FIND v(dout0_11) AT=50.05n

.meas tran vdout0_12ck40 FIND v(dout0_12) AT=50.05n

.meas tran vdout0_13ck40 FIND v(dout0_13) AT=50.05n

.meas tran vdout0_14ck40 FIND v(dout0_14) AT=50.05n

.meas tran vdout0_15ck40 FIND v(dout0_15) AT=50.05n

.meas tran vdout0_16ck40 FIND v(dout0_16) AT=50.05n

.meas tran vdout0_17ck40 FIND v(dout0_17) AT=50.05n

.meas tran vdout0_18ck40 FIND v(dout0_18) AT=50.05n

.meas tran vdout0_19ck40 FIND v(dout0_19) AT=50.05n

.meas tran vdout0_20ck40 FIND v(dout0_20) AT=50.05n

.meas tran vdout0_21ck40 FIND v(dout0_21) AT=50.05n

.meas tran vdout0_22ck40 FIND v(dout0_22) AT=50.05n

.meas tran vdout0_23ck40 FIND v(dout0_23) AT=50.05n

.meas tran vdout0_24ck40 FIND v(dout0_24) AT=50.05n

.meas tran vdout0_25ck40 FIND v(dout0_25) AT=50.05n

.meas tran vdout0_26ck40 FIND v(dout0_26) AT=50.05n

.meas tran vdout0_27ck40 FIND v(dout0_27) AT=50.05n

.meas tran vdout0_28ck40 FIND v(dout0_28) AT=50.05n

.meas tran vdout0_29ck40 FIND v(dout0_29) AT=50.05n

.meas tran vdout0_30ck40 FIND v(dout0_30) AT=50.05n

.meas tran vdout0_31ck40 FIND v(dout0_31) AT=50.05n

.meas tran vdout0_32ck40 FIND v(dout0_32) AT=50.05n

.meas tran vdout0_33ck40 FIND v(dout0_33) AT=50.05n

.meas tran vdout0_34ck40 FIND v(dout0_34) AT=50.05n

.meas tran vdout0_35ck40 FIND v(dout0_35) AT=50.05n

.meas tran vdout0_36ck40 FIND v(dout0_36) AT=50.05n

.meas tran vdout0_37ck40 FIND v(dout0_37) AT=50.05n

.meas tran vdout0_38ck40 FIND v(dout0_38) AT=50.05n

.meas tran vdout0_39ck40 FIND v(dout0_39) AT=50.05n

.meas tran vdout0_40ck40 FIND v(dout0_40) AT=50.05n

.meas tran vdout0_41ck40 FIND v(dout0_41) AT=50.05n

.meas tran vdout0_42ck40 FIND v(dout0_42) AT=50.05n

.meas tran vdout0_43ck40 FIND v(dout0_43) AT=50.05n

.meas tran vdout0_44ck40 FIND v(dout0_44) AT=50.05n

.meas tran vdout0_45ck40 FIND v(dout0_45) AT=50.05n

.meas tran vdout0_46ck40 FIND v(dout0_46) AT=50.05n

.meas tran vdout0_47ck40 FIND v(dout0_47) AT=50.05n

.meas tran vdout0_48ck40 FIND v(dout0_48) AT=50.05n

.meas tran vdout0_49ck40 FIND v(dout0_49) AT=50.05n

.meas tran vdout0_50ck40 FIND v(dout0_50) AT=50.05n

.meas tran vdout0_51ck40 FIND v(dout0_51) AT=50.05n

.meas tran vdout0_52ck40 FIND v(dout0_52) AT=50.05n

.meas tran vdout0_53ck40 FIND v(dout0_53) AT=50.05n

.meas tran vdout0_54ck40 FIND v(dout0_54) AT=50.05n

.meas tran vdout0_55ck40 FIND v(dout0_55) AT=50.05n

.meas tran vdout0_56ck40 FIND v(dout0_56) AT=50.05n

.meas tran vdout0_57ck40 FIND v(dout0_57) AT=50.05n

.meas tran vdout0_58ck40 FIND v(dout0_58) AT=50.05n

.meas tran vdout0_59ck40 FIND v(dout0_59) AT=50.05n

.meas tran vdout0_60ck40 FIND v(dout0_60) AT=50.05n

.meas tran vdout0_61ck40 FIND v(dout0_61) AT=50.05n

.meas tran vdout0_62ck40 FIND v(dout0_62) AT=50.05n

.meas tran vdout0_63ck40 FIND v(dout0_63) AT=50.05n

.meas tran vdout0_64ck40 FIND v(dout0_64) AT=50.05n

.meas tran vdout0_0ck50 FIND v(dout0_0) AT=60.05n

.meas tran vdout0_1ck50 FIND v(dout0_1) AT=60.05n

.meas tran vdout0_2ck50 FIND v(dout0_2) AT=60.05n

.meas tran vdout0_3ck50 FIND v(dout0_3) AT=60.05n

.meas tran vdout0_4ck50 FIND v(dout0_4) AT=60.05n

.meas tran vdout0_5ck50 FIND v(dout0_5) AT=60.05n

.meas tran vdout0_6ck50 FIND v(dout0_6) AT=60.05n

.meas tran vdout0_7ck50 FIND v(dout0_7) AT=60.05n

.meas tran vdout0_8ck50 FIND v(dout0_8) AT=60.05n

.meas tran vdout0_9ck50 FIND v(dout0_9) AT=60.05n

.meas tran vdout0_10ck50 FIND v(dout0_10) AT=60.05n

.meas tran vdout0_11ck50 FIND v(dout0_11) AT=60.05n

.meas tran vdout0_12ck50 FIND v(dout0_12) AT=60.05n

.meas tran vdout0_13ck50 FIND v(dout0_13) AT=60.05n

.meas tran vdout0_14ck50 FIND v(dout0_14) AT=60.05n

.meas tran vdout0_15ck50 FIND v(dout0_15) AT=60.05n

.meas tran vdout0_16ck50 FIND v(dout0_16) AT=60.05n

.meas tran vdout0_17ck50 FIND v(dout0_17) AT=60.05n

.meas tran vdout0_18ck50 FIND v(dout0_18) AT=60.05n

.meas tran vdout0_19ck50 FIND v(dout0_19) AT=60.05n

.meas tran vdout0_20ck50 FIND v(dout0_20) AT=60.05n

.meas tran vdout0_21ck50 FIND v(dout0_21) AT=60.05n

.meas tran vdout0_22ck50 FIND v(dout0_22) AT=60.05n

.meas tran vdout0_23ck50 FIND v(dout0_23) AT=60.05n

.meas tran vdout0_24ck50 FIND v(dout0_24) AT=60.05n

.meas tran vdout0_25ck50 FIND v(dout0_25) AT=60.05n

.meas tran vdout0_26ck50 FIND v(dout0_26) AT=60.05n

.meas tran vdout0_27ck50 FIND v(dout0_27) AT=60.05n

.meas tran vdout0_28ck50 FIND v(dout0_28) AT=60.05n

.meas tran vdout0_29ck50 FIND v(dout0_29) AT=60.05n

.meas tran vdout0_30ck50 FIND v(dout0_30) AT=60.05n

.meas tran vdout0_31ck50 FIND v(dout0_31) AT=60.05n

.meas tran vdout0_32ck50 FIND v(dout0_32) AT=60.05n

.meas tran vdout0_33ck50 FIND v(dout0_33) AT=60.05n

.meas tran vdout0_34ck50 FIND v(dout0_34) AT=60.05n

.meas tran vdout0_35ck50 FIND v(dout0_35) AT=60.05n

.meas tran vdout0_36ck50 FIND v(dout0_36) AT=60.05n

.meas tran vdout0_37ck50 FIND v(dout0_37) AT=60.05n

.meas tran vdout0_38ck50 FIND v(dout0_38) AT=60.05n

.meas tran vdout0_39ck50 FIND v(dout0_39) AT=60.05n

.meas tran vdout0_40ck50 FIND v(dout0_40) AT=60.05n

.meas tran vdout0_41ck50 FIND v(dout0_41) AT=60.05n

.meas tran vdout0_42ck50 FIND v(dout0_42) AT=60.05n

.meas tran vdout0_43ck50 FIND v(dout0_43) AT=60.05n

.meas tran vdout0_44ck50 FIND v(dout0_44) AT=60.05n

.meas tran vdout0_45ck50 FIND v(dout0_45) AT=60.05n

.meas tran vdout0_46ck50 FIND v(dout0_46) AT=60.05n

.meas tran vdout0_47ck50 FIND v(dout0_47) AT=60.05n

.meas tran vdout0_48ck50 FIND v(dout0_48) AT=60.05n

.meas tran vdout0_49ck50 FIND v(dout0_49) AT=60.05n

.meas tran vdout0_50ck50 FIND v(dout0_50) AT=60.05n

.meas tran vdout0_51ck50 FIND v(dout0_51) AT=60.05n

.meas tran vdout0_52ck50 FIND v(dout0_52) AT=60.05n

.meas tran vdout0_53ck50 FIND v(dout0_53) AT=60.05n

.meas tran vdout0_54ck50 FIND v(dout0_54) AT=60.05n

.meas tran vdout0_55ck50 FIND v(dout0_55) AT=60.05n

.meas tran vdout0_56ck50 FIND v(dout0_56) AT=60.05n

.meas tran vdout0_57ck50 FIND v(dout0_57) AT=60.05n

.meas tran vdout0_58ck50 FIND v(dout0_58) AT=60.05n

.meas tran vdout0_59ck50 FIND v(dout0_59) AT=60.05n

.meas tran vdout0_60ck50 FIND v(dout0_60) AT=60.05n

.meas tran vdout0_61ck50 FIND v(dout0_61) AT=60.05n

.meas tran vdout0_62ck50 FIND v(dout0_62) AT=60.05n

.meas tran vdout0_63ck50 FIND v(dout0_63) AT=60.05n

.meas tran vdout0_64ck50 FIND v(dout0_64) AT=60.05n

.meas tran vdout0_0ck60 FIND v(dout0_0) AT=70.05n

.meas tran vdout0_1ck60 FIND v(dout0_1) AT=70.05n

.meas tran vdout0_2ck60 FIND v(dout0_2) AT=70.05n

.meas tran vdout0_3ck60 FIND v(dout0_3) AT=70.05n

.meas tran vdout0_4ck60 FIND v(dout0_4) AT=70.05n

.meas tran vdout0_5ck60 FIND v(dout0_5) AT=70.05n

.meas tran vdout0_6ck60 FIND v(dout0_6) AT=70.05n

.meas tran vdout0_7ck60 FIND v(dout0_7) AT=70.05n

.meas tran vdout0_8ck60 FIND v(dout0_8) AT=70.05n

.meas tran vdout0_9ck60 FIND v(dout0_9) AT=70.05n

.meas tran vdout0_10ck60 FIND v(dout0_10) AT=70.05n

.meas tran vdout0_11ck60 FIND v(dout0_11) AT=70.05n

.meas tran vdout0_12ck60 FIND v(dout0_12) AT=70.05n

.meas tran vdout0_13ck60 FIND v(dout0_13) AT=70.05n

.meas tran vdout0_14ck60 FIND v(dout0_14) AT=70.05n

.meas tran vdout0_15ck60 FIND v(dout0_15) AT=70.05n

.meas tran vdout0_16ck60 FIND v(dout0_16) AT=70.05n

.meas tran vdout0_17ck60 FIND v(dout0_17) AT=70.05n

.meas tran vdout0_18ck60 FIND v(dout0_18) AT=70.05n

.meas tran vdout0_19ck60 FIND v(dout0_19) AT=70.05n

.meas tran vdout0_20ck60 FIND v(dout0_20) AT=70.05n

.meas tran vdout0_21ck60 FIND v(dout0_21) AT=70.05n

.meas tran vdout0_22ck60 FIND v(dout0_22) AT=70.05n

.meas tran vdout0_23ck60 FIND v(dout0_23) AT=70.05n

.meas tran vdout0_24ck60 FIND v(dout0_24) AT=70.05n

.meas tran vdout0_25ck60 FIND v(dout0_25) AT=70.05n

.meas tran vdout0_26ck60 FIND v(dout0_26) AT=70.05n

.meas tran vdout0_27ck60 FIND v(dout0_27) AT=70.05n

.meas tran vdout0_28ck60 FIND v(dout0_28) AT=70.05n

.meas tran vdout0_29ck60 FIND v(dout0_29) AT=70.05n

.meas tran vdout0_30ck60 FIND v(dout0_30) AT=70.05n

.meas tran vdout0_31ck60 FIND v(dout0_31) AT=70.05n

.meas tran vdout0_32ck60 FIND v(dout0_32) AT=70.05n

.meas tran vdout0_33ck60 FIND v(dout0_33) AT=70.05n

.meas tran vdout0_34ck60 FIND v(dout0_34) AT=70.05n

.meas tran vdout0_35ck60 FIND v(dout0_35) AT=70.05n

.meas tran vdout0_36ck60 FIND v(dout0_36) AT=70.05n

.meas tran vdout0_37ck60 FIND v(dout0_37) AT=70.05n

.meas tran vdout0_38ck60 FIND v(dout0_38) AT=70.05n

.meas tran vdout0_39ck60 FIND v(dout0_39) AT=70.05n

.meas tran vdout0_40ck60 FIND v(dout0_40) AT=70.05n

.meas tran vdout0_41ck60 FIND v(dout0_41) AT=70.05n

.meas tran vdout0_42ck60 FIND v(dout0_42) AT=70.05n

.meas tran vdout0_43ck60 FIND v(dout0_43) AT=70.05n

.meas tran vdout0_44ck60 FIND v(dout0_44) AT=70.05n

.meas tran vdout0_45ck60 FIND v(dout0_45) AT=70.05n

.meas tran vdout0_46ck60 FIND v(dout0_46) AT=70.05n

.meas tran vdout0_47ck60 FIND v(dout0_47) AT=70.05n

.meas tran vdout0_48ck60 FIND v(dout0_48) AT=70.05n

.meas tran vdout0_49ck60 FIND v(dout0_49) AT=70.05n

.meas tran vdout0_50ck60 FIND v(dout0_50) AT=70.05n

.meas tran vdout0_51ck60 FIND v(dout0_51) AT=70.05n

.meas tran vdout0_52ck60 FIND v(dout0_52) AT=70.05n

.meas tran vdout0_53ck60 FIND v(dout0_53) AT=70.05n

.meas tran vdout0_54ck60 FIND v(dout0_54) AT=70.05n

.meas tran vdout0_55ck60 FIND v(dout0_55) AT=70.05n

.meas tran vdout0_56ck60 FIND v(dout0_56) AT=70.05n

.meas tran vdout0_57ck60 FIND v(dout0_57) AT=70.05n

.meas tran vdout0_58ck60 FIND v(dout0_58) AT=70.05n

.meas tran vdout0_59ck60 FIND v(dout0_59) AT=70.05n

.meas tran vdout0_60ck60 FIND v(dout0_60) AT=70.05n

.meas tran vdout0_61ck60 FIND v(dout0_61) AT=70.05n

.meas tran vdout0_62ck60 FIND v(dout0_62) AT=70.05n

.meas tran vdout0_63ck60 FIND v(dout0_63) AT=70.05n

.meas tran vdout0_64ck60 FIND v(dout0_64) AT=70.05n

.meas tran vdout0_0ck70 FIND v(dout0_0) AT=80.05n

.meas tran vdout0_1ck70 FIND v(dout0_1) AT=80.05n

.meas tran vdout0_2ck70 FIND v(dout0_2) AT=80.05n

.meas tran vdout0_3ck70 FIND v(dout0_3) AT=80.05n

.meas tran vdout0_4ck70 FIND v(dout0_4) AT=80.05n

.meas tran vdout0_5ck70 FIND v(dout0_5) AT=80.05n

.meas tran vdout0_6ck70 FIND v(dout0_6) AT=80.05n

.meas tran vdout0_7ck70 FIND v(dout0_7) AT=80.05n

.meas tran vdout0_8ck70 FIND v(dout0_8) AT=80.05n

.meas tran vdout0_9ck70 FIND v(dout0_9) AT=80.05n

.meas tran vdout0_10ck70 FIND v(dout0_10) AT=80.05n

.meas tran vdout0_11ck70 FIND v(dout0_11) AT=80.05n

.meas tran vdout0_12ck70 FIND v(dout0_12) AT=80.05n

.meas tran vdout0_13ck70 FIND v(dout0_13) AT=80.05n

.meas tran vdout0_14ck70 FIND v(dout0_14) AT=80.05n

.meas tran vdout0_15ck70 FIND v(dout0_15) AT=80.05n

.meas tran vdout0_16ck70 FIND v(dout0_16) AT=80.05n

.meas tran vdout0_17ck70 FIND v(dout0_17) AT=80.05n

.meas tran vdout0_18ck70 FIND v(dout0_18) AT=80.05n

.meas tran vdout0_19ck70 FIND v(dout0_19) AT=80.05n

.meas tran vdout0_20ck70 FIND v(dout0_20) AT=80.05n

.meas tran vdout0_21ck70 FIND v(dout0_21) AT=80.05n

.meas tran vdout0_22ck70 FIND v(dout0_22) AT=80.05n

.meas tran vdout0_23ck70 FIND v(dout0_23) AT=80.05n

.meas tran vdout0_24ck70 FIND v(dout0_24) AT=80.05n

.meas tran vdout0_25ck70 FIND v(dout0_25) AT=80.05n

.meas tran vdout0_26ck70 FIND v(dout0_26) AT=80.05n

.meas tran vdout0_27ck70 FIND v(dout0_27) AT=80.05n

.meas tran vdout0_28ck70 FIND v(dout0_28) AT=80.05n

.meas tran vdout0_29ck70 FIND v(dout0_29) AT=80.05n

.meas tran vdout0_30ck70 FIND v(dout0_30) AT=80.05n

.meas tran vdout0_31ck70 FIND v(dout0_31) AT=80.05n

.meas tran vdout0_32ck70 FIND v(dout0_32) AT=80.05n

.meas tran vdout0_33ck70 FIND v(dout0_33) AT=80.05n

.meas tran vdout0_34ck70 FIND v(dout0_34) AT=80.05n

.meas tran vdout0_35ck70 FIND v(dout0_35) AT=80.05n

.meas tran vdout0_36ck70 FIND v(dout0_36) AT=80.05n

.meas tran vdout0_37ck70 FIND v(dout0_37) AT=80.05n

.meas tran vdout0_38ck70 FIND v(dout0_38) AT=80.05n

.meas tran vdout0_39ck70 FIND v(dout0_39) AT=80.05n

.meas tran vdout0_40ck70 FIND v(dout0_40) AT=80.05n

.meas tran vdout0_41ck70 FIND v(dout0_41) AT=80.05n

.meas tran vdout0_42ck70 FIND v(dout0_42) AT=80.05n

.meas tran vdout0_43ck70 FIND v(dout0_43) AT=80.05n

.meas tran vdout0_44ck70 FIND v(dout0_44) AT=80.05n

.meas tran vdout0_45ck70 FIND v(dout0_45) AT=80.05n

.meas tran vdout0_46ck70 FIND v(dout0_46) AT=80.05n

.meas tran vdout0_47ck70 FIND v(dout0_47) AT=80.05n

.meas tran vdout0_48ck70 FIND v(dout0_48) AT=80.05n

.meas tran vdout0_49ck70 FIND v(dout0_49) AT=80.05n

.meas tran vdout0_50ck70 FIND v(dout0_50) AT=80.05n

.meas tran vdout0_51ck70 FIND v(dout0_51) AT=80.05n

.meas tran vdout0_52ck70 FIND v(dout0_52) AT=80.05n

.meas tran vdout0_53ck70 FIND v(dout0_53) AT=80.05n

.meas tran vdout0_54ck70 FIND v(dout0_54) AT=80.05n

.meas tran vdout0_55ck70 FIND v(dout0_55) AT=80.05n

.meas tran vdout0_56ck70 FIND v(dout0_56) AT=80.05n

.meas tran vdout0_57ck70 FIND v(dout0_57) AT=80.05n

.meas tran vdout0_58ck70 FIND v(dout0_58) AT=80.05n

.meas tran vdout0_59ck70 FIND v(dout0_59) AT=80.05n

.meas tran vdout0_60ck70 FIND v(dout0_60) AT=80.05n

.meas tran vdout0_61ck70 FIND v(dout0_61) AT=80.05n

.meas tran vdout0_62ck70 FIND v(dout0_62) AT=80.05n

.meas tran vdout0_63ck70 FIND v(dout0_63) AT=80.05n

.meas tran vdout0_64ck70 FIND v(dout0_64) AT=80.05n

.meas tran vdout0_0ck80 FIND v(dout0_0) AT=90.05n

.meas tran vdout0_1ck80 FIND v(dout0_1) AT=90.05n

.meas tran vdout0_2ck80 FIND v(dout0_2) AT=90.05n

.meas tran vdout0_3ck80 FIND v(dout0_3) AT=90.05n

.meas tran vdout0_4ck80 FIND v(dout0_4) AT=90.05n

.meas tran vdout0_5ck80 FIND v(dout0_5) AT=90.05n

.meas tran vdout0_6ck80 FIND v(dout0_6) AT=90.05n

.meas tran vdout0_7ck80 FIND v(dout0_7) AT=90.05n

.meas tran vdout0_8ck80 FIND v(dout0_8) AT=90.05n

.meas tran vdout0_9ck80 FIND v(dout0_9) AT=90.05n

.meas tran vdout0_10ck80 FIND v(dout0_10) AT=90.05n

.meas tran vdout0_11ck80 FIND v(dout0_11) AT=90.05n

.meas tran vdout0_12ck80 FIND v(dout0_12) AT=90.05n

.meas tran vdout0_13ck80 FIND v(dout0_13) AT=90.05n

.meas tran vdout0_14ck80 FIND v(dout0_14) AT=90.05n

.meas tran vdout0_15ck80 FIND v(dout0_15) AT=90.05n

.meas tran vdout0_16ck80 FIND v(dout0_16) AT=90.05n

.meas tran vdout0_17ck80 FIND v(dout0_17) AT=90.05n

.meas tran vdout0_18ck80 FIND v(dout0_18) AT=90.05n

.meas tran vdout0_19ck80 FIND v(dout0_19) AT=90.05n

.meas tran vdout0_20ck80 FIND v(dout0_20) AT=90.05n

.meas tran vdout0_21ck80 FIND v(dout0_21) AT=90.05n

.meas tran vdout0_22ck80 FIND v(dout0_22) AT=90.05n

.meas tran vdout0_23ck80 FIND v(dout0_23) AT=90.05n

.meas tran vdout0_24ck80 FIND v(dout0_24) AT=90.05n

.meas tran vdout0_25ck80 FIND v(dout0_25) AT=90.05n

.meas tran vdout0_26ck80 FIND v(dout0_26) AT=90.05n

.meas tran vdout0_27ck80 FIND v(dout0_27) AT=90.05n

.meas tran vdout0_28ck80 FIND v(dout0_28) AT=90.05n

.meas tran vdout0_29ck80 FIND v(dout0_29) AT=90.05n

.meas tran vdout0_30ck80 FIND v(dout0_30) AT=90.05n

.meas tran vdout0_31ck80 FIND v(dout0_31) AT=90.05n

.meas tran vdout0_32ck80 FIND v(dout0_32) AT=90.05n

.meas tran vdout0_33ck80 FIND v(dout0_33) AT=90.05n

.meas tran vdout0_34ck80 FIND v(dout0_34) AT=90.05n

.meas tran vdout0_35ck80 FIND v(dout0_35) AT=90.05n

.meas tran vdout0_36ck80 FIND v(dout0_36) AT=90.05n

.meas tran vdout0_37ck80 FIND v(dout0_37) AT=90.05n

.meas tran vdout0_38ck80 FIND v(dout0_38) AT=90.05n

.meas tran vdout0_39ck80 FIND v(dout0_39) AT=90.05n

.meas tran vdout0_40ck80 FIND v(dout0_40) AT=90.05n

.meas tran vdout0_41ck80 FIND v(dout0_41) AT=90.05n

.meas tran vdout0_42ck80 FIND v(dout0_42) AT=90.05n

.meas tran vdout0_43ck80 FIND v(dout0_43) AT=90.05n

.meas tran vdout0_44ck80 FIND v(dout0_44) AT=90.05n

.meas tran vdout0_45ck80 FIND v(dout0_45) AT=90.05n

.meas tran vdout0_46ck80 FIND v(dout0_46) AT=90.05n

.meas tran vdout0_47ck80 FIND v(dout0_47) AT=90.05n

.meas tran vdout0_48ck80 FIND v(dout0_48) AT=90.05n

.meas tran vdout0_49ck80 FIND v(dout0_49) AT=90.05n

.meas tran vdout0_50ck80 FIND v(dout0_50) AT=90.05n

.meas tran vdout0_51ck80 FIND v(dout0_51) AT=90.05n

.meas tran vdout0_52ck80 FIND v(dout0_52) AT=90.05n

.meas tran vdout0_53ck80 FIND v(dout0_53) AT=90.05n

.meas tran vdout0_54ck80 FIND v(dout0_54) AT=90.05n

.meas tran vdout0_55ck80 FIND v(dout0_55) AT=90.05n

.meas tran vdout0_56ck80 FIND v(dout0_56) AT=90.05n

.meas tran vdout0_57ck80 FIND v(dout0_57) AT=90.05n

.meas tran vdout0_58ck80 FIND v(dout0_58) AT=90.05n

.meas tran vdout0_59ck80 FIND v(dout0_59) AT=90.05n

.meas tran vdout0_60ck80 FIND v(dout0_60) AT=90.05n

.meas tran vdout0_61ck80 FIND v(dout0_61) AT=90.05n

.meas tran vdout0_62ck80 FIND v(dout0_62) AT=90.05n

.meas tran vdout0_63ck80 FIND v(dout0_63) AT=90.05n

.meas tran vdout0_64ck80 FIND v(dout0_64) AT=90.05n

.meas tran vdout0_0ck100 FIND v(dout0_0) AT=110.05n

.meas tran vdout0_1ck100 FIND v(dout0_1) AT=110.05n

.meas tran vdout0_2ck100 FIND v(dout0_2) AT=110.05n

.meas tran vdout0_3ck100 FIND v(dout0_3) AT=110.05n

.meas tran vdout0_4ck100 FIND v(dout0_4) AT=110.05n

.meas tran vdout0_5ck100 FIND v(dout0_5) AT=110.05n

.meas tran vdout0_6ck100 FIND v(dout0_6) AT=110.05n

.meas tran vdout0_7ck100 FIND v(dout0_7) AT=110.05n

.meas tran vdout0_8ck100 FIND v(dout0_8) AT=110.05n

.meas tran vdout0_9ck100 FIND v(dout0_9) AT=110.05n

.meas tran vdout0_10ck100 FIND v(dout0_10) AT=110.05n

.meas tran vdout0_11ck100 FIND v(dout0_11) AT=110.05n

.meas tran vdout0_12ck100 FIND v(dout0_12) AT=110.05n

.meas tran vdout0_13ck100 FIND v(dout0_13) AT=110.05n

.meas tran vdout0_14ck100 FIND v(dout0_14) AT=110.05n

.meas tran vdout0_15ck100 FIND v(dout0_15) AT=110.05n

.meas tran vdout0_16ck100 FIND v(dout0_16) AT=110.05n

.meas tran vdout0_17ck100 FIND v(dout0_17) AT=110.05n

.meas tran vdout0_18ck100 FIND v(dout0_18) AT=110.05n

.meas tran vdout0_19ck100 FIND v(dout0_19) AT=110.05n

.meas tran vdout0_20ck100 FIND v(dout0_20) AT=110.05n

.meas tran vdout0_21ck100 FIND v(dout0_21) AT=110.05n

.meas tran vdout0_22ck100 FIND v(dout0_22) AT=110.05n

.meas tran vdout0_23ck100 FIND v(dout0_23) AT=110.05n

.meas tran vdout0_24ck100 FIND v(dout0_24) AT=110.05n

.meas tran vdout0_25ck100 FIND v(dout0_25) AT=110.05n

.meas tran vdout0_26ck100 FIND v(dout0_26) AT=110.05n

.meas tran vdout0_27ck100 FIND v(dout0_27) AT=110.05n

.meas tran vdout0_28ck100 FIND v(dout0_28) AT=110.05n

.meas tran vdout0_29ck100 FIND v(dout0_29) AT=110.05n

.meas tran vdout0_30ck100 FIND v(dout0_30) AT=110.05n

.meas tran vdout0_31ck100 FIND v(dout0_31) AT=110.05n

.meas tran vdout0_32ck100 FIND v(dout0_32) AT=110.05n

.meas tran vdout0_33ck100 FIND v(dout0_33) AT=110.05n

.meas tran vdout0_34ck100 FIND v(dout0_34) AT=110.05n

.meas tran vdout0_35ck100 FIND v(dout0_35) AT=110.05n

.meas tran vdout0_36ck100 FIND v(dout0_36) AT=110.05n

.meas tran vdout0_37ck100 FIND v(dout0_37) AT=110.05n

.meas tran vdout0_38ck100 FIND v(dout0_38) AT=110.05n

.meas tran vdout0_39ck100 FIND v(dout0_39) AT=110.05n

.meas tran vdout0_40ck100 FIND v(dout0_40) AT=110.05n

.meas tran vdout0_41ck100 FIND v(dout0_41) AT=110.05n

.meas tran vdout0_42ck100 FIND v(dout0_42) AT=110.05n

.meas tran vdout0_43ck100 FIND v(dout0_43) AT=110.05n

.meas tran vdout0_44ck100 FIND v(dout0_44) AT=110.05n

.meas tran vdout0_45ck100 FIND v(dout0_45) AT=110.05n

.meas tran vdout0_46ck100 FIND v(dout0_46) AT=110.05n

.meas tran vdout0_47ck100 FIND v(dout0_47) AT=110.05n

.meas tran vdout0_48ck100 FIND v(dout0_48) AT=110.05n

.meas tran vdout0_49ck100 FIND v(dout0_49) AT=110.05n

.meas tran vdout0_50ck100 FIND v(dout0_50) AT=110.05n

.meas tran vdout0_51ck100 FIND v(dout0_51) AT=110.05n

.meas tran vdout0_52ck100 FIND v(dout0_52) AT=110.05n

.meas tran vdout0_53ck100 FIND v(dout0_53) AT=110.05n

.meas tran vdout0_54ck100 FIND v(dout0_54) AT=110.05n

.meas tran vdout0_55ck100 FIND v(dout0_55) AT=110.05n

.meas tran vdout0_56ck100 FIND v(dout0_56) AT=110.05n

.meas tran vdout0_57ck100 FIND v(dout0_57) AT=110.05n

.meas tran vdout0_58ck100 FIND v(dout0_58) AT=110.05n

.meas tran vdout0_59ck100 FIND v(dout0_59) AT=110.05n

.meas tran vdout0_60ck100 FIND v(dout0_60) AT=110.05n

.meas tran vdout0_61ck100 FIND v(dout0_61) AT=110.05n

.meas tran vdout0_62ck100 FIND v(dout0_62) AT=110.05n

.meas tran vdout0_63ck100 FIND v(dout0_63) AT=110.05n

.meas tran vdout0_64ck100 FIND v(dout0_64) AT=110.05n

.meas tran vdout0_0ck120 FIND v(dout0_0) AT=130.05n

.meas tran vdout0_1ck120 FIND v(dout0_1) AT=130.05n

.meas tran vdout0_2ck120 FIND v(dout0_2) AT=130.05n

.meas tran vdout0_3ck120 FIND v(dout0_3) AT=130.05n

.meas tran vdout0_4ck120 FIND v(dout0_4) AT=130.05n

.meas tran vdout0_5ck120 FIND v(dout0_5) AT=130.05n

.meas tran vdout0_6ck120 FIND v(dout0_6) AT=130.05n

.meas tran vdout0_7ck120 FIND v(dout0_7) AT=130.05n

.meas tran vdout0_8ck120 FIND v(dout0_8) AT=130.05n

.meas tran vdout0_9ck120 FIND v(dout0_9) AT=130.05n

.meas tran vdout0_10ck120 FIND v(dout0_10) AT=130.05n

.meas tran vdout0_11ck120 FIND v(dout0_11) AT=130.05n

.meas tran vdout0_12ck120 FIND v(dout0_12) AT=130.05n

.meas tran vdout0_13ck120 FIND v(dout0_13) AT=130.05n

.meas tran vdout0_14ck120 FIND v(dout0_14) AT=130.05n

.meas tran vdout0_15ck120 FIND v(dout0_15) AT=130.05n

.meas tran vdout0_16ck120 FIND v(dout0_16) AT=130.05n

.meas tran vdout0_17ck120 FIND v(dout0_17) AT=130.05n

.meas tran vdout0_18ck120 FIND v(dout0_18) AT=130.05n

.meas tran vdout0_19ck120 FIND v(dout0_19) AT=130.05n

.meas tran vdout0_20ck120 FIND v(dout0_20) AT=130.05n

.meas tran vdout0_21ck120 FIND v(dout0_21) AT=130.05n

.meas tran vdout0_22ck120 FIND v(dout0_22) AT=130.05n

.meas tran vdout0_23ck120 FIND v(dout0_23) AT=130.05n

.meas tran vdout0_24ck120 FIND v(dout0_24) AT=130.05n

.meas tran vdout0_25ck120 FIND v(dout0_25) AT=130.05n

.meas tran vdout0_26ck120 FIND v(dout0_26) AT=130.05n

.meas tran vdout0_27ck120 FIND v(dout0_27) AT=130.05n

.meas tran vdout0_28ck120 FIND v(dout0_28) AT=130.05n

.meas tran vdout0_29ck120 FIND v(dout0_29) AT=130.05n

.meas tran vdout0_30ck120 FIND v(dout0_30) AT=130.05n

.meas tran vdout0_31ck120 FIND v(dout0_31) AT=130.05n

.meas tran vdout0_32ck120 FIND v(dout0_32) AT=130.05n

.meas tran vdout0_33ck120 FIND v(dout0_33) AT=130.05n

.meas tran vdout0_34ck120 FIND v(dout0_34) AT=130.05n

.meas tran vdout0_35ck120 FIND v(dout0_35) AT=130.05n

.meas tran vdout0_36ck120 FIND v(dout0_36) AT=130.05n

.meas tran vdout0_37ck120 FIND v(dout0_37) AT=130.05n

.meas tran vdout0_38ck120 FIND v(dout0_38) AT=130.05n

.meas tran vdout0_39ck120 FIND v(dout0_39) AT=130.05n

.meas tran vdout0_40ck120 FIND v(dout0_40) AT=130.05n

.meas tran vdout0_41ck120 FIND v(dout0_41) AT=130.05n

.meas tran vdout0_42ck120 FIND v(dout0_42) AT=130.05n

.meas tran vdout0_43ck120 FIND v(dout0_43) AT=130.05n

.meas tran vdout0_44ck120 FIND v(dout0_44) AT=130.05n

.meas tran vdout0_45ck120 FIND v(dout0_45) AT=130.05n

.meas tran vdout0_46ck120 FIND v(dout0_46) AT=130.05n

.meas tran vdout0_47ck120 FIND v(dout0_47) AT=130.05n

.meas tran vdout0_48ck120 FIND v(dout0_48) AT=130.05n

.meas tran vdout0_49ck120 FIND v(dout0_49) AT=130.05n

.meas tran vdout0_50ck120 FIND v(dout0_50) AT=130.05n

.meas tran vdout0_51ck120 FIND v(dout0_51) AT=130.05n

.meas tran vdout0_52ck120 FIND v(dout0_52) AT=130.05n

.meas tran vdout0_53ck120 FIND v(dout0_53) AT=130.05n

.meas tran vdout0_54ck120 FIND v(dout0_54) AT=130.05n

.meas tran vdout0_55ck120 FIND v(dout0_55) AT=130.05n

.meas tran vdout0_56ck120 FIND v(dout0_56) AT=130.05n

.meas tran vdout0_57ck120 FIND v(dout0_57) AT=130.05n

.meas tran vdout0_58ck120 FIND v(dout0_58) AT=130.05n

.meas tran vdout0_59ck120 FIND v(dout0_59) AT=130.05n

.meas tran vdout0_60ck120 FIND v(dout0_60) AT=130.05n

.meas tran vdout0_61ck120 FIND v(dout0_61) AT=130.05n

.meas tran vdout0_62ck120 FIND v(dout0_62) AT=130.05n

.meas tran vdout0_63ck120 FIND v(dout0_63) AT=130.05n

.meas tran vdout0_64ck120 FIND v(dout0_64) AT=130.05n

.meas tran vdout0_0ck160 FIND v(dout0_0) AT=170.05n

.meas tran vdout0_1ck160 FIND v(dout0_1) AT=170.05n

.meas tran vdout0_2ck160 FIND v(dout0_2) AT=170.05n

.meas tran vdout0_3ck160 FIND v(dout0_3) AT=170.05n

.meas tran vdout0_4ck160 FIND v(dout0_4) AT=170.05n

.meas tran vdout0_5ck160 FIND v(dout0_5) AT=170.05n

.meas tran vdout0_6ck160 FIND v(dout0_6) AT=170.05n

.meas tran vdout0_7ck160 FIND v(dout0_7) AT=170.05n

.meas tran vdout0_8ck160 FIND v(dout0_8) AT=170.05n

.meas tran vdout0_9ck160 FIND v(dout0_9) AT=170.05n

.meas tran vdout0_10ck160 FIND v(dout0_10) AT=170.05n

.meas tran vdout0_11ck160 FIND v(dout0_11) AT=170.05n

.meas tran vdout0_12ck160 FIND v(dout0_12) AT=170.05n

.meas tran vdout0_13ck160 FIND v(dout0_13) AT=170.05n

.meas tran vdout0_14ck160 FIND v(dout0_14) AT=170.05n

.meas tran vdout0_15ck160 FIND v(dout0_15) AT=170.05n

.meas tran vdout0_16ck160 FIND v(dout0_16) AT=170.05n

.meas tran vdout0_17ck160 FIND v(dout0_17) AT=170.05n

.meas tran vdout0_18ck160 FIND v(dout0_18) AT=170.05n

.meas tran vdout0_19ck160 FIND v(dout0_19) AT=170.05n

.meas tran vdout0_20ck160 FIND v(dout0_20) AT=170.05n

.meas tran vdout0_21ck160 FIND v(dout0_21) AT=170.05n

.meas tran vdout0_22ck160 FIND v(dout0_22) AT=170.05n

.meas tran vdout0_23ck160 FIND v(dout0_23) AT=170.05n

.meas tran vdout0_24ck160 FIND v(dout0_24) AT=170.05n

.meas tran vdout0_25ck160 FIND v(dout0_25) AT=170.05n

.meas tran vdout0_26ck160 FIND v(dout0_26) AT=170.05n

.meas tran vdout0_27ck160 FIND v(dout0_27) AT=170.05n

.meas tran vdout0_28ck160 FIND v(dout0_28) AT=170.05n

.meas tran vdout0_29ck160 FIND v(dout0_29) AT=170.05n

.meas tran vdout0_30ck160 FIND v(dout0_30) AT=170.05n

.meas tran vdout0_31ck160 FIND v(dout0_31) AT=170.05n

.meas tran vdout0_32ck160 FIND v(dout0_32) AT=170.05n

.meas tran vdout0_33ck160 FIND v(dout0_33) AT=170.05n

.meas tran vdout0_34ck160 FIND v(dout0_34) AT=170.05n

.meas tran vdout0_35ck160 FIND v(dout0_35) AT=170.05n

.meas tran vdout0_36ck160 FIND v(dout0_36) AT=170.05n

.meas tran vdout0_37ck160 FIND v(dout0_37) AT=170.05n

.meas tran vdout0_38ck160 FIND v(dout0_38) AT=170.05n

.meas tran vdout0_39ck160 FIND v(dout0_39) AT=170.05n

.meas tran vdout0_40ck160 FIND v(dout0_40) AT=170.05n

.meas tran vdout0_41ck160 FIND v(dout0_41) AT=170.05n

.meas tran vdout0_42ck160 FIND v(dout0_42) AT=170.05n

.meas tran vdout0_43ck160 FIND v(dout0_43) AT=170.05n

.meas tran vdout0_44ck160 FIND v(dout0_44) AT=170.05n

.meas tran vdout0_45ck160 FIND v(dout0_45) AT=170.05n

.meas tran vdout0_46ck160 FIND v(dout0_46) AT=170.05n

.meas tran vdout0_47ck160 FIND v(dout0_47) AT=170.05n

.meas tran vdout0_48ck160 FIND v(dout0_48) AT=170.05n

.meas tran vdout0_49ck160 FIND v(dout0_49) AT=170.05n

.meas tran vdout0_50ck160 FIND v(dout0_50) AT=170.05n

.meas tran vdout0_51ck160 FIND v(dout0_51) AT=170.05n

.meas tran vdout0_52ck160 FIND v(dout0_52) AT=170.05n

.meas tran vdout0_53ck160 FIND v(dout0_53) AT=170.05n

.meas tran vdout0_54ck160 FIND v(dout0_54) AT=170.05n

.meas tran vdout0_55ck160 FIND v(dout0_55) AT=170.05n

.meas tran vdout0_56ck160 FIND v(dout0_56) AT=170.05n

.meas tran vdout0_57ck160 FIND v(dout0_57) AT=170.05n

.meas tran vdout0_58ck160 FIND v(dout0_58) AT=170.05n

.meas tran vdout0_59ck160 FIND v(dout0_59) AT=170.05n

.meas tran vdout0_60ck160 FIND v(dout0_60) AT=170.05n

.meas tran vdout0_61ck160 FIND v(dout0_61) AT=170.05n

.meas tran vdout0_62ck160 FIND v(dout0_62) AT=170.05n

.meas tran vdout0_63ck160 FIND v(dout0_63) AT=170.05n

.meas tran vdout0_64ck160 FIND v(dout0_64) AT=170.05n

.meas tran vdout0_0ck200 FIND v(dout0_0) AT=210.05n

.meas tran vdout0_1ck200 FIND v(dout0_1) AT=210.05n

.meas tran vdout0_2ck200 FIND v(dout0_2) AT=210.05n

.meas tran vdout0_3ck200 FIND v(dout0_3) AT=210.05n

.meas tran vdout0_4ck200 FIND v(dout0_4) AT=210.05n

.meas tran vdout0_5ck200 FIND v(dout0_5) AT=210.05n

.meas tran vdout0_6ck200 FIND v(dout0_6) AT=210.05n

.meas tran vdout0_7ck200 FIND v(dout0_7) AT=210.05n

.meas tran vdout0_8ck200 FIND v(dout0_8) AT=210.05n

.meas tran vdout0_9ck200 FIND v(dout0_9) AT=210.05n

.meas tran vdout0_10ck200 FIND v(dout0_10) AT=210.05n

.meas tran vdout0_11ck200 FIND v(dout0_11) AT=210.05n

.meas tran vdout0_12ck200 FIND v(dout0_12) AT=210.05n

.meas tran vdout0_13ck200 FIND v(dout0_13) AT=210.05n

.meas tran vdout0_14ck200 FIND v(dout0_14) AT=210.05n

.meas tran vdout0_15ck200 FIND v(dout0_15) AT=210.05n

.meas tran vdout0_16ck200 FIND v(dout0_16) AT=210.05n

.meas tran vdout0_17ck200 FIND v(dout0_17) AT=210.05n

.meas tran vdout0_18ck200 FIND v(dout0_18) AT=210.05n

.meas tran vdout0_19ck200 FIND v(dout0_19) AT=210.05n

.meas tran vdout0_20ck200 FIND v(dout0_20) AT=210.05n

.meas tran vdout0_21ck200 FIND v(dout0_21) AT=210.05n

.meas tran vdout0_22ck200 FIND v(dout0_22) AT=210.05n

.meas tran vdout0_23ck200 FIND v(dout0_23) AT=210.05n

.meas tran vdout0_24ck200 FIND v(dout0_24) AT=210.05n

.meas tran vdout0_25ck200 FIND v(dout0_25) AT=210.05n

.meas tran vdout0_26ck200 FIND v(dout0_26) AT=210.05n

.meas tran vdout0_27ck200 FIND v(dout0_27) AT=210.05n

.meas tran vdout0_28ck200 FIND v(dout0_28) AT=210.05n

.meas tran vdout0_29ck200 FIND v(dout0_29) AT=210.05n

.meas tran vdout0_30ck200 FIND v(dout0_30) AT=210.05n

.meas tran vdout0_31ck200 FIND v(dout0_31) AT=210.05n

.meas tran vdout0_32ck200 FIND v(dout0_32) AT=210.05n

.meas tran vdout0_33ck200 FIND v(dout0_33) AT=210.05n

.meas tran vdout0_34ck200 FIND v(dout0_34) AT=210.05n

.meas tran vdout0_35ck200 FIND v(dout0_35) AT=210.05n

.meas tran vdout0_36ck200 FIND v(dout0_36) AT=210.05n

.meas tran vdout0_37ck200 FIND v(dout0_37) AT=210.05n

.meas tran vdout0_38ck200 FIND v(dout0_38) AT=210.05n

.meas tran vdout0_39ck200 FIND v(dout0_39) AT=210.05n

.meas tran vdout0_40ck200 FIND v(dout0_40) AT=210.05n

.meas tran vdout0_41ck200 FIND v(dout0_41) AT=210.05n

.meas tran vdout0_42ck200 FIND v(dout0_42) AT=210.05n

.meas tran vdout0_43ck200 FIND v(dout0_43) AT=210.05n

.meas tran vdout0_44ck200 FIND v(dout0_44) AT=210.05n

.meas tran vdout0_45ck200 FIND v(dout0_45) AT=210.05n

.meas tran vdout0_46ck200 FIND v(dout0_46) AT=210.05n

.meas tran vdout0_47ck200 FIND v(dout0_47) AT=210.05n

.meas tran vdout0_48ck200 FIND v(dout0_48) AT=210.05n

.meas tran vdout0_49ck200 FIND v(dout0_49) AT=210.05n

.meas tran vdout0_50ck200 FIND v(dout0_50) AT=210.05n

.meas tran vdout0_51ck200 FIND v(dout0_51) AT=210.05n

.meas tran vdout0_52ck200 FIND v(dout0_52) AT=210.05n

.meas tran vdout0_53ck200 FIND v(dout0_53) AT=210.05n

.meas tran vdout0_54ck200 FIND v(dout0_54) AT=210.05n

.meas tran vdout0_55ck200 FIND v(dout0_55) AT=210.05n

.meas tran vdout0_56ck200 FIND v(dout0_56) AT=210.05n

.meas tran vdout0_57ck200 FIND v(dout0_57) AT=210.05n

.meas tran vdout0_58ck200 FIND v(dout0_58) AT=210.05n

.meas tran vdout0_59ck200 FIND v(dout0_59) AT=210.05n

.meas tran vdout0_60ck200 FIND v(dout0_60) AT=210.05n

.meas tran vdout0_61ck200 FIND v(dout0_61) AT=210.05n

.meas tran vdout0_62ck200 FIND v(dout0_62) AT=210.05n

.meas tran vdout0_63ck200 FIND v(dout0_63) AT=210.05n

.meas tran vdout0_64ck200 FIND v(dout0_64) AT=210.05n

.meas tran vdout0_0ck230 FIND v(dout0_0) AT=240.05n

.meas tran vdout0_1ck230 FIND v(dout0_1) AT=240.05n

.meas tran vdout0_2ck230 FIND v(dout0_2) AT=240.05n

.meas tran vdout0_3ck230 FIND v(dout0_3) AT=240.05n

.meas tran vdout0_4ck230 FIND v(dout0_4) AT=240.05n

.meas tran vdout0_5ck230 FIND v(dout0_5) AT=240.05n

.meas tran vdout0_6ck230 FIND v(dout0_6) AT=240.05n

.meas tran vdout0_7ck230 FIND v(dout0_7) AT=240.05n

.meas tran vdout0_8ck230 FIND v(dout0_8) AT=240.05n

.meas tran vdout0_9ck230 FIND v(dout0_9) AT=240.05n

.meas tran vdout0_10ck230 FIND v(dout0_10) AT=240.05n

.meas tran vdout0_11ck230 FIND v(dout0_11) AT=240.05n

.meas tran vdout0_12ck230 FIND v(dout0_12) AT=240.05n

.meas tran vdout0_13ck230 FIND v(dout0_13) AT=240.05n

.meas tran vdout0_14ck230 FIND v(dout0_14) AT=240.05n

.meas tran vdout0_15ck230 FIND v(dout0_15) AT=240.05n

.meas tran vdout0_16ck230 FIND v(dout0_16) AT=240.05n

.meas tran vdout0_17ck230 FIND v(dout0_17) AT=240.05n

.meas tran vdout0_18ck230 FIND v(dout0_18) AT=240.05n

.meas tran vdout0_19ck230 FIND v(dout0_19) AT=240.05n

.meas tran vdout0_20ck230 FIND v(dout0_20) AT=240.05n

.meas tran vdout0_21ck230 FIND v(dout0_21) AT=240.05n

.meas tran vdout0_22ck230 FIND v(dout0_22) AT=240.05n

.meas tran vdout0_23ck230 FIND v(dout0_23) AT=240.05n

.meas tran vdout0_24ck230 FIND v(dout0_24) AT=240.05n

.meas tran vdout0_25ck230 FIND v(dout0_25) AT=240.05n

.meas tran vdout0_26ck230 FIND v(dout0_26) AT=240.05n

.meas tran vdout0_27ck230 FIND v(dout0_27) AT=240.05n

.meas tran vdout0_28ck230 FIND v(dout0_28) AT=240.05n

.meas tran vdout0_29ck230 FIND v(dout0_29) AT=240.05n

.meas tran vdout0_30ck230 FIND v(dout0_30) AT=240.05n

.meas tran vdout0_31ck230 FIND v(dout0_31) AT=240.05n

.meas tran vdout0_32ck230 FIND v(dout0_32) AT=240.05n

.meas tran vdout0_33ck230 FIND v(dout0_33) AT=240.05n

.meas tran vdout0_34ck230 FIND v(dout0_34) AT=240.05n

.meas tran vdout0_35ck230 FIND v(dout0_35) AT=240.05n

.meas tran vdout0_36ck230 FIND v(dout0_36) AT=240.05n

.meas tran vdout0_37ck230 FIND v(dout0_37) AT=240.05n

.meas tran vdout0_38ck230 FIND v(dout0_38) AT=240.05n

.meas tran vdout0_39ck230 FIND v(dout0_39) AT=240.05n

.meas tran vdout0_40ck230 FIND v(dout0_40) AT=240.05n

.meas tran vdout0_41ck230 FIND v(dout0_41) AT=240.05n

.meas tran vdout0_42ck230 FIND v(dout0_42) AT=240.05n

.meas tran vdout0_43ck230 FIND v(dout0_43) AT=240.05n

.meas tran vdout0_44ck230 FIND v(dout0_44) AT=240.05n

.meas tran vdout0_45ck230 FIND v(dout0_45) AT=240.05n

.meas tran vdout0_46ck230 FIND v(dout0_46) AT=240.05n

.meas tran vdout0_47ck230 FIND v(dout0_47) AT=240.05n

.meas tran vdout0_48ck230 FIND v(dout0_48) AT=240.05n

.meas tran vdout0_49ck230 FIND v(dout0_49) AT=240.05n

.meas tran vdout0_50ck230 FIND v(dout0_50) AT=240.05n

.meas tran vdout0_51ck230 FIND v(dout0_51) AT=240.05n

.meas tran vdout0_52ck230 FIND v(dout0_52) AT=240.05n

.meas tran vdout0_53ck230 FIND v(dout0_53) AT=240.05n

.meas tran vdout0_54ck230 FIND v(dout0_54) AT=240.05n

.meas tran vdout0_55ck230 FIND v(dout0_55) AT=240.05n

.meas tran vdout0_56ck230 FIND v(dout0_56) AT=240.05n

.meas tran vdout0_57ck230 FIND v(dout0_57) AT=240.05n

.meas tran vdout0_58ck230 FIND v(dout0_58) AT=240.05n

.meas tran vdout0_59ck230 FIND v(dout0_59) AT=240.05n

.meas tran vdout0_60ck230 FIND v(dout0_60) AT=240.05n

.meas tran vdout0_61ck230 FIND v(dout0_61) AT=240.05n

.meas tran vdout0_62ck230 FIND v(dout0_62) AT=240.05n

.meas tran vdout0_63ck230 FIND v(dout0_63) AT=240.05n

.meas tran vdout0_64ck230 FIND v(dout0_64) AT=240.05n

.meas tran vdout0_0ck250 FIND v(dout0_0) AT=260.05n

.meas tran vdout0_1ck250 FIND v(dout0_1) AT=260.05n

.meas tran vdout0_2ck250 FIND v(dout0_2) AT=260.05n

.meas tran vdout0_3ck250 FIND v(dout0_3) AT=260.05n

.meas tran vdout0_4ck250 FIND v(dout0_4) AT=260.05n

.meas tran vdout0_5ck250 FIND v(dout0_5) AT=260.05n

.meas tran vdout0_6ck250 FIND v(dout0_6) AT=260.05n

.meas tran vdout0_7ck250 FIND v(dout0_7) AT=260.05n

.meas tran vdout0_8ck250 FIND v(dout0_8) AT=260.05n

.meas tran vdout0_9ck250 FIND v(dout0_9) AT=260.05n

.meas tran vdout0_10ck250 FIND v(dout0_10) AT=260.05n

.meas tran vdout0_11ck250 FIND v(dout0_11) AT=260.05n

.meas tran vdout0_12ck250 FIND v(dout0_12) AT=260.05n

.meas tran vdout0_13ck250 FIND v(dout0_13) AT=260.05n

.meas tran vdout0_14ck250 FIND v(dout0_14) AT=260.05n

.meas tran vdout0_15ck250 FIND v(dout0_15) AT=260.05n

.meas tran vdout0_16ck250 FIND v(dout0_16) AT=260.05n

.meas tran vdout0_17ck250 FIND v(dout0_17) AT=260.05n

.meas tran vdout0_18ck250 FIND v(dout0_18) AT=260.05n

.meas tran vdout0_19ck250 FIND v(dout0_19) AT=260.05n

.meas tran vdout0_20ck250 FIND v(dout0_20) AT=260.05n

.meas tran vdout0_21ck250 FIND v(dout0_21) AT=260.05n

.meas tran vdout0_22ck250 FIND v(dout0_22) AT=260.05n

.meas tran vdout0_23ck250 FIND v(dout0_23) AT=260.05n

.meas tran vdout0_24ck250 FIND v(dout0_24) AT=260.05n

.meas tran vdout0_25ck250 FIND v(dout0_25) AT=260.05n

.meas tran vdout0_26ck250 FIND v(dout0_26) AT=260.05n

.meas tran vdout0_27ck250 FIND v(dout0_27) AT=260.05n

.meas tran vdout0_28ck250 FIND v(dout0_28) AT=260.05n

.meas tran vdout0_29ck250 FIND v(dout0_29) AT=260.05n

.meas tran vdout0_30ck250 FIND v(dout0_30) AT=260.05n

.meas tran vdout0_31ck250 FIND v(dout0_31) AT=260.05n

.meas tran vdout0_32ck250 FIND v(dout0_32) AT=260.05n

.meas tran vdout0_33ck250 FIND v(dout0_33) AT=260.05n

.meas tran vdout0_34ck250 FIND v(dout0_34) AT=260.05n

.meas tran vdout0_35ck250 FIND v(dout0_35) AT=260.05n

.meas tran vdout0_36ck250 FIND v(dout0_36) AT=260.05n

.meas tran vdout0_37ck250 FIND v(dout0_37) AT=260.05n

.meas tran vdout0_38ck250 FIND v(dout0_38) AT=260.05n

.meas tran vdout0_39ck250 FIND v(dout0_39) AT=260.05n

.meas tran vdout0_40ck250 FIND v(dout0_40) AT=260.05n

.meas tran vdout0_41ck250 FIND v(dout0_41) AT=260.05n

.meas tran vdout0_42ck250 FIND v(dout0_42) AT=260.05n

.meas tran vdout0_43ck250 FIND v(dout0_43) AT=260.05n

.meas tran vdout0_44ck250 FIND v(dout0_44) AT=260.05n

.meas tran vdout0_45ck250 FIND v(dout0_45) AT=260.05n

.meas tran vdout0_46ck250 FIND v(dout0_46) AT=260.05n

.meas tran vdout0_47ck250 FIND v(dout0_47) AT=260.05n

.meas tran vdout0_48ck250 FIND v(dout0_48) AT=260.05n

.meas tran vdout0_49ck250 FIND v(dout0_49) AT=260.05n

.meas tran vdout0_50ck250 FIND v(dout0_50) AT=260.05n

.meas tran vdout0_51ck250 FIND v(dout0_51) AT=260.05n

.meas tran vdout0_52ck250 FIND v(dout0_52) AT=260.05n

.meas tran vdout0_53ck250 FIND v(dout0_53) AT=260.05n

.meas tran vdout0_54ck250 FIND v(dout0_54) AT=260.05n

.meas tran vdout0_55ck250 FIND v(dout0_55) AT=260.05n

.meas tran vdout0_56ck250 FIND v(dout0_56) AT=260.05n

.meas tran vdout0_57ck250 FIND v(dout0_57) AT=260.05n

.meas tran vdout0_58ck250 FIND v(dout0_58) AT=260.05n

.meas tran vdout0_59ck250 FIND v(dout0_59) AT=260.05n

.meas tran vdout0_60ck250 FIND v(dout0_60) AT=260.05n

.meas tran vdout0_61ck250 FIND v(dout0_61) AT=260.05n

.meas tran vdout0_62ck250 FIND v(dout0_62) AT=260.05n

.meas tran vdout0_63ck250 FIND v(dout0_63) AT=260.05n

.meas tran vdout0_64ck250 FIND v(dout0_64) AT=260.05n

.meas tran vdout0_0ck260 FIND v(dout0_0) AT=270.05n

.meas tran vdout0_1ck260 FIND v(dout0_1) AT=270.05n

.meas tran vdout0_2ck260 FIND v(dout0_2) AT=270.05n

.meas tran vdout0_3ck260 FIND v(dout0_3) AT=270.05n

.meas tran vdout0_4ck260 FIND v(dout0_4) AT=270.05n

.meas tran vdout0_5ck260 FIND v(dout0_5) AT=270.05n

.meas tran vdout0_6ck260 FIND v(dout0_6) AT=270.05n

.meas tran vdout0_7ck260 FIND v(dout0_7) AT=270.05n

.meas tran vdout0_8ck260 FIND v(dout0_8) AT=270.05n

.meas tran vdout0_9ck260 FIND v(dout0_9) AT=270.05n

.meas tran vdout0_10ck260 FIND v(dout0_10) AT=270.05n

.meas tran vdout0_11ck260 FIND v(dout0_11) AT=270.05n

.meas tran vdout0_12ck260 FIND v(dout0_12) AT=270.05n

.meas tran vdout0_13ck260 FIND v(dout0_13) AT=270.05n

.meas tran vdout0_14ck260 FIND v(dout0_14) AT=270.05n

.meas tran vdout0_15ck260 FIND v(dout0_15) AT=270.05n

.meas tran vdout0_16ck260 FIND v(dout0_16) AT=270.05n

.meas tran vdout0_17ck260 FIND v(dout0_17) AT=270.05n

.meas tran vdout0_18ck260 FIND v(dout0_18) AT=270.05n

.meas tran vdout0_19ck260 FIND v(dout0_19) AT=270.05n

.meas tran vdout0_20ck260 FIND v(dout0_20) AT=270.05n

.meas tran vdout0_21ck260 FIND v(dout0_21) AT=270.05n

.meas tran vdout0_22ck260 FIND v(dout0_22) AT=270.05n

.meas tran vdout0_23ck260 FIND v(dout0_23) AT=270.05n

.meas tran vdout0_24ck260 FIND v(dout0_24) AT=270.05n

.meas tran vdout0_25ck260 FIND v(dout0_25) AT=270.05n

.meas tran vdout0_26ck260 FIND v(dout0_26) AT=270.05n

.meas tran vdout0_27ck260 FIND v(dout0_27) AT=270.05n

.meas tran vdout0_28ck260 FIND v(dout0_28) AT=270.05n

.meas tran vdout0_29ck260 FIND v(dout0_29) AT=270.05n

.meas tran vdout0_30ck260 FIND v(dout0_30) AT=270.05n

.meas tran vdout0_31ck260 FIND v(dout0_31) AT=270.05n

.meas tran vdout0_32ck260 FIND v(dout0_32) AT=270.05n

.meas tran vdout0_33ck260 FIND v(dout0_33) AT=270.05n

.meas tran vdout0_34ck260 FIND v(dout0_34) AT=270.05n

.meas tran vdout0_35ck260 FIND v(dout0_35) AT=270.05n

.meas tran vdout0_36ck260 FIND v(dout0_36) AT=270.05n

.meas tran vdout0_37ck260 FIND v(dout0_37) AT=270.05n

.meas tran vdout0_38ck260 FIND v(dout0_38) AT=270.05n

.meas tran vdout0_39ck260 FIND v(dout0_39) AT=270.05n

.meas tran vdout0_40ck260 FIND v(dout0_40) AT=270.05n

.meas tran vdout0_41ck260 FIND v(dout0_41) AT=270.05n

.meas tran vdout0_42ck260 FIND v(dout0_42) AT=270.05n

.meas tran vdout0_43ck260 FIND v(dout0_43) AT=270.05n

.meas tran vdout0_44ck260 FIND v(dout0_44) AT=270.05n

.meas tran vdout0_45ck260 FIND v(dout0_45) AT=270.05n

.meas tran vdout0_46ck260 FIND v(dout0_46) AT=270.05n

.meas tran vdout0_47ck260 FIND v(dout0_47) AT=270.05n

.meas tran vdout0_48ck260 FIND v(dout0_48) AT=270.05n

.meas tran vdout0_49ck260 FIND v(dout0_49) AT=270.05n

.meas tran vdout0_50ck260 FIND v(dout0_50) AT=270.05n

.meas tran vdout0_51ck260 FIND v(dout0_51) AT=270.05n

.meas tran vdout0_52ck260 FIND v(dout0_52) AT=270.05n

.meas tran vdout0_53ck260 FIND v(dout0_53) AT=270.05n

.meas tran vdout0_54ck260 FIND v(dout0_54) AT=270.05n

.meas tran vdout0_55ck260 FIND v(dout0_55) AT=270.05n

.meas tran vdout0_56ck260 FIND v(dout0_56) AT=270.05n

.meas tran vdout0_57ck260 FIND v(dout0_57) AT=270.05n

.meas tran vdout0_58ck260 FIND v(dout0_58) AT=270.05n

.meas tran vdout0_59ck260 FIND v(dout0_59) AT=270.05n

.meas tran vdout0_60ck260 FIND v(dout0_60) AT=270.05n

.meas tran vdout0_61ck260 FIND v(dout0_61) AT=270.05n

.meas tran vdout0_62ck260 FIND v(dout0_62) AT=270.05n

.meas tran vdout0_63ck260 FIND v(dout0_63) AT=270.05n

.meas tran vdout0_64ck260 FIND v(dout0_64) AT=270.05n

.meas tran vdout0_0ck280 FIND v(dout0_0) AT=290.05n

.meas tran vdout0_1ck280 FIND v(dout0_1) AT=290.05n

.meas tran vdout0_2ck280 FIND v(dout0_2) AT=290.05n

.meas tran vdout0_3ck280 FIND v(dout0_3) AT=290.05n

.meas tran vdout0_4ck280 FIND v(dout0_4) AT=290.05n

.meas tran vdout0_5ck280 FIND v(dout0_5) AT=290.05n

.meas tran vdout0_6ck280 FIND v(dout0_6) AT=290.05n

.meas tran vdout0_7ck280 FIND v(dout0_7) AT=290.05n

.meas tran vdout0_8ck280 FIND v(dout0_8) AT=290.05n

.meas tran vdout0_9ck280 FIND v(dout0_9) AT=290.05n

.meas tran vdout0_10ck280 FIND v(dout0_10) AT=290.05n

.meas tran vdout0_11ck280 FIND v(dout0_11) AT=290.05n

.meas tran vdout0_12ck280 FIND v(dout0_12) AT=290.05n

.meas tran vdout0_13ck280 FIND v(dout0_13) AT=290.05n

.meas tran vdout0_14ck280 FIND v(dout0_14) AT=290.05n

.meas tran vdout0_15ck280 FIND v(dout0_15) AT=290.05n

.meas tran vdout0_16ck280 FIND v(dout0_16) AT=290.05n

.meas tran vdout0_17ck280 FIND v(dout0_17) AT=290.05n

.meas tran vdout0_18ck280 FIND v(dout0_18) AT=290.05n

.meas tran vdout0_19ck280 FIND v(dout0_19) AT=290.05n

.meas tran vdout0_20ck280 FIND v(dout0_20) AT=290.05n

.meas tran vdout0_21ck280 FIND v(dout0_21) AT=290.05n

.meas tran vdout0_22ck280 FIND v(dout0_22) AT=290.05n

.meas tran vdout0_23ck280 FIND v(dout0_23) AT=290.05n

.meas tran vdout0_24ck280 FIND v(dout0_24) AT=290.05n

.meas tran vdout0_25ck280 FIND v(dout0_25) AT=290.05n

.meas tran vdout0_26ck280 FIND v(dout0_26) AT=290.05n

.meas tran vdout0_27ck280 FIND v(dout0_27) AT=290.05n

.meas tran vdout0_28ck280 FIND v(dout0_28) AT=290.05n

.meas tran vdout0_29ck280 FIND v(dout0_29) AT=290.05n

.meas tran vdout0_30ck280 FIND v(dout0_30) AT=290.05n

.meas tran vdout0_31ck280 FIND v(dout0_31) AT=290.05n

.meas tran vdout0_32ck280 FIND v(dout0_32) AT=290.05n

.meas tran vdout0_33ck280 FIND v(dout0_33) AT=290.05n

.meas tran vdout0_34ck280 FIND v(dout0_34) AT=290.05n

.meas tran vdout0_35ck280 FIND v(dout0_35) AT=290.05n

.meas tran vdout0_36ck280 FIND v(dout0_36) AT=290.05n

.meas tran vdout0_37ck280 FIND v(dout0_37) AT=290.05n

.meas tran vdout0_38ck280 FIND v(dout0_38) AT=290.05n

.meas tran vdout0_39ck280 FIND v(dout0_39) AT=290.05n

.meas tran vdout0_40ck280 FIND v(dout0_40) AT=290.05n

.meas tran vdout0_41ck280 FIND v(dout0_41) AT=290.05n

.meas tran vdout0_42ck280 FIND v(dout0_42) AT=290.05n

.meas tran vdout0_43ck280 FIND v(dout0_43) AT=290.05n

.meas tran vdout0_44ck280 FIND v(dout0_44) AT=290.05n

.meas tran vdout0_45ck280 FIND v(dout0_45) AT=290.05n

.meas tran vdout0_46ck280 FIND v(dout0_46) AT=290.05n

.meas tran vdout0_47ck280 FIND v(dout0_47) AT=290.05n

.meas tran vdout0_48ck280 FIND v(dout0_48) AT=290.05n

.meas tran vdout0_49ck280 FIND v(dout0_49) AT=290.05n

.meas tran vdout0_50ck280 FIND v(dout0_50) AT=290.05n

.meas tran vdout0_51ck280 FIND v(dout0_51) AT=290.05n

.meas tran vdout0_52ck280 FIND v(dout0_52) AT=290.05n

.meas tran vdout0_53ck280 FIND v(dout0_53) AT=290.05n

.meas tran vdout0_54ck280 FIND v(dout0_54) AT=290.05n

.meas tran vdout0_55ck280 FIND v(dout0_55) AT=290.05n

.meas tran vdout0_56ck280 FIND v(dout0_56) AT=290.05n

.meas tran vdout0_57ck280 FIND v(dout0_57) AT=290.05n

.meas tran vdout0_58ck280 FIND v(dout0_58) AT=290.05n

.meas tran vdout0_59ck280 FIND v(dout0_59) AT=290.05n

.meas tran vdout0_60ck280 FIND v(dout0_60) AT=290.05n

.meas tran vdout0_61ck280 FIND v(dout0_61) AT=290.05n

.meas tran vdout0_62ck280 FIND v(dout0_62) AT=290.05n

.meas tran vdout0_63ck280 FIND v(dout0_63) AT=290.05n

.meas tran vdout0_64ck280 FIND v(dout0_64) AT=290.05n

.meas tran vdout0_0ck300 FIND v(dout0_0) AT=310.05n

.meas tran vdout0_1ck300 FIND v(dout0_1) AT=310.05n

.meas tran vdout0_2ck300 FIND v(dout0_2) AT=310.05n

.meas tran vdout0_3ck300 FIND v(dout0_3) AT=310.05n

.meas tran vdout0_4ck300 FIND v(dout0_4) AT=310.05n

.meas tran vdout0_5ck300 FIND v(dout0_5) AT=310.05n

.meas tran vdout0_6ck300 FIND v(dout0_6) AT=310.05n

.meas tran vdout0_7ck300 FIND v(dout0_7) AT=310.05n

.meas tran vdout0_8ck300 FIND v(dout0_8) AT=310.05n

.meas tran vdout0_9ck300 FIND v(dout0_9) AT=310.05n

.meas tran vdout0_10ck300 FIND v(dout0_10) AT=310.05n

.meas tran vdout0_11ck300 FIND v(dout0_11) AT=310.05n

.meas tran vdout0_12ck300 FIND v(dout0_12) AT=310.05n

.meas tran vdout0_13ck300 FIND v(dout0_13) AT=310.05n

.meas tran vdout0_14ck300 FIND v(dout0_14) AT=310.05n

.meas tran vdout0_15ck300 FIND v(dout0_15) AT=310.05n

.meas tran vdout0_16ck300 FIND v(dout0_16) AT=310.05n

.meas tran vdout0_17ck300 FIND v(dout0_17) AT=310.05n

.meas tran vdout0_18ck300 FIND v(dout0_18) AT=310.05n

.meas tran vdout0_19ck300 FIND v(dout0_19) AT=310.05n

.meas tran vdout0_20ck300 FIND v(dout0_20) AT=310.05n

.meas tran vdout0_21ck300 FIND v(dout0_21) AT=310.05n

.meas tran vdout0_22ck300 FIND v(dout0_22) AT=310.05n

.meas tran vdout0_23ck300 FIND v(dout0_23) AT=310.05n

.meas tran vdout0_24ck300 FIND v(dout0_24) AT=310.05n

.meas tran vdout0_25ck300 FIND v(dout0_25) AT=310.05n

.meas tran vdout0_26ck300 FIND v(dout0_26) AT=310.05n

.meas tran vdout0_27ck300 FIND v(dout0_27) AT=310.05n

.meas tran vdout0_28ck300 FIND v(dout0_28) AT=310.05n

.meas tran vdout0_29ck300 FIND v(dout0_29) AT=310.05n

.meas tran vdout0_30ck300 FIND v(dout0_30) AT=310.05n

.meas tran vdout0_31ck300 FIND v(dout0_31) AT=310.05n

.meas tran vdout0_32ck300 FIND v(dout0_32) AT=310.05n

.meas tran vdout0_33ck300 FIND v(dout0_33) AT=310.05n

.meas tran vdout0_34ck300 FIND v(dout0_34) AT=310.05n

.meas tran vdout0_35ck300 FIND v(dout0_35) AT=310.05n

.meas tran vdout0_36ck300 FIND v(dout0_36) AT=310.05n

.meas tran vdout0_37ck300 FIND v(dout0_37) AT=310.05n

.meas tran vdout0_38ck300 FIND v(dout0_38) AT=310.05n

.meas tran vdout0_39ck300 FIND v(dout0_39) AT=310.05n

.meas tran vdout0_40ck300 FIND v(dout0_40) AT=310.05n

.meas tran vdout0_41ck300 FIND v(dout0_41) AT=310.05n

.meas tran vdout0_42ck300 FIND v(dout0_42) AT=310.05n

.meas tran vdout0_43ck300 FIND v(dout0_43) AT=310.05n

.meas tran vdout0_44ck300 FIND v(dout0_44) AT=310.05n

.meas tran vdout0_45ck300 FIND v(dout0_45) AT=310.05n

.meas tran vdout0_46ck300 FIND v(dout0_46) AT=310.05n

.meas tran vdout0_47ck300 FIND v(dout0_47) AT=310.05n

.meas tran vdout0_48ck300 FIND v(dout0_48) AT=310.05n

.meas tran vdout0_49ck300 FIND v(dout0_49) AT=310.05n

.meas tran vdout0_50ck300 FIND v(dout0_50) AT=310.05n

.meas tran vdout0_51ck300 FIND v(dout0_51) AT=310.05n

.meas tran vdout0_52ck300 FIND v(dout0_52) AT=310.05n

.meas tran vdout0_53ck300 FIND v(dout0_53) AT=310.05n

.meas tran vdout0_54ck300 FIND v(dout0_54) AT=310.05n

.meas tran vdout0_55ck300 FIND v(dout0_55) AT=310.05n

.meas tran vdout0_56ck300 FIND v(dout0_56) AT=310.05n

.meas tran vdout0_57ck300 FIND v(dout0_57) AT=310.05n

.meas tran vdout0_58ck300 FIND v(dout0_58) AT=310.05n

.meas tran vdout0_59ck300 FIND v(dout0_59) AT=310.05n

.meas tran vdout0_60ck300 FIND v(dout0_60) AT=310.05n

.meas tran vdout0_61ck300 FIND v(dout0_61) AT=310.05n

.meas tran vdout0_62ck300 FIND v(dout0_62) AT=310.05n

.meas tran vdout0_63ck300 FIND v(dout0_63) AT=310.05n

.meas tran vdout0_64ck300 FIND v(dout0_64) AT=310.05n

.meas tran vdout0_0ck310 FIND v(dout0_0) AT=320.05n

.meas tran vdout0_1ck310 FIND v(dout0_1) AT=320.05n

.meas tran vdout0_2ck310 FIND v(dout0_2) AT=320.05n

.meas tran vdout0_3ck310 FIND v(dout0_3) AT=320.05n

.meas tran vdout0_4ck310 FIND v(dout0_4) AT=320.05n

.meas tran vdout0_5ck310 FIND v(dout0_5) AT=320.05n

.meas tran vdout0_6ck310 FIND v(dout0_6) AT=320.05n

.meas tran vdout0_7ck310 FIND v(dout0_7) AT=320.05n

.meas tran vdout0_8ck310 FIND v(dout0_8) AT=320.05n

.meas tran vdout0_9ck310 FIND v(dout0_9) AT=320.05n

.meas tran vdout0_10ck310 FIND v(dout0_10) AT=320.05n

.meas tran vdout0_11ck310 FIND v(dout0_11) AT=320.05n

.meas tran vdout0_12ck310 FIND v(dout0_12) AT=320.05n

.meas tran vdout0_13ck310 FIND v(dout0_13) AT=320.05n

.meas tran vdout0_14ck310 FIND v(dout0_14) AT=320.05n

.meas tran vdout0_15ck310 FIND v(dout0_15) AT=320.05n

.meas tran vdout0_16ck310 FIND v(dout0_16) AT=320.05n

.meas tran vdout0_17ck310 FIND v(dout0_17) AT=320.05n

.meas tran vdout0_18ck310 FIND v(dout0_18) AT=320.05n

.meas tran vdout0_19ck310 FIND v(dout0_19) AT=320.05n

.meas tran vdout0_20ck310 FIND v(dout0_20) AT=320.05n

.meas tran vdout0_21ck310 FIND v(dout0_21) AT=320.05n

.meas tran vdout0_22ck310 FIND v(dout0_22) AT=320.05n

.meas tran vdout0_23ck310 FIND v(dout0_23) AT=320.05n

.meas tran vdout0_24ck310 FIND v(dout0_24) AT=320.05n

.meas tran vdout0_25ck310 FIND v(dout0_25) AT=320.05n

.meas tran vdout0_26ck310 FIND v(dout0_26) AT=320.05n

.meas tran vdout0_27ck310 FIND v(dout0_27) AT=320.05n

.meas tran vdout0_28ck310 FIND v(dout0_28) AT=320.05n

.meas tran vdout0_29ck310 FIND v(dout0_29) AT=320.05n

.meas tran vdout0_30ck310 FIND v(dout0_30) AT=320.05n

.meas tran vdout0_31ck310 FIND v(dout0_31) AT=320.05n

.meas tran vdout0_32ck310 FIND v(dout0_32) AT=320.05n

.meas tran vdout0_33ck310 FIND v(dout0_33) AT=320.05n

.meas tran vdout0_34ck310 FIND v(dout0_34) AT=320.05n

.meas tran vdout0_35ck310 FIND v(dout0_35) AT=320.05n

.meas tran vdout0_36ck310 FIND v(dout0_36) AT=320.05n

.meas tran vdout0_37ck310 FIND v(dout0_37) AT=320.05n

.meas tran vdout0_38ck310 FIND v(dout0_38) AT=320.05n

.meas tran vdout0_39ck310 FIND v(dout0_39) AT=320.05n

.meas tran vdout0_40ck310 FIND v(dout0_40) AT=320.05n

.meas tran vdout0_41ck310 FIND v(dout0_41) AT=320.05n

.meas tran vdout0_42ck310 FIND v(dout0_42) AT=320.05n

.meas tran vdout0_43ck310 FIND v(dout0_43) AT=320.05n

.meas tran vdout0_44ck310 FIND v(dout0_44) AT=320.05n

.meas tran vdout0_45ck310 FIND v(dout0_45) AT=320.05n

.meas tran vdout0_46ck310 FIND v(dout0_46) AT=320.05n

.meas tran vdout0_47ck310 FIND v(dout0_47) AT=320.05n

.meas tran vdout0_48ck310 FIND v(dout0_48) AT=320.05n

.meas tran vdout0_49ck310 FIND v(dout0_49) AT=320.05n

.meas tran vdout0_50ck310 FIND v(dout0_50) AT=320.05n

.meas tran vdout0_51ck310 FIND v(dout0_51) AT=320.05n

.meas tran vdout0_52ck310 FIND v(dout0_52) AT=320.05n

.meas tran vdout0_53ck310 FIND v(dout0_53) AT=320.05n

.meas tran vdout0_54ck310 FIND v(dout0_54) AT=320.05n

.meas tran vdout0_55ck310 FIND v(dout0_55) AT=320.05n

.meas tran vdout0_56ck310 FIND v(dout0_56) AT=320.05n

.meas tran vdout0_57ck310 FIND v(dout0_57) AT=320.05n

.meas tran vdout0_58ck310 FIND v(dout0_58) AT=320.05n

.meas tran vdout0_59ck310 FIND v(dout0_59) AT=320.05n

.meas tran vdout0_60ck310 FIND v(dout0_60) AT=320.05n

.meas tran vdout0_61ck310 FIND v(dout0_61) AT=320.05n

.meas tran vdout0_62ck310 FIND v(dout0_62) AT=320.05n

.meas tran vdout0_63ck310 FIND v(dout0_63) AT=320.05n

.meas tran vdout0_64ck310 FIND v(dout0_64) AT=320.05n

.meas tran vdout0_0ck320 FIND v(dout0_0) AT=330.05n

.meas tran vdout0_1ck320 FIND v(dout0_1) AT=330.05n

.meas tran vdout0_2ck320 FIND v(dout0_2) AT=330.05n

.meas tran vdout0_3ck320 FIND v(dout0_3) AT=330.05n

.meas tran vdout0_4ck320 FIND v(dout0_4) AT=330.05n

.meas tran vdout0_5ck320 FIND v(dout0_5) AT=330.05n

.meas tran vdout0_6ck320 FIND v(dout0_6) AT=330.05n

.meas tran vdout0_7ck320 FIND v(dout0_7) AT=330.05n

.meas tran vdout0_8ck320 FIND v(dout0_8) AT=330.05n

.meas tran vdout0_9ck320 FIND v(dout0_9) AT=330.05n

.meas tran vdout0_10ck320 FIND v(dout0_10) AT=330.05n

.meas tran vdout0_11ck320 FIND v(dout0_11) AT=330.05n

.meas tran vdout0_12ck320 FIND v(dout0_12) AT=330.05n

.meas tran vdout0_13ck320 FIND v(dout0_13) AT=330.05n

.meas tran vdout0_14ck320 FIND v(dout0_14) AT=330.05n

.meas tran vdout0_15ck320 FIND v(dout0_15) AT=330.05n

.meas tran vdout0_16ck320 FIND v(dout0_16) AT=330.05n

.meas tran vdout0_17ck320 FIND v(dout0_17) AT=330.05n

.meas tran vdout0_18ck320 FIND v(dout0_18) AT=330.05n

.meas tran vdout0_19ck320 FIND v(dout0_19) AT=330.05n

.meas tran vdout0_20ck320 FIND v(dout0_20) AT=330.05n

.meas tran vdout0_21ck320 FIND v(dout0_21) AT=330.05n

.meas tran vdout0_22ck320 FIND v(dout0_22) AT=330.05n

.meas tran vdout0_23ck320 FIND v(dout0_23) AT=330.05n

.meas tran vdout0_24ck320 FIND v(dout0_24) AT=330.05n

.meas tran vdout0_25ck320 FIND v(dout0_25) AT=330.05n

.meas tran vdout0_26ck320 FIND v(dout0_26) AT=330.05n

.meas tran vdout0_27ck320 FIND v(dout0_27) AT=330.05n

.meas tran vdout0_28ck320 FIND v(dout0_28) AT=330.05n

.meas tran vdout0_29ck320 FIND v(dout0_29) AT=330.05n

.meas tran vdout0_30ck320 FIND v(dout0_30) AT=330.05n

.meas tran vdout0_31ck320 FIND v(dout0_31) AT=330.05n

.meas tran vdout0_32ck320 FIND v(dout0_32) AT=330.05n

.meas tran vdout0_33ck320 FIND v(dout0_33) AT=330.05n

.meas tran vdout0_34ck320 FIND v(dout0_34) AT=330.05n

.meas tran vdout0_35ck320 FIND v(dout0_35) AT=330.05n

.meas tran vdout0_36ck320 FIND v(dout0_36) AT=330.05n

.meas tran vdout0_37ck320 FIND v(dout0_37) AT=330.05n

.meas tran vdout0_38ck320 FIND v(dout0_38) AT=330.05n

.meas tran vdout0_39ck320 FIND v(dout0_39) AT=330.05n

.meas tran vdout0_40ck320 FIND v(dout0_40) AT=330.05n

.meas tran vdout0_41ck320 FIND v(dout0_41) AT=330.05n

.meas tran vdout0_42ck320 FIND v(dout0_42) AT=330.05n

.meas tran vdout0_43ck320 FIND v(dout0_43) AT=330.05n

.meas tran vdout0_44ck320 FIND v(dout0_44) AT=330.05n

.meas tran vdout0_45ck320 FIND v(dout0_45) AT=330.05n

.meas tran vdout0_46ck320 FIND v(dout0_46) AT=330.05n

.meas tran vdout0_47ck320 FIND v(dout0_47) AT=330.05n

.meas tran vdout0_48ck320 FIND v(dout0_48) AT=330.05n

.meas tran vdout0_49ck320 FIND v(dout0_49) AT=330.05n

.meas tran vdout0_50ck320 FIND v(dout0_50) AT=330.05n

.meas tran vdout0_51ck320 FIND v(dout0_51) AT=330.05n

.meas tran vdout0_52ck320 FIND v(dout0_52) AT=330.05n

.meas tran vdout0_53ck320 FIND v(dout0_53) AT=330.05n

.meas tran vdout0_54ck320 FIND v(dout0_54) AT=330.05n

.meas tran vdout0_55ck320 FIND v(dout0_55) AT=330.05n

.meas tran vdout0_56ck320 FIND v(dout0_56) AT=330.05n

.meas tran vdout0_57ck320 FIND v(dout0_57) AT=330.05n

.meas tran vdout0_58ck320 FIND v(dout0_58) AT=330.05n

.meas tran vdout0_59ck320 FIND v(dout0_59) AT=330.05n

.meas tran vdout0_60ck320 FIND v(dout0_60) AT=330.05n

.meas tran vdout0_61ck320 FIND v(dout0_61) AT=330.05n

.meas tran vdout0_62ck320 FIND v(dout0_62) AT=330.05n

.meas tran vdout0_63ck320 FIND v(dout0_63) AT=330.05n

.meas tran vdout0_64ck320 FIND v(dout0_64) AT=330.05n

.meas tran vdout0_0ck380 FIND v(dout0_0) AT=390.05n

.meas tran vdout0_1ck380 FIND v(dout0_1) AT=390.05n

.meas tran vdout0_2ck380 FIND v(dout0_2) AT=390.05n

.meas tran vdout0_3ck380 FIND v(dout0_3) AT=390.05n

.meas tran vdout0_4ck380 FIND v(dout0_4) AT=390.05n

.meas tran vdout0_5ck380 FIND v(dout0_5) AT=390.05n

.meas tran vdout0_6ck380 FIND v(dout0_6) AT=390.05n

.meas tran vdout0_7ck380 FIND v(dout0_7) AT=390.05n

.meas tran vdout0_8ck380 FIND v(dout0_8) AT=390.05n

.meas tran vdout0_9ck380 FIND v(dout0_9) AT=390.05n

.meas tran vdout0_10ck380 FIND v(dout0_10) AT=390.05n

.meas tran vdout0_11ck380 FIND v(dout0_11) AT=390.05n

.meas tran vdout0_12ck380 FIND v(dout0_12) AT=390.05n

.meas tran vdout0_13ck380 FIND v(dout0_13) AT=390.05n

.meas tran vdout0_14ck380 FIND v(dout0_14) AT=390.05n

.meas tran vdout0_15ck380 FIND v(dout0_15) AT=390.05n

.meas tran vdout0_16ck380 FIND v(dout0_16) AT=390.05n

.meas tran vdout0_17ck380 FIND v(dout0_17) AT=390.05n

.meas tran vdout0_18ck380 FIND v(dout0_18) AT=390.05n

.meas tran vdout0_19ck380 FIND v(dout0_19) AT=390.05n

.meas tran vdout0_20ck380 FIND v(dout0_20) AT=390.05n

.meas tran vdout0_21ck380 FIND v(dout0_21) AT=390.05n

.meas tran vdout0_22ck380 FIND v(dout0_22) AT=390.05n

.meas tran vdout0_23ck380 FIND v(dout0_23) AT=390.05n

.meas tran vdout0_24ck380 FIND v(dout0_24) AT=390.05n

.meas tran vdout0_25ck380 FIND v(dout0_25) AT=390.05n

.meas tran vdout0_26ck380 FIND v(dout0_26) AT=390.05n

.meas tran vdout0_27ck380 FIND v(dout0_27) AT=390.05n

.meas tran vdout0_28ck380 FIND v(dout0_28) AT=390.05n

.meas tran vdout0_29ck380 FIND v(dout0_29) AT=390.05n

.meas tran vdout0_30ck380 FIND v(dout0_30) AT=390.05n

.meas tran vdout0_31ck380 FIND v(dout0_31) AT=390.05n

.meas tran vdout0_32ck380 FIND v(dout0_32) AT=390.05n

.meas tran vdout0_33ck380 FIND v(dout0_33) AT=390.05n

.meas tran vdout0_34ck380 FIND v(dout0_34) AT=390.05n

.meas tran vdout0_35ck380 FIND v(dout0_35) AT=390.05n

.meas tran vdout0_36ck380 FIND v(dout0_36) AT=390.05n

.meas tran vdout0_37ck380 FIND v(dout0_37) AT=390.05n

.meas tran vdout0_38ck380 FIND v(dout0_38) AT=390.05n

.meas tran vdout0_39ck380 FIND v(dout0_39) AT=390.05n

.meas tran vdout0_40ck380 FIND v(dout0_40) AT=390.05n

.meas tran vdout0_41ck380 FIND v(dout0_41) AT=390.05n

.meas tran vdout0_42ck380 FIND v(dout0_42) AT=390.05n

.meas tran vdout0_43ck380 FIND v(dout0_43) AT=390.05n

.meas tran vdout0_44ck380 FIND v(dout0_44) AT=390.05n

.meas tran vdout0_45ck380 FIND v(dout0_45) AT=390.05n

.meas tran vdout0_46ck380 FIND v(dout0_46) AT=390.05n

.meas tran vdout0_47ck380 FIND v(dout0_47) AT=390.05n

.meas tran vdout0_48ck380 FIND v(dout0_48) AT=390.05n

.meas tran vdout0_49ck380 FIND v(dout0_49) AT=390.05n

.meas tran vdout0_50ck380 FIND v(dout0_50) AT=390.05n

.meas tran vdout0_51ck380 FIND v(dout0_51) AT=390.05n

.meas tran vdout0_52ck380 FIND v(dout0_52) AT=390.05n

.meas tran vdout0_53ck380 FIND v(dout0_53) AT=390.05n

.meas tran vdout0_54ck380 FIND v(dout0_54) AT=390.05n

.meas tran vdout0_55ck380 FIND v(dout0_55) AT=390.05n

.meas tran vdout0_56ck380 FIND v(dout0_56) AT=390.05n

.meas tran vdout0_57ck380 FIND v(dout0_57) AT=390.05n

.meas tran vdout0_58ck380 FIND v(dout0_58) AT=390.05n

.meas tran vdout0_59ck380 FIND v(dout0_59) AT=390.05n

.meas tran vdout0_60ck380 FIND v(dout0_60) AT=390.05n

.meas tran vdout0_61ck380 FIND v(dout0_61) AT=390.05n

.meas tran vdout0_62ck380 FIND v(dout0_62) AT=390.05n

.meas tran vdout0_63ck380 FIND v(dout0_63) AT=390.05n

.meas tran vdout0_64ck380 FIND v(dout0_64) AT=390.05n

.meas tran vdout0_0ck390 FIND v(dout0_0) AT=400.05n

.meas tran vdout0_1ck390 FIND v(dout0_1) AT=400.05n

.meas tran vdout0_2ck390 FIND v(dout0_2) AT=400.05n

.meas tran vdout0_3ck390 FIND v(dout0_3) AT=400.05n

.meas tran vdout0_4ck390 FIND v(dout0_4) AT=400.05n

.meas tran vdout0_5ck390 FIND v(dout0_5) AT=400.05n

.meas tran vdout0_6ck390 FIND v(dout0_6) AT=400.05n

.meas tran vdout0_7ck390 FIND v(dout0_7) AT=400.05n

.meas tran vdout0_8ck390 FIND v(dout0_8) AT=400.05n

.meas tran vdout0_9ck390 FIND v(dout0_9) AT=400.05n

.meas tran vdout0_10ck390 FIND v(dout0_10) AT=400.05n

.meas tran vdout0_11ck390 FIND v(dout0_11) AT=400.05n

.meas tran vdout0_12ck390 FIND v(dout0_12) AT=400.05n

.meas tran vdout0_13ck390 FIND v(dout0_13) AT=400.05n

.meas tran vdout0_14ck390 FIND v(dout0_14) AT=400.05n

.meas tran vdout0_15ck390 FIND v(dout0_15) AT=400.05n

.meas tran vdout0_16ck390 FIND v(dout0_16) AT=400.05n

.meas tran vdout0_17ck390 FIND v(dout0_17) AT=400.05n

.meas tran vdout0_18ck390 FIND v(dout0_18) AT=400.05n

.meas tran vdout0_19ck390 FIND v(dout0_19) AT=400.05n

.meas tran vdout0_20ck390 FIND v(dout0_20) AT=400.05n

.meas tran vdout0_21ck390 FIND v(dout0_21) AT=400.05n

.meas tran vdout0_22ck390 FIND v(dout0_22) AT=400.05n

.meas tran vdout0_23ck390 FIND v(dout0_23) AT=400.05n

.meas tran vdout0_24ck390 FIND v(dout0_24) AT=400.05n

.meas tran vdout0_25ck390 FIND v(dout0_25) AT=400.05n

.meas tran vdout0_26ck390 FIND v(dout0_26) AT=400.05n

.meas tran vdout0_27ck390 FIND v(dout0_27) AT=400.05n

.meas tran vdout0_28ck390 FIND v(dout0_28) AT=400.05n

.meas tran vdout0_29ck390 FIND v(dout0_29) AT=400.05n

.meas tran vdout0_30ck390 FIND v(dout0_30) AT=400.05n

.meas tran vdout0_31ck390 FIND v(dout0_31) AT=400.05n

.meas tran vdout0_32ck390 FIND v(dout0_32) AT=400.05n

.meas tran vdout0_33ck390 FIND v(dout0_33) AT=400.05n

.meas tran vdout0_34ck390 FIND v(dout0_34) AT=400.05n

.meas tran vdout0_35ck390 FIND v(dout0_35) AT=400.05n

.meas tran vdout0_36ck390 FIND v(dout0_36) AT=400.05n

.meas tran vdout0_37ck390 FIND v(dout0_37) AT=400.05n

.meas tran vdout0_38ck390 FIND v(dout0_38) AT=400.05n

.meas tran vdout0_39ck390 FIND v(dout0_39) AT=400.05n

.meas tran vdout0_40ck390 FIND v(dout0_40) AT=400.05n

.meas tran vdout0_41ck390 FIND v(dout0_41) AT=400.05n

.meas tran vdout0_42ck390 FIND v(dout0_42) AT=400.05n

.meas tran vdout0_43ck390 FIND v(dout0_43) AT=400.05n

.meas tran vdout0_44ck390 FIND v(dout0_44) AT=400.05n

.meas tran vdout0_45ck390 FIND v(dout0_45) AT=400.05n

.meas tran vdout0_46ck390 FIND v(dout0_46) AT=400.05n

.meas tran vdout0_47ck390 FIND v(dout0_47) AT=400.05n

.meas tran vdout0_48ck390 FIND v(dout0_48) AT=400.05n

.meas tran vdout0_49ck390 FIND v(dout0_49) AT=400.05n

.meas tran vdout0_50ck390 FIND v(dout0_50) AT=400.05n

.meas tran vdout0_51ck390 FIND v(dout0_51) AT=400.05n

.meas tran vdout0_52ck390 FIND v(dout0_52) AT=400.05n

.meas tran vdout0_53ck390 FIND v(dout0_53) AT=400.05n

.meas tran vdout0_54ck390 FIND v(dout0_54) AT=400.05n

.meas tran vdout0_55ck390 FIND v(dout0_55) AT=400.05n

.meas tran vdout0_56ck390 FIND v(dout0_56) AT=400.05n

.meas tran vdout0_57ck390 FIND v(dout0_57) AT=400.05n

.meas tran vdout0_58ck390 FIND v(dout0_58) AT=400.05n

.meas tran vdout0_59ck390 FIND v(dout0_59) AT=400.05n

.meas tran vdout0_60ck390 FIND v(dout0_60) AT=400.05n

.meas tran vdout0_61ck390 FIND v(dout0_61) AT=400.05n

.meas tran vdout0_62ck390 FIND v(dout0_62) AT=400.05n

.meas tran vdout0_63ck390 FIND v(dout0_63) AT=400.05n

.meas tran vdout0_64ck390 FIND v(dout0_64) AT=400.05n

.meas tran vdout0_0ck410 FIND v(dout0_0) AT=420.05n

.meas tran vdout0_1ck410 FIND v(dout0_1) AT=420.05n

.meas tran vdout0_2ck410 FIND v(dout0_2) AT=420.05n

.meas tran vdout0_3ck410 FIND v(dout0_3) AT=420.05n

.meas tran vdout0_4ck410 FIND v(dout0_4) AT=420.05n

.meas tran vdout0_5ck410 FIND v(dout0_5) AT=420.05n

.meas tran vdout0_6ck410 FIND v(dout0_6) AT=420.05n

.meas tran vdout0_7ck410 FIND v(dout0_7) AT=420.05n

.meas tran vdout0_8ck410 FIND v(dout0_8) AT=420.05n

.meas tran vdout0_9ck410 FIND v(dout0_9) AT=420.05n

.meas tran vdout0_10ck410 FIND v(dout0_10) AT=420.05n

.meas tran vdout0_11ck410 FIND v(dout0_11) AT=420.05n

.meas tran vdout0_12ck410 FIND v(dout0_12) AT=420.05n

.meas tran vdout0_13ck410 FIND v(dout0_13) AT=420.05n

.meas tran vdout0_14ck410 FIND v(dout0_14) AT=420.05n

.meas tran vdout0_15ck410 FIND v(dout0_15) AT=420.05n

.meas tran vdout0_16ck410 FIND v(dout0_16) AT=420.05n

.meas tran vdout0_17ck410 FIND v(dout0_17) AT=420.05n

.meas tran vdout0_18ck410 FIND v(dout0_18) AT=420.05n

.meas tran vdout0_19ck410 FIND v(dout0_19) AT=420.05n

.meas tran vdout0_20ck410 FIND v(dout0_20) AT=420.05n

.meas tran vdout0_21ck410 FIND v(dout0_21) AT=420.05n

.meas tran vdout0_22ck410 FIND v(dout0_22) AT=420.05n

.meas tran vdout0_23ck410 FIND v(dout0_23) AT=420.05n

.meas tran vdout0_24ck410 FIND v(dout0_24) AT=420.05n

.meas tran vdout0_25ck410 FIND v(dout0_25) AT=420.05n

.meas tran vdout0_26ck410 FIND v(dout0_26) AT=420.05n

.meas tran vdout0_27ck410 FIND v(dout0_27) AT=420.05n

.meas tran vdout0_28ck410 FIND v(dout0_28) AT=420.05n

.meas tran vdout0_29ck410 FIND v(dout0_29) AT=420.05n

.meas tran vdout0_30ck410 FIND v(dout0_30) AT=420.05n

.meas tran vdout0_31ck410 FIND v(dout0_31) AT=420.05n

.meas tran vdout0_32ck410 FIND v(dout0_32) AT=420.05n

.meas tran vdout0_33ck410 FIND v(dout0_33) AT=420.05n

.meas tran vdout0_34ck410 FIND v(dout0_34) AT=420.05n

.meas tran vdout0_35ck410 FIND v(dout0_35) AT=420.05n

.meas tran vdout0_36ck410 FIND v(dout0_36) AT=420.05n

.meas tran vdout0_37ck410 FIND v(dout0_37) AT=420.05n

.meas tran vdout0_38ck410 FIND v(dout0_38) AT=420.05n

.meas tran vdout0_39ck410 FIND v(dout0_39) AT=420.05n

.meas tran vdout0_40ck410 FIND v(dout0_40) AT=420.05n

.meas tran vdout0_41ck410 FIND v(dout0_41) AT=420.05n

.meas tran vdout0_42ck410 FIND v(dout0_42) AT=420.05n

.meas tran vdout0_43ck410 FIND v(dout0_43) AT=420.05n

.meas tran vdout0_44ck410 FIND v(dout0_44) AT=420.05n

.meas tran vdout0_45ck410 FIND v(dout0_45) AT=420.05n

.meas tran vdout0_46ck410 FIND v(dout0_46) AT=420.05n

.meas tran vdout0_47ck410 FIND v(dout0_47) AT=420.05n

.meas tran vdout0_48ck410 FIND v(dout0_48) AT=420.05n

.meas tran vdout0_49ck410 FIND v(dout0_49) AT=420.05n

.meas tran vdout0_50ck410 FIND v(dout0_50) AT=420.05n

.meas tran vdout0_51ck410 FIND v(dout0_51) AT=420.05n

.meas tran vdout0_52ck410 FIND v(dout0_52) AT=420.05n

.meas tran vdout0_53ck410 FIND v(dout0_53) AT=420.05n

.meas tran vdout0_54ck410 FIND v(dout0_54) AT=420.05n

.meas tran vdout0_55ck410 FIND v(dout0_55) AT=420.05n

.meas tran vdout0_56ck410 FIND v(dout0_56) AT=420.05n

.meas tran vdout0_57ck410 FIND v(dout0_57) AT=420.05n

.meas tran vdout0_58ck410 FIND v(dout0_58) AT=420.05n

.meas tran vdout0_59ck410 FIND v(dout0_59) AT=420.05n

.meas tran vdout0_60ck410 FIND v(dout0_60) AT=420.05n

.meas tran vdout0_61ck410 FIND v(dout0_61) AT=420.05n

.meas tran vdout0_62ck410 FIND v(dout0_62) AT=420.05n

.meas tran vdout0_63ck410 FIND v(dout0_63) AT=420.05n

.meas tran vdout0_64ck410 FIND v(dout0_64) AT=420.05n

.meas tran vdout0_0ck430 FIND v(dout0_0) AT=440.05n

.meas tran vdout0_1ck430 FIND v(dout0_1) AT=440.05n

.meas tran vdout0_2ck430 FIND v(dout0_2) AT=440.05n

.meas tran vdout0_3ck430 FIND v(dout0_3) AT=440.05n

.meas tran vdout0_4ck430 FIND v(dout0_4) AT=440.05n

.meas tran vdout0_5ck430 FIND v(dout0_5) AT=440.05n

.meas tran vdout0_6ck430 FIND v(dout0_6) AT=440.05n

.meas tran vdout0_7ck430 FIND v(dout0_7) AT=440.05n

.meas tran vdout0_8ck430 FIND v(dout0_8) AT=440.05n

.meas tran vdout0_9ck430 FIND v(dout0_9) AT=440.05n

.meas tran vdout0_10ck430 FIND v(dout0_10) AT=440.05n

.meas tran vdout0_11ck430 FIND v(dout0_11) AT=440.05n

.meas tran vdout0_12ck430 FIND v(dout0_12) AT=440.05n

.meas tran vdout0_13ck430 FIND v(dout0_13) AT=440.05n

.meas tran vdout0_14ck430 FIND v(dout0_14) AT=440.05n

.meas tran vdout0_15ck430 FIND v(dout0_15) AT=440.05n

.meas tran vdout0_16ck430 FIND v(dout0_16) AT=440.05n

.meas tran vdout0_17ck430 FIND v(dout0_17) AT=440.05n

.meas tran vdout0_18ck430 FIND v(dout0_18) AT=440.05n

.meas tran vdout0_19ck430 FIND v(dout0_19) AT=440.05n

.meas tran vdout0_20ck430 FIND v(dout0_20) AT=440.05n

.meas tran vdout0_21ck430 FIND v(dout0_21) AT=440.05n

.meas tran vdout0_22ck430 FIND v(dout0_22) AT=440.05n

.meas tran vdout0_23ck430 FIND v(dout0_23) AT=440.05n

.meas tran vdout0_24ck430 FIND v(dout0_24) AT=440.05n

.meas tran vdout0_25ck430 FIND v(dout0_25) AT=440.05n

.meas tran vdout0_26ck430 FIND v(dout0_26) AT=440.05n

.meas tran vdout0_27ck430 FIND v(dout0_27) AT=440.05n

.meas tran vdout0_28ck430 FIND v(dout0_28) AT=440.05n

.meas tran vdout0_29ck430 FIND v(dout0_29) AT=440.05n

.meas tran vdout0_30ck430 FIND v(dout0_30) AT=440.05n

.meas tran vdout0_31ck430 FIND v(dout0_31) AT=440.05n

.meas tran vdout0_32ck430 FIND v(dout0_32) AT=440.05n

.meas tran vdout0_33ck430 FIND v(dout0_33) AT=440.05n

.meas tran vdout0_34ck430 FIND v(dout0_34) AT=440.05n

.meas tran vdout0_35ck430 FIND v(dout0_35) AT=440.05n

.meas tran vdout0_36ck430 FIND v(dout0_36) AT=440.05n

.meas tran vdout0_37ck430 FIND v(dout0_37) AT=440.05n

.meas tran vdout0_38ck430 FIND v(dout0_38) AT=440.05n

.meas tran vdout0_39ck430 FIND v(dout0_39) AT=440.05n

.meas tran vdout0_40ck430 FIND v(dout0_40) AT=440.05n

.meas tran vdout0_41ck430 FIND v(dout0_41) AT=440.05n

.meas tran vdout0_42ck430 FIND v(dout0_42) AT=440.05n

.meas tran vdout0_43ck430 FIND v(dout0_43) AT=440.05n

.meas tran vdout0_44ck430 FIND v(dout0_44) AT=440.05n

.meas tran vdout0_45ck430 FIND v(dout0_45) AT=440.05n

.meas tran vdout0_46ck430 FIND v(dout0_46) AT=440.05n

.meas tran vdout0_47ck430 FIND v(dout0_47) AT=440.05n

.meas tran vdout0_48ck430 FIND v(dout0_48) AT=440.05n

.meas tran vdout0_49ck430 FIND v(dout0_49) AT=440.05n

.meas tran vdout0_50ck430 FIND v(dout0_50) AT=440.05n

.meas tran vdout0_51ck430 FIND v(dout0_51) AT=440.05n

.meas tran vdout0_52ck430 FIND v(dout0_52) AT=440.05n

.meas tran vdout0_53ck430 FIND v(dout0_53) AT=440.05n

.meas tran vdout0_54ck430 FIND v(dout0_54) AT=440.05n

.meas tran vdout0_55ck430 FIND v(dout0_55) AT=440.05n

.meas tran vdout0_56ck430 FIND v(dout0_56) AT=440.05n

.meas tran vdout0_57ck430 FIND v(dout0_57) AT=440.05n

.meas tran vdout0_58ck430 FIND v(dout0_58) AT=440.05n

.meas tran vdout0_59ck430 FIND v(dout0_59) AT=440.05n

.meas tran vdout0_60ck430 FIND v(dout0_60) AT=440.05n

.meas tran vdout0_61ck430 FIND v(dout0_61) AT=440.05n

.meas tran vdout0_62ck430 FIND v(dout0_62) AT=440.05n

.meas tran vdout0_63ck430 FIND v(dout0_63) AT=440.05n

.meas tran vdout0_64ck430 FIND v(dout0_64) AT=440.05n

.meas tran vdout0_0ck490 FIND v(dout0_0) AT=500.05n

.meas tran vdout0_1ck490 FIND v(dout0_1) AT=500.05n

.meas tran vdout0_2ck490 FIND v(dout0_2) AT=500.05n

.meas tran vdout0_3ck490 FIND v(dout0_3) AT=500.05n

.meas tran vdout0_4ck490 FIND v(dout0_4) AT=500.05n

.meas tran vdout0_5ck490 FIND v(dout0_5) AT=500.05n

.meas tran vdout0_6ck490 FIND v(dout0_6) AT=500.05n

.meas tran vdout0_7ck490 FIND v(dout0_7) AT=500.05n

.meas tran vdout0_8ck490 FIND v(dout0_8) AT=500.05n

.meas tran vdout0_9ck490 FIND v(dout0_9) AT=500.05n

.meas tran vdout0_10ck490 FIND v(dout0_10) AT=500.05n

.meas tran vdout0_11ck490 FIND v(dout0_11) AT=500.05n

.meas tran vdout0_12ck490 FIND v(dout0_12) AT=500.05n

.meas tran vdout0_13ck490 FIND v(dout0_13) AT=500.05n

.meas tran vdout0_14ck490 FIND v(dout0_14) AT=500.05n

.meas tran vdout0_15ck490 FIND v(dout0_15) AT=500.05n

.meas tran vdout0_16ck490 FIND v(dout0_16) AT=500.05n

.meas tran vdout0_17ck490 FIND v(dout0_17) AT=500.05n

.meas tran vdout0_18ck490 FIND v(dout0_18) AT=500.05n

.meas tran vdout0_19ck490 FIND v(dout0_19) AT=500.05n

.meas tran vdout0_20ck490 FIND v(dout0_20) AT=500.05n

.meas tran vdout0_21ck490 FIND v(dout0_21) AT=500.05n

.meas tran vdout0_22ck490 FIND v(dout0_22) AT=500.05n

.meas tran vdout0_23ck490 FIND v(dout0_23) AT=500.05n

.meas tran vdout0_24ck490 FIND v(dout0_24) AT=500.05n

.meas tran vdout0_25ck490 FIND v(dout0_25) AT=500.05n

.meas tran vdout0_26ck490 FIND v(dout0_26) AT=500.05n

.meas tran vdout0_27ck490 FIND v(dout0_27) AT=500.05n

.meas tran vdout0_28ck490 FIND v(dout0_28) AT=500.05n

.meas tran vdout0_29ck490 FIND v(dout0_29) AT=500.05n

.meas tran vdout0_30ck490 FIND v(dout0_30) AT=500.05n

.meas tran vdout0_31ck490 FIND v(dout0_31) AT=500.05n

.meas tran vdout0_32ck490 FIND v(dout0_32) AT=500.05n

.meas tran vdout0_33ck490 FIND v(dout0_33) AT=500.05n

.meas tran vdout0_34ck490 FIND v(dout0_34) AT=500.05n

.meas tran vdout0_35ck490 FIND v(dout0_35) AT=500.05n

.meas tran vdout0_36ck490 FIND v(dout0_36) AT=500.05n

.meas tran vdout0_37ck490 FIND v(dout0_37) AT=500.05n

.meas tran vdout0_38ck490 FIND v(dout0_38) AT=500.05n

.meas tran vdout0_39ck490 FIND v(dout0_39) AT=500.05n

.meas tran vdout0_40ck490 FIND v(dout0_40) AT=500.05n

.meas tran vdout0_41ck490 FIND v(dout0_41) AT=500.05n

.meas tran vdout0_42ck490 FIND v(dout0_42) AT=500.05n

.meas tran vdout0_43ck490 FIND v(dout0_43) AT=500.05n

.meas tran vdout0_44ck490 FIND v(dout0_44) AT=500.05n

.meas tran vdout0_45ck490 FIND v(dout0_45) AT=500.05n

.meas tran vdout0_46ck490 FIND v(dout0_46) AT=500.05n

.meas tran vdout0_47ck490 FIND v(dout0_47) AT=500.05n

.meas tran vdout0_48ck490 FIND v(dout0_48) AT=500.05n

.meas tran vdout0_49ck490 FIND v(dout0_49) AT=500.05n

.meas tran vdout0_50ck490 FIND v(dout0_50) AT=500.05n

.meas tran vdout0_51ck490 FIND v(dout0_51) AT=500.05n

.meas tran vdout0_52ck490 FIND v(dout0_52) AT=500.05n

.meas tran vdout0_53ck490 FIND v(dout0_53) AT=500.05n

.meas tran vdout0_54ck490 FIND v(dout0_54) AT=500.05n

.meas tran vdout0_55ck490 FIND v(dout0_55) AT=500.05n

.meas tran vdout0_56ck490 FIND v(dout0_56) AT=500.05n

.meas tran vdout0_57ck490 FIND v(dout0_57) AT=500.05n

.meas tran vdout0_58ck490 FIND v(dout0_58) AT=500.05n

.meas tran vdout0_59ck490 FIND v(dout0_59) AT=500.05n

.meas tran vdout0_60ck490 FIND v(dout0_60) AT=500.05n

.meas tran vdout0_61ck490 FIND v(dout0_61) AT=500.05n

.meas tran vdout0_62ck490 FIND v(dout0_62) AT=500.05n

.meas tran vdout0_63ck490 FIND v(dout0_63) AT=500.05n

.meas tran vdout0_64ck490 FIND v(dout0_64) AT=500.05n

.meas tran vdout0_0ck510 FIND v(dout0_0) AT=520.05n

.meas tran vdout0_1ck510 FIND v(dout0_1) AT=520.05n

.meas tran vdout0_2ck510 FIND v(dout0_2) AT=520.05n

.meas tran vdout0_3ck510 FIND v(dout0_3) AT=520.05n

.meas tran vdout0_4ck510 FIND v(dout0_4) AT=520.05n

.meas tran vdout0_5ck510 FIND v(dout0_5) AT=520.05n

.meas tran vdout0_6ck510 FIND v(dout0_6) AT=520.05n

.meas tran vdout0_7ck510 FIND v(dout0_7) AT=520.05n

.meas tran vdout0_8ck510 FIND v(dout0_8) AT=520.05n

.meas tran vdout0_9ck510 FIND v(dout0_9) AT=520.05n

.meas tran vdout0_10ck510 FIND v(dout0_10) AT=520.05n

.meas tran vdout0_11ck510 FIND v(dout0_11) AT=520.05n

.meas tran vdout0_12ck510 FIND v(dout0_12) AT=520.05n

.meas tran vdout0_13ck510 FIND v(dout0_13) AT=520.05n

.meas tran vdout0_14ck510 FIND v(dout0_14) AT=520.05n

.meas tran vdout0_15ck510 FIND v(dout0_15) AT=520.05n

.meas tran vdout0_16ck510 FIND v(dout0_16) AT=520.05n

.meas tran vdout0_17ck510 FIND v(dout0_17) AT=520.05n

.meas tran vdout0_18ck510 FIND v(dout0_18) AT=520.05n

.meas tran vdout0_19ck510 FIND v(dout0_19) AT=520.05n

.meas tran vdout0_20ck510 FIND v(dout0_20) AT=520.05n

.meas tran vdout0_21ck510 FIND v(dout0_21) AT=520.05n

.meas tran vdout0_22ck510 FIND v(dout0_22) AT=520.05n

.meas tran vdout0_23ck510 FIND v(dout0_23) AT=520.05n

.meas tran vdout0_24ck510 FIND v(dout0_24) AT=520.05n

.meas tran vdout0_25ck510 FIND v(dout0_25) AT=520.05n

.meas tran vdout0_26ck510 FIND v(dout0_26) AT=520.05n

.meas tran vdout0_27ck510 FIND v(dout0_27) AT=520.05n

.meas tran vdout0_28ck510 FIND v(dout0_28) AT=520.05n

.meas tran vdout0_29ck510 FIND v(dout0_29) AT=520.05n

.meas tran vdout0_30ck510 FIND v(dout0_30) AT=520.05n

.meas tran vdout0_31ck510 FIND v(dout0_31) AT=520.05n

.meas tran vdout0_32ck510 FIND v(dout0_32) AT=520.05n

.meas tran vdout0_33ck510 FIND v(dout0_33) AT=520.05n

.meas tran vdout0_34ck510 FIND v(dout0_34) AT=520.05n

.meas tran vdout0_35ck510 FIND v(dout0_35) AT=520.05n

.meas tran vdout0_36ck510 FIND v(dout0_36) AT=520.05n

.meas tran vdout0_37ck510 FIND v(dout0_37) AT=520.05n

.meas tran vdout0_38ck510 FIND v(dout0_38) AT=520.05n

.meas tran vdout0_39ck510 FIND v(dout0_39) AT=520.05n

.meas tran vdout0_40ck510 FIND v(dout0_40) AT=520.05n

.meas tran vdout0_41ck510 FIND v(dout0_41) AT=520.05n

.meas tran vdout0_42ck510 FIND v(dout0_42) AT=520.05n

.meas tran vdout0_43ck510 FIND v(dout0_43) AT=520.05n

.meas tran vdout0_44ck510 FIND v(dout0_44) AT=520.05n

.meas tran vdout0_45ck510 FIND v(dout0_45) AT=520.05n

.meas tran vdout0_46ck510 FIND v(dout0_46) AT=520.05n

.meas tran vdout0_47ck510 FIND v(dout0_47) AT=520.05n

.meas tran vdout0_48ck510 FIND v(dout0_48) AT=520.05n

.meas tran vdout0_49ck510 FIND v(dout0_49) AT=520.05n

.meas tran vdout0_50ck510 FIND v(dout0_50) AT=520.05n

.meas tran vdout0_51ck510 FIND v(dout0_51) AT=520.05n

.meas tran vdout0_52ck510 FIND v(dout0_52) AT=520.05n

.meas tran vdout0_53ck510 FIND v(dout0_53) AT=520.05n

.meas tran vdout0_54ck510 FIND v(dout0_54) AT=520.05n

.meas tran vdout0_55ck510 FIND v(dout0_55) AT=520.05n

.meas tran vdout0_56ck510 FIND v(dout0_56) AT=520.05n

.meas tran vdout0_57ck510 FIND v(dout0_57) AT=520.05n

.meas tran vdout0_58ck510 FIND v(dout0_58) AT=520.05n

.meas tran vdout0_59ck510 FIND v(dout0_59) AT=520.05n

.meas tran vdout0_60ck510 FIND v(dout0_60) AT=520.05n

.meas tran vdout0_61ck510 FIND v(dout0_61) AT=520.05n

.meas tran vdout0_62ck510 FIND v(dout0_62) AT=520.05n

.meas tran vdout0_63ck510 FIND v(dout0_63) AT=520.05n

.meas tran vdout0_64ck510 FIND v(dout0_64) AT=520.05n

.meas tran vdout0_0ck530 FIND v(dout0_0) AT=540.05n

.meas tran vdout0_1ck530 FIND v(dout0_1) AT=540.05n

.meas tran vdout0_2ck530 FIND v(dout0_2) AT=540.05n

.meas tran vdout0_3ck530 FIND v(dout0_3) AT=540.05n

.meas tran vdout0_4ck530 FIND v(dout0_4) AT=540.05n

.meas tran vdout0_5ck530 FIND v(dout0_5) AT=540.05n

.meas tran vdout0_6ck530 FIND v(dout0_6) AT=540.05n

.meas tran vdout0_7ck530 FIND v(dout0_7) AT=540.05n

.meas tran vdout0_8ck530 FIND v(dout0_8) AT=540.05n

.meas tran vdout0_9ck530 FIND v(dout0_9) AT=540.05n

.meas tran vdout0_10ck530 FIND v(dout0_10) AT=540.05n

.meas tran vdout0_11ck530 FIND v(dout0_11) AT=540.05n

.meas tran vdout0_12ck530 FIND v(dout0_12) AT=540.05n

.meas tran vdout0_13ck530 FIND v(dout0_13) AT=540.05n

.meas tran vdout0_14ck530 FIND v(dout0_14) AT=540.05n

.meas tran vdout0_15ck530 FIND v(dout0_15) AT=540.05n

.meas tran vdout0_16ck530 FIND v(dout0_16) AT=540.05n

.meas tran vdout0_17ck530 FIND v(dout0_17) AT=540.05n

.meas tran vdout0_18ck530 FIND v(dout0_18) AT=540.05n

.meas tran vdout0_19ck530 FIND v(dout0_19) AT=540.05n

.meas tran vdout0_20ck530 FIND v(dout0_20) AT=540.05n

.meas tran vdout0_21ck530 FIND v(dout0_21) AT=540.05n

.meas tran vdout0_22ck530 FIND v(dout0_22) AT=540.05n

.meas tran vdout0_23ck530 FIND v(dout0_23) AT=540.05n

.meas tran vdout0_24ck530 FIND v(dout0_24) AT=540.05n

.meas tran vdout0_25ck530 FIND v(dout0_25) AT=540.05n

.meas tran vdout0_26ck530 FIND v(dout0_26) AT=540.05n

.meas tran vdout0_27ck530 FIND v(dout0_27) AT=540.05n

.meas tran vdout0_28ck530 FIND v(dout0_28) AT=540.05n

.meas tran vdout0_29ck530 FIND v(dout0_29) AT=540.05n

.meas tran vdout0_30ck530 FIND v(dout0_30) AT=540.05n

.meas tran vdout0_31ck530 FIND v(dout0_31) AT=540.05n

.meas tran vdout0_32ck530 FIND v(dout0_32) AT=540.05n

.meas tran vdout0_33ck530 FIND v(dout0_33) AT=540.05n

.meas tran vdout0_34ck530 FIND v(dout0_34) AT=540.05n

.meas tran vdout0_35ck530 FIND v(dout0_35) AT=540.05n

.meas tran vdout0_36ck530 FIND v(dout0_36) AT=540.05n

.meas tran vdout0_37ck530 FIND v(dout0_37) AT=540.05n

.meas tran vdout0_38ck530 FIND v(dout0_38) AT=540.05n

.meas tran vdout0_39ck530 FIND v(dout0_39) AT=540.05n

.meas tran vdout0_40ck530 FIND v(dout0_40) AT=540.05n

.meas tran vdout0_41ck530 FIND v(dout0_41) AT=540.05n

.meas tran vdout0_42ck530 FIND v(dout0_42) AT=540.05n

.meas tran vdout0_43ck530 FIND v(dout0_43) AT=540.05n

.meas tran vdout0_44ck530 FIND v(dout0_44) AT=540.05n

.meas tran vdout0_45ck530 FIND v(dout0_45) AT=540.05n

.meas tran vdout0_46ck530 FIND v(dout0_46) AT=540.05n

.meas tran vdout0_47ck530 FIND v(dout0_47) AT=540.05n

.meas tran vdout0_48ck530 FIND v(dout0_48) AT=540.05n

.meas tran vdout0_49ck530 FIND v(dout0_49) AT=540.05n

.meas tran vdout0_50ck530 FIND v(dout0_50) AT=540.05n

.meas tran vdout0_51ck530 FIND v(dout0_51) AT=540.05n

.meas tran vdout0_52ck530 FIND v(dout0_52) AT=540.05n

.meas tran vdout0_53ck530 FIND v(dout0_53) AT=540.05n

.meas tran vdout0_54ck530 FIND v(dout0_54) AT=540.05n

.meas tran vdout0_55ck530 FIND v(dout0_55) AT=540.05n

.meas tran vdout0_56ck530 FIND v(dout0_56) AT=540.05n

.meas tran vdout0_57ck530 FIND v(dout0_57) AT=540.05n

.meas tran vdout0_58ck530 FIND v(dout0_58) AT=540.05n

.meas tran vdout0_59ck530 FIND v(dout0_59) AT=540.05n

.meas tran vdout0_60ck530 FIND v(dout0_60) AT=540.05n

.meas tran vdout0_61ck530 FIND v(dout0_61) AT=540.05n

.meas tran vdout0_62ck530 FIND v(dout0_62) AT=540.05n

.meas tran vdout0_63ck530 FIND v(dout0_63) AT=540.05n

.meas tran vdout0_64ck530 FIND v(dout0_64) AT=540.05n

.meas tran vdout0_0ck550 FIND v(dout0_0) AT=560.05n

.meas tran vdout0_1ck550 FIND v(dout0_1) AT=560.05n

.meas tran vdout0_2ck550 FIND v(dout0_2) AT=560.05n

.meas tran vdout0_3ck550 FIND v(dout0_3) AT=560.05n

.meas tran vdout0_4ck550 FIND v(dout0_4) AT=560.05n

.meas tran vdout0_5ck550 FIND v(dout0_5) AT=560.05n

.meas tran vdout0_6ck550 FIND v(dout0_6) AT=560.05n

.meas tran vdout0_7ck550 FIND v(dout0_7) AT=560.05n

.meas tran vdout0_8ck550 FIND v(dout0_8) AT=560.05n

.meas tran vdout0_9ck550 FIND v(dout0_9) AT=560.05n

.meas tran vdout0_10ck550 FIND v(dout0_10) AT=560.05n

.meas tran vdout0_11ck550 FIND v(dout0_11) AT=560.05n

.meas tran vdout0_12ck550 FIND v(dout0_12) AT=560.05n

.meas tran vdout0_13ck550 FIND v(dout0_13) AT=560.05n

.meas tran vdout0_14ck550 FIND v(dout0_14) AT=560.05n

.meas tran vdout0_15ck550 FIND v(dout0_15) AT=560.05n

.meas tran vdout0_16ck550 FIND v(dout0_16) AT=560.05n

.meas tran vdout0_17ck550 FIND v(dout0_17) AT=560.05n

.meas tran vdout0_18ck550 FIND v(dout0_18) AT=560.05n

.meas tran vdout0_19ck550 FIND v(dout0_19) AT=560.05n

.meas tran vdout0_20ck550 FIND v(dout0_20) AT=560.05n

.meas tran vdout0_21ck550 FIND v(dout0_21) AT=560.05n

.meas tran vdout0_22ck550 FIND v(dout0_22) AT=560.05n

.meas tran vdout0_23ck550 FIND v(dout0_23) AT=560.05n

.meas tran vdout0_24ck550 FIND v(dout0_24) AT=560.05n

.meas tran vdout0_25ck550 FIND v(dout0_25) AT=560.05n

.meas tran vdout0_26ck550 FIND v(dout0_26) AT=560.05n

.meas tran vdout0_27ck550 FIND v(dout0_27) AT=560.05n

.meas tran vdout0_28ck550 FIND v(dout0_28) AT=560.05n

.meas tran vdout0_29ck550 FIND v(dout0_29) AT=560.05n

.meas tran vdout0_30ck550 FIND v(dout0_30) AT=560.05n

.meas tran vdout0_31ck550 FIND v(dout0_31) AT=560.05n

.meas tran vdout0_32ck550 FIND v(dout0_32) AT=560.05n

.meas tran vdout0_33ck550 FIND v(dout0_33) AT=560.05n

.meas tran vdout0_34ck550 FIND v(dout0_34) AT=560.05n

.meas tran vdout0_35ck550 FIND v(dout0_35) AT=560.05n

.meas tran vdout0_36ck550 FIND v(dout0_36) AT=560.05n

.meas tran vdout0_37ck550 FIND v(dout0_37) AT=560.05n

.meas tran vdout0_38ck550 FIND v(dout0_38) AT=560.05n

.meas tran vdout0_39ck550 FIND v(dout0_39) AT=560.05n

.meas tran vdout0_40ck550 FIND v(dout0_40) AT=560.05n

.meas tran vdout0_41ck550 FIND v(dout0_41) AT=560.05n

.meas tran vdout0_42ck550 FIND v(dout0_42) AT=560.05n

.meas tran vdout0_43ck550 FIND v(dout0_43) AT=560.05n

.meas tran vdout0_44ck550 FIND v(dout0_44) AT=560.05n

.meas tran vdout0_45ck550 FIND v(dout0_45) AT=560.05n

.meas tran vdout0_46ck550 FIND v(dout0_46) AT=560.05n

.meas tran vdout0_47ck550 FIND v(dout0_47) AT=560.05n

.meas tran vdout0_48ck550 FIND v(dout0_48) AT=560.05n

.meas tran vdout0_49ck550 FIND v(dout0_49) AT=560.05n

.meas tran vdout0_50ck550 FIND v(dout0_50) AT=560.05n

.meas tran vdout0_51ck550 FIND v(dout0_51) AT=560.05n

.meas tran vdout0_52ck550 FIND v(dout0_52) AT=560.05n

.meas tran vdout0_53ck550 FIND v(dout0_53) AT=560.05n

.meas tran vdout0_54ck550 FIND v(dout0_54) AT=560.05n

.meas tran vdout0_55ck550 FIND v(dout0_55) AT=560.05n

.meas tran vdout0_56ck550 FIND v(dout0_56) AT=560.05n

.meas tran vdout0_57ck550 FIND v(dout0_57) AT=560.05n

.meas tran vdout0_58ck550 FIND v(dout0_58) AT=560.05n

.meas tran vdout0_59ck550 FIND v(dout0_59) AT=560.05n

.meas tran vdout0_60ck550 FIND v(dout0_60) AT=560.05n

.meas tran vdout0_61ck550 FIND v(dout0_61) AT=560.05n

.meas tran vdout0_62ck550 FIND v(dout0_62) AT=560.05n

.meas tran vdout0_63ck550 FIND v(dout0_63) AT=560.05n

.meas tran vdout0_64ck550 FIND v(dout0_64) AT=560.05n

.meas tran vdout0_0ck590 FIND v(dout0_0) AT=600.05n

.meas tran vdout0_1ck590 FIND v(dout0_1) AT=600.05n

.meas tran vdout0_2ck590 FIND v(dout0_2) AT=600.05n

.meas tran vdout0_3ck590 FIND v(dout0_3) AT=600.05n

.meas tran vdout0_4ck590 FIND v(dout0_4) AT=600.05n

.meas tran vdout0_5ck590 FIND v(dout0_5) AT=600.05n

.meas tran vdout0_6ck590 FIND v(dout0_6) AT=600.05n

.meas tran vdout0_7ck590 FIND v(dout0_7) AT=600.05n

.meas tran vdout0_8ck590 FIND v(dout0_8) AT=600.05n

.meas tran vdout0_9ck590 FIND v(dout0_9) AT=600.05n

.meas tran vdout0_10ck590 FIND v(dout0_10) AT=600.05n

.meas tran vdout0_11ck590 FIND v(dout0_11) AT=600.05n

.meas tran vdout0_12ck590 FIND v(dout0_12) AT=600.05n

.meas tran vdout0_13ck590 FIND v(dout0_13) AT=600.05n

.meas tran vdout0_14ck590 FIND v(dout0_14) AT=600.05n

.meas tran vdout0_15ck590 FIND v(dout0_15) AT=600.05n

.meas tran vdout0_16ck590 FIND v(dout0_16) AT=600.05n

.meas tran vdout0_17ck590 FIND v(dout0_17) AT=600.05n

.meas tran vdout0_18ck590 FIND v(dout0_18) AT=600.05n

.meas tran vdout0_19ck590 FIND v(dout0_19) AT=600.05n

.meas tran vdout0_20ck590 FIND v(dout0_20) AT=600.05n

.meas tran vdout0_21ck590 FIND v(dout0_21) AT=600.05n

.meas tran vdout0_22ck590 FIND v(dout0_22) AT=600.05n

.meas tran vdout0_23ck590 FIND v(dout0_23) AT=600.05n

.meas tran vdout0_24ck590 FIND v(dout0_24) AT=600.05n

.meas tran vdout0_25ck590 FIND v(dout0_25) AT=600.05n

.meas tran vdout0_26ck590 FIND v(dout0_26) AT=600.05n

.meas tran vdout0_27ck590 FIND v(dout0_27) AT=600.05n

.meas tran vdout0_28ck590 FIND v(dout0_28) AT=600.05n

.meas tran vdout0_29ck590 FIND v(dout0_29) AT=600.05n

.meas tran vdout0_30ck590 FIND v(dout0_30) AT=600.05n

.meas tran vdout0_31ck590 FIND v(dout0_31) AT=600.05n

.meas tran vdout0_32ck590 FIND v(dout0_32) AT=600.05n

.meas tran vdout0_33ck590 FIND v(dout0_33) AT=600.05n

.meas tran vdout0_34ck590 FIND v(dout0_34) AT=600.05n

.meas tran vdout0_35ck590 FIND v(dout0_35) AT=600.05n

.meas tran vdout0_36ck590 FIND v(dout0_36) AT=600.05n

.meas tran vdout0_37ck590 FIND v(dout0_37) AT=600.05n

.meas tran vdout0_38ck590 FIND v(dout0_38) AT=600.05n

.meas tran vdout0_39ck590 FIND v(dout0_39) AT=600.05n

.meas tran vdout0_40ck590 FIND v(dout0_40) AT=600.05n

.meas tran vdout0_41ck590 FIND v(dout0_41) AT=600.05n

.meas tran vdout0_42ck590 FIND v(dout0_42) AT=600.05n

.meas tran vdout0_43ck590 FIND v(dout0_43) AT=600.05n

.meas tran vdout0_44ck590 FIND v(dout0_44) AT=600.05n

.meas tran vdout0_45ck590 FIND v(dout0_45) AT=600.05n

.meas tran vdout0_46ck590 FIND v(dout0_46) AT=600.05n

.meas tran vdout0_47ck590 FIND v(dout0_47) AT=600.05n

.meas tran vdout0_48ck590 FIND v(dout0_48) AT=600.05n

.meas tran vdout0_49ck590 FIND v(dout0_49) AT=600.05n

.meas tran vdout0_50ck590 FIND v(dout0_50) AT=600.05n

.meas tran vdout0_51ck590 FIND v(dout0_51) AT=600.05n

.meas tran vdout0_52ck590 FIND v(dout0_52) AT=600.05n

.meas tran vdout0_53ck590 FIND v(dout0_53) AT=600.05n

.meas tran vdout0_54ck590 FIND v(dout0_54) AT=600.05n

.meas tran vdout0_55ck590 FIND v(dout0_55) AT=600.05n

.meas tran vdout0_56ck590 FIND v(dout0_56) AT=600.05n

.meas tran vdout0_57ck590 FIND v(dout0_57) AT=600.05n

.meas tran vdout0_58ck590 FIND v(dout0_58) AT=600.05n

.meas tran vdout0_59ck590 FIND v(dout0_59) AT=600.05n

.meas tran vdout0_60ck590 FIND v(dout0_60) AT=600.05n

.meas tran vdout0_61ck590 FIND v(dout0_61) AT=600.05n

.meas tran vdout0_62ck590 FIND v(dout0_62) AT=600.05n

.meas tran vdout0_63ck590 FIND v(dout0_63) AT=600.05n

.meas tran vdout0_64ck590 FIND v(dout0_64) AT=600.05n

.meas tran vdout0_0ck610 FIND v(dout0_0) AT=620.05n

.meas tran vdout0_1ck610 FIND v(dout0_1) AT=620.05n

.meas tran vdout0_2ck610 FIND v(dout0_2) AT=620.05n

.meas tran vdout0_3ck610 FIND v(dout0_3) AT=620.05n

.meas tran vdout0_4ck610 FIND v(dout0_4) AT=620.05n

.meas tran vdout0_5ck610 FIND v(dout0_5) AT=620.05n

.meas tran vdout0_6ck610 FIND v(dout0_6) AT=620.05n

.meas tran vdout0_7ck610 FIND v(dout0_7) AT=620.05n

.meas tran vdout0_8ck610 FIND v(dout0_8) AT=620.05n

.meas tran vdout0_9ck610 FIND v(dout0_9) AT=620.05n

.meas tran vdout0_10ck610 FIND v(dout0_10) AT=620.05n

.meas tran vdout0_11ck610 FIND v(dout0_11) AT=620.05n

.meas tran vdout0_12ck610 FIND v(dout0_12) AT=620.05n

.meas tran vdout0_13ck610 FIND v(dout0_13) AT=620.05n

.meas tran vdout0_14ck610 FIND v(dout0_14) AT=620.05n

.meas tran vdout0_15ck610 FIND v(dout0_15) AT=620.05n

.meas tran vdout0_16ck610 FIND v(dout0_16) AT=620.05n

.meas tran vdout0_17ck610 FIND v(dout0_17) AT=620.05n

.meas tran vdout0_18ck610 FIND v(dout0_18) AT=620.05n

.meas tran vdout0_19ck610 FIND v(dout0_19) AT=620.05n

.meas tran vdout0_20ck610 FIND v(dout0_20) AT=620.05n

.meas tran vdout0_21ck610 FIND v(dout0_21) AT=620.05n

.meas tran vdout0_22ck610 FIND v(dout0_22) AT=620.05n

.meas tran vdout0_23ck610 FIND v(dout0_23) AT=620.05n

.meas tran vdout0_24ck610 FIND v(dout0_24) AT=620.05n

.meas tran vdout0_25ck610 FIND v(dout0_25) AT=620.05n

.meas tran vdout0_26ck610 FIND v(dout0_26) AT=620.05n

.meas tran vdout0_27ck610 FIND v(dout0_27) AT=620.05n

.meas tran vdout0_28ck610 FIND v(dout0_28) AT=620.05n

.meas tran vdout0_29ck610 FIND v(dout0_29) AT=620.05n

.meas tran vdout0_30ck610 FIND v(dout0_30) AT=620.05n

.meas tran vdout0_31ck610 FIND v(dout0_31) AT=620.05n

.meas tran vdout0_32ck610 FIND v(dout0_32) AT=620.05n

.meas tran vdout0_33ck610 FIND v(dout0_33) AT=620.05n

.meas tran vdout0_34ck610 FIND v(dout0_34) AT=620.05n

.meas tran vdout0_35ck610 FIND v(dout0_35) AT=620.05n

.meas tran vdout0_36ck610 FIND v(dout0_36) AT=620.05n

.meas tran vdout0_37ck610 FIND v(dout0_37) AT=620.05n

.meas tran vdout0_38ck610 FIND v(dout0_38) AT=620.05n

.meas tran vdout0_39ck610 FIND v(dout0_39) AT=620.05n

.meas tran vdout0_40ck610 FIND v(dout0_40) AT=620.05n

.meas tran vdout0_41ck610 FIND v(dout0_41) AT=620.05n

.meas tran vdout0_42ck610 FIND v(dout0_42) AT=620.05n

.meas tran vdout0_43ck610 FIND v(dout0_43) AT=620.05n

.meas tran vdout0_44ck610 FIND v(dout0_44) AT=620.05n

.meas tran vdout0_45ck610 FIND v(dout0_45) AT=620.05n

.meas tran vdout0_46ck610 FIND v(dout0_46) AT=620.05n

.meas tran vdout0_47ck610 FIND v(dout0_47) AT=620.05n

.meas tran vdout0_48ck610 FIND v(dout0_48) AT=620.05n

.meas tran vdout0_49ck610 FIND v(dout0_49) AT=620.05n

.meas tran vdout0_50ck610 FIND v(dout0_50) AT=620.05n

.meas tran vdout0_51ck610 FIND v(dout0_51) AT=620.05n

.meas tran vdout0_52ck610 FIND v(dout0_52) AT=620.05n

.meas tran vdout0_53ck610 FIND v(dout0_53) AT=620.05n

.meas tran vdout0_54ck610 FIND v(dout0_54) AT=620.05n

.meas tran vdout0_55ck610 FIND v(dout0_55) AT=620.05n

.meas tran vdout0_56ck610 FIND v(dout0_56) AT=620.05n

.meas tran vdout0_57ck610 FIND v(dout0_57) AT=620.05n

.meas tran vdout0_58ck610 FIND v(dout0_58) AT=620.05n

.meas tran vdout0_59ck610 FIND v(dout0_59) AT=620.05n

.meas tran vdout0_60ck610 FIND v(dout0_60) AT=620.05n

.meas tran vdout0_61ck610 FIND v(dout0_61) AT=620.05n

.meas tran vdout0_62ck610 FIND v(dout0_62) AT=620.05n

.meas tran vdout0_63ck610 FIND v(dout0_63) AT=620.05n

.meas tran vdout0_64ck610 FIND v(dout0_64) AT=620.05n

.meas tran vdout0_0ck630 FIND v(dout0_0) AT=640.05n

.meas tran vdout0_1ck630 FIND v(dout0_1) AT=640.05n

.meas tran vdout0_2ck630 FIND v(dout0_2) AT=640.05n

.meas tran vdout0_3ck630 FIND v(dout0_3) AT=640.05n

.meas tran vdout0_4ck630 FIND v(dout0_4) AT=640.05n

.meas tran vdout0_5ck630 FIND v(dout0_5) AT=640.05n

.meas tran vdout0_6ck630 FIND v(dout0_6) AT=640.05n

.meas tran vdout0_7ck630 FIND v(dout0_7) AT=640.05n

.meas tran vdout0_8ck630 FIND v(dout0_8) AT=640.05n

.meas tran vdout0_9ck630 FIND v(dout0_9) AT=640.05n

.meas tran vdout0_10ck630 FIND v(dout0_10) AT=640.05n

.meas tran vdout0_11ck630 FIND v(dout0_11) AT=640.05n

.meas tran vdout0_12ck630 FIND v(dout0_12) AT=640.05n

.meas tran vdout0_13ck630 FIND v(dout0_13) AT=640.05n

.meas tran vdout0_14ck630 FIND v(dout0_14) AT=640.05n

.meas tran vdout0_15ck630 FIND v(dout0_15) AT=640.05n

.meas tran vdout0_16ck630 FIND v(dout0_16) AT=640.05n

.meas tran vdout0_17ck630 FIND v(dout0_17) AT=640.05n

.meas tran vdout0_18ck630 FIND v(dout0_18) AT=640.05n

.meas tran vdout0_19ck630 FIND v(dout0_19) AT=640.05n

.meas tran vdout0_20ck630 FIND v(dout0_20) AT=640.05n

.meas tran vdout0_21ck630 FIND v(dout0_21) AT=640.05n

.meas tran vdout0_22ck630 FIND v(dout0_22) AT=640.05n

.meas tran vdout0_23ck630 FIND v(dout0_23) AT=640.05n

.meas tran vdout0_24ck630 FIND v(dout0_24) AT=640.05n

.meas tran vdout0_25ck630 FIND v(dout0_25) AT=640.05n

.meas tran vdout0_26ck630 FIND v(dout0_26) AT=640.05n

.meas tran vdout0_27ck630 FIND v(dout0_27) AT=640.05n

.meas tran vdout0_28ck630 FIND v(dout0_28) AT=640.05n

.meas tran vdout0_29ck630 FIND v(dout0_29) AT=640.05n

.meas tran vdout0_30ck630 FIND v(dout0_30) AT=640.05n

.meas tran vdout0_31ck630 FIND v(dout0_31) AT=640.05n

.meas tran vdout0_32ck630 FIND v(dout0_32) AT=640.05n

.meas tran vdout0_33ck630 FIND v(dout0_33) AT=640.05n

.meas tran vdout0_34ck630 FIND v(dout0_34) AT=640.05n

.meas tran vdout0_35ck630 FIND v(dout0_35) AT=640.05n

.meas tran vdout0_36ck630 FIND v(dout0_36) AT=640.05n

.meas tran vdout0_37ck630 FIND v(dout0_37) AT=640.05n

.meas tran vdout0_38ck630 FIND v(dout0_38) AT=640.05n

.meas tran vdout0_39ck630 FIND v(dout0_39) AT=640.05n

.meas tran vdout0_40ck630 FIND v(dout0_40) AT=640.05n

.meas tran vdout0_41ck630 FIND v(dout0_41) AT=640.05n

.meas tran vdout0_42ck630 FIND v(dout0_42) AT=640.05n

.meas tran vdout0_43ck630 FIND v(dout0_43) AT=640.05n

.meas tran vdout0_44ck630 FIND v(dout0_44) AT=640.05n

.meas tran vdout0_45ck630 FIND v(dout0_45) AT=640.05n

.meas tran vdout0_46ck630 FIND v(dout0_46) AT=640.05n

.meas tran vdout0_47ck630 FIND v(dout0_47) AT=640.05n

.meas tran vdout0_48ck630 FIND v(dout0_48) AT=640.05n

.meas tran vdout0_49ck630 FIND v(dout0_49) AT=640.05n

.meas tran vdout0_50ck630 FIND v(dout0_50) AT=640.05n

.meas tran vdout0_51ck630 FIND v(dout0_51) AT=640.05n

.meas tran vdout0_52ck630 FIND v(dout0_52) AT=640.05n

.meas tran vdout0_53ck630 FIND v(dout0_53) AT=640.05n

.meas tran vdout0_54ck630 FIND v(dout0_54) AT=640.05n

.meas tran vdout0_55ck630 FIND v(dout0_55) AT=640.05n

.meas tran vdout0_56ck630 FIND v(dout0_56) AT=640.05n

.meas tran vdout0_57ck630 FIND v(dout0_57) AT=640.05n

.meas tran vdout0_58ck630 FIND v(dout0_58) AT=640.05n

.meas tran vdout0_59ck630 FIND v(dout0_59) AT=640.05n

.meas tran vdout0_60ck630 FIND v(dout0_60) AT=640.05n

.meas tran vdout0_61ck630 FIND v(dout0_61) AT=640.05n

.meas tran vdout0_62ck630 FIND v(dout0_62) AT=640.05n

.meas tran vdout0_63ck630 FIND v(dout0_63) AT=640.05n

.meas tran vdout0_64ck630 FIND v(dout0_64) AT=640.05n

.meas tran vdout0_0ck640 FIND v(dout0_0) AT=650.05n

.meas tran vdout0_1ck640 FIND v(dout0_1) AT=650.05n

.meas tran vdout0_2ck640 FIND v(dout0_2) AT=650.05n

.meas tran vdout0_3ck640 FIND v(dout0_3) AT=650.05n

.meas tran vdout0_4ck640 FIND v(dout0_4) AT=650.05n

.meas tran vdout0_5ck640 FIND v(dout0_5) AT=650.05n

.meas tran vdout0_6ck640 FIND v(dout0_6) AT=650.05n

.meas tran vdout0_7ck640 FIND v(dout0_7) AT=650.05n

.meas tran vdout0_8ck640 FIND v(dout0_8) AT=650.05n

.meas tran vdout0_9ck640 FIND v(dout0_9) AT=650.05n

.meas tran vdout0_10ck640 FIND v(dout0_10) AT=650.05n

.meas tran vdout0_11ck640 FIND v(dout0_11) AT=650.05n

.meas tran vdout0_12ck640 FIND v(dout0_12) AT=650.05n

.meas tran vdout0_13ck640 FIND v(dout0_13) AT=650.05n

.meas tran vdout0_14ck640 FIND v(dout0_14) AT=650.05n

.meas tran vdout0_15ck640 FIND v(dout0_15) AT=650.05n

.meas tran vdout0_16ck640 FIND v(dout0_16) AT=650.05n

.meas tran vdout0_17ck640 FIND v(dout0_17) AT=650.05n

.meas tran vdout0_18ck640 FIND v(dout0_18) AT=650.05n

.meas tran vdout0_19ck640 FIND v(dout0_19) AT=650.05n

.meas tran vdout0_20ck640 FIND v(dout0_20) AT=650.05n

.meas tran vdout0_21ck640 FIND v(dout0_21) AT=650.05n

.meas tran vdout0_22ck640 FIND v(dout0_22) AT=650.05n

.meas tran vdout0_23ck640 FIND v(dout0_23) AT=650.05n

.meas tran vdout0_24ck640 FIND v(dout0_24) AT=650.05n

.meas tran vdout0_25ck640 FIND v(dout0_25) AT=650.05n

.meas tran vdout0_26ck640 FIND v(dout0_26) AT=650.05n

.meas tran vdout0_27ck640 FIND v(dout0_27) AT=650.05n

.meas tran vdout0_28ck640 FIND v(dout0_28) AT=650.05n

.meas tran vdout0_29ck640 FIND v(dout0_29) AT=650.05n

.meas tran vdout0_30ck640 FIND v(dout0_30) AT=650.05n

.meas tran vdout0_31ck640 FIND v(dout0_31) AT=650.05n

.meas tran vdout0_32ck640 FIND v(dout0_32) AT=650.05n

.meas tran vdout0_33ck640 FIND v(dout0_33) AT=650.05n

.meas tran vdout0_34ck640 FIND v(dout0_34) AT=650.05n

.meas tran vdout0_35ck640 FIND v(dout0_35) AT=650.05n

.meas tran vdout0_36ck640 FIND v(dout0_36) AT=650.05n

.meas tran vdout0_37ck640 FIND v(dout0_37) AT=650.05n

.meas tran vdout0_38ck640 FIND v(dout0_38) AT=650.05n

.meas tran vdout0_39ck640 FIND v(dout0_39) AT=650.05n

.meas tran vdout0_40ck640 FIND v(dout0_40) AT=650.05n

.meas tran vdout0_41ck640 FIND v(dout0_41) AT=650.05n

.meas tran vdout0_42ck640 FIND v(dout0_42) AT=650.05n

.meas tran vdout0_43ck640 FIND v(dout0_43) AT=650.05n

.meas tran vdout0_44ck640 FIND v(dout0_44) AT=650.05n

.meas tran vdout0_45ck640 FIND v(dout0_45) AT=650.05n

.meas tran vdout0_46ck640 FIND v(dout0_46) AT=650.05n

.meas tran vdout0_47ck640 FIND v(dout0_47) AT=650.05n

.meas tran vdout0_48ck640 FIND v(dout0_48) AT=650.05n

.meas tran vdout0_49ck640 FIND v(dout0_49) AT=650.05n

.meas tran vdout0_50ck640 FIND v(dout0_50) AT=650.05n

.meas tran vdout0_51ck640 FIND v(dout0_51) AT=650.05n

.meas tran vdout0_52ck640 FIND v(dout0_52) AT=650.05n

.meas tran vdout0_53ck640 FIND v(dout0_53) AT=650.05n

.meas tran vdout0_54ck640 FIND v(dout0_54) AT=650.05n

.meas tran vdout0_55ck640 FIND v(dout0_55) AT=650.05n

.meas tran vdout0_56ck640 FIND v(dout0_56) AT=650.05n

.meas tran vdout0_57ck640 FIND v(dout0_57) AT=650.05n

.meas tran vdout0_58ck640 FIND v(dout0_58) AT=650.05n

.meas tran vdout0_59ck640 FIND v(dout0_59) AT=650.05n

.meas tran vdout0_60ck640 FIND v(dout0_60) AT=650.05n

.meas tran vdout0_61ck640 FIND v(dout0_61) AT=650.05n

.meas tran vdout0_62ck640 FIND v(dout0_62) AT=650.05n

.meas tran vdout0_63ck640 FIND v(dout0_63) AT=650.05n

.meas tran vdout0_64ck640 FIND v(dout0_64) AT=650.05n

.meas tran vdout0_0ck650 FIND v(dout0_0) AT=660.05n

.meas tran vdout0_1ck650 FIND v(dout0_1) AT=660.05n

.meas tran vdout0_2ck650 FIND v(dout0_2) AT=660.05n

.meas tran vdout0_3ck650 FIND v(dout0_3) AT=660.05n

.meas tran vdout0_4ck650 FIND v(dout0_4) AT=660.05n

.meas tran vdout0_5ck650 FIND v(dout0_5) AT=660.05n

.meas tran vdout0_6ck650 FIND v(dout0_6) AT=660.05n

.meas tran vdout0_7ck650 FIND v(dout0_7) AT=660.05n

.meas tran vdout0_8ck650 FIND v(dout0_8) AT=660.05n

.meas tran vdout0_9ck650 FIND v(dout0_9) AT=660.05n

.meas tran vdout0_10ck650 FIND v(dout0_10) AT=660.05n

.meas tran vdout0_11ck650 FIND v(dout0_11) AT=660.05n

.meas tran vdout0_12ck650 FIND v(dout0_12) AT=660.05n

.meas tran vdout0_13ck650 FIND v(dout0_13) AT=660.05n

.meas tran vdout0_14ck650 FIND v(dout0_14) AT=660.05n

.meas tran vdout0_15ck650 FIND v(dout0_15) AT=660.05n

.meas tran vdout0_16ck650 FIND v(dout0_16) AT=660.05n

.meas tran vdout0_17ck650 FIND v(dout0_17) AT=660.05n

.meas tran vdout0_18ck650 FIND v(dout0_18) AT=660.05n

.meas tran vdout0_19ck650 FIND v(dout0_19) AT=660.05n

.meas tran vdout0_20ck650 FIND v(dout0_20) AT=660.05n

.meas tran vdout0_21ck650 FIND v(dout0_21) AT=660.05n

.meas tran vdout0_22ck650 FIND v(dout0_22) AT=660.05n

.meas tran vdout0_23ck650 FIND v(dout0_23) AT=660.05n

.meas tran vdout0_24ck650 FIND v(dout0_24) AT=660.05n

.meas tran vdout0_25ck650 FIND v(dout0_25) AT=660.05n

.meas tran vdout0_26ck650 FIND v(dout0_26) AT=660.05n

.meas tran vdout0_27ck650 FIND v(dout0_27) AT=660.05n

.meas tran vdout0_28ck650 FIND v(dout0_28) AT=660.05n

.meas tran vdout0_29ck650 FIND v(dout0_29) AT=660.05n

.meas tran vdout0_30ck650 FIND v(dout0_30) AT=660.05n

.meas tran vdout0_31ck650 FIND v(dout0_31) AT=660.05n

.meas tran vdout0_32ck650 FIND v(dout0_32) AT=660.05n

.meas tran vdout0_33ck650 FIND v(dout0_33) AT=660.05n

.meas tran vdout0_34ck650 FIND v(dout0_34) AT=660.05n

.meas tran vdout0_35ck650 FIND v(dout0_35) AT=660.05n

.meas tran vdout0_36ck650 FIND v(dout0_36) AT=660.05n

.meas tran vdout0_37ck650 FIND v(dout0_37) AT=660.05n

.meas tran vdout0_38ck650 FIND v(dout0_38) AT=660.05n

.meas tran vdout0_39ck650 FIND v(dout0_39) AT=660.05n

.meas tran vdout0_40ck650 FIND v(dout0_40) AT=660.05n

.meas tran vdout0_41ck650 FIND v(dout0_41) AT=660.05n

.meas tran vdout0_42ck650 FIND v(dout0_42) AT=660.05n

.meas tran vdout0_43ck650 FIND v(dout0_43) AT=660.05n

.meas tran vdout0_44ck650 FIND v(dout0_44) AT=660.05n

.meas tran vdout0_45ck650 FIND v(dout0_45) AT=660.05n

.meas tran vdout0_46ck650 FIND v(dout0_46) AT=660.05n

.meas tran vdout0_47ck650 FIND v(dout0_47) AT=660.05n

.meas tran vdout0_48ck650 FIND v(dout0_48) AT=660.05n

.meas tran vdout0_49ck650 FIND v(dout0_49) AT=660.05n

.meas tran vdout0_50ck650 FIND v(dout0_50) AT=660.05n

.meas tran vdout0_51ck650 FIND v(dout0_51) AT=660.05n

.meas tran vdout0_52ck650 FIND v(dout0_52) AT=660.05n

.meas tran vdout0_53ck650 FIND v(dout0_53) AT=660.05n

.meas tran vdout0_54ck650 FIND v(dout0_54) AT=660.05n

.meas tran vdout0_55ck650 FIND v(dout0_55) AT=660.05n

.meas tran vdout0_56ck650 FIND v(dout0_56) AT=660.05n

.meas tran vdout0_57ck650 FIND v(dout0_57) AT=660.05n

.meas tran vdout0_58ck650 FIND v(dout0_58) AT=660.05n

.meas tran vdout0_59ck650 FIND v(dout0_59) AT=660.05n

.meas tran vdout0_60ck650 FIND v(dout0_60) AT=660.05n

.meas tran vdout0_61ck650 FIND v(dout0_61) AT=660.05n

.meas tran vdout0_62ck650 FIND v(dout0_62) AT=660.05n

.meas tran vdout0_63ck650 FIND v(dout0_63) AT=660.05n

.meas tran vdout0_64ck650 FIND v(dout0_64) AT=660.05n

.meas tran vdout0_0ck680 FIND v(dout0_0) AT=690.05n

.meas tran vdout0_1ck680 FIND v(dout0_1) AT=690.05n

.meas tran vdout0_2ck680 FIND v(dout0_2) AT=690.05n

.meas tran vdout0_3ck680 FIND v(dout0_3) AT=690.05n

.meas tran vdout0_4ck680 FIND v(dout0_4) AT=690.05n

.meas tran vdout0_5ck680 FIND v(dout0_5) AT=690.05n

.meas tran vdout0_6ck680 FIND v(dout0_6) AT=690.05n

.meas tran vdout0_7ck680 FIND v(dout0_7) AT=690.05n

.meas tran vdout0_8ck680 FIND v(dout0_8) AT=690.05n

.meas tran vdout0_9ck680 FIND v(dout0_9) AT=690.05n

.meas tran vdout0_10ck680 FIND v(dout0_10) AT=690.05n

.meas tran vdout0_11ck680 FIND v(dout0_11) AT=690.05n

.meas tran vdout0_12ck680 FIND v(dout0_12) AT=690.05n

.meas tran vdout0_13ck680 FIND v(dout0_13) AT=690.05n

.meas tran vdout0_14ck680 FIND v(dout0_14) AT=690.05n

.meas tran vdout0_15ck680 FIND v(dout0_15) AT=690.05n

.meas tran vdout0_16ck680 FIND v(dout0_16) AT=690.05n

.meas tran vdout0_17ck680 FIND v(dout0_17) AT=690.05n

.meas tran vdout0_18ck680 FIND v(dout0_18) AT=690.05n

.meas tran vdout0_19ck680 FIND v(dout0_19) AT=690.05n

.meas tran vdout0_20ck680 FIND v(dout0_20) AT=690.05n

.meas tran vdout0_21ck680 FIND v(dout0_21) AT=690.05n

.meas tran vdout0_22ck680 FIND v(dout0_22) AT=690.05n

.meas tran vdout0_23ck680 FIND v(dout0_23) AT=690.05n

.meas tran vdout0_24ck680 FIND v(dout0_24) AT=690.05n

.meas tran vdout0_25ck680 FIND v(dout0_25) AT=690.05n

.meas tran vdout0_26ck680 FIND v(dout0_26) AT=690.05n

.meas tran vdout0_27ck680 FIND v(dout0_27) AT=690.05n

.meas tran vdout0_28ck680 FIND v(dout0_28) AT=690.05n

.meas tran vdout0_29ck680 FIND v(dout0_29) AT=690.05n

.meas tran vdout0_30ck680 FIND v(dout0_30) AT=690.05n

.meas tran vdout0_31ck680 FIND v(dout0_31) AT=690.05n

.meas tran vdout0_32ck680 FIND v(dout0_32) AT=690.05n

.meas tran vdout0_33ck680 FIND v(dout0_33) AT=690.05n

.meas tran vdout0_34ck680 FIND v(dout0_34) AT=690.05n

.meas tran vdout0_35ck680 FIND v(dout0_35) AT=690.05n

.meas tran vdout0_36ck680 FIND v(dout0_36) AT=690.05n

.meas tran vdout0_37ck680 FIND v(dout0_37) AT=690.05n

.meas tran vdout0_38ck680 FIND v(dout0_38) AT=690.05n

.meas tran vdout0_39ck680 FIND v(dout0_39) AT=690.05n

.meas tran vdout0_40ck680 FIND v(dout0_40) AT=690.05n

.meas tran vdout0_41ck680 FIND v(dout0_41) AT=690.05n

.meas tran vdout0_42ck680 FIND v(dout0_42) AT=690.05n

.meas tran vdout0_43ck680 FIND v(dout0_43) AT=690.05n

.meas tran vdout0_44ck680 FIND v(dout0_44) AT=690.05n

.meas tran vdout0_45ck680 FIND v(dout0_45) AT=690.05n

.meas tran vdout0_46ck680 FIND v(dout0_46) AT=690.05n

.meas tran vdout0_47ck680 FIND v(dout0_47) AT=690.05n

.meas tran vdout0_48ck680 FIND v(dout0_48) AT=690.05n

.meas tran vdout0_49ck680 FIND v(dout0_49) AT=690.05n

.meas tran vdout0_50ck680 FIND v(dout0_50) AT=690.05n

.meas tran vdout0_51ck680 FIND v(dout0_51) AT=690.05n

.meas tran vdout0_52ck680 FIND v(dout0_52) AT=690.05n

.meas tran vdout0_53ck680 FIND v(dout0_53) AT=690.05n

.meas tran vdout0_54ck680 FIND v(dout0_54) AT=690.05n

.meas tran vdout0_55ck680 FIND v(dout0_55) AT=690.05n

.meas tran vdout0_56ck680 FIND v(dout0_56) AT=690.05n

.meas tran vdout0_57ck680 FIND v(dout0_57) AT=690.05n

.meas tran vdout0_58ck680 FIND v(dout0_58) AT=690.05n

.meas tran vdout0_59ck680 FIND v(dout0_59) AT=690.05n

.meas tran vdout0_60ck680 FIND v(dout0_60) AT=690.05n

.meas tran vdout0_61ck680 FIND v(dout0_61) AT=690.05n

.meas tran vdout0_62ck680 FIND v(dout0_62) AT=690.05n

.meas tran vdout0_63ck680 FIND v(dout0_63) AT=690.05n

.meas tran vdout0_64ck680 FIND v(dout0_64) AT=690.05n

.meas tran vdout0_0ck700 FIND v(dout0_0) AT=710.05n

.meas tran vdout0_1ck700 FIND v(dout0_1) AT=710.05n

.meas tran vdout0_2ck700 FIND v(dout0_2) AT=710.05n

.meas tran vdout0_3ck700 FIND v(dout0_3) AT=710.05n

.meas tran vdout0_4ck700 FIND v(dout0_4) AT=710.05n

.meas tran vdout0_5ck700 FIND v(dout0_5) AT=710.05n

.meas tran vdout0_6ck700 FIND v(dout0_6) AT=710.05n

.meas tran vdout0_7ck700 FIND v(dout0_7) AT=710.05n

.meas tran vdout0_8ck700 FIND v(dout0_8) AT=710.05n

.meas tran vdout0_9ck700 FIND v(dout0_9) AT=710.05n

.meas tran vdout0_10ck700 FIND v(dout0_10) AT=710.05n

.meas tran vdout0_11ck700 FIND v(dout0_11) AT=710.05n

.meas tran vdout0_12ck700 FIND v(dout0_12) AT=710.05n

.meas tran vdout0_13ck700 FIND v(dout0_13) AT=710.05n

.meas tran vdout0_14ck700 FIND v(dout0_14) AT=710.05n

.meas tran vdout0_15ck700 FIND v(dout0_15) AT=710.05n

.meas tran vdout0_16ck700 FIND v(dout0_16) AT=710.05n

.meas tran vdout0_17ck700 FIND v(dout0_17) AT=710.05n

.meas tran vdout0_18ck700 FIND v(dout0_18) AT=710.05n

.meas tran vdout0_19ck700 FIND v(dout0_19) AT=710.05n

.meas tran vdout0_20ck700 FIND v(dout0_20) AT=710.05n

.meas tran vdout0_21ck700 FIND v(dout0_21) AT=710.05n

.meas tran vdout0_22ck700 FIND v(dout0_22) AT=710.05n

.meas tran vdout0_23ck700 FIND v(dout0_23) AT=710.05n

.meas tran vdout0_24ck700 FIND v(dout0_24) AT=710.05n

.meas tran vdout0_25ck700 FIND v(dout0_25) AT=710.05n

.meas tran vdout0_26ck700 FIND v(dout0_26) AT=710.05n

.meas tran vdout0_27ck700 FIND v(dout0_27) AT=710.05n

.meas tran vdout0_28ck700 FIND v(dout0_28) AT=710.05n

.meas tran vdout0_29ck700 FIND v(dout0_29) AT=710.05n

.meas tran vdout0_30ck700 FIND v(dout0_30) AT=710.05n

.meas tran vdout0_31ck700 FIND v(dout0_31) AT=710.05n

.meas tran vdout0_32ck700 FIND v(dout0_32) AT=710.05n

.meas tran vdout0_33ck700 FIND v(dout0_33) AT=710.05n

.meas tran vdout0_34ck700 FIND v(dout0_34) AT=710.05n

.meas tran vdout0_35ck700 FIND v(dout0_35) AT=710.05n

.meas tran vdout0_36ck700 FIND v(dout0_36) AT=710.05n

.meas tran vdout0_37ck700 FIND v(dout0_37) AT=710.05n

.meas tran vdout0_38ck700 FIND v(dout0_38) AT=710.05n

.meas tran vdout0_39ck700 FIND v(dout0_39) AT=710.05n

.meas tran vdout0_40ck700 FIND v(dout0_40) AT=710.05n

.meas tran vdout0_41ck700 FIND v(dout0_41) AT=710.05n

.meas tran vdout0_42ck700 FIND v(dout0_42) AT=710.05n

.meas tran vdout0_43ck700 FIND v(dout0_43) AT=710.05n

.meas tran vdout0_44ck700 FIND v(dout0_44) AT=710.05n

.meas tran vdout0_45ck700 FIND v(dout0_45) AT=710.05n

.meas tran vdout0_46ck700 FIND v(dout0_46) AT=710.05n

.meas tran vdout0_47ck700 FIND v(dout0_47) AT=710.05n

.meas tran vdout0_48ck700 FIND v(dout0_48) AT=710.05n

.meas tran vdout0_49ck700 FIND v(dout0_49) AT=710.05n

.meas tran vdout0_50ck700 FIND v(dout0_50) AT=710.05n

.meas tran vdout0_51ck700 FIND v(dout0_51) AT=710.05n

.meas tran vdout0_52ck700 FIND v(dout0_52) AT=710.05n

.meas tran vdout0_53ck700 FIND v(dout0_53) AT=710.05n

.meas tran vdout0_54ck700 FIND v(dout0_54) AT=710.05n

.meas tran vdout0_55ck700 FIND v(dout0_55) AT=710.05n

.meas tran vdout0_56ck700 FIND v(dout0_56) AT=710.05n

.meas tran vdout0_57ck700 FIND v(dout0_57) AT=710.05n

.meas tran vdout0_58ck700 FIND v(dout0_58) AT=710.05n

.meas tran vdout0_59ck700 FIND v(dout0_59) AT=710.05n

.meas tran vdout0_60ck700 FIND v(dout0_60) AT=710.05n

.meas tran vdout0_61ck700 FIND v(dout0_61) AT=710.05n

.meas tran vdout0_62ck700 FIND v(dout0_62) AT=710.05n

.meas tran vdout0_63ck700 FIND v(dout0_63) AT=710.05n

.meas tran vdout0_64ck700 FIND v(dout0_64) AT=710.05n

.meas tran vdout0_0ck710 FIND v(dout0_0) AT=720.05n

.meas tran vdout0_1ck710 FIND v(dout0_1) AT=720.05n

.meas tran vdout0_2ck710 FIND v(dout0_2) AT=720.05n

.meas tran vdout0_3ck710 FIND v(dout0_3) AT=720.05n

.meas tran vdout0_4ck710 FIND v(dout0_4) AT=720.05n

.meas tran vdout0_5ck710 FIND v(dout0_5) AT=720.05n

.meas tran vdout0_6ck710 FIND v(dout0_6) AT=720.05n

.meas tran vdout0_7ck710 FIND v(dout0_7) AT=720.05n

.meas tran vdout0_8ck710 FIND v(dout0_8) AT=720.05n

.meas tran vdout0_9ck710 FIND v(dout0_9) AT=720.05n

.meas tran vdout0_10ck710 FIND v(dout0_10) AT=720.05n

.meas tran vdout0_11ck710 FIND v(dout0_11) AT=720.05n

.meas tran vdout0_12ck710 FIND v(dout0_12) AT=720.05n

.meas tran vdout0_13ck710 FIND v(dout0_13) AT=720.05n

.meas tran vdout0_14ck710 FIND v(dout0_14) AT=720.05n

.meas tran vdout0_15ck710 FIND v(dout0_15) AT=720.05n

.meas tran vdout0_16ck710 FIND v(dout0_16) AT=720.05n

.meas tran vdout0_17ck710 FIND v(dout0_17) AT=720.05n

.meas tran vdout0_18ck710 FIND v(dout0_18) AT=720.05n

.meas tran vdout0_19ck710 FIND v(dout0_19) AT=720.05n

.meas tran vdout0_20ck710 FIND v(dout0_20) AT=720.05n

.meas tran vdout0_21ck710 FIND v(dout0_21) AT=720.05n

.meas tran vdout0_22ck710 FIND v(dout0_22) AT=720.05n

.meas tran vdout0_23ck710 FIND v(dout0_23) AT=720.05n

.meas tran vdout0_24ck710 FIND v(dout0_24) AT=720.05n

.meas tran vdout0_25ck710 FIND v(dout0_25) AT=720.05n

.meas tran vdout0_26ck710 FIND v(dout0_26) AT=720.05n

.meas tran vdout0_27ck710 FIND v(dout0_27) AT=720.05n

.meas tran vdout0_28ck710 FIND v(dout0_28) AT=720.05n

.meas tran vdout0_29ck710 FIND v(dout0_29) AT=720.05n

.meas tran vdout0_30ck710 FIND v(dout0_30) AT=720.05n

.meas tran vdout0_31ck710 FIND v(dout0_31) AT=720.05n

.meas tran vdout0_32ck710 FIND v(dout0_32) AT=720.05n

.meas tran vdout0_33ck710 FIND v(dout0_33) AT=720.05n

.meas tran vdout0_34ck710 FIND v(dout0_34) AT=720.05n

.meas tran vdout0_35ck710 FIND v(dout0_35) AT=720.05n

.meas tran vdout0_36ck710 FIND v(dout0_36) AT=720.05n

.meas tran vdout0_37ck710 FIND v(dout0_37) AT=720.05n

.meas tran vdout0_38ck710 FIND v(dout0_38) AT=720.05n

.meas tran vdout0_39ck710 FIND v(dout0_39) AT=720.05n

.meas tran vdout0_40ck710 FIND v(dout0_40) AT=720.05n

.meas tran vdout0_41ck710 FIND v(dout0_41) AT=720.05n

.meas tran vdout0_42ck710 FIND v(dout0_42) AT=720.05n

.meas tran vdout0_43ck710 FIND v(dout0_43) AT=720.05n

.meas tran vdout0_44ck710 FIND v(dout0_44) AT=720.05n

.meas tran vdout0_45ck710 FIND v(dout0_45) AT=720.05n

.meas tran vdout0_46ck710 FIND v(dout0_46) AT=720.05n

.meas tran vdout0_47ck710 FIND v(dout0_47) AT=720.05n

.meas tran vdout0_48ck710 FIND v(dout0_48) AT=720.05n

.meas tran vdout0_49ck710 FIND v(dout0_49) AT=720.05n

.meas tran vdout0_50ck710 FIND v(dout0_50) AT=720.05n

.meas tran vdout0_51ck710 FIND v(dout0_51) AT=720.05n

.meas tran vdout0_52ck710 FIND v(dout0_52) AT=720.05n

.meas tran vdout0_53ck710 FIND v(dout0_53) AT=720.05n

.meas tran vdout0_54ck710 FIND v(dout0_54) AT=720.05n

.meas tran vdout0_55ck710 FIND v(dout0_55) AT=720.05n

.meas tran vdout0_56ck710 FIND v(dout0_56) AT=720.05n

.meas tran vdout0_57ck710 FIND v(dout0_57) AT=720.05n

.meas tran vdout0_58ck710 FIND v(dout0_58) AT=720.05n

.meas tran vdout0_59ck710 FIND v(dout0_59) AT=720.05n

.meas tran vdout0_60ck710 FIND v(dout0_60) AT=720.05n

.meas tran vdout0_61ck710 FIND v(dout0_61) AT=720.05n

.meas tran vdout0_62ck710 FIND v(dout0_62) AT=720.05n

.meas tran vdout0_63ck710 FIND v(dout0_63) AT=720.05n

.meas tran vdout0_64ck710 FIND v(dout0_64) AT=720.05n

.meas tran vdout0_0ck720 FIND v(dout0_0) AT=730.05n

.meas tran vdout0_1ck720 FIND v(dout0_1) AT=730.05n

.meas tran vdout0_2ck720 FIND v(dout0_2) AT=730.05n

.meas tran vdout0_3ck720 FIND v(dout0_3) AT=730.05n

.meas tran vdout0_4ck720 FIND v(dout0_4) AT=730.05n

.meas tran vdout0_5ck720 FIND v(dout0_5) AT=730.05n

.meas tran vdout0_6ck720 FIND v(dout0_6) AT=730.05n

.meas tran vdout0_7ck720 FIND v(dout0_7) AT=730.05n

.meas tran vdout0_8ck720 FIND v(dout0_8) AT=730.05n

.meas tran vdout0_9ck720 FIND v(dout0_9) AT=730.05n

.meas tran vdout0_10ck720 FIND v(dout0_10) AT=730.05n

.meas tran vdout0_11ck720 FIND v(dout0_11) AT=730.05n

.meas tran vdout0_12ck720 FIND v(dout0_12) AT=730.05n

.meas tran vdout0_13ck720 FIND v(dout0_13) AT=730.05n

.meas tran vdout0_14ck720 FIND v(dout0_14) AT=730.05n

.meas tran vdout0_15ck720 FIND v(dout0_15) AT=730.05n

.meas tran vdout0_16ck720 FIND v(dout0_16) AT=730.05n

.meas tran vdout0_17ck720 FIND v(dout0_17) AT=730.05n

.meas tran vdout0_18ck720 FIND v(dout0_18) AT=730.05n

.meas tran vdout0_19ck720 FIND v(dout0_19) AT=730.05n

.meas tran vdout0_20ck720 FIND v(dout0_20) AT=730.05n

.meas tran vdout0_21ck720 FIND v(dout0_21) AT=730.05n

.meas tran vdout0_22ck720 FIND v(dout0_22) AT=730.05n

.meas tran vdout0_23ck720 FIND v(dout0_23) AT=730.05n

.meas tran vdout0_24ck720 FIND v(dout0_24) AT=730.05n

.meas tran vdout0_25ck720 FIND v(dout0_25) AT=730.05n

.meas tran vdout0_26ck720 FIND v(dout0_26) AT=730.05n

.meas tran vdout0_27ck720 FIND v(dout0_27) AT=730.05n

.meas tran vdout0_28ck720 FIND v(dout0_28) AT=730.05n

.meas tran vdout0_29ck720 FIND v(dout0_29) AT=730.05n

.meas tran vdout0_30ck720 FIND v(dout0_30) AT=730.05n

.meas tran vdout0_31ck720 FIND v(dout0_31) AT=730.05n

.meas tran vdout0_32ck720 FIND v(dout0_32) AT=730.05n

.meas tran vdout0_33ck720 FIND v(dout0_33) AT=730.05n

.meas tran vdout0_34ck720 FIND v(dout0_34) AT=730.05n

.meas tran vdout0_35ck720 FIND v(dout0_35) AT=730.05n

.meas tran vdout0_36ck720 FIND v(dout0_36) AT=730.05n

.meas tran vdout0_37ck720 FIND v(dout0_37) AT=730.05n

.meas tran vdout0_38ck720 FIND v(dout0_38) AT=730.05n

.meas tran vdout0_39ck720 FIND v(dout0_39) AT=730.05n

.meas tran vdout0_40ck720 FIND v(dout0_40) AT=730.05n

.meas tran vdout0_41ck720 FIND v(dout0_41) AT=730.05n

.meas tran vdout0_42ck720 FIND v(dout0_42) AT=730.05n

.meas tran vdout0_43ck720 FIND v(dout0_43) AT=730.05n

.meas tran vdout0_44ck720 FIND v(dout0_44) AT=730.05n

.meas tran vdout0_45ck720 FIND v(dout0_45) AT=730.05n

.meas tran vdout0_46ck720 FIND v(dout0_46) AT=730.05n

.meas tran vdout0_47ck720 FIND v(dout0_47) AT=730.05n

.meas tran vdout0_48ck720 FIND v(dout0_48) AT=730.05n

.meas tran vdout0_49ck720 FIND v(dout0_49) AT=730.05n

.meas tran vdout0_50ck720 FIND v(dout0_50) AT=730.05n

.meas tran vdout0_51ck720 FIND v(dout0_51) AT=730.05n

.meas tran vdout0_52ck720 FIND v(dout0_52) AT=730.05n

.meas tran vdout0_53ck720 FIND v(dout0_53) AT=730.05n

.meas tran vdout0_54ck720 FIND v(dout0_54) AT=730.05n

.meas tran vdout0_55ck720 FIND v(dout0_55) AT=730.05n

.meas tran vdout0_56ck720 FIND v(dout0_56) AT=730.05n

.meas tran vdout0_57ck720 FIND v(dout0_57) AT=730.05n

.meas tran vdout0_58ck720 FIND v(dout0_58) AT=730.05n

.meas tran vdout0_59ck720 FIND v(dout0_59) AT=730.05n

.meas tran vdout0_60ck720 FIND v(dout0_60) AT=730.05n

.meas tran vdout0_61ck720 FIND v(dout0_61) AT=730.05n

.meas tran vdout0_62ck720 FIND v(dout0_62) AT=730.05n

.meas tran vdout0_63ck720 FIND v(dout0_63) AT=730.05n

.meas tran vdout0_64ck720 FIND v(dout0_64) AT=730.05n

.meas tran vdout0_0ck750 FIND v(dout0_0) AT=760.05n

.meas tran vdout0_1ck750 FIND v(dout0_1) AT=760.05n

.meas tran vdout0_2ck750 FIND v(dout0_2) AT=760.05n

.meas tran vdout0_3ck750 FIND v(dout0_3) AT=760.05n

.meas tran vdout0_4ck750 FIND v(dout0_4) AT=760.05n

.meas tran vdout0_5ck750 FIND v(dout0_5) AT=760.05n

.meas tran vdout0_6ck750 FIND v(dout0_6) AT=760.05n

.meas tran vdout0_7ck750 FIND v(dout0_7) AT=760.05n

.meas tran vdout0_8ck750 FIND v(dout0_8) AT=760.05n

.meas tran vdout0_9ck750 FIND v(dout0_9) AT=760.05n

.meas tran vdout0_10ck750 FIND v(dout0_10) AT=760.05n

.meas tran vdout0_11ck750 FIND v(dout0_11) AT=760.05n

.meas tran vdout0_12ck750 FIND v(dout0_12) AT=760.05n

.meas tran vdout0_13ck750 FIND v(dout0_13) AT=760.05n

.meas tran vdout0_14ck750 FIND v(dout0_14) AT=760.05n

.meas tran vdout0_15ck750 FIND v(dout0_15) AT=760.05n

.meas tran vdout0_16ck750 FIND v(dout0_16) AT=760.05n

.meas tran vdout0_17ck750 FIND v(dout0_17) AT=760.05n

.meas tran vdout0_18ck750 FIND v(dout0_18) AT=760.05n

.meas tran vdout0_19ck750 FIND v(dout0_19) AT=760.05n

.meas tran vdout0_20ck750 FIND v(dout0_20) AT=760.05n

.meas tran vdout0_21ck750 FIND v(dout0_21) AT=760.05n

.meas tran vdout0_22ck750 FIND v(dout0_22) AT=760.05n

.meas tran vdout0_23ck750 FIND v(dout0_23) AT=760.05n

.meas tran vdout0_24ck750 FIND v(dout0_24) AT=760.05n

.meas tran vdout0_25ck750 FIND v(dout0_25) AT=760.05n

.meas tran vdout0_26ck750 FIND v(dout0_26) AT=760.05n

.meas tran vdout0_27ck750 FIND v(dout0_27) AT=760.05n

.meas tran vdout0_28ck750 FIND v(dout0_28) AT=760.05n

.meas tran vdout0_29ck750 FIND v(dout0_29) AT=760.05n

.meas tran vdout0_30ck750 FIND v(dout0_30) AT=760.05n

.meas tran vdout0_31ck750 FIND v(dout0_31) AT=760.05n

.meas tran vdout0_32ck750 FIND v(dout0_32) AT=760.05n

.meas tran vdout0_33ck750 FIND v(dout0_33) AT=760.05n

.meas tran vdout0_34ck750 FIND v(dout0_34) AT=760.05n

.meas tran vdout0_35ck750 FIND v(dout0_35) AT=760.05n

.meas tran vdout0_36ck750 FIND v(dout0_36) AT=760.05n

.meas tran vdout0_37ck750 FIND v(dout0_37) AT=760.05n

.meas tran vdout0_38ck750 FIND v(dout0_38) AT=760.05n

.meas tran vdout0_39ck750 FIND v(dout0_39) AT=760.05n

.meas tran vdout0_40ck750 FIND v(dout0_40) AT=760.05n

.meas tran vdout0_41ck750 FIND v(dout0_41) AT=760.05n

.meas tran vdout0_42ck750 FIND v(dout0_42) AT=760.05n

.meas tran vdout0_43ck750 FIND v(dout0_43) AT=760.05n

.meas tran vdout0_44ck750 FIND v(dout0_44) AT=760.05n

.meas tran vdout0_45ck750 FIND v(dout0_45) AT=760.05n

.meas tran vdout0_46ck750 FIND v(dout0_46) AT=760.05n

.meas tran vdout0_47ck750 FIND v(dout0_47) AT=760.05n

.meas tran vdout0_48ck750 FIND v(dout0_48) AT=760.05n

.meas tran vdout0_49ck750 FIND v(dout0_49) AT=760.05n

.meas tran vdout0_50ck750 FIND v(dout0_50) AT=760.05n

.meas tran vdout0_51ck750 FIND v(dout0_51) AT=760.05n

.meas tran vdout0_52ck750 FIND v(dout0_52) AT=760.05n

.meas tran vdout0_53ck750 FIND v(dout0_53) AT=760.05n

.meas tran vdout0_54ck750 FIND v(dout0_54) AT=760.05n

.meas tran vdout0_55ck750 FIND v(dout0_55) AT=760.05n

.meas tran vdout0_56ck750 FIND v(dout0_56) AT=760.05n

.meas tran vdout0_57ck750 FIND v(dout0_57) AT=760.05n

.meas tran vdout0_58ck750 FIND v(dout0_58) AT=760.05n

.meas tran vdout0_59ck750 FIND v(dout0_59) AT=760.05n

.meas tran vdout0_60ck750 FIND v(dout0_60) AT=760.05n

.meas tran vdout0_61ck750 FIND v(dout0_61) AT=760.05n

.meas tran vdout0_62ck750 FIND v(dout0_62) AT=760.05n

.meas tran vdout0_63ck750 FIND v(dout0_63) AT=760.05n

.meas tran vdout0_64ck750 FIND v(dout0_64) AT=760.05n

.meas tran vdout0_0ck810 FIND v(dout0_0) AT=820.05n

.meas tran vdout0_1ck810 FIND v(dout0_1) AT=820.05n

.meas tran vdout0_2ck810 FIND v(dout0_2) AT=820.05n

.meas tran vdout0_3ck810 FIND v(dout0_3) AT=820.05n

.meas tran vdout0_4ck810 FIND v(dout0_4) AT=820.05n

.meas tran vdout0_5ck810 FIND v(dout0_5) AT=820.05n

.meas tran vdout0_6ck810 FIND v(dout0_6) AT=820.05n

.meas tran vdout0_7ck810 FIND v(dout0_7) AT=820.05n

.meas tran vdout0_8ck810 FIND v(dout0_8) AT=820.05n

.meas tran vdout0_9ck810 FIND v(dout0_9) AT=820.05n

.meas tran vdout0_10ck810 FIND v(dout0_10) AT=820.05n

.meas tran vdout0_11ck810 FIND v(dout0_11) AT=820.05n

.meas tran vdout0_12ck810 FIND v(dout0_12) AT=820.05n

.meas tran vdout0_13ck810 FIND v(dout0_13) AT=820.05n

.meas tran vdout0_14ck810 FIND v(dout0_14) AT=820.05n

.meas tran vdout0_15ck810 FIND v(dout0_15) AT=820.05n

.meas tran vdout0_16ck810 FIND v(dout0_16) AT=820.05n

.meas tran vdout0_17ck810 FIND v(dout0_17) AT=820.05n

.meas tran vdout0_18ck810 FIND v(dout0_18) AT=820.05n

.meas tran vdout0_19ck810 FIND v(dout0_19) AT=820.05n

.meas tran vdout0_20ck810 FIND v(dout0_20) AT=820.05n

.meas tran vdout0_21ck810 FIND v(dout0_21) AT=820.05n

.meas tran vdout0_22ck810 FIND v(dout0_22) AT=820.05n

.meas tran vdout0_23ck810 FIND v(dout0_23) AT=820.05n

.meas tran vdout0_24ck810 FIND v(dout0_24) AT=820.05n

.meas tran vdout0_25ck810 FIND v(dout0_25) AT=820.05n

.meas tran vdout0_26ck810 FIND v(dout0_26) AT=820.05n

.meas tran vdout0_27ck810 FIND v(dout0_27) AT=820.05n

.meas tran vdout0_28ck810 FIND v(dout0_28) AT=820.05n

.meas tran vdout0_29ck810 FIND v(dout0_29) AT=820.05n

.meas tran vdout0_30ck810 FIND v(dout0_30) AT=820.05n

.meas tran vdout0_31ck810 FIND v(dout0_31) AT=820.05n

.meas tran vdout0_32ck810 FIND v(dout0_32) AT=820.05n

.meas tran vdout0_33ck810 FIND v(dout0_33) AT=820.05n

.meas tran vdout0_34ck810 FIND v(dout0_34) AT=820.05n

.meas tran vdout0_35ck810 FIND v(dout0_35) AT=820.05n

.meas tran vdout0_36ck810 FIND v(dout0_36) AT=820.05n

.meas tran vdout0_37ck810 FIND v(dout0_37) AT=820.05n

.meas tran vdout0_38ck810 FIND v(dout0_38) AT=820.05n

.meas tran vdout0_39ck810 FIND v(dout0_39) AT=820.05n

.meas tran vdout0_40ck810 FIND v(dout0_40) AT=820.05n

.meas tran vdout0_41ck810 FIND v(dout0_41) AT=820.05n

.meas tran vdout0_42ck810 FIND v(dout0_42) AT=820.05n

.meas tran vdout0_43ck810 FIND v(dout0_43) AT=820.05n

.meas tran vdout0_44ck810 FIND v(dout0_44) AT=820.05n

.meas tran vdout0_45ck810 FIND v(dout0_45) AT=820.05n

.meas tran vdout0_46ck810 FIND v(dout0_46) AT=820.05n

.meas tran vdout0_47ck810 FIND v(dout0_47) AT=820.05n

.meas tran vdout0_48ck810 FIND v(dout0_48) AT=820.05n

.meas tran vdout0_49ck810 FIND v(dout0_49) AT=820.05n

.meas tran vdout0_50ck810 FIND v(dout0_50) AT=820.05n

.meas tran vdout0_51ck810 FIND v(dout0_51) AT=820.05n

.meas tran vdout0_52ck810 FIND v(dout0_52) AT=820.05n

.meas tran vdout0_53ck810 FIND v(dout0_53) AT=820.05n

.meas tran vdout0_54ck810 FIND v(dout0_54) AT=820.05n

.meas tran vdout0_55ck810 FIND v(dout0_55) AT=820.05n

.meas tran vdout0_56ck810 FIND v(dout0_56) AT=820.05n

.meas tran vdout0_57ck810 FIND v(dout0_57) AT=820.05n

.meas tran vdout0_58ck810 FIND v(dout0_58) AT=820.05n

.meas tran vdout0_59ck810 FIND v(dout0_59) AT=820.05n

.meas tran vdout0_60ck810 FIND v(dout0_60) AT=820.05n

.meas tran vdout0_61ck810 FIND v(dout0_61) AT=820.05n

.meas tran vdout0_62ck810 FIND v(dout0_62) AT=820.05n

.meas tran vdout0_63ck810 FIND v(dout0_63) AT=820.05n

.meas tran vdout0_64ck810 FIND v(dout0_64) AT=820.05n

.meas tran vdout0_0ck820 FIND v(dout0_0) AT=830.05n

.meas tran vdout0_1ck820 FIND v(dout0_1) AT=830.05n

.meas tran vdout0_2ck820 FIND v(dout0_2) AT=830.05n

.meas tran vdout0_3ck820 FIND v(dout0_3) AT=830.05n

.meas tran vdout0_4ck820 FIND v(dout0_4) AT=830.05n

.meas tran vdout0_5ck820 FIND v(dout0_5) AT=830.05n

.meas tran vdout0_6ck820 FIND v(dout0_6) AT=830.05n

.meas tran vdout0_7ck820 FIND v(dout0_7) AT=830.05n

.meas tran vdout0_8ck820 FIND v(dout0_8) AT=830.05n

.meas tran vdout0_9ck820 FIND v(dout0_9) AT=830.05n

.meas tran vdout0_10ck820 FIND v(dout0_10) AT=830.05n

.meas tran vdout0_11ck820 FIND v(dout0_11) AT=830.05n

.meas tran vdout0_12ck820 FIND v(dout0_12) AT=830.05n

.meas tran vdout0_13ck820 FIND v(dout0_13) AT=830.05n

.meas tran vdout0_14ck820 FIND v(dout0_14) AT=830.05n

.meas tran vdout0_15ck820 FIND v(dout0_15) AT=830.05n

.meas tran vdout0_16ck820 FIND v(dout0_16) AT=830.05n

.meas tran vdout0_17ck820 FIND v(dout0_17) AT=830.05n

.meas tran vdout0_18ck820 FIND v(dout0_18) AT=830.05n

.meas tran vdout0_19ck820 FIND v(dout0_19) AT=830.05n

.meas tran vdout0_20ck820 FIND v(dout0_20) AT=830.05n

.meas tran vdout0_21ck820 FIND v(dout0_21) AT=830.05n

.meas tran vdout0_22ck820 FIND v(dout0_22) AT=830.05n

.meas tran vdout0_23ck820 FIND v(dout0_23) AT=830.05n

.meas tran vdout0_24ck820 FIND v(dout0_24) AT=830.05n

.meas tran vdout0_25ck820 FIND v(dout0_25) AT=830.05n

.meas tran vdout0_26ck820 FIND v(dout0_26) AT=830.05n

.meas tran vdout0_27ck820 FIND v(dout0_27) AT=830.05n

.meas tran vdout0_28ck820 FIND v(dout0_28) AT=830.05n

.meas tran vdout0_29ck820 FIND v(dout0_29) AT=830.05n

.meas tran vdout0_30ck820 FIND v(dout0_30) AT=830.05n

.meas tran vdout0_31ck820 FIND v(dout0_31) AT=830.05n

.meas tran vdout0_32ck820 FIND v(dout0_32) AT=830.05n

.meas tran vdout0_33ck820 FIND v(dout0_33) AT=830.05n

.meas tran vdout0_34ck820 FIND v(dout0_34) AT=830.05n

.meas tran vdout0_35ck820 FIND v(dout0_35) AT=830.05n

.meas tran vdout0_36ck820 FIND v(dout0_36) AT=830.05n

.meas tran vdout0_37ck820 FIND v(dout0_37) AT=830.05n

.meas tran vdout0_38ck820 FIND v(dout0_38) AT=830.05n

.meas tran vdout0_39ck820 FIND v(dout0_39) AT=830.05n

.meas tran vdout0_40ck820 FIND v(dout0_40) AT=830.05n

.meas tran vdout0_41ck820 FIND v(dout0_41) AT=830.05n

.meas tran vdout0_42ck820 FIND v(dout0_42) AT=830.05n

.meas tran vdout0_43ck820 FIND v(dout0_43) AT=830.05n

.meas tran vdout0_44ck820 FIND v(dout0_44) AT=830.05n

.meas tran vdout0_45ck820 FIND v(dout0_45) AT=830.05n

.meas tran vdout0_46ck820 FIND v(dout0_46) AT=830.05n

.meas tran vdout0_47ck820 FIND v(dout0_47) AT=830.05n

.meas tran vdout0_48ck820 FIND v(dout0_48) AT=830.05n

.meas tran vdout0_49ck820 FIND v(dout0_49) AT=830.05n

.meas tran vdout0_50ck820 FIND v(dout0_50) AT=830.05n

.meas tran vdout0_51ck820 FIND v(dout0_51) AT=830.05n

.meas tran vdout0_52ck820 FIND v(dout0_52) AT=830.05n

.meas tran vdout0_53ck820 FIND v(dout0_53) AT=830.05n

.meas tran vdout0_54ck820 FIND v(dout0_54) AT=830.05n

.meas tran vdout0_55ck820 FIND v(dout0_55) AT=830.05n

.meas tran vdout0_56ck820 FIND v(dout0_56) AT=830.05n

.meas tran vdout0_57ck820 FIND v(dout0_57) AT=830.05n

.meas tran vdout0_58ck820 FIND v(dout0_58) AT=830.05n

.meas tran vdout0_59ck820 FIND v(dout0_59) AT=830.05n

.meas tran vdout0_60ck820 FIND v(dout0_60) AT=830.05n

.meas tran vdout0_61ck820 FIND v(dout0_61) AT=830.05n

.meas tran vdout0_62ck820 FIND v(dout0_62) AT=830.05n

.meas tran vdout0_63ck820 FIND v(dout0_63) AT=830.05n

.meas tran vdout0_64ck820 FIND v(dout0_64) AT=830.05n

.meas tran vdout0_0ck860 FIND v(dout0_0) AT=870.05n

.meas tran vdout0_1ck860 FIND v(dout0_1) AT=870.05n

.meas tran vdout0_2ck860 FIND v(dout0_2) AT=870.05n

.meas tran vdout0_3ck860 FIND v(dout0_3) AT=870.05n

.meas tran vdout0_4ck860 FIND v(dout0_4) AT=870.05n

.meas tran vdout0_5ck860 FIND v(dout0_5) AT=870.05n

.meas tran vdout0_6ck860 FIND v(dout0_6) AT=870.05n

.meas tran vdout0_7ck860 FIND v(dout0_7) AT=870.05n

.meas tran vdout0_8ck860 FIND v(dout0_8) AT=870.05n

.meas tran vdout0_9ck860 FIND v(dout0_9) AT=870.05n

.meas tran vdout0_10ck860 FIND v(dout0_10) AT=870.05n

.meas tran vdout0_11ck860 FIND v(dout0_11) AT=870.05n

.meas tran vdout0_12ck860 FIND v(dout0_12) AT=870.05n

.meas tran vdout0_13ck860 FIND v(dout0_13) AT=870.05n

.meas tran vdout0_14ck860 FIND v(dout0_14) AT=870.05n

.meas tran vdout0_15ck860 FIND v(dout0_15) AT=870.05n

.meas tran vdout0_16ck860 FIND v(dout0_16) AT=870.05n

.meas tran vdout0_17ck860 FIND v(dout0_17) AT=870.05n

.meas tran vdout0_18ck860 FIND v(dout0_18) AT=870.05n

.meas tran vdout0_19ck860 FIND v(dout0_19) AT=870.05n

.meas tran vdout0_20ck860 FIND v(dout0_20) AT=870.05n

.meas tran vdout0_21ck860 FIND v(dout0_21) AT=870.05n

.meas tran vdout0_22ck860 FIND v(dout0_22) AT=870.05n

.meas tran vdout0_23ck860 FIND v(dout0_23) AT=870.05n

.meas tran vdout0_24ck860 FIND v(dout0_24) AT=870.05n

.meas tran vdout0_25ck860 FIND v(dout0_25) AT=870.05n

.meas tran vdout0_26ck860 FIND v(dout0_26) AT=870.05n

.meas tran vdout0_27ck860 FIND v(dout0_27) AT=870.05n

.meas tran vdout0_28ck860 FIND v(dout0_28) AT=870.05n

.meas tran vdout0_29ck860 FIND v(dout0_29) AT=870.05n

.meas tran vdout0_30ck860 FIND v(dout0_30) AT=870.05n

.meas tran vdout0_31ck860 FIND v(dout0_31) AT=870.05n

.meas tran vdout0_32ck860 FIND v(dout0_32) AT=870.05n

.meas tran vdout0_33ck860 FIND v(dout0_33) AT=870.05n

.meas tran vdout0_34ck860 FIND v(dout0_34) AT=870.05n

.meas tran vdout0_35ck860 FIND v(dout0_35) AT=870.05n

.meas tran vdout0_36ck860 FIND v(dout0_36) AT=870.05n

.meas tran vdout0_37ck860 FIND v(dout0_37) AT=870.05n

.meas tran vdout0_38ck860 FIND v(dout0_38) AT=870.05n

.meas tran vdout0_39ck860 FIND v(dout0_39) AT=870.05n

.meas tran vdout0_40ck860 FIND v(dout0_40) AT=870.05n

.meas tran vdout0_41ck860 FIND v(dout0_41) AT=870.05n

.meas tran vdout0_42ck860 FIND v(dout0_42) AT=870.05n

.meas tran vdout0_43ck860 FIND v(dout0_43) AT=870.05n

.meas tran vdout0_44ck860 FIND v(dout0_44) AT=870.05n

.meas tran vdout0_45ck860 FIND v(dout0_45) AT=870.05n

.meas tran vdout0_46ck860 FIND v(dout0_46) AT=870.05n

.meas tran vdout0_47ck860 FIND v(dout0_47) AT=870.05n

.meas tran vdout0_48ck860 FIND v(dout0_48) AT=870.05n

.meas tran vdout0_49ck860 FIND v(dout0_49) AT=870.05n

.meas tran vdout0_50ck860 FIND v(dout0_50) AT=870.05n

.meas tran vdout0_51ck860 FIND v(dout0_51) AT=870.05n

.meas tran vdout0_52ck860 FIND v(dout0_52) AT=870.05n

.meas tran vdout0_53ck860 FIND v(dout0_53) AT=870.05n

.meas tran vdout0_54ck860 FIND v(dout0_54) AT=870.05n

.meas tran vdout0_55ck860 FIND v(dout0_55) AT=870.05n

.meas tran vdout0_56ck860 FIND v(dout0_56) AT=870.05n

.meas tran vdout0_57ck860 FIND v(dout0_57) AT=870.05n

.meas tran vdout0_58ck860 FIND v(dout0_58) AT=870.05n

.meas tran vdout0_59ck860 FIND v(dout0_59) AT=870.05n

.meas tran vdout0_60ck860 FIND v(dout0_60) AT=870.05n

.meas tran vdout0_61ck860 FIND v(dout0_61) AT=870.05n

.meas tran vdout0_62ck860 FIND v(dout0_62) AT=870.05n

.meas tran vdout0_63ck860 FIND v(dout0_63) AT=870.05n

.meas tran vdout0_64ck860 FIND v(dout0_64) AT=870.05n

.meas tran vdout0_0ck980 FIND v(dout0_0) AT=990.05n

.meas tran vdout0_1ck980 FIND v(dout0_1) AT=990.05n

.meas tran vdout0_2ck980 FIND v(dout0_2) AT=990.05n

.meas tran vdout0_3ck980 FIND v(dout0_3) AT=990.05n

.meas tran vdout0_4ck980 FIND v(dout0_4) AT=990.05n

.meas tran vdout0_5ck980 FIND v(dout0_5) AT=990.05n

.meas tran vdout0_6ck980 FIND v(dout0_6) AT=990.05n

.meas tran vdout0_7ck980 FIND v(dout0_7) AT=990.05n

.meas tran vdout0_8ck980 FIND v(dout0_8) AT=990.05n

.meas tran vdout0_9ck980 FIND v(dout0_9) AT=990.05n

.meas tran vdout0_10ck980 FIND v(dout0_10) AT=990.05n

.meas tran vdout0_11ck980 FIND v(dout0_11) AT=990.05n

.meas tran vdout0_12ck980 FIND v(dout0_12) AT=990.05n

.meas tran vdout0_13ck980 FIND v(dout0_13) AT=990.05n

.meas tran vdout0_14ck980 FIND v(dout0_14) AT=990.05n

.meas tran vdout0_15ck980 FIND v(dout0_15) AT=990.05n

.meas tran vdout0_16ck980 FIND v(dout0_16) AT=990.05n

.meas tran vdout0_17ck980 FIND v(dout0_17) AT=990.05n

.meas tran vdout0_18ck980 FIND v(dout0_18) AT=990.05n

.meas tran vdout0_19ck980 FIND v(dout0_19) AT=990.05n

.meas tran vdout0_20ck980 FIND v(dout0_20) AT=990.05n

.meas tran vdout0_21ck980 FIND v(dout0_21) AT=990.05n

.meas tran vdout0_22ck980 FIND v(dout0_22) AT=990.05n

.meas tran vdout0_23ck980 FIND v(dout0_23) AT=990.05n

.meas tran vdout0_24ck980 FIND v(dout0_24) AT=990.05n

.meas tran vdout0_25ck980 FIND v(dout0_25) AT=990.05n

.meas tran vdout0_26ck980 FIND v(dout0_26) AT=990.05n

.meas tran vdout0_27ck980 FIND v(dout0_27) AT=990.05n

.meas tran vdout0_28ck980 FIND v(dout0_28) AT=990.05n

.meas tran vdout0_29ck980 FIND v(dout0_29) AT=990.05n

.meas tran vdout0_30ck980 FIND v(dout0_30) AT=990.05n

.meas tran vdout0_31ck980 FIND v(dout0_31) AT=990.05n

.meas tran vdout0_32ck980 FIND v(dout0_32) AT=990.05n

.meas tran vdout0_33ck980 FIND v(dout0_33) AT=990.05n

.meas tran vdout0_34ck980 FIND v(dout0_34) AT=990.05n

.meas tran vdout0_35ck980 FIND v(dout0_35) AT=990.05n

.meas tran vdout0_36ck980 FIND v(dout0_36) AT=990.05n

.meas tran vdout0_37ck980 FIND v(dout0_37) AT=990.05n

.meas tran vdout0_38ck980 FIND v(dout0_38) AT=990.05n

.meas tran vdout0_39ck980 FIND v(dout0_39) AT=990.05n

.meas tran vdout0_40ck980 FIND v(dout0_40) AT=990.05n

.meas tran vdout0_41ck980 FIND v(dout0_41) AT=990.05n

.meas tran vdout0_42ck980 FIND v(dout0_42) AT=990.05n

.meas tran vdout0_43ck980 FIND v(dout0_43) AT=990.05n

.meas tran vdout0_44ck980 FIND v(dout0_44) AT=990.05n

.meas tran vdout0_45ck980 FIND v(dout0_45) AT=990.05n

.meas tran vdout0_46ck980 FIND v(dout0_46) AT=990.05n

.meas tran vdout0_47ck980 FIND v(dout0_47) AT=990.05n

.meas tran vdout0_48ck980 FIND v(dout0_48) AT=990.05n

.meas tran vdout0_49ck980 FIND v(dout0_49) AT=990.05n

.meas tran vdout0_50ck980 FIND v(dout0_50) AT=990.05n

.meas tran vdout0_51ck980 FIND v(dout0_51) AT=990.05n

.meas tran vdout0_52ck980 FIND v(dout0_52) AT=990.05n

.meas tran vdout0_53ck980 FIND v(dout0_53) AT=990.05n

.meas tran vdout0_54ck980 FIND v(dout0_54) AT=990.05n

.meas tran vdout0_55ck980 FIND v(dout0_55) AT=990.05n

.meas tran vdout0_56ck980 FIND v(dout0_56) AT=990.05n

.meas tran vdout0_57ck980 FIND v(dout0_57) AT=990.05n

.meas tran vdout0_58ck980 FIND v(dout0_58) AT=990.05n

.meas tran vdout0_59ck980 FIND v(dout0_59) AT=990.05n

.meas tran vdout0_60ck980 FIND v(dout0_60) AT=990.05n

.meas tran vdout0_61ck980 FIND v(dout0_61) AT=990.05n

.meas tran vdout0_62ck980 FIND v(dout0_62) AT=990.05n

.meas tran vdout0_63ck980 FIND v(dout0_63) AT=990.05n

.meas tran vdout0_64ck980 FIND v(dout0_64) AT=990.05n

.meas tran vdout0_0ck1010 FIND v(dout0_0) AT=1020.05n

.meas tran vdout0_1ck1010 FIND v(dout0_1) AT=1020.05n

.meas tran vdout0_2ck1010 FIND v(dout0_2) AT=1020.05n

.meas tran vdout0_3ck1010 FIND v(dout0_3) AT=1020.05n

.meas tran vdout0_4ck1010 FIND v(dout0_4) AT=1020.05n

.meas tran vdout0_5ck1010 FIND v(dout0_5) AT=1020.05n

.meas tran vdout0_6ck1010 FIND v(dout0_6) AT=1020.05n

.meas tran vdout0_7ck1010 FIND v(dout0_7) AT=1020.05n

.meas tran vdout0_8ck1010 FIND v(dout0_8) AT=1020.05n

.meas tran vdout0_9ck1010 FIND v(dout0_9) AT=1020.05n

.meas tran vdout0_10ck1010 FIND v(dout0_10) AT=1020.05n

.meas tran vdout0_11ck1010 FIND v(dout0_11) AT=1020.05n

.meas tran vdout0_12ck1010 FIND v(dout0_12) AT=1020.05n

.meas tran vdout0_13ck1010 FIND v(dout0_13) AT=1020.05n

.meas tran vdout0_14ck1010 FIND v(dout0_14) AT=1020.05n

.meas tran vdout0_15ck1010 FIND v(dout0_15) AT=1020.05n

.meas tran vdout0_16ck1010 FIND v(dout0_16) AT=1020.05n

.meas tran vdout0_17ck1010 FIND v(dout0_17) AT=1020.05n

.meas tran vdout0_18ck1010 FIND v(dout0_18) AT=1020.05n

.meas tran vdout0_19ck1010 FIND v(dout0_19) AT=1020.05n

.meas tran vdout0_20ck1010 FIND v(dout0_20) AT=1020.05n

.meas tran vdout0_21ck1010 FIND v(dout0_21) AT=1020.05n

.meas tran vdout0_22ck1010 FIND v(dout0_22) AT=1020.05n

.meas tran vdout0_23ck1010 FIND v(dout0_23) AT=1020.05n

.meas tran vdout0_24ck1010 FIND v(dout0_24) AT=1020.05n

.meas tran vdout0_25ck1010 FIND v(dout0_25) AT=1020.05n

.meas tran vdout0_26ck1010 FIND v(dout0_26) AT=1020.05n

.meas tran vdout0_27ck1010 FIND v(dout0_27) AT=1020.05n

.meas tran vdout0_28ck1010 FIND v(dout0_28) AT=1020.05n

.meas tran vdout0_29ck1010 FIND v(dout0_29) AT=1020.05n

.meas tran vdout0_30ck1010 FIND v(dout0_30) AT=1020.05n

.meas tran vdout0_31ck1010 FIND v(dout0_31) AT=1020.05n

.meas tran vdout0_32ck1010 FIND v(dout0_32) AT=1020.05n

.meas tran vdout0_33ck1010 FIND v(dout0_33) AT=1020.05n

.meas tran vdout0_34ck1010 FIND v(dout0_34) AT=1020.05n

.meas tran vdout0_35ck1010 FIND v(dout0_35) AT=1020.05n

.meas tran vdout0_36ck1010 FIND v(dout0_36) AT=1020.05n

.meas tran vdout0_37ck1010 FIND v(dout0_37) AT=1020.05n

.meas tran vdout0_38ck1010 FIND v(dout0_38) AT=1020.05n

.meas tran vdout0_39ck1010 FIND v(dout0_39) AT=1020.05n

.meas tran vdout0_40ck1010 FIND v(dout0_40) AT=1020.05n

.meas tran vdout0_41ck1010 FIND v(dout0_41) AT=1020.05n

.meas tran vdout0_42ck1010 FIND v(dout0_42) AT=1020.05n

.meas tran vdout0_43ck1010 FIND v(dout0_43) AT=1020.05n

.meas tran vdout0_44ck1010 FIND v(dout0_44) AT=1020.05n

.meas tran vdout0_45ck1010 FIND v(dout0_45) AT=1020.05n

.meas tran vdout0_46ck1010 FIND v(dout0_46) AT=1020.05n

.meas tran vdout0_47ck1010 FIND v(dout0_47) AT=1020.05n

.meas tran vdout0_48ck1010 FIND v(dout0_48) AT=1020.05n

.meas tran vdout0_49ck1010 FIND v(dout0_49) AT=1020.05n

.meas tran vdout0_50ck1010 FIND v(dout0_50) AT=1020.05n

.meas tran vdout0_51ck1010 FIND v(dout0_51) AT=1020.05n

.meas tran vdout0_52ck1010 FIND v(dout0_52) AT=1020.05n

.meas tran vdout0_53ck1010 FIND v(dout0_53) AT=1020.05n

.meas tran vdout0_54ck1010 FIND v(dout0_54) AT=1020.05n

.meas tran vdout0_55ck1010 FIND v(dout0_55) AT=1020.05n

.meas tran vdout0_56ck1010 FIND v(dout0_56) AT=1020.05n

.meas tran vdout0_57ck1010 FIND v(dout0_57) AT=1020.05n

.meas tran vdout0_58ck1010 FIND v(dout0_58) AT=1020.05n

.meas tran vdout0_59ck1010 FIND v(dout0_59) AT=1020.05n

.meas tran vdout0_60ck1010 FIND v(dout0_60) AT=1020.05n

.meas tran vdout0_61ck1010 FIND v(dout0_61) AT=1020.05n

.meas tran vdout0_62ck1010 FIND v(dout0_62) AT=1020.05n

.meas tran vdout0_63ck1010 FIND v(dout0_63) AT=1020.05n

.meas tran vdout0_64ck1010 FIND v(dout0_64) AT=1020.05n

.meas tran vdout0_0ck1080 FIND v(dout0_0) AT=1090.05n

.meas tran vdout0_1ck1080 FIND v(dout0_1) AT=1090.05n

.meas tran vdout0_2ck1080 FIND v(dout0_2) AT=1090.05n

.meas tran vdout0_3ck1080 FIND v(dout0_3) AT=1090.05n

.meas tran vdout0_4ck1080 FIND v(dout0_4) AT=1090.05n

.meas tran vdout0_5ck1080 FIND v(dout0_5) AT=1090.05n

.meas tran vdout0_6ck1080 FIND v(dout0_6) AT=1090.05n

.meas tran vdout0_7ck1080 FIND v(dout0_7) AT=1090.05n

.meas tran vdout0_8ck1080 FIND v(dout0_8) AT=1090.05n

.meas tran vdout0_9ck1080 FIND v(dout0_9) AT=1090.05n

.meas tran vdout0_10ck1080 FIND v(dout0_10) AT=1090.05n

.meas tran vdout0_11ck1080 FIND v(dout0_11) AT=1090.05n

.meas tran vdout0_12ck1080 FIND v(dout0_12) AT=1090.05n

.meas tran vdout0_13ck1080 FIND v(dout0_13) AT=1090.05n

.meas tran vdout0_14ck1080 FIND v(dout0_14) AT=1090.05n

.meas tran vdout0_15ck1080 FIND v(dout0_15) AT=1090.05n

.meas tran vdout0_16ck1080 FIND v(dout0_16) AT=1090.05n

.meas tran vdout0_17ck1080 FIND v(dout0_17) AT=1090.05n

.meas tran vdout0_18ck1080 FIND v(dout0_18) AT=1090.05n

.meas tran vdout0_19ck1080 FIND v(dout0_19) AT=1090.05n

.meas tran vdout0_20ck1080 FIND v(dout0_20) AT=1090.05n

.meas tran vdout0_21ck1080 FIND v(dout0_21) AT=1090.05n

.meas tran vdout0_22ck1080 FIND v(dout0_22) AT=1090.05n

.meas tran vdout0_23ck1080 FIND v(dout0_23) AT=1090.05n

.meas tran vdout0_24ck1080 FIND v(dout0_24) AT=1090.05n

.meas tran vdout0_25ck1080 FIND v(dout0_25) AT=1090.05n

.meas tran vdout0_26ck1080 FIND v(dout0_26) AT=1090.05n

.meas tran vdout0_27ck1080 FIND v(dout0_27) AT=1090.05n

.meas tran vdout0_28ck1080 FIND v(dout0_28) AT=1090.05n

.meas tran vdout0_29ck1080 FIND v(dout0_29) AT=1090.05n

.meas tran vdout0_30ck1080 FIND v(dout0_30) AT=1090.05n

.meas tran vdout0_31ck1080 FIND v(dout0_31) AT=1090.05n

.meas tran vdout0_32ck1080 FIND v(dout0_32) AT=1090.05n

.meas tran vdout0_33ck1080 FIND v(dout0_33) AT=1090.05n

.meas tran vdout0_34ck1080 FIND v(dout0_34) AT=1090.05n

.meas tran vdout0_35ck1080 FIND v(dout0_35) AT=1090.05n

.meas tran vdout0_36ck1080 FIND v(dout0_36) AT=1090.05n

.meas tran vdout0_37ck1080 FIND v(dout0_37) AT=1090.05n

.meas tran vdout0_38ck1080 FIND v(dout0_38) AT=1090.05n

.meas tran vdout0_39ck1080 FIND v(dout0_39) AT=1090.05n

.meas tran vdout0_40ck1080 FIND v(dout0_40) AT=1090.05n

.meas tran vdout0_41ck1080 FIND v(dout0_41) AT=1090.05n

.meas tran vdout0_42ck1080 FIND v(dout0_42) AT=1090.05n

.meas tran vdout0_43ck1080 FIND v(dout0_43) AT=1090.05n

.meas tran vdout0_44ck1080 FIND v(dout0_44) AT=1090.05n

.meas tran vdout0_45ck1080 FIND v(dout0_45) AT=1090.05n

.meas tran vdout0_46ck1080 FIND v(dout0_46) AT=1090.05n

.meas tran vdout0_47ck1080 FIND v(dout0_47) AT=1090.05n

.meas tran vdout0_48ck1080 FIND v(dout0_48) AT=1090.05n

.meas tran vdout0_49ck1080 FIND v(dout0_49) AT=1090.05n

.meas tran vdout0_50ck1080 FIND v(dout0_50) AT=1090.05n

.meas tran vdout0_51ck1080 FIND v(dout0_51) AT=1090.05n

.meas tran vdout0_52ck1080 FIND v(dout0_52) AT=1090.05n

.meas tran vdout0_53ck1080 FIND v(dout0_53) AT=1090.05n

.meas tran vdout0_54ck1080 FIND v(dout0_54) AT=1090.05n

.meas tran vdout0_55ck1080 FIND v(dout0_55) AT=1090.05n

.meas tran vdout0_56ck1080 FIND v(dout0_56) AT=1090.05n

.meas tran vdout0_57ck1080 FIND v(dout0_57) AT=1090.05n

.meas tran vdout0_58ck1080 FIND v(dout0_58) AT=1090.05n

.meas tran vdout0_59ck1080 FIND v(dout0_59) AT=1090.05n

.meas tran vdout0_60ck1080 FIND v(dout0_60) AT=1090.05n

.meas tran vdout0_61ck1080 FIND v(dout0_61) AT=1090.05n

.meas tran vdout0_62ck1080 FIND v(dout0_62) AT=1090.05n

.meas tran vdout0_63ck1080 FIND v(dout0_63) AT=1090.05n

.meas tran vdout0_64ck1080 FIND v(dout0_64) AT=1090.05n

.meas tran vdout0_0ck1100 FIND v(dout0_0) AT=1110.05n

.meas tran vdout0_1ck1100 FIND v(dout0_1) AT=1110.05n

.meas tran vdout0_2ck1100 FIND v(dout0_2) AT=1110.05n

.meas tran vdout0_3ck1100 FIND v(dout0_3) AT=1110.05n

.meas tran vdout0_4ck1100 FIND v(dout0_4) AT=1110.05n

.meas tran vdout0_5ck1100 FIND v(dout0_5) AT=1110.05n

.meas tran vdout0_6ck1100 FIND v(dout0_6) AT=1110.05n

.meas tran vdout0_7ck1100 FIND v(dout0_7) AT=1110.05n

.meas tran vdout0_8ck1100 FIND v(dout0_8) AT=1110.05n

.meas tran vdout0_9ck1100 FIND v(dout0_9) AT=1110.05n

.meas tran vdout0_10ck1100 FIND v(dout0_10) AT=1110.05n

.meas tran vdout0_11ck1100 FIND v(dout0_11) AT=1110.05n

.meas tran vdout0_12ck1100 FIND v(dout0_12) AT=1110.05n

.meas tran vdout0_13ck1100 FIND v(dout0_13) AT=1110.05n

.meas tran vdout0_14ck1100 FIND v(dout0_14) AT=1110.05n

.meas tran vdout0_15ck1100 FIND v(dout0_15) AT=1110.05n

.meas tran vdout0_16ck1100 FIND v(dout0_16) AT=1110.05n

.meas tran vdout0_17ck1100 FIND v(dout0_17) AT=1110.05n

.meas tran vdout0_18ck1100 FIND v(dout0_18) AT=1110.05n

.meas tran vdout0_19ck1100 FIND v(dout0_19) AT=1110.05n

.meas tran vdout0_20ck1100 FIND v(dout0_20) AT=1110.05n

.meas tran vdout0_21ck1100 FIND v(dout0_21) AT=1110.05n

.meas tran vdout0_22ck1100 FIND v(dout0_22) AT=1110.05n

.meas tran vdout0_23ck1100 FIND v(dout0_23) AT=1110.05n

.meas tran vdout0_24ck1100 FIND v(dout0_24) AT=1110.05n

.meas tran vdout0_25ck1100 FIND v(dout0_25) AT=1110.05n

.meas tran vdout0_26ck1100 FIND v(dout0_26) AT=1110.05n

.meas tran vdout0_27ck1100 FIND v(dout0_27) AT=1110.05n

.meas tran vdout0_28ck1100 FIND v(dout0_28) AT=1110.05n

.meas tran vdout0_29ck1100 FIND v(dout0_29) AT=1110.05n

.meas tran vdout0_30ck1100 FIND v(dout0_30) AT=1110.05n

.meas tran vdout0_31ck1100 FIND v(dout0_31) AT=1110.05n

.meas tran vdout0_32ck1100 FIND v(dout0_32) AT=1110.05n

.meas tran vdout0_33ck1100 FIND v(dout0_33) AT=1110.05n

.meas tran vdout0_34ck1100 FIND v(dout0_34) AT=1110.05n

.meas tran vdout0_35ck1100 FIND v(dout0_35) AT=1110.05n

.meas tran vdout0_36ck1100 FIND v(dout0_36) AT=1110.05n

.meas tran vdout0_37ck1100 FIND v(dout0_37) AT=1110.05n

.meas tran vdout0_38ck1100 FIND v(dout0_38) AT=1110.05n

.meas tran vdout0_39ck1100 FIND v(dout0_39) AT=1110.05n

.meas tran vdout0_40ck1100 FIND v(dout0_40) AT=1110.05n

.meas tran vdout0_41ck1100 FIND v(dout0_41) AT=1110.05n

.meas tran vdout0_42ck1100 FIND v(dout0_42) AT=1110.05n

.meas tran vdout0_43ck1100 FIND v(dout0_43) AT=1110.05n

.meas tran vdout0_44ck1100 FIND v(dout0_44) AT=1110.05n

.meas tran vdout0_45ck1100 FIND v(dout0_45) AT=1110.05n

.meas tran vdout0_46ck1100 FIND v(dout0_46) AT=1110.05n

.meas tran vdout0_47ck1100 FIND v(dout0_47) AT=1110.05n

.meas tran vdout0_48ck1100 FIND v(dout0_48) AT=1110.05n

.meas tran vdout0_49ck1100 FIND v(dout0_49) AT=1110.05n

.meas tran vdout0_50ck1100 FIND v(dout0_50) AT=1110.05n

.meas tran vdout0_51ck1100 FIND v(dout0_51) AT=1110.05n

.meas tran vdout0_52ck1100 FIND v(dout0_52) AT=1110.05n

.meas tran vdout0_53ck1100 FIND v(dout0_53) AT=1110.05n

.meas tran vdout0_54ck1100 FIND v(dout0_54) AT=1110.05n

.meas tran vdout0_55ck1100 FIND v(dout0_55) AT=1110.05n

.meas tran vdout0_56ck1100 FIND v(dout0_56) AT=1110.05n

.meas tran vdout0_57ck1100 FIND v(dout0_57) AT=1110.05n

.meas tran vdout0_58ck1100 FIND v(dout0_58) AT=1110.05n

.meas tran vdout0_59ck1100 FIND v(dout0_59) AT=1110.05n

.meas tran vdout0_60ck1100 FIND v(dout0_60) AT=1110.05n

.meas tran vdout0_61ck1100 FIND v(dout0_61) AT=1110.05n

.meas tran vdout0_62ck1100 FIND v(dout0_62) AT=1110.05n

.meas tran vdout0_63ck1100 FIND v(dout0_63) AT=1110.05n

.meas tran vdout0_64ck1100 FIND v(dout0_64) AT=1110.05n

.meas tran vdout0_0ck1130 FIND v(dout0_0) AT=1140.05n

.meas tran vdout0_1ck1130 FIND v(dout0_1) AT=1140.05n

.meas tran vdout0_2ck1130 FIND v(dout0_2) AT=1140.05n

.meas tran vdout0_3ck1130 FIND v(dout0_3) AT=1140.05n

.meas tran vdout0_4ck1130 FIND v(dout0_4) AT=1140.05n

.meas tran vdout0_5ck1130 FIND v(dout0_5) AT=1140.05n

.meas tran vdout0_6ck1130 FIND v(dout0_6) AT=1140.05n

.meas tran vdout0_7ck1130 FIND v(dout0_7) AT=1140.05n

.meas tran vdout0_8ck1130 FIND v(dout0_8) AT=1140.05n

.meas tran vdout0_9ck1130 FIND v(dout0_9) AT=1140.05n

.meas tran vdout0_10ck1130 FIND v(dout0_10) AT=1140.05n

.meas tran vdout0_11ck1130 FIND v(dout0_11) AT=1140.05n

.meas tran vdout0_12ck1130 FIND v(dout0_12) AT=1140.05n

.meas tran vdout0_13ck1130 FIND v(dout0_13) AT=1140.05n

.meas tran vdout0_14ck1130 FIND v(dout0_14) AT=1140.05n

.meas tran vdout0_15ck1130 FIND v(dout0_15) AT=1140.05n

.meas tran vdout0_16ck1130 FIND v(dout0_16) AT=1140.05n

.meas tran vdout0_17ck1130 FIND v(dout0_17) AT=1140.05n

.meas tran vdout0_18ck1130 FIND v(dout0_18) AT=1140.05n

.meas tran vdout0_19ck1130 FIND v(dout0_19) AT=1140.05n

.meas tran vdout0_20ck1130 FIND v(dout0_20) AT=1140.05n

.meas tran vdout0_21ck1130 FIND v(dout0_21) AT=1140.05n

.meas tran vdout0_22ck1130 FIND v(dout0_22) AT=1140.05n

.meas tran vdout0_23ck1130 FIND v(dout0_23) AT=1140.05n

.meas tran vdout0_24ck1130 FIND v(dout0_24) AT=1140.05n

.meas tran vdout0_25ck1130 FIND v(dout0_25) AT=1140.05n

.meas tran vdout0_26ck1130 FIND v(dout0_26) AT=1140.05n

.meas tran vdout0_27ck1130 FIND v(dout0_27) AT=1140.05n

.meas tran vdout0_28ck1130 FIND v(dout0_28) AT=1140.05n

.meas tran vdout0_29ck1130 FIND v(dout0_29) AT=1140.05n

.meas tran vdout0_30ck1130 FIND v(dout0_30) AT=1140.05n

.meas tran vdout0_31ck1130 FIND v(dout0_31) AT=1140.05n

.meas tran vdout0_32ck1130 FIND v(dout0_32) AT=1140.05n

.meas tran vdout0_33ck1130 FIND v(dout0_33) AT=1140.05n

.meas tran vdout0_34ck1130 FIND v(dout0_34) AT=1140.05n

.meas tran vdout0_35ck1130 FIND v(dout0_35) AT=1140.05n

.meas tran vdout0_36ck1130 FIND v(dout0_36) AT=1140.05n

.meas tran vdout0_37ck1130 FIND v(dout0_37) AT=1140.05n

.meas tran vdout0_38ck1130 FIND v(dout0_38) AT=1140.05n

.meas tran vdout0_39ck1130 FIND v(dout0_39) AT=1140.05n

.meas tran vdout0_40ck1130 FIND v(dout0_40) AT=1140.05n

.meas tran vdout0_41ck1130 FIND v(dout0_41) AT=1140.05n

.meas tran vdout0_42ck1130 FIND v(dout0_42) AT=1140.05n

.meas tran vdout0_43ck1130 FIND v(dout0_43) AT=1140.05n

.meas tran vdout0_44ck1130 FIND v(dout0_44) AT=1140.05n

.meas tran vdout0_45ck1130 FIND v(dout0_45) AT=1140.05n

.meas tran vdout0_46ck1130 FIND v(dout0_46) AT=1140.05n

.meas tran vdout0_47ck1130 FIND v(dout0_47) AT=1140.05n

.meas tran vdout0_48ck1130 FIND v(dout0_48) AT=1140.05n

.meas tran vdout0_49ck1130 FIND v(dout0_49) AT=1140.05n

.meas tran vdout0_50ck1130 FIND v(dout0_50) AT=1140.05n

.meas tran vdout0_51ck1130 FIND v(dout0_51) AT=1140.05n

.meas tran vdout0_52ck1130 FIND v(dout0_52) AT=1140.05n

.meas tran vdout0_53ck1130 FIND v(dout0_53) AT=1140.05n

.meas tran vdout0_54ck1130 FIND v(dout0_54) AT=1140.05n

.meas tran vdout0_55ck1130 FIND v(dout0_55) AT=1140.05n

.meas tran vdout0_56ck1130 FIND v(dout0_56) AT=1140.05n

.meas tran vdout0_57ck1130 FIND v(dout0_57) AT=1140.05n

.meas tran vdout0_58ck1130 FIND v(dout0_58) AT=1140.05n

.meas tran vdout0_59ck1130 FIND v(dout0_59) AT=1140.05n

.meas tran vdout0_60ck1130 FIND v(dout0_60) AT=1140.05n

.meas tran vdout0_61ck1130 FIND v(dout0_61) AT=1140.05n

.meas tran vdout0_62ck1130 FIND v(dout0_62) AT=1140.05n

.meas tran vdout0_63ck1130 FIND v(dout0_63) AT=1140.05n

.meas tran vdout0_64ck1130 FIND v(dout0_64) AT=1140.05n

.meas tran vdout0_0ck1190 FIND v(dout0_0) AT=1200.05n

.meas tran vdout0_1ck1190 FIND v(dout0_1) AT=1200.05n

.meas tran vdout0_2ck1190 FIND v(dout0_2) AT=1200.05n

.meas tran vdout0_3ck1190 FIND v(dout0_3) AT=1200.05n

.meas tran vdout0_4ck1190 FIND v(dout0_4) AT=1200.05n

.meas tran vdout0_5ck1190 FIND v(dout0_5) AT=1200.05n

.meas tran vdout0_6ck1190 FIND v(dout0_6) AT=1200.05n

.meas tran vdout0_7ck1190 FIND v(dout0_7) AT=1200.05n

.meas tran vdout0_8ck1190 FIND v(dout0_8) AT=1200.05n

.meas tran vdout0_9ck1190 FIND v(dout0_9) AT=1200.05n

.meas tran vdout0_10ck1190 FIND v(dout0_10) AT=1200.05n

.meas tran vdout0_11ck1190 FIND v(dout0_11) AT=1200.05n

.meas tran vdout0_12ck1190 FIND v(dout0_12) AT=1200.05n

.meas tran vdout0_13ck1190 FIND v(dout0_13) AT=1200.05n

.meas tran vdout0_14ck1190 FIND v(dout0_14) AT=1200.05n

.meas tran vdout0_15ck1190 FIND v(dout0_15) AT=1200.05n

.meas tran vdout0_16ck1190 FIND v(dout0_16) AT=1200.05n

.meas tran vdout0_17ck1190 FIND v(dout0_17) AT=1200.05n

.meas tran vdout0_18ck1190 FIND v(dout0_18) AT=1200.05n

.meas tran vdout0_19ck1190 FIND v(dout0_19) AT=1200.05n

.meas tran vdout0_20ck1190 FIND v(dout0_20) AT=1200.05n

.meas tran vdout0_21ck1190 FIND v(dout0_21) AT=1200.05n

.meas tran vdout0_22ck1190 FIND v(dout0_22) AT=1200.05n

.meas tran vdout0_23ck1190 FIND v(dout0_23) AT=1200.05n

.meas tran vdout0_24ck1190 FIND v(dout0_24) AT=1200.05n

.meas tran vdout0_25ck1190 FIND v(dout0_25) AT=1200.05n

.meas tran vdout0_26ck1190 FIND v(dout0_26) AT=1200.05n

.meas tran vdout0_27ck1190 FIND v(dout0_27) AT=1200.05n

.meas tran vdout0_28ck1190 FIND v(dout0_28) AT=1200.05n

.meas tran vdout0_29ck1190 FIND v(dout0_29) AT=1200.05n

.meas tran vdout0_30ck1190 FIND v(dout0_30) AT=1200.05n

.meas tran vdout0_31ck1190 FIND v(dout0_31) AT=1200.05n

.meas tran vdout0_32ck1190 FIND v(dout0_32) AT=1200.05n

.meas tran vdout0_33ck1190 FIND v(dout0_33) AT=1200.05n

.meas tran vdout0_34ck1190 FIND v(dout0_34) AT=1200.05n

.meas tran vdout0_35ck1190 FIND v(dout0_35) AT=1200.05n

.meas tran vdout0_36ck1190 FIND v(dout0_36) AT=1200.05n

.meas tran vdout0_37ck1190 FIND v(dout0_37) AT=1200.05n

.meas tran vdout0_38ck1190 FIND v(dout0_38) AT=1200.05n

.meas tran vdout0_39ck1190 FIND v(dout0_39) AT=1200.05n

.meas tran vdout0_40ck1190 FIND v(dout0_40) AT=1200.05n

.meas tran vdout0_41ck1190 FIND v(dout0_41) AT=1200.05n

.meas tran vdout0_42ck1190 FIND v(dout0_42) AT=1200.05n

.meas tran vdout0_43ck1190 FIND v(dout0_43) AT=1200.05n

.meas tran vdout0_44ck1190 FIND v(dout0_44) AT=1200.05n

.meas tran vdout0_45ck1190 FIND v(dout0_45) AT=1200.05n

.meas tran vdout0_46ck1190 FIND v(dout0_46) AT=1200.05n

.meas tran vdout0_47ck1190 FIND v(dout0_47) AT=1200.05n

.meas tran vdout0_48ck1190 FIND v(dout0_48) AT=1200.05n

.meas tran vdout0_49ck1190 FIND v(dout0_49) AT=1200.05n

.meas tran vdout0_50ck1190 FIND v(dout0_50) AT=1200.05n

.meas tran vdout0_51ck1190 FIND v(dout0_51) AT=1200.05n

.meas tran vdout0_52ck1190 FIND v(dout0_52) AT=1200.05n

.meas tran vdout0_53ck1190 FIND v(dout0_53) AT=1200.05n

.meas tran vdout0_54ck1190 FIND v(dout0_54) AT=1200.05n

.meas tran vdout0_55ck1190 FIND v(dout0_55) AT=1200.05n

.meas tran vdout0_56ck1190 FIND v(dout0_56) AT=1200.05n

.meas tran vdout0_57ck1190 FIND v(dout0_57) AT=1200.05n

.meas tran vdout0_58ck1190 FIND v(dout0_58) AT=1200.05n

.meas tran vdout0_59ck1190 FIND v(dout0_59) AT=1200.05n

.meas tran vdout0_60ck1190 FIND v(dout0_60) AT=1200.05n

.meas tran vdout0_61ck1190 FIND v(dout0_61) AT=1200.05n

.meas tran vdout0_62ck1190 FIND v(dout0_62) AT=1200.05n

.meas tran vdout0_63ck1190 FIND v(dout0_63) AT=1200.05n

.meas tran vdout0_64ck1190 FIND v(dout0_64) AT=1200.05n

.meas tran vdout0_0ck1210 FIND v(dout0_0) AT=1220.05n

.meas tran vdout0_1ck1210 FIND v(dout0_1) AT=1220.05n

.meas tran vdout0_2ck1210 FIND v(dout0_2) AT=1220.05n

.meas tran vdout0_3ck1210 FIND v(dout0_3) AT=1220.05n

.meas tran vdout0_4ck1210 FIND v(dout0_4) AT=1220.05n

.meas tran vdout0_5ck1210 FIND v(dout0_5) AT=1220.05n

.meas tran vdout0_6ck1210 FIND v(dout0_6) AT=1220.05n

.meas tran vdout0_7ck1210 FIND v(dout0_7) AT=1220.05n

.meas tran vdout0_8ck1210 FIND v(dout0_8) AT=1220.05n

.meas tran vdout0_9ck1210 FIND v(dout0_9) AT=1220.05n

.meas tran vdout0_10ck1210 FIND v(dout0_10) AT=1220.05n

.meas tran vdout0_11ck1210 FIND v(dout0_11) AT=1220.05n

.meas tran vdout0_12ck1210 FIND v(dout0_12) AT=1220.05n

.meas tran vdout0_13ck1210 FIND v(dout0_13) AT=1220.05n

.meas tran vdout0_14ck1210 FIND v(dout0_14) AT=1220.05n

.meas tran vdout0_15ck1210 FIND v(dout0_15) AT=1220.05n

.meas tran vdout0_16ck1210 FIND v(dout0_16) AT=1220.05n

.meas tran vdout0_17ck1210 FIND v(dout0_17) AT=1220.05n

.meas tran vdout0_18ck1210 FIND v(dout0_18) AT=1220.05n

.meas tran vdout0_19ck1210 FIND v(dout0_19) AT=1220.05n

.meas tran vdout0_20ck1210 FIND v(dout0_20) AT=1220.05n

.meas tran vdout0_21ck1210 FIND v(dout0_21) AT=1220.05n

.meas tran vdout0_22ck1210 FIND v(dout0_22) AT=1220.05n

.meas tran vdout0_23ck1210 FIND v(dout0_23) AT=1220.05n

.meas tran vdout0_24ck1210 FIND v(dout0_24) AT=1220.05n

.meas tran vdout0_25ck1210 FIND v(dout0_25) AT=1220.05n

.meas tran vdout0_26ck1210 FIND v(dout0_26) AT=1220.05n

.meas tran vdout0_27ck1210 FIND v(dout0_27) AT=1220.05n

.meas tran vdout0_28ck1210 FIND v(dout0_28) AT=1220.05n

.meas tran vdout0_29ck1210 FIND v(dout0_29) AT=1220.05n

.meas tran vdout0_30ck1210 FIND v(dout0_30) AT=1220.05n

.meas tran vdout0_31ck1210 FIND v(dout0_31) AT=1220.05n

.meas tran vdout0_32ck1210 FIND v(dout0_32) AT=1220.05n

.meas tran vdout0_33ck1210 FIND v(dout0_33) AT=1220.05n

.meas tran vdout0_34ck1210 FIND v(dout0_34) AT=1220.05n

.meas tran vdout0_35ck1210 FIND v(dout0_35) AT=1220.05n

.meas tran vdout0_36ck1210 FIND v(dout0_36) AT=1220.05n

.meas tran vdout0_37ck1210 FIND v(dout0_37) AT=1220.05n

.meas tran vdout0_38ck1210 FIND v(dout0_38) AT=1220.05n

.meas tran vdout0_39ck1210 FIND v(dout0_39) AT=1220.05n

.meas tran vdout0_40ck1210 FIND v(dout0_40) AT=1220.05n

.meas tran vdout0_41ck1210 FIND v(dout0_41) AT=1220.05n

.meas tran vdout0_42ck1210 FIND v(dout0_42) AT=1220.05n

.meas tran vdout0_43ck1210 FIND v(dout0_43) AT=1220.05n

.meas tran vdout0_44ck1210 FIND v(dout0_44) AT=1220.05n

.meas tran vdout0_45ck1210 FIND v(dout0_45) AT=1220.05n

.meas tran vdout0_46ck1210 FIND v(dout0_46) AT=1220.05n

.meas tran vdout0_47ck1210 FIND v(dout0_47) AT=1220.05n

.meas tran vdout0_48ck1210 FIND v(dout0_48) AT=1220.05n

.meas tran vdout0_49ck1210 FIND v(dout0_49) AT=1220.05n

.meas tran vdout0_50ck1210 FIND v(dout0_50) AT=1220.05n

.meas tran vdout0_51ck1210 FIND v(dout0_51) AT=1220.05n

.meas tran vdout0_52ck1210 FIND v(dout0_52) AT=1220.05n

.meas tran vdout0_53ck1210 FIND v(dout0_53) AT=1220.05n

.meas tran vdout0_54ck1210 FIND v(dout0_54) AT=1220.05n

.meas tran vdout0_55ck1210 FIND v(dout0_55) AT=1220.05n

.meas tran vdout0_56ck1210 FIND v(dout0_56) AT=1220.05n

.meas tran vdout0_57ck1210 FIND v(dout0_57) AT=1220.05n

.meas tran vdout0_58ck1210 FIND v(dout0_58) AT=1220.05n

.meas tran vdout0_59ck1210 FIND v(dout0_59) AT=1220.05n

.meas tran vdout0_60ck1210 FIND v(dout0_60) AT=1220.05n

.meas tran vdout0_61ck1210 FIND v(dout0_61) AT=1220.05n

.meas tran vdout0_62ck1210 FIND v(dout0_62) AT=1220.05n

.meas tran vdout0_63ck1210 FIND v(dout0_63) AT=1220.05n

.meas tran vdout0_64ck1210 FIND v(dout0_64) AT=1220.05n

.meas tran vdout0_0ck1230 FIND v(dout0_0) AT=1240.05n

.meas tran vdout0_1ck1230 FIND v(dout0_1) AT=1240.05n

.meas tran vdout0_2ck1230 FIND v(dout0_2) AT=1240.05n

.meas tran vdout0_3ck1230 FIND v(dout0_3) AT=1240.05n

.meas tran vdout0_4ck1230 FIND v(dout0_4) AT=1240.05n

.meas tran vdout0_5ck1230 FIND v(dout0_5) AT=1240.05n

.meas tran vdout0_6ck1230 FIND v(dout0_6) AT=1240.05n

.meas tran vdout0_7ck1230 FIND v(dout0_7) AT=1240.05n

.meas tran vdout0_8ck1230 FIND v(dout0_8) AT=1240.05n

.meas tran vdout0_9ck1230 FIND v(dout0_9) AT=1240.05n

.meas tran vdout0_10ck1230 FIND v(dout0_10) AT=1240.05n

.meas tran vdout0_11ck1230 FIND v(dout0_11) AT=1240.05n

.meas tran vdout0_12ck1230 FIND v(dout0_12) AT=1240.05n

.meas tran vdout0_13ck1230 FIND v(dout0_13) AT=1240.05n

.meas tran vdout0_14ck1230 FIND v(dout0_14) AT=1240.05n

.meas tran vdout0_15ck1230 FIND v(dout0_15) AT=1240.05n

.meas tran vdout0_16ck1230 FIND v(dout0_16) AT=1240.05n

.meas tran vdout0_17ck1230 FIND v(dout0_17) AT=1240.05n

.meas tran vdout0_18ck1230 FIND v(dout0_18) AT=1240.05n

.meas tran vdout0_19ck1230 FIND v(dout0_19) AT=1240.05n

.meas tran vdout0_20ck1230 FIND v(dout0_20) AT=1240.05n

.meas tran vdout0_21ck1230 FIND v(dout0_21) AT=1240.05n

.meas tran vdout0_22ck1230 FIND v(dout0_22) AT=1240.05n

.meas tran vdout0_23ck1230 FIND v(dout0_23) AT=1240.05n

.meas tran vdout0_24ck1230 FIND v(dout0_24) AT=1240.05n

.meas tran vdout0_25ck1230 FIND v(dout0_25) AT=1240.05n

.meas tran vdout0_26ck1230 FIND v(dout0_26) AT=1240.05n

.meas tran vdout0_27ck1230 FIND v(dout0_27) AT=1240.05n

.meas tran vdout0_28ck1230 FIND v(dout0_28) AT=1240.05n

.meas tran vdout0_29ck1230 FIND v(dout0_29) AT=1240.05n

.meas tran vdout0_30ck1230 FIND v(dout0_30) AT=1240.05n

.meas tran vdout0_31ck1230 FIND v(dout0_31) AT=1240.05n

.meas tran vdout0_32ck1230 FIND v(dout0_32) AT=1240.05n

.meas tran vdout0_33ck1230 FIND v(dout0_33) AT=1240.05n

.meas tran vdout0_34ck1230 FIND v(dout0_34) AT=1240.05n

.meas tran vdout0_35ck1230 FIND v(dout0_35) AT=1240.05n

.meas tran vdout0_36ck1230 FIND v(dout0_36) AT=1240.05n

.meas tran vdout0_37ck1230 FIND v(dout0_37) AT=1240.05n

.meas tran vdout0_38ck1230 FIND v(dout0_38) AT=1240.05n

.meas tran vdout0_39ck1230 FIND v(dout0_39) AT=1240.05n

.meas tran vdout0_40ck1230 FIND v(dout0_40) AT=1240.05n

.meas tran vdout0_41ck1230 FIND v(dout0_41) AT=1240.05n

.meas tran vdout0_42ck1230 FIND v(dout0_42) AT=1240.05n

.meas tran vdout0_43ck1230 FIND v(dout0_43) AT=1240.05n

.meas tran vdout0_44ck1230 FIND v(dout0_44) AT=1240.05n

.meas tran vdout0_45ck1230 FIND v(dout0_45) AT=1240.05n

.meas tran vdout0_46ck1230 FIND v(dout0_46) AT=1240.05n

.meas tran vdout0_47ck1230 FIND v(dout0_47) AT=1240.05n

.meas tran vdout0_48ck1230 FIND v(dout0_48) AT=1240.05n

.meas tran vdout0_49ck1230 FIND v(dout0_49) AT=1240.05n

.meas tran vdout0_50ck1230 FIND v(dout0_50) AT=1240.05n

.meas tran vdout0_51ck1230 FIND v(dout0_51) AT=1240.05n

.meas tran vdout0_52ck1230 FIND v(dout0_52) AT=1240.05n

.meas tran vdout0_53ck1230 FIND v(dout0_53) AT=1240.05n

.meas tran vdout0_54ck1230 FIND v(dout0_54) AT=1240.05n

.meas tran vdout0_55ck1230 FIND v(dout0_55) AT=1240.05n

.meas tran vdout0_56ck1230 FIND v(dout0_56) AT=1240.05n

.meas tran vdout0_57ck1230 FIND v(dout0_57) AT=1240.05n

.meas tran vdout0_58ck1230 FIND v(dout0_58) AT=1240.05n

.meas tran vdout0_59ck1230 FIND v(dout0_59) AT=1240.05n

.meas tran vdout0_60ck1230 FIND v(dout0_60) AT=1240.05n

.meas tran vdout0_61ck1230 FIND v(dout0_61) AT=1240.05n

.meas tran vdout0_62ck1230 FIND v(dout0_62) AT=1240.05n

.meas tran vdout0_63ck1230 FIND v(dout0_63) AT=1240.05n

.meas tran vdout0_64ck1230 FIND v(dout0_64) AT=1240.05n

.meas tran vdout0_0ck1240 FIND v(dout0_0) AT=1250.05n

.meas tran vdout0_1ck1240 FIND v(dout0_1) AT=1250.05n

.meas tran vdout0_2ck1240 FIND v(dout0_2) AT=1250.05n

.meas tran vdout0_3ck1240 FIND v(dout0_3) AT=1250.05n

.meas tran vdout0_4ck1240 FIND v(dout0_4) AT=1250.05n

.meas tran vdout0_5ck1240 FIND v(dout0_5) AT=1250.05n

.meas tran vdout0_6ck1240 FIND v(dout0_6) AT=1250.05n

.meas tran vdout0_7ck1240 FIND v(dout0_7) AT=1250.05n

.meas tran vdout0_8ck1240 FIND v(dout0_8) AT=1250.05n

.meas tran vdout0_9ck1240 FIND v(dout0_9) AT=1250.05n

.meas tran vdout0_10ck1240 FIND v(dout0_10) AT=1250.05n

.meas tran vdout0_11ck1240 FIND v(dout0_11) AT=1250.05n

.meas tran vdout0_12ck1240 FIND v(dout0_12) AT=1250.05n

.meas tran vdout0_13ck1240 FIND v(dout0_13) AT=1250.05n

.meas tran vdout0_14ck1240 FIND v(dout0_14) AT=1250.05n

.meas tran vdout0_15ck1240 FIND v(dout0_15) AT=1250.05n

.meas tran vdout0_16ck1240 FIND v(dout0_16) AT=1250.05n

.meas tran vdout0_17ck1240 FIND v(dout0_17) AT=1250.05n

.meas tran vdout0_18ck1240 FIND v(dout0_18) AT=1250.05n

.meas tran vdout0_19ck1240 FIND v(dout0_19) AT=1250.05n

.meas tran vdout0_20ck1240 FIND v(dout0_20) AT=1250.05n

.meas tran vdout0_21ck1240 FIND v(dout0_21) AT=1250.05n

.meas tran vdout0_22ck1240 FIND v(dout0_22) AT=1250.05n

.meas tran vdout0_23ck1240 FIND v(dout0_23) AT=1250.05n

.meas tran vdout0_24ck1240 FIND v(dout0_24) AT=1250.05n

.meas tran vdout0_25ck1240 FIND v(dout0_25) AT=1250.05n

.meas tran vdout0_26ck1240 FIND v(dout0_26) AT=1250.05n

.meas tran vdout0_27ck1240 FIND v(dout0_27) AT=1250.05n

.meas tran vdout0_28ck1240 FIND v(dout0_28) AT=1250.05n

.meas tran vdout0_29ck1240 FIND v(dout0_29) AT=1250.05n

.meas tran vdout0_30ck1240 FIND v(dout0_30) AT=1250.05n

.meas tran vdout0_31ck1240 FIND v(dout0_31) AT=1250.05n

.meas tran vdout0_32ck1240 FIND v(dout0_32) AT=1250.05n

.meas tran vdout0_33ck1240 FIND v(dout0_33) AT=1250.05n

.meas tran vdout0_34ck1240 FIND v(dout0_34) AT=1250.05n

.meas tran vdout0_35ck1240 FIND v(dout0_35) AT=1250.05n

.meas tran vdout0_36ck1240 FIND v(dout0_36) AT=1250.05n

.meas tran vdout0_37ck1240 FIND v(dout0_37) AT=1250.05n

.meas tran vdout0_38ck1240 FIND v(dout0_38) AT=1250.05n

.meas tran vdout0_39ck1240 FIND v(dout0_39) AT=1250.05n

.meas tran vdout0_40ck1240 FIND v(dout0_40) AT=1250.05n

.meas tran vdout0_41ck1240 FIND v(dout0_41) AT=1250.05n

.meas tran vdout0_42ck1240 FIND v(dout0_42) AT=1250.05n

.meas tran vdout0_43ck1240 FIND v(dout0_43) AT=1250.05n

.meas tran vdout0_44ck1240 FIND v(dout0_44) AT=1250.05n

.meas tran vdout0_45ck1240 FIND v(dout0_45) AT=1250.05n

.meas tran vdout0_46ck1240 FIND v(dout0_46) AT=1250.05n

.meas tran vdout0_47ck1240 FIND v(dout0_47) AT=1250.05n

.meas tran vdout0_48ck1240 FIND v(dout0_48) AT=1250.05n

.meas tran vdout0_49ck1240 FIND v(dout0_49) AT=1250.05n

.meas tran vdout0_50ck1240 FIND v(dout0_50) AT=1250.05n

.meas tran vdout0_51ck1240 FIND v(dout0_51) AT=1250.05n

.meas tran vdout0_52ck1240 FIND v(dout0_52) AT=1250.05n

.meas tran vdout0_53ck1240 FIND v(dout0_53) AT=1250.05n

.meas tran vdout0_54ck1240 FIND v(dout0_54) AT=1250.05n

.meas tran vdout0_55ck1240 FIND v(dout0_55) AT=1250.05n

.meas tran vdout0_56ck1240 FIND v(dout0_56) AT=1250.05n

.meas tran vdout0_57ck1240 FIND v(dout0_57) AT=1250.05n

.meas tran vdout0_58ck1240 FIND v(dout0_58) AT=1250.05n

.meas tran vdout0_59ck1240 FIND v(dout0_59) AT=1250.05n

.meas tran vdout0_60ck1240 FIND v(dout0_60) AT=1250.05n

.meas tran vdout0_61ck1240 FIND v(dout0_61) AT=1250.05n

.meas tran vdout0_62ck1240 FIND v(dout0_62) AT=1250.05n

.meas tran vdout0_63ck1240 FIND v(dout0_63) AT=1250.05n

.meas tran vdout0_64ck1240 FIND v(dout0_64) AT=1250.05n

.meas tran vdout0_0ck1270 FIND v(dout0_0) AT=1280.05n

.meas tran vdout0_1ck1270 FIND v(dout0_1) AT=1280.05n

.meas tran vdout0_2ck1270 FIND v(dout0_2) AT=1280.05n

.meas tran vdout0_3ck1270 FIND v(dout0_3) AT=1280.05n

.meas tran vdout0_4ck1270 FIND v(dout0_4) AT=1280.05n

.meas tran vdout0_5ck1270 FIND v(dout0_5) AT=1280.05n

.meas tran vdout0_6ck1270 FIND v(dout0_6) AT=1280.05n

.meas tran vdout0_7ck1270 FIND v(dout0_7) AT=1280.05n

.meas tran vdout0_8ck1270 FIND v(dout0_8) AT=1280.05n

.meas tran vdout0_9ck1270 FIND v(dout0_9) AT=1280.05n

.meas tran vdout0_10ck1270 FIND v(dout0_10) AT=1280.05n

.meas tran vdout0_11ck1270 FIND v(dout0_11) AT=1280.05n

.meas tran vdout0_12ck1270 FIND v(dout0_12) AT=1280.05n

.meas tran vdout0_13ck1270 FIND v(dout0_13) AT=1280.05n

.meas tran vdout0_14ck1270 FIND v(dout0_14) AT=1280.05n

.meas tran vdout0_15ck1270 FIND v(dout0_15) AT=1280.05n

.meas tran vdout0_16ck1270 FIND v(dout0_16) AT=1280.05n

.meas tran vdout0_17ck1270 FIND v(dout0_17) AT=1280.05n

.meas tran vdout0_18ck1270 FIND v(dout0_18) AT=1280.05n

.meas tran vdout0_19ck1270 FIND v(dout0_19) AT=1280.05n

.meas tran vdout0_20ck1270 FIND v(dout0_20) AT=1280.05n

.meas tran vdout0_21ck1270 FIND v(dout0_21) AT=1280.05n

.meas tran vdout0_22ck1270 FIND v(dout0_22) AT=1280.05n

.meas tran vdout0_23ck1270 FIND v(dout0_23) AT=1280.05n

.meas tran vdout0_24ck1270 FIND v(dout0_24) AT=1280.05n

.meas tran vdout0_25ck1270 FIND v(dout0_25) AT=1280.05n

.meas tran vdout0_26ck1270 FIND v(dout0_26) AT=1280.05n

.meas tran vdout0_27ck1270 FIND v(dout0_27) AT=1280.05n

.meas tran vdout0_28ck1270 FIND v(dout0_28) AT=1280.05n

.meas tran vdout0_29ck1270 FIND v(dout0_29) AT=1280.05n

.meas tran vdout0_30ck1270 FIND v(dout0_30) AT=1280.05n

.meas tran vdout0_31ck1270 FIND v(dout0_31) AT=1280.05n

.meas tran vdout0_32ck1270 FIND v(dout0_32) AT=1280.05n

.meas tran vdout0_33ck1270 FIND v(dout0_33) AT=1280.05n

.meas tran vdout0_34ck1270 FIND v(dout0_34) AT=1280.05n

.meas tran vdout0_35ck1270 FIND v(dout0_35) AT=1280.05n

.meas tran vdout0_36ck1270 FIND v(dout0_36) AT=1280.05n

.meas tran vdout0_37ck1270 FIND v(dout0_37) AT=1280.05n

.meas tran vdout0_38ck1270 FIND v(dout0_38) AT=1280.05n

.meas tran vdout0_39ck1270 FIND v(dout0_39) AT=1280.05n

.meas tran vdout0_40ck1270 FIND v(dout0_40) AT=1280.05n

.meas tran vdout0_41ck1270 FIND v(dout0_41) AT=1280.05n

.meas tran vdout0_42ck1270 FIND v(dout0_42) AT=1280.05n

.meas tran vdout0_43ck1270 FIND v(dout0_43) AT=1280.05n

.meas tran vdout0_44ck1270 FIND v(dout0_44) AT=1280.05n

.meas tran vdout0_45ck1270 FIND v(dout0_45) AT=1280.05n

.meas tran vdout0_46ck1270 FIND v(dout0_46) AT=1280.05n

.meas tran vdout0_47ck1270 FIND v(dout0_47) AT=1280.05n

.meas tran vdout0_48ck1270 FIND v(dout0_48) AT=1280.05n

.meas tran vdout0_49ck1270 FIND v(dout0_49) AT=1280.05n

.meas tran vdout0_50ck1270 FIND v(dout0_50) AT=1280.05n

.meas tran vdout0_51ck1270 FIND v(dout0_51) AT=1280.05n

.meas tran vdout0_52ck1270 FIND v(dout0_52) AT=1280.05n

.meas tran vdout0_53ck1270 FIND v(dout0_53) AT=1280.05n

.meas tran vdout0_54ck1270 FIND v(dout0_54) AT=1280.05n

.meas tran vdout0_55ck1270 FIND v(dout0_55) AT=1280.05n

.meas tran vdout0_56ck1270 FIND v(dout0_56) AT=1280.05n

.meas tran vdout0_57ck1270 FIND v(dout0_57) AT=1280.05n

.meas tran vdout0_58ck1270 FIND v(dout0_58) AT=1280.05n

.meas tran vdout0_59ck1270 FIND v(dout0_59) AT=1280.05n

.meas tran vdout0_60ck1270 FIND v(dout0_60) AT=1280.05n

.meas tran vdout0_61ck1270 FIND v(dout0_61) AT=1280.05n

.meas tran vdout0_62ck1270 FIND v(dout0_62) AT=1280.05n

.meas tran vdout0_63ck1270 FIND v(dout0_63) AT=1280.05n

.meas tran vdout0_64ck1270 FIND v(dout0_64) AT=1280.05n

.meas tran vdout0_0ck1280 FIND v(dout0_0) AT=1290.05n

.meas tran vdout0_1ck1280 FIND v(dout0_1) AT=1290.05n

.meas tran vdout0_2ck1280 FIND v(dout0_2) AT=1290.05n

.meas tran vdout0_3ck1280 FIND v(dout0_3) AT=1290.05n

.meas tran vdout0_4ck1280 FIND v(dout0_4) AT=1290.05n

.meas tran vdout0_5ck1280 FIND v(dout0_5) AT=1290.05n

.meas tran vdout0_6ck1280 FIND v(dout0_6) AT=1290.05n

.meas tran vdout0_7ck1280 FIND v(dout0_7) AT=1290.05n

.meas tran vdout0_8ck1280 FIND v(dout0_8) AT=1290.05n

.meas tran vdout0_9ck1280 FIND v(dout0_9) AT=1290.05n

.meas tran vdout0_10ck1280 FIND v(dout0_10) AT=1290.05n

.meas tran vdout0_11ck1280 FIND v(dout0_11) AT=1290.05n

.meas tran vdout0_12ck1280 FIND v(dout0_12) AT=1290.05n

.meas tran vdout0_13ck1280 FIND v(dout0_13) AT=1290.05n

.meas tran vdout0_14ck1280 FIND v(dout0_14) AT=1290.05n

.meas tran vdout0_15ck1280 FIND v(dout0_15) AT=1290.05n

.meas tran vdout0_16ck1280 FIND v(dout0_16) AT=1290.05n

.meas tran vdout0_17ck1280 FIND v(dout0_17) AT=1290.05n

.meas tran vdout0_18ck1280 FIND v(dout0_18) AT=1290.05n

.meas tran vdout0_19ck1280 FIND v(dout0_19) AT=1290.05n

.meas tran vdout0_20ck1280 FIND v(dout0_20) AT=1290.05n

.meas tran vdout0_21ck1280 FIND v(dout0_21) AT=1290.05n

.meas tran vdout0_22ck1280 FIND v(dout0_22) AT=1290.05n

.meas tran vdout0_23ck1280 FIND v(dout0_23) AT=1290.05n

.meas tran vdout0_24ck1280 FIND v(dout0_24) AT=1290.05n

.meas tran vdout0_25ck1280 FIND v(dout0_25) AT=1290.05n

.meas tran vdout0_26ck1280 FIND v(dout0_26) AT=1290.05n

.meas tran vdout0_27ck1280 FIND v(dout0_27) AT=1290.05n

.meas tran vdout0_28ck1280 FIND v(dout0_28) AT=1290.05n

.meas tran vdout0_29ck1280 FIND v(dout0_29) AT=1290.05n

.meas tran vdout0_30ck1280 FIND v(dout0_30) AT=1290.05n

.meas tran vdout0_31ck1280 FIND v(dout0_31) AT=1290.05n

.meas tran vdout0_32ck1280 FIND v(dout0_32) AT=1290.05n

.meas tran vdout0_33ck1280 FIND v(dout0_33) AT=1290.05n

.meas tran vdout0_34ck1280 FIND v(dout0_34) AT=1290.05n

.meas tran vdout0_35ck1280 FIND v(dout0_35) AT=1290.05n

.meas tran vdout0_36ck1280 FIND v(dout0_36) AT=1290.05n

.meas tran vdout0_37ck1280 FIND v(dout0_37) AT=1290.05n

.meas tran vdout0_38ck1280 FIND v(dout0_38) AT=1290.05n

.meas tran vdout0_39ck1280 FIND v(dout0_39) AT=1290.05n

.meas tran vdout0_40ck1280 FIND v(dout0_40) AT=1290.05n

.meas tran vdout0_41ck1280 FIND v(dout0_41) AT=1290.05n

.meas tran vdout0_42ck1280 FIND v(dout0_42) AT=1290.05n

.meas tran vdout0_43ck1280 FIND v(dout0_43) AT=1290.05n

.meas tran vdout0_44ck1280 FIND v(dout0_44) AT=1290.05n

.meas tran vdout0_45ck1280 FIND v(dout0_45) AT=1290.05n

.meas tran vdout0_46ck1280 FIND v(dout0_46) AT=1290.05n

.meas tran vdout0_47ck1280 FIND v(dout0_47) AT=1290.05n

.meas tran vdout0_48ck1280 FIND v(dout0_48) AT=1290.05n

.meas tran vdout0_49ck1280 FIND v(dout0_49) AT=1290.05n

.meas tran vdout0_50ck1280 FIND v(dout0_50) AT=1290.05n

.meas tran vdout0_51ck1280 FIND v(dout0_51) AT=1290.05n

.meas tran vdout0_52ck1280 FIND v(dout0_52) AT=1290.05n

.meas tran vdout0_53ck1280 FIND v(dout0_53) AT=1290.05n

.meas tran vdout0_54ck1280 FIND v(dout0_54) AT=1290.05n

.meas tran vdout0_55ck1280 FIND v(dout0_55) AT=1290.05n

.meas tran vdout0_56ck1280 FIND v(dout0_56) AT=1290.05n

.meas tran vdout0_57ck1280 FIND v(dout0_57) AT=1290.05n

.meas tran vdout0_58ck1280 FIND v(dout0_58) AT=1290.05n

.meas tran vdout0_59ck1280 FIND v(dout0_59) AT=1290.05n

.meas tran vdout0_60ck1280 FIND v(dout0_60) AT=1290.05n

.meas tran vdout0_61ck1280 FIND v(dout0_61) AT=1290.05n

.meas tran vdout0_62ck1280 FIND v(dout0_62) AT=1290.05n

.meas tran vdout0_63ck1280 FIND v(dout0_63) AT=1290.05n

.meas tran vdout0_64ck1280 FIND v(dout0_64) AT=1290.05n

.meas tran vdout0_0ck1290 FIND v(dout0_0) AT=1300.05n

.meas tran vdout0_1ck1290 FIND v(dout0_1) AT=1300.05n

.meas tran vdout0_2ck1290 FIND v(dout0_2) AT=1300.05n

.meas tran vdout0_3ck1290 FIND v(dout0_3) AT=1300.05n

.meas tran vdout0_4ck1290 FIND v(dout0_4) AT=1300.05n

.meas tran vdout0_5ck1290 FIND v(dout0_5) AT=1300.05n

.meas tran vdout0_6ck1290 FIND v(dout0_6) AT=1300.05n

.meas tran vdout0_7ck1290 FIND v(dout0_7) AT=1300.05n

.meas tran vdout0_8ck1290 FIND v(dout0_8) AT=1300.05n

.meas tran vdout0_9ck1290 FIND v(dout0_9) AT=1300.05n

.meas tran vdout0_10ck1290 FIND v(dout0_10) AT=1300.05n

.meas tran vdout0_11ck1290 FIND v(dout0_11) AT=1300.05n

.meas tran vdout0_12ck1290 FIND v(dout0_12) AT=1300.05n

.meas tran vdout0_13ck1290 FIND v(dout0_13) AT=1300.05n

.meas tran vdout0_14ck1290 FIND v(dout0_14) AT=1300.05n

.meas tran vdout0_15ck1290 FIND v(dout0_15) AT=1300.05n

.meas tran vdout0_16ck1290 FIND v(dout0_16) AT=1300.05n

.meas tran vdout0_17ck1290 FIND v(dout0_17) AT=1300.05n

.meas tran vdout0_18ck1290 FIND v(dout0_18) AT=1300.05n

.meas tran vdout0_19ck1290 FIND v(dout0_19) AT=1300.05n

.meas tran vdout0_20ck1290 FIND v(dout0_20) AT=1300.05n

.meas tran vdout0_21ck1290 FIND v(dout0_21) AT=1300.05n

.meas tran vdout0_22ck1290 FIND v(dout0_22) AT=1300.05n

.meas tran vdout0_23ck1290 FIND v(dout0_23) AT=1300.05n

.meas tran vdout0_24ck1290 FIND v(dout0_24) AT=1300.05n

.meas tran vdout0_25ck1290 FIND v(dout0_25) AT=1300.05n

.meas tran vdout0_26ck1290 FIND v(dout0_26) AT=1300.05n

.meas tran vdout0_27ck1290 FIND v(dout0_27) AT=1300.05n

.meas tran vdout0_28ck1290 FIND v(dout0_28) AT=1300.05n

.meas tran vdout0_29ck1290 FIND v(dout0_29) AT=1300.05n

.meas tran vdout0_30ck1290 FIND v(dout0_30) AT=1300.05n

.meas tran vdout0_31ck1290 FIND v(dout0_31) AT=1300.05n

.meas tran vdout0_32ck1290 FIND v(dout0_32) AT=1300.05n

.meas tran vdout0_33ck1290 FIND v(dout0_33) AT=1300.05n

.meas tran vdout0_34ck1290 FIND v(dout0_34) AT=1300.05n

.meas tran vdout0_35ck1290 FIND v(dout0_35) AT=1300.05n

.meas tran vdout0_36ck1290 FIND v(dout0_36) AT=1300.05n

.meas tran vdout0_37ck1290 FIND v(dout0_37) AT=1300.05n

.meas tran vdout0_38ck1290 FIND v(dout0_38) AT=1300.05n

.meas tran vdout0_39ck1290 FIND v(dout0_39) AT=1300.05n

.meas tran vdout0_40ck1290 FIND v(dout0_40) AT=1300.05n

.meas tran vdout0_41ck1290 FIND v(dout0_41) AT=1300.05n

.meas tran vdout0_42ck1290 FIND v(dout0_42) AT=1300.05n

.meas tran vdout0_43ck1290 FIND v(dout0_43) AT=1300.05n

.meas tran vdout0_44ck1290 FIND v(dout0_44) AT=1300.05n

.meas tran vdout0_45ck1290 FIND v(dout0_45) AT=1300.05n

.meas tran vdout0_46ck1290 FIND v(dout0_46) AT=1300.05n

.meas tran vdout0_47ck1290 FIND v(dout0_47) AT=1300.05n

.meas tran vdout0_48ck1290 FIND v(dout0_48) AT=1300.05n

.meas tran vdout0_49ck1290 FIND v(dout0_49) AT=1300.05n

.meas tran vdout0_50ck1290 FIND v(dout0_50) AT=1300.05n

.meas tran vdout0_51ck1290 FIND v(dout0_51) AT=1300.05n

.meas tran vdout0_52ck1290 FIND v(dout0_52) AT=1300.05n

.meas tran vdout0_53ck1290 FIND v(dout0_53) AT=1300.05n

.meas tran vdout0_54ck1290 FIND v(dout0_54) AT=1300.05n

.meas tran vdout0_55ck1290 FIND v(dout0_55) AT=1300.05n

.meas tran vdout0_56ck1290 FIND v(dout0_56) AT=1300.05n

.meas tran vdout0_57ck1290 FIND v(dout0_57) AT=1300.05n

.meas tran vdout0_58ck1290 FIND v(dout0_58) AT=1300.05n

.meas tran vdout0_59ck1290 FIND v(dout0_59) AT=1300.05n

.meas tran vdout0_60ck1290 FIND v(dout0_60) AT=1300.05n

.meas tran vdout0_61ck1290 FIND v(dout0_61) AT=1300.05n

.meas tran vdout0_62ck1290 FIND v(dout0_62) AT=1300.05n

.meas tran vdout0_63ck1290 FIND v(dout0_63) AT=1300.05n

.meas tran vdout0_64ck1290 FIND v(dout0_64) AT=1300.05n

.meas tran vdout0_0ck1340 FIND v(dout0_0) AT=1350.05n

.meas tran vdout0_1ck1340 FIND v(dout0_1) AT=1350.05n

.meas tran vdout0_2ck1340 FIND v(dout0_2) AT=1350.05n

.meas tran vdout0_3ck1340 FIND v(dout0_3) AT=1350.05n

.meas tran vdout0_4ck1340 FIND v(dout0_4) AT=1350.05n

.meas tran vdout0_5ck1340 FIND v(dout0_5) AT=1350.05n

.meas tran vdout0_6ck1340 FIND v(dout0_6) AT=1350.05n

.meas tran vdout0_7ck1340 FIND v(dout0_7) AT=1350.05n

.meas tran vdout0_8ck1340 FIND v(dout0_8) AT=1350.05n

.meas tran vdout0_9ck1340 FIND v(dout0_9) AT=1350.05n

.meas tran vdout0_10ck1340 FIND v(dout0_10) AT=1350.05n

.meas tran vdout0_11ck1340 FIND v(dout0_11) AT=1350.05n

.meas tran vdout0_12ck1340 FIND v(dout0_12) AT=1350.05n

.meas tran vdout0_13ck1340 FIND v(dout0_13) AT=1350.05n

.meas tran vdout0_14ck1340 FIND v(dout0_14) AT=1350.05n

.meas tran vdout0_15ck1340 FIND v(dout0_15) AT=1350.05n

.meas tran vdout0_16ck1340 FIND v(dout0_16) AT=1350.05n

.meas tran vdout0_17ck1340 FIND v(dout0_17) AT=1350.05n

.meas tran vdout0_18ck1340 FIND v(dout0_18) AT=1350.05n

.meas tran vdout0_19ck1340 FIND v(dout0_19) AT=1350.05n

.meas tran vdout0_20ck1340 FIND v(dout0_20) AT=1350.05n

.meas tran vdout0_21ck1340 FIND v(dout0_21) AT=1350.05n

.meas tran vdout0_22ck1340 FIND v(dout0_22) AT=1350.05n

.meas tran vdout0_23ck1340 FIND v(dout0_23) AT=1350.05n

.meas tran vdout0_24ck1340 FIND v(dout0_24) AT=1350.05n

.meas tran vdout0_25ck1340 FIND v(dout0_25) AT=1350.05n

.meas tran vdout0_26ck1340 FIND v(dout0_26) AT=1350.05n

.meas tran vdout0_27ck1340 FIND v(dout0_27) AT=1350.05n

.meas tran vdout0_28ck1340 FIND v(dout0_28) AT=1350.05n

.meas tran vdout0_29ck1340 FIND v(dout0_29) AT=1350.05n

.meas tran vdout0_30ck1340 FIND v(dout0_30) AT=1350.05n

.meas tran vdout0_31ck1340 FIND v(dout0_31) AT=1350.05n

.meas tran vdout0_32ck1340 FIND v(dout0_32) AT=1350.05n

.meas tran vdout0_33ck1340 FIND v(dout0_33) AT=1350.05n

.meas tran vdout0_34ck1340 FIND v(dout0_34) AT=1350.05n

.meas tran vdout0_35ck1340 FIND v(dout0_35) AT=1350.05n

.meas tran vdout0_36ck1340 FIND v(dout0_36) AT=1350.05n

.meas tran vdout0_37ck1340 FIND v(dout0_37) AT=1350.05n

.meas tran vdout0_38ck1340 FIND v(dout0_38) AT=1350.05n

.meas tran vdout0_39ck1340 FIND v(dout0_39) AT=1350.05n

.meas tran vdout0_40ck1340 FIND v(dout0_40) AT=1350.05n

.meas tran vdout0_41ck1340 FIND v(dout0_41) AT=1350.05n

.meas tran vdout0_42ck1340 FIND v(dout0_42) AT=1350.05n

.meas tran vdout0_43ck1340 FIND v(dout0_43) AT=1350.05n

.meas tran vdout0_44ck1340 FIND v(dout0_44) AT=1350.05n

.meas tran vdout0_45ck1340 FIND v(dout0_45) AT=1350.05n

.meas tran vdout0_46ck1340 FIND v(dout0_46) AT=1350.05n

.meas tran vdout0_47ck1340 FIND v(dout0_47) AT=1350.05n

.meas tran vdout0_48ck1340 FIND v(dout0_48) AT=1350.05n

.meas tran vdout0_49ck1340 FIND v(dout0_49) AT=1350.05n

.meas tran vdout0_50ck1340 FIND v(dout0_50) AT=1350.05n

.meas tran vdout0_51ck1340 FIND v(dout0_51) AT=1350.05n

.meas tran vdout0_52ck1340 FIND v(dout0_52) AT=1350.05n

.meas tran vdout0_53ck1340 FIND v(dout0_53) AT=1350.05n

.meas tran vdout0_54ck1340 FIND v(dout0_54) AT=1350.05n

.meas tran vdout0_55ck1340 FIND v(dout0_55) AT=1350.05n

.meas tran vdout0_56ck1340 FIND v(dout0_56) AT=1350.05n

.meas tran vdout0_57ck1340 FIND v(dout0_57) AT=1350.05n

.meas tran vdout0_58ck1340 FIND v(dout0_58) AT=1350.05n

.meas tran vdout0_59ck1340 FIND v(dout0_59) AT=1350.05n

.meas tran vdout0_60ck1340 FIND v(dout0_60) AT=1350.05n

.meas tran vdout0_61ck1340 FIND v(dout0_61) AT=1350.05n

.meas tran vdout0_62ck1340 FIND v(dout0_62) AT=1350.05n

.meas tran vdout0_63ck1340 FIND v(dout0_63) AT=1350.05n

.meas tran vdout0_64ck1340 FIND v(dout0_64) AT=1350.05n

.meas tran vdout0_0ck1390 FIND v(dout0_0) AT=1400.05n

.meas tran vdout0_1ck1390 FIND v(dout0_1) AT=1400.05n

.meas tran vdout0_2ck1390 FIND v(dout0_2) AT=1400.05n

.meas tran vdout0_3ck1390 FIND v(dout0_3) AT=1400.05n

.meas tran vdout0_4ck1390 FIND v(dout0_4) AT=1400.05n

.meas tran vdout0_5ck1390 FIND v(dout0_5) AT=1400.05n

.meas tran vdout0_6ck1390 FIND v(dout0_6) AT=1400.05n

.meas tran vdout0_7ck1390 FIND v(dout0_7) AT=1400.05n

.meas tran vdout0_8ck1390 FIND v(dout0_8) AT=1400.05n

.meas tran vdout0_9ck1390 FIND v(dout0_9) AT=1400.05n

.meas tran vdout0_10ck1390 FIND v(dout0_10) AT=1400.05n

.meas tran vdout0_11ck1390 FIND v(dout0_11) AT=1400.05n

.meas tran vdout0_12ck1390 FIND v(dout0_12) AT=1400.05n

.meas tran vdout0_13ck1390 FIND v(dout0_13) AT=1400.05n

.meas tran vdout0_14ck1390 FIND v(dout0_14) AT=1400.05n

.meas tran vdout0_15ck1390 FIND v(dout0_15) AT=1400.05n

.meas tran vdout0_16ck1390 FIND v(dout0_16) AT=1400.05n

.meas tran vdout0_17ck1390 FIND v(dout0_17) AT=1400.05n

.meas tran vdout0_18ck1390 FIND v(dout0_18) AT=1400.05n

.meas tran vdout0_19ck1390 FIND v(dout0_19) AT=1400.05n

.meas tran vdout0_20ck1390 FIND v(dout0_20) AT=1400.05n

.meas tran vdout0_21ck1390 FIND v(dout0_21) AT=1400.05n

.meas tran vdout0_22ck1390 FIND v(dout0_22) AT=1400.05n

.meas tran vdout0_23ck1390 FIND v(dout0_23) AT=1400.05n

.meas tran vdout0_24ck1390 FIND v(dout0_24) AT=1400.05n

.meas tran vdout0_25ck1390 FIND v(dout0_25) AT=1400.05n

.meas tran vdout0_26ck1390 FIND v(dout0_26) AT=1400.05n

.meas tran vdout0_27ck1390 FIND v(dout0_27) AT=1400.05n

.meas tran vdout0_28ck1390 FIND v(dout0_28) AT=1400.05n

.meas tran vdout0_29ck1390 FIND v(dout0_29) AT=1400.05n

.meas tran vdout0_30ck1390 FIND v(dout0_30) AT=1400.05n

.meas tran vdout0_31ck1390 FIND v(dout0_31) AT=1400.05n

.meas tran vdout0_32ck1390 FIND v(dout0_32) AT=1400.05n

.meas tran vdout0_33ck1390 FIND v(dout0_33) AT=1400.05n

.meas tran vdout0_34ck1390 FIND v(dout0_34) AT=1400.05n

.meas tran vdout0_35ck1390 FIND v(dout0_35) AT=1400.05n

.meas tran vdout0_36ck1390 FIND v(dout0_36) AT=1400.05n

.meas tran vdout0_37ck1390 FIND v(dout0_37) AT=1400.05n

.meas tran vdout0_38ck1390 FIND v(dout0_38) AT=1400.05n

.meas tran vdout0_39ck1390 FIND v(dout0_39) AT=1400.05n

.meas tran vdout0_40ck1390 FIND v(dout0_40) AT=1400.05n

.meas tran vdout0_41ck1390 FIND v(dout0_41) AT=1400.05n

.meas tran vdout0_42ck1390 FIND v(dout0_42) AT=1400.05n

.meas tran vdout0_43ck1390 FIND v(dout0_43) AT=1400.05n

.meas tran vdout0_44ck1390 FIND v(dout0_44) AT=1400.05n

.meas tran vdout0_45ck1390 FIND v(dout0_45) AT=1400.05n

.meas tran vdout0_46ck1390 FIND v(dout0_46) AT=1400.05n

.meas tran vdout0_47ck1390 FIND v(dout0_47) AT=1400.05n

.meas tran vdout0_48ck1390 FIND v(dout0_48) AT=1400.05n

.meas tran vdout0_49ck1390 FIND v(dout0_49) AT=1400.05n

.meas tran vdout0_50ck1390 FIND v(dout0_50) AT=1400.05n

.meas tran vdout0_51ck1390 FIND v(dout0_51) AT=1400.05n

.meas tran vdout0_52ck1390 FIND v(dout0_52) AT=1400.05n

.meas tran vdout0_53ck1390 FIND v(dout0_53) AT=1400.05n

.meas tran vdout0_54ck1390 FIND v(dout0_54) AT=1400.05n

.meas tran vdout0_55ck1390 FIND v(dout0_55) AT=1400.05n

.meas tran vdout0_56ck1390 FIND v(dout0_56) AT=1400.05n

.meas tran vdout0_57ck1390 FIND v(dout0_57) AT=1400.05n

.meas tran vdout0_58ck1390 FIND v(dout0_58) AT=1400.05n

.meas tran vdout0_59ck1390 FIND v(dout0_59) AT=1400.05n

.meas tran vdout0_60ck1390 FIND v(dout0_60) AT=1400.05n

.meas tran vdout0_61ck1390 FIND v(dout0_61) AT=1400.05n

.meas tran vdout0_62ck1390 FIND v(dout0_62) AT=1400.05n

.meas tran vdout0_63ck1390 FIND v(dout0_63) AT=1400.05n

.meas tran vdout0_64ck1390 FIND v(dout0_64) AT=1400.05n

.meas tran vdout0_0ck1410 FIND v(dout0_0) AT=1420.05n

.meas tran vdout0_1ck1410 FIND v(dout0_1) AT=1420.05n

.meas tran vdout0_2ck1410 FIND v(dout0_2) AT=1420.05n

.meas tran vdout0_3ck1410 FIND v(dout0_3) AT=1420.05n

.meas tran vdout0_4ck1410 FIND v(dout0_4) AT=1420.05n

.meas tran vdout0_5ck1410 FIND v(dout0_5) AT=1420.05n

.meas tran vdout0_6ck1410 FIND v(dout0_6) AT=1420.05n

.meas tran vdout0_7ck1410 FIND v(dout0_7) AT=1420.05n

.meas tran vdout0_8ck1410 FIND v(dout0_8) AT=1420.05n

.meas tran vdout0_9ck1410 FIND v(dout0_9) AT=1420.05n

.meas tran vdout0_10ck1410 FIND v(dout0_10) AT=1420.05n

.meas tran vdout0_11ck1410 FIND v(dout0_11) AT=1420.05n

.meas tran vdout0_12ck1410 FIND v(dout0_12) AT=1420.05n

.meas tran vdout0_13ck1410 FIND v(dout0_13) AT=1420.05n

.meas tran vdout0_14ck1410 FIND v(dout0_14) AT=1420.05n

.meas tran vdout0_15ck1410 FIND v(dout0_15) AT=1420.05n

.meas tran vdout0_16ck1410 FIND v(dout0_16) AT=1420.05n

.meas tran vdout0_17ck1410 FIND v(dout0_17) AT=1420.05n

.meas tran vdout0_18ck1410 FIND v(dout0_18) AT=1420.05n

.meas tran vdout0_19ck1410 FIND v(dout0_19) AT=1420.05n

.meas tran vdout0_20ck1410 FIND v(dout0_20) AT=1420.05n

.meas tran vdout0_21ck1410 FIND v(dout0_21) AT=1420.05n

.meas tran vdout0_22ck1410 FIND v(dout0_22) AT=1420.05n

.meas tran vdout0_23ck1410 FIND v(dout0_23) AT=1420.05n

.meas tran vdout0_24ck1410 FIND v(dout0_24) AT=1420.05n

.meas tran vdout0_25ck1410 FIND v(dout0_25) AT=1420.05n

.meas tran vdout0_26ck1410 FIND v(dout0_26) AT=1420.05n

.meas tran vdout0_27ck1410 FIND v(dout0_27) AT=1420.05n

.meas tran vdout0_28ck1410 FIND v(dout0_28) AT=1420.05n

.meas tran vdout0_29ck1410 FIND v(dout0_29) AT=1420.05n

.meas tran vdout0_30ck1410 FIND v(dout0_30) AT=1420.05n

.meas tran vdout0_31ck1410 FIND v(dout0_31) AT=1420.05n

.meas tran vdout0_32ck1410 FIND v(dout0_32) AT=1420.05n

.meas tran vdout0_33ck1410 FIND v(dout0_33) AT=1420.05n

.meas tran vdout0_34ck1410 FIND v(dout0_34) AT=1420.05n

.meas tran vdout0_35ck1410 FIND v(dout0_35) AT=1420.05n

.meas tran vdout0_36ck1410 FIND v(dout0_36) AT=1420.05n

.meas tran vdout0_37ck1410 FIND v(dout0_37) AT=1420.05n

.meas tran vdout0_38ck1410 FIND v(dout0_38) AT=1420.05n

.meas tran vdout0_39ck1410 FIND v(dout0_39) AT=1420.05n

.meas tran vdout0_40ck1410 FIND v(dout0_40) AT=1420.05n

.meas tran vdout0_41ck1410 FIND v(dout0_41) AT=1420.05n

.meas tran vdout0_42ck1410 FIND v(dout0_42) AT=1420.05n

.meas tran vdout0_43ck1410 FIND v(dout0_43) AT=1420.05n

.meas tran vdout0_44ck1410 FIND v(dout0_44) AT=1420.05n

.meas tran vdout0_45ck1410 FIND v(dout0_45) AT=1420.05n

.meas tran vdout0_46ck1410 FIND v(dout0_46) AT=1420.05n

.meas tran vdout0_47ck1410 FIND v(dout0_47) AT=1420.05n

.meas tran vdout0_48ck1410 FIND v(dout0_48) AT=1420.05n

.meas tran vdout0_49ck1410 FIND v(dout0_49) AT=1420.05n

.meas tran vdout0_50ck1410 FIND v(dout0_50) AT=1420.05n

.meas tran vdout0_51ck1410 FIND v(dout0_51) AT=1420.05n

.meas tran vdout0_52ck1410 FIND v(dout0_52) AT=1420.05n

.meas tran vdout0_53ck1410 FIND v(dout0_53) AT=1420.05n

.meas tran vdout0_54ck1410 FIND v(dout0_54) AT=1420.05n

.meas tran vdout0_55ck1410 FIND v(dout0_55) AT=1420.05n

.meas tran vdout0_56ck1410 FIND v(dout0_56) AT=1420.05n

.meas tran vdout0_57ck1410 FIND v(dout0_57) AT=1420.05n

.meas tran vdout0_58ck1410 FIND v(dout0_58) AT=1420.05n

.meas tran vdout0_59ck1410 FIND v(dout0_59) AT=1420.05n

.meas tran vdout0_60ck1410 FIND v(dout0_60) AT=1420.05n

.meas tran vdout0_61ck1410 FIND v(dout0_61) AT=1420.05n

.meas tran vdout0_62ck1410 FIND v(dout0_62) AT=1420.05n

.meas tran vdout0_63ck1410 FIND v(dout0_63) AT=1420.05n

.meas tran vdout0_64ck1410 FIND v(dout0_64) AT=1420.05n

.meas tran vdout0_0ck1430 FIND v(dout0_0) AT=1440.05n

.meas tran vdout0_1ck1430 FIND v(dout0_1) AT=1440.05n

.meas tran vdout0_2ck1430 FIND v(dout0_2) AT=1440.05n

.meas tran vdout0_3ck1430 FIND v(dout0_3) AT=1440.05n

.meas tran vdout0_4ck1430 FIND v(dout0_4) AT=1440.05n

.meas tran vdout0_5ck1430 FIND v(dout0_5) AT=1440.05n

.meas tran vdout0_6ck1430 FIND v(dout0_6) AT=1440.05n

.meas tran vdout0_7ck1430 FIND v(dout0_7) AT=1440.05n

.meas tran vdout0_8ck1430 FIND v(dout0_8) AT=1440.05n

.meas tran vdout0_9ck1430 FIND v(dout0_9) AT=1440.05n

.meas tran vdout0_10ck1430 FIND v(dout0_10) AT=1440.05n

.meas tran vdout0_11ck1430 FIND v(dout0_11) AT=1440.05n

.meas tran vdout0_12ck1430 FIND v(dout0_12) AT=1440.05n

.meas tran vdout0_13ck1430 FIND v(dout0_13) AT=1440.05n

.meas tran vdout0_14ck1430 FIND v(dout0_14) AT=1440.05n

.meas tran vdout0_15ck1430 FIND v(dout0_15) AT=1440.05n

.meas tran vdout0_16ck1430 FIND v(dout0_16) AT=1440.05n

.meas tran vdout0_17ck1430 FIND v(dout0_17) AT=1440.05n

.meas tran vdout0_18ck1430 FIND v(dout0_18) AT=1440.05n

.meas tran vdout0_19ck1430 FIND v(dout0_19) AT=1440.05n

.meas tran vdout0_20ck1430 FIND v(dout0_20) AT=1440.05n

.meas tran vdout0_21ck1430 FIND v(dout0_21) AT=1440.05n

.meas tran vdout0_22ck1430 FIND v(dout0_22) AT=1440.05n

.meas tran vdout0_23ck1430 FIND v(dout0_23) AT=1440.05n

.meas tran vdout0_24ck1430 FIND v(dout0_24) AT=1440.05n

.meas tran vdout0_25ck1430 FIND v(dout0_25) AT=1440.05n

.meas tran vdout0_26ck1430 FIND v(dout0_26) AT=1440.05n

.meas tran vdout0_27ck1430 FIND v(dout0_27) AT=1440.05n

.meas tran vdout0_28ck1430 FIND v(dout0_28) AT=1440.05n

.meas tran vdout0_29ck1430 FIND v(dout0_29) AT=1440.05n

.meas tran vdout0_30ck1430 FIND v(dout0_30) AT=1440.05n

.meas tran vdout0_31ck1430 FIND v(dout0_31) AT=1440.05n

.meas tran vdout0_32ck1430 FIND v(dout0_32) AT=1440.05n

.meas tran vdout0_33ck1430 FIND v(dout0_33) AT=1440.05n

.meas tran vdout0_34ck1430 FIND v(dout0_34) AT=1440.05n

.meas tran vdout0_35ck1430 FIND v(dout0_35) AT=1440.05n

.meas tran vdout0_36ck1430 FIND v(dout0_36) AT=1440.05n

.meas tran vdout0_37ck1430 FIND v(dout0_37) AT=1440.05n

.meas tran vdout0_38ck1430 FIND v(dout0_38) AT=1440.05n

.meas tran vdout0_39ck1430 FIND v(dout0_39) AT=1440.05n

.meas tran vdout0_40ck1430 FIND v(dout0_40) AT=1440.05n

.meas tran vdout0_41ck1430 FIND v(dout0_41) AT=1440.05n

.meas tran vdout0_42ck1430 FIND v(dout0_42) AT=1440.05n

.meas tran vdout0_43ck1430 FIND v(dout0_43) AT=1440.05n

.meas tran vdout0_44ck1430 FIND v(dout0_44) AT=1440.05n

.meas tran vdout0_45ck1430 FIND v(dout0_45) AT=1440.05n

.meas tran vdout0_46ck1430 FIND v(dout0_46) AT=1440.05n

.meas tran vdout0_47ck1430 FIND v(dout0_47) AT=1440.05n

.meas tran vdout0_48ck1430 FIND v(dout0_48) AT=1440.05n

.meas tran vdout0_49ck1430 FIND v(dout0_49) AT=1440.05n

.meas tran vdout0_50ck1430 FIND v(dout0_50) AT=1440.05n

.meas tran vdout0_51ck1430 FIND v(dout0_51) AT=1440.05n

.meas tran vdout0_52ck1430 FIND v(dout0_52) AT=1440.05n

.meas tran vdout0_53ck1430 FIND v(dout0_53) AT=1440.05n

.meas tran vdout0_54ck1430 FIND v(dout0_54) AT=1440.05n

.meas tran vdout0_55ck1430 FIND v(dout0_55) AT=1440.05n

.meas tran vdout0_56ck1430 FIND v(dout0_56) AT=1440.05n

.meas tran vdout0_57ck1430 FIND v(dout0_57) AT=1440.05n

.meas tran vdout0_58ck1430 FIND v(dout0_58) AT=1440.05n

.meas tran vdout0_59ck1430 FIND v(dout0_59) AT=1440.05n

.meas tran vdout0_60ck1430 FIND v(dout0_60) AT=1440.05n

.meas tran vdout0_61ck1430 FIND v(dout0_61) AT=1440.05n

.meas tran vdout0_62ck1430 FIND v(dout0_62) AT=1440.05n

.meas tran vdout0_63ck1430 FIND v(dout0_63) AT=1440.05n

.meas tran vdout0_64ck1430 FIND v(dout0_64) AT=1440.05n

.meas tran vdout0_0ck1450 FIND v(dout0_0) AT=1460.05n

.meas tran vdout0_1ck1450 FIND v(dout0_1) AT=1460.05n

.meas tran vdout0_2ck1450 FIND v(dout0_2) AT=1460.05n

.meas tran vdout0_3ck1450 FIND v(dout0_3) AT=1460.05n

.meas tran vdout0_4ck1450 FIND v(dout0_4) AT=1460.05n

.meas tran vdout0_5ck1450 FIND v(dout0_5) AT=1460.05n

.meas tran vdout0_6ck1450 FIND v(dout0_6) AT=1460.05n

.meas tran vdout0_7ck1450 FIND v(dout0_7) AT=1460.05n

.meas tran vdout0_8ck1450 FIND v(dout0_8) AT=1460.05n

.meas tran vdout0_9ck1450 FIND v(dout0_9) AT=1460.05n

.meas tran vdout0_10ck1450 FIND v(dout0_10) AT=1460.05n

.meas tran vdout0_11ck1450 FIND v(dout0_11) AT=1460.05n

.meas tran vdout0_12ck1450 FIND v(dout0_12) AT=1460.05n

.meas tran vdout0_13ck1450 FIND v(dout0_13) AT=1460.05n

.meas tran vdout0_14ck1450 FIND v(dout0_14) AT=1460.05n

.meas tran vdout0_15ck1450 FIND v(dout0_15) AT=1460.05n

.meas tran vdout0_16ck1450 FIND v(dout0_16) AT=1460.05n

.meas tran vdout0_17ck1450 FIND v(dout0_17) AT=1460.05n

.meas tran vdout0_18ck1450 FIND v(dout0_18) AT=1460.05n

.meas tran vdout0_19ck1450 FIND v(dout0_19) AT=1460.05n

.meas tran vdout0_20ck1450 FIND v(dout0_20) AT=1460.05n

.meas tran vdout0_21ck1450 FIND v(dout0_21) AT=1460.05n

.meas tran vdout0_22ck1450 FIND v(dout0_22) AT=1460.05n

.meas tran vdout0_23ck1450 FIND v(dout0_23) AT=1460.05n

.meas tran vdout0_24ck1450 FIND v(dout0_24) AT=1460.05n

.meas tran vdout0_25ck1450 FIND v(dout0_25) AT=1460.05n

.meas tran vdout0_26ck1450 FIND v(dout0_26) AT=1460.05n

.meas tran vdout0_27ck1450 FIND v(dout0_27) AT=1460.05n

.meas tran vdout0_28ck1450 FIND v(dout0_28) AT=1460.05n

.meas tran vdout0_29ck1450 FIND v(dout0_29) AT=1460.05n

.meas tran vdout0_30ck1450 FIND v(dout0_30) AT=1460.05n

.meas tran vdout0_31ck1450 FIND v(dout0_31) AT=1460.05n

.meas tran vdout0_32ck1450 FIND v(dout0_32) AT=1460.05n

.meas tran vdout0_33ck1450 FIND v(dout0_33) AT=1460.05n

.meas tran vdout0_34ck1450 FIND v(dout0_34) AT=1460.05n

.meas tran vdout0_35ck1450 FIND v(dout0_35) AT=1460.05n

.meas tran vdout0_36ck1450 FIND v(dout0_36) AT=1460.05n

.meas tran vdout0_37ck1450 FIND v(dout0_37) AT=1460.05n

.meas tran vdout0_38ck1450 FIND v(dout0_38) AT=1460.05n

.meas tran vdout0_39ck1450 FIND v(dout0_39) AT=1460.05n

.meas tran vdout0_40ck1450 FIND v(dout0_40) AT=1460.05n

.meas tran vdout0_41ck1450 FIND v(dout0_41) AT=1460.05n

.meas tran vdout0_42ck1450 FIND v(dout0_42) AT=1460.05n

.meas tran vdout0_43ck1450 FIND v(dout0_43) AT=1460.05n

.meas tran vdout0_44ck1450 FIND v(dout0_44) AT=1460.05n

.meas tran vdout0_45ck1450 FIND v(dout0_45) AT=1460.05n

.meas tran vdout0_46ck1450 FIND v(dout0_46) AT=1460.05n

.meas tran vdout0_47ck1450 FIND v(dout0_47) AT=1460.05n

.meas tran vdout0_48ck1450 FIND v(dout0_48) AT=1460.05n

.meas tran vdout0_49ck1450 FIND v(dout0_49) AT=1460.05n

.meas tran vdout0_50ck1450 FIND v(dout0_50) AT=1460.05n

.meas tran vdout0_51ck1450 FIND v(dout0_51) AT=1460.05n

.meas tran vdout0_52ck1450 FIND v(dout0_52) AT=1460.05n

.meas tran vdout0_53ck1450 FIND v(dout0_53) AT=1460.05n

.meas tran vdout0_54ck1450 FIND v(dout0_54) AT=1460.05n

.meas tran vdout0_55ck1450 FIND v(dout0_55) AT=1460.05n

.meas tran vdout0_56ck1450 FIND v(dout0_56) AT=1460.05n

.meas tran vdout0_57ck1450 FIND v(dout0_57) AT=1460.05n

.meas tran vdout0_58ck1450 FIND v(dout0_58) AT=1460.05n

.meas tran vdout0_59ck1450 FIND v(dout0_59) AT=1460.05n

.meas tran vdout0_60ck1450 FIND v(dout0_60) AT=1460.05n

.meas tran vdout0_61ck1450 FIND v(dout0_61) AT=1460.05n

.meas tran vdout0_62ck1450 FIND v(dout0_62) AT=1460.05n

.meas tran vdout0_63ck1450 FIND v(dout0_63) AT=1460.05n

.meas tran vdout0_64ck1450 FIND v(dout0_64) AT=1460.05n

.meas tran vdout0_0ck1460 FIND v(dout0_0) AT=1470.05n

.meas tran vdout0_1ck1460 FIND v(dout0_1) AT=1470.05n

.meas tran vdout0_2ck1460 FIND v(dout0_2) AT=1470.05n

.meas tran vdout0_3ck1460 FIND v(dout0_3) AT=1470.05n

.meas tran vdout0_4ck1460 FIND v(dout0_4) AT=1470.05n

.meas tran vdout0_5ck1460 FIND v(dout0_5) AT=1470.05n

.meas tran vdout0_6ck1460 FIND v(dout0_6) AT=1470.05n

.meas tran vdout0_7ck1460 FIND v(dout0_7) AT=1470.05n

.meas tran vdout0_8ck1460 FIND v(dout0_8) AT=1470.05n

.meas tran vdout0_9ck1460 FIND v(dout0_9) AT=1470.05n

.meas tran vdout0_10ck1460 FIND v(dout0_10) AT=1470.05n

.meas tran vdout0_11ck1460 FIND v(dout0_11) AT=1470.05n

.meas tran vdout0_12ck1460 FIND v(dout0_12) AT=1470.05n

.meas tran vdout0_13ck1460 FIND v(dout0_13) AT=1470.05n

.meas tran vdout0_14ck1460 FIND v(dout0_14) AT=1470.05n

.meas tran vdout0_15ck1460 FIND v(dout0_15) AT=1470.05n

.meas tran vdout0_16ck1460 FIND v(dout0_16) AT=1470.05n

.meas tran vdout0_17ck1460 FIND v(dout0_17) AT=1470.05n

.meas tran vdout0_18ck1460 FIND v(dout0_18) AT=1470.05n

.meas tran vdout0_19ck1460 FIND v(dout0_19) AT=1470.05n

.meas tran vdout0_20ck1460 FIND v(dout0_20) AT=1470.05n

.meas tran vdout0_21ck1460 FIND v(dout0_21) AT=1470.05n

.meas tran vdout0_22ck1460 FIND v(dout0_22) AT=1470.05n

.meas tran vdout0_23ck1460 FIND v(dout0_23) AT=1470.05n

.meas tran vdout0_24ck1460 FIND v(dout0_24) AT=1470.05n

.meas tran vdout0_25ck1460 FIND v(dout0_25) AT=1470.05n

.meas tran vdout0_26ck1460 FIND v(dout0_26) AT=1470.05n

.meas tran vdout0_27ck1460 FIND v(dout0_27) AT=1470.05n

.meas tran vdout0_28ck1460 FIND v(dout0_28) AT=1470.05n

.meas tran vdout0_29ck1460 FIND v(dout0_29) AT=1470.05n

.meas tran vdout0_30ck1460 FIND v(dout0_30) AT=1470.05n

.meas tran vdout0_31ck1460 FIND v(dout0_31) AT=1470.05n

.meas tran vdout0_32ck1460 FIND v(dout0_32) AT=1470.05n

.meas tran vdout0_33ck1460 FIND v(dout0_33) AT=1470.05n

.meas tran vdout0_34ck1460 FIND v(dout0_34) AT=1470.05n

.meas tran vdout0_35ck1460 FIND v(dout0_35) AT=1470.05n

.meas tran vdout0_36ck1460 FIND v(dout0_36) AT=1470.05n

.meas tran vdout0_37ck1460 FIND v(dout0_37) AT=1470.05n

.meas tran vdout0_38ck1460 FIND v(dout0_38) AT=1470.05n

.meas tran vdout0_39ck1460 FIND v(dout0_39) AT=1470.05n

.meas tran vdout0_40ck1460 FIND v(dout0_40) AT=1470.05n

.meas tran vdout0_41ck1460 FIND v(dout0_41) AT=1470.05n

.meas tran vdout0_42ck1460 FIND v(dout0_42) AT=1470.05n

.meas tran vdout0_43ck1460 FIND v(dout0_43) AT=1470.05n

.meas tran vdout0_44ck1460 FIND v(dout0_44) AT=1470.05n

.meas tran vdout0_45ck1460 FIND v(dout0_45) AT=1470.05n

.meas tran vdout0_46ck1460 FIND v(dout0_46) AT=1470.05n

.meas tran vdout0_47ck1460 FIND v(dout0_47) AT=1470.05n

.meas tran vdout0_48ck1460 FIND v(dout0_48) AT=1470.05n

.meas tran vdout0_49ck1460 FIND v(dout0_49) AT=1470.05n

.meas tran vdout0_50ck1460 FIND v(dout0_50) AT=1470.05n

.meas tran vdout0_51ck1460 FIND v(dout0_51) AT=1470.05n

.meas tran vdout0_52ck1460 FIND v(dout0_52) AT=1470.05n

.meas tran vdout0_53ck1460 FIND v(dout0_53) AT=1470.05n

.meas tran vdout0_54ck1460 FIND v(dout0_54) AT=1470.05n

.meas tran vdout0_55ck1460 FIND v(dout0_55) AT=1470.05n

.meas tran vdout0_56ck1460 FIND v(dout0_56) AT=1470.05n

.meas tran vdout0_57ck1460 FIND v(dout0_57) AT=1470.05n

.meas tran vdout0_58ck1460 FIND v(dout0_58) AT=1470.05n

.meas tran vdout0_59ck1460 FIND v(dout0_59) AT=1470.05n

.meas tran vdout0_60ck1460 FIND v(dout0_60) AT=1470.05n

.meas tran vdout0_61ck1460 FIND v(dout0_61) AT=1470.05n

.meas tran vdout0_62ck1460 FIND v(dout0_62) AT=1470.05n

.meas tran vdout0_63ck1460 FIND v(dout0_63) AT=1470.05n

.meas tran vdout0_64ck1460 FIND v(dout0_64) AT=1470.05n

.meas tran vdout0_0ck1470 FIND v(dout0_0) AT=1480.05n

.meas tran vdout0_1ck1470 FIND v(dout0_1) AT=1480.05n

.meas tran vdout0_2ck1470 FIND v(dout0_2) AT=1480.05n

.meas tran vdout0_3ck1470 FIND v(dout0_3) AT=1480.05n

.meas tran vdout0_4ck1470 FIND v(dout0_4) AT=1480.05n

.meas tran vdout0_5ck1470 FIND v(dout0_5) AT=1480.05n

.meas tran vdout0_6ck1470 FIND v(dout0_6) AT=1480.05n

.meas tran vdout0_7ck1470 FIND v(dout0_7) AT=1480.05n

.meas tran vdout0_8ck1470 FIND v(dout0_8) AT=1480.05n

.meas tran vdout0_9ck1470 FIND v(dout0_9) AT=1480.05n

.meas tran vdout0_10ck1470 FIND v(dout0_10) AT=1480.05n

.meas tran vdout0_11ck1470 FIND v(dout0_11) AT=1480.05n

.meas tran vdout0_12ck1470 FIND v(dout0_12) AT=1480.05n

.meas tran vdout0_13ck1470 FIND v(dout0_13) AT=1480.05n

.meas tran vdout0_14ck1470 FIND v(dout0_14) AT=1480.05n

.meas tran vdout0_15ck1470 FIND v(dout0_15) AT=1480.05n

.meas tran vdout0_16ck1470 FIND v(dout0_16) AT=1480.05n

.meas tran vdout0_17ck1470 FIND v(dout0_17) AT=1480.05n

.meas tran vdout0_18ck1470 FIND v(dout0_18) AT=1480.05n

.meas tran vdout0_19ck1470 FIND v(dout0_19) AT=1480.05n

.meas tran vdout0_20ck1470 FIND v(dout0_20) AT=1480.05n

.meas tran vdout0_21ck1470 FIND v(dout0_21) AT=1480.05n

.meas tran vdout0_22ck1470 FIND v(dout0_22) AT=1480.05n

.meas tran vdout0_23ck1470 FIND v(dout0_23) AT=1480.05n

.meas tran vdout0_24ck1470 FIND v(dout0_24) AT=1480.05n

.meas tran vdout0_25ck1470 FIND v(dout0_25) AT=1480.05n

.meas tran vdout0_26ck1470 FIND v(dout0_26) AT=1480.05n

.meas tran vdout0_27ck1470 FIND v(dout0_27) AT=1480.05n

.meas tran vdout0_28ck1470 FIND v(dout0_28) AT=1480.05n

.meas tran vdout0_29ck1470 FIND v(dout0_29) AT=1480.05n

.meas tran vdout0_30ck1470 FIND v(dout0_30) AT=1480.05n

.meas tran vdout0_31ck1470 FIND v(dout0_31) AT=1480.05n

.meas tran vdout0_32ck1470 FIND v(dout0_32) AT=1480.05n

.meas tran vdout0_33ck1470 FIND v(dout0_33) AT=1480.05n

.meas tran vdout0_34ck1470 FIND v(dout0_34) AT=1480.05n

.meas tran vdout0_35ck1470 FIND v(dout0_35) AT=1480.05n

.meas tran vdout0_36ck1470 FIND v(dout0_36) AT=1480.05n

.meas tran vdout0_37ck1470 FIND v(dout0_37) AT=1480.05n

.meas tran vdout0_38ck1470 FIND v(dout0_38) AT=1480.05n

.meas tran vdout0_39ck1470 FIND v(dout0_39) AT=1480.05n

.meas tran vdout0_40ck1470 FIND v(dout0_40) AT=1480.05n

.meas tran vdout0_41ck1470 FIND v(dout0_41) AT=1480.05n

.meas tran vdout0_42ck1470 FIND v(dout0_42) AT=1480.05n

.meas tran vdout0_43ck1470 FIND v(dout0_43) AT=1480.05n

.meas tran vdout0_44ck1470 FIND v(dout0_44) AT=1480.05n

.meas tran vdout0_45ck1470 FIND v(dout0_45) AT=1480.05n

.meas tran vdout0_46ck1470 FIND v(dout0_46) AT=1480.05n

.meas tran vdout0_47ck1470 FIND v(dout0_47) AT=1480.05n

.meas tran vdout0_48ck1470 FIND v(dout0_48) AT=1480.05n

.meas tran vdout0_49ck1470 FIND v(dout0_49) AT=1480.05n

.meas tran vdout0_50ck1470 FIND v(dout0_50) AT=1480.05n

.meas tran vdout0_51ck1470 FIND v(dout0_51) AT=1480.05n

.meas tran vdout0_52ck1470 FIND v(dout0_52) AT=1480.05n

.meas tran vdout0_53ck1470 FIND v(dout0_53) AT=1480.05n

.meas tran vdout0_54ck1470 FIND v(dout0_54) AT=1480.05n

.meas tran vdout0_55ck1470 FIND v(dout0_55) AT=1480.05n

.meas tran vdout0_56ck1470 FIND v(dout0_56) AT=1480.05n

.meas tran vdout0_57ck1470 FIND v(dout0_57) AT=1480.05n

.meas tran vdout0_58ck1470 FIND v(dout0_58) AT=1480.05n

.meas tran vdout0_59ck1470 FIND v(dout0_59) AT=1480.05n

.meas tran vdout0_60ck1470 FIND v(dout0_60) AT=1480.05n

.meas tran vdout0_61ck1470 FIND v(dout0_61) AT=1480.05n

.meas tran vdout0_62ck1470 FIND v(dout0_62) AT=1480.05n

.meas tran vdout0_63ck1470 FIND v(dout0_63) AT=1480.05n

.meas tran vdout0_64ck1470 FIND v(dout0_64) AT=1480.05n

.meas tran vdout0_0ck1480 FIND v(dout0_0) AT=1490.05n

.meas tran vdout0_1ck1480 FIND v(dout0_1) AT=1490.05n

.meas tran vdout0_2ck1480 FIND v(dout0_2) AT=1490.05n

.meas tran vdout0_3ck1480 FIND v(dout0_3) AT=1490.05n

.meas tran vdout0_4ck1480 FIND v(dout0_4) AT=1490.05n

.meas tran vdout0_5ck1480 FIND v(dout0_5) AT=1490.05n

.meas tran vdout0_6ck1480 FIND v(dout0_6) AT=1490.05n

.meas tran vdout0_7ck1480 FIND v(dout0_7) AT=1490.05n

.meas tran vdout0_8ck1480 FIND v(dout0_8) AT=1490.05n

.meas tran vdout0_9ck1480 FIND v(dout0_9) AT=1490.05n

.meas tran vdout0_10ck1480 FIND v(dout0_10) AT=1490.05n

.meas tran vdout0_11ck1480 FIND v(dout0_11) AT=1490.05n

.meas tran vdout0_12ck1480 FIND v(dout0_12) AT=1490.05n

.meas tran vdout0_13ck1480 FIND v(dout0_13) AT=1490.05n

.meas tran vdout0_14ck1480 FIND v(dout0_14) AT=1490.05n

.meas tran vdout0_15ck1480 FIND v(dout0_15) AT=1490.05n

.meas tran vdout0_16ck1480 FIND v(dout0_16) AT=1490.05n

.meas tran vdout0_17ck1480 FIND v(dout0_17) AT=1490.05n

.meas tran vdout0_18ck1480 FIND v(dout0_18) AT=1490.05n

.meas tran vdout0_19ck1480 FIND v(dout0_19) AT=1490.05n

.meas tran vdout0_20ck1480 FIND v(dout0_20) AT=1490.05n

.meas tran vdout0_21ck1480 FIND v(dout0_21) AT=1490.05n

.meas tran vdout0_22ck1480 FIND v(dout0_22) AT=1490.05n

.meas tran vdout0_23ck1480 FIND v(dout0_23) AT=1490.05n

.meas tran vdout0_24ck1480 FIND v(dout0_24) AT=1490.05n

.meas tran vdout0_25ck1480 FIND v(dout0_25) AT=1490.05n

.meas tran vdout0_26ck1480 FIND v(dout0_26) AT=1490.05n

.meas tran vdout0_27ck1480 FIND v(dout0_27) AT=1490.05n

.meas tran vdout0_28ck1480 FIND v(dout0_28) AT=1490.05n

.meas tran vdout0_29ck1480 FIND v(dout0_29) AT=1490.05n

.meas tran vdout0_30ck1480 FIND v(dout0_30) AT=1490.05n

.meas tran vdout0_31ck1480 FIND v(dout0_31) AT=1490.05n

.meas tran vdout0_32ck1480 FIND v(dout0_32) AT=1490.05n

.meas tran vdout0_33ck1480 FIND v(dout0_33) AT=1490.05n

.meas tran vdout0_34ck1480 FIND v(dout0_34) AT=1490.05n

.meas tran vdout0_35ck1480 FIND v(dout0_35) AT=1490.05n

.meas tran vdout0_36ck1480 FIND v(dout0_36) AT=1490.05n

.meas tran vdout0_37ck1480 FIND v(dout0_37) AT=1490.05n

.meas tran vdout0_38ck1480 FIND v(dout0_38) AT=1490.05n

.meas tran vdout0_39ck1480 FIND v(dout0_39) AT=1490.05n

.meas tran vdout0_40ck1480 FIND v(dout0_40) AT=1490.05n

.meas tran vdout0_41ck1480 FIND v(dout0_41) AT=1490.05n

.meas tran vdout0_42ck1480 FIND v(dout0_42) AT=1490.05n

.meas tran vdout0_43ck1480 FIND v(dout0_43) AT=1490.05n

.meas tran vdout0_44ck1480 FIND v(dout0_44) AT=1490.05n

.meas tran vdout0_45ck1480 FIND v(dout0_45) AT=1490.05n

.meas tran vdout0_46ck1480 FIND v(dout0_46) AT=1490.05n

.meas tran vdout0_47ck1480 FIND v(dout0_47) AT=1490.05n

.meas tran vdout0_48ck1480 FIND v(dout0_48) AT=1490.05n

.meas tran vdout0_49ck1480 FIND v(dout0_49) AT=1490.05n

.meas tran vdout0_50ck1480 FIND v(dout0_50) AT=1490.05n

.meas tran vdout0_51ck1480 FIND v(dout0_51) AT=1490.05n

.meas tran vdout0_52ck1480 FIND v(dout0_52) AT=1490.05n

.meas tran vdout0_53ck1480 FIND v(dout0_53) AT=1490.05n

.meas tran vdout0_54ck1480 FIND v(dout0_54) AT=1490.05n

.meas tran vdout0_55ck1480 FIND v(dout0_55) AT=1490.05n

.meas tran vdout0_56ck1480 FIND v(dout0_56) AT=1490.05n

.meas tran vdout0_57ck1480 FIND v(dout0_57) AT=1490.05n

.meas tran vdout0_58ck1480 FIND v(dout0_58) AT=1490.05n

.meas tran vdout0_59ck1480 FIND v(dout0_59) AT=1490.05n

.meas tran vdout0_60ck1480 FIND v(dout0_60) AT=1490.05n

.meas tran vdout0_61ck1480 FIND v(dout0_61) AT=1490.05n

.meas tran vdout0_62ck1480 FIND v(dout0_62) AT=1490.05n

.meas tran vdout0_63ck1480 FIND v(dout0_63) AT=1490.05n

.meas tran vdout0_64ck1480 FIND v(dout0_64) AT=1490.05n

.meas tran vdout0_0ck1490 FIND v(dout0_0) AT=1500.05n

.meas tran vdout0_1ck1490 FIND v(dout0_1) AT=1500.05n

.meas tran vdout0_2ck1490 FIND v(dout0_2) AT=1500.05n

.meas tran vdout0_3ck1490 FIND v(dout0_3) AT=1500.05n

.meas tran vdout0_4ck1490 FIND v(dout0_4) AT=1500.05n

.meas tran vdout0_5ck1490 FIND v(dout0_5) AT=1500.05n

.meas tran vdout0_6ck1490 FIND v(dout0_6) AT=1500.05n

.meas tran vdout0_7ck1490 FIND v(dout0_7) AT=1500.05n

.meas tran vdout0_8ck1490 FIND v(dout0_8) AT=1500.05n

.meas tran vdout0_9ck1490 FIND v(dout0_9) AT=1500.05n

.meas tran vdout0_10ck1490 FIND v(dout0_10) AT=1500.05n

.meas tran vdout0_11ck1490 FIND v(dout0_11) AT=1500.05n

.meas tran vdout0_12ck1490 FIND v(dout0_12) AT=1500.05n

.meas tran vdout0_13ck1490 FIND v(dout0_13) AT=1500.05n

.meas tran vdout0_14ck1490 FIND v(dout0_14) AT=1500.05n

.meas tran vdout0_15ck1490 FIND v(dout0_15) AT=1500.05n

.meas tran vdout0_16ck1490 FIND v(dout0_16) AT=1500.05n

.meas tran vdout0_17ck1490 FIND v(dout0_17) AT=1500.05n

.meas tran vdout0_18ck1490 FIND v(dout0_18) AT=1500.05n

.meas tran vdout0_19ck1490 FIND v(dout0_19) AT=1500.05n

.meas tran vdout0_20ck1490 FIND v(dout0_20) AT=1500.05n

.meas tran vdout0_21ck1490 FIND v(dout0_21) AT=1500.05n

.meas tran vdout0_22ck1490 FIND v(dout0_22) AT=1500.05n

.meas tran vdout0_23ck1490 FIND v(dout0_23) AT=1500.05n

.meas tran vdout0_24ck1490 FIND v(dout0_24) AT=1500.05n

.meas tran vdout0_25ck1490 FIND v(dout0_25) AT=1500.05n

.meas tran vdout0_26ck1490 FIND v(dout0_26) AT=1500.05n

.meas tran vdout0_27ck1490 FIND v(dout0_27) AT=1500.05n

.meas tran vdout0_28ck1490 FIND v(dout0_28) AT=1500.05n

.meas tran vdout0_29ck1490 FIND v(dout0_29) AT=1500.05n

.meas tran vdout0_30ck1490 FIND v(dout0_30) AT=1500.05n

.meas tran vdout0_31ck1490 FIND v(dout0_31) AT=1500.05n

.meas tran vdout0_32ck1490 FIND v(dout0_32) AT=1500.05n

.meas tran vdout0_33ck1490 FIND v(dout0_33) AT=1500.05n

.meas tran vdout0_34ck1490 FIND v(dout0_34) AT=1500.05n

.meas tran vdout0_35ck1490 FIND v(dout0_35) AT=1500.05n

.meas tran vdout0_36ck1490 FIND v(dout0_36) AT=1500.05n

.meas tran vdout0_37ck1490 FIND v(dout0_37) AT=1500.05n

.meas tran vdout0_38ck1490 FIND v(dout0_38) AT=1500.05n

.meas tran vdout0_39ck1490 FIND v(dout0_39) AT=1500.05n

.meas tran vdout0_40ck1490 FIND v(dout0_40) AT=1500.05n

.meas tran vdout0_41ck1490 FIND v(dout0_41) AT=1500.05n

.meas tran vdout0_42ck1490 FIND v(dout0_42) AT=1500.05n

.meas tran vdout0_43ck1490 FIND v(dout0_43) AT=1500.05n

.meas tran vdout0_44ck1490 FIND v(dout0_44) AT=1500.05n

.meas tran vdout0_45ck1490 FIND v(dout0_45) AT=1500.05n

.meas tran vdout0_46ck1490 FIND v(dout0_46) AT=1500.05n

.meas tran vdout0_47ck1490 FIND v(dout0_47) AT=1500.05n

.meas tran vdout0_48ck1490 FIND v(dout0_48) AT=1500.05n

.meas tran vdout0_49ck1490 FIND v(dout0_49) AT=1500.05n

.meas tran vdout0_50ck1490 FIND v(dout0_50) AT=1500.05n

.meas tran vdout0_51ck1490 FIND v(dout0_51) AT=1500.05n

.meas tran vdout0_52ck1490 FIND v(dout0_52) AT=1500.05n

.meas tran vdout0_53ck1490 FIND v(dout0_53) AT=1500.05n

.meas tran vdout0_54ck1490 FIND v(dout0_54) AT=1500.05n

.meas tran vdout0_55ck1490 FIND v(dout0_55) AT=1500.05n

.meas tran vdout0_56ck1490 FIND v(dout0_56) AT=1500.05n

.meas tran vdout0_57ck1490 FIND v(dout0_57) AT=1500.05n

.meas tran vdout0_58ck1490 FIND v(dout0_58) AT=1500.05n

.meas tran vdout0_59ck1490 FIND v(dout0_59) AT=1500.05n

.meas tran vdout0_60ck1490 FIND v(dout0_60) AT=1500.05n

.meas tran vdout0_61ck1490 FIND v(dout0_61) AT=1500.05n

.meas tran vdout0_62ck1490 FIND v(dout0_62) AT=1500.05n

.meas tran vdout0_63ck1490 FIND v(dout0_63) AT=1500.05n

.meas tran vdout0_64ck1490 FIND v(dout0_64) AT=1500.05n

.meas tran vdout0_0ck1500 FIND v(dout0_0) AT=1510.05n

.meas tran vdout0_1ck1500 FIND v(dout0_1) AT=1510.05n

.meas tran vdout0_2ck1500 FIND v(dout0_2) AT=1510.05n

.meas tran vdout0_3ck1500 FIND v(dout0_3) AT=1510.05n

.meas tran vdout0_4ck1500 FIND v(dout0_4) AT=1510.05n

.meas tran vdout0_5ck1500 FIND v(dout0_5) AT=1510.05n

.meas tran vdout0_6ck1500 FIND v(dout0_6) AT=1510.05n

.meas tran vdout0_7ck1500 FIND v(dout0_7) AT=1510.05n

.meas tran vdout0_8ck1500 FIND v(dout0_8) AT=1510.05n

.meas tran vdout0_9ck1500 FIND v(dout0_9) AT=1510.05n

.meas tran vdout0_10ck1500 FIND v(dout0_10) AT=1510.05n

.meas tran vdout0_11ck1500 FIND v(dout0_11) AT=1510.05n

.meas tran vdout0_12ck1500 FIND v(dout0_12) AT=1510.05n

.meas tran vdout0_13ck1500 FIND v(dout0_13) AT=1510.05n

.meas tran vdout0_14ck1500 FIND v(dout0_14) AT=1510.05n

.meas tran vdout0_15ck1500 FIND v(dout0_15) AT=1510.05n

.meas tran vdout0_16ck1500 FIND v(dout0_16) AT=1510.05n

.meas tran vdout0_17ck1500 FIND v(dout0_17) AT=1510.05n

.meas tran vdout0_18ck1500 FIND v(dout0_18) AT=1510.05n

.meas tran vdout0_19ck1500 FIND v(dout0_19) AT=1510.05n

.meas tran vdout0_20ck1500 FIND v(dout0_20) AT=1510.05n

.meas tran vdout0_21ck1500 FIND v(dout0_21) AT=1510.05n

.meas tran vdout0_22ck1500 FIND v(dout0_22) AT=1510.05n

.meas tran vdout0_23ck1500 FIND v(dout0_23) AT=1510.05n

.meas tran vdout0_24ck1500 FIND v(dout0_24) AT=1510.05n

.meas tran vdout0_25ck1500 FIND v(dout0_25) AT=1510.05n

.meas tran vdout0_26ck1500 FIND v(dout0_26) AT=1510.05n

.meas tran vdout0_27ck1500 FIND v(dout0_27) AT=1510.05n

.meas tran vdout0_28ck1500 FIND v(dout0_28) AT=1510.05n

.meas tran vdout0_29ck1500 FIND v(dout0_29) AT=1510.05n

.meas tran vdout0_30ck1500 FIND v(dout0_30) AT=1510.05n

.meas tran vdout0_31ck1500 FIND v(dout0_31) AT=1510.05n

.meas tran vdout0_32ck1500 FIND v(dout0_32) AT=1510.05n

.meas tran vdout0_33ck1500 FIND v(dout0_33) AT=1510.05n

.meas tran vdout0_34ck1500 FIND v(dout0_34) AT=1510.05n

.meas tran vdout0_35ck1500 FIND v(dout0_35) AT=1510.05n

.meas tran vdout0_36ck1500 FIND v(dout0_36) AT=1510.05n

.meas tran vdout0_37ck1500 FIND v(dout0_37) AT=1510.05n

.meas tran vdout0_38ck1500 FIND v(dout0_38) AT=1510.05n

.meas tran vdout0_39ck1500 FIND v(dout0_39) AT=1510.05n

.meas tran vdout0_40ck1500 FIND v(dout0_40) AT=1510.05n

.meas tran vdout0_41ck1500 FIND v(dout0_41) AT=1510.05n

.meas tran vdout0_42ck1500 FIND v(dout0_42) AT=1510.05n

.meas tran vdout0_43ck1500 FIND v(dout0_43) AT=1510.05n

.meas tran vdout0_44ck1500 FIND v(dout0_44) AT=1510.05n

.meas tran vdout0_45ck1500 FIND v(dout0_45) AT=1510.05n

.meas tran vdout0_46ck1500 FIND v(dout0_46) AT=1510.05n

.meas tran vdout0_47ck1500 FIND v(dout0_47) AT=1510.05n

.meas tran vdout0_48ck1500 FIND v(dout0_48) AT=1510.05n

.meas tran vdout0_49ck1500 FIND v(dout0_49) AT=1510.05n

.meas tran vdout0_50ck1500 FIND v(dout0_50) AT=1510.05n

.meas tran vdout0_51ck1500 FIND v(dout0_51) AT=1510.05n

.meas tran vdout0_52ck1500 FIND v(dout0_52) AT=1510.05n

.meas tran vdout0_53ck1500 FIND v(dout0_53) AT=1510.05n

.meas tran vdout0_54ck1500 FIND v(dout0_54) AT=1510.05n

.meas tran vdout0_55ck1500 FIND v(dout0_55) AT=1510.05n

.meas tran vdout0_56ck1500 FIND v(dout0_56) AT=1510.05n

.meas tran vdout0_57ck1500 FIND v(dout0_57) AT=1510.05n

.meas tran vdout0_58ck1500 FIND v(dout0_58) AT=1510.05n

.meas tran vdout0_59ck1500 FIND v(dout0_59) AT=1510.05n

.meas tran vdout0_60ck1500 FIND v(dout0_60) AT=1510.05n

.meas tran vdout0_61ck1500 FIND v(dout0_61) AT=1510.05n

.meas tran vdout0_62ck1500 FIND v(dout0_62) AT=1510.05n

.meas tran vdout0_63ck1500 FIND v(dout0_63) AT=1510.05n

.meas tran vdout0_64ck1500 FIND v(dout0_64) AT=1510.05n

.meas tran vdout0_0ck1520 FIND v(dout0_0) AT=1530.05n

.meas tran vdout0_1ck1520 FIND v(dout0_1) AT=1530.05n

.meas tran vdout0_2ck1520 FIND v(dout0_2) AT=1530.05n

.meas tran vdout0_3ck1520 FIND v(dout0_3) AT=1530.05n

.meas tran vdout0_4ck1520 FIND v(dout0_4) AT=1530.05n

.meas tran vdout0_5ck1520 FIND v(dout0_5) AT=1530.05n

.meas tran vdout0_6ck1520 FIND v(dout0_6) AT=1530.05n

.meas tran vdout0_7ck1520 FIND v(dout0_7) AT=1530.05n

.meas tran vdout0_8ck1520 FIND v(dout0_8) AT=1530.05n

.meas tran vdout0_9ck1520 FIND v(dout0_9) AT=1530.05n

.meas tran vdout0_10ck1520 FIND v(dout0_10) AT=1530.05n

.meas tran vdout0_11ck1520 FIND v(dout0_11) AT=1530.05n

.meas tran vdout0_12ck1520 FIND v(dout0_12) AT=1530.05n

.meas tran vdout0_13ck1520 FIND v(dout0_13) AT=1530.05n

.meas tran vdout0_14ck1520 FIND v(dout0_14) AT=1530.05n

.meas tran vdout0_15ck1520 FIND v(dout0_15) AT=1530.05n

.meas tran vdout0_16ck1520 FIND v(dout0_16) AT=1530.05n

.meas tran vdout0_17ck1520 FIND v(dout0_17) AT=1530.05n

.meas tran vdout0_18ck1520 FIND v(dout0_18) AT=1530.05n

.meas tran vdout0_19ck1520 FIND v(dout0_19) AT=1530.05n

.meas tran vdout0_20ck1520 FIND v(dout0_20) AT=1530.05n

.meas tran vdout0_21ck1520 FIND v(dout0_21) AT=1530.05n

.meas tran vdout0_22ck1520 FIND v(dout0_22) AT=1530.05n

.meas tran vdout0_23ck1520 FIND v(dout0_23) AT=1530.05n

.meas tran vdout0_24ck1520 FIND v(dout0_24) AT=1530.05n

.meas tran vdout0_25ck1520 FIND v(dout0_25) AT=1530.05n

.meas tran vdout0_26ck1520 FIND v(dout0_26) AT=1530.05n

.meas tran vdout0_27ck1520 FIND v(dout0_27) AT=1530.05n

.meas tran vdout0_28ck1520 FIND v(dout0_28) AT=1530.05n

.meas tran vdout0_29ck1520 FIND v(dout0_29) AT=1530.05n

.meas tran vdout0_30ck1520 FIND v(dout0_30) AT=1530.05n

.meas tran vdout0_31ck1520 FIND v(dout0_31) AT=1530.05n

.meas tran vdout0_32ck1520 FIND v(dout0_32) AT=1530.05n

.meas tran vdout0_33ck1520 FIND v(dout0_33) AT=1530.05n

.meas tran vdout0_34ck1520 FIND v(dout0_34) AT=1530.05n

.meas tran vdout0_35ck1520 FIND v(dout0_35) AT=1530.05n

.meas tran vdout0_36ck1520 FIND v(dout0_36) AT=1530.05n

.meas tran vdout0_37ck1520 FIND v(dout0_37) AT=1530.05n

.meas tran vdout0_38ck1520 FIND v(dout0_38) AT=1530.05n

.meas tran vdout0_39ck1520 FIND v(dout0_39) AT=1530.05n

.meas tran vdout0_40ck1520 FIND v(dout0_40) AT=1530.05n

.meas tran vdout0_41ck1520 FIND v(dout0_41) AT=1530.05n

.meas tran vdout0_42ck1520 FIND v(dout0_42) AT=1530.05n

.meas tran vdout0_43ck1520 FIND v(dout0_43) AT=1530.05n

.meas tran vdout0_44ck1520 FIND v(dout0_44) AT=1530.05n

.meas tran vdout0_45ck1520 FIND v(dout0_45) AT=1530.05n

.meas tran vdout0_46ck1520 FIND v(dout0_46) AT=1530.05n

.meas tran vdout0_47ck1520 FIND v(dout0_47) AT=1530.05n

.meas tran vdout0_48ck1520 FIND v(dout0_48) AT=1530.05n

.meas tran vdout0_49ck1520 FIND v(dout0_49) AT=1530.05n

.meas tran vdout0_50ck1520 FIND v(dout0_50) AT=1530.05n

.meas tran vdout0_51ck1520 FIND v(dout0_51) AT=1530.05n

.meas tran vdout0_52ck1520 FIND v(dout0_52) AT=1530.05n

.meas tran vdout0_53ck1520 FIND v(dout0_53) AT=1530.05n

.meas tran vdout0_54ck1520 FIND v(dout0_54) AT=1530.05n

.meas tran vdout0_55ck1520 FIND v(dout0_55) AT=1530.05n

.meas tran vdout0_56ck1520 FIND v(dout0_56) AT=1530.05n

.meas tran vdout0_57ck1520 FIND v(dout0_57) AT=1530.05n

.meas tran vdout0_58ck1520 FIND v(dout0_58) AT=1530.05n

.meas tran vdout0_59ck1520 FIND v(dout0_59) AT=1530.05n

.meas tran vdout0_60ck1520 FIND v(dout0_60) AT=1530.05n

.meas tran vdout0_61ck1520 FIND v(dout0_61) AT=1530.05n

.meas tran vdout0_62ck1520 FIND v(dout0_62) AT=1530.05n

.meas tran vdout0_63ck1520 FIND v(dout0_63) AT=1530.05n

.meas tran vdout0_64ck1520 FIND v(dout0_64) AT=1530.05n

.meas tran vdout0_0ck1610 FIND v(dout0_0) AT=1620.05n

.meas tran vdout0_1ck1610 FIND v(dout0_1) AT=1620.05n

.meas tran vdout0_2ck1610 FIND v(dout0_2) AT=1620.05n

.meas tran vdout0_3ck1610 FIND v(dout0_3) AT=1620.05n

.meas tran vdout0_4ck1610 FIND v(dout0_4) AT=1620.05n

.meas tran vdout0_5ck1610 FIND v(dout0_5) AT=1620.05n

.meas tran vdout0_6ck1610 FIND v(dout0_6) AT=1620.05n

.meas tran vdout0_7ck1610 FIND v(dout0_7) AT=1620.05n

.meas tran vdout0_8ck1610 FIND v(dout0_8) AT=1620.05n

.meas tran vdout0_9ck1610 FIND v(dout0_9) AT=1620.05n

.meas tran vdout0_10ck1610 FIND v(dout0_10) AT=1620.05n

.meas tran vdout0_11ck1610 FIND v(dout0_11) AT=1620.05n

.meas tran vdout0_12ck1610 FIND v(dout0_12) AT=1620.05n

.meas tran vdout0_13ck1610 FIND v(dout0_13) AT=1620.05n

.meas tran vdout0_14ck1610 FIND v(dout0_14) AT=1620.05n

.meas tran vdout0_15ck1610 FIND v(dout0_15) AT=1620.05n

.meas tran vdout0_16ck1610 FIND v(dout0_16) AT=1620.05n

.meas tran vdout0_17ck1610 FIND v(dout0_17) AT=1620.05n

.meas tran vdout0_18ck1610 FIND v(dout0_18) AT=1620.05n

.meas tran vdout0_19ck1610 FIND v(dout0_19) AT=1620.05n

.meas tran vdout0_20ck1610 FIND v(dout0_20) AT=1620.05n

.meas tran vdout0_21ck1610 FIND v(dout0_21) AT=1620.05n

.meas tran vdout0_22ck1610 FIND v(dout0_22) AT=1620.05n

.meas tran vdout0_23ck1610 FIND v(dout0_23) AT=1620.05n

.meas tran vdout0_24ck1610 FIND v(dout0_24) AT=1620.05n

.meas tran vdout0_25ck1610 FIND v(dout0_25) AT=1620.05n

.meas tran vdout0_26ck1610 FIND v(dout0_26) AT=1620.05n

.meas tran vdout0_27ck1610 FIND v(dout0_27) AT=1620.05n

.meas tran vdout0_28ck1610 FIND v(dout0_28) AT=1620.05n

.meas tran vdout0_29ck1610 FIND v(dout0_29) AT=1620.05n

.meas tran vdout0_30ck1610 FIND v(dout0_30) AT=1620.05n

.meas tran vdout0_31ck1610 FIND v(dout0_31) AT=1620.05n

.meas tran vdout0_32ck1610 FIND v(dout0_32) AT=1620.05n

.meas tran vdout0_33ck1610 FIND v(dout0_33) AT=1620.05n

.meas tran vdout0_34ck1610 FIND v(dout0_34) AT=1620.05n

.meas tran vdout0_35ck1610 FIND v(dout0_35) AT=1620.05n

.meas tran vdout0_36ck1610 FIND v(dout0_36) AT=1620.05n

.meas tran vdout0_37ck1610 FIND v(dout0_37) AT=1620.05n

.meas tran vdout0_38ck1610 FIND v(dout0_38) AT=1620.05n

.meas tran vdout0_39ck1610 FIND v(dout0_39) AT=1620.05n

.meas tran vdout0_40ck1610 FIND v(dout0_40) AT=1620.05n

.meas tran vdout0_41ck1610 FIND v(dout0_41) AT=1620.05n

.meas tran vdout0_42ck1610 FIND v(dout0_42) AT=1620.05n

.meas tran vdout0_43ck1610 FIND v(dout0_43) AT=1620.05n

.meas tran vdout0_44ck1610 FIND v(dout0_44) AT=1620.05n

.meas tran vdout0_45ck1610 FIND v(dout0_45) AT=1620.05n

.meas tran vdout0_46ck1610 FIND v(dout0_46) AT=1620.05n

.meas tran vdout0_47ck1610 FIND v(dout0_47) AT=1620.05n

.meas tran vdout0_48ck1610 FIND v(dout0_48) AT=1620.05n

.meas tran vdout0_49ck1610 FIND v(dout0_49) AT=1620.05n

.meas tran vdout0_50ck1610 FIND v(dout0_50) AT=1620.05n

.meas tran vdout0_51ck1610 FIND v(dout0_51) AT=1620.05n

.meas tran vdout0_52ck1610 FIND v(dout0_52) AT=1620.05n

.meas tran vdout0_53ck1610 FIND v(dout0_53) AT=1620.05n

.meas tran vdout0_54ck1610 FIND v(dout0_54) AT=1620.05n

.meas tran vdout0_55ck1610 FIND v(dout0_55) AT=1620.05n

.meas tran vdout0_56ck1610 FIND v(dout0_56) AT=1620.05n

.meas tran vdout0_57ck1610 FIND v(dout0_57) AT=1620.05n

.meas tran vdout0_58ck1610 FIND v(dout0_58) AT=1620.05n

.meas tran vdout0_59ck1610 FIND v(dout0_59) AT=1620.05n

.meas tran vdout0_60ck1610 FIND v(dout0_60) AT=1620.05n

.meas tran vdout0_61ck1610 FIND v(dout0_61) AT=1620.05n

.meas tran vdout0_62ck1610 FIND v(dout0_62) AT=1620.05n

.meas tran vdout0_63ck1610 FIND v(dout0_63) AT=1620.05n

.meas tran vdout0_64ck1610 FIND v(dout0_64) AT=1620.05n

.meas tran vdout0_0ck1630 FIND v(dout0_0) AT=1640.05n

.meas tran vdout0_1ck1630 FIND v(dout0_1) AT=1640.05n

.meas tran vdout0_2ck1630 FIND v(dout0_2) AT=1640.05n

.meas tran vdout0_3ck1630 FIND v(dout0_3) AT=1640.05n

.meas tran vdout0_4ck1630 FIND v(dout0_4) AT=1640.05n

.meas tran vdout0_5ck1630 FIND v(dout0_5) AT=1640.05n

.meas tran vdout0_6ck1630 FIND v(dout0_6) AT=1640.05n

.meas tran vdout0_7ck1630 FIND v(dout0_7) AT=1640.05n

.meas tran vdout0_8ck1630 FIND v(dout0_8) AT=1640.05n

.meas tran vdout0_9ck1630 FIND v(dout0_9) AT=1640.05n

.meas tran vdout0_10ck1630 FIND v(dout0_10) AT=1640.05n

.meas tran vdout0_11ck1630 FIND v(dout0_11) AT=1640.05n

.meas tran vdout0_12ck1630 FIND v(dout0_12) AT=1640.05n

.meas tran vdout0_13ck1630 FIND v(dout0_13) AT=1640.05n

.meas tran vdout0_14ck1630 FIND v(dout0_14) AT=1640.05n

.meas tran vdout0_15ck1630 FIND v(dout0_15) AT=1640.05n

.meas tran vdout0_16ck1630 FIND v(dout0_16) AT=1640.05n

.meas tran vdout0_17ck1630 FIND v(dout0_17) AT=1640.05n

.meas tran vdout0_18ck1630 FIND v(dout0_18) AT=1640.05n

.meas tran vdout0_19ck1630 FIND v(dout0_19) AT=1640.05n

.meas tran vdout0_20ck1630 FIND v(dout0_20) AT=1640.05n

.meas tran vdout0_21ck1630 FIND v(dout0_21) AT=1640.05n

.meas tran vdout0_22ck1630 FIND v(dout0_22) AT=1640.05n

.meas tran vdout0_23ck1630 FIND v(dout0_23) AT=1640.05n

.meas tran vdout0_24ck1630 FIND v(dout0_24) AT=1640.05n

.meas tran vdout0_25ck1630 FIND v(dout0_25) AT=1640.05n

.meas tran vdout0_26ck1630 FIND v(dout0_26) AT=1640.05n

.meas tran vdout0_27ck1630 FIND v(dout0_27) AT=1640.05n

.meas tran vdout0_28ck1630 FIND v(dout0_28) AT=1640.05n

.meas tran vdout0_29ck1630 FIND v(dout0_29) AT=1640.05n

.meas tran vdout0_30ck1630 FIND v(dout0_30) AT=1640.05n

.meas tran vdout0_31ck1630 FIND v(dout0_31) AT=1640.05n

.meas tran vdout0_32ck1630 FIND v(dout0_32) AT=1640.05n

.meas tran vdout0_33ck1630 FIND v(dout0_33) AT=1640.05n

.meas tran vdout0_34ck1630 FIND v(dout0_34) AT=1640.05n

.meas tran vdout0_35ck1630 FIND v(dout0_35) AT=1640.05n

.meas tran vdout0_36ck1630 FIND v(dout0_36) AT=1640.05n

.meas tran vdout0_37ck1630 FIND v(dout0_37) AT=1640.05n

.meas tran vdout0_38ck1630 FIND v(dout0_38) AT=1640.05n

.meas tran vdout0_39ck1630 FIND v(dout0_39) AT=1640.05n

.meas tran vdout0_40ck1630 FIND v(dout0_40) AT=1640.05n

.meas tran vdout0_41ck1630 FIND v(dout0_41) AT=1640.05n

.meas tran vdout0_42ck1630 FIND v(dout0_42) AT=1640.05n

.meas tran vdout0_43ck1630 FIND v(dout0_43) AT=1640.05n

.meas tran vdout0_44ck1630 FIND v(dout0_44) AT=1640.05n

.meas tran vdout0_45ck1630 FIND v(dout0_45) AT=1640.05n

.meas tran vdout0_46ck1630 FIND v(dout0_46) AT=1640.05n

.meas tran vdout0_47ck1630 FIND v(dout0_47) AT=1640.05n

.meas tran vdout0_48ck1630 FIND v(dout0_48) AT=1640.05n

.meas tran vdout0_49ck1630 FIND v(dout0_49) AT=1640.05n

.meas tran vdout0_50ck1630 FIND v(dout0_50) AT=1640.05n

.meas tran vdout0_51ck1630 FIND v(dout0_51) AT=1640.05n

.meas tran vdout0_52ck1630 FIND v(dout0_52) AT=1640.05n

.meas tran vdout0_53ck1630 FIND v(dout0_53) AT=1640.05n

.meas tran vdout0_54ck1630 FIND v(dout0_54) AT=1640.05n

.meas tran vdout0_55ck1630 FIND v(dout0_55) AT=1640.05n

.meas tran vdout0_56ck1630 FIND v(dout0_56) AT=1640.05n

.meas tran vdout0_57ck1630 FIND v(dout0_57) AT=1640.05n

.meas tran vdout0_58ck1630 FIND v(dout0_58) AT=1640.05n

.meas tran vdout0_59ck1630 FIND v(dout0_59) AT=1640.05n

.meas tran vdout0_60ck1630 FIND v(dout0_60) AT=1640.05n

.meas tran vdout0_61ck1630 FIND v(dout0_61) AT=1640.05n

.meas tran vdout0_62ck1630 FIND v(dout0_62) AT=1640.05n

.meas tran vdout0_63ck1630 FIND v(dout0_63) AT=1640.05n

.meas tran vdout0_64ck1630 FIND v(dout0_64) AT=1640.05n

.meas tran vdout0_0ck1640 FIND v(dout0_0) AT=1650.05n

.meas tran vdout0_1ck1640 FIND v(dout0_1) AT=1650.05n

.meas tran vdout0_2ck1640 FIND v(dout0_2) AT=1650.05n

.meas tran vdout0_3ck1640 FIND v(dout0_3) AT=1650.05n

.meas tran vdout0_4ck1640 FIND v(dout0_4) AT=1650.05n

.meas tran vdout0_5ck1640 FIND v(dout0_5) AT=1650.05n

.meas tran vdout0_6ck1640 FIND v(dout0_6) AT=1650.05n

.meas tran vdout0_7ck1640 FIND v(dout0_7) AT=1650.05n

.meas tran vdout0_8ck1640 FIND v(dout0_8) AT=1650.05n

.meas tran vdout0_9ck1640 FIND v(dout0_9) AT=1650.05n

.meas tran vdout0_10ck1640 FIND v(dout0_10) AT=1650.05n

.meas tran vdout0_11ck1640 FIND v(dout0_11) AT=1650.05n

.meas tran vdout0_12ck1640 FIND v(dout0_12) AT=1650.05n

.meas tran vdout0_13ck1640 FIND v(dout0_13) AT=1650.05n

.meas tran vdout0_14ck1640 FIND v(dout0_14) AT=1650.05n

.meas tran vdout0_15ck1640 FIND v(dout0_15) AT=1650.05n

.meas tran vdout0_16ck1640 FIND v(dout0_16) AT=1650.05n

.meas tran vdout0_17ck1640 FIND v(dout0_17) AT=1650.05n

.meas tran vdout0_18ck1640 FIND v(dout0_18) AT=1650.05n

.meas tran vdout0_19ck1640 FIND v(dout0_19) AT=1650.05n

.meas tran vdout0_20ck1640 FIND v(dout0_20) AT=1650.05n

.meas tran vdout0_21ck1640 FIND v(dout0_21) AT=1650.05n

.meas tran vdout0_22ck1640 FIND v(dout0_22) AT=1650.05n

.meas tran vdout0_23ck1640 FIND v(dout0_23) AT=1650.05n

.meas tran vdout0_24ck1640 FIND v(dout0_24) AT=1650.05n

.meas tran vdout0_25ck1640 FIND v(dout0_25) AT=1650.05n

.meas tran vdout0_26ck1640 FIND v(dout0_26) AT=1650.05n

.meas tran vdout0_27ck1640 FIND v(dout0_27) AT=1650.05n

.meas tran vdout0_28ck1640 FIND v(dout0_28) AT=1650.05n

.meas tran vdout0_29ck1640 FIND v(dout0_29) AT=1650.05n

.meas tran vdout0_30ck1640 FIND v(dout0_30) AT=1650.05n

.meas tran vdout0_31ck1640 FIND v(dout0_31) AT=1650.05n

.meas tran vdout0_32ck1640 FIND v(dout0_32) AT=1650.05n

.meas tran vdout0_33ck1640 FIND v(dout0_33) AT=1650.05n

.meas tran vdout0_34ck1640 FIND v(dout0_34) AT=1650.05n

.meas tran vdout0_35ck1640 FIND v(dout0_35) AT=1650.05n

.meas tran vdout0_36ck1640 FIND v(dout0_36) AT=1650.05n

.meas tran vdout0_37ck1640 FIND v(dout0_37) AT=1650.05n

.meas tran vdout0_38ck1640 FIND v(dout0_38) AT=1650.05n

.meas tran vdout0_39ck1640 FIND v(dout0_39) AT=1650.05n

.meas tran vdout0_40ck1640 FIND v(dout0_40) AT=1650.05n

.meas tran vdout0_41ck1640 FIND v(dout0_41) AT=1650.05n

.meas tran vdout0_42ck1640 FIND v(dout0_42) AT=1650.05n

.meas tran vdout0_43ck1640 FIND v(dout0_43) AT=1650.05n

.meas tran vdout0_44ck1640 FIND v(dout0_44) AT=1650.05n

.meas tran vdout0_45ck1640 FIND v(dout0_45) AT=1650.05n

.meas tran vdout0_46ck1640 FIND v(dout0_46) AT=1650.05n

.meas tran vdout0_47ck1640 FIND v(dout0_47) AT=1650.05n

.meas tran vdout0_48ck1640 FIND v(dout0_48) AT=1650.05n

.meas tran vdout0_49ck1640 FIND v(dout0_49) AT=1650.05n

.meas tran vdout0_50ck1640 FIND v(dout0_50) AT=1650.05n

.meas tran vdout0_51ck1640 FIND v(dout0_51) AT=1650.05n

.meas tran vdout0_52ck1640 FIND v(dout0_52) AT=1650.05n

.meas tran vdout0_53ck1640 FIND v(dout0_53) AT=1650.05n

.meas tran vdout0_54ck1640 FIND v(dout0_54) AT=1650.05n

.meas tran vdout0_55ck1640 FIND v(dout0_55) AT=1650.05n

.meas tran vdout0_56ck1640 FIND v(dout0_56) AT=1650.05n

.meas tran vdout0_57ck1640 FIND v(dout0_57) AT=1650.05n

.meas tran vdout0_58ck1640 FIND v(dout0_58) AT=1650.05n

.meas tran vdout0_59ck1640 FIND v(dout0_59) AT=1650.05n

.meas tran vdout0_60ck1640 FIND v(dout0_60) AT=1650.05n

.meas tran vdout0_61ck1640 FIND v(dout0_61) AT=1650.05n

.meas tran vdout0_62ck1640 FIND v(dout0_62) AT=1650.05n

.meas tran vdout0_63ck1640 FIND v(dout0_63) AT=1650.05n

.meas tran vdout0_64ck1640 FIND v(dout0_64) AT=1650.05n

.meas tran vdout0_0ck1710 FIND v(dout0_0) AT=1720.05n

.meas tran vdout0_1ck1710 FIND v(dout0_1) AT=1720.05n

.meas tran vdout0_2ck1710 FIND v(dout0_2) AT=1720.05n

.meas tran vdout0_3ck1710 FIND v(dout0_3) AT=1720.05n

.meas tran vdout0_4ck1710 FIND v(dout0_4) AT=1720.05n

.meas tran vdout0_5ck1710 FIND v(dout0_5) AT=1720.05n

.meas tran vdout0_6ck1710 FIND v(dout0_6) AT=1720.05n

.meas tran vdout0_7ck1710 FIND v(dout0_7) AT=1720.05n

.meas tran vdout0_8ck1710 FIND v(dout0_8) AT=1720.05n

.meas tran vdout0_9ck1710 FIND v(dout0_9) AT=1720.05n

.meas tran vdout0_10ck1710 FIND v(dout0_10) AT=1720.05n

.meas tran vdout0_11ck1710 FIND v(dout0_11) AT=1720.05n

.meas tran vdout0_12ck1710 FIND v(dout0_12) AT=1720.05n

.meas tran vdout0_13ck1710 FIND v(dout0_13) AT=1720.05n

.meas tran vdout0_14ck1710 FIND v(dout0_14) AT=1720.05n

.meas tran vdout0_15ck1710 FIND v(dout0_15) AT=1720.05n

.meas tran vdout0_16ck1710 FIND v(dout0_16) AT=1720.05n

.meas tran vdout0_17ck1710 FIND v(dout0_17) AT=1720.05n

.meas tran vdout0_18ck1710 FIND v(dout0_18) AT=1720.05n

.meas tran vdout0_19ck1710 FIND v(dout0_19) AT=1720.05n

.meas tran vdout0_20ck1710 FIND v(dout0_20) AT=1720.05n

.meas tran vdout0_21ck1710 FIND v(dout0_21) AT=1720.05n

.meas tran vdout0_22ck1710 FIND v(dout0_22) AT=1720.05n

.meas tran vdout0_23ck1710 FIND v(dout0_23) AT=1720.05n

.meas tran vdout0_24ck1710 FIND v(dout0_24) AT=1720.05n

.meas tran vdout0_25ck1710 FIND v(dout0_25) AT=1720.05n

.meas tran vdout0_26ck1710 FIND v(dout0_26) AT=1720.05n

.meas tran vdout0_27ck1710 FIND v(dout0_27) AT=1720.05n

.meas tran vdout0_28ck1710 FIND v(dout0_28) AT=1720.05n

.meas tran vdout0_29ck1710 FIND v(dout0_29) AT=1720.05n

.meas tran vdout0_30ck1710 FIND v(dout0_30) AT=1720.05n

.meas tran vdout0_31ck1710 FIND v(dout0_31) AT=1720.05n

.meas tran vdout0_32ck1710 FIND v(dout0_32) AT=1720.05n

.meas tran vdout0_33ck1710 FIND v(dout0_33) AT=1720.05n

.meas tran vdout0_34ck1710 FIND v(dout0_34) AT=1720.05n

.meas tran vdout0_35ck1710 FIND v(dout0_35) AT=1720.05n

.meas tran vdout0_36ck1710 FIND v(dout0_36) AT=1720.05n

.meas tran vdout0_37ck1710 FIND v(dout0_37) AT=1720.05n

.meas tran vdout0_38ck1710 FIND v(dout0_38) AT=1720.05n

.meas tran vdout0_39ck1710 FIND v(dout0_39) AT=1720.05n

.meas tran vdout0_40ck1710 FIND v(dout0_40) AT=1720.05n

.meas tran vdout0_41ck1710 FIND v(dout0_41) AT=1720.05n

.meas tran vdout0_42ck1710 FIND v(dout0_42) AT=1720.05n

.meas tran vdout0_43ck1710 FIND v(dout0_43) AT=1720.05n

.meas tran vdout0_44ck1710 FIND v(dout0_44) AT=1720.05n

.meas tran vdout0_45ck1710 FIND v(dout0_45) AT=1720.05n

.meas tran vdout0_46ck1710 FIND v(dout0_46) AT=1720.05n

.meas tran vdout0_47ck1710 FIND v(dout0_47) AT=1720.05n

.meas tran vdout0_48ck1710 FIND v(dout0_48) AT=1720.05n

.meas tran vdout0_49ck1710 FIND v(dout0_49) AT=1720.05n

.meas tran vdout0_50ck1710 FIND v(dout0_50) AT=1720.05n

.meas tran vdout0_51ck1710 FIND v(dout0_51) AT=1720.05n

.meas tran vdout0_52ck1710 FIND v(dout0_52) AT=1720.05n

.meas tran vdout0_53ck1710 FIND v(dout0_53) AT=1720.05n

.meas tran vdout0_54ck1710 FIND v(dout0_54) AT=1720.05n

.meas tran vdout0_55ck1710 FIND v(dout0_55) AT=1720.05n

.meas tran vdout0_56ck1710 FIND v(dout0_56) AT=1720.05n

.meas tran vdout0_57ck1710 FIND v(dout0_57) AT=1720.05n

.meas tran vdout0_58ck1710 FIND v(dout0_58) AT=1720.05n

.meas tran vdout0_59ck1710 FIND v(dout0_59) AT=1720.05n

.meas tran vdout0_60ck1710 FIND v(dout0_60) AT=1720.05n

.meas tran vdout0_61ck1710 FIND v(dout0_61) AT=1720.05n

.meas tran vdout0_62ck1710 FIND v(dout0_62) AT=1720.05n

.meas tran vdout0_63ck1710 FIND v(dout0_63) AT=1720.05n

.meas tran vdout0_64ck1710 FIND v(dout0_64) AT=1720.05n

.meas tran vdout0_0ck1730 FIND v(dout0_0) AT=1740.05n

.meas tran vdout0_1ck1730 FIND v(dout0_1) AT=1740.05n

.meas tran vdout0_2ck1730 FIND v(dout0_2) AT=1740.05n

.meas tran vdout0_3ck1730 FIND v(dout0_3) AT=1740.05n

.meas tran vdout0_4ck1730 FIND v(dout0_4) AT=1740.05n

.meas tran vdout0_5ck1730 FIND v(dout0_5) AT=1740.05n

.meas tran vdout0_6ck1730 FIND v(dout0_6) AT=1740.05n

.meas tran vdout0_7ck1730 FIND v(dout0_7) AT=1740.05n

.meas tran vdout0_8ck1730 FIND v(dout0_8) AT=1740.05n

.meas tran vdout0_9ck1730 FIND v(dout0_9) AT=1740.05n

.meas tran vdout0_10ck1730 FIND v(dout0_10) AT=1740.05n

.meas tran vdout0_11ck1730 FIND v(dout0_11) AT=1740.05n

.meas tran vdout0_12ck1730 FIND v(dout0_12) AT=1740.05n

.meas tran vdout0_13ck1730 FIND v(dout0_13) AT=1740.05n

.meas tran vdout0_14ck1730 FIND v(dout0_14) AT=1740.05n

.meas tran vdout0_15ck1730 FIND v(dout0_15) AT=1740.05n

.meas tran vdout0_16ck1730 FIND v(dout0_16) AT=1740.05n

.meas tran vdout0_17ck1730 FIND v(dout0_17) AT=1740.05n

.meas tran vdout0_18ck1730 FIND v(dout0_18) AT=1740.05n

.meas tran vdout0_19ck1730 FIND v(dout0_19) AT=1740.05n

.meas tran vdout0_20ck1730 FIND v(dout0_20) AT=1740.05n

.meas tran vdout0_21ck1730 FIND v(dout0_21) AT=1740.05n

.meas tran vdout0_22ck1730 FIND v(dout0_22) AT=1740.05n

.meas tran vdout0_23ck1730 FIND v(dout0_23) AT=1740.05n

.meas tran vdout0_24ck1730 FIND v(dout0_24) AT=1740.05n

.meas tran vdout0_25ck1730 FIND v(dout0_25) AT=1740.05n

.meas tran vdout0_26ck1730 FIND v(dout0_26) AT=1740.05n

.meas tran vdout0_27ck1730 FIND v(dout0_27) AT=1740.05n

.meas tran vdout0_28ck1730 FIND v(dout0_28) AT=1740.05n

.meas tran vdout0_29ck1730 FIND v(dout0_29) AT=1740.05n

.meas tran vdout0_30ck1730 FIND v(dout0_30) AT=1740.05n

.meas tran vdout0_31ck1730 FIND v(dout0_31) AT=1740.05n

.meas tran vdout0_32ck1730 FIND v(dout0_32) AT=1740.05n

.meas tran vdout0_33ck1730 FIND v(dout0_33) AT=1740.05n

.meas tran vdout0_34ck1730 FIND v(dout0_34) AT=1740.05n

.meas tran vdout0_35ck1730 FIND v(dout0_35) AT=1740.05n

.meas tran vdout0_36ck1730 FIND v(dout0_36) AT=1740.05n

.meas tran vdout0_37ck1730 FIND v(dout0_37) AT=1740.05n

.meas tran vdout0_38ck1730 FIND v(dout0_38) AT=1740.05n

.meas tran vdout0_39ck1730 FIND v(dout0_39) AT=1740.05n

.meas tran vdout0_40ck1730 FIND v(dout0_40) AT=1740.05n

.meas tran vdout0_41ck1730 FIND v(dout0_41) AT=1740.05n

.meas tran vdout0_42ck1730 FIND v(dout0_42) AT=1740.05n

.meas tran vdout0_43ck1730 FIND v(dout0_43) AT=1740.05n

.meas tran vdout0_44ck1730 FIND v(dout0_44) AT=1740.05n

.meas tran vdout0_45ck1730 FIND v(dout0_45) AT=1740.05n

.meas tran vdout0_46ck1730 FIND v(dout0_46) AT=1740.05n

.meas tran vdout0_47ck1730 FIND v(dout0_47) AT=1740.05n

.meas tran vdout0_48ck1730 FIND v(dout0_48) AT=1740.05n

.meas tran vdout0_49ck1730 FIND v(dout0_49) AT=1740.05n

.meas tran vdout0_50ck1730 FIND v(dout0_50) AT=1740.05n

.meas tran vdout0_51ck1730 FIND v(dout0_51) AT=1740.05n

.meas tran vdout0_52ck1730 FIND v(dout0_52) AT=1740.05n

.meas tran vdout0_53ck1730 FIND v(dout0_53) AT=1740.05n

.meas tran vdout0_54ck1730 FIND v(dout0_54) AT=1740.05n

.meas tran vdout0_55ck1730 FIND v(dout0_55) AT=1740.05n

.meas tran vdout0_56ck1730 FIND v(dout0_56) AT=1740.05n

.meas tran vdout0_57ck1730 FIND v(dout0_57) AT=1740.05n

.meas tran vdout0_58ck1730 FIND v(dout0_58) AT=1740.05n

.meas tran vdout0_59ck1730 FIND v(dout0_59) AT=1740.05n

.meas tran vdout0_60ck1730 FIND v(dout0_60) AT=1740.05n

.meas tran vdout0_61ck1730 FIND v(dout0_61) AT=1740.05n

.meas tran vdout0_62ck1730 FIND v(dout0_62) AT=1740.05n

.meas tran vdout0_63ck1730 FIND v(dout0_63) AT=1740.05n

.meas tran vdout0_64ck1730 FIND v(dout0_64) AT=1740.05n

.meas tran vdout0_0ck1770 FIND v(dout0_0) AT=1780.05n

.meas tran vdout0_1ck1770 FIND v(dout0_1) AT=1780.05n

.meas tran vdout0_2ck1770 FIND v(dout0_2) AT=1780.05n

.meas tran vdout0_3ck1770 FIND v(dout0_3) AT=1780.05n

.meas tran vdout0_4ck1770 FIND v(dout0_4) AT=1780.05n

.meas tran vdout0_5ck1770 FIND v(dout0_5) AT=1780.05n

.meas tran vdout0_6ck1770 FIND v(dout0_6) AT=1780.05n

.meas tran vdout0_7ck1770 FIND v(dout0_7) AT=1780.05n

.meas tran vdout0_8ck1770 FIND v(dout0_8) AT=1780.05n

.meas tran vdout0_9ck1770 FIND v(dout0_9) AT=1780.05n

.meas tran vdout0_10ck1770 FIND v(dout0_10) AT=1780.05n

.meas tran vdout0_11ck1770 FIND v(dout0_11) AT=1780.05n

.meas tran vdout0_12ck1770 FIND v(dout0_12) AT=1780.05n

.meas tran vdout0_13ck1770 FIND v(dout0_13) AT=1780.05n

.meas tran vdout0_14ck1770 FIND v(dout0_14) AT=1780.05n

.meas tran vdout0_15ck1770 FIND v(dout0_15) AT=1780.05n

.meas tran vdout0_16ck1770 FIND v(dout0_16) AT=1780.05n

.meas tran vdout0_17ck1770 FIND v(dout0_17) AT=1780.05n

.meas tran vdout0_18ck1770 FIND v(dout0_18) AT=1780.05n

.meas tran vdout0_19ck1770 FIND v(dout0_19) AT=1780.05n

.meas tran vdout0_20ck1770 FIND v(dout0_20) AT=1780.05n

.meas tran vdout0_21ck1770 FIND v(dout0_21) AT=1780.05n

.meas tran vdout0_22ck1770 FIND v(dout0_22) AT=1780.05n

.meas tran vdout0_23ck1770 FIND v(dout0_23) AT=1780.05n

.meas tran vdout0_24ck1770 FIND v(dout0_24) AT=1780.05n

.meas tran vdout0_25ck1770 FIND v(dout0_25) AT=1780.05n

.meas tran vdout0_26ck1770 FIND v(dout0_26) AT=1780.05n

.meas tran vdout0_27ck1770 FIND v(dout0_27) AT=1780.05n

.meas tran vdout0_28ck1770 FIND v(dout0_28) AT=1780.05n

.meas tran vdout0_29ck1770 FIND v(dout0_29) AT=1780.05n

.meas tran vdout0_30ck1770 FIND v(dout0_30) AT=1780.05n

.meas tran vdout0_31ck1770 FIND v(dout0_31) AT=1780.05n

.meas tran vdout0_32ck1770 FIND v(dout0_32) AT=1780.05n

.meas tran vdout0_33ck1770 FIND v(dout0_33) AT=1780.05n

.meas tran vdout0_34ck1770 FIND v(dout0_34) AT=1780.05n

.meas tran vdout0_35ck1770 FIND v(dout0_35) AT=1780.05n

.meas tran vdout0_36ck1770 FIND v(dout0_36) AT=1780.05n

.meas tran vdout0_37ck1770 FIND v(dout0_37) AT=1780.05n

.meas tran vdout0_38ck1770 FIND v(dout0_38) AT=1780.05n

.meas tran vdout0_39ck1770 FIND v(dout0_39) AT=1780.05n

.meas tran vdout0_40ck1770 FIND v(dout0_40) AT=1780.05n

.meas tran vdout0_41ck1770 FIND v(dout0_41) AT=1780.05n

.meas tran vdout0_42ck1770 FIND v(dout0_42) AT=1780.05n

.meas tran vdout0_43ck1770 FIND v(dout0_43) AT=1780.05n

.meas tran vdout0_44ck1770 FIND v(dout0_44) AT=1780.05n

.meas tran vdout0_45ck1770 FIND v(dout0_45) AT=1780.05n

.meas tran vdout0_46ck1770 FIND v(dout0_46) AT=1780.05n

.meas tran vdout0_47ck1770 FIND v(dout0_47) AT=1780.05n

.meas tran vdout0_48ck1770 FIND v(dout0_48) AT=1780.05n

.meas tran vdout0_49ck1770 FIND v(dout0_49) AT=1780.05n

.meas tran vdout0_50ck1770 FIND v(dout0_50) AT=1780.05n

.meas tran vdout0_51ck1770 FIND v(dout0_51) AT=1780.05n

.meas tran vdout0_52ck1770 FIND v(dout0_52) AT=1780.05n

.meas tran vdout0_53ck1770 FIND v(dout0_53) AT=1780.05n

.meas tran vdout0_54ck1770 FIND v(dout0_54) AT=1780.05n

.meas tran vdout0_55ck1770 FIND v(dout0_55) AT=1780.05n

.meas tran vdout0_56ck1770 FIND v(dout0_56) AT=1780.05n

.meas tran vdout0_57ck1770 FIND v(dout0_57) AT=1780.05n

.meas tran vdout0_58ck1770 FIND v(dout0_58) AT=1780.05n

.meas tran vdout0_59ck1770 FIND v(dout0_59) AT=1780.05n

.meas tran vdout0_60ck1770 FIND v(dout0_60) AT=1780.05n

.meas tran vdout0_61ck1770 FIND v(dout0_61) AT=1780.05n

.meas tran vdout0_62ck1770 FIND v(dout0_62) AT=1780.05n

.meas tran vdout0_63ck1770 FIND v(dout0_63) AT=1780.05n

.meas tran vdout0_64ck1770 FIND v(dout0_64) AT=1780.05n

.meas tran vdout0_0ck1780 FIND v(dout0_0) AT=1790.05n

.meas tran vdout0_1ck1780 FIND v(dout0_1) AT=1790.05n

.meas tran vdout0_2ck1780 FIND v(dout0_2) AT=1790.05n

.meas tran vdout0_3ck1780 FIND v(dout0_3) AT=1790.05n

.meas tran vdout0_4ck1780 FIND v(dout0_4) AT=1790.05n

.meas tran vdout0_5ck1780 FIND v(dout0_5) AT=1790.05n

.meas tran vdout0_6ck1780 FIND v(dout0_6) AT=1790.05n

.meas tran vdout0_7ck1780 FIND v(dout0_7) AT=1790.05n

.meas tran vdout0_8ck1780 FIND v(dout0_8) AT=1790.05n

.meas tran vdout0_9ck1780 FIND v(dout0_9) AT=1790.05n

.meas tran vdout0_10ck1780 FIND v(dout0_10) AT=1790.05n

.meas tran vdout0_11ck1780 FIND v(dout0_11) AT=1790.05n

.meas tran vdout0_12ck1780 FIND v(dout0_12) AT=1790.05n

.meas tran vdout0_13ck1780 FIND v(dout0_13) AT=1790.05n

.meas tran vdout0_14ck1780 FIND v(dout0_14) AT=1790.05n

.meas tran vdout0_15ck1780 FIND v(dout0_15) AT=1790.05n

.meas tran vdout0_16ck1780 FIND v(dout0_16) AT=1790.05n

.meas tran vdout0_17ck1780 FIND v(dout0_17) AT=1790.05n

.meas tran vdout0_18ck1780 FIND v(dout0_18) AT=1790.05n

.meas tran vdout0_19ck1780 FIND v(dout0_19) AT=1790.05n

.meas tran vdout0_20ck1780 FIND v(dout0_20) AT=1790.05n

.meas tran vdout0_21ck1780 FIND v(dout0_21) AT=1790.05n

.meas tran vdout0_22ck1780 FIND v(dout0_22) AT=1790.05n

.meas tran vdout0_23ck1780 FIND v(dout0_23) AT=1790.05n

.meas tran vdout0_24ck1780 FIND v(dout0_24) AT=1790.05n

.meas tran vdout0_25ck1780 FIND v(dout0_25) AT=1790.05n

.meas tran vdout0_26ck1780 FIND v(dout0_26) AT=1790.05n

.meas tran vdout0_27ck1780 FIND v(dout0_27) AT=1790.05n

.meas tran vdout0_28ck1780 FIND v(dout0_28) AT=1790.05n

.meas tran vdout0_29ck1780 FIND v(dout0_29) AT=1790.05n

.meas tran vdout0_30ck1780 FIND v(dout0_30) AT=1790.05n

.meas tran vdout0_31ck1780 FIND v(dout0_31) AT=1790.05n

.meas tran vdout0_32ck1780 FIND v(dout0_32) AT=1790.05n

.meas tran vdout0_33ck1780 FIND v(dout0_33) AT=1790.05n

.meas tran vdout0_34ck1780 FIND v(dout0_34) AT=1790.05n

.meas tran vdout0_35ck1780 FIND v(dout0_35) AT=1790.05n

.meas tran vdout0_36ck1780 FIND v(dout0_36) AT=1790.05n

.meas tran vdout0_37ck1780 FIND v(dout0_37) AT=1790.05n

.meas tran vdout0_38ck1780 FIND v(dout0_38) AT=1790.05n

.meas tran vdout0_39ck1780 FIND v(dout0_39) AT=1790.05n

.meas tran vdout0_40ck1780 FIND v(dout0_40) AT=1790.05n

.meas tran vdout0_41ck1780 FIND v(dout0_41) AT=1790.05n

.meas tran vdout0_42ck1780 FIND v(dout0_42) AT=1790.05n

.meas tran vdout0_43ck1780 FIND v(dout0_43) AT=1790.05n

.meas tran vdout0_44ck1780 FIND v(dout0_44) AT=1790.05n

.meas tran vdout0_45ck1780 FIND v(dout0_45) AT=1790.05n

.meas tran vdout0_46ck1780 FIND v(dout0_46) AT=1790.05n

.meas tran vdout0_47ck1780 FIND v(dout0_47) AT=1790.05n

.meas tran vdout0_48ck1780 FIND v(dout0_48) AT=1790.05n

.meas tran vdout0_49ck1780 FIND v(dout0_49) AT=1790.05n

.meas tran vdout0_50ck1780 FIND v(dout0_50) AT=1790.05n

.meas tran vdout0_51ck1780 FIND v(dout0_51) AT=1790.05n

.meas tran vdout0_52ck1780 FIND v(dout0_52) AT=1790.05n

.meas tran vdout0_53ck1780 FIND v(dout0_53) AT=1790.05n

.meas tran vdout0_54ck1780 FIND v(dout0_54) AT=1790.05n

.meas tran vdout0_55ck1780 FIND v(dout0_55) AT=1790.05n

.meas tran vdout0_56ck1780 FIND v(dout0_56) AT=1790.05n

.meas tran vdout0_57ck1780 FIND v(dout0_57) AT=1790.05n

.meas tran vdout0_58ck1780 FIND v(dout0_58) AT=1790.05n

.meas tran vdout0_59ck1780 FIND v(dout0_59) AT=1790.05n

.meas tran vdout0_60ck1780 FIND v(dout0_60) AT=1790.05n

.meas tran vdout0_61ck1780 FIND v(dout0_61) AT=1790.05n

.meas tran vdout0_62ck1780 FIND v(dout0_62) AT=1790.05n

.meas tran vdout0_63ck1780 FIND v(dout0_63) AT=1790.05n

.meas tran vdout0_64ck1780 FIND v(dout0_64) AT=1790.05n

.meas tran vdout0_0ck1790 FIND v(dout0_0) AT=1800.05n

.meas tran vdout0_1ck1790 FIND v(dout0_1) AT=1800.05n

.meas tran vdout0_2ck1790 FIND v(dout0_2) AT=1800.05n

.meas tran vdout0_3ck1790 FIND v(dout0_3) AT=1800.05n

.meas tran vdout0_4ck1790 FIND v(dout0_4) AT=1800.05n

.meas tran vdout0_5ck1790 FIND v(dout0_5) AT=1800.05n

.meas tran vdout0_6ck1790 FIND v(dout0_6) AT=1800.05n

.meas tran vdout0_7ck1790 FIND v(dout0_7) AT=1800.05n

.meas tran vdout0_8ck1790 FIND v(dout0_8) AT=1800.05n

.meas tran vdout0_9ck1790 FIND v(dout0_9) AT=1800.05n

.meas tran vdout0_10ck1790 FIND v(dout0_10) AT=1800.05n

.meas tran vdout0_11ck1790 FIND v(dout0_11) AT=1800.05n

.meas tran vdout0_12ck1790 FIND v(dout0_12) AT=1800.05n

.meas tran vdout0_13ck1790 FIND v(dout0_13) AT=1800.05n

.meas tran vdout0_14ck1790 FIND v(dout0_14) AT=1800.05n

.meas tran vdout0_15ck1790 FIND v(dout0_15) AT=1800.05n

.meas tran vdout0_16ck1790 FIND v(dout0_16) AT=1800.05n

.meas tran vdout0_17ck1790 FIND v(dout0_17) AT=1800.05n

.meas tran vdout0_18ck1790 FIND v(dout0_18) AT=1800.05n

.meas tran vdout0_19ck1790 FIND v(dout0_19) AT=1800.05n

.meas tran vdout0_20ck1790 FIND v(dout0_20) AT=1800.05n

.meas tran vdout0_21ck1790 FIND v(dout0_21) AT=1800.05n

.meas tran vdout0_22ck1790 FIND v(dout0_22) AT=1800.05n

.meas tran vdout0_23ck1790 FIND v(dout0_23) AT=1800.05n

.meas tran vdout0_24ck1790 FIND v(dout0_24) AT=1800.05n

.meas tran vdout0_25ck1790 FIND v(dout0_25) AT=1800.05n

.meas tran vdout0_26ck1790 FIND v(dout0_26) AT=1800.05n

.meas tran vdout0_27ck1790 FIND v(dout0_27) AT=1800.05n

.meas tran vdout0_28ck1790 FIND v(dout0_28) AT=1800.05n

.meas tran vdout0_29ck1790 FIND v(dout0_29) AT=1800.05n

.meas tran vdout0_30ck1790 FIND v(dout0_30) AT=1800.05n

.meas tran vdout0_31ck1790 FIND v(dout0_31) AT=1800.05n

.meas tran vdout0_32ck1790 FIND v(dout0_32) AT=1800.05n

.meas tran vdout0_33ck1790 FIND v(dout0_33) AT=1800.05n

.meas tran vdout0_34ck1790 FIND v(dout0_34) AT=1800.05n

.meas tran vdout0_35ck1790 FIND v(dout0_35) AT=1800.05n

.meas tran vdout0_36ck1790 FIND v(dout0_36) AT=1800.05n

.meas tran vdout0_37ck1790 FIND v(dout0_37) AT=1800.05n

.meas tran vdout0_38ck1790 FIND v(dout0_38) AT=1800.05n

.meas tran vdout0_39ck1790 FIND v(dout0_39) AT=1800.05n

.meas tran vdout0_40ck1790 FIND v(dout0_40) AT=1800.05n

.meas tran vdout0_41ck1790 FIND v(dout0_41) AT=1800.05n

.meas tran vdout0_42ck1790 FIND v(dout0_42) AT=1800.05n

.meas tran vdout0_43ck1790 FIND v(dout0_43) AT=1800.05n

.meas tran vdout0_44ck1790 FIND v(dout0_44) AT=1800.05n

.meas tran vdout0_45ck1790 FIND v(dout0_45) AT=1800.05n

.meas tran vdout0_46ck1790 FIND v(dout0_46) AT=1800.05n

.meas tran vdout0_47ck1790 FIND v(dout0_47) AT=1800.05n

.meas tran vdout0_48ck1790 FIND v(dout0_48) AT=1800.05n

.meas tran vdout0_49ck1790 FIND v(dout0_49) AT=1800.05n

.meas tran vdout0_50ck1790 FIND v(dout0_50) AT=1800.05n

.meas tran vdout0_51ck1790 FIND v(dout0_51) AT=1800.05n

.meas tran vdout0_52ck1790 FIND v(dout0_52) AT=1800.05n

.meas tran vdout0_53ck1790 FIND v(dout0_53) AT=1800.05n

.meas tran vdout0_54ck1790 FIND v(dout0_54) AT=1800.05n

.meas tran vdout0_55ck1790 FIND v(dout0_55) AT=1800.05n

.meas tran vdout0_56ck1790 FIND v(dout0_56) AT=1800.05n

.meas tran vdout0_57ck1790 FIND v(dout0_57) AT=1800.05n

.meas tran vdout0_58ck1790 FIND v(dout0_58) AT=1800.05n

.meas tran vdout0_59ck1790 FIND v(dout0_59) AT=1800.05n

.meas tran vdout0_60ck1790 FIND v(dout0_60) AT=1800.05n

.meas tran vdout0_61ck1790 FIND v(dout0_61) AT=1800.05n

.meas tran vdout0_62ck1790 FIND v(dout0_62) AT=1800.05n

.meas tran vdout0_63ck1790 FIND v(dout0_63) AT=1800.05n

.meas tran vdout0_64ck1790 FIND v(dout0_64) AT=1800.05n

.meas tran vdout0_0ck1810 FIND v(dout0_0) AT=1820.05n

.meas tran vdout0_1ck1810 FIND v(dout0_1) AT=1820.05n

.meas tran vdout0_2ck1810 FIND v(dout0_2) AT=1820.05n

.meas tran vdout0_3ck1810 FIND v(dout0_3) AT=1820.05n

.meas tran vdout0_4ck1810 FIND v(dout0_4) AT=1820.05n

.meas tran vdout0_5ck1810 FIND v(dout0_5) AT=1820.05n

.meas tran vdout0_6ck1810 FIND v(dout0_6) AT=1820.05n

.meas tran vdout0_7ck1810 FIND v(dout0_7) AT=1820.05n

.meas tran vdout0_8ck1810 FIND v(dout0_8) AT=1820.05n

.meas tran vdout0_9ck1810 FIND v(dout0_9) AT=1820.05n

.meas tran vdout0_10ck1810 FIND v(dout0_10) AT=1820.05n

.meas tran vdout0_11ck1810 FIND v(dout0_11) AT=1820.05n

.meas tran vdout0_12ck1810 FIND v(dout0_12) AT=1820.05n

.meas tran vdout0_13ck1810 FIND v(dout0_13) AT=1820.05n

.meas tran vdout0_14ck1810 FIND v(dout0_14) AT=1820.05n

.meas tran vdout0_15ck1810 FIND v(dout0_15) AT=1820.05n

.meas tran vdout0_16ck1810 FIND v(dout0_16) AT=1820.05n

.meas tran vdout0_17ck1810 FIND v(dout0_17) AT=1820.05n

.meas tran vdout0_18ck1810 FIND v(dout0_18) AT=1820.05n

.meas tran vdout0_19ck1810 FIND v(dout0_19) AT=1820.05n

.meas tran vdout0_20ck1810 FIND v(dout0_20) AT=1820.05n

.meas tran vdout0_21ck1810 FIND v(dout0_21) AT=1820.05n

.meas tran vdout0_22ck1810 FIND v(dout0_22) AT=1820.05n

.meas tran vdout0_23ck1810 FIND v(dout0_23) AT=1820.05n

.meas tran vdout0_24ck1810 FIND v(dout0_24) AT=1820.05n

.meas tran vdout0_25ck1810 FIND v(dout0_25) AT=1820.05n

.meas tran vdout0_26ck1810 FIND v(dout0_26) AT=1820.05n

.meas tran vdout0_27ck1810 FIND v(dout0_27) AT=1820.05n

.meas tran vdout0_28ck1810 FIND v(dout0_28) AT=1820.05n

.meas tran vdout0_29ck1810 FIND v(dout0_29) AT=1820.05n

.meas tran vdout0_30ck1810 FIND v(dout0_30) AT=1820.05n

.meas tran vdout0_31ck1810 FIND v(dout0_31) AT=1820.05n

.meas tran vdout0_32ck1810 FIND v(dout0_32) AT=1820.05n

.meas tran vdout0_33ck1810 FIND v(dout0_33) AT=1820.05n

.meas tran vdout0_34ck1810 FIND v(dout0_34) AT=1820.05n

.meas tran vdout0_35ck1810 FIND v(dout0_35) AT=1820.05n

.meas tran vdout0_36ck1810 FIND v(dout0_36) AT=1820.05n

.meas tran vdout0_37ck1810 FIND v(dout0_37) AT=1820.05n

.meas tran vdout0_38ck1810 FIND v(dout0_38) AT=1820.05n

.meas tran vdout0_39ck1810 FIND v(dout0_39) AT=1820.05n

.meas tran vdout0_40ck1810 FIND v(dout0_40) AT=1820.05n

.meas tran vdout0_41ck1810 FIND v(dout0_41) AT=1820.05n

.meas tran vdout0_42ck1810 FIND v(dout0_42) AT=1820.05n

.meas tran vdout0_43ck1810 FIND v(dout0_43) AT=1820.05n

.meas tran vdout0_44ck1810 FIND v(dout0_44) AT=1820.05n

.meas tran vdout0_45ck1810 FIND v(dout0_45) AT=1820.05n

.meas tran vdout0_46ck1810 FIND v(dout0_46) AT=1820.05n

.meas tran vdout0_47ck1810 FIND v(dout0_47) AT=1820.05n

.meas tran vdout0_48ck1810 FIND v(dout0_48) AT=1820.05n

.meas tran vdout0_49ck1810 FIND v(dout0_49) AT=1820.05n

.meas tran vdout0_50ck1810 FIND v(dout0_50) AT=1820.05n

.meas tran vdout0_51ck1810 FIND v(dout0_51) AT=1820.05n

.meas tran vdout0_52ck1810 FIND v(dout0_52) AT=1820.05n

.meas tran vdout0_53ck1810 FIND v(dout0_53) AT=1820.05n

.meas tran vdout0_54ck1810 FIND v(dout0_54) AT=1820.05n

.meas tran vdout0_55ck1810 FIND v(dout0_55) AT=1820.05n

.meas tran vdout0_56ck1810 FIND v(dout0_56) AT=1820.05n

.meas tran vdout0_57ck1810 FIND v(dout0_57) AT=1820.05n

.meas tran vdout0_58ck1810 FIND v(dout0_58) AT=1820.05n

.meas tran vdout0_59ck1810 FIND v(dout0_59) AT=1820.05n

.meas tran vdout0_60ck1810 FIND v(dout0_60) AT=1820.05n

.meas tran vdout0_61ck1810 FIND v(dout0_61) AT=1820.05n

.meas tran vdout0_62ck1810 FIND v(dout0_62) AT=1820.05n

.meas tran vdout0_63ck1810 FIND v(dout0_63) AT=1820.05n

.meas tran vdout0_64ck1810 FIND v(dout0_64) AT=1820.05n

.meas tran vdout0_0ck1820 FIND v(dout0_0) AT=1830.05n

.meas tran vdout0_1ck1820 FIND v(dout0_1) AT=1830.05n

.meas tran vdout0_2ck1820 FIND v(dout0_2) AT=1830.05n

.meas tran vdout0_3ck1820 FIND v(dout0_3) AT=1830.05n

.meas tran vdout0_4ck1820 FIND v(dout0_4) AT=1830.05n

.meas tran vdout0_5ck1820 FIND v(dout0_5) AT=1830.05n

.meas tran vdout0_6ck1820 FIND v(dout0_6) AT=1830.05n

.meas tran vdout0_7ck1820 FIND v(dout0_7) AT=1830.05n

.meas tran vdout0_8ck1820 FIND v(dout0_8) AT=1830.05n

.meas tran vdout0_9ck1820 FIND v(dout0_9) AT=1830.05n

.meas tran vdout0_10ck1820 FIND v(dout0_10) AT=1830.05n

.meas tran vdout0_11ck1820 FIND v(dout0_11) AT=1830.05n

.meas tran vdout0_12ck1820 FIND v(dout0_12) AT=1830.05n

.meas tran vdout0_13ck1820 FIND v(dout0_13) AT=1830.05n

.meas tran vdout0_14ck1820 FIND v(dout0_14) AT=1830.05n

.meas tran vdout0_15ck1820 FIND v(dout0_15) AT=1830.05n

.meas tran vdout0_16ck1820 FIND v(dout0_16) AT=1830.05n

.meas tran vdout0_17ck1820 FIND v(dout0_17) AT=1830.05n

.meas tran vdout0_18ck1820 FIND v(dout0_18) AT=1830.05n

.meas tran vdout0_19ck1820 FIND v(dout0_19) AT=1830.05n

.meas tran vdout0_20ck1820 FIND v(dout0_20) AT=1830.05n

.meas tran vdout0_21ck1820 FIND v(dout0_21) AT=1830.05n

.meas tran vdout0_22ck1820 FIND v(dout0_22) AT=1830.05n

.meas tran vdout0_23ck1820 FIND v(dout0_23) AT=1830.05n

.meas tran vdout0_24ck1820 FIND v(dout0_24) AT=1830.05n

.meas tran vdout0_25ck1820 FIND v(dout0_25) AT=1830.05n

.meas tran vdout0_26ck1820 FIND v(dout0_26) AT=1830.05n

.meas tran vdout0_27ck1820 FIND v(dout0_27) AT=1830.05n

.meas tran vdout0_28ck1820 FIND v(dout0_28) AT=1830.05n

.meas tran vdout0_29ck1820 FIND v(dout0_29) AT=1830.05n

.meas tran vdout0_30ck1820 FIND v(dout0_30) AT=1830.05n

.meas tran vdout0_31ck1820 FIND v(dout0_31) AT=1830.05n

.meas tran vdout0_32ck1820 FIND v(dout0_32) AT=1830.05n

.meas tran vdout0_33ck1820 FIND v(dout0_33) AT=1830.05n

.meas tran vdout0_34ck1820 FIND v(dout0_34) AT=1830.05n

.meas tran vdout0_35ck1820 FIND v(dout0_35) AT=1830.05n

.meas tran vdout0_36ck1820 FIND v(dout0_36) AT=1830.05n

.meas tran vdout0_37ck1820 FIND v(dout0_37) AT=1830.05n

.meas tran vdout0_38ck1820 FIND v(dout0_38) AT=1830.05n

.meas tran vdout0_39ck1820 FIND v(dout0_39) AT=1830.05n

.meas tran vdout0_40ck1820 FIND v(dout0_40) AT=1830.05n

.meas tran vdout0_41ck1820 FIND v(dout0_41) AT=1830.05n

.meas tran vdout0_42ck1820 FIND v(dout0_42) AT=1830.05n

.meas tran vdout0_43ck1820 FIND v(dout0_43) AT=1830.05n

.meas tran vdout0_44ck1820 FIND v(dout0_44) AT=1830.05n

.meas tran vdout0_45ck1820 FIND v(dout0_45) AT=1830.05n

.meas tran vdout0_46ck1820 FIND v(dout0_46) AT=1830.05n

.meas tran vdout0_47ck1820 FIND v(dout0_47) AT=1830.05n

.meas tran vdout0_48ck1820 FIND v(dout0_48) AT=1830.05n

.meas tran vdout0_49ck1820 FIND v(dout0_49) AT=1830.05n

.meas tran vdout0_50ck1820 FIND v(dout0_50) AT=1830.05n

.meas tran vdout0_51ck1820 FIND v(dout0_51) AT=1830.05n

.meas tran vdout0_52ck1820 FIND v(dout0_52) AT=1830.05n

.meas tran vdout0_53ck1820 FIND v(dout0_53) AT=1830.05n

.meas tran vdout0_54ck1820 FIND v(dout0_54) AT=1830.05n

.meas tran vdout0_55ck1820 FIND v(dout0_55) AT=1830.05n

.meas tran vdout0_56ck1820 FIND v(dout0_56) AT=1830.05n

.meas tran vdout0_57ck1820 FIND v(dout0_57) AT=1830.05n

.meas tran vdout0_58ck1820 FIND v(dout0_58) AT=1830.05n

.meas tran vdout0_59ck1820 FIND v(dout0_59) AT=1830.05n

.meas tran vdout0_60ck1820 FIND v(dout0_60) AT=1830.05n

.meas tran vdout0_61ck1820 FIND v(dout0_61) AT=1830.05n

.meas tran vdout0_62ck1820 FIND v(dout0_62) AT=1830.05n

.meas tran vdout0_63ck1820 FIND v(dout0_63) AT=1830.05n

.meas tran vdout0_64ck1820 FIND v(dout0_64) AT=1830.05n

.meas tran vdout0_0ck1830 FIND v(dout0_0) AT=1840.05n

.meas tran vdout0_1ck1830 FIND v(dout0_1) AT=1840.05n

.meas tran vdout0_2ck1830 FIND v(dout0_2) AT=1840.05n

.meas tran vdout0_3ck1830 FIND v(dout0_3) AT=1840.05n

.meas tran vdout0_4ck1830 FIND v(dout0_4) AT=1840.05n

.meas tran vdout0_5ck1830 FIND v(dout0_5) AT=1840.05n

.meas tran vdout0_6ck1830 FIND v(dout0_6) AT=1840.05n

.meas tran vdout0_7ck1830 FIND v(dout0_7) AT=1840.05n

.meas tran vdout0_8ck1830 FIND v(dout0_8) AT=1840.05n

.meas tran vdout0_9ck1830 FIND v(dout0_9) AT=1840.05n

.meas tran vdout0_10ck1830 FIND v(dout0_10) AT=1840.05n

.meas tran vdout0_11ck1830 FIND v(dout0_11) AT=1840.05n

.meas tran vdout0_12ck1830 FIND v(dout0_12) AT=1840.05n

.meas tran vdout0_13ck1830 FIND v(dout0_13) AT=1840.05n

.meas tran vdout0_14ck1830 FIND v(dout0_14) AT=1840.05n

.meas tran vdout0_15ck1830 FIND v(dout0_15) AT=1840.05n

.meas tran vdout0_16ck1830 FIND v(dout0_16) AT=1840.05n

.meas tran vdout0_17ck1830 FIND v(dout0_17) AT=1840.05n

.meas tran vdout0_18ck1830 FIND v(dout0_18) AT=1840.05n

.meas tran vdout0_19ck1830 FIND v(dout0_19) AT=1840.05n

.meas tran vdout0_20ck1830 FIND v(dout0_20) AT=1840.05n

.meas tran vdout0_21ck1830 FIND v(dout0_21) AT=1840.05n

.meas tran vdout0_22ck1830 FIND v(dout0_22) AT=1840.05n

.meas tran vdout0_23ck1830 FIND v(dout0_23) AT=1840.05n

.meas tran vdout0_24ck1830 FIND v(dout0_24) AT=1840.05n

.meas tran vdout0_25ck1830 FIND v(dout0_25) AT=1840.05n

.meas tran vdout0_26ck1830 FIND v(dout0_26) AT=1840.05n

.meas tran vdout0_27ck1830 FIND v(dout0_27) AT=1840.05n

.meas tran vdout0_28ck1830 FIND v(dout0_28) AT=1840.05n

.meas tran vdout0_29ck1830 FIND v(dout0_29) AT=1840.05n

.meas tran vdout0_30ck1830 FIND v(dout0_30) AT=1840.05n

.meas tran vdout0_31ck1830 FIND v(dout0_31) AT=1840.05n

.meas tran vdout0_32ck1830 FIND v(dout0_32) AT=1840.05n

.meas tran vdout0_33ck1830 FIND v(dout0_33) AT=1840.05n

.meas tran vdout0_34ck1830 FIND v(dout0_34) AT=1840.05n

.meas tran vdout0_35ck1830 FIND v(dout0_35) AT=1840.05n

.meas tran vdout0_36ck1830 FIND v(dout0_36) AT=1840.05n

.meas tran vdout0_37ck1830 FIND v(dout0_37) AT=1840.05n

.meas tran vdout0_38ck1830 FIND v(dout0_38) AT=1840.05n

.meas tran vdout0_39ck1830 FIND v(dout0_39) AT=1840.05n

.meas tran vdout0_40ck1830 FIND v(dout0_40) AT=1840.05n

.meas tran vdout0_41ck1830 FIND v(dout0_41) AT=1840.05n

.meas tran vdout0_42ck1830 FIND v(dout0_42) AT=1840.05n

.meas tran vdout0_43ck1830 FIND v(dout0_43) AT=1840.05n

.meas tran vdout0_44ck1830 FIND v(dout0_44) AT=1840.05n

.meas tran vdout0_45ck1830 FIND v(dout0_45) AT=1840.05n

.meas tran vdout0_46ck1830 FIND v(dout0_46) AT=1840.05n

.meas tran vdout0_47ck1830 FIND v(dout0_47) AT=1840.05n

.meas tran vdout0_48ck1830 FIND v(dout0_48) AT=1840.05n

.meas tran vdout0_49ck1830 FIND v(dout0_49) AT=1840.05n

.meas tran vdout0_50ck1830 FIND v(dout0_50) AT=1840.05n

.meas tran vdout0_51ck1830 FIND v(dout0_51) AT=1840.05n

.meas tran vdout0_52ck1830 FIND v(dout0_52) AT=1840.05n

.meas tran vdout0_53ck1830 FIND v(dout0_53) AT=1840.05n

.meas tran vdout0_54ck1830 FIND v(dout0_54) AT=1840.05n

.meas tran vdout0_55ck1830 FIND v(dout0_55) AT=1840.05n

.meas tran vdout0_56ck1830 FIND v(dout0_56) AT=1840.05n

.meas tran vdout0_57ck1830 FIND v(dout0_57) AT=1840.05n

.meas tran vdout0_58ck1830 FIND v(dout0_58) AT=1840.05n

.meas tran vdout0_59ck1830 FIND v(dout0_59) AT=1840.05n

.meas tran vdout0_60ck1830 FIND v(dout0_60) AT=1840.05n

.meas tran vdout0_61ck1830 FIND v(dout0_61) AT=1840.05n

.meas tran vdout0_62ck1830 FIND v(dout0_62) AT=1840.05n

.meas tran vdout0_63ck1830 FIND v(dout0_63) AT=1840.05n

.meas tran vdout0_64ck1830 FIND v(dout0_64) AT=1840.05n

.meas tran vdout0_0ck1840 FIND v(dout0_0) AT=1850.05n

.meas tran vdout0_1ck1840 FIND v(dout0_1) AT=1850.05n

.meas tran vdout0_2ck1840 FIND v(dout0_2) AT=1850.05n

.meas tran vdout0_3ck1840 FIND v(dout0_3) AT=1850.05n

.meas tran vdout0_4ck1840 FIND v(dout0_4) AT=1850.05n

.meas tran vdout0_5ck1840 FIND v(dout0_5) AT=1850.05n

.meas tran vdout0_6ck1840 FIND v(dout0_6) AT=1850.05n

.meas tran vdout0_7ck1840 FIND v(dout0_7) AT=1850.05n

.meas tran vdout0_8ck1840 FIND v(dout0_8) AT=1850.05n

.meas tran vdout0_9ck1840 FIND v(dout0_9) AT=1850.05n

.meas tran vdout0_10ck1840 FIND v(dout0_10) AT=1850.05n

.meas tran vdout0_11ck1840 FIND v(dout0_11) AT=1850.05n

.meas tran vdout0_12ck1840 FIND v(dout0_12) AT=1850.05n

.meas tran vdout0_13ck1840 FIND v(dout0_13) AT=1850.05n

.meas tran vdout0_14ck1840 FIND v(dout0_14) AT=1850.05n

.meas tran vdout0_15ck1840 FIND v(dout0_15) AT=1850.05n

.meas tran vdout0_16ck1840 FIND v(dout0_16) AT=1850.05n

.meas tran vdout0_17ck1840 FIND v(dout0_17) AT=1850.05n

.meas tran vdout0_18ck1840 FIND v(dout0_18) AT=1850.05n

.meas tran vdout0_19ck1840 FIND v(dout0_19) AT=1850.05n

.meas tran vdout0_20ck1840 FIND v(dout0_20) AT=1850.05n

.meas tran vdout0_21ck1840 FIND v(dout0_21) AT=1850.05n

.meas tran vdout0_22ck1840 FIND v(dout0_22) AT=1850.05n

.meas tran vdout0_23ck1840 FIND v(dout0_23) AT=1850.05n

.meas tran vdout0_24ck1840 FIND v(dout0_24) AT=1850.05n

.meas tran vdout0_25ck1840 FIND v(dout0_25) AT=1850.05n

.meas tran vdout0_26ck1840 FIND v(dout0_26) AT=1850.05n

.meas tran vdout0_27ck1840 FIND v(dout0_27) AT=1850.05n

.meas tran vdout0_28ck1840 FIND v(dout0_28) AT=1850.05n

.meas tran vdout0_29ck1840 FIND v(dout0_29) AT=1850.05n

.meas tran vdout0_30ck1840 FIND v(dout0_30) AT=1850.05n

.meas tran vdout0_31ck1840 FIND v(dout0_31) AT=1850.05n

.meas tran vdout0_32ck1840 FIND v(dout0_32) AT=1850.05n

.meas tran vdout0_33ck1840 FIND v(dout0_33) AT=1850.05n

.meas tran vdout0_34ck1840 FIND v(dout0_34) AT=1850.05n

.meas tran vdout0_35ck1840 FIND v(dout0_35) AT=1850.05n

.meas tran vdout0_36ck1840 FIND v(dout0_36) AT=1850.05n

.meas tran vdout0_37ck1840 FIND v(dout0_37) AT=1850.05n

.meas tran vdout0_38ck1840 FIND v(dout0_38) AT=1850.05n

.meas tran vdout0_39ck1840 FIND v(dout0_39) AT=1850.05n

.meas tran vdout0_40ck1840 FIND v(dout0_40) AT=1850.05n

.meas tran vdout0_41ck1840 FIND v(dout0_41) AT=1850.05n

.meas tran vdout0_42ck1840 FIND v(dout0_42) AT=1850.05n

.meas tran vdout0_43ck1840 FIND v(dout0_43) AT=1850.05n

.meas tran vdout0_44ck1840 FIND v(dout0_44) AT=1850.05n

.meas tran vdout0_45ck1840 FIND v(dout0_45) AT=1850.05n

.meas tran vdout0_46ck1840 FIND v(dout0_46) AT=1850.05n

.meas tran vdout0_47ck1840 FIND v(dout0_47) AT=1850.05n

.meas tran vdout0_48ck1840 FIND v(dout0_48) AT=1850.05n

.meas tran vdout0_49ck1840 FIND v(dout0_49) AT=1850.05n

.meas tran vdout0_50ck1840 FIND v(dout0_50) AT=1850.05n

.meas tran vdout0_51ck1840 FIND v(dout0_51) AT=1850.05n

.meas tran vdout0_52ck1840 FIND v(dout0_52) AT=1850.05n

.meas tran vdout0_53ck1840 FIND v(dout0_53) AT=1850.05n

.meas tran vdout0_54ck1840 FIND v(dout0_54) AT=1850.05n

.meas tran vdout0_55ck1840 FIND v(dout0_55) AT=1850.05n

.meas tran vdout0_56ck1840 FIND v(dout0_56) AT=1850.05n

.meas tran vdout0_57ck1840 FIND v(dout0_57) AT=1850.05n

.meas tran vdout0_58ck1840 FIND v(dout0_58) AT=1850.05n

.meas tran vdout0_59ck1840 FIND v(dout0_59) AT=1850.05n

.meas tran vdout0_60ck1840 FIND v(dout0_60) AT=1850.05n

.meas tran vdout0_61ck1840 FIND v(dout0_61) AT=1850.05n

.meas tran vdout0_62ck1840 FIND v(dout0_62) AT=1850.05n

.meas tran vdout0_63ck1840 FIND v(dout0_63) AT=1850.05n

.meas tran vdout0_64ck1840 FIND v(dout0_64) AT=1850.05n

.meas tran vdout0_0ck1850 FIND v(dout0_0) AT=1860.05n

.meas tran vdout0_1ck1850 FIND v(dout0_1) AT=1860.05n

.meas tran vdout0_2ck1850 FIND v(dout0_2) AT=1860.05n

.meas tran vdout0_3ck1850 FIND v(dout0_3) AT=1860.05n

.meas tran vdout0_4ck1850 FIND v(dout0_4) AT=1860.05n

.meas tran vdout0_5ck1850 FIND v(dout0_5) AT=1860.05n

.meas tran vdout0_6ck1850 FIND v(dout0_6) AT=1860.05n

.meas tran vdout0_7ck1850 FIND v(dout0_7) AT=1860.05n

.meas tran vdout0_8ck1850 FIND v(dout0_8) AT=1860.05n

.meas tran vdout0_9ck1850 FIND v(dout0_9) AT=1860.05n

.meas tran vdout0_10ck1850 FIND v(dout0_10) AT=1860.05n

.meas tran vdout0_11ck1850 FIND v(dout0_11) AT=1860.05n

.meas tran vdout0_12ck1850 FIND v(dout0_12) AT=1860.05n

.meas tran vdout0_13ck1850 FIND v(dout0_13) AT=1860.05n

.meas tran vdout0_14ck1850 FIND v(dout0_14) AT=1860.05n

.meas tran vdout0_15ck1850 FIND v(dout0_15) AT=1860.05n

.meas tran vdout0_16ck1850 FIND v(dout0_16) AT=1860.05n

.meas tran vdout0_17ck1850 FIND v(dout0_17) AT=1860.05n

.meas tran vdout0_18ck1850 FIND v(dout0_18) AT=1860.05n

.meas tran vdout0_19ck1850 FIND v(dout0_19) AT=1860.05n

.meas tran vdout0_20ck1850 FIND v(dout0_20) AT=1860.05n

.meas tran vdout0_21ck1850 FIND v(dout0_21) AT=1860.05n

.meas tran vdout0_22ck1850 FIND v(dout0_22) AT=1860.05n

.meas tran vdout0_23ck1850 FIND v(dout0_23) AT=1860.05n

.meas tran vdout0_24ck1850 FIND v(dout0_24) AT=1860.05n

.meas tran vdout0_25ck1850 FIND v(dout0_25) AT=1860.05n

.meas tran vdout0_26ck1850 FIND v(dout0_26) AT=1860.05n

.meas tran vdout0_27ck1850 FIND v(dout0_27) AT=1860.05n

.meas tran vdout0_28ck1850 FIND v(dout0_28) AT=1860.05n

.meas tran vdout0_29ck1850 FIND v(dout0_29) AT=1860.05n

.meas tran vdout0_30ck1850 FIND v(dout0_30) AT=1860.05n

.meas tran vdout0_31ck1850 FIND v(dout0_31) AT=1860.05n

.meas tran vdout0_32ck1850 FIND v(dout0_32) AT=1860.05n

.meas tran vdout0_33ck1850 FIND v(dout0_33) AT=1860.05n

.meas tran vdout0_34ck1850 FIND v(dout0_34) AT=1860.05n

.meas tran vdout0_35ck1850 FIND v(dout0_35) AT=1860.05n

.meas tran vdout0_36ck1850 FIND v(dout0_36) AT=1860.05n

.meas tran vdout0_37ck1850 FIND v(dout0_37) AT=1860.05n

.meas tran vdout0_38ck1850 FIND v(dout0_38) AT=1860.05n

.meas tran vdout0_39ck1850 FIND v(dout0_39) AT=1860.05n

.meas tran vdout0_40ck1850 FIND v(dout0_40) AT=1860.05n

.meas tran vdout0_41ck1850 FIND v(dout0_41) AT=1860.05n

.meas tran vdout0_42ck1850 FIND v(dout0_42) AT=1860.05n

.meas tran vdout0_43ck1850 FIND v(dout0_43) AT=1860.05n

.meas tran vdout0_44ck1850 FIND v(dout0_44) AT=1860.05n

.meas tran vdout0_45ck1850 FIND v(dout0_45) AT=1860.05n

.meas tran vdout0_46ck1850 FIND v(dout0_46) AT=1860.05n

.meas tran vdout0_47ck1850 FIND v(dout0_47) AT=1860.05n

.meas tran vdout0_48ck1850 FIND v(dout0_48) AT=1860.05n

.meas tran vdout0_49ck1850 FIND v(dout0_49) AT=1860.05n

.meas tran vdout0_50ck1850 FIND v(dout0_50) AT=1860.05n

.meas tran vdout0_51ck1850 FIND v(dout0_51) AT=1860.05n

.meas tran vdout0_52ck1850 FIND v(dout0_52) AT=1860.05n

.meas tran vdout0_53ck1850 FIND v(dout0_53) AT=1860.05n

.meas tran vdout0_54ck1850 FIND v(dout0_54) AT=1860.05n

.meas tran vdout0_55ck1850 FIND v(dout0_55) AT=1860.05n

.meas tran vdout0_56ck1850 FIND v(dout0_56) AT=1860.05n

.meas tran vdout0_57ck1850 FIND v(dout0_57) AT=1860.05n

.meas tran vdout0_58ck1850 FIND v(dout0_58) AT=1860.05n

.meas tran vdout0_59ck1850 FIND v(dout0_59) AT=1860.05n

.meas tran vdout0_60ck1850 FIND v(dout0_60) AT=1860.05n

.meas tran vdout0_61ck1850 FIND v(dout0_61) AT=1860.05n

.meas tran vdout0_62ck1850 FIND v(dout0_62) AT=1860.05n

.meas tran vdout0_63ck1850 FIND v(dout0_63) AT=1860.05n

.meas tran vdout0_64ck1850 FIND v(dout0_64) AT=1860.05n

.meas tran vdout0_0ck1860 FIND v(dout0_0) AT=1870.05n

.meas tran vdout0_1ck1860 FIND v(dout0_1) AT=1870.05n

.meas tran vdout0_2ck1860 FIND v(dout0_2) AT=1870.05n

.meas tran vdout0_3ck1860 FIND v(dout0_3) AT=1870.05n

.meas tran vdout0_4ck1860 FIND v(dout0_4) AT=1870.05n

.meas tran vdout0_5ck1860 FIND v(dout0_5) AT=1870.05n

.meas tran vdout0_6ck1860 FIND v(dout0_6) AT=1870.05n

.meas tran vdout0_7ck1860 FIND v(dout0_7) AT=1870.05n

.meas tran vdout0_8ck1860 FIND v(dout0_8) AT=1870.05n

.meas tran vdout0_9ck1860 FIND v(dout0_9) AT=1870.05n

.meas tran vdout0_10ck1860 FIND v(dout0_10) AT=1870.05n

.meas tran vdout0_11ck1860 FIND v(dout0_11) AT=1870.05n

.meas tran vdout0_12ck1860 FIND v(dout0_12) AT=1870.05n

.meas tran vdout0_13ck1860 FIND v(dout0_13) AT=1870.05n

.meas tran vdout0_14ck1860 FIND v(dout0_14) AT=1870.05n

.meas tran vdout0_15ck1860 FIND v(dout0_15) AT=1870.05n

.meas tran vdout0_16ck1860 FIND v(dout0_16) AT=1870.05n

.meas tran vdout0_17ck1860 FIND v(dout0_17) AT=1870.05n

.meas tran vdout0_18ck1860 FIND v(dout0_18) AT=1870.05n

.meas tran vdout0_19ck1860 FIND v(dout0_19) AT=1870.05n

.meas tran vdout0_20ck1860 FIND v(dout0_20) AT=1870.05n

.meas tran vdout0_21ck1860 FIND v(dout0_21) AT=1870.05n

.meas tran vdout0_22ck1860 FIND v(dout0_22) AT=1870.05n

.meas tran vdout0_23ck1860 FIND v(dout0_23) AT=1870.05n

.meas tran vdout0_24ck1860 FIND v(dout0_24) AT=1870.05n

.meas tran vdout0_25ck1860 FIND v(dout0_25) AT=1870.05n

.meas tran vdout0_26ck1860 FIND v(dout0_26) AT=1870.05n

.meas tran vdout0_27ck1860 FIND v(dout0_27) AT=1870.05n

.meas tran vdout0_28ck1860 FIND v(dout0_28) AT=1870.05n

.meas tran vdout0_29ck1860 FIND v(dout0_29) AT=1870.05n

.meas tran vdout0_30ck1860 FIND v(dout0_30) AT=1870.05n

.meas tran vdout0_31ck1860 FIND v(dout0_31) AT=1870.05n

.meas tran vdout0_32ck1860 FIND v(dout0_32) AT=1870.05n

.meas tran vdout0_33ck1860 FIND v(dout0_33) AT=1870.05n

.meas tran vdout0_34ck1860 FIND v(dout0_34) AT=1870.05n

.meas tran vdout0_35ck1860 FIND v(dout0_35) AT=1870.05n

.meas tran vdout0_36ck1860 FIND v(dout0_36) AT=1870.05n

.meas tran vdout0_37ck1860 FIND v(dout0_37) AT=1870.05n

.meas tran vdout0_38ck1860 FIND v(dout0_38) AT=1870.05n

.meas tran vdout0_39ck1860 FIND v(dout0_39) AT=1870.05n

.meas tran vdout0_40ck1860 FIND v(dout0_40) AT=1870.05n

.meas tran vdout0_41ck1860 FIND v(dout0_41) AT=1870.05n

.meas tran vdout0_42ck1860 FIND v(dout0_42) AT=1870.05n

.meas tran vdout0_43ck1860 FIND v(dout0_43) AT=1870.05n

.meas tran vdout0_44ck1860 FIND v(dout0_44) AT=1870.05n

.meas tran vdout0_45ck1860 FIND v(dout0_45) AT=1870.05n

.meas tran vdout0_46ck1860 FIND v(dout0_46) AT=1870.05n

.meas tran vdout0_47ck1860 FIND v(dout0_47) AT=1870.05n

.meas tran vdout0_48ck1860 FIND v(dout0_48) AT=1870.05n

.meas tran vdout0_49ck1860 FIND v(dout0_49) AT=1870.05n

.meas tran vdout0_50ck1860 FIND v(dout0_50) AT=1870.05n

.meas tran vdout0_51ck1860 FIND v(dout0_51) AT=1870.05n

.meas tran vdout0_52ck1860 FIND v(dout0_52) AT=1870.05n

.meas tran vdout0_53ck1860 FIND v(dout0_53) AT=1870.05n

.meas tran vdout0_54ck1860 FIND v(dout0_54) AT=1870.05n

.meas tran vdout0_55ck1860 FIND v(dout0_55) AT=1870.05n

.meas tran vdout0_56ck1860 FIND v(dout0_56) AT=1870.05n

.meas tran vdout0_57ck1860 FIND v(dout0_57) AT=1870.05n

.meas tran vdout0_58ck1860 FIND v(dout0_58) AT=1870.05n

.meas tran vdout0_59ck1860 FIND v(dout0_59) AT=1870.05n

.meas tran vdout0_60ck1860 FIND v(dout0_60) AT=1870.05n

.meas tran vdout0_61ck1860 FIND v(dout0_61) AT=1870.05n

.meas tran vdout0_62ck1860 FIND v(dout0_62) AT=1870.05n

.meas tran vdout0_63ck1860 FIND v(dout0_63) AT=1870.05n

.meas tran vdout0_64ck1860 FIND v(dout0_64) AT=1870.05n

.meas tran vdout0_0ck1870 FIND v(dout0_0) AT=1880.05n

.meas tran vdout0_1ck1870 FIND v(dout0_1) AT=1880.05n

.meas tran vdout0_2ck1870 FIND v(dout0_2) AT=1880.05n

.meas tran vdout0_3ck1870 FIND v(dout0_3) AT=1880.05n

.meas tran vdout0_4ck1870 FIND v(dout0_4) AT=1880.05n

.meas tran vdout0_5ck1870 FIND v(dout0_5) AT=1880.05n

.meas tran vdout0_6ck1870 FIND v(dout0_6) AT=1880.05n

.meas tran vdout0_7ck1870 FIND v(dout0_7) AT=1880.05n

.meas tran vdout0_8ck1870 FIND v(dout0_8) AT=1880.05n

.meas tran vdout0_9ck1870 FIND v(dout0_9) AT=1880.05n

.meas tran vdout0_10ck1870 FIND v(dout0_10) AT=1880.05n

.meas tran vdout0_11ck1870 FIND v(dout0_11) AT=1880.05n

.meas tran vdout0_12ck1870 FIND v(dout0_12) AT=1880.05n

.meas tran vdout0_13ck1870 FIND v(dout0_13) AT=1880.05n

.meas tran vdout0_14ck1870 FIND v(dout0_14) AT=1880.05n

.meas tran vdout0_15ck1870 FIND v(dout0_15) AT=1880.05n

.meas tran vdout0_16ck1870 FIND v(dout0_16) AT=1880.05n

.meas tran vdout0_17ck1870 FIND v(dout0_17) AT=1880.05n

.meas tran vdout0_18ck1870 FIND v(dout0_18) AT=1880.05n

.meas tran vdout0_19ck1870 FIND v(dout0_19) AT=1880.05n

.meas tran vdout0_20ck1870 FIND v(dout0_20) AT=1880.05n

.meas tran vdout0_21ck1870 FIND v(dout0_21) AT=1880.05n

.meas tran vdout0_22ck1870 FIND v(dout0_22) AT=1880.05n

.meas tran vdout0_23ck1870 FIND v(dout0_23) AT=1880.05n

.meas tran vdout0_24ck1870 FIND v(dout0_24) AT=1880.05n

.meas tran vdout0_25ck1870 FIND v(dout0_25) AT=1880.05n

.meas tran vdout0_26ck1870 FIND v(dout0_26) AT=1880.05n

.meas tran vdout0_27ck1870 FIND v(dout0_27) AT=1880.05n

.meas tran vdout0_28ck1870 FIND v(dout0_28) AT=1880.05n

.meas tran vdout0_29ck1870 FIND v(dout0_29) AT=1880.05n

.meas tran vdout0_30ck1870 FIND v(dout0_30) AT=1880.05n

.meas tran vdout0_31ck1870 FIND v(dout0_31) AT=1880.05n

.meas tran vdout0_32ck1870 FIND v(dout0_32) AT=1880.05n

.meas tran vdout0_33ck1870 FIND v(dout0_33) AT=1880.05n

.meas tran vdout0_34ck1870 FIND v(dout0_34) AT=1880.05n

.meas tran vdout0_35ck1870 FIND v(dout0_35) AT=1880.05n

.meas tran vdout0_36ck1870 FIND v(dout0_36) AT=1880.05n

.meas tran vdout0_37ck1870 FIND v(dout0_37) AT=1880.05n

.meas tran vdout0_38ck1870 FIND v(dout0_38) AT=1880.05n

.meas tran vdout0_39ck1870 FIND v(dout0_39) AT=1880.05n

.meas tran vdout0_40ck1870 FIND v(dout0_40) AT=1880.05n

.meas tran vdout0_41ck1870 FIND v(dout0_41) AT=1880.05n

.meas tran vdout0_42ck1870 FIND v(dout0_42) AT=1880.05n

.meas tran vdout0_43ck1870 FIND v(dout0_43) AT=1880.05n

.meas tran vdout0_44ck1870 FIND v(dout0_44) AT=1880.05n

.meas tran vdout0_45ck1870 FIND v(dout0_45) AT=1880.05n

.meas tran vdout0_46ck1870 FIND v(dout0_46) AT=1880.05n

.meas tran vdout0_47ck1870 FIND v(dout0_47) AT=1880.05n

.meas tran vdout0_48ck1870 FIND v(dout0_48) AT=1880.05n

.meas tran vdout0_49ck1870 FIND v(dout0_49) AT=1880.05n

.meas tran vdout0_50ck1870 FIND v(dout0_50) AT=1880.05n

.meas tran vdout0_51ck1870 FIND v(dout0_51) AT=1880.05n

.meas tran vdout0_52ck1870 FIND v(dout0_52) AT=1880.05n

.meas tran vdout0_53ck1870 FIND v(dout0_53) AT=1880.05n

.meas tran vdout0_54ck1870 FIND v(dout0_54) AT=1880.05n

.meas tran vdout0_55ck1870 FIND v(dout0_55) AT=1880.05n

.meas tran vdout0_56ck1870 FIND v(dout0_56) AT=1880.05n

.meas tran vdout0_57ck1870 FIND v(dout0_57) AT=1880.05n

.meas tran vdout0_58ck1870 FIND v(dout0_58) AT=1880.05n

.meas tran vdout0_59ck1870 FIND v(dout0_59) AT=1880.05n

.meas tran vdout0_60ck1870 FIND v(dout0_60) AT=1880.05n

.meas tran vdout0_61ck1870 FIND v(dout0_61) AT=1880.05n

.meas tran vdout0_62ck1870 FIND v(dout0_62) AT=1880.05n

.meas tran vdout0_63ck1870 FIND v(dout0_63) AT=1880.05n

.meas tran vdout0_64ck1870 FIND v(dout0_64) AT=1880.05n

.meas tran vdout0_0ck1880 FIND v(dout0_0) AT=1890.05n

.meas tran vdout0_1ck1880 FIND v(dout0_1) AT=1890.05n

.meas tran vdout0_2ck1880 FIND v(dout0_2) AT=1890.05n

.meas tran vdout0_3ck1880 FIND v(dout0_3) AT=1890.05n

.meas tran vdout0_4ck1880 FIND v(dout0_4) AT=1890.05n

.meas tran vdout0_5ck1880 FIND v(dout0_5) AT=1890.05n

.meas tran vdout0_6ck1880 FIND v(dout0_6) AT=1890.05n

.meas tran vdout0_7ck1880 FIND v(dout0_7) AT=1890.05n

.meas tran vdout0_8ck1880 FIND v(dout0_8) AT=1890.05n

.meas tran vdout0_9ck1880 FIND v(dout0_9) AT=1890.05n

.meas tran vdout0_10ck1880 FIND v(dout0_10) AT=1890.05n

.meas tran vdout0_11ck1880 FIND v(dout0_11) AT=1890.05n

.meas tran vdout0_12ck1880 FIND v(dout0_12) AT=1890.05n

.meas tran vdout0_13ck1880 FIND v(dout0_13) AT=1890.05n

.meas tran vdout0_14ck1880 FIND v(dout0_14) AT=1890.05n

.meas tran vdout0_15ck1880 FIND v(dout0_15) AT=1890.05n

.meas tran vdout0_16ck1880 FIND v(dout0_16) AT=1890.05n

.meas tran vdout0_17ck1880 FIND v(dout0_17) AT=1890.05n

.meas tran vdout0_18ck1880 FIND v(dout0_18) AT=1890.05n

.meas tran vdout0_19ck1880 FIND v(dout0_19) AT=1890.05n

.meas tran vdout0_20ck1880 FIND v(dout0_20) AT=1890.05n

.meas tran vdout0_21ck1880 FIND v(dout0_21) AT=1890.05n

.meas tran vdout0_22ck1880 FIND v(dout0_22) AT=1890.05n

.meas tran vdout0_23ck1880 FIND v(dout0_23) AT=1890.05n

.meas tran vdout0_24ck1880 FIND v(dout0_24) AT=1890.05n

.meas tran vdout0_25ck1880 FIND v(dout0_25) AT=1890.05n

.meas tran vdout0_26ck1880 FIND v(dout0_26) AT=1890.05n

.meas tran vdout0_27ck1880 FIND v(dout0_27) AT=1890.05n

.meas tran vdout0_28ck1880 FIND v(dout0_28) AT=1890.05n

.meas tran vdout0_29ck1880 FIND v(dout0_29) AT=1890.05n

.meas tran vdout0_30ck1880 FIND v(dout0_30) AT=1890.05n

.meas tran vdout0_31ck1880 FIND v(dout0_31) AT=1890.05n

.meas tran vdout0_32ck1880 FIND v(dout0_32) AT=1890.05n

.meas tran vdout0_33ck1880 FIND v(dout0_33) AT=1890.05n

.meas tran vdout0_34ck1880 FIND v(dout0_34) AT=1890.05n

.meas tran vdout0_35ck1880 FIND v(dout0_35) AT=1890.05n

.meas tran vdout0_36ck1880 FIND v(dout0_36) AT=1890.05n

.meas tran vdout0_37ck1880 FIND v(dout0_37) AT=1890.05n

.meas tran vdout0_38ck1880 FIND v(dout0_38) AT=1890.05n

.meas tran vdout0_39ck1880 FIND v(dout0_39) AT=1890.05n

.meas tran vdout0_40ck1880 FIND v(dout0_40) AT=1890.05n

.meas tran vdout0_41ck1880 FIND v(dout0_41) AT=1890.05n

.meas tran vdout0_42ck1880 FIND v(dout0_42) AT=1890.05n

.meas tran vdout0_43ck1880 FIND v(dout0_43) AT=1890.05n

.meas tran vdout0_44ck1880 FIND v(dout0_44) AT=1890.05n

.meas tran vdout0_45ck1880 FIND v(dout0_45) AT=1890.05n

.meas tran vdout0_46ck1880 FIND v(dout0_46) AT=1890.05n

.meas tran vdout0_47ck1880 FIND v(dout0_47) AT=1890.05n

.meas tran vdout0_48ck1880 FIND v(dout0_48) AT=1890.05n

.meas tran vdout0_49ck1880 FIND v(dout0_49) AT=1890.05n

.meas tran vdout0_50ck1880 FIND v(dout0_50) AT=1890.05n

.meas tran vdout0_51ck1880 FIND v(dout0_51) AT=1890.05n

.meas tran vdout0_52ck1880 FIND v(dout0_52) AT=1890.05n

.meas tran vdout0_53ck1880 FIND v(dout0_53) AT=1890.05n

.meas tran vdout0_54ck1880 FIND v(dout0_54) AT=1890.05n

.meas tran vdout0_55ck1880 FIND v(dout0_55) AT=1890.05n

.meas tran vdout0_56ck1880 FIND v(dout0_56) AT=1890.05n

.meas tran vdout0_57ck1880 FIND v(dout0_57) AT=1890.05n

.meas tran vdout0_58ck1880 FIND v(dout0_58) AT=1890.05n

.meas tran vdout0_59ck1880 FIND v(dout0_59) AT=1890.05n

.meas tran vdout0_60ck1880 FIND v(dout0_60) AT=1890.05n

.meas tran vdout0_61ck1880 FIND v(dout0_61) AT=1890.05n

.meas tran vdout0_62ck1880 FIND v(dout0_62) AT=1890.05n

.meas tran vdout0_63ck1880 FIND v(dout0_63) AT=1890.05n

.meas tran vdout0_64ck1880 FIND v(dout0_64) AT=1890.05n

.meas tran vdout0_0ck1890 FIND v(dout0_0) AT=1900.05n

.meas tran vdout0_1ck1890 FIND v(dout0_1) AT=1900.05n

.meas tran vdout0_2ck1890 FIND v(dout0_2) AT=1900.05n

.meas tran vdout0_3ck1890 FIND v(dout0_3) AT=1900.05n

.meas tran vdout0_4ck1890 FIND v(dout0_4) AT=1900.05n

.meas tran vdout0_5ck1890 FIND v(dout0_5) AT=1900.05n

.meas tran vdout0_6ck1890 FIND v(dout0_6) AT=1900.05n

.meas tran vdout0_7ck1890 FIND v(dout0_7) AT=1900.05n

.meas tran vdout0_8ck1890 FIND v(dout0_8) AT=1900.05n

.meas tran vdout0_9ck1890 FIND v(dout0_9) AT=1900.05n

.meas tran vdout0_10ck1890 FIND v(dout0_10) AT=1900.05n

.meas tran vdout0_11ck1890 FIND v(dout0_11) AT=1900.05n

.meas tran vdout0_12ck1890 FIND v(dout0_12) AT=1900.05n

.meas tran vdout0_13ck1890 FIND v(dout0_13) AT=1900.05n

.meas tran vdout0_14ck1890 FIND v(dout0_14) AT=1900.05n

.meas tran vdout0_15ck1890 FIND v(dout0_15) AT=1900.05n

.meas tran vdout0_16ck1890 FIND v(dout0_16) AT=1900.05n

.meas tran vdout0_17ck1890 FIND v(dout0_17) AT=1900.05n

.meas tran vdout0_18ck1890 FIND v(dout0_18) AT=1900.05n

.meas tran vdout0_19ck1890 FIND v(dout0_19) AT=1900.05n

.meas tran vdout0_20ck1890 FIND v(dout0_20) AT=1900.05n

.meas tran vdout0_21ck1890 FIND v(dout0_21) AT=1900.05n

.meas tran vdout0_22ck1890 FIND v(dout0_22) AT=1900.05n

.meas tran vdout0_23ck1890 FIND v(dout0_23) AT=1900.05n

.meas tran vdout0_24ck1890 FIND v(dout0_24) AT=1900.05n

.meas tran vdout0_25ck1890 FIND v(dout0_25) AT=1900.05n

.meas tran vdout0_26ck1890 FIND v(dout0_26) AT=1900.05n

.meas tran vdout0_27ck1890 FIND v(dout0_27) AT=1900.05n

.meas tran vdout0_28ck1890 FIND v(dout0_28) AT=1900.05n

.meas tran vdout0_29ck1890 FIND v(dout0_29) AT=1900.05n

.meas tran vdout0_30ck1890 FIND v(dout0_30) AT=1900.05n

.meas tran vdout0_31ck1890 FIND v(dout0_31) AT=1900.05n

.meas tran vdout0_32ck1890 FIND v(dout0_32) AT=1900.05n

.meas tran vdout0_33ck1890 FIND v(dout0_33) AT=1900.05n

.meas tran vdout0_34ck1890 FIND v(dout0_34) AT=1900.05n

.meas tran vdout0_35ck1890 FIND v(dout0_35) AT=1900.05n

.meas tran vdout0_36ck1890 FIND v(dout0_36) AT=1900.05n

.meas tran vdout0_37ck1890 FIND v(dout0_37) AT=1900.05n

.meas tran vdout0_38ck1890 FIND v(dout0_38) AT=1900.05n

.meas tran vdout0_39ck1890 FIND v(dout0_39) AT=1900.05n

.meas tran vdout0_40ck1890 FIND v(dout0_40) AT=1900.05n

.meas tran vdout0_41ck1890 FIND v(dout0_41) AT=1900.05n

.meas tran vdout0_42ck1890 FIND v(dout0_42) AT=1900.05n

.meas tran vdout0_43ck1890 FIND v(dout0_43) AT=1900.05n

.meas tran vdout0_44ck1890 FIND v(dout0_44) AT=1900.05n

.meas tran vdout0_45ck1890 FIND v(dout0_45) AT=1900.05n

.meas tran vdout0_46ck1890 FIND v(dout0_46) AT=1900.05n

.meas tran vdout0_47ck1890 FIND v(dout0_47) AT=1900.05n

.meas tran vdout0_48ck1890 FIND v(dout0_48) AT=1900.05n

.meas tran vdout0_49ck1890 FIND v(dout0_49) AT=1900.05n

.meas tran vdout0_50ck1890 FIND v(dout0_50) AT=1900.05n

.meas tran vdout0_51ck1890 FIND v(dout0_51) AT=1900.05n

.meas tran vdout0_52ck1890 FIND v(dout0_52) AT=1900.05n

.meas tran vdout0_53ck1890 FIND v(dout0_53) AT=1900.05n

.meas tran vdout0_54ck1890 FIND v(dout0_54) AT=1900.05n

.meas tran vdout0_55ck1890 FIND v(dout0_55) AT=1900.05n

.meas tran vdout0_56ck1890 FIND v(dout0_56) AT=1900.05n

.meas tran vdout0_57ck1890 FIND v(dout0_57) AT=1900.05n

.meas tran vdout0_58ck1890 FIND v(dout0_58) AT=1900.05n

.meas tran vdout0_59ck1890 FIND v(dout0_59) AT=1900.05n

.meas tran vdout0_60ck1890 FIND v(dout0_60) AT=1900.05n

.meas tran vdout0_61ck1890 FIND v(dout0_61) AT=1900.05n

.meas tran vdout0_62ck1890 FIND v(dout0_62) AT=1900.05n

.meas tran vdout0_63ck1890 FIND v(dout0_63) AT=1900.05n

.meas tran vdout0_64ck1890 FIND v(dout0_64) AT=1900.05n

.meas tran vdout0_0ck1900 FIND v(dout0_0) AT=1910.05n

.meas tran vdout0_1ck1900 FIND v(dout0_1) AT=1910.05n

.meas tran vdout0_2ck1900 FIND v(dout0_2) AT=1910.05n

.meas tran vdout0_3ck1900 FIND v(dout0_3) AT=1910.05n

.meas tran vdout0_4ck1900 FIND v(dout0_4) AT=1910.05n

.meas tran vdout0_5ck1900 FIND v(dout0_5) AT=1910.05n

.meas tran vdout0_6ck1900 FIND v(dout0_6) AT=1910.05n

.meas tran vdout0_7ck1900 FIND v(dout0_7) AT=1910.05n

.meas tran vdout0_8ck1900 FIND v(dout0_8) AT=1910.05n

.meas tran vdout0_9ck1900 FIND v(dout0_9) AT=1910.05n

.meas tran vdout0_10ck1900 FIND v(dout0_10) AT=1910.05n

.meas tran vdout0_11ck1900 FIND v(dout0_11) AT=1910.05n

.meas tran vdout0_12ck1900 FIND v(dout0_12) AT=1910.05n

.meas tran vdout0_13ck1900 FIND v(dout0_13) AT=1910.05n

.meas tran vdout0_14ck1900 FIND v(dout0_14) AT=1910.05n

.meas tran vdout0_15ck1900 FIND v(dout0_15) AT=1910.05n

.meas tran vdout0_16ck1900 FIND v(dout0_16) AT=1910.05n

.meas tran vdout0_17ck1900 FIND v(dout0_17) AT=1910.05n

.meas tran vdout0_18ck1900 FIND v(dout0_18) AT=1910.05n

.meas tran vdout0_19ck1900 FIND v(dout0_19) AT=1910.05n

.meas tran vdout0_20ck1900 FIND v(dout0_20) AT=1910.05n

.meas tran vdout0_21ck1900 FIND v(dout0_21) AT=1910.05n

.meas tran vdout0_22ck1900 FIND v(dout0_22) AT=1910.05n

.meas tran vdout0_23ck1900 FIND v(dout0_23) AT=1910.05n

.meas tran vdout0_24ck1900 FIND v(dout0_24) AT=1910.05n

.meas tran vdout0_25ck1900 FIND v(dout0_25) AT=1910.05n

.meas tran vdout0_26ck1900 FIND v(dout0_26) AT=1910.05n

.meas tran vdout0_27ck1900 FIND v(dout0_27) AT=1910.05n

.meas tran vdout0_28ck1900 FIND v(dout0_28) AT=1910.05n

.meas tran vdout0_29ck1900 FIND v(dout0_29) AT=1910.05n

.meas tran vdout0_30ck1900 FIND v(dout0_30) AT=1910.05n

.meas tran vdout0_31ck1900 FIND v(dout0_31) AT=1910.05n

.meas tran vdout0_32ck1900 FIND v(dout0_32) AT=1910.05n

.meas tran vdout0_33ck1900 FIND v(dout0_33) AT=1910.05n

.meas tran vdout0_34ck1900 FIND v(dout0_34) AT=1910.05n

.meas tran vdout0_35ck1900 FIND v(dout0_35) AT=1910.05n

.meas tran vdout0_36ck1900 FIND v(dout0_36) AT=1910.05n

.meas tran vdout0_37ck1900 FIND v(dout0_37) AT=1910.05n

.meas tran vdout0_38ck1900 FIND v(dout0_38) AT=1910.05n

.meas tran vdout0_39ck1900 FIND v(dout0_39) AT=1910.05n

.meas tran vdout0_40ck1900 FIND v(dout0_40) AT=1910.05n

.meas tran vdout0_41ck1900 FIND v(dout0_41) AT=1910.05n

.meas tran vdout0_42ck1900 FIND v(dout0_42) AT=1910.05n

.meas tran vdout0_43ck1900 FIND v(dout0_43) AT=1910.05n

.meas tran vdout0_44ck1900 FIND v(dout0_44) AT=1910.05n

.meas tran vdout0_45ck1900 FIND v(dout0_45) AT=1910.05n

.meas tran vdout0_46ck1900 FIND v(dout0_46) AT=1910.05n

.meas tran vdout0_47ck1900 FIND v(dout0_47) AT=1910.05n

.meas tran vdout0_48ck1900 FIND v(dout0_48) AT=1910.05n

.meas tran vdout0_49ck1900 FIND v(dout0_49) AT=1910.05n

.meas tran vdout0_50ck1900 FIND v(dout0_50) AT=1910.05n

.meas tran vdout0_51ck1900 FIND v(dout0_51) AT=1910.05n

.meas tran vdout0_52ck1900 FIND v(dout0_52) AT=1910.05n

.meas tran vdout0_53ck1900 FIND v(dout0_53) AT=1910.05n

.meas tran vdout0_54ck1900 FIND v(dout0_54) AT=1910.05n

.meas tran vdout0_55ck1900 FIND v(dout0_55) AT=1910.05n

.meas tran vdout0_56ck1900 FIND v(dout0_56) AT=1910.05n

.meas tran vdout0_57ck1900 FIND v(dout0_57) AT=1910.05n

.meas tran vdout0_58ck1900 FIND v(dout0_58) AT=1910.05n

.meas tran vdout0_59ck1900 FIND v(dout0_59) AT=1910.05n

.meas tran vdout0_60ck1900 FIND v(dout0_60) AT=1910.05n

.meas tran vdout0_61ck1900 FIND v(dout0_61) AT=1910.05n

.meas tran vdout0_62ck1900 FIND v(dout0_62) AT=1910.05n

.meas tran vdout0_63ck1900 FIND v(dout0_63) AT=1910.05n

.meas tran vdout0_64ck1900 FIND v(dout0_64) AT=1910.05n

.meas tran vdout0_0ck1930 FIND v(dout0_0) AT=1940.05n

.meas tran vdout0_1ck1930 FIND v(dout0_1) AT=1940.05n

.meas tran vdout0_2ck1930 FIND v(dout0_2) AT=1940.05n

.meas tran vdout0_3ck1930 FIND v(dout0_3) AT=1940.05n

.meas tran vdout0_4ck1930 FIND v(dout0_4) AT=1940.05n

.meas tran vdout0_5ck1930 FIND v(dout0_5) AT=1940.05n

.meas tran vdout0_6ck1930 FIND v(dout0_6) AT=1940.05n

.meas tran vdout0_7ck1930 FIND v(dout0_7) AT=1940.05n

.meas tran vdout0_8ck1930 FIND v(dout0_8) AT=1940.05n

.meas tran vdout0_9ck1930 FIND v(dout0_9) AT=1940.05n

.meas tran vdout0_10ck1930 FIND v(dout0_10) AT=1940.05n

.meas tran vdout0_11ck1930 FIND v(dout0_11) AT=1940.05n

.meas tran vdout0_12ck1930 FIND v(dout0_12) AT=1940.05n

.meas tran vdout0_13ck1930 FIND v(dout0_13) AT=1940.05n

.meas tran vdout0_14ck1930 FIND v(dout0_14) AT=1940.05n

.meas tran vdout0_15ck1930 FIND v(dout0_15) AT=1940.05n

.meas tran vdout0_16ck1930 FIND v(dout0_16) AT=1940.05n

.meas tran vdout0_17ck1930 FIND v(dout0_17) AT=1940.05n

.meas tran vdout0_18ck1930 FIND v(dout0_18) AT=1940.05n

.meas tran vdout0_19ck1930 FIND v(dout0_19) AT=1940.05n

.meas tran vdout0_20ck1930 FIND v(dout0_20) AT=1940.05n

.meas tran vdout0_21ck1930 FIND v(dout0_21) AT=1940.05n

.meas tran vdout0_22ck1930 FIND v(dout0_22) AT=1940.05n

.meas tran vdout0_23ck1930 FIND v(dout0_23) AT=1940.05n

.meas tran vdout0_24ck1930 FIND v(dout0_24) AT=1940.05n

.meas tran vdout0_25ck1930 FIND v(dout0_25) AT=1940.05n

.meas tran vdout0_26ck1930 FIND v(dout0_26) AT=1940.05n

.meas tran vdout0_27ck1930 FIND v(dout0_27) AT=1940.05n

.meas tran vdout0_28ck1930 FIND v(dout0_28) AT=1940.05n

.meas tran vdout0_29ck1930 FIND v(dout0_29) AT=1940.05n

.meas tran vdout0_30ck1930 FIND v(dout0_30) AT=1940.05n

.meas tran vdout0_31ck1930 FIND v(dout0_31) AT=1940.05n

.meas tran vdout0_32ck1930 FIND v(dout0_32) AT=1940.05n

.meas tran vdout0_33ck1930 FIND v(dout0_33) AT=1940.05n

.meas tran vdout0_34ck1930 FIND v(dout0_34) AT=1940.05n

.meas tran vdout0_35ck1930 FIND v(dout0_35) AT=1940.05n

.meas tran vdout0_36ck1930 FIND v(dout0_36) AT=1940.05n

.meas tran vdout0_37ck1930 FIND v(dout0_37) AT=1940.05n

.meas tran vdout0_38ck1930 FIND v(dout0_38) AT=1940.05n

.meas tran vdout0_39ck1930 FIND v(dout0_39) AT=1940.05n

.meas tran vdout0_40ck1930 FIND v(dout0_40) AT=1940.05n

.meas tran vdout0_41ck1930 FIND v(dout0_41) AT=1940.05n

.meas tran vdout0_42ck1930 FIND v(dout0_42) AT=1940.05n

.meas tran vdout0_43ck1930 FIND v(dout0_43) AT=1940.05n

.meas tran vdout0_44ck1930 FIND v(dout0_44) AT=1940.05n

.meas tran vdout0_45ck1930 FIND v(dout0_45) AT=1940.05n

.meas tran vdout0_46ck1930 FIND v(dout0_46) AT=1940.05n

.meas tran vdout0_47ck1930 FIND v(dout0_47) AT=1940.05n

.meas tran vdout0_48ck1930 FIND v(dout0_48) AT=1940.05n

.meas tran vdout0_49ck1930 FIND v(dout0_49) AT=1940.05n

.meas tran vdout0_50ck1930 FIND v(dout0_50) AT=1940.05n

.meas tran vdout0_51ck1930 FIND v(dout0_51) AT=1940.05n

.meas tran vdout0_52ck1930 FIND v(dout0_52) AT=1940.05n

.meas tran vdout0_53ck1930 FIND v(dout0_53) AT=1940.05n

.meas tran vdout0_54ck1930 FIND v(dout0_54) AT=1940.05n

.meas tran vdout0_55ck1930 FIND v(dout0_55) AT=1940.05n

.meas tran vdout0_56ck1930 FIND v(dout0_56) AT=1940.05n

.meas tran vdout0_57ck1930 FIND v(dout0_57) AT=1940.05n

.meas tran vdout0_58ck1930 FIND v(dout0_58) AT=1940.05n

.meas tran vdout0_59ck1930 FIND v(dout0_59) AT=1940.05n

.meas tran vdout0_60ck1930 FIND v(dout0_60) AT=1940.05n

.meas tran vdout0_61ck1930 FIND v(dout0_61) AT=1940.05n

.meas tran vdout0_62ck1930 FIND v(dout0_62) AT=1940.05n

.meas tran vdout0_63ck1930 FIND v(dout0_63) AT=1940.05n

.meas tran vdout0_64ck1930 FIND v(dout0_64) AT=1940.05n

.meas tran vdout0_0ck1960 FIND v(dout0_0) AT=1970.05n

.meas tran vdout0_1ck1960 FIND v(dout0_1) AT=1970.05n

.meas tran vdout0_2ck1960 FIND v(dout0_2) AT=1970.05n

.meas tran vdout0_3ck1960 FIND v(dout0_3) AT=1970.05n

.meas tran vdout0_4ck1960 FIND v(dout0_4) AT=1970.05n

.meas tran vdout0_5ck1960 FIND v(dout0_5) AT=1970.05n

.meas tran vdout0_6ck1960 FIND v(dout0_6) AT=1970.05n

.meas tran vdout0_7ck1960 FIND v(dout0_7) AT=1970.05n

.meas tran vdout0_8ck1960 FIND v(dout0_8) AT=1970.05n

.meas tran vdout0_9ck1960 FIND v(dout0_9) AT=1970.05n

.meas tran vdout0_10ck1960 FIND v(dout0_10) AT=1970.05n

.meas tran vdout0_11ck1960 FIND v(dout0_11) AT=1970.05n

.meas tran vdout0_12ck1960 FIND v(dout0_12) AT=1970.05n

.meas tran vdout0_13ck1960 FIND v(dout0_13) AT=1970.05n

.meas tran vdout0_14ck1960 FIND v(dout0_14) AT=1970.05n

.meas tran vdout0_15ck1960 FIND v(dout0_15) AT=1970.05n

.meas tran vdout0_16ck1960 FIND v(dout0_16) AT=1970.05n

.meas tran vdout0_17ck1960 FIND v(dout0_17) AT=1970.05n

.meas tran vdout0_18ck1960 FIND v(dout0_18) AT=1970.05n

.meas tran vdout0_19ck1960 FIND v(dout0_19) AT=1970.05n

.meas tran vdout0_20ck1960 FIND v(dout0_20) AT=1970.05n

.meas tran vdout0_21ck1960 FIND v(dout0_21) AT=1970.05n

.meas tran vdout0_22ck1960 FIND v(dout0_22) AT=1970.05n

.meas tran vdout0_23ck1960 FIND v(dout0_23) AT=1970.05n

.meas tran vdout0_24ck1960 FIND v(dout0_24) AT=1970.05n

.meas tran vdout0_25ck1960 FIND v(dout0_25) AT=1970.05n

.meas tran vdout0_26ck1960 FIND v(dout0_26) AT=1970.05n

.meas tran vdout0_27ck1960 FIND v(dout0_27) AT=1970.05n

.meas tran vdout0_28ck1960 FIND v(dout0_28) AT=1970.05n

.meas tran vdout0_29ck1960 FIND v(dout0_29) AT=1970.05n

.meas tran vdout0_30ck1960 FIND v(dout0_30) AT=1970.05n

.meas tran vdout0_31ck1960 FIND v(dout0_31) AT=1970.05n

.meas tran vdout0_32ck1960 FIND v(dout0_32) AT=1970.05n

.meas tran vdout0_33ck1960 FIND v(dout0_33) AT=1970.05n

.meas tran vdout0_34ck1960 FIND v(dout0_34) AT=1970.05n

.meas tran vdout0_35ck1960 FIND v(dout0_35) AT=1970.05n

.meas tran vdout0_36ck1960 FIND v(dout0_36) AT=1970.05n

.meas tran vdout0_37ck1960 FIND v(dout0_37) AT=1970.05n

.meas tran vdout0_38ck1960 FIND v(dout0_38) AT=1970.05n

.meas tran vdout0_39ck1960 FIND v(dout0_39) AT=1970.05n

.meas tran vdout0_40ck1960 FIND v(dout0_40) AT=1970.05n

.meas tran vdout0_41ck1960 FIND v(dout0_41) AT=1970.05n

.meas tran vdout0_42ck1960 FIND v(dout0_42) AT=1970.05n

.meas tran vdout0_43ck1960 FIND v(dout0_43) AT=1970.05n

.meas tran vdout0_44ck1960 FIND v(dout0_44) AT=1970.05n

.meas tran vdout0_45ck1960 FIND v(dout0_45) AT=1970.05n

.meas tran vdout0_46ck1960 FIND v(dout0_46) AT=1970.05n

.meas tran vdout0_47ck1960 FIND v(dout0_47) AT=1970.05n

.meas tran vdout0_48ck1960 FIND v(dout0_48) AT=1970.05n

.meas tran vdout0_49ck1960 FIND v(dout0_49) AT=1970.05n

.meas tran vdout0_50ck1960 FIND v(dout0_50) AT=1970.05n

.meas tran vdout0_51ck1960 FIND v(dout0_51) AT=1970.05n

.meas tran vdout0_52ck1960 FIND v(dout0_52) AT=1970.05n

.meas tran vdout0_53ck1960 FIND v(dout0_53) AT=1970.05n

.meas tran vdout0_54ck1960 FIND v(dout0_54) AT=1970.05n

.meas tran vdout0_55ck1960 FIND v(dout0_55) AT=1970.05n

.meas tran vdout0_56ck1960 FIND v(dout0_56) AT=1970.05n

.meas tran vdout0_57ck1960 FIND v(dout0_57) AT=1970.05n

.meas tran vdout0_58ck1960 FIND v(dout0_58) AT=1970.05n

.meas tran vdout0_59ck1960 FIND v(dout0_59) AT=1970.05n

.meas tran vdout0_60ck1960 FIND v(dout0_60) AT=1970.05n

.meas tran vdout0_61ck1960 FIND v(dout0_61) AT=1970.05n

.meas tran vdout0_62ck1960 FIND v(dout0_62) AT=1970.05n

.meas tran vdout0_63ck1960 FIND v(dout0_63) AT=1970.05n

.meas tran vdout0_64ck1960 FIND v(dout0_64) AT=1970.05n

.meas tran vdout0_0ck1990 FIND v(dout0_0) AT=2000.05n

.meas tran vdout0_1ck1990 FIND v(dout0_1) AT=2000.05n

.meas tran vdout0_2ck1990 FIND v(dout0_2) AT=2000.05n

.meas tran vdout0_3ck1990 FIND v(dout0_3) AT=2000.05n

.meas tran vdout0_4ck1990 FIND v(dout0_4) AT=2000.05n

.meas tran vdout0_5ck1990 FIND v(dout0_5) AT=2000.05n

.meas tran vdout0_6ck1990 FIND v(dout0_6) AT=2000.05n

.meas tran vdout0_7ck1990 FIND v(dout0_7) AT=2000.05n

.meas tran vdout0_8ck1990 FIND v(dout0_8) AT=2000.05n

.meas tran vdout0_9ck1990 FIND v(dout0_9) AT=2000.05n

.meas tran vdout0_10ck1990 FIND v(dout0_10) AT=2000.05n

.meas tran vdout0_11ck1990 FIND v(dout0_11) AT=2000.05n

.meas tran vdout0_12ck1990 FIND v(dout0_12) AT=2000.05n

.meas tran vdout0_13ck1990 FIND v(dout0_13) AT=2000.05n

.meas tran vdout0_14ck1990 FIND v(dout0_14) AT=2000.05n

.meas tran vdout0_15ck1990 FIND v(dout0_15) AT=2000.05n

.meas tran vdout0_16ck1990 FIND v(dout0_16) AT=2000.05n

.meas tran vdout0_17ck1990 FIND v(dout0_17) AT=2000.05n

.meas tran vdout0_18ck1990 FIND v(dout0_18) AT=2000.05n

.meas tran vdout0_19ck1990 FIND v(dout0_19) AT=2000.05n

.meas tran vdout0_20ck1990 FIND v(dout0_20) AT=2000.05n

.meas tran vdout0_21ck1990 FIND v(dout0_21) AT=2000.05n

.meas tran vdout0_22ck1990 FIND v(dout0_22) AT=2000.05n

.meas tran vdout0_23ck1990 FIND v(dout0_23) AT=2000.05n

.meas tran vdout0_24ck1990 FIND v(dout0_24) AT=2000.05n

.meas tran vdout0_25ck1990 FIND v(dout0_25) AT=2000.05n

.meas tran vdout0_26ck1990 FIND v(dout0_26) AT=2000.05n

.meas tran vdout0_27ck1990 FIND v(dout0_27) AT=2000.05n

.meas tran vdout0_28ck1990 FIND v(dout0_28) AT=2000.05n

.meas tran vdout0_29ck1990 FIND v(dout0_29) AT=2000.05n

.meas tran vdout0_30ck1990 FIND v(dout0_30) AT=2000.05n

.meas tran vdout0_31ck1990 FIND v(dout0_31) AT=2000.05n

.meas tran vdout0_32ck1990 FIND v(dout0_32) AT=2000.05n

.meas tran vdout0_33ck1990 FIND v(dout0_33) AT=2000.05n

.meas tran vdout0_34ck1990 FIND v(dout0_34) AT=2000.05n

.meas tran vdout0_35ck1990 FIND v(dout0_35) AT=2000.05n

.meas tran vdout0_36ck1990 FIND v(dout0_36) AT=2000.05n

.meas tran vdout0_37ck1990 FIND v(dout0_37) AT=2000.05n

.meas tran vdout0_38ck1990 FIND v(dout0_38) AT=2000.05n

.meas tran vdout0_39ck1990 FIND v(dout0_39) AT=2000.05n

.meas tran vdout0_40ck1990 FIND v(dout0_40) AT=2000.05n

.meas tran vdout0_41ck1990 FIND v(dout0_41) AT=2000.05n

.meas tran vdout0_42ck1990 FIND v(dout0_42) AT=2000.05n

.meas tran vdout0_43ck1990 FIND v(dout0_43) AT=2000.05n

.meas tran vdout0_44ck1990 FIND v(dout0_44) AT=2000.05n

.meas tran vdout0_45ck1990 FIND v(dout0_45) AT=2000.05n

.meas tran vdout0_46ck1990 FIND v(dout0_46) AT=2000.05n

.meas tran vdout0_47ck1990 FIND v(dout0_47) AT=2000.05n

.meas tran vdout0_48ck1990 FIND v(dout0_48) AT=2000.05n

.meas tran vdout0_49ck1990 FIND v(dout0_49) AT=2000.05n

.meas tran vdout0_50ck1990 FIND v(dout0_50) AT=2000.05n

.meas tran vdout0_51ck1990 FIND v(dout0_51) AT=2000.05n

.meas tran vdout0_52ck1990 FIND v(dout0_52) AT=2000.05n

.meas tran vdout0_53ck1990 FIND v(dout0_53) AT=2000.05n

.meas tran vdout0_54ck1990 FIND v(dout0_54) AT=2000.05n

.meas tran vdout0_55ck1990 FIND v(dout0_55) AT=2000.05n

.meas tran vdout0_56ck1990 FIND v(dout0_56) AT=2000.05n

.meas tran vdout0_57ck1990 FIND v(dout0_57) AT=2000.05n

.meas tran vdout0_58ck1990 FIND v(dout0_58) AT=2000.05n

.meas tran vdout0_59ck1990 FIND v(dout0_59) AT=2000.05n

.meas tran vdout0_60ck1990 FIND v(dout0_60) AT=2000.05n

.meas tran vdout0_61ck1990 FIND v(dout0_61) AT=2000.05n

.meas tran vdout0_62ck1990 FIND v(dout0_62) AT=2000.05n

.meas tran vdout0_63ck1990 FIND v(dout0_63) AT=2000.05n

.meas tran vdout0_64ck1990 FIND v(dout0_64) AT=2000.05n

.meas tran vdout0_0ck2010 FIND v(dout0_0) AT=2020.05n

.meas tran vdout0_1ck2010 FIND v(dout0_1) AT=2020.05n

.meas tran vdout0_2ck2010 FIND v(dout0_2) AT=2020.05n

.meas tran vdout0_3ck2010 FIND v(dout0_3) AT=2020.05n

.meas tran vdout0_4ck2010 FIND v(dout0_4) AT=2020.05n

.meas tran vdout0_5ck2010 FIND v(dout0_5) AT=2020.05n

.meas tran vdout0_6ck2010 FIND v(dout0_6) AT=2020.05n

.meas tran vdout0_7ck2010 FIND v(dout0_7) AT=2020.05n

.meas tran vdout0_8ck2010 FIND v(dout0_8) AT=2020.05n

.meas tran vdout0_9ck2010 FIND v(dout0_9) AT=2020.05n

.meas tran vdout0_10ck2010 FIND v(dout0_10) AT=2020.05n

.meas tran vdout0_11ck2010 FIND v(dout0_11) AT=2020.05n

.meas tran vdout0_12ck2010 FIND v(dout0_12) AT=2020.05n

.meas tran vdout0_13ck2010 FIND v(dout0_13) AT=2020.05n

.meas tran vdout0_14ck2010 FIND v(dout0_14) AT=2020.05n

.meas tran vdout0_15ck2010 FIND v(dout0_15) AT=2020.05n

.meas tran vdout0_16ck2010 FIND v(dout0_16) AT=2020.05n

.meas tran vdout0_17ck2010 FIND v(dout0_17) AT=2020.05n

.meas tran vdout0_18ck2010 FIND v(dout0_18) AT=2020.05n

.meas tran vdout0_19ck2010 FIND v(dout0_19) AT=2020.05n

.meas tran vdout0_20ck2010 FIND v(dout0_20) AT=2020.05n

.meas tran vdout0_21ck2010 FIND v(dout0_21) AT=2020.05n

.meas tran vdout0_22ck2010 FIND v(dout0_22) AT=2020.05n

.meas tran vdout0_23ck2010 FIND v(dout0_23) AT=2020.05n

.meas tran vdout0_24ck2010 FIND v(dout0_24) AT=2020.05n

.meas tran vdout0_25ck2010 FIND v(dout0_25) AT=2020.05n

.meas tran vdout0_26ck2010 FIND v(dout0_26) AT=2020.05n

.meas tran vdout0_27ck2010 FIND v(dout0_27) AT=2020.05n

.meas tran vdout0_28ck2010 FIND v(dout0_28) AT=2020.05n

.meas tran vdout0_29ck2010 FIND v(dout0_29) AT=2020.05n

.meas tran vdout0_30ck2010 FIND v(dout0_30) AT=2020.05n

.meas tran vdout0_31ck2010 FIND v(dout0_31) AT=2020.05n

.meas tran vdout0_32ck2010 FIND v(dout0_32) AT=2020.05n

.meas tran vdout0_33ck2010 FIND v(dout0_33) AT=2020.05n

.meas tran vdout0_34ck2010 FIND v(dout0_34) AT=2020.05n

.meas tran vdout0_35ck2010 FIND v(dout0_35) AT=2020.05n

.meas tran vdout0_36ck2010 FIND v(dout0_36) AT=2020.05n

.meas tran vdout0_37ck2010 FIND v(dout0_37) AT=2020.05n

.meas tran vdout0_38ck2010 FIND v(dout0_38) AT=2020.05n

.meas tran vdout0_39ck2010 FIND v(dout0_39) AT=2020.05n

.meas tran vdout0_40ck2010 FIND v(dout0_40) AT=2020.05n

.meas tran vdout0_41ck2010 FIND v(dout0_41) AT=2020.05n

.meas tran vdout0_42ck2010 FIND v(dout0_42) AT=2020.05n

.meas tran vdout0_43ck2010 FIND v(dout0_43) AT=2020.05n

.meas tran vdout0_44ck2010 FIND v(dout0_44) AT=2020.05n

.meas tran vdout0_45ck2010 FIND v(dout0_45) AT=2020.05n

.meas tran vdout0_46ck2010 FIND v(dout0_46) AT=2020.05n

.meas tran vdout0_47ck2010 FIND v(dout0_47) AT=2020.05n

.meas tran vdout0_48ck2010 FIND v(dout0_48) AT=2020.05n

.meas tran vdout0_49ck2010 FIND v(dout0_49) AT=2020.05n

.meas tran vdout0_50ck2010 FIND v(dout0_50) AT=2020.05n

.meas tran vdout0_51ck2010 FIND v(dout0_51) AT=2020.05n

.meas tran vdout0_52ck2010 FIND v(dout0_52) AT=2020.05n

.meas tran vdout0_53ck2010 FIND v(dout0_53) AT=2020.05n

.meas tran vdout0_54ck2010 FIND v(dout0_54) AT=2020.05n

.meas tran vdout0_55ck2010 FIND v(dout0_55) AT=2020.05n

.meas tran vdout0_56ck2010 FIND v(dout0_56) AT=2020.05n

.meas tran vdout0_57ck2010 FIND v(dout0_57) AT=2020.05n

.meas tran vdout0_58ck2010 FIND v(dout0_58) AT=2020.05n

.meas tran vdout0_59ck2010 FIND v(dout0_59) AT=2020.05n

.meas tran vdout0_60ck2010 FIND v(dout0_60) AT=2020.05n

.meas tran vdout0_61ck2010 FIND v(dout0_61) AT=2020.05n

.meas tran vdout0_62ck2010 FIND v(dout0_62) AT=2020.05n

.meas tran vdout0_63ck2010 FIND v(dout0_63) AT=2020.05n

.meas tran vdout0_64ck2010 FIND v(dout0_64) AT=2020.05n

.meas tran vdout0_0ck2020 FIND v(dout0_0) AT=2030.05n

.meas tran vdout0_1ck2020 FIND v(dout0_1) AT=2030.05n

.meas tran vdout0_2ck2020 FIND v(dout0_2) AT=2030.05n

.meas tran vdout0_3ck2020 FIND v(dout0_3) AT=2030.05n

.meas tran vdout0_4ck2020 FIND v(dout0_4) AT=2030.05n

.meas tran vdout0_5ck2020 FIND v(dout0_5) AT=2030.05n

.meas tran vdout0_6ck2020 FIND v(dout0_6) AT=2030.05n

.meas tran vdout0_7ck2020 FIND v(dout0_7) AT=2030.05n

.meas tran vdout0_8ck2020 FIND v(dout0_8) AT=2030.05n

.meas tran vdout0_9ck2020 FIND v(dout0_9) AT=2030.05n

.meas tran vdout0_10ck2020 FIND v(dout0_10) AT=2030.05n

.meas tran vdout0_11ck2020 FIND v(dout0_11) AT=2030.05n

.meas tran vdout0_12ck2020 FIND v(dout0_12) AT=2030.05n

.meas tran vdout0_13ck2020 FIND v(dout0_13) AT=2030.05n

.meas tran vdout0_14ck2020 FIND v(dout0_14) AT=2030.05n

.meas tran vdout0_15ck2020 FIND v(dout0_15) AT=2030.05n

.meas tran vdout0_16ck2020 FIND v(dout0_16) AT=2030.05n

.meas tran vdout0_17ck2020 FIND v(dout0_17) AT=2030.05n

.meas tran vdout0_18ck2020 FIND v(dout0_18) AT=2030.05n

.meas tran vdout0_19ck2020 FIND v(dout0_19) AT=2030.05n

.meas tran vdout0_20ck2020 FIND v(dout0_20) AT=2030.05n

.meas tran vdout0_21ck2020 FIND v(dout0_21) AT=2030.05n

.meas tran vdout0_22ck2020 FIND v(dout0_22) AT=2030.05n

.meas tran vdout0_23ck2020 FIND v(dout0_23) AT=2030.05n

.meas tran vdout0_24ck2020 FIND v(dout0_24) AT=2030.05n

.meas tran vdout0_25ck2020 FIND v(dout0_25) AT=2030.05n

.meas tran vdout0_26ck2020 FIND v(dout0_26) AT=2030.05n

.meas tran vdout0_27ck2020 FIND v(dout0_27) AT=2030.05n

.meas tran vdout0_28ck2020 FIND v(dout0_28) AT=2030.05n

.meas tran vdout0_29ck2020 FIND v(dout0_29) AT=2030.05n

.meas tran vdout0_30ck2020 FIND v(dout0_30) AT=2030.05n

.meas tran vdout0_31ck2020 FIND v(dout0_31) AT=2030.05n

.meas tran vdout0_32ck2020 FIND v(dout0_32) AT=2030.05n

.meas tran vdout0_33ck2020 FIND v(dout0_33) AT=2030.05n

.meas tran vdout0_34ck2020 FIND v(dout0_34) AT=2030.05n

.meas tran vdout0_35ck2020 FIND v(dout0_35) AT=2030.05n

.meas tran vdout0_36ck2020 FIND v(dout0_36) AT=2030.05n

.meas tran vdout0_37ck2020 FIND v(dout0_37) AT=2030.05n

.meas tran vdout0_38ck2020 FIND v(dout0_38) AT=2030.05n

.meas tran vdout0_39ck2020 FIND v(dout0_39) AT=2030.05n

.meas tran vdout0_40ck2020 FIND v(dout0_40) AT=2030.05n

.meas tran vdout0_41ck2020 FIND v(dout0_41) AT=2030.05n

.meas tran vdout0_42ck2020 FIND v(dout0_42) AT=2030.05n

.meas tran vdout0_43ck2020 FIND v(dout0_43) AT=2030.05n

.meas tran vdout0_44ck2020 FIND v(dout0_44) AT=2030.05n

.meas tran vdout0_45ck2020 FIND v(dout0_45) AT=2030.05n

.meas tran vdout0_46ck2020 FIND v(dout0_46) AT=2030.05n

.meas tran vdout0_47ck2020 FIND v(dout0_47) AT=2030.05n

.meas tran vdout0_48ck2020 FIND v(dout0_48) AT=2030.05n

.meas tran vdout0_49ck2020 FIND v(dout0_49) AT=2030.05n

.meas tran vdout0_50ck2020 FIND v(dout0_50) AT=2030.05n

.meas tran vdout0_51ck2020 FIND v(dout0_51) AT=2030.05n

.meas tran vdout0_52ck2020 FIND v(dout0_52) AT=2030.05n

.meas tran vdout0_53ck2020 FIND v(dout0_53) AT=2030.05n

.meas tran vdout0_54ck2020 FIND v(dout0_54) AT=2030.05n

.meas tran vdout0_55ck2020 FIND v(dout0_55) AT=2030.05n

.meas tran vdout0_56ck2020 FIND v(dout0_56) AT=2030.05n

.meas tran vdout0_57ck2020 FIND v(dout0_57) AT=2030.05n

.meas tran vdout0_58ck2020 FIND v(dout0_58) AT=2030.05n

.meas tran vdout0_59ck2020 FIND v(dout0_59) AT=2030.05n

.meas tran vdout0_60ck2020 FIND v(dout0_60) AT=2030.05n

.meas tran vdout0_61ck2020 FIND v(dout0_61) AT=2030.05n

.meas tran vdout0_62ck2020 FIND v(dout0_62) AT=2030.05n

.meas tran vdout0_63ck2020 FIND v(dout0_63) AT=2030.05n

.meas tran vdout0_64ck2020 FIND v(dout0_64) AT=2030.05n
