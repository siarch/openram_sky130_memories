.meas tran vdout0_0ck40 FIND v(dout0_0) AT=50.05n

.meas tran vdout0_1ck40 FIND v(dout0_1) AT=50.05n

.meas tran vdout0_2ck40 FIND v(dout0_2) AT=50.05n

.meas tran vdout0_3ck40 FIND v(dout0_3) AT=50.05n

.meas tran vdout0_4ck40 FIND v(dout0_4) AT=50.05n

.meas tran vdout0_5ck40 FIND v(dout0_5) AT=50.05n

.meas tran vdout0_6ck40 FIND v(dout0_6) AT=50.05n

.meas tran vdout0_7ck40 FIND v(dout0_7) AT=50.05n

.meas tran vdout0_8ck40 FIND v(dout0_8) AT=50.05n

.meas tran vdout0_9ck40 FIND v(dout0_9) AT=50.05n

.meas tran vdout0_10ck40 FIND v(dout0_10) AT=50.05n

.meas tran vdout0_11ck40 FIND v(dout0_11) AT=50.05n

.meas tran vdout0_12ck40 FIND v(dout0_12) AT=50.05n

.meas tran vdout0_13ck40 FIND v(dout0_13) AT=50.05n

.meas tran vdout0_14ck40 FIND v(dout0_14) AT=50.05n

.meas tran vdout0_15ck40 FIND v(dout0_15) AT=50.05n

.meas tran vdout0_16ck40 FIND v(dout0_16) AT=50.05n

.meas tran vdout0_17ck40 FIND v(dout0_17) AT=50.05n

.meas tran vdout0_18ck40 FIND v(dout0_18) AT=50.05n

.meas tran vdout0_19ck40 FIND v(dout0_19) AT=50.05n

.meas tran vdout0_20ck40 FIND v(dout0_20) AT=50.05n

.meas tran vdout0_21ck40 FIND v(dout0_21) AT=50.05n

.meas tran vdout0_22ck40 FIND v(dout0_22) AT=50.05n

.meas tran vdout0_23ck40 FIND v(dout0_23) AT=50.05n

.meas tran vdout0_24ck40 FIND v(dout0_24) AT=50.05n

.meas tran vdout0_25ck40 FIND v(dout0_25) AT=50.05n

.meas tran vdout0_26ck40 FIND v(dout0_26) AT=50.05n

.meas tran vdout0_27ck40 FIND v(dout0_27) AT=50.05n

.meas tran vdout0_28ck40 FIND v(dout0_28) AT=50.05n

.meas tran vdout0_29ck40 FIND v(dout0_29) AT=50.05n

.meas tran vdout0_30ck40 FIND v(dout0_30) AT=50.05n

.meas tran vdout0_31ck40 FIND v(dout0_31) AT=50.05n

.meas tran vdout0_32ck40 FIND v(dout0_32) AT=50.05n

.meas tran vdout0_0ck60 FIND v(dout0_0) AT=70.05n

.meas tran vdout0_1ck60 FIND v(dout0_1) AT=70.05n

.meas tran vdout0_2ck60 FIND v(dout0_2) AT=70.05n

.meas tran vdout0_3ck60 FIND v(dout0_3) AT=70.05n

.meas tran vdout0_4ck60 FIND v(dout0_4) AT=70.05n

.meas tran vdout0_5ck60 FIND v(dout0_5) AT=70.05n

.meas tran vdout0_6ck60 FIND v(dout0_6) AT=70.05n

.meas tran vdout0_7ck60 FIND v(dout0_7) AT=70.05n

.meas tran vdout0_8ck60 FIND v(dout0_8) AT=70.05n

.meas tran vdout0_9ck60 FIND v(dout0_9) AT=70.05n

.meas tran vdout0_10ck60 FIND v(dout0_10) AT=70.05n

.meas tran vdout0_11ck60 FIND v(dout0_11) AT=70.05n

.meas tran vdout0_12ck60 FIND v(dout0_12) AT=70.05n

.meas tran vdout0_13ck60 FIND v(dout0_13) AT=70.05n

.meas tran vdout0_14ck60 FIND v(dout0_14) AT=70.05n

.meas tran vdout0_15ck60 FIND v(dout0_15) AT=70.05n

.meas tran vdout0_16ck60 FIND v(dout0_16) AT=70.05n

.meas tran vdout0_17ck60 FIND v(dout0_17) AT=70.05n

.meas tran vdout0_18ck60 FIND v(dout0_18) AT=70.05n

.meas tran vdout0_19ck60 FIND v(dout0_19) AT=70.05n

.meas tran vdout0_20ck60 FIND v(dout0_20) AT=70.05n

.meas tran vdout0_21ck60 FIND v(dout0_21) AT=70.05n

.meas tran vdout0_22ck60 FIND v(dout0_22) AT=70.05n

.meas tran vdout0_23ck60 FIND v(dout0_23) AT=70.05n

.meas tran vdout0_24ck60 FIND v(dout0_24) AT=70.05n

.meas tran vdout0_25ck60 FIND v(dout0_25) AT=70.05n

.meas tran vdout0_26ck60 FIND v(dout0_26) AT=70.05n

.meas tran vdout0_27ck60 FIND v(dout0_27) AT=70.05n

.meas tran vdout0_28ck60 FIND v(dout0_28) AT=70.05n

.meas tran vdout0_29ck60 FIND v(dout0_29) AT=70.05n

.meas tran vdout0_30ck60 FIND v(dout0_30) AT=70.05n

.meas tran vdout0_31ck60 FIND v(dout0_31) AT=70.05n

.meas tran vdout0_32ck60 FIND v(dout0_32) AT=70.05n

.meas tran vdout0_0ck120 FIND v(dout0_0) AT=130.05n

.meas tran vdout0_1ck120 FIND v(dout0_1) AT=130.05n

.meas tran vdout0_2ck120 FIND v(dout0_2) AT=130.05n

.meas tran vdout0_3ck120 FIND v(dout0_3) AT=130.05n

.meas tran vdout0_4ck120 FIND v(dout0_4) AT=130.05n

.meas tran vdout0_5ck120 FIND v(dout0_5) AT=130.05n

.meas tran vdout0_6ck120 FIND v(dout0_6) AT=130.05n

.meas tran vdout0_7ck120 FIND v(dout0_7) AT=130.05n

.meas tran vdout0_8ck120 FIND v(dout0_8) AT=130.05n

.meas tran vdout0_9ck120 FIND v(dout0_9) AT=130.05n

.meas tran vdout0_10ck120 FIND v(dout0_10) AT=130.05n

.meas tran vdout0_11ck120 FIND v(dout0_11) AT=130.05n

.meas tran vdout0_12ck120 FIND v(dout0_12) AT=130.05n

.meas tran vdout0_13ck120 FIND v(dout0_13) AT=130.05n

.meas tran vdout0_14ck120 FIND v(dout0_14) AT=130.05n

.meas tran vdout0_15ck120 FIND v(dout0_15) AT=130.05n

.meas tran vdout0_16ck120 FIND v(dout0_16) AT=130.05n

.meas tran vdout0_17ck120 FIND v(dout0_17) AT=130.05n

.meas tran vdout0_18ck120 FIND v(dout0_18) AT=130.05n

.meas tran vdout0_19ck120 FIND v(dout0_19) AT=130.05n

.meas tran vdout0_20ck120 FIND v(dout0_20) AT=130.05n

.meas tran vdout0_21ck120 FIND v(dout0_21) AT=130.05n

.meas tran vdout0_22ck120 FIND v(dout0_22) AT=130.05n

.meas tran vdout0_23ck120 FIND v(dout0_23) AT=130.05n

.meas tran vdout0_24ck120 FIND v(dout0_24) AT=130.05n

.meas tran vdout0_25ck120 FIND v(dout0_25) AT=130.05n

.meas tran vdout0_26ck120 FIND v(dout0_26) AT=130.05n

.meas tran vdout0_27ck120 FIND v(dout0_27) AT=130.05n

.meas tran vdout0_28ck120 FIND v(dout0_28) AT=130.05n

.meas tran vdout0_29ck120 FIND v(dout0_29) AT=130.05n

.meas tran vdout0_30ck120 FIND v(dout0_30) AT=130.05n

.meas tran vdout0_31ck120 FIND v(dout0_31) AT=130.05n

.meas tran vdout0_32ck120 FIND v(dout0_32) AT=130.05n

.meas tran vdout0_0ck130 FIND v(dout0_0) AT=140.05n

.meas tran vdout0_1ck130 FIND v(dout0_1) AT=140.05n

.meas tran vdout0_2ck130 FIND v(dout0_2) AT=140.05n

.meas tran vdout0_3ck130 FIND v(dout0_3) AT=140.05n

.meas tran vdout0_4ck130 FIND v(dout0_4) AT=140.05n

.meas tran vdout0_5ck130 FIND v(dout0_5) AT=140.05n

.meas tran vdout0_6ck130 FIND v(dout0_6) AT=140.05n

.meas tran vdout0_7ck130 FIND v(dout0_7) AT=140.05n

.meas tran vdout0_8ck130 FIND v(dout0_8) AT=140.05n

.meas tran vdout0_9ck130 FIND v(dout0_9) AT=140.05n

.meas tran vdout0_10ck130 FIND v(dout0_10) AT=140.05n

.meas tran vdout0_11ck130 FIND v(dout0_11) AT=140.05n

.meas tran vdout0_12ck130 FIND v(dout0_12) AT=140.05n

.meas tran vdout0_13ck130 FIND v(dout0_13) AT=140.05n

.meas tran vdout0_14ck130 FIND v(dout0_14) AT=140.05n

.meas tran vdout0_15ck130 FIND v(dout0_15) AT=140.05n

.meas tran vdout0_16ck130 FIND v(dout0_16) AT=140.05n

.meas tran vdout0_17ck130 FIND v(dout0_17) AT=140.05n

.meas tran vdout0_18ck130 FIND v(dout0_18) AT=140.05n

.meas tran vdout0_19ck130 FIND v(dout0_19) AT=140.05n

.meas tran vdout0_20ck130 FIND v(dout0_20) AT=140.05n

.meas tran vdout0_21ck130 FIND v(dout0_21) AT=140.05n

.meas tran vdout0_22ck130 FIND v(dout0_22) AT=140.05n

.meas tran vdout0_23ck130 FIND v(dout0_23) AT=140.05n

.meas tran vdout0_24ck130 FIND v(dout0_24) AT=140.05n

.meas tran vdout0_25ck130 FIND v(dout0_25) AT=140.05n

.meas tran vdout0_26ck130 FIND v(dout0_26) AT=140.05n

.meas tran vdout0_27ck130 FIND v(dout0_27) AT=140.05n

.meas tran vdout0_28ck130 FIND v(dout0_28) AT=140.05n

.meas tran vdout0_29ck130 FIND v(dout0_29) AT=140.05n

.meas tran vdout0_30ck130 FIND v(dout0_30) AT=140.05n

.meas tran vdout0_31ck130 FIND v(dout0_31) AT=140.05n

.meas tran vdout0_32ck130 FIND v(dout0_32) AT=140.05n

.meas tran vdout0_0ck140 FIND v(dout0_0) AT=150.05n

.meas tran vdout0_1ck140 FIND v(dout0_1) AT=150.05n

.meas tran vdout0_2ck140 FIND v(dout0_2) AT=150.05n

.meas tran vdout0_3ck140 FIND v(dout0_3) AT=150.05n

.meas tran vdout0_4ck140 FIND v(dout0_4) AT=150.05n

.meas tran vdout0_5ck140 FIND v(dout0_5) AT=150.05n

.meas tran vdout0_6ck140 FIND v(dout0_6) AT=150.05n

.meas tran vdout0_7ck140 FIND v(dout0_7) AT=150.05n

.meas tran vdout0_8ck140 FIND v(dout0_8) AT=150.05n

.meas tran vdout0_9ck140 FIND v(dout0_9) AT=150.05n

.meas tran vdout0_10ck140 FIND v(dout0_10) AT=150.05n

.meas tran vdout0_11ck140 FIND v(dout0_11) AT=150.05n

.meas tran vdout0_12ck140 FIND v(dout0_12) AT=150.05n

.meas tran vdout0_13ck140 FIND v(dout0_13) AT=150.05n

.meas tran vdout0_14ck140 FIND v(dout0_14) AT=150.05n

.meas tran vdout0_15ck140 FIND v(dout0_15) AT=150.05n

.meas tran vdout0_16ck140 FIND v(dout0_16) AT=150.05n

.meas tran vdout0_17ck140 FIND v(dout0_17) AT=150.05n

.meas tran vdout0_18ck140 FIND v(dout0_18) AT=150.05n

.meas tran vdout0_19ck140 FIND v(dout0_19) AT=150.05n

.meas tran vdout0_20ck140 FIND v(dout0_20) AT=150.05n

.meas tran vdout0_21ck140 FIND v(dout0_21) AT=150.05n

.meas tran vdout0_22ck140 FIND v(dout0_22) AT=150.05n

.meas tran vdout0_23ck140 FIND v(dout0_23) AT=150.05n

.meas tran vdout0_24ck140 FIND v(dout0_24) AT=150.05n

.meas tran vdout0_25ck140 FIND v(dout0_25) AT=150.05n

.meas tran vdout0_26ck140 FIND v(dout0_26) AT=150.05n

.meas tran vdout0_27ck140 FIND v(dout0_27) AT=150.05n

.meas tran vdout0_28ck140 FIND v(dout0_28) AT=150.05n

.meas tran vdout0_29ck140 FIND v(dout0_29) AT=150.05n

.meas tran vdout0_30ck140 FIND v(dout0_30) AT=150.05n

.meas tran vdout0_31ck140 FIND v(dout0_31) AT=150.05n

.meas tran vdout0_32ck140 FIND v(dout0_32) AT=150.05n

.meas tran vdout0_0ck180 FIND v(dout0_0) AT=190.05n

.meas tran vdout0_1ck180 FIND v(dout0_1) AT=190.05n

.meas tran vdout0_2ck180 FIND v(dout0_2) AT=190.05n

.meas tran vdout0_3ck180 FIND v(dout0_3) AT=190.05n

.meas tran vdout0_4ck180 FIND v(dout0_4) AT=190.05n

.meas tran vdout0_5ck180 FIND v(dout0_5) AT=190.05n

.meas tran vdout0_6ck180 FIND v(dout0_6) AT=190.05n

.meas tran vdout0_7ck180 FIND v(dout0_7) AT=190.05n

.meas tran vdout0_8ck180 FIND v(dout0_8) AT=190.05n

.meas tran vdout0_9ck180 FIND v(dout0_9) AT=190.05n

.meas tran vdout0_10ck180 FIND v(dout0_10) AT=190.05n

.meas tran vdout0_11ck180 FIND v(dout0_11) AT=190.05n

.meas tran vdout0_12ck180 FIND v(dout0_12) AT=190.05n

.meas tran vdout0_13ck180 FIND v(dout0_13) AT=190.05n

.meas tran vdout0_14ck180 FIND v(dout0_14) AT=190.05n

.meas tran vdout0_15ck180 FIND v(dout0_15) AT=190.05n

.meas tran vdout0_16ck180 FIND v(dout0_16) AT=190.05n

.meas tran vdout0_17ck180 FIND v(dout0_17) AT=190.05n

.meas tran vdout0_18ck180 FIND v(dout0_18) AT=190.05n

.meas tran vdout0_19ck180 FIND v(dout0_19) AT=190.05n

.meas tran vdout0_20ck180 FIND v(dout0_20) AT=190.05n

.meas tran vdout0_21ck180 FIND v(dout0_21) AT=190.05n

.meas tran vdout0_22ck180 FIND v(dout0_22) AT=190.05n

.meas tran vdout0_23ck180 FIND v(dout0_23) AT=190.05n

.meas tran vdout0_24ck180 FIND v(dout0_24) AT=190.05n

.meas tran vdout0_25ck180 FIND v(dout0_25) AT=190.05n

.meas tran vdout0_26ck180 FIND v(dout0_26) AT=190.05n

.meas tran vdout0_27ck180 FIND v(dout0_27) AT=190.05n

.meas tran vdout0_28ck180 FIND v(dout0_28) AT=190.05n

.meas tran vdout0_29ck180 FIND v(dout0_29) AT=190.05n

.meas tran vdout0_30ck180 FIND v(dout0_30) AT=190.05n

.meas tran vdout0_31ck180 FIND v(dout0_31) AT=190.05n

.meas tran vdout0_32ck180 FIND v(dout0_32) AT=190.05n

.meas tran vdout0_0ck210 FIND v(dout0_0) AT=220.05n

.meas tran vdout0_1ck210 FIND v(dout0_1) AT=220.05n

.meas tran vdout0_2ck210 FIND v(dout0_2) AT=220.05n

.meas tran vdout0_3ck210 FIND v(dout0_3) AT=220.05n

.meas tran vdout0_4ck210 FIND v(dout0_4) AT=220.05n

.meas tran vdout0_5ck210 FIND v(dout0_5) AT=220.05n

.meas tran vdout0_6ck210 FIND v(dout0_6) AT=220.05n

.meas tran vdout0_7ck210 FIND v(dout0_7) AT=220.05n

.meas tran vdout0_8ck210 FIND v(dout0_8) AT=220.05n

.meas tran vdout0_9ck210 FIND v(dout0_9) AT=220.05n

.meas tran vdout0_10ck210 FIND v(dout0_10) AT=220.05n

.meas tran vdout0_11ck210 FIND v(dout0_11) AT=220.05n

.meas tran vdout0_12ck210 FIND v(dout0_12) AT=220.05n

.meas tran vdout0_13ck210 FIND v(dout0_13) AT=220.05n

.meas tran vdout0_14ck210 FIND v(dout0_14) AT=220.05n

.meas tran vdout0_15ck210 FIND v(dout0_15) AT=220.05n

.meas tran vdout0_16ck210 FIND v(dout0_16) AT=220.05n

.meas tran vdout0_17ck210 FIND v(dout0_17) AT=220.05n

.meas tran vdout0_18ck210 FIND v(dout0_18) AT=220.05n

.meas tran vdout0_19ck210 FIND v(dout0_19) AT=220.05n

.meas tran vdout0_20ck210 FIND v(dout0_20) AT=220.05n

.meas tran vdout0_21ck210 FIND v(dout0_21) AT=220.05n

.meas tran vdout0_22ck210 FIND v(dout0_22) AT=220.05n

.meas tran vdout0_23ck210 FIND v(dout0_23) AT=220.05n

.meas tran vdout0_24ck210 FIND v(dout0_24) AT=220.05n

.meas tran vdout0_25ck210 FIND v(dout0_25) AT=220.05n

.meas tran vdout0_26ck210 FIND v(dout0_26) AT=220.05n

.meas tran vdout0_27ck210 FIND v(dout0_27) AT=220.05n

.meas tran vdout0_28ck210 FIND v(dout0_28) AT=220.05n

.meas tran vdout0_29ck210 FIND v(dout0_29) AT=220.05n

.meas tran vdout0_30ck210 FIND v(dout0_30) AT=220.05n

.meas tran vdout0_31ck210 FIND v(dout0_31) AT=220.05n

.meas tran vdout0_32ck210 FIND v(dout0_32) AT=220.05n

.meas tran vdout0_0ck260 FIND v(dout0_0) AT=270.05n

.meas tran vdout0_1ck260 FIND v(dout0_1) AT=270.05n

.meas tran vdout0_2ck260 FIND v(dout0_2) AT=270.05n

.meas tran vdout0_3ck260 FIND v(dout0_3) AT=270.05n

.meas tran vdout0_4ck260 FIND v(dout0_4) AT=270.05n

.meas tran vdout0_5ck260 FIND v(dout0_5) AT=270.05n

.meas tran vdout0_6ck260 FIND v(dout0_6) AT=270.05n

.meas tran vdout0_7ck260 FIND v(dout0_7) AT=270.05n

.meas tran vdout0_8ck260 FIND v(dout0_8) AT=270.05n

.meas tran vdout0_9ck260 FIND v(dout0_9) AT=270.05n

.meas tran vdout0_10ck260 FIND v(dout0_10) AT=270.05n

.meas tran vdout0_11ck260 FIND v(dout0_11) AT=270.05n

.meas tran vdout0_12ck260 FIND v(dout0_12) AT=270.05n

.meas tran vdout0_13ck260 FIND v(dout0_13) AT=270.05n

.meas tran vdout0_14ck260 FIND v(dout0_14) AT=270.05n

.meas tran vdout0_15ck260 FIND v(dout0_15) AT=270.05n

.meas tran vdout0_16ck260 FIND v(dout0_16) AT=270.05n

.meas tran vdout0_17ck260 FIND v(dout0_17) AT=270.05n

.meas tran vdout0_18ck260 FIND v(dout0_18) AT=270.05n

.meas tran vdout0_19ck260 FIND v(dout0_19) AT=270.05n

.meas tran vdout0_20ck260 FIND v(dout0_20) AT=270.05n

.meas tran vdout0_21ck260 FIND v(dout0_21) AT=270.05n

.meas tran vdout0_22ck260 FIND v(dout0_22) AT=270.05n

.meas tran vdout0_23ck260 FIND v(dout0_23) AT=270.05n

.meas tran vdout0_24ck260 FIND v(dout0_24) AT=270.05n

.meas tran vdout0_25ck260 FIND v(dout0_25) AT=270.05n

.meas tran vdout0_26ck260 FIND v(dout0_26) AT=270.05n

.meas tran vdout0_27ck260 FIND v(dout0_27) AT=270.05n

.meas tran vdout0_28ck260 FIND v(dout0_28) AT=270.05n

.meas tran vdout0_29ck260 FIND v(dout0_29) AT=270.05n

.meas tran vdout0_30ck260 FIND v(dout0_30) AT=270.05n

.meas tran vdout0_31ck260 FIND v(dout0_31) AT=270.05n

.meas tran vdout0_32ck260 FIND v(dout0_32) AT=270.05n

.meas tran vdout0_0ck270 FIND v(dout0_0) AT=280.05n

.meas tran vdout0_1ck270 FIND v(dout0_1) AT=280.05n

.meas tran vdout0_2ck270 FIND v(dout0_2) AT=280.05n

.meas tran vdout0_3ck270 FIND v(dout0_3) AT=280.05n

.meas tran vdout0_4ck270 FIND v(dout0_4) AT=280.05n

.meas tran vdout0_5ck270 FIND v(dout0_5) AT=280.05n

.meas tran vdout0_6ck270 FIND v(dout0_6) AT=280.05n

.meas tran vdout0_7ck270 FIND v(dout0_7) AT=280.05n

.meas tran vdout0_8ck270 FIND v(dout0_8) AT=280.05n

.meas tran vdout0_9ck270 FIND v(dout0_9) AT=280.05n

.meas tran vdout0_10ck270 FIND v(dout0_10) AT=280.05n

.meas tran vdout0_11ck270 FIND v(dout0_11) AT=280.05n

.meas tran vdout0_12ck270 FIND v(dout0_12) AT=280.05n

.meas tran vdout0_13ck270 FIND v(dout0_13) AT=280.05n

.meas tran vdout0_14ck270 FIND v(dout0_14) AT=280.05n

.meas tran vdout0_15ck270 FIND v(dout0_15) AT=280.05n

.meas tran vdout0_16ck270 FIND v(dout0_16) AT=280.05n

.meas tran vdout0_17ck270 FIND v(dout0_17) AT=280.05n

.meas tran vdout0_18ck270 FIND v(dout0_18) AT=280.05n

.meas tran vdout0_19ck270 FIND v(dout0_19) AT=280.05n

.meas tran vdout0_20ck270 FIND v(dout0_20) AT=280.05n

.meas tran vdout0_21ck270 FIND v(dout0_21) AT=280.05n

.meas tran vdout0_22ck270 FIND v(dout0_22) AT=280.05n

.meas tran vdout0_23ck270 FIND v(dout0_23) AT=280.05n

.meas tran vdout0_24ck270 FIND v(dout0_24) AT=280.05n

.meas tran vdout0_25ck270 FIND v(dout0_25) AT=280.05n

.meas tran vdout0_26ck270 FIND v(dout0_26) AT=280.05n

.meas tran vdout0_27ck270 FIND v(dout0_27) AT=280.05n

.meas tran vdout0_28ck270 FIND v(dout0_28) AT=280.05n

.meas tran vdout0_29ck270 FIND v(dout0_29) AT=280.05n

.meas tran vdout0_30ck270 FIND v(dout0_30) AT=280.05n

.meas tran vdout0_31ck270 FIND v(dout0_31) AT=280.05n

.meas tran vdout0_32ck270 FIND v(dout0_32) AT=280.05n

.meas tran vdout0_0ck300 FIND v(dout0_0) AT=310.05n

.meas tran vdout0_1ck300 FIND v(dout0_1) AT=310.05n

.meas tran vdout0_2ck300 FIND v(dout0_2) AT=310.05n

.meas tran vdout0_3ck300 FIND v(dout0_3) AT=310.05n

.meas tran vdout0_4ck300 FIND v(dout0_4) AT=310.05n

.meas tran vdout0_5ck300 FIND v(dout0_5) AT=310.05n

.meas tran vdout0_6ck300 FIND v(dout0_6) AT=310.05n

.meas tran vdout0_7ck300 FIND v(dout0_7) AT=310.05n

.meas tran vdout0_8ck300 FIND v(dout0_8) AT=310.05n

.meas tran vdout0_9ck300 FIND v(dout0_9) AT=310.05n

.meas tran vdout0_10ck300 FIND v(dout0_10) AT=310.05n

.meas tran vdout0_11ck300 FIND v(dout0_11) AT=310.05n

.meas tran vdout0_12ck300 FIND v(dout0_12) AT=310.05n

.meas tran vdout0_13ck300 FIND v(dout0_13) AT=310.05n

.meas tran vdout0_14ck300 FIND v(dout0_14) AT=310.05n

.meas tran vdout0_15ck300 FIND v(dout0_15) AT=310.05n

.meas tran vdout0_16ck300 FIND v(dout0_16) AT=310.05n

.meas tran vdout0_17ck300 FIND v(dout0_17) AT=310.05n

.meas tran vdout0_18ck300 FIND v(dout0_18) AT=310.05n

.meas tran vdout0_19ck300 FIND v(dout0_19) AT=310.05n

.meas tran vdout0_20ck300 FIND v(dout0_20) AT=310.05n

.meas tran vdout0_21ck300 FIND v(dout0_21) AT=310.05n

.meas tran vdout0_22ck300 FIND v(dout0_22) AT=310.05n

.meas tran vdout0_23ck300 FIND v(dout0_23) AT=310.05n

.meas tran vdout0_24ck300 FIND v(dout0_24) AT=310.05n

.meas tran vdout0_25ck300 FIND v(dout0_25) AT=310.05n

.meas tran vdout0_26ck300 FIND v(dout0_26) AT=310.05n

.meas tran vdout0_27ck300 FIND v(dout0_27) AT=310.05n

.meas tran vdout0_28ck300 FIND v(dout0_28) AT=310.05n

.meas tran vdout0_29ck300 FIND v(dout0_29) AT=310.05n

.meas tran vdout0_30ck300 FIND v(dout0_30) AT=310.05n

.meas tran vdout0_31ck300 FIND v(dout0_31) AT=310.05n

.meas tran vdout0_32ck300 FIND v(dout0_32) AT=310.05n

.meas tran vdout0_0ck370 FIND v(dout0_0) AT=380.05n

.meas tran vdout0_1ck370 FIND v(dout0_1) AT=380.05n

.meas tran vdout0_2ck370 FIND v(dout0_2) AT=380.05n

.meas tran vdout0_3ck370 FIND v(dout0_3) AT=380.05n

.meas tran vdout0_4ck370 FIND v(dout0_4) AT=380.05n

.meas tran vdout0_5ck370 FIND v(dout0_5) AT=380.05n

.meas tran vdout0_6ck370 FIND v(dout0_6) AT=380.05n

.meas tran vdout0_7ck370 FIND v(dout0_7) AT=380.05n

.meas tran vdout0_8ck370 FIND v(dout0_8) AT=380.05n

.meas tran vdout0_9ck370 FIND v(dout0_9) AT=380.05n

.meas tran vdout0_10ck370 FIND v(dout0_10) AT=380.05n

.meas tran vdout0_11ck370 FIND v(dout0_11) AT=380.05n

.meas tran vdout0_12ck370 FIND v(dout0_12) AT=380.05n

.meas tran vdout0_13ck370 FIND v(dout0_13) AT=380.05n

.meas tran vdout0_14ck370 FIND v(dout0_14) AT=380.05n

.meas tran vdout0_15ck370 FIND v(dout0_15) AT=380.05n

.meas tran vdout0_16ck370 FIND v(dout0_16) AT=380.05n

.meas tran vdout0_17ck370 FIND v(dout0_17) AT=380.05n

.meas tran vdout0_18ck370 FIND v(dout0_18) AT=380.05n

.meas tran vdout0_19ck370 FIND v(dout0_19) AT=380.05n

.meas tran vdout0_20ck370 FIND v(dout0_20) AT=380.05n

.meas tran vdout0_21ck370 FIND v(dout0_21) AT=380.05n

.meas tran vdout0_22ck370 FIND v(dout0_22) AT=380.05n

.meas tran vdout0_23ck370 FIND v(dout0_23) AT=380.05n

.meas tran vdout0_24ck370 FIND v(dout0_24) AT=380.05n

.meas tran vdout0_25ck370 FIND v(dout0_25) AT=380.05n

.meas tran vdout0_26ck370 FIND v(dout0_26) AT=380.05n

.meas tran vdout0_27ck370 FIND v(dout0_27) AT=380.05n

.meas tran vdout0_28ck370 FIND v(dout0_28) AT=380.05n

.meas tran vdout0_29ck370 FIND v(dout0_29) AT=380.05n

.meas tran vdout0_30ck370 FIND v(dout0_30) AT=380.05n

.meas tran vdout0_31ck370 FIND v(dout0_31) AT=380.05n

.meas tran vdout0_32ck370 FIND v(dout0_32) AT=380.05n

.meas tran vdout0_0ck380 FIND v(dout0_0) AT=390.05n

.meas tran vdout0_1ck380 FIND v(dout0_1) AT=390.05n

.meas tran vdout0_2ck380 FIND v(dout0_2) AT=390.05n

.meas tran vdout0_3ck380 FIND v(dout0_3) AT=390.05n

.meas tran vdout0_4ck380 FIND v(dout0_4) AT=390.05n

.meas tran vdout0_5ck380 FIND v(dout0_5) AT=390.05n

.meas tran vdout0_6ck380 FIND v(dout0_6) AT=390.05n

.meas tran vdout0_7ck380 FIND v(dout0_7) AT=390.05n

.meas tran vdout0_8ck380 FIND v(dout0_8) AT=390.05n

.meas tran vdout0_9ck380 FIND v(dout0_9) AT=390.05n

.meas tran vdout0_10ck380 FIND v(dout0_10) AT=390.05n

.meas tran vdout0_11ck380 FIND v(dout0_11) AT=390.05n

.meas tran vdout0_12ck380 FIND v(dout0_12) AT=390.05n

.meas tran vdout0_13ck380 FIND v(dout0_13) AT=390.05n

.meas tran vdout0_14ck380 FIND v(dout0_14) AT=390.05n

.meas tran vdout0_15ck380 FIND v(dout0_15) AT=390.05n

.meas tran vdout0_16ck380 FIND v(dout0_16) AT=390.05n

.meas tran vdout0_17ck380 FIND v(dout0_17) AT=390.05n

.meas tran vdout0_18ck380 FIND v(dout0_18) AT=390.05n

.meas tran vdout0_19ck380 FIND v(dout0_19) AT=390.05n

.meas tran vdout0_20ck380 FIND v(dout0_20) AT=390.05n

.meas tran vdout0_21ck380 FIND v(dout0_21) AT=390.05n

.meas tran vdout0_22ck380 FIND v(dout0_22) AT=390.05n

.meas tran vdout0_23ck380 FIND v(dout0_23) AT=390.05n

.meas tran vdout0_24ck380 FIND v(dout0_24) AT=390.05n

.meas tran vdout0_25ck380 FIND v(dout0_25) AT=390.05n

.meas tran vdout0_26ck380 FIND v(dout0_26) AT=390.05n

.meas tran vdout0_27ck380 FIND v(dout0_27) AT=390.05n

.meas tran vdout0_28ck380 FIND v(dout0_28) AT=390.05n

.meas tran vdout0_29ck380 FIND v(dout0_29) AT=390.05n

.meas tran vdout0_30ck380 FIND v(dout0_30) AT=390.05n

.meas tran vdout0_31ck380 FIND v(dout0_31) AT=390.05n

.meas tran vdout0_32ck380 FIND v(dout0_32) AT=390.05n

.meas tran vdout0_0ck390 FIND v(dout0_0) AT=400.05n

.meas tran vdout0_1ck390 FIND v(dout0_1) AT=400.05n

.meas tran vdout0_2ck390 FIND v(dout0_2) AT=400.05n

.meas tran vdout0_3ck390 FIND v(dout0_3) AT=400.05n

.meas tran vdout0_4ck390 FIND v(dout0_4) AT=400.05n

.meas tran vdout0_5ck390 FIND v(dout0_5) AT=400.05n

.meas tran vdout0_6ck390 FIND v(dout0_6) AT=400.05n

.meas tran vdout0_7ck390 FIND v(dout0_7) AT=400.05n

.meas tran vdout0_8ck390 FIND v(dout0_8) AT=400.05n

.meas tran vdout0_9ck390 FIND v(dout0_9) AT=400.05n

.meas tran vdout0_10ck390 FIND v(dout0_10) AT=400.05n

.meas tran vdout0_11ck390 FIND v(dout0_11) AT=400.05n

.meas tran vdout0_12ck390 FIND v(dout0_12) AT=400.05n

.meas tran vdout0_13ck390 FIND v(dout0_13) AT=400.05n

.meas tran vdout0_14ck390 FIND v(dout0_14) AT=400.05n

.meas tran vdout0_15ck390 FIND v(dout0_15) AT=400.05n

.meas tran vdout0_16ck390 FIND v(dout0_16) AT=400.05n

.meas tran vdout0_17ck390 FIND v(dout0_17) AT=400.05n

.meas tran vdout0_18ck390 FIND v(dout0_18) AT=400.05n

.meas tran vdout0_19ck390 FIND v(dout0_19) AT=400.05n

.meas tran vdout0_20ck390 FIND v(dout0_20) AT=400.05n

.meas tran vdout0_21ck390 FIND v(dout0_21) AT=400.05n

.meas tran vdout0_22ck390 FIND v(dout0_22) AT=400.05n

.meas tran vdout0_23ck390 FIND v(dout0_23) AT=400.05n

.meas tran vdout0_24ck390 FIND v(dout0_24) AT=400.05n

.meas tran vdout0_25ck390 FIND v(dout0_25) AT=400.05n

.meas tran vdout0_26ck390 FIND v(dout0_26) AT=400.05n

.meas tran vdout0_27ck390 FIND v(dout0_27) AT=400.05n

.meas tran vdout0_28ck390 FIND v(dout0_28) AT=400.05n

.meas tran vdout0_29ck390 FIND v(dout0_29) AT=400.05n

.meas tran vdout0_30ck390 FIND v(dout0_30) AT=400.05n

.meas tran vdout0_31ck390 FIND v(dout0_31) AT=400.05n

.meas tran vdout0_32ck390 FIND v(dout0_32) AT=400.05n

.meas tran vdout0_0ck420 FIND v(dout0_0) AT=430.05n

.meas tran vdout0_1ck420 FIND v(dout0_1) AT=430.05n

.meas tran vdout0_2ck420 FIND v(dout0_2) AT=430.05n

.meas tran vdout0_3ck420 FIND v(dout0_3) AT=430.05n

.meas tran vdout0_4ck420 FIND v(dout0_4) AT=430.05n

.meas tran vdout0_5ck420 FIND v(dout0_5) AT=430.05n

.meas tran vdout0_6ck420 FIND v(dout0_6) AT=430.05n

.meas tran vdout0_7ck420 FIND v(dout0_7) AT=430.05n

.meas tran vdout0_8ck420 FIND v(dout0_8) AT=430.05n

.meas tran vdout0_9ck420 FIND v(dout0_9) AT=430.05n

.meas tran vdout0_10ck420 FIND v(dout0_10) AT=430.05n

.meas tran vdout0_11ck420 FIND v(dout0_11) AT=430.05n

.meas tran vdout0_12ck420 FIND v(dout0_12) AT=430.05n

.meas tran vdout0_13ck420 FIND v(dout0_13) AT=430.05n

.meas tran vdout0_14ck420 FIND v(dout0_14) AT=430.05n

.meas tran vdout0_15ck420 FIND v(dout0_15) AT=430.05n

.meas tran vdout0_16ck420 FIND v(dout0_16) AT=430.05n

.meas tran vdout0_17ck420 FIND v(dout0_17) AT=430.05n

.meas tran vdout0_18ck420 FIND v(dout0_18) AT=430.05n

.meas tran vdout0_19ck420 FIND v(dout0_19) AT=430.05n

.meas tran vdout0_20ck420 FIND v(dout0_20) AT=430.05n

.meas tran vdout0_21ck420 FIND v(dout0_21) AT=430.05n

.meas tran vdout0_22ck420 FIND v(dout0_22) AT=430.05n

.meas tran vdout0_23ck420 FIND v(dout0_23) AT=430.05n

.meas tran vdout0_24ck420 FIND v(dout0_24) AT=430.05n

.meas tran vdout0_25ck420 FIND v(dout0_25) AT=430.05n

.meas tran vdout0_26ck420 FIND v(dout0_26) AT=430.05n

.meas tran vdout0_27ck420 FIND v(dout0_27) AT=430.05n

.meas tran vdout0_28ck420 FIND v(dout0_28) AT=430.05n

.meas tran vdout0_29ck420 FIND v(dout0_29) AT=430.05n

.meas tran vdout0_30ck420 FIND v(dout0_30) AT=430.05n

.meas tran vdout0_31ck420 FIND v(dout0_31) AT=430.05n

.meas tran vdout0_32ck420 FIND v(dout0_32) AT=430.05n

.meas tran vdout0_0ck440 FIND v(dout0_0) AT=450.05n

.meas tran vdout0_1ck440 FIND v(dout0_1) AT=450.05n

.meas tran vdout0_2ck440 FIND v(dout0_2) AT=450.05n

.meas tran vdout0_3ck440 FIND v(dout0_3) AT=450.05n

.meas tran vdout0_4ck440 FIND v(dout0_4) AT=450.05n

.meas tran vdout0_5ck440 FIND v(dout0_5) AT=450.05n

.meas tran vdout0_6ck440 FIND v(dout0_6) AT=450.05n

.meas tran vdout0_7ck440 FIND v(dout0_7) AT=450.05n

.meas tran vdout0_8ck440 FIND v(dout0_8) AT=450.05n

.meas tran vdout0_9ck440 FIND v(dout0_9) AT=450.05n

.meas tran vdout0_10ck440 FIND v(dout0_10) AT=450.05n

.meas tran vdout0_11ck440 FIND v(dout0_11) AT=450.05n

.meas tran vdout0_12ck440 FIND v(dout0_12) AT=450.05n

.meas tran vdout0_13ck440 FIND v(dout0_13) AT=450.05n

.meas tran vdout0_14ck440 FIND v(dout0_14) AT=450.05n

.meas tran vdout0_15ck440 FIND v(dout0_15) AT=450.05n

.meas tran vdout0_16ck440 FIND v(dout0_16) AT=450.05n

.meas tran vdout0_17ck440 FIND v(dout0_17) AT=450.05n

.meas tran vdout0_18ck440 FIND v(dout0_18) AT=450.05n

.meas tran vdout0_19ck440 FIND v(dout0_19) AT=450.05n

.meas tran vdout0_20ck440 FIND v(dout0_20) AT=450.05n

.meas tran vdout0_21ck440 FIND v(dout0_21) AT=450.05n

.meas tran vdout0_22ck440 FIND v(dout0_22) AT=450.05n

.meas tran vdout0_23ck440 FIND v(dout0_23) AT=450.05n

.meas tran vdout0_24ck440 FIND v(dout0_24) AT=450.05n

.meas tran vdout0_25ck440 FIND v(dout0_25) AT=450.05n

.meas tran vdout0_26ck440 FIND v(dout0_26) AT=450.05n

.meas tran vdout0_27ck440 FIND v(dout0_27) AT=450.05n

.meas tran vdout0_28ck440 FIND v(dout0_28) AT=450.05n

.meas tran vdout0_29ck440 FIND v(dout0_29) AT=450.05n

.meas tran vdout0_30ck440 FIND v(dout0_30) AT=450.05n

.meas tran vdout0_31ck440 FIND v(dout0_31) AT=450.05n

.meas tran vdout0_32ck440 FIND v(dout0_32) AT=450.05n

.meas tran vdout0_0ck450 FIND v(dout0_0) AT=460.05n

.meas tran vdout0_1ck450 FIND v(dout0_1) AT=460.05n

.meas tran vdout0_2ck450 FIND v(dout0_2) AT=460.05n

.meas tran vdout0_3ck450 FIND v(dout0_3) AT=460.05n

.meas tran vdout0_4ck450 FIND v(dout0_4) AT=460.05n

.meas tran vdout0_5ck450 FIND v(dout0_5) AT=460.05n

.meas tran vdout0_6ck450 FIND v(dout0_6) AT=460.05n

.meas tran vdout0_7ck450 FIND v(dout0_7) AT=460.05n

.meas tran vdout0_8ck450 FIND v(dout0_8) AT=460.05n

.meas tran vdout0_9ck450 FIND v(dout0_9) AT=460.05n

.meas tran vdout0_10ck450 FIND v(dout0_10) AT=460.05n

.meas tran vdout0_11ck450 FIND v(dout0_11) AT=460.05n

.meas tran vdout0_12ck450 FIND v(dout0_12) AT=460.05n

.meas tran vdout0_13ck450 FIND v(dout0_13) AT=460.05n

.meas tran vdout0_14ck450 FIND v(dout0_14) AT=460.05n

.meas tran vdout0_15ck450 FIND v(dout0_15) AT=460.05n

.meas tran vdout0_16ck450 FIND v(dout0_16) AT=460.05n

.meas tran vdout0_17ck450 FIND v(dout0_17) AT=460.05n

.meas tran vdout0_18ck450 FIND v(dout0_18) AT=460.05n

.meas tran vdout0_19ck450 FIND v(dout0_19) AT=460.05n

.meas tran vdout0_20ck450 FIND v(dout0_20) AT=460.05n

.meas tran vdout0_21ck450 FIND v(dout0_21) AT=460.05n

.meas tran vdout0_22ck450 FIND v(dout0_22) AT=460.05n

.meas tran vdout0_23ck450 FIND v(dout0_23) AT=460.05n

.meas tran vdout0_24ck450 FIND v(dout0_24) AT=460.05n

.meas tran vdout0_25ck450 FIND v(dout0_25) AT=460.05n

.meas tran vdout0_26ck450 FIND v(dout0_26) AT=460.05n

.meas tran vdout0_27ck450 FIND v(dout0_27) AT=460.05n

.meas tran vdout0_28ck450 FIND v(dout0_28) AT=460.05n

.meas tran vdout0_29ck450 FIND v(dout0_29) AT=460.05n

.meas tran vdout0_30ck450 FIND v(dout0_30) AT=460.05n

.meas tran vdout0_31ck450 FIND v(dout0_31) AT=460.05n

.meas tran vdout0_32ck450 FIND v(dout0_32) AT=460.05n

.meas tran vdout0_0ck460 FIND v(dout0_0) AT=470.05n

.meas tran vdout0_1ck460 FIND v(dout0_1) AT=470.05n

.meas tran vdout0_2ck460 FIND v(dout0_2) AT=470.05n

.meas tran vdout0_3ck460 FIND v(dout0_3) AT=470.05n

.meas tran vdout0_4ck460 FIND v(dout0_4) AT=470.05n

.meas tran vdout0_5ck460 FIND v(dout0_5) AT=470.05n

.meas tran vdout0_6ck460 FIND v(dout0_6) AT=470.05n

.meas tran vdout0_7ck460 FIND v(dout0_7) AT=470.05n

.meas tran vdout0_8ck460 FIND v(dout0_8) AT=470.05n

.meas tran vdout0_9ck460 FIND v(dout0_9) AT=470.05n

.meas tran vdout0_10ck460 FIND v(dout0_10) AT=470.05n

.meas tran vdout0_11ck460 FIND v(dout0_11) AT=470.05n

.meas tran vdout0_12ck460 FIND v(dout0_12) AT=470.05n

.meas tran vdout0_13ck460 FIND v(dout0_13) AT=470.05n

.meas tran vdout0_14ck460 FIND v(dout0_14) AT=470.05n

.meas tran vdout0_15ck460 FIND v(dout0_15) AT=470.05n

.meas tran vdout0_16ck460 FIND v(dout0_16) AT=470.05n

.meas tran vdout0_17ck460 FIND v(dout0_17) AT=470.05n

.meas tran vdout0_18ck460 FIND v(dout0_18) AT=470.05n

.meas tran vdout0_19ck460 FIND v(dout0_19) AT=470.05n

.meas tran vdout0_20ck460 FIND v(dout0_20) AT=470.05n

.meas tran vdout0_21ck460 FIND v(dout0_21) AT=470.05n

.meas tran vdout0_22ck460 FIND v(dout0_22) AT=470.05n

.meas tran vdout0_23ck460 FIND v(dout0_23) AT=470.05n

.meas tran vdout0_24ck460 FIND v(dout0_24) AT=470.05n

.meas tran vdout0_25ck460 FIND v(dout0_25) AT=470.05n

.meas tran vdout0_26ck460 FIND v(dout0_26) AT=470.05n

.meas tran vdout0_27ck460 FIND v(dout0_27) AT=470.05n

.meas tran vdout0_28ck460 FIND v(dout0_28) AT=470.05n

.meas tran vdout0_29ck460 FIND v(dout0_29) AT=470.05n

.meas tran vdout0_30ck460 FIND v(dout0_30) AT=470.05n

.meas tran vdout0_31ck460 FIND v(dout0_31) AT=470.05n

.meas tran vdout0_32ck460 FIND v(dout0_32) AT=470.05n

.meas tran vdout0_0ck480 FIND v(dout0_0) AT=490.05n

.meas tran vdout0_1ck480 FIND v(dout0_1) AT=490.05n

.meas tran vdout0_2ck480 FIND v(dout0_2) AT=490.05n

.meas tran vdout0_3ck480 FIND v(dout0_3) AT=490.05n

.meas tran vdout0_4ck480 FIND v(dout0_4) AT=490.05n

.meas tran vdout0_5ck480 FIND v(dout0_5) AT=490.05n

.meas tran vdout0_6ck480 FIND v(dout0_6) AT=490.05n

.meas tran vdout0_7ck480 FIND v(dout0_7) AT=490.05n

.meas tran vdout0_8ck480 FIND v(dout0_8) AT=490.05n

.meas tran vdout0_9ck480 FIND v(dout0_9) AT=490.05n

.meas tran vdout0_10ck480 FIND v(dout0_10) AT=490.05n

.meas tran vdout0_11ck480 FIND v(dout0_11) AT=490.05n

.meas tran vdout0_12ck480 FIND v(dout0_12) AT=490.05n

.meas tran vdout0_13ck480 FIND v(dout0_13) AT=490.05n

.meas tran vdout0_14ck480 FIND v(dout0_14) AT=490.05n

.meas tran vdout0_15ck480 FIND v(dout0_15) AT=490.05n

.meas tran vdout0_16ck480 FIND v(dout0_16) AT=490.05n

.meas tran vdout0_17ck480 FIND v(dout0_17) AT=490.05n

.meas tran vdout0_18ck480 FIND v(dout0_18) AT=490.05n

.meas tran vdout0_19ck480 FIND v(dout0_19) AT=490.05n

.meas tran vdout0_20ck480 FIND v(dout0_20) AT=490.05n

.meas tran vdout0_21ck480 FIND v(dout0_21) AT=490.05n

.meas tran vdout0_22ck480 FIND v(dout0_22) AT=490.05n

.meas tran vdout0_23ck480 FIND v(dout0_23) AT=490.05n

.meas tran vdout0_24ck480 FIND v(dout0_24) AT=490.05n

.meas tran vdout0_25ck480 FIND v(dout0_25) AT=490.05n

.meas tran vdout0_26ck480 FIND v(dout0_26) AT=490.05n

.meas tran vdout0_27ck480 FIND v(dout0_27) AT=490.05n

.meas tran vdout0_28ck480 FIND v(dout0_28) AT=490.05n

.meas tran vdout0_29ck480 FIND v(dout0_29) AT=490.05n

.meas tran vdout0_30ck480 FIND v(dout0_30) AT=490.05n

.meas tran vdout0_31ck480 FIND v(dout0_31) AT=490.05n

.meas tran vdout0_32ck480 FIND v(dout0_32) AT=490.05n

.meas tran vdout0_0ck570 FIND v(dout0_0) AT=580.05n

.meas tran vdout0_1ck570 FIND v(dout0_1) AT=580.05n

.meas tran vdout0_2ck570 FIND v(dout0_2) AT=580.05n

.meas tran vdout0_3ck570 FIND v(dout0_3) AT=580.05n

.meas tran vdout0_4ck570 FIND v(dout0_4) AT=580.05n

.meas tran vdout0_5ck570 FIND v(dout0_5) AT=580.05n

.meas tran vdout0_6ck570 FIND v(dout0_6) AT=580.05n

.meas tran vdout0_7ck570 FIND v(dout0_7) AT=580.05n

.meas tran vdout0_8ck570 FIND v(dout0_8) AT=580.05n

.meas tran vdout0_9ck570 FIND v(dout0_9) AT=580.05n

.meas tran vdout0_10ck570 FIND v(dout0_10) AT=580.05n

.meas tran vdout0_11ck570 FIND v(dout0_11) AT=580.05n

.meas tran vdout0_12ck570 FIND v(dout0_12) AT=580.05n

.meas tran vdout0_13ck570 FIND v(dout0_13) AT=580.05n

.meas tran vdout0_14ck570 FIND v(dout0_14) AT=580.05n

.meas tran vdout0_15ck570 FIND v(dout0_15) AT=580.05n

.meas tran vdout0_16ck570 FIND v(dout0_16) AT=580.05n

.meas tran vdout0_17ck570 FIND v(dout0_17) AT=580.05n

.meas tran vdout0_18ck570 FIND v(dout0_18) AT=580.05n

.meas tran vdout0_19ck570 FIND v(dout0_19) AT=580.05n

.meas tran vdout0_20ck570 FIND v(dout0_20) AT=580.05n

.meas tran vdout0_21ck570 FIND v(dout0_21) AT=580.05n

.meas tran vdout0_22ck570 FIND v(dout0_22) AT=580.05n

.meas tran vdout0_23ck570 FIND v(dout0_23) AT=580.05n

.meas tran vdout0_24ck570 FIND v(dout0_24) AT=580.05n

.meas tran vdout0_25ck570 FIND v(dout0_25) AT=580.05n

.meas tran vdout0_26ck570 FIND v(dout0_26) AT=580.05n

.meas tran vdout0_27ck570 FIND v(dout0_27) AT=580.05n

.meas tran vdout0_28ck570 FIND v(dout0_28) AT=580.05n

.meas tran vdout0_29ck570 FIND v(dout0_29) AT=580.05n

.meas tran vdout0_30ck570 FIND v(dout0_30) AT=580.05n

.meas tran vdout0_31ck570 FIND v(dout0_31) AT=580.05n

.meas tran vdout0_32ck570 FIND v(dout0_32) AT=580.05n

.meas tran vdout0_0ck590 FIND v(dout0_0) AT=600.05n

.meas tran vdout0_1ck590 FIND v(dout0_1) AT=600.05n

.meas tran vdout0_2ck590 FIND v(dout0_2) AT=600.05n

.meas tran vdout0_3ck590 FIND v(dout0_3) AT=600.05n

.meas tran vdout0_4ck590 FIND v(dout0_4) AT=600.05n

.meas tran vdout0_5ck590 FIND v(dout0_5) AT=600.05n

.meas tran vdout0_6ck590 FIND v(dout0_6) AT=600.05n

.meas tran vdout0_7ck590 FIND v(dout0_7) AT=600.05n

.meas tran vdout0_8ck590 FIND v(dout0_8) AT=600.05n

.meas tran vdout0_9ck590 FIND v(dout0_9) AT=600.05n

.meas tran vdout0_10ck590 FIND v(dout0_10) AT=600.05n

.meas tran vdout0_11ck590 FIND v(dout0_11) AT=600.05n

.meas tran vdout0_12ck590 FIND v(dout0_12) AT=600.05n

.meas tran vdout0_13ck590 FIND v(dout0_13) AT=600.05n

.meas tran vdout0_14ck590 FIND v(dout0_14) AT=600.05n

.meas tran vdout0_15ck590 FIND v(dout0_15) AT=600.05n

.meas tran vdout0_16ck590 FIND v(dout0_16) AT=600.05n

.meas tran vdout0_17ck590 FIND v(dout0_17) AT=600.05n

.meas tran vdout0_18ck590 FIND v(dout0_18) AT=600.05n

.meas tran vdout0_19ck590 FIND v(dout0_19) AT=600.05n

.meas tran vdout0_20ck590 FIND v(dout0_20) AT=600.05n

.meas tran vdout0_21ck590 FIND v(dout0_21) AT=600.05n

.meas tran vdout0_22ck590 FIND v(dout0_22) AT=600.05n

.meas tran vdout0_23ck590 FIND v(dout0_23) AT=600.05n

.meas tran vdout0_24ck590 FIND v(dout0_24) AT=600.05n

.meas tran vdout0_25ck590 FIND v(dout0_25) AT=600.05n

.meas tran vdout0_26ck590 FIND v(dout0_26) AT=600.05n

.meas tran vdout0_27ck590 FIND v(dout0_27) AT=600.05n

.meas tran vdout0_28ck590 FIND v(dout0_28) AT=600.05n

.meas tran vdout0_29ck590 FIND v(dout0_29) AT=600.05n

.meas tran vdout0_30ck590 FIND v(dout0_30) AT=600.05n

.meas tran vdout0_31ck590 FIND v(dout0_31) AT=600.05n

.meas tran vdout0_32ck590 FIND v(dout0_32) AT=600.05n

.meas tran vdout0_0ck600 FIND v(dout0_0) AT=610.05n

.meas tran vdout0_1ck600 FIND v(dout0_1) AT=610.05n

.meas tran vdout0_2ck600 FIND v(dout0_2) AT=610.05n

.meas tran vdout0_3ck600 FIND v(dout0_3) AT=610.05n

.meas tran vdout0_4ck600 FIND v(dout0_4) AT=610.05n

.meas tran vdout0_5ck600 FIND v(dout0_5) AT=610.05n

.meas tran vdout0_6ck600 FIND v(dout0_6) AT=610.05n

.meas tran vdout0_7ck600 FIND v(dout0_7) AT=610.05n

.meas tran vdout0_8ck600 FIND v(dout0_8) AT=610.05n

.meas tran vdout0_9ck600 FIND v(dout0_9) AT=610.05n

.meas tran vdout0_10ck600 FIND v(dout0_10) AT=610.05n

.meas tran vdout0_11ck600 FIND v(dout0_11) AT=610.05n

.meas tran vdout0_12ck600 FIND v(dout0_12) AT=610.05n

.meas tran vdout0_13ck600 FIND v(dout0_13) AT=610.05n

.meas tran vdout0_14ck600 FIND v(dout0_14) AT=610.05n

.meas tran vdout0_15ck600 FIND v(dout0_15) AT=610.05n

.meas tran vdout0_16ck600 FIND v(dout0_16) AT=610.05n

.meas tran vdout0_17ck600 FIND v(dout0_17) AT=610.05n

.meas tran vdout0_18ck600 FIND v(dout0_18) AT=610.05n

.meas tran vdout0_19ck600 FIND v(dout0_19) AT=610.05n

.meas tran vdout0_20ck600 FIND v(dout0_20) AT=610.05n

.meas tran vdout0_21ck600 FIND v(dout0_21) AT=610.05n

.meas tran vdout0_22ck600 FIND v(dout0_22) AT=610.05n

.meas tran vdout0_23ck600 FIND v(dout0_23) AT=610.05n

.meas tran vdout0_24ck600 FIND v(dout0_24) AT=610.05n

.meas tran vdout0_25ck600 FIND v(dout0_25) AT=610.05n

.meas tran vdout0_26ck600 FIND v(dout0_26) AT=610.05n

.meas tran vdout0_27ck600 FIND v(dout0_27) AT=610.05n

.meas tran vdout0_28ck600 FIND v(dout0_28) AT=610.05n

.meas tran vdout0_29ck600 FIND v(dout0_29) AT=610.05n

.meas tran vdout0_30ck600 FIND v(dout0_30) AT=610.05n

.meas tran vdout0_31ck600 FIND v(dout0_31) AT=610.05n

.meas tran vdout0_32ck600 FIND v(dout0_32) AT=610.05n

.meas tran vdout0_0ck630 FIND v(dout0_0) AT=640.05n

.meas tran vdout0_1ck630 FIND v(dout0_1) AT=640.05n

.meas tran vdout0_2ck630 FIND v(dout0_2) AT=640.05n

.meas tran vdout0_3ck630 FIND v(dout0_3) AT=640.05n

.meas tran vdout0_4ck630 FIND v(dout0_4) AT=640.05n

.meas tran vdout0_5ck630 FIND v(dout0_5) AT=640.05n

.meas tran vdout0_6ck630 FIND v(dout0_6) AT=640.05n

.meas tran vdout0_7ck630 FIND v(dout0_7) AT=640.05n

.meas tran vdout0_8ck630 FIND v(dout0_8) AT=640.05n

.meas tran vdout0_9ck630 FIND v(dout0_9) AT=640.05n

.meas tran vdout0_10ck630 FIND v(dout0_10) AT=640.05n

.meas tran vdout0_11ck630 FIND v(dout0_11) AT=640.05n

.meas tran vdout0_12ck630 FIND v(dout0_12) AT=640.05n

.meas tran vdout0_13ck630 FIND v(dout0_13) AT=640.05n

.meas tran vdout0_14ck630 FIND v(dout0_14) AT=640.05n

.meas tran vdout0_15ck630 FIND v(dout0_15) AT=640.05n

.meas tran vdout0_16ck630 FIND v(dout0_16) AT=640.05n

.meas tran vdout0_17ck630 FIND v(dout0_17) AT=640.05n

.meas tran vdout0_18ck630 FIND v(dout0_18) AT=640.05n

.meas tran vdout0_19ck630 FIND v(dout0_19) AT=640.05n

.meas tran vdout0_20ck630 FIND v(dout0_20) AT=640.05n

.meas tran vdout0_21ck630 FIND v(dout0_21) AT=640.05n

.meas tran vdout0_22ck630 FIND v(dout0_22) AT=640.05n

.meas tran vdout0_23ck630 FIND v(dout0_23) AT=640.05n

.meas tran vdout0_24ck630 FIND v(dout0_24) AT=640.05n

.meas tran vdout0_25ck630 FIND v(dout0_25) AT=640.05n

.meas tran vdout0_26ck630 FIND v(dout0_26) AT=640.05n

.meas tran vdout0_27ck630 FIND v(dout0_27) AT=640.05n

.meas tran vdout0_28ck630 FIND v(dout0_28) AT=640.05n

.meas tran vdout0_29ck630 FIND v(dout0_29) AT=640.05n

.meas tran vdout0_30ck630 FIND v(dout0_30) AT=640.05n

.meas tran vdout0_31ck630 FIND v(dout0_31) AT=640.05n

.meas tran vdout0_32ck630 FIND v(dout0_32) AT=640.05n

.meas tran vdout0_0ck640 FIND v(dout0_0) AT=650.05n

.meas tran vdout0_1ck640 FIND v(dout0_1) AT=650.05n

.meas tran vdout0_2ck640 FIND v(dout0_2) AT=650.05n

.meas tran vdout0_3ck640 FIND v(dout0_3) AT=650.05n

.meas tran vdout0_4ck640 FIND v(dout0_4) AT=650.05n

.meas tran vdout0_5ck640 FIND v(dout0_5) AT=650.05n

.meas tran vdout0_6ck640 FIND v(dout0_6) AT=650.05n

.meas tran vdout0_7ck640 FIND v(dout0_7) AT=650.05n

.meas tran vdout0_8ck640 FIND v(dout0_8) AT=650.05n

.meas tran vdout0_9ck640 FIND v(dout0_9) AT=650.05n

.meas tran vdout0_10ck640 FIND v(dout0_10) AT=650.05n

.meas tran vdout0_11ck640 FIND v(dout0_11) AT=650.05n

.meas tran vdout0_12ck640 FIND v(dout0_12) AT=650.05n

.meas tran vdout0_13ck640 FIND v(dout0_13) AT=650.05n

.meas tran vdout0_14ck640 FIND v(dout0_14) AT=650.05n

.meas tran vdout0_15ck640 FIND v(dout0_15) AT=650.05n

.meas tran vdout0_16ck640 FIND v(dout0_16) AT=650.05n

.meas tran vdout0_17ck640 FIND v(dout0_17) AT=650.05n

.meas tran vdout0_18ck640 FIND v(dout0_18) AT=650.05n

.meas tran vdout0_19ck640 FIND v(dout0_19) AT=650.05n

.meas tran vdout0_20ck640 FIND v(dout0_20) AT=650.05n

.meas tran vdout0_21ck640 FIND v(dout0_21) AT=650.05n

.meas tran vdout0_22ck640 FIND v(dout0_22) AT=650.05n

.meas tran vdout0_23ck640 FIND v(dout0_23) AT=650.05n

.meas tran vdout0_24ck640 FIND v(dout0_24) AT=650.05n

.meas tran vdout0_25ck640 FIND v(dout0_25) AT=650.05n

.meas tran vdout0_26ck640 FIND v(dout0_26) AT=650.05n

.meas tran vdout0_27ck640 FIND v(dout0_27) AT=650.05n

.meas tran vdout0_28ck640 FIND v(dout0_28) AT=650.05n

.meas tran vdout0_29ck640 FIND v(dout0_29) AT=650.05n

.meas tran vdout0_30ck640 FIND v(dout0_30) AT=650.05n

.meas tran vdout0_31ck640 FIND v(dout0_31) AT=650.05n

.meas tran vdout0_32ck640 FIND v(dout0_32) AT=650.05n

.meas tran vdout0_0ck670 FIND v(dout0_0) AT=680.05n

.meas tran vdout0_1ck670 FIND v(dout0_1) AT=680.05n

.meas tran vdout0_2ck670 FIND v(dout0_2) AT=680.05n

.meas tran vdout0_3ck670 FIND v(dout0_3) AT=680.05n

.meas tran vdout0_4ck670 FIND v(dout0_4) AT=680.05n

.meas tran vdout0_5ck670 FIND v(dout0_5) AT=680.05n

.meas tran vdout0_6ck670 FIND v(dout0_6) AT=680.05n

.meas tran vdout0_7ck670 FIND v(dout0_7) AT=680.05n

.meas tran vdout0_8ck670 FIND v(dout0_8) AT=680.05n

.meas tran vdout0_9ck670 FIND v(dout0_9) AT=680.05n

.meas tran vdout0_10ck670 FIND v(dout0_10) AT=680.05n

.meas tran vdout0_11ck670 FIND v(dout0_11) AT=680.05n

.meas tran vdout0_12ck670 FIND v(dout0_12) AT=680.05n

.meas tran vdout0_13ck670 FIND v(dout0_13) AT=680.05n

.meas tran vdout0_14ck670 FIND v(dout0_14) AT=680.05n

.meas tran vdout0_15ck670 FIND v(dout0_15) AT=680.05n

.meas tran vdout0_16ck670 FIND v(dout0_16) AT=680.05n

.meas tran vdout0_17ck670 FIND v(dout0_17) AT=680.05n

.meas tran vdout0_18ck670 FIND v(dout0_18) AT=680.05n

.meas tran vdout0_19ck670 FIND v(dout0_19) AT=680.05n

.meas tran vdout0_20ck670 FIND v(dout0_20) AT=680.05n

.meas tran vdout0_21ck670 FIND v(dout0_21) AT=680.05n

.meas tran vdout0_22ck670 FIND v(dout0_22) AT=680.05n

.meas tran vdout0_23ck670 FIND v(dout0_23) AT=680.05n

.meas tran vdout0_24ck670 FIND v(dout0_24) AT=680.05n

.meas tran vdout0_25ck670 FIND v(dout0_25) AT=680.05n

.meas tran vdout0_26ck670 FIND v(dout0_26) AT=680.05n

.meas tran vdout0_27ck670 FIND v(dout0_27) AT=680.05n

.meas tran vdout0_28ck670 FIND v(dout0_28) AT=680.05n

.meas tran vdout0_29ck670 FIND v(dout0_29) AT=680.05n

.meas tran vdout0_30ck670 FIND v(dout0_30) AT=680.05n

.meas tran vdout0_31ck670 FIND v(dout0_31) AT=680.05n

.meas tran vdout0_32ck670 FIND v(dout0_32) AT=680.05n

.meas tran vdout0_0ck690 FIND v(dout0_0) AT=700.05n

.meas tran vdout0_1ck690 FIND v(dout0_1) AT=700.05n

.meas tran vdout0_2ck690 FIND v(dout0_2) AT=700.05n

.meas tran vdout0_3ck690 FIND v(dout0_3) AT=700.05n

.meas tran vdout0_4ck690 FIND v(dout0_4) AT=700.05n

.meas tran vdout0_5ck690 FIND v(dout0_5) AT=700.05n

.meas tran vdout0_6ck690 FIND v(dout0_6) AT=700.05n

.meas tran vdout0_7ck690 FIND v(dout0_7) AT=700.05n

.meas tran vdout0_8ck690 FIND v(dout0_8) AT=700.05n

.meas tran vdout0_9ck690 FIND v(dout0_9) AT=700.05n

.meas tran vdout0_10ck690 FIND v(dout0_10) AT=700.05n

.meas tran vdout0_11ck690 FIND v(dout0_11) AT=700.05n

.meas tran vdout0_12ck690 FIND v(dout0_12) AT=700.05n

.meas tran vdout0_13ck690 FIND v(dout0_13) AT=700.05n

.meas tran vdout0_14ck690 FIND v(dout0_14) AT=700.05n

.meas tran vdout0_15ck690 FIND v(dout0_15) AT=700.05n

.meas tran vdout0_16ck690 FIND v(dout0_16) AT=700.05n

.meas tran vdout0_17ck690 FIND v(dout0_17) AT=700.05n

.meas tran vdout0_18ck690 FIND v(dout0_18) AT=700.05n

.meas tran vdout0_19ck690 FIND v(dout0_19) AT=700.05n

.meas tran vdout0_20ck690 FIND v(dout0_20) AT=700.05n

.meas tran vdout0_21ck690 FIND v(dout0_21) AT=700.05n

.meas tran vdout0_22ck690 FIND v(dout0_22) AT=700.05n

.meas tran vdout0_23ck690 FIND v(dout0_23) AT=700.05n

.meas tran vdout0_24ck690 FIND v(dout0_24) AT=700.05n

.meas tran vdout0_25ck690 FIND v(dout0_25) AT=700.05n

.meas tran vdout0_26ck690 FIND v(dout0_26) AT=700.05n

.meas tran vdout0_27ck690 FIND v(dout0_27) AT=700.05n

.meas tran vdout0_28ck690 FIND v(dout0_28) AT=700.05n

.meas tran vdout0_29ck690 FIND v(dout0_29) AT=700.05n

.meas tran vdout0_30ck690 FIND v(dout0_30) AT=700.05n

.meas tran vdout0_31ck690 FIND v(dout0_31) AT=700.05n

.meas tran vdout0_32ck690 FIND v(dout0_32) AT=700.05n

.meas tran vdout0_0ck720 FIND v(dout0_0) AT=730.05n

.meas tran vdout0_1ck720 FIND v(dout0_1) AT=730.05n

.meas tran vdout0_2ck720 FIND v(dout0_2) AT=730.05n

.meas tran vdout0_3ck720 FIND v(dout0_3) AT=730.05n

.meas tran vdout0_4ck720 FIND v(dout0_4) AT=730.05n

.meas tran vdout0_5ck720 FIND v(dout0_5) AT=730.05n

.meas tran vdout0_6ck720 FIND v(dout0_6) AT=730.05n

.meas tran vdout0_7ck720 FIND v(dout0_7) AT=730.05n

.meas tran vdout0_8ck720 FIND v(dout0_8) AT=730.05n

.meas tran vdout0_9ck720 FIND v(dout0_9) AT=730.05n

.meas tran vdout0_10ck720 FIND v(dout0_10) AT=730.05n

.meas tran vdout0_11ck720 FIND v(dout0_11) AT=730.05n

.meas tran vdout0_12ck720 FIND v(dout0_12) AT=730.05n

.meas tran vdout0_13ck720 FIND v(dout0_13) AT=730.05n

.meas tran vdout0_14ck720 FIND v(dout0_14) AT=730.05n

.meas tran vdout0_15ck720 FIND v(dout0_15) AT=730.05n

.meas tran vdout0_16ck720 FIND v(dout0_16) AT=730.05n

.meas tran vdout0_17ck720 FIND v(dout0_17) AT=730.05n

.meas tran vdout0_18ck720 FIND v(dout0_18) AT=730.05n

.meas tran vdout0_19ck720 FIND v(dout0_19) AT=730.05n

.meas tran vdout0_20ck720 FIND v(dout0_20) AT=730.05n

.meas tran vdout0_21ck720 FIND v(dout0_21) AT=730.05n

.meas tran vdout0_22ck720 FIND v(dout0_22) AT=730.05n

.meas tran vdout0_23ck720 FIND v(dout0_23) AT=730.05n

.meas tran vdout0_24ck720 FIND v(dout0_24) AT=730.05n

.meas tran vdout0_25ck720 FIND v(dout0_25) AT=730.05n

.meas tran vdout0_26ck720 FIND v(dout0_26) AT=730.05n

.meas tran vdout0_27ck720 FIND v(dout0_27) AT=730.05n

.meas tran vdout0_28ck720 FIND v(dout0_28) AT=730.05n

.meas tran vdout0_29ck720 FIND v(dout0_29) AT=730.05n

.meas tran vdout0_30ck720 FIND v(dout0_30) AT=730.05n

.meas tran vdout0_31ck720 FIND v(dout0_31) AT=730.05n

.meas tran vdout0_32ck720 FIND v(dout0_32) AT=730.05n

.meas tran vdout0_0ck730 FIND v(dout0_0) AT=740.05n

.meas tran vdout0_1ck730 FIND v(dout0_1) AT=740.05n

.meas tran vdout0_2ck730 FIND v(dout0_2) AT=740.05n

.meas tran vdout0_3ck730 FIND v(dout0_3) AT=740.05n

.meas tran vdout0_4ck730 FIND v(dout0_4) AT=740.05n

.meas tran vdout0_5ck730 FIND v(dout0_5) AT=740.05n

.meas tran vdout0_6ck730 FIND v(dout0_6) AT=740.05n

.meas tran vdout0_7ck730 FIND v(dout0_7) AT=740.05n

.meas tran vdout0_8ck730 FIND v(dout0_8) AT=740.05n

.meas tran vdout0_9ck730 FIND v(dout0_9) AT=740.05n

.meas tran vdout0_10ck730 FIND v(dout0_10) AT=740.05n

.meas tran vdout0_11ck730 FIND v(dout0_11) AT=740.05n

.meas tran vdout0_12ck730 FIND v(dout0_12) AT=740.05n

.meas tran vdout0_13ck730 FIND v(dout0_13) AT=740.05n

.meas tran vdout0_14ck730 FIND v(dout0_14) AT=740.05n

.meas tran vdout0_15ck730 FIND v(dout0_15) AT=740.05n

.meas tran vdout0_16ck730 FIND v(dout0_16) AT=740.05n

.meas tran vdout0_17ck730 FIND v(dout0_17) AT=740.05n

.meas tran vdout0_18ck730 FIND v(dout0_18) AT=740.05n

.meas tran vdout0_19ck730 FIND v(dout0_19) AT=740.05n

.meas tran vdout0_20ck730 FIND v(dout0_20) AT=740.05n

.meas tran vdout0_21ck730 FIND v(dout0_21) AT=740.05n

.meas tran vdout0_22ck730 FIND v(dout0_22) AT=740.05n

.meas tran vdout0_23ck730 FIND v(dout0_23) AT=740.05n

.meas tran vdout0_24ck730 FIND v(dout0_24) AT=740.05n

.meas tran vdout0_25ck730 FIND v(dout0_25) AT=740.05n

.meas tran vdout0_26ck730 FIND v(dout0_26) AT=740.05n

.meas tran vdout0_27ck730 FIND v(dout0_27) AT=740.05n

.meas tran vdout0_28ck730 FIND v(dout0_28) AT=740.05n

.meas tran vdout0_29ck730 FIND v(dout0_29) AT=740.05n

.meas tran vdout0_30ck730 FIND v(dout0_30) AT=740.05n

.meas tran vdout0_31ck730 FIND v(dout0_31) AT=740.05n

.meas tran vdout0_32ck730 FIND v(dout0_32) AT=740.05n

.meas tran vdout0_0ck810 FIND v(dout0_0) AT=820.05n

.meas tran vdout0_1ck810 FIND v(dout0_1) AT=820.05n

.meas tran vdout0_2ck810 FIND v(dout0_2) AT=820.05n

.meas tran vdout0_3ck810 FIND v(dout0_3) AT=820.05n

.meas tran vdout0_4ck810 FIND v(dout0_4) AT=820.05n

.meas tran vdout0_5ck810 FIND v(dout0_5) AT=820.05n

.meas tran vdout0_6ck810 FIND v(dout0_6) AT=820.05n

.meas tran vdout0_7ck810 FIND v(dout0_7) AT=820.05n

.meas tran vdout0_8ck810 FIND v(dout0_8) AT=820.05n

.meas tran vdout0_9ck810 FIND v(dout0_9) AT=820.05n

.meas tran vdout0_10ck810 FIND v(dout0_10) AT=820.05n

.meas tran vdout0_11ck810 FIND v(dout0_11) AT=820.05n

.meas tran vdout0_12ck810 FIND v(dout0_12) AT=820.05n

.meas tran vdout0_13ck810 FIND v(dout0_13) AT=820.05n

.meas tran vdout0_14ck810 FIND v(dout0_14) AT=820.05n

.meas tran vdout0_15ck810 FIND v(dout0_15) AT=820.05n

.meas tran vdout0_16ck810 FIND v(dout0_16) AT=820.05n

.meas tran vdout0_17ck810 FIND v(dout0_17) AT=820.05n

.meas tran vdout0_18ck810 FIND v(dout0_18) AT=820.05n

.meas tran vdout0_19ck810 FIND v(dout0_19) AT=820.05n

.meas tran vdout0_20ck810 FIND v(dout0_20) AT=820.05n

.meas tran vdout0_21ck810 FIND v(dout0_21) AT=820.05n

.meas tran vdout0_22ck810 FIND v(dout0_22) AT=820.05n

.meas tran vdout0_23ck810 FIND v(dout0_23) AT=820.05n

.meas tran vdout0_24ck810 FIND v(dout0_24) AT=820.05n

.meas tran vdout0_25ck810 FIND v(dout0_25) AT=820.05n

.meas tran vdout0_26ck810 FIND v(dout0_26) AT=820.05n

.meas tran vdout0_27ck810 FIND v(dout0_27) AT=820.05n

.meas tran vdout0_28ck810 FIND v(dout0_28) AT=820.05n

.meas tran vdout0_29ck810 FIND v(dout0_29) AT=820.05n

.meas tran vdout0_30ck810 FIND v(dout0_30) AT=820.05n

.meas tran vdout0_31ck810 FIND v(dout0_31) AT=820.05n

.meas tran vdout0_32ck810 FIND v(dout0_32) AT=820.05n

.meas tran vdout0_0ck820 FIND v(dout0_0) AT=830.05n

.meas tran vdout0_1ck820 FIND v(dout0_1) AT=830.05n

.meas tran vdout0_2ck820 FIND v(dout0_2) AT=830.05n

.meas tran vdout0_3ck820 FIND v(dout0_3) AT=830.05n

.meas tran vdout0_4ck820 FIND v(dout0_4) AT=830.05n

.meas tran vdout0_5ck820 FIND v(dout0_5) AT=830.05n

.meas tran vdout0_6ck820 FIND v(dout0_6) AT=830.05n

.meas tran vdout0_7ck820 FIND v(dout0_7) AT=830.05n

.meas tran vdout0_8ck820 FIND v(dout0_8) AT=830.05n

.meas tran vdout0_9ck820 FIND v(dout0_9) AT=830.05n

.meas tran vdout0_10ck820 FIND v(dout0_10) AT=830.05n

.meas tran vdout0_11ck820 FIND v(dout0_11) AT=830.05n

.meas tran vdout0_12ck820 FIND v(dout0_12) AT=830.05n

.meas tran vdout0_13ck820 FIND v(dout0_13) AT=830.05n

.meas tran vdout0_14ck820 FIND v(dout0_14) AT=830.05n

.meas tran vdout0_15ck820 FIND v(dout0_15) AT=830.05n

.meas tran vdout0_16ck820 FIND v(dout0_16) AT=830.05n

.meas tran vdout0_17ck820 FIND v(dout0_17) AT=830.05n

.meas tran vdout0_18ck820 FIND v(dout0_18) AT=830.05n

.meas tran vdout0_19ck820 FIND v(dout0_19) AT=830.05n

.meas tran vdout0_20ck820 FIND v(dout0_20) AT=830.05n

.meas tran vdout0_21ck820 FIND v(dout0_21) AT=830.05n

.meas tran vdout0_22ck820 FIND v(dout0_22) AT=830.05n

.meas tran vdout0_23ck820 FIND v(dout0_23) AT=830.05n

.meas tran vdout0_24ck820 FIND v(dout0_24) AT=830.05n

.meas tran vdout0_25ck820 FIND v(dout0_25) AT=830.05n

.meas tran vdout0_26ck820 FIND v(dout0_26) AT=830.05n

.meas tran vdout0_27ck820 FIND v(dout0_27) AT=830.05n

.meas tran vdout0_28ck820 FIND v(dout0_28) AT=830.05n

.meas tran vdout0_29ck820 FIND v(dout0_29) AT=830.05n

.meas tran vdout0_30ck820 FIND v(dout0_30) AT=830.05n

.meas tran vdout0_31ck820 FIND v(dout0_31) AT=830.05n

.meas tran vdout0_32ck820 FIND v(dout0_32) AT=830.05n

.meas tran vdout0_0ck840 FIND v(dout0_0) AT=850.05n

.meas tran vdout0_1ck840 FIND v(dout0_1) AT=850.05n

.meas tran vdout0_2ck840 FIND v(dout0_2) AT=850.05n

.meas tran vdout0_3ck840 FIND v(dout0_3) AT=850.05n

.meas tran vdout0_4ck840 FIND v(dout0_4) AT=850.05n

.meas tran vdout0_5ck840 FIND v(dout0_5) AT=850.05n

.meas tran vdout0_6ck840 FIND v(dout0_6) AT=850.05n

.meas tran vdout0_7ck840 FIND v(dout0_7) AT=850.05n

.meas tran vdout0_8ck840 FIND v(dout0_8) AT=850.05n

.meas tran vdout0_9ck840 FIND v(dout0_9) AT=850.05n

.meas tran vdout0_10ck840 FIND v(dout0_10) AT=850.05n

.meas tran vdout0_11ck840 FIND v(dout0_11) AT=850.05n

.meas tran vdout0_12ck840 FIND v(dout0_12) AT=850.05n

.meas tran vdout0_13ck840 FIND v(dout0_13) AT=850.05n

.meas tran vdout0_14ck840 FIND v(dout0_14) AT=850.05n

.meas tran vdout0_15ck840 FIND v(dout0_15) AT=850.05n

.meas tran vdout0_16ck840 FIND v(dout0_16) AT=850.05n

.meas tran vdout0_17ck840 FIND v(dout0_17) AT=850.05n

.meas tran vdout0_18ck840 FIND v(dout0_18) AT=850.05n

.meas tran vdout0_19ck840 FIND v(dout0_19) AT=850.05n

.meas tran vdout0_20ck840 FIND v(dout0_20) AT=850.05n

.meas tran vdout0_21ck840 FIND v(dout0_21) AT=850.05n

.meas tran vdout0_22ck840 FIND v(dout0_22) AT=850.05n

.meas tran vdout0_23ck840 FIND v(dout0_23) AT=850.05n

.meas tran vdout0_24ck840 FIND v(dout0_24) AT=850.05n

.meas tran vdout0_25ck840 FIND v(dout0_25) AT=850.05n

.meas tran vdout0_26ck840 FIND v(dout0_26) AT=850.05n

.meas tran vdout0_27ck840 FIND v(dout0_27) AT=850.05n

.meas tran vdout0_28ck840 FIND v(dout0_28) AT=850.05n

.meas tran vdout0_29ck840 FIND v(dout0_29) AT=850.05n

.meas tran vdout0_30ck840 FIND v(dout0_30) AT=850.05n

.meas tran vdout0_31ck840 FIND v(dout0_31) AT=850.05n

.meas tran vdout0_32ck840 FIND v(dout0_32) AT=850.05n

.meas tran vdout0_0ck850 FIND v(dout0_0) AT=860.05n

.meas tran vdout0_1ck850 FIND v(dout0_1) AT=860.05n

.meas tran vdout0_2ck850 FIND v(dout0_2) AT=860.05n

.meas tran vdout0_3ck850 FIND v(dout0_3) AT=860.05n

.meas tran vdout0_4ck850 FIND v(dout0_4) AT=860.05n

.meas tran vdout0_5ck850 FIND v(dout0_5) AT=860.05n

.meas tran vdout0_6ck850 FIND v(dout0_6) AT=860.05n

.meas tran vdout0_7ck850 FIND v(dout0_7) AT=860.05n

.meas tran vdout0_8ck850 FIND v(dout0_8) AT=860.05n

.meas tran vdout0_9ck850 FIND v(dout0_9) AT=860.05n

.meas tran vdout0_10ck850 FIND v(dout0_10) AT=860.05n

.meas tran vdout0_11ck850 FIND v(dout0_11) AT=860.05n

.meas tran vdout0_12ck850 FIND v(dout0_12) AT=860.05n

.meas tran vdout0_13ck850 FIND v(dout0_13) AT=860.05n

.meas tran vdout0_14ck850 FIND v(dout0_14) AT=860.05n

.meas tran vdout0_15ck850 FIND v(dout0_15) AT=860.05n

.meas tran vdout0_16ck850 FIND v(dout0_16) AT=860.05n

.meas tran vdout0_17ck850 FIND v(dout0_17) AT=860.05n

.meas tran vdout0_18ck850 FIND v(dout0_18) AT=860.05n

.meas tran vdout0_19ck850 FIND v(dout0_19) AT=860.05n

.meas tran vdout0_20ck850 FIND v(dout0_20) AT=860.05n

.meas tran vdout0_21ck850 FIND v(dout0_21) AT=860.05n

.meas tran vdout0_22ck850 FIND v(dout0_22) AT=860.05n

.meas tran vdout0_23ck850 FIND v(dout0_23) AT=860.05n

.meas tran vdout0_24ck850 FIND v(dout0_24) AT=860.05n

.meas tran vdout0_25ck850 FIND v(dout0_25) AT=860.05n

.meas tran vdout0_26ck850 FIND v(dout0_26) AT=860.05n

.meas tran vdout0_27ck850 FIND v(dout0_27) AT=860.05n

.meas tran vdout0_28ck850 FIND v(dout0_28) AT=860.05n

.meas tran vdout0_29ck850 FIND v(dout0_29) AT=860.05n

.meas tran vdout0_30ck850 FIND v(dout0_30) AT=860.05n

.meas tran vdout0_31ck850 FIND v(dout0_31) AT=860.05n

.meas tran vdout0_32ck850 FIND v(dout0_32) AT=860.05n

.meas tran vdout0_0ck930 FIND v(dout0_0) AT=940.05n

.meas tran vdout0_1ck930 FIND v(dout0_1) AT=940.05n

.meas tran vdout0_2ck930 FIND v(dout0_2) AT=940.05n

.meas tran vdout0_3ck930 FIND v(dout0_3) AT=940.05n

.meas tran vdout0_4ck930 FIND v(dout0_4) AT=940.05n

.meas tran vdout0_5ck930 FIND v(dout0_5) AT=940.05n

.meas tran vdout0_6ck930 FIND v(dout0_6) AT=940.05n

.meas tran vdout0_7ck930 FIND v(dout0_7) AT=940.05n

.meas tran vdout0_8ck930 FIND v(dout0_8) AT=940.05n

.meas tran vdout0_9ck930 FIND v(dout0_9) AT=940.05n

.meas tran vdout0_10ck930 FIND v(dout0_10) AT=940.05n

.meas tran vdout0_11ck930 FIND v(dout0_11) AT=940.05n

.meas tran vdout0_12ck930 FIND v(dout0_12) AT=940.05n

.meas tran vdout0_13ck930 FIND v(dout0_13) AT=940.05n

.meas tran vdout0_14ck930 FIND v(dout0_14) AT=940.05n

.meas tran vdout0_15ck930 FIND v(dout0_15) AT=940.05n

.meas tran vdout0_16ck930 FIND v(dout0_16) AT=940.05n

.meas tran vdout0_17ck930 FIND v(dout0_17) AT=940.05n

.meas tran vdout0_18ck930 FIND v(dout0_18) AT=940.05n

.meas tran vdout0_19ck930 FIND v(dout0_19) AT=940.05n

.meas tran vdout0_20ck930 FIND v(dout0_20) AT=940.05n

.meas tran vdout0_21ck930 FIND v(dout0_21) AT=940.05n

.meas tran vdout0_22ck930 FIND v(dout0_22) AT=940.05n

.meas tran vdout0_23ck930 FIND v(dout0_23) AT=940.05n

.meas tran vdout0_24ck930 FIND v(dout0_24) AT=940.05n

.meas tran vdout0_25ck930 FIND v(dout0_25) AT=940.05n

.meas tran vdout0_26ck930 FIND v(dout0_26) AT=940.05n

.meas tran vdout0_27ck930 FIND v(dout0_27) AT=940.05n

.meas tran vdout0_28ck930 FIND v(dout0_28) AT=940.05n

.meas tran vdout0_29ck930 FIND v(dout0_29) AT=940.05n

.meas tran vdout0_30ck930 FIND v(dout0_30) AT=940.05n

.meas tran vdout0_31ck930 FIND v(dout0_31) AT=940.05n

.meas tran vdout0_32ck930 FIND v(dout0_32) AT=940.05n

.meas tran vdout0_0ck950 FIND v(dout0_0) AT=960.05n

.meas tran vdout0_1ck950 FIND v(dout0_1) AT=960.05n

.meas tran vdout0_2ck950 FIND v(dout0_2) AT=960.05n

.meas tran vdout0_3ck950 FIND v(dout0_3) AT=960.05n

.meas tran vdout0_4ck950 FIND v(dout0_4) AT=960.05n

.meas tran vdout0_5ck950 FIND v(dout0_5) AT=960.05n

.meas tran vdout0_6ck950 FIND v(dout0_6) AT=960.05n

.meas tran vdout0_7ck950 FIND v(dout0_7) AT=960.05n

.meas tran vdout0_8ck950 FIND v(dout0_8) AT=960.05n

.meas tran vdout0_9ck950 FIND v(dout0_9) AT=960.05n

.meas tran vdout0_10ck950 FIND v(dout0_10) AT=960.05n

.meas tran vdout0_11ck950 FIND v(dout0_11) AT=960.05n

.meas tran vdout0_12ck950 FIND v(dout0_12) AT=960.05n

.meas tran vdout0_13ck950 FIND v(dout0_13) AT=960.05n

.meas tran vdout0_14ck950 FIND v(dout0_14) AT=960.05n

.meas tran vdout0_15ck950 FIND v(dout0_15) AT=960.05n

.meas tran vdout0_16ck950 FIND v(dout0_16) AT=960.05n

.meas tran vdout0_17ck950 FIND v(dout0_17) AT=960.05n

.meas tran vdout0_18ck950 FIND v(dout0_18) AT=960.05n

.meas tran vdout0_19ck950 FIND v(dout0_19) AT=960.05n

.meas tran vdout0_20ck950 FIND v(dout0_20) AT=960.05n

.meas tran vdout0_21ck950 FIND v(dout0_21) AT=960.05n

.meas tran vdout0_22ck950 FIND v(dout0_22) AT=960.05n

.meas tran vdout0_23ck950 FIND v(dout0_23) AT=960.05n

.meas tran vdout0_24ck950 FIND v(dout0_24) AT=960.05n

.meas tran vdout0_25ck950 FIND v(dout0_25) AT=960.05n

.meas tran vdout0_26ck950 FIND v(dout0_26) AT=960.05n

.meas tran vdout0_27ck950 FIND v(dout0_27) AT=960.05n

.meas tran vdout0_28ck950 FIND v(dout0_28) AT=960.05n

.meas tran vdout0_29ck950 FIND v(dout0_29) AT=960.05n

.meas tran vdout0_30ck950 FIND v(dout0_30) AT=960.05n

.meas tran vdout0_31ck950 FIND v(dout0_31) AT=960.05n

.meas tran vdout0_32ck950 FIND v(dout0_32) AT=960.05n

.meas tran vdout0_0ck960 FIND v(dout0_0) AT=970.05n

.meas tran vdout0_1ck960 FIND v(dout0_1) AT=970.05n

.meas tran vdout0_2ck960 FIND v(dout0_2) AT=970.05n

.meas tran vdout0_3ck960 FIND v(dout0_3) AT=970.05n

.meas tran vdout0_4ck960 FIND v(dout0_4) AT=970.05n

.meas tran vdout0_5ck960 FIND v(dout0_5) AT=970.05n

.meas tran vdout0_6ck960 FIND v(dout0_6) AT=970.05n

.meas tran vdout0_7ck960 FIND v(dout0_7) AT=970.05n

.meas tran vdout0_8ck960 FIND v(dout0_8) AT=970.05n

.meas tran vdout0_9ck960 FIND v(dout0_9) AT=970.05n

.meas tran vdout0_10ck960 FIND v(dout0_10) AT=970.05n

.meas tran vdout0_11ck960 FIND v(dout0_11) AT=970.05n

.meas tran vdout0_12ck960 FIND v(dout0_12) AT=970.05n

.meas tran vdout0_13ck960 FIND v(dout0_13) AT=970.05n

.meas tran vdout0_14ck960 FIND v(dout0_14) AT=970.05n

.meas tran vdout0_15ck960 FIND v(dout0_15) AT=970.05n

.meas tran vdout0_16ck960 FIND v(dout0_16) AT=970.05n

.meas tran vdout0_17ck960 FIND v(dout0_17) AT=970.05n

.meas tran vdout0_18ck960 FIND v(dout0_18) AT=970.05n

.meas tran vdout0_19ck960 FIND v(dout0_19) AT=970.05n

.meas tran vdout0_20ck960 FIND v(dout0_20) AT=970.05n

.meas tran vdout0_21ck960 FIND v(dout0_21) AT=970.05n

.meas tran vdout0_22ck960 FIND v(dout0_22) AT=970.05n

.meas tran vdout0_23ck960 FIND v(dout0_23) AT=970.05n

.meas tran vdout0_24ck960 FIND v(dout0_24) AT=970.05n

.meas tran vdout0_25ck960 FIND v(dout0_25) AT=970.05n

.meas tran vdout0_26ck960 FIND v(dout0_26) AT=970.05n

.meas tran vdout0_27ck960 FIND v(dout0_27) AT=970.05n

.meas tran vdout0_28ck960 FIND v(dout0_28) AT=970.05n

.meas tran vdout0_29ck960 FIND v(dout0_29) AT=970.05n

.meas tran vdout0_30ck960 FIND v(dout0_30) AT=970.05n

.meas tran vdout0_31ck960 FIND v(dout0_31) AT=970.05n

.meas tran vdout0_32ck960 FIND v(dout0_32) AT=970.05n

.meas tran vdout0_0ck990 FIND v(dout0_0) AT=1000.05n

.meas tran vdout0_1ck990 FIND v(dout0_1) AT=1000.05n

.meas tran vdout0_2ck990 FIND v(dout0_2) AT=1000.05n

.meas tran vdout0_3ck990 FIND v(dout0_3) AT=1000.05n

.meas tran vdout0_4ck990 FIND v(dout0_4) AT=1000.05n

.meas tran vdout0_5ck990 FIND v(dout0_5) AT=1000.05n

.meas tran vdout0_6ck990 FIND v(dout0_6) AT=1000.05n

.meas tran vdout0_7ck990 FIND v(dout0_7) AT=1000.05n

.meas tran vdout0_8ck990 FIND v(dout0_8) AT=1000.05n

.meas tran vdout0_9ck990 FIND v(dout0_9) AT=1000.05n

.meas tran vdout0_10ck990 FIND v(dout0_10) AT=1000.05n

.meas tran vdout0_11ck990 FIND v(dout0_11) AT=1000.05n

.meas tran vdout0_12ck990 FIND v(dout0_12) AT=1000.05n

.meas tran vdout0_13ck990 FIND v(dout0_13) AT=1000.05n

.meas tran vdout0_14ck990 FIND v(dout0_14) AT=1000.05n

.meas tran vdout0_15ck990 FIND v(dout0_15) AT=1000.05n

.meas tran vdout0_16ck990 FIND v(dout0_16) AT=1000.05n

.meas tran vdout0_17ck990 FIND v(dout0_17) AT=1000.05n

.meas tran vdout0_18ck990 FIND v(dout0_18) AT=1000.05n

.meas tran vdout0_19ck990 FIND v(dout0_19) AT=1000.05n

.meas tran vdout0_20ck990 FIND v(dout0_20) AT=1000.05n

.meas tran vdout0_21ck990 FIND v(dout0_21) AT=1000.05n

.meas tran vdout0_22ck990 FIND v(dout0_22) AT=1000.05n

.meas tran vdout0_23ck990 FIND v(dout0_23) AT=1000.05n

.meas tran vdout0_24ck990 FIND v(dout0_24) AT=1000.05n

.meas tran vdout0_25ck990 FIND v(dout0_25) AT=1000.05n

.meas tran vdout0_26ck990 FIND v(dout0_26) AT=1000.05n

.meas tran vdout0_27ck990 FIND v(dout0_27) AT=1000.05n

.meas tran vdout0_28ck990 FIND v(dout0_28) AT=1000.05n

.meas tran vdout0_29ck990 FIND v(dout0_29) AT=1000.05n

.meas tran vdout0_30ck990 FIND v(dout0_30) AT=1000.05n

.meas tran vdout0_31ck990 FIND v(dout0_31) AT=1000.05n

.meas tran vdout0_32ck990 FIND v(dout0_32) AT=1000.05n

.meas tran vdout0_0ck1020 FIND v(dout0_0) AT=1030.05n

.meas tran vdout0_1ck1020 FIND v(dout0_1) AT=1030.05n

.meas tran vdout0_2ck1020 FIND v(dout0_2) AT=1030.05n

.meas tran vdout0_3ck1020 FIND v(dout0_3) AT=1030.05n

.meas tran vdout0_4ck1020 FIND v(dout0_4) AT=1030.05n

.meas tran vdout0_5ck1020 FIND v(dout0_5) AT=1030.05n

.meas tran vdout0_6ck1020 FIND v(dout0_6) AT=1030.05n

.meas tran vdout0_7ck1020 FIND v(dout0_7) AT=1030.05n

.meas tran vdout0_8ck1020 FIND v(dout0_8) AT=1030.05n

.meas tran vdout0_9ck1020 FIND v(dout0_9) AT=1030.05n

.meas tran vdout0_10ck1020 FIND v(dout0_10) AT=1030.05n

.meas tran vdout0_11ck1020 FIND v(dout0_11) AT=1030.05n

.meas tran vdout0_12ck1020 FIND v(dout0_12) AT=1030.05n

.meas tran vdout0_13ck1020 FIND v(dout0_13) AT=1030.05n

.meas tran vdout0_14ck1020 FIND v(dout0_14) AT=1030.05n

.meas tran vdout0_15ck1020 FIND v(dout0_15) AT=1030.05n

.meas tran vdout0_16ck1020 FIND v(dout0_16) AT=1030.05n

.meas tran vdout0_17ck1020 FIND v(dout0_17) AT=1030.05n

.meas tran vdout0_18ck1020 FIND v(dout0_18) AT=1030.05n

.meas tran vdout0_19ck1020 FIND v(dout0_19) AT=1030.05n

.meas tran vdout0_20ck1020 FIND v(dout0_20) AT=1030.05n

.meas tran vdout0_21ck1020 FIND v(dout0_21) AT=1030.05n

.meas tran vdout0_22ck1020 FIND v(dout0_22) AT=1030.05n

.meas tran vdout0_23ck1020 FIND v(dout0_23) AT=1030.05n

.meas tran vdout0_24ck1020 FIND v(dout0_24) AT=1030.05n

.meas tran vdout0_25ck1020 FIND v(dout0_25) AT=1030.05n

.meas tran vdout0_26ck1020 FIND v(dout0_26) AT=1030.05n

.meas tran vdout0_27ck1020 FIND v(dout0_27) AT=1030.05n

.meas tran vdout0_28ck1020 FIND v(dout0_28) AT=1030.05n

.meas tran vdout0_29ck1020 FIND v(dout0_29) AT=1030.05n

.meas tran vdout0_30ck1020 FIND v(dout0_30) AT=1030.05n

.meas tran vdout0_31ck1020 FIND v(dout0_31) AT=1030.05n

.meas tran vdout0_32ck1020 FIND v(dout0_32) AT=1030.05n

.meas tran vdout0_0ck1030 FIND v(dout0_0) AT=1040.05n

.meas tran vdout0_1ck1030 FIND v(dout0_1) AT=1040.05n

.meas tran vdout0_2ck1030 FIND v(dout0_2) AT=1040.05n

.meas tran vdout0_3ck1030 FIND v(dout0_3) AT=1040.05n

.meas tran vdout0_4ck1030 FIND v(dout0_4) AT=1040.05n

.meas tran vdout0_5ck1030 FIND v(dout0_5) AT=1040.05n

.meas tran vdout0_6ck1030 FIND v(dout0_6) AT=1040.05n

.meas tran vdout0_7ck1030 FIND v(dout0_7) AT=1040.05n

.meas tran vdout0_8ck1030 FIND v(dout0_8) AT=1040.05n

.meas tran vdout0_9ck1030 FIND v(dout0_9) AT=1040.05n

.meas tran vdout0_10ck1030 FIND v(dout0_10) AT=1040.05n

.meas tran vdout0_11ck1030 FIND v(dout0_11) AT=1040.05n

.meas tran vdout0_12ck1030 FIND v(dout0_12) AT=1040.05n

.meas tran vdout0_13ck1030 FIND v(dout0_13) AT=1040.05n

.meas tran vdout0_14ck1030 FIND v(dout0_14) AT=1040.05n

.meas tran vdout0_15ck1030 FIND v(dout0_15) AT=1040.05n

.meas tran vdout0_16ck1030 FIND v(dout0_16) AT=1040.05n

.meas tran vdout0_17ck1030 FIND v(dout0_17) AT=1040.05n

.meas tran vdout0_18ck1030 FIND v(dout0_18) AT=1040.05n

.meas tran vdout0_19ck1030 FIND v(dout0_19) AT=1040.05n

.meas tran vdout0_20ck1030 FIND v(dout0_20) AT=1040.05n

.meas tran vdout0_21ck1030 FIND v(dout0_21) AT=1040.05n

.meas tran vdout0_22ck1030 FIND v(dout0_22) AT=1040.05n

.meas tran vdout0_23ck1030 FIND v(dout0_23) AT=1040.05n

.meas tran vdout0_24ck1030 FIND v(dout0_24) AT=1040.05n

.meas tran vdout0_25ck1030 FIND v(dout0_25) AT=1040.05n

.meas tran vdout0_26ck1030 FIND v(dout0_26) AT=1040.05n

.meas tran vdout0_27ck1030 FIND v(dout0_27) AT=1040.05n

.meas tran vdout0_28ck1030 FIND v(dout0_28) AT=1040.05n

.meas tran vdout0_29ck1030 FIND v(dout0_29) AT=1040.05n

.meas tran vdout0_30ck1030 FIND v(dout0_30) AT=1040.05n

.meas tran vdout0_31ck1030 FIND v(dout0_31) AT=1040.05n

.meas tran vdout0_32ck1030 FIND v(dout0_32) AT=1040.05n

.meas tran vdout0_0ck1040 FIND v(dout0_0) AT=1050.05n

.meas tran vdout0_1ck1040 FIND v(dout0_1) AT=1050.05n

.meas tran vdout0_2ck1040 FIND v(dout0_2) AT=1050.05n

.meas tran vdout0_3ck1040 FIND v(dout0_3) AT=1050.05n

.meas tran vdout0_4ck1040 FIND v(dout0_4) AT=1050.05n

.meas tran vdout0_5ck1040 FIND v(dout0_5) AT=1050.05n

.meas tran vdout0_6ck1040 FIND v(dout0_6) AT=1050.05n

.meas tran vdout0_7ck1040 FIND v(dout0_7) AT=1050.05n

.meas tran vdout0_8ck1040 FIND v(dout0_8) AT=1050.05n

.meas tran vdout0_9ck1040 FIND v(dout0_9) AT=1050.05n

.meas tran vdout0_10ck1040 FIND v(dout0_10) AT=1050.05n

.meas tran vdout0_11ck1040 FIND v(dout0_11) AT=1050.05n

.meas tran vdout0_12ck1040 FIND v(dout0_12) AT=1050.05n

.meas tran vdout0_13ck1040 FIND v(dout0_13) AT=1050.05n

.meas tran vdout0_14ck1040 FIND v(dout0_14) AT=1050.05n

.meas tran vdout0_15ck1040 FIND v(dout0_15) AT=1050.05n

.meas tran vdout0_16ck1040 FIND v(dout0_16) AT=1050.05n

.meas tran vdout0_17ck1040 FIND v(dout0_17) AT=1050.05n

.meas tran vdout0_18ck1040 FIND v(dout0_18) AT=1050.05n

.meas tran vdout0_19ck1040 FIND v(dout0_19) AT=1050.05n

.meas tran vdout0_20ck1040 FIND v(dout0_20) AT=1050.05n

.meas tran vdout0_21ck1040 FIND v(dout0_21) AT=1050.05n

.meas tran vdout0_22ck1040 FIND v(dout0_22) AT=1050.05n

.meas tran vdout0_23ck1040 FIND v(dout0_23) AT=1050.05n

.meas tran vdout0_24ck1040 FIND v(dout0_24) AT=1050.05n

.meas tran vdout0_25ck1040 FIND v(dout0_25) AT=1050.05n

.meas tran vdout0_26ck1040 FIND v(dout0_26) AT=1050.05n

.meas tran vdout0_27ck1040 FIND v(dout0_27) AT=1050.05n

.meas tran vdout0_28ck1040 FIND v(dout0_28) AT=1050.05n

.meas tran vdout0_29ck1040 FIND v(dout0_29) AT=1050.05n

.meas tran vdout0_30ck1040 FIND v(dout0_30) AT=1050.05n

.meas tran vdout0_31ck1040 FIND v(dout0_31) AT=1050.05n

.meas tran vdout0_32ck1040 FIND v(dout0_32) AT=1050.05n

.meas tran vdout0_0ck1050 FIND v(dout0_0) AT=1060.05n

.meas tran vdout0_1ck1050 FIND v(dout0_1) AT=1060.05n

.meas tran vdout0_2ck1050 FIND v(dout0_2) AT=1060.05n

.meas tran vdout0_3ck1050 FIND v(dout0_3) AT=1060.05n

.meas tran vdout0_4ck1050 FIND v(dout0_4) AT=1060.05n

.meas tran vdout0_5ck1050 FIND v(dout0_5) AT=1060.05n

.meas tran vdout0_6ck1050 FIND v(dout0_6) AT=1060.05n

.meas tran vdout0_7ck1050 FIND v(dout0_7) AT=1060.05n

.meas tran vdout0_8ck1050 FIND v(dout0_8) AT=1060.05n

.meas tran vdout0_9ck1050 FIND v(dout0_9) AT=1060.05n

.meas tran vdout0_10ck1050 FIND v(dout0_10) AT=1060.05n

.meas tran vdout0_11ck1050 FIND v(dout0_11) AT=1060.05n

.meas tran vdout0_12ck1050 FIND v(dout0_12) AT=1060.05n

.meas tran vdout0_13ck1050 FIND v(dout0_13) AT=1060.05n

.meas tran vdout0_14ck1050 FIND v(dout0_14) AT=1060.05n

.meas tran vdout0_15ck1050 FIND v(dout0_15) AT=1060.05n

.meas tran vdout0_16ck1050 FIND v(dout0_16) AT=1060.05n

.meas tran vdout0_17ck1050 FIND v(dout0_17) AT=1060.05n

.meas tran vdout0_18ck1050 FIND v(dout0_18) AT=1060.05n

.meas tran vdout0_19ck1050 FIND v(dout0_19) AT=1060.05n

.meas tran vdout0_20ck1050 FIND v(dout0_20) AT=1060.05n

.meas tran vdout0_21ck1050 FIND v(dout0_21) AT=1060.05n

.meas tran vdout0_22ck1050 FIND v(dout0_22) AT=1060.05n

.meas tran vdout0_23ck1050 FIND v(dout0_23) AT=1060.05n

.meas tran vdout0_24ck1050 FIND v(dout0_24) AT=1060.05n

.meas tran vdout0_25ck1050 FIND v(dout0_25) AT=1060.05n

.meas tran vdout0_26ck1050 FIND v(dout0_26) AT=1060.05n

.meas tran vdout0_27ck1050 FIND v(dout0_27) AT=1060.05n

.meas tran vdout0_28ck1050 FIND v(dout0_28) AT=1060.05n

.meas tran vdout0_29ck1050 FIND v(dout0_29) AT=1060.05n

.meas tran vdout0_30ck1050 FIND v(dout0_30) AT=1060.05n

.meas tran vdout0_31ck1050 FIND v(dout0_31) AT=1060.05n

.meas tran vdout0_32ck1050 FIND v(dout0_32) AT=1060.05n

.meas tran vdout0_0ck1110 FIND v(dout0_0) AT=1120.05n

.meas tran vdout0_1ck1110 FIND v(dout0_1) AT=1120.05n

.meas tran vdout0_2ck1110 FIND v(dout0_2) AT=1120.05n

.meas tran vdout0_3ck1110 FIND v(dout0_3) AT=1120.05n

.meas tran vdout0_4ck1110 FIND v(dout0_4) AT=1120.05n

.meas tran vdout0_5ck1110 FIND v(dout0_5) AT=1120.05n

.meas tran vdout0_6ck1110 FIND v(dout0_6) AT=1120.05n

.meas tran vdout0_7ck1110 FIND v(dout0_7) AT=1120.05n

.meas tran vdout0_8ck1110 FIND v(dout0_8) AT=1120.05n

.meas tran vdout0_9ck1110 FIND v(dout0_9) AT=1120.05n

.meas tran vdout0_10ck1110 FIND v(dout0_10) AT=1120.05n

.meas tran vdout0_11ck1110 FIND v(dout0_11) AT=1120.05n

.meas tran vdout0_12ck1110 FIND v(dout0_12) AT=1120.05n

.meas tran vdout0_13ck1110 FIND v(dout0_13) AT=1120.05n

.meas tran vdout0_14ck1110 FIND v(dout0_14) AT=1120.05n

.meas tran vdout0_15ck1110 FIND v(dout0_15) AT=1120.05n

.meas tran vdout0_16ck1110 FIND v(dout0_16) AT=1120.05n

.meas tran vdout0_17ck1110 FIND v(dout0_17) AT=1120.05n

.meas tran vdout0_18ck1110 FIND v(dout0_18) AT=1120.05n

.meas tran vdout0_19ck1110 FIND v(dout0_19) AT=1120.05n

.meas tran vdout0_20ck1110 FIND v(dout0_20) AT=1120.05n

.meas tran vdout0_21ck1110 FIND v(dout0_21) AT=1120.05n

.meas tran vdout0_22ck1110 FIND v(dout0_22) AT=1120.05n

.meas tran vdout0_23ck1110 FIND v(dout0_23) AT=1120.05n

.meas tran vdout0_24ck1110 FIND v(dout0_24) AT=1120.05n

.meas tran vdout0_25ck1110 FIND v(dout0_25) AT=1120.05n

.meas tran vdout0_26ck1110 FIND v(dout0_26) AT=1120.05n

.meas tran vdout0_27ck1110 FIND v(dout0_27) AT=1120.05n

.meas tran vdout0_28ck1110 FIND v(dout0_28) AT=1120.05n

.meas tran vdout0_29ck1110 FIND v(dout0_29) AT=1120.05n

.meas tran vdout0_30ck1110 FIND v(dout0_30) AT=1120.05n

.meas tran vdout0_31ck1110 FIND v(dout0_31) AT=1120.05n

.meas tran vdout0_32ck1110 FIND v(dout0_32) AT=1120.05n

.meas tran vdout0_0ck1140 FIND v(dout0_0) AT=1150.05n

.meas tran vdout0_1ck1140 FIND v(dout0_1) AT=1150.05n

.meas tran vdout0_2ck1140 FIND v(dout0_2) AT=1150.05n

.meas tran vdout0_3ck1140 FIND v(dout0_3) AT=1150.05n

.meas tran vdout0_4ck1140 FIND v(dout0_4) AT=1150.05n

.meas tran vdout0_5ck1140 FIND v(dout0_5) AT=1150.05n

.meas tran vdout0_6ck1140 FIND v(dout0_6) AT=1150.05n

.meas tran vdout0_7ck1140 FIND v(dout0_7) AT=1150.05n

.meas tran vdout0_8ck1140 FIND v(dout0_8) AT=1150.05n

.meas tran vdout0_9ck1140 FIND v(dout0_9) AT=1150.05n

.meas tran vdout0_10ck1140 FIND v(dout0_10) AT=1150.05n

.meas tran vdout0_11ck1140 FIND v(dout0_11) AT=1150.05n

.meas tran vdout0_12ck1140 FIND v(dout0_12) AT=1150.05n

.meas tran vdout0_13ck1140 FIND v(dout0_13) AT=1150.05n

.meas tran vdout0_14ck1140 FIND v(dout0_14) AT=1150.05n

.meas tran vdout0_15ck1140 FIND v(dout0_15) AT=1150.05n

.meas tran vdout0_16ck1140 FIND v(dout0_16) AT=1150.05n

.meas tran vdout0_17ck1140 FIND v(dout0_17) AT=1150.05n

.meas tran vdout0_18ck1140 FIND v(dout0_18) AT=1150.05n

.meas tran vdout0_19ck1140 FIND v(dout0_19) AT=1150.05n

.meas tran vdout0_20ck1140 FIND v(dout0_20) AT=1150.05n

.meas tran vdout0_21ck1140 FIND v(dout0_21) AT=1150.05n

.meas tran vdout0_22ck1140 FIND v(dout0_22) AT=1150.05n

.meas tran vdout0_23ck1140 FIND v(dout0_23) AT=1150.05n

.meas tran vdout0_24ck1140 FIND v(dout0_24) AT=1150.05n

.meas tran vdout0_25ck1140 FIND v(dout0_25) AT=1150.05n

.meas tran vdout0_26ck1140 FIND v(dout0_26) AT=1150.05n

.meas tran vdout0_27ck1140 FIND v(dout0_27) AT=1150.05n

.meas tran vdout0_28ck1140 FIND v(dout0_28) AT=1150.05n

.meas tran vdout0_29ck1140 FIND v(dout0_29) AT=1150.05n

.meas tran vdout0_30ck1140 FIND v(dout0_30) AT=1150.05n

.meas tran vdout0_31ck1140 FIND v(dout0_31) AT=1150.05n

.meas tran vdout0_32ck1140 FIND v(dout0_32) AT=1150.05n

.meas tran vdout0_0ck1170 FIND v(dout0_0) AT=1180.05n

.meas tran vdout0_1ck1170 FIND v(dout0_1) AT=1180.05n

.meas tran vdout0_2ck1170 FIND v(dout0_2) AT=1180.05n

.meas tran vdout0_3ck1170 FIND v(dout0_3) AT=1180.05n

.meas tran vdout0_4ck1170 FIND v(dout0_4) AT=1180.05n

.meas tran vdout0_5ck1170 FIND v(dout0_5) AT=1180.05n

.meas tran vdout0_6ck1170 FIND v(dout0_6) AT=1180.05n

.meas tran vdout0_7ck1170 FIND v(dout0_7) AT=1180.05n

.meas tran vdout0_8ck1170 FIND v(dout0_8) AT=1180.05n

.meas tran vdout0_9ck1170 FIND v(dout0_9) AT=1180.05n

.meas tran vdout0_10ck1170 FIND v(dout0_10) AT=1180.05n

.meas tran vdout0_11ck1170 FIND v(dout0_11) AT=1180.05n

.meas tran vdout0_12ck1170 FIND v(dout0_12) AT=1180.05n

.meas tran vdout0_13ck1170 FIND v(dout0_13) AT=1180.05n

.meas tran vdout0_14ck1170 FIND v(dout0_14) AT=1180.05n

.meas tran vdout0_15ck1170 FIND v(dout0_15) AT=1180.05n

.meas tran vdout0_16ck1170 FIND v(dout0_16) AT=1180.05n

.meas tran vdout0_17ck1170 FIND v(dout0_17) AT=1180.05n

.meas tran vdout0_18ck1170 FIND v(dout0_18) AT=1180.05n

.meas tran vdout0_19ck1170 FIND v(dout0_19) AT=1180.05n

.meas tran vdout0_20ck1170 FIND v(dout0_20) AT=1180.05n

.meas tran vdout0_21ck1170 FIND v(dout0_21) AT=1180.05n

.meas tran vdout0_22ck1170 FIND v(dout0_22) AT=1180.05n

.meas tran vdout0_23ck1170 FIND v(dout0_23) AT=1180.05n

.meas tran vdout0_24ck1170 FIND v(dout0_24) AT=1180.05n

.meas tran vdout0_25ck1170 FIND v(dout0_25) AT=1180.05n

.meas tran vdout0_26ck1170 FIND v(dout0_26) AT=1180.05n

.meas tran vdout0_27ck1170 FIND v(dout0_27) AT=1180.05n

.meas tran vdout0_28ck1170 FIND v(dout0_28) AT=1180.05n

.meas tran vdout0_29ck1170 FIND v(dout0_29) AT=1180.05n

.meas tran vdout0_30ck1170 FIND v(dout0_30) AT=1180.05n

.meas tran vdout0_31ck1170 FIND v(dout0_31) AT=1180.05n

.meas tran vdout0_32ck1170 FIND v(dout0_32) AT=1180.05n

.meas tran vdout0_0ck1200 FIND v(dout0_0) AT=1210.05n

.meas tran vdout0_1ck1200 FIND v(dout0_1) AT=1210.05n

.meas tran vdout0_2ck1200 FIND v(dout0_2) AT=1210.05n

.meas tran vdout0_3ck1200 FIND v(dout0_3) AT=1210.05n

.meas tran vdout0_4ck1200 FIND v(dout0_4) AT=1210.05n

.meas tran vdout0_5ck1200 FIND v(dout0_5) AT=1210.05n

.meas tran vdout0_6ck1200 FIND v(dout0_6) AT=1210.05n

.meas tran vdout0_7ck1200 FIND v(dout0_7) AT=1210.05n

.meas tran vdout0_8ck1200 FIND v(dout0_8) AT=1210.05n

.meas tran vdout0_9ck1200 FIND v(dout0_9) AT=1210.05n

.meas tran vdout0_10ck1200 FIND v(dout0_10) AT=1210.05n

.meas tran vdout0_11ck1200 FIND v(dout0_11) AT=1210.05n

.meas tran vdout0_12ck1200 FIND v(dout0_12) AT=1210.05n

.meas tran vdout0_13ck1200 FIND v(dout0_13) AT=1210.05n

.meas tran vdout0_14ck1200 FIND v(dout0_14) AT=1210.05n

.meas tran vdout0_15ck1200 FIND v(dout0_15) AT=1210.05n

.meas tran vdout0_16ck1200 FIND v(dout0_16) AT=1210.05n

.meas tran vdout0_17ck1200 FIND v(dout0_17) AT=1210.05n

.meas tran vdout0_18ck1200 FIND v(dout0_18) AT=1210.05n

.meas tran vdout0_19ck1200 FIND v(dout0_19) AT=1210.05n

.meas tran vdout0_20ck1200 FIND v(dout0_20) AT=1210.05n

.meas tran vdout0_21ck1200 FIND v(dout0_21) AT=1210.05n

.meas tran vdout0_22ck1200 FIND v(dout0_22) AT=1210.05n

.meas tran vdout0_23ck1200 FIND v(dout0_23) AT=1210.05n

.meas tran vdout0_24ck1200 FIND v(dout0_24) AT=1210.05n

.meas tran vdout0_25ck1200 FIND v(dout0_25) AT=1210.05n

.meas tran vdout0_26ck1200 FIND v(dout0_26) AT=1210.05n

.meas tran vdout0_27ck1200 FIND v(dout0_27) AT=1210.05n

.meas tran vdout0_28ck1200 FIND v(dout0_28) AT=1210.05n

.meas tran vdout0_29ck1200 FIND v(dout0_29) AT=1210.05n

.meas tran vdout0_30ck1200 FIND v(dout0_30) AT=1210.05n

.meas tran vdout0_31ck1200 FIND v(dout0_31) AT=1210.05n

.meas tran vdout0_32ck1200 FIND v(dout0_32) AT=1210.05n

.meas tran vdout0_0ck1260 FIND v(dout0_0) AT=1270.05n

.meas tran vdout0_1ck1260 FIND v(dout0_1) AT=1270.05n

.meas tran vdout0_2ck1260 FIND v(dout0_2) AT=1270.05n

.meas tran vdout0_3ck1260 FIND v(dout0_3) AT=1270.05n

.meas tran vdout0_4ck1260 FIND v(dout0_4) AT=1270.05n

.meas tran vdout0_5ck1260 FIND v(dout0_5) AT=1270.05n

.meas tran vdout0_6ck1260 FIND v(dout0_6) AT=1270.05n

.meas tran vdout0_7ck1260 FIND v(dout0_7) AT=1270.05n

.meas tran vdout0_8ck1260 FIND v(dout0_8) AT=1270.05n

.meas tran vdout0_9ck1260 FIND v(dout0_9) AT=1270.05n

.meas tran vdout0_10ck1260 FIND v(dout0_10) AT=1270.05n

.meas tran vdout0_11ck1260 FIND v(dout0_11) AT=1270.05n

.meas tran vdout0_12ck1260 FIND v(dout0_12) AT=1270.05n

.meas tran vdout0_13ck1260 FIND v(dout0_13) AT=1270.05n

.meas tran vdout0_14ck1260 FIND v(dout0_14) AT=1270.05n

.meas tran vdout0_15ck1260 FIND v(dout0_15) AT=1270.05n

.meas tran vdout0_16ck1260 FIND v(dout0_16) AT=1270.05n

.meas tran vdout0_17ck1260 FIND v(dout0_17) AT=1270.05n

.meas tran vdout0_18ck1260 FIND v(dout0_18) AT=1270.05n

.meas tran vdout0_19ck1260 FIND v(dout0_19) AT=1270.05n

.meas tran vdout0_20ck1260 FIND v(dout0_20) AT=1270.05n

.meas tran vdout0_21ck1260 FIND v(dout0_21) AT=1270.05n

.meas tran vdout0_22ck1260 FIND v(dout0_22) AT=1270.05n

.meas tran vdout0_23ck1260 FIND v(dout0_23) AT=1270.05n

.meas tran vdout0_24ck1260 FIND v(dout0_24) AT=1270.05n

.meas tran vdout0_25ck1260 FIND v(dout0_25) AT=1270.05n

.meas tran vdout0_26ck1260 FIND v(dout0_26) AT=1270.05n

.meas tran vdout0_27ck1260 FIND v(dout0_27) AT=1270.05n

.meas tran vdout0_28ck1260 FIND v(dout0_28) AT=1270.05n

.meas tran vdout0_29ck1260 FIND v(dout0_29) AT=1270.05n

.meas tran vdout0_30ck1260 FIND v(dout0_30) AT=1270.05n

.meas tran vdout0_31ck1260 FIND v(dout0_31) AT=1270.05n

.meas tran vdout0_32ck1260 FIND v(dout0_32) AT=1270.05n

.meas tran vdout0_0ck1290 FIND v(dout0_0) AT=1300.05n

.meas tran vdout0_1ck1290 FIND v(dout0_1) AT=1300.05n

.meas tran vdout0_2ck1290 FIND v(dout0_2) AT=1300.05n

.meas tran vdout0_3ck1290 FIND v(dout0_3) AT=1300.05n

.meas tran vdout0_4ck1290 FIND v(dout0_4) AT=1300.05n

.meas tran vdout0_5ck1290 FIND v(dout0_5) AT=1300.05n

.meas tran vdout0_6ck1290 FIND v(dout0_6) AT=1300.05n

.meas tran vdout0_7ck1290 FIND v(dout0_7) AT=1300.05n

.meas tran vdout0_8ck1290 FIND v(dout0_8) AT=1300.05n

.meas tran vdout0_9ck1290 FIND v(dout0_9) AT=1300.05n

.meas tran vdout0_10ck1290 FIND v(dout0_10) AT=1300.05n

.meas tran vdout0_11ck1290 FIND v(dout0_11) AT=1300.05n

.meas tran vdout0_12ck1290 FIND v(dout0_12) AT=1300.05n

.meas tran vdout0_13ck1290 FIND v(dout0_13) AT=1300.05n

.meas tran vdout0_14ck1290 FIND v(dout0_14) AT=1300.05n

.meas tran vdout0_15ck1290 FIND v(dout0_15) AT=1300.05n

.meas tran vdout0_16ck1290 FIND v(dout0_16) AT=1300.05n

.meas tran vdout0_17ck1290 FIND v(dout0_17) AT=1300.05n

.meas tran vdout0_18ck1290 FIND v(dout0_18) AT=1300.05n

.meas tran vdout0_19ck1290 FIND v(dout0_19) AT=1300.05n

.meas tran vdout0_20ck1290 FIND v(dout0_20) AT=1300.05n

.meas tran vdout0_21ck1290 FIND v(dout0_21) AT=1300.05n

.meas tran vdout0_22ck1290 FIND v(dout0_22) AT=1300.05n

.meas tran vdout0_23ck1290 FIND v(dout0_23) AT=1300.05n

.meas tran vdout0_24ck1290 FIND v(dout0_24) AT=1300.05n

.meas tran vdout0_25ck1290 FIND v(dout0_25) AT=1300.05n

.meas tran vdout0_26ck1290 FIND v(dout0_26) AT=1300.05n

.meas tran vdout0_27ck1290 FIND v(dout0_27) AT=1300.05n

.meas tran vdout0_28ck1290 FIND v(dout0_28) AT=1300.05n

.meas tran vdout0_29ck1290 FIND v(dout0_29) AT=1300.05n

.meas tran vdout0_30ck1290 FIND v(dout0_30) AT=1300.05n

.meas tran vdout0_31ck1290 FIND v(dout0_31) AT=1300.05n

.meas tran vdout0_32ck1290 FIND v(dout0_32) AT=1300.05n

.meas tran vdout0_0ck1310 FIND v(dout0_0) AT=1320.05n

.meas tran vdout0_1ck1310 FIND v(dout0_1) AT=1320.05n

.meas tran vdout0_2ck1310 FIND v(dout0_2) AT=1320.05n

.meas tran vdout0_3ck1310 FIND v(dout0_3) AT=1320.05n

.meas tran vdout0_4ck1310 FIND v(dout0_4) AT=1320.05n

.meas tran vdout0_5ck1310 FIND v(dout0_5) AT=1320.05n

.meas tran vdout0_6ck1310 FIND v(dout0_6) AT=1320.05n

.meas tran vdout0_7ck1310 FIND v(dout0_7) AT=1320.05n

.meas tran vdout0_8ck1310 FIND v(dout0_8) AT=1320.05n

.meas tran vdout0_9ck1310 FIND v(dout0_9) AT=1320.05n

.meas tran vdout0_10ck1310 FIND v(dout0_10) AT=1320.05n

.meas tran vdout0_11ck1310 FIND v(dout0_11) AT=1320.05n

.meas tran vdout0_12ck1310 FIND v(dout0_12) AT=1320.05n

.meas tran vdout0_13ck1310 FIND v(dout0_13) AT=1320.05n

.meas tran vdout0_14ck1310 FIND v(dout0_14) AT=1320.05n

.meas tran vdout0_15ck1310 FIND v(dout0_15) AT=1320.05n

.meas tran vdout0_16ck1310 FIND v(dout0_16) AT=1320.05n

.meas tran vdout0_17ck1310 FIND v(dout0_17) AT=1320.05n

.meas tran vdout0_18ck1310 FIND v(dout0_18) AT=1320.05n

.meas tran vdout0_19ck1310 FIND v(dout0_19) AT=1320.05n

.meas tran vdout0_20ck1310 FIND v(dout0_20) AT=1320.05n

.meas tran vdout0_21ck1310 FIND v(dout0_21) AT=1320.05n

.meas tran vdout0_22ck1310 FIND v(dout0_22) AT=1320.05n

.meas tran vdout0_23ck1310 FIND v(dout0_23) AT=1320.05n

.meas tran vdout0_24ck1310 FIND v(dout0_24) AT=1320.05n

.meas tran vdout0_25ck1310 FIND v(dout0_25) AT=1320.05n

.meas tran vdout0_26ck1310 FIND v(dout0_26) AT=1320.05n

.meas tran vdout0_27ck1310 FIND v(dout0_27) AT=1320.05n

.meas tran vdout0_28ck1310 FIND v(dout0_28) AT=1320.05n

.meas tran vdout0_29ck1310 FIND v(dout0_29) AT=1320.05n

.meas tran vdout0_30ck1310 FIND v(dout0_30) AT=1320.05n

.meas tran vdout0_31ck1310 FIND v(dout0_31) AT=1320.05n

.meas tran vdout0_32ck1310 FIND v(dout0_32) AT=1320.05n

.meas tran vdout0_0ck1340 FIND v(dout0_0) AT=1350.05n

.meas tran vdout0_1ck1340 FIND v(dout0_1) AT=1350.05n

.meas tran vdout0_2ck1340 FIND v(dout0_2) AT=1350.05n

.meas tran vdout0_3ck1340 FIND v(dout0_3) AT=1350.05n

.meas tran vdout0_4ck1340 FIND v(dout0_4) AT=1350.05n

.meas tran vdout0_5ck1340 FIND v(dout0_5) AT=1350.05n

.meas tran vdout0_6ck1340 FIND v(dout0_6) AT=1350.05n

.meas tran vdout0_7ck1340 FIND v(dout0_7) AT=1350.05n

.meas tran vdout0_8ck1340 FIND v(dout0_8) AT=1350.05n

.meas tran vdout0_9ck1340 FIND v(dout0_9) AT=1350.05n

.meas tran vdout0_10ck1340 FIND v(dout0_10) AT=1350.05n

.meas tran vdout0_11ck1340 FIND v(dout0_11) AT=1350.05n

.meas tran vdout0_12ck1340 FIND v(dout0_12) AT=1350.05n

.meas tran vdout0_13ck1340 FIND v(dout0_13) AT=1350.05n

.meas tran vdout0_14ck1340 FIND v(dout0_14) AT=1350.05n

.meas tran vdout0_15ck1340 FIND v(dout0_15) AT=1350.05n

.meas tran vdout0_16ck1340 FIND v(dout0_16) AT=1350.05n

.meas tran vdout0_17ck1340 FIND v(dout0_17) AT=1350.05n

.meas tran vdout0_18ck1340 FIND v(dout0_18) AT=1350.05n

.meas tran vdout0_19ck1340 FIND v(dout0_19) AT=1350.05n

.meas tran vdout0_20ck1340 FIND v(dout0_20) AT=1350.05n

.meas tran vdout0_21ck1340 FIND v(dout0_21) AT=1350.05n

.meas tran vdout0_22ck1340 FIND v(dout0_22) AT=1350.05n

.meas tran vdout0_23ck1340 FIND v(dout0_23) AT=1350.05n

.meas tran vdout0_24ck1340 FIND v(dout0_24) AT=1350.05n

.meas tran vdout0_25ck1340 FIND v(dout0_25) AT=1350.05n

.meas tran vdout0_26ck1340 FIND v(dout0_26) AT=1350.05n

.meas tran vdout0_27ck1340 FIND v(dout0_27) AT=1350.05n

.meas tran vdout0_28ck1340 FIND v(dout0_28) AT=1350.05n

.meas tran vdout0_29ck1340 FIND v(dout0_29) AT=1350.05n

.meas tran vdout0_30ck1340 FIND v(dout0_30) AT=1350.05n

.meas tran vdout0_31ck1340 FIND v(dout0_31) AT=1350.05n

.meas tran vdout0_32ck1340 FIND v(dout0_32) AT=1350.05n

.meas tran vdout0_0ck1370 FIND v(dout0_0) AT=1380.05n

.meas tran vdout0_1ck1370 FIND v(dout0_1) AT=1380.05n

.meas tran vdout0_2ck1370 FIND v(dout0_2) AT=1380.05n

.meas tran vdout0_3ck1370 FIND v(dout0_3) AT=1380.05n

.meas tran vdout0_4ck1370 FIND v(dout0_4) AT=1380.05n

.meas tran vdout0_5ck1370 FIND v(dout0_5) AT=1380.05n

.meas tran vdout0_6ck1370 FIND v(dout0_6) AT=1380.05n

.meas tran vdout0_7ck1370 FIND v(dout0_7) AT=1380.05n

.meas tran vdout0_8ck1370 FIND v(dout0_8) AT=1380.05n

.meas tran vdout0_9ck1370 FIND v(dout0_9) AT=1380.05n

.meas tran vdout0_10ck1370 FIND v(dout0_10) AT=1380.05n

.meas tran vdout0_11ck1370 FIND v(dout0_11) AT=1380.05n

.meas tran vdout0_12ck1370 FIND v(dout0_12) AT=1380.05n

.meas tran vdout0_13ck1370 FIND v(dout0_13) AT=1380.05n

.meas tran vdout0_14ck1370 FIND v(dout0_14) AT=1380.05n

.meas tran vdout0_15ck1370 FIND v(dout0_15) AT=1380.05n

.meas tran vdout0_16ck1370 FIND v(dout0_16) AT=1380.05n

.meas tran vdout0_17ck1370 FIND v(dout0_17) AT=1380.05n

.meas tran vdout0_18ck1370 FIND v(dout0_18) AT=1380.05n

.meas tran vdout0_19ck1370 FIND v(dout0_19) AT=1380.05n

.meas tran vdout0_20ck1370 FIND v(dout0_20) AT=1380.05n

.meas tran vdout0_21ck1370 FIND v(dout0_21) AT=1380.05n

.meas tran vdout0_22ck1370 FIND v(dout0_22) AT=1380.05n

.meas tran vdout0_23ck1370 FIND v(dout0_23) AT=1380.05n

.meas tran vdout0_24ck1370 FIND v(dout0_24) AT=1380.05n

.meas tran vdout0_25ck1370 FIND v(dout0_25) AT=1380.05n

.meas tran vdout0_26ck1370 FIND v(dout0_26) AT=1380.05n

.meas tran vdout0_27ck1370 FIND v(dout0_27) AT=1380.05n

.meas tran vdout0_28ck1370 FIND v(dout0_28) AT=1380.05n

.meas tran vdout0_29ck1370 FIND v(dout0_29) AT=1380.05n

.meas tran vdout0_30ck1370 FIND v(dout0_30) AT=1380.05n

.meas tran vdout0_31ck1370 FIND v(dout0_31) AT=1380.05n

.meas tran vdout0_32ck1370 FIND v(dout0_32) AT=1380.05n

.meas tran vdout0_0ck1400 FIND v(dout0_0) AT=1410.05n

.meas tran vdout0_1ck1400 FIND v(dout0_1) AT=1410.05n

.meas tran vdout0_2ck1400 FIND v(dout0_2) AT=1410.05n

.meas tran vdout0_3ck1400 FIND v(dout0_3) AT=1410.05n

.meas tran vdout0_4ck1400 FIND v(dout0_4) AT=1410.05n

.meas tran vdout0_5ck1400 FIND v(dout0_5) AT=1410.05n

.meas tran vdout0_6ck1400 FIND v(dout0_6) AT=1410.05n

.meas tran vdout0_7ck1400 FIND v(dout0_7) AT=1410.05n

.meas tran vdout0_8ck1400 FIND v(dout0_8) AT=1410.05n

.meas tran vdout0_9ck1400 FIND v(dout0_9) AT=1410.05n

.meas tran vdout0_10ck1400 FIND v(dout0_10) AT=1410.05n

.meas tran vdout0_11ck1400 FIND v(dout0_11) AT=1410.05n

.meas tran vdout0_12ck1400 FIND v(dout0_12) AT=1410.05n

.meas tran vdout0_13ck1400 FIND v(dout0_13) AT=1410.05n

.meas tran vdout0_14ck1400 FIND v(dout0_14) AT=1410.05n

.meas tran vdout0_15ck1400 FIND v(dout0_15) AT=1410.05n

.meas tran vdout0_16ck1400 FIND v(dout0_16) AT=1410.05n

.meas tran vdout0_17ck1400 FIND v(dout0_17) AT=1410.05n

.meas tran vdout0_18ck1400 FIND v(dout0_18) AT=1410.05n

.meas tran vdout0_19ck1400 FIND v(dout0_19) AT=1410.05n

.meas tran vdout0_20ck1400 FIND v(dout0_20) AT=1410.05n

.meas tran vdout0_21ck1400 FIND v(dout0_21) AT=1410.05n

.meas tran vdout0_22ck1400 FIND v(dout0_22) AT=1410.05n

.meas tran vdout0_23ck1400 FIND v(dout0_23) AT=1410.05n

.meas tran vdout0_24ck1400 FIND v(dout0_24) AT=1410.05n

.meas tran vdout0_25ck1400 FIND v(dout0_25) AT=1410.05n

.meas tran vdout0_26ck1400 FIND v(dout0_26) AT=1410.05n

.meas tran vdout0_27ck1400 FIND v(dout0_27) AT=1410.05n

.meas tran vdout0_28ck1400 FIND v(dout0_28) AT=1410.05n

.meas tran vdout0_29ck1400 FIND v(dout0_29) AT=1410.05n

.meas tran vdout0_30ck1400 FIND v(dout0_30) AT=1410.05n

.meas tran vdout0_31ck1400 FIND v(dout0_31) AT=1410.05n

.meas tran vdout0_32ck1400 FIND v(dout0_32) AT=1410.05n

.meas tran vdout0_0ck1460 FIND v(dout0_0) AT=1470.05n

.meas tran vdout0_1ck1460 FIND v(dout0_1) AT=1470.05n

.meas tran vdout0_2ck1460 FIND v(dout0_2) AT=1470.05n

.meas tran vdout0_3ck1460 FIND v(dout0_3) AT=1470.05n

.meas tran vdout0_4ck1460 FIND v(dout0_4) AT=1470.05n

.meas tran vdout0_5ck1460 FIND v(dout0_5) AT=1470.05n

.meas tran vdout0_6ck1460 FIND v(dout0_6) AT=1470.05n

.meas tran vdout0_7ck1460 FIND v(dout0_7) AT=1470.05n

.meas tran vdout0_8ck1460 FIND v(dout0_8) AT=1470.05n

.meas tran vdout0_9ck1460 FIND v(dout0_9) AT=1470.05n

.meas tran vdout0_10ck1460 FIND v(dout0_10) AT=1470.05n

.meas tran vdout0_11ck1460 FIND v(dout0_11) AT=1470.05n

.meas tran vdout0_12ck1460 FIND v(dout0_12) AT=1470.05n

.meas tran vdout0_13ck1460 FIND v(dout0_13) AT=1470.05n

.meas tran vdout0_14ck1460 FIND v(dout0_14) AT=1470.05n

.meas tran vdout0_15ck1460 FIND v(dout0_15) AT=1470.05n

.meas tran vdout0_16ck1460 FIND v(dout0_16) AT=1470.05n

.meas tran vdout0_17ck1460 FIND v(dout0_17) AT=1470.05n

.meas tran vdout0_18ck1460 FIND v(dout0_18) AT=1470.05n

.meas tran vdout0_19ck1460 FIND v(dout0_19) AT=1470.05n

.meas tran vdout0_20ck1460 FIND v(dout0_20) AT=1470.05n

.meas tran vdout0_21ck1460 FIND v(dout0_21) AT=1470.05n

.meas tran vdout0_22ck1460 FIND v(dout0_22) AT=1470.05n

.meas tran vdout0_23ck1460 FIND v(dout0_23) AT=1470.05n

.meas tran vdout0_24ck1460 FIND v(dout0_24) AT=1470.05n

.meas tran vdout0_25ck1460 FIND v(dout0_25) AT=1470.05n

.meas tran vdout0_26ck1460 FIND v(dout0_26) AT=1470.05n

.meas tran vdout0_27ck1460 FIND v(dout0_27) AT=1470.05n

.meas tran vdout0_28ck1460 FIND v(dout0_28) AT=1470.05n

.meas tran vdout0_29ck1460 FIND v(dout0_29) AT=1470.05n

.meas tran vdout0_30ck1460 FIND v(dout0_30) AT=1470.05n

.meas tran vdout0_31ck1460 FIND v(dout0_31) AT=1470.05n

.meas tran vdout0_32ck1460 FIND v(dout0_32) AT=1470.05n

.meas tran vdout0_0ck1490 FIND v(dout0_0) AT=1500.05n

.meas tran vdout0_1ck1490 FIND v(dout0_1) AT=1500.05n

.meas tran vdout0_2ck1490 FIND v(dout0_2) AT=1500.05n

.meas tran vdout0_3ck1490 FIND v(dout0_3) AT=1500.05n

.meas tran vdout0_4ck1490 FIND v(dout0_4) AT=1500.05n

.meas tran vdout0_5ck1490 FIND v(dout0_5) AT=1500.05n

.meas tran vdout0_6ck1490 FIND v(dout0_6) AT=1500.05n

.meas tran vdout0_7ck1490 FIND v(dout0_7) AT=1500.05n

.meas tran vdout0_8ck1490 FIND v(dout0_8) AT=1500.05n

.meas tran vdout0_9ck1490 FIND v(dout0_9) AT=1500.05n

.meas tran vdout0_10ck1490 FIND v(dout0_10) AT=1500.05n

.meas tran vdout0_11ck1490 FIND v(dout0_11) AT=1500.05n

.meas tran vdout0_12ck1490 FIND v(dout0_12) AT=1500.05n

.meas tran vdout0_13ck1490 FIND v(dout0_13) AT=1500.05n

.meas tran vdout0_14ck1490 FIND v(dout0_14) AT=1500.05n

.meas tran vdout0_15ck1490 FIND v(dout0_15) AT=1500.05n

.meas tran vdout0_16ck1490 FIND v(dout0_16) AT=1500.05n

.meas tran vdout0_17ck1490 FIND v(dout0_17) AT=1500.05n

.meas tran vdout0_18ck1490 FIND v(dout0_18) AT=1500.05n

.meas tran vdout0_19ck1490 FIND v(dout0_19) AT=1500.05n

.meas tran vdout0_20ck1490 FIND v(dout0_20) AT=1500.05n

.meas tran vdout0_21ck1490 FIND v(dout0_21) AT=1500.05n

.meas tran vdout0_22ck1490 FIND v(dout0_22) AT=1500.05n

.meas tran vdout0_23ck1490 FIND v(dout0_23) AT=1500.05n

.meas tran vdout0_24ck1490 FIND v(dout0_24) AT=1500.05n

.meas tran vdout0_25ck1490 FIND v(dout0_25) AT=1500.05n

.meas tran vdout0_26ck1490 FIND v(dout0_26) AT=1500.05n

.meas tran vdout0_27ck1490 FIND v(dout0_27) AT=1500.05n

.meas tran vdout0_28ck1490 FIND v(dout0_28) AT=1500.05n

.meas tran vdout0_29ck1490 FIND v(dout0_29) AT=1500.05n

.meas tran vdout0_30ck1490 FIND v(dout0_30) AT=1500.05n

.meas tran vdout0_31ck1490 FIND v(dout0_31) AT=1500.05n

.meas tran vdout0_32ck1490 FIND v(dout0_32) AT=1500.05n

.meas tran vdout0_0ck1500 FIND v(dout0_0) AT=1510.05n

.meas tran vdout0_1ck1500 FIND v(dout0_1) AT=1510.05n

.meas tran vdout0_2ck1500 FIND v(dout0_2) AT=1510.05n

.meas tran vdout0_3ck1500 FIND v(dout0_3) AT=1510.05n

.meas tran vdout0_4ck1500 FIND v(dout0_4) AT=1510.05n

.meas tran vdout0_5ck1500 FIND v(dout0_5) AT=1510.05n

.meas tran vdout0_6ck1500 FIND v(dout0_6) AT=1510.05n

.meas tran vdout0_7ck1500 FIND v(dout0_7) AT=1510.05n

.meas tran vdout0_8ck1500 FIND v(dout0_8) AT=1510.05n

.meas tran vdout0_9ck1500 FIND v(dout0_9) AT=1510.05n

.meas tran vdout0_10ck1500 FIND v(dout0_10) AT=1510.05n

.meas tran vdout0_11ck1500 FIND v(dout0_11) AT=1510.05n

.meas tran vdout0_12ck1500 FIND v(dout0_12) AT=1510.05n

.meas tran vdout0_13ck1500 FIND v(dout0_13) AT=1510.05n

.meas tran vdout0_14ck1500 FIND v(dout0_14) AT=1510.05n

.meas tran vdout0_15ck1500 FIND v(dout0_15) AT=1510.05n

.meas tran vdout0_16ck1500 FIND v(dout0_16) AT=1510.05n

.meas tran vdout0_17ck1500 FIND v(dout0_17) AT=1510.05n

.meas tran vdout0_18ck1500 FIND v(dout0_18) AT=1510.05n

.meas tran vdout0_19ck1500 FIND v(dout0_19) AT=1510.05n

.meas tran vdout0_20ck1500 FIND v(dout0_20) AT=1510.05n

.meas tran vdout0_21ck1500 FIND v(dout0_21) AT=1510.05n

.meas tran vdout0_22ck1500 FIND v(dout0_22) AT=1510.05n

.meas tran vdout0_23ck1500 FIND v(dout0_23) AT=1510.05n

.meas tran vdout0_24ck1500 FIND v(dout0_24) AT=1510.05n

.meas tran vdout0_25ck1500 FIND v(dout0_25) AT=1510.05n

.meas tran vdout0_26ck1500 FIND v(dout0_26) AT=1510.05n

.meas tran vdout0_27ck1500 FIND v(dout0_27) AT=1510.05n

.meas tran vdout0_28ck1500 FIND v(dout0_28) AT=1510.05n

.meas tran vdout0_29ck1500 FIND v(dout0_29) AT=1510.05n

.meas tran vdout0_30ck1500 FIND v(dout0_30) AT=1510.05n

.meas tran vdout0_31ck1500 FIND v(dout0_31) AT=1510.05n

.meas tran vdout0_32ck1500 FIND v(dout0_32) AT=1510.05n

.meas tran vdout0_0ck1520 FIND v(dout0_0) AT=1530.05n

.meas tran vdout0_1ck1520 FIND v(dout0_1) AT=1530.05n

.meas tran vdout0_2ck1520 FIND v(dout0_2) AT=1530.05n

.meas tran vdout0_3ck1520 FIND v(dout0_3) AT=1530.05n

.meas tran vdout0_4ck1520 FIND v(dout0_4) AT=1530.05n

.meas tran vdout0_5ck1520 FIND v(dout0_5) AT=1530.05n

.meas tran vdout0_6ck1520 FIND v(dout0_6) AT=1530.05n

.meas tran vdout0_7ck1520 FIND v(dout0_7) AT=1530.05n

.meas tran vdout0_8ck1520 FIND v(dout0_8) AT=1530.05n

.meas tran vdout0_9ck1520 FIND v(dout0_9) AT=1530.05n

.meas tran vdout0_10ck1520 FIND v(dout0_10) AT=1530.05n

.meas tran vdout0_11ck1520 FIND v(dout0_11) AT=1530.05n

.meas tran vdout0_12ck1520 FIND v(dout0_12) AT=1530.05n

.meas tran vdout0_13ck1520 FIND v(dout0_13) AT=1530.05n

.meas tran vdout0_14ck1520 FIND v(dout0_14) AT=1530.05n

.meas tran vdout0_15ck1520 FIND v(dout0_15) AT=1530.05n

.meas tran vdout0_16ck1520 FIND v(dout0_16) AT=1530.05n

.meas tran vdout0_17ck1520 FIND v(dout0_17) AT=1530.05n

.meas tran vdout0_18ck1520 FIND v(dout0_18) AT=1530.05n

.meas tran vdout0_19ck1520 FIND v(dout0_19) AT=1530.05n

.meas tran vdout0_20ck1520 FIND v(dout0_20) AT=1530.05n

.meas tran vdout0_21ck1520 FIND v(dout0_21) AT=1530.05n

.meas tran vdout0_22ck1520 FIND v(dout0_22) AT=1530.05n

.meas tran vdout0_23ck1520 FIND v(dout0_23) AT=1530.05n

.meas tran vdout0_24ck1520 FIND v(dout0_24) AT=1530.05n

.meas tran vdout0_25ck1520 FIND v(dout0_25) AT=1530.05n

.meas tran vdout0_26ck1520 FIND v(dout0_26) AT=1530.05n

.meas tran vdout0_27ck1520 FIND v(dout0_27) AT=1530.05n

.meas tran vdout0_28ck1520 FIND v(dout0_28) AT=1530.05n

.meas tran vdout0_29ck1520 FIND v(dout0_29) AT=1530.05n

.meas tran vdout0_30ck1520 FIND v(dout0_30) AT=1530.05n

.meas tran vdout0_31ck1520 FIND v(dout0_31) AT=1530.05n

.meas tran vdout0_32ck1520 FIND v(dout0_32) AT=1530.05n

.meas tran vdout0_0ck1530 FIND v(dout0_0) AT=1540.05n

.meas tran vdout0_1ck1530 FIND v(dout0_1) AT=1540.05n

.meas tran vdout0_2ck1530 FIND v(dout0_2) AT=1540.05n

.meas tran vdout0_3ck1530 FIND v(dout0_3) AT=1540.05n

.meas tran vdout0_4ck1530 FIND v(dout0_4) AT=1540.05n

.meas tran vdout0_5ck1530 FIND v(dout0_5) AT=1540.05n

.meas tran vdout0_6ck1530 FIND v(dout0_6) AT=1540.05n

.meas tran vdout0_7ck1530 FIND v(dout0_7) AT=1540.05n

.meas tran vdout0_8ck1530 FIND v(dout0_8) AT=1540.05n

.meas tran vdout0_9ck1530 FIND v(dout0_9) AT=1540.05n

.meas tran vdout0_10ck1530 FIND v(dout0_10) AT=1540.05n

.meas tran vdout0_11ck1530 FIND v(dout0_11) AT=1540.05n

.meas tran vdout0_12ck1530 FIND v(dout0_12) AT=1540.05n

.meas tran vdout0_13ck1530 FIND v(dout0_13) AT=1540.05n

.meas tran vdout0_14ck1530 FIND v(dout0_14) AT=1540.05n

.meas tran vdout0_15ck1530 FIND v(dout0_15) AT=1540.05n

.meas tran vdout0_16ck1530 FIND v(dout0_16) AT=1540.05n

.meas tran vdout0_17ck1530 FIND v(dout0_17) AT=1540.05n

.meas tran vdout0_18ck1530 FIND v(dout0_18) AT=1540.05n

.meas tran vdout0_19ck1530 FIND v(dout0_19) AT=1540.05n

.meas tran vdout0_20ck1530 FIND v(dout0_20) AT=1540.05n

.meas tran vdout0_21ck1530 FIND v(dout0_21) AT=1540.05n

.meas tran vdout0_22ck1530 FIND v(dout0_22) AT=1540.05n

.meas tran vdout0_23ck1530 FIND v(dout0_23) AT=1540.05n

.meas tran vdout0_24ck1530 FIND v(dout0_24) AT=1540.05n

.meas tran vdout0_25ck1530 FIND v(dout0_25) AT=1540.05n

.meas tran vdout0_26ck1530 FIND v(dout0_26) AT=1540.05n

.meas tran vdout0_27ck1530 FIND v(dout0_27) AT=1540.05n

.meas tran vdout0_28ck1530 FIND v(dout0_28) AT=1540.05n

.meas tran vdout0_29ck1530 FIND v(dout0_29) AT=1540.05n

.meas tran vdout0_30ck1530 FIND v(dout0_30) AT=1540.05n

.meas tran vdout0_31ck1530 FIND v(dout0_31) AT=1540.05n

.meas tran vdout0_32ck1530 FIND v(dout0_32) AT=1540.05n

.meas tran vdout0_0ck1570 FIND v(dout0_0) AT=1580.05n

.meas tran vdout0_1ck1570 FIND v(dout0_1) AT=1580.05n

.meas tran vdout0_2ck1570 FIND v(dout0_2) AT=1580.05n

.meas tran vdout0_3ck1570 FIND v(dout0_3) AT=1580.05n

.meas tran vdout0_4ck1570 FIND v(dout0_4) AT=1580.05n

.meas tran vdout0_5ck1570 FIND v(dout0_5) AT=1580.05n

.meas tran vdout0_6ck1570 FIND v(dout0_6) AT=1580.05n

.meas tran vdout0_7ck1570 FIND v(dout0_7) AT=1580.05n

.meas tran vdout0_8ck1570 FIND v(dout0_8) AT=1580.05n

.meas tran vdout0_9ck1570 FIND v(dout0_9) AT=1580.05n

.meas tran vdout0_10ck1570 FIND v(dout0_10) AT=1580.05n

.meas tran vdout0_11ck1570 FIND v(dout0_11) AT=1580.05n

.meas tran vdout0_12ck1570 FIND v(dout0_12) AT=1580.05n

.meas tran vdout0_13ck1570 FIND v(dout0_13) AT=1580.05n

.meas tran vdout0_14ck1570 FIND v(dout0_14) AT=1580.05n

.meas tran vdout0_15ck1570 FIND v(dout0_15) AT=1580.05n

.meas tran vdout0_16ck1570 FIND v(dout0_16) AT=1580.05n

.meas tran vdout0_17ck1570 FIND v(dout0_17) AT=1580.05n

.meas tran vdout0_18ck1570 FIND v(dout0_18) AT=1580.05n

.meas tran vdout0_19ck1570 FIND v(dout0_19) AT=1580.05n

.meas tran vdout0_20ck1570 FIND v(dout0_20) AT=1580.05n

.meas tran vdout0_21ck1570 FIND v(dout0_21) AT=1580.05n

.meas tran vdout0_22ck1570 FIND v(dout0_22) AT=1580.05n

.meas tran vdout0_23ck1570 FIND v(dout0_23) AT=1580.05n

.meas tran vdout0_24ck1570 FIND v(dout0_24) AT=1580.05n

.meas tran vdout0_25ck1570 FIND v(dout0_25) AT=1580.05n

.meas tran vdout0_26ck1570 FIND v(dout0_26) AT=1580.05n

.meas tran vdout0_27ck1570 FIND v(dout0_27) AT=1580.05n

.meas tran vdout0_28ck1570 FIND v(dout0_28) AT=1580.05n

.meas tran vdout0_29ck1570 FIND v(dout0_29) AT=1580.05n

.meas tran vdout0_30ck1570 FIND v(dout0_30) AT=1580.05n

.meas tran vdout0_31ck1570 FIND v(dout0_31) AT=1580.05n

.meas tran vdout0_32ck1570 FIND v(dout0_32) AT=1580.05n

.meas tran vdout0_0ck1640 FIND v(dout0_0) AT=1650.05n

.meas tran vdout0_1ck1640 FIND v(dout0_1) AT=1650.05n

.meas tran vdout0_2ck1640 FIND v(dout0_2) AT=1650.05n

.meas tran vdout0_3ck1640 FIND v(dout0_3) AT=1650.05n

.meas tran vdout0_4ck1640 FIND v(dout0_4) AT=1650.05n

.meas tran vdout0_5ck1640 FIND v(dout0_5) AT=1650.05n

.meas tran vdout0_6ck1640 FIND v(dout0_6) AT=1650.05n

.meas tran vdout0_7ck1640 FIND v(dout0_7) AT=1650.05n

.meas tran vdout0_8ck1640 FIND v(dout0_8) AT=1650.05n

.meas tran vdout0_9ck1640 FIND v(dout0_9) AT=1650.05n

.meas tran vdout0_10ck1640 FIND v(dout0_10) AT=1650.05n

.meas tran vdout0_11ck1640 FIND v(dout0_11) AT=1650.05n

.meas tran vdout0_12ck1640 FIND v(dout0_12) AT=1650.05n

.meas tran vdout0_13ck1640 FIND v(dout0_13) AT=1650.05n

.meas tran vdout0_14ck1640 FIND v(dout0_14) AT=1650.05n

.meas tran vdout0_15ck1640 FIND v(dout0_15) AT=1650.05n

.meas tran vdout0_16ck1640 FIND v(dout0_16) AT=1650.05n

.meas tran vdout0_17ck1640 FIND v(dout0_17) AT=1650.05n

.meas tran vdout0_18ck1640 FIND v(dout0_18) AT=1650.05n

.meas tran vdout0_19ck1640 FIND v(dout0_19) AT=1650.05n

.meas tran vdout0_20ck1640 FIND v(dout0_20) AT=1650.05n

.meas tran vdout0_21ck1640 FIND v(dout0_21) AT=1650.05n

.meas tran vdout0_22ck1640 FIND v(dout0_22) AT=1650.05n

.meas tran vdout0_23ck1640 FIND v(dout0_23) AT=1650.05n

.meas tran vdout0_24ck1640 FIND v(dout0_24) AT=1650.05n

.meas tran vdout0_25ck1640 FIND v(dout0_25) AT=1650.05n

.meas tran vdout0_26ck1640 FIND v(dout0_26) AT=1650.05n

.meas tran vdout0_27ck1640 FIND v(dout0_27) AT=1650.05n

.meas tran vdout0_28ck1640 FIND v(dout0_28) AT=1650.05n

.meas tran vdout0_29ck1640 FIND v(dout0_29) AT=1650.05n

.meas tran vdout0_30ck1640 FIND v(dout0_30) AT=1650.05n

.meas tran vdout0_31ck1640 FIND v(dout0_31) AT=1650.05n

.meas tran vdout0_32ck1640 FIND v(dout0_32) AT=1650.05n

.meas tran vdout0_0ck1650 FIND v(dout0_0) AT=1660.05n

.meas tran vdout0_1ck1650 FIND v(dout0_1) AT=1660.05n

.meas tran vdout0_2ck1650 FIND v(dout0_2) AT=1660.05n

.meas tran vdout0_3ck1650 FIND v(dout0_3) AT=1660.05n

.meas tran vdout0_4ck1650 FIND v(dout0_4) AT=1660.05n

.meas tran vdout0_5ck1650 FIND v(dout0_5) AT=1660.05n

.meas tran vdout0_6ck1650 FIND v(dout0_6) AT=1660.05n

.meas tran vdout0_7ck1650 FIND v(dout0_7) AT=1660.05n

.meas tran vdout0_8ck1650 FIND v(dout0_8) AT=1660.05n

.meas tran vdout0_9ck1650 FIND v(dout0_9) AT=1660.05n

.meas tran vdout0_10ck1650 FIND v(dout0_10) AT=1660.05n

.meas tran vdout0_11ck1650 FIND v(dout0_11) AT=1660.05n

.meas tran vdout0_12ck1650 FIND v(dout0_12) AT=1660.05n

.meas tran vdout0_13ck1650 FIND v(dout0_13) AT=1660.05n

.meas tran vdout0_14ck1650 FIND v(dout0_14) AT=1660.05n

.meas tran vdout0_15ck1650 FIND v(dout0_15) AT=1660.05n

.meas tran vdout0_16ck1650 FIND v(dout0_16) AT=1660.05n

.meas tran vdout0_17ck1650 FIND v(dout0_17) AT=1660.05n

.meas tran vdout0_18ck1650 FIND v(dout0_18) AT=1660.05n

.meas tran vdout0_19ck1650 FIND v(dout0_19) AT=1660.05n

.meas tran vdout0_20ck1650 FIND v(dout0_20) AT=1660.05n

.meas tran vdout0_21ck1650 FIND v(dout0_21) AT=1660.05n

.meas tran vdout0_22ck1650 FIND v(dout0_22) AT=1660.05n

.meas tran vdout0_23ck1650 FIND v(dout0_23) AT=1660.05n

.meas tran vdout0_24ck1650 FIND v(dout0_24) AT=1660.05n

.meas tran vdout0_25ck1650 FIND v(dout0_25) AT=1660.05n

.meas tran vdout0_26ck1650 FIND v(dout0_26) AT=1660.05n

.meas tran vdout0_27ck1650 FIND v(dout0_27) AT=1660.05n

.meas tran vdout0_28ck1650 FIND v(dout0_28) AT=1660.05n

.meas tran vdout0_29ck1650 FIND v(dout0_29) AT=1660.05n

.meas tran vdout0_30ck1650 FIND v(dout0_30) AT=1660.05n

.meas tran vdout0_31ck1650 FIND v(dout0_31) AT=1660.05n

.meas tran vdout0_32ck1650 FIND v(dout0_32) AT=1660.05n

.meas tran vdout0_0ck1670 FIND v(dout0_0) AT=1680.05n

.meas tran vdout0_1ck1670 FIND v(dout0_1) AT=1680.05n

.meas tran vdout0_2ck1670 FIND v(dout0_2) AT=1680.05n

.meas tran vdout0_3ck1670 FIND v(dout0_3) AT=1680.05n

.meas tran vdout0_4ck1670 FIND v(dout0_4) AT=1680.05n

.meas tran vdout0_5ck1670 FIND v(dout0_5) AT=1680.05n

.meas tran vdout0_6ck1670 FIND v(dout0_6) AT=1680.05n

.meas tran vdout0_7ck1670 FIND v(dout0_7) AT=1680.05n

.meas tran vdout0_8ck1670 FIND v(dout0_8) AT=1680.05n

.meas tran vdout0_9ck1670 FIND v(dout0_9) AT=1680.05n

.meas tran vdout0_10ck1670 FIND v(dout0_10) AT=1680.05n

.meas tran vdout0_11ck1670 FIND v(dout0_11) AT=1680.05n

.meas tran vdout0_12ck1670 FIND v(dout0_12) AT=1680.05n

.meas tran vdout0_13ck1670 FIND v(dout0_13) AT=1680.05n

.meas tran vdout0_14ck1670 FIND v(dout0_14) AT=1680.05n

.meas tran vdout0_15ck1670 FIND v(dout0_15) AT=1680.05n

.meas tran vdout0_16ck1670 FIND v(dout0_16) AT=1680.05n

.meas tran vdout0_17ck1670 FIND v(dout0_17) AT=1680.05n

.meas tran vdout0_18ck1670 FIND v(dout0_18) AT=1680.05n

.meas tran vdout0_19ck1670 FIND v(dout0_19) AT=1680.05n

.meas tran vdout0_20ck1670 FIND v(dout0_20) AT=1680.05n

.meas tran vdout0_21ck1670 FIND v(dout0_21) AT=1680.05n

.meas tran vdout0_22ck1670 FIND v(dout0_22) AT=1680.05n

.meas tran vdout0_23ck1670 FIND v(dout0_23) AT=1680.05n

.meas tran vdout0_24ck1670 FIND v(dout0_24) AT=1680.05n

.meas tran vdout0_25ck1670 FIND v(dout0_25) AT=1680.05n

.meas tran vdout0_26ck1670 FIND v(dout0_26) AT=1680.05n

.meas tran vdout0_27ck1670 FIND v(dout0_27) AT=1680.05n

.meas tran vdout0_28ck1670 FIND v(dout0_28) AT=1680.05n

.meas tran vdout0_29ck1670 FIND v(dout0_29) AT=1680.05n

.meas tran vdout0_30ck1670 FIND v(dout0_30) AT=1680.05n

.meas tran vdout0_31ck1670 FIND v(dout0_31) AT=1680.05n

.meas tran vdout0_32ck1670 FIND v(dout0_32) AT=1680.05n

.meas tran vdout0_0ck1680 FIND v(dout0_0) AT=1690.05n

.meas tran vdout0_1ck1680 FIND v(dout0_1) AT=1690.05n

.meas tran vdout0_2ck1680 FIND v(dout0_2) AT=1690.05n

.meas tran vdout0_3ck1680 FIND v(dout0_3) AT=1690.05n

.meas tran vdout0_4ck1680 FIND v(dout0_4) AT=1690.05n

.meas tran vdout0_5ck1680 FIND v(dout0_5) AT=1690.05n

.meas tran vdout0_6ck1680 FIND v(dout0_6) AT=1690.05n

.meas tran vdout0_7ck1680 FIND v(dout0_7) AT=1690.05n

.meas tran vdout0_8ck1680 FIND v(dout0_8) AT=1690.05n

.meas tran vdout0_9ck1680 FIND v(dout0_9) AT=1690.05n

.meas tran vdout0_10ck1680 FIND v(dout0_10) AT=1690.05n

.meas tran vdout0_11ck1680 FIND v(dout0_11) AT=1690.05n

.meas tran vdout0_12ck1680 FIND v(dout0_12) AT=1690.05n

.meas tran vdout0_13ck1680 FIND v(dout0_13) AT=1690.05n

.meas tran vdout0_14ck1680 FIND v(dout0_14) AT=1690.05n

.meas tran vdout0_15ck1680 FIND v(dout0_15) AT=1690.05n

.meas tran vdout0_16ck1680 FIND v(dout0_16) AT=1690.05n

.meas tran vdout0_17ck1680 FIND v(dout0_17) AT=1690.05n

.meas tran vdout0_18ck1680 FIND v(dout0_18) AT=1690.05n

.meas tran vdout0_19ck1680 FIND v(dout0_19) AT=1690.05n

.meas tran vdout0_20ck1680 FIND v(dout0_20) AT=1690.05n

.meas tran vdout0_21ck1680 FIND v(dout0_21) AT=1690.05n

.meas tran vdout0_22ck1680 FIND v(dout0_22) AT=1690.05n

.meas tran vdout0_23ck1680 FIND v(dout0_23) AT=1690.05n

.meas tran vdout0_24ck1680 FIND v(dout0_24) AT=1690.05n

.meas tran vdout0_25ck1680 FIND v(dout0_25) AT=1690.05n

.meas tran vdout0_26ck1680 FIND v(dout0_26) AT=1690.05n

.meas tran vdout0_27ck1680 FIND v(dout0_27) AT=1690.05n

.meas tran vdout0_28ck1680 FIND v(dout0_28) AT=1690.05n

.meas tran vdout0_29ck1680 FIND v(dout0_29) AT=1690.05n

.meas tran vdout0_30ck1680 FIND v(dout0_30) AT=1690.05n

.meas tran vdout0_31ck1680 FIND v(dout0_31) AT=1690.05n

.meas tran vdout0_32ck1680 FIND v(dout0_32) AT=1690.05n

.meas tran vdout0_0ck1700 FIND v(dout0_0) AT=1710.05n

.meas tran vdout0_1ck1700 FIND v(dout0_1) AT=1710.05n

.meas tran vdout0_2ck1700 FIND v(dout0_2) AT=1710.05n

.meas tran vdout0_3ck1700 FIND v(dout0_3) AT=1710.05n

.meas tran vdout0_4ck1700 FIND v(dout0_4) AT=1710.05n

.meas tran vdout0_5ck1700 FIND v(dout0_5) AT=1710.05n

.meas tran vdout0_6ck1700 FIND v(dout0_6) AT=1710.05n

.meas tran vdout0_7ck1700 FIND v(dout0_7) AT=1710.05n

.meas tran vdout0_8ck1700 FIND v(dout0_8) AT=1710.05n

.meas tran vdout0_9ck1700 FIND v(dout0_9) AT=1710.05n

.meas tran vdout0_10ck1700 FIND v(dout0_10) AT=1710.05n

.meas tran vdout0_11ck1700 FIND v(dout0_11) AT=1710.05n

.meas tran vdout0_12ck1700 FIND v(dout0_12) AT=1710.05n

.meas tran vdout0_13ck1700 FIND v(dout0_13) AT=1710.05n

.meas tran vdout0_14ck1700 FIND v(dout0_14) AT=1710.05n

.meas tran vdout0_15ck1700 FIND v(dout0_15) AT=1710.05n

.meas tran vdout0_16ck1700 FIND v(dout0_16) AT=1710.05n

.meas tran vdout0_17ck1700 FIND v(dout0_17) AT=1710.05n

.meas tran vdout0_18ck1700 FIND v(dout0_18) AT=1710.05n

.meas tran vdout0_19ck1700 FIND v(dout0_19) AT=1710.05n

.meas tran vdout0_20ck1700 FIND v(dout0_20) AT=1710.05n

.meas tran vdout0_21ck1700 FIND v(dout0_21) AT=1710.05n

.meas tran vdout0_22ck1700 FIND v(dout0_22) AT=1710.05n

.meas tran vdout0_23ck1700 FIND v(dout0_23) AT=1710.05n

.meas tran vdout0_24ck1700 FIND v(dout0_24) AT=1710.05n

.meas tran vdout0_25ck1700 FIND v(dout0_25) AT=1710.05n

.meas tran vdout0_26ck1700 FIND v(dout0_26) AT=1710.05n

.meas tran vdout0_27ck1700 FIND v(dout0_27) AT=1710.05n

.meas tran vdout0_28ck1700 FIND v(dout0_28) AT=1710.05n

.meas tran vdout0_29ck1700 FIND v(dout0_29) AT=1710.05n

.meas tran vdout0_30ck1700 FIND v(dout0_30) AT=1710.05n

.meas tran vdout0_31ck1700 FIND v(dout0_31) AT=1710.05n

.meas tran vdout0_32ck1700 FIND v(dout0_32) AT=1710.05n

.meas tran vdout0_0ck1710 FIND v(dout0_0) AT=1720.05n

.meas tran vdout0_1ck1710 FIND v(dout0_1) AT=1720.05n

.meas tran vdout0_2ck1710 FIND v(dout0_2) AT=1720.05n

.meas tran vdout0_3ck1710 FIND v(dout0_3) AT=1720.05n

.meas tran vdout0_4ck1710 FIND v(dout0_4) AT=1720.05n

.meas tran vdout0_5ck1710 FIND v(dout0_5) AT=1720.05n

.meas tran vdout0_6ck1710 FIND v(dout0_6) AT=1720.05n

.meas tran vdout0_7ck1710 FIND v(dout0_7) AT=1720.05n

.meas tran vdout0_8ck1710 FIND v(dout0_8) AT=1720.05n

.meas tran vdout0_9ck1710 FIND v(dout0_9) AT=1720.05n

.meas tran vdout0_10ck1710 FIND v(dout0_10) AT=1720.05n

.meas tran vdout0_11ck1710 FIND v(dout0_11) AT=1720.05n

.meas tran vdout0_12ck1710 FIND v(dout0_12) AT=1720.05n

.meas tran vdout0_13ck1710 FIND v(dout0_13) AT=1720.05n

.meas tran vdout0_14ck1710 FIND v(dout0_14) AT=1720.05n

.meas tran vdout0_15ck1710 FIND v(dout0_15) AT=1720.05n

.meas tran vdout0_16ck1710 FIND v(dout0_16) AT=1720.05n

.meas tran vdout0_17ck1710 FIND v(dout0_17) AT=1720.05n

.meas tran vdout0_18ck1710 FIND v(dout0_18) AT=1720.05n

.meas tran vdout0_19ck1710 FIND v(dout0_19) AT=1720.05n

.meas tran vdout0_20ck1710 FIND v(dout0_20) AT=1720.05n

.meas tran vdout0_21ck1710 FIND v(dout0_21) AT=1720.05n

.meas tran vdout0_22ck1710 FIND v(dout0_22) AT=1720.05n

.meas tran vdout0_23ck1710 FIND v(dout0_23) AT=1720.05n

.meas tran vdout0_24ck1710 FIND v(dout0_24) AT=1720.05n

.meas tran vdout0_25ck1710 FIND v(dout0_25) AT=1720.05n

.meas tran vdout0_26ck1710 FIND v(dout0_26) AT=1720.05n

.meas tran vdout0_27ck1710 FIND v(dout0_27) AT=1720.05n

.meas tran vdout0_28ck1710 FIND v(dout0_28) AT=1720.05n

.meas tran vdout0_29ck1710 FIND v(dout0_29) AT=1720.05n

.meas tran vdout0_30ck1710 FIND v(dout0_30) AT=1720.05n

.meas tran vdout0_31ck1710 FIND v(dout0_31) AT=1720.05n

.meas tran vdout0_32ck1710 FIND v(dout0_32) AT=1720.05n

.meas tran vdout0_0ck1800 FIND v(dout0_0) AT=1810.05n

.meas tran vdout0_1ck1800 FIND v(dout0_1) AT=1810.05n

.meas tran vdout0_2ck1800 FIND v(dout0_2) AT=1810.05n

.meas tran vdout0_3ck1800 FIND v(dout0_3) AT=1810.05n

.meas tran vdout0_4ck1800 FIND v(dout0_4) AT=1810.05n

.meas tran vdout0_5ck1800 FIND v(dout0_5) AT=1810.05n

.meas tran vdout0_6ck1800 FIND v(dout0_6) AT=1810.05n

.meas tran vdout0_7ck1800 FIND v(dout0_7) AT=1810.05n

.meas tran vdout0_8ck1800 FIND v(dout0_8) AT=1810.05n

.meas tran vdout0_9ck1800 FIND v(dout0_9) AT=1810.05n

.meas tran vdout0_10ck1800 FIND v(dout0_10) AT=1810.05n

.meas tran vdout0_11ck1800 FIND v(dout0_11) AT=1810.05n

.meas tran vdout0_12ck1800 FIND v(dout0_12) AT=1810.05n

.meas tran vdout0_13ck1800 FIND v(dout0_13) AT=1810.05n

.meas tran vdout0_14ck1800 FIND v(dout0_14) AT=1810.05n

.meas tran vdout0_15ck1800 FIND v(dout0_15) AT=1810.05n

.meas tran vdout0_16ck1800 FIND v(dout0_16) AT=1810.05n

.meas tran vdout0_17ck1800 FIND v(dout0_17) AT=1810.05n

.meas tran vdout0_18ck1800 FIND v(dout0_18) AT=1810.05n

.meas tran vdout0_19ck1800 FIND v(dout0_19) AT=1810.05n

.meas tran vdout0_20ck1800 FIND v(dout0_20) AT=1810.05n

.meas tran vdout0_21ck1800 FIND v(dout0_21) AT=1810.05n

.meas tran vdout0_22ck1800 FIND v(dout0_22) AT=1810.05n

.meas tran vdout0_23ck1800 FIND v(dout0_23) AT=1810.05n

.meas tran vdout0_24ck1800 FIND v(dout0_24) AT=1810.05n

.meas tran vdout0_25ck1800 FIND v(dout0_25) AT=1810.05n

.meas tran vdout0_26ck1800 FIND v(dout0_26) AT=1810.05n

.meas tran vdout0_27ck1800 FIND v(dout0_27) AT=1810.05n

.meas tran vdout0_28ck1800 FIND v(dout0_28) AT=1810.05n

.meas tran vdout0_29ck1800 FIND v(dout0_29) AT=1810.05n

.meas tran vdout0_30ck1800 FIND v(dout0_30) AT=1810.05n

.meas tran vdout0_31ck1800 FIND v(dout0_31) AT=1810.05n

.meas tran vdout0_32ck1800 FIND v(dout0_32) AT=1810.05n

.meas tran vdout0_0ck1810 FIND v(dout0_0) AT=1820.05n

.meas tran vdout0_1ck1810 FIND v(dout0_1) AT=1820.05n

.meas tran vdout0_2ck1810 FIND v(dout0_2) AT=1820.05n

.meas tran vdout0_3ck1810 FIND v(dout0_3) AT=1820.05n

.meas tran vdout0_4ck1810 FIND v(dout0_4) AT=1820.05n

.meas tran vdout0_5ck1810 FIND v(dout0_5) AT=1820.05n

.meas tran vdout0_6ck1810 FIND v(dout0_6) AT=1820.05n

.meas tran vdout0_7ck1810 FIND v(dout0_7) AT=1820.05n

.meas tran vdout0_8ck1810 FIND v(dout0_8) AT=1820.05n

.meas tran vdout0_9ck1810 FIND v(dout0_9) AT=1820.05n

.meas tran vdout0_10ck1810 FIND v(dout0_10) AT=1820.05n

.meas tran vdout0_11ck1810 FIND v(dout0_11) AT=1820.05n

.meas tran vdout0_12ck1810 FIND v(dout0_12) AT=1820.05n

.meas tran vdout0_13ck1810 FIND v(dout0_13) AT=1820.05n

.meas tran vdout0_14ck1810 FIND v(dout0_14) AT=1820.05n

.meas tran vdout0_15ck1810 FIND v(dout0_15) AT=1820.05n

.meas tran vdout0_16ck1810 FIND v(dout0_16) AT=1820.05n

.meas tran vdout0_17ck1810 FIND v(dout0_17) AT=1820.05n

.meas tran vdout0_18ck1810 FIND v(dout0_18) AT=1820.05n

.meas tran vdout0_19ck1810 FIND v(dout0_19) AT=1820.05n

.meas tran vdout0_20ck1810 FIND v(dout0_20) AT=1820.05n

.meas tran vdout0_21ck1810 FIND v(dout0_21) AT=1820.05n

.meas tran vdout0_22ck1810 FIND v(dout0_22) AT=1820.05n

.meas tran vdout0_23ck1810 FIND v(dout0_23) AT=1820.05n

.meas tran vdout0_24ck1810 FIND v(dout0_24) AT=1820.05n

.meas tran vdout0_25ck1810 FIND v(dout0_25) AT=1820.05n

.meas tran vdout0_26ck1810 FIND v(dout0_26) AT=1820.05n

.meas tran vdout0_27ck1810 FIND v(dout0_27) AT=1820.05n

.meas tran vdout0_28ck1810 FIND v(dout0_28) AT=1820.05n

.meas tran vdout0_29ck1810 FIND v(dout0_29) AT=1820.05n

.meas tran vdout0_30ck1810 FIND v(dout0_30) AT=1820.05n

.meas tran vdout0_31ck1810 FIND v(dout0_31) AT=1820.05n

.meas tran vdout0_32ck1810 FIND v(dout0_32) AT=1820.05n

.meas tran vdout0_0ck1830 FIND v(dout0_0) AT=1840.05n

.meas tran vdout0_1ck1830 FIND v(dout0_1) AT=1840.05n

.meas tran vdout0_2ck1830 FIND v(dout0_2) AT=1840.05n

.meas tran vdout0_3ck1830 FIND v(dout0_3) AT=1840.05n

.meas tran vdout0_4ck1830 FIND v(dout0_4) AT=1840.05n

.meas tran vdout0_5ck1830 FIND v(dout0_5) AT=1840.05n

.meas tran vdout0_6ck1830 FIND v(dout0_6) AT=1840.05n

.meas tran vdout0_7ck1830 FIND v(dout0_7) AT=1840.05n

.meas tran vdout0_8ck1830 FIND v(dout0_8) AT=1840.05n

.meas tran vdout0_9ck1830 FIND v(dout0_9) AT=1840.05n

.meas tran vdout0_10ck1830 FIND v(dout0_10) AT=1840.05n

.meas tran vdout0_11ck1830 FIND v(dout0_11) AT=1840.05n

.meas tran vdout0_12ck1830 FIND v(dout0_12) AT=1840.05n

.meas tran vdout0_13ck1830 FIND v(dout0_13) AT=1840.05n

.meas tran vdout0_14ck1830 FIND v(dout0_14) AT=1840.05n

.meas tran vdout0_15ck1830 FIND v(dout0_15) AT=1840.05n

.meas tran vdout0_16ck1830 FIND v(dout0_16) AT=1840.05n

.meas tran vdout0_17ck1830 FIND v(dout0_17) AT=1840.05n

.meas tran vdout0_18ck1830 FIND v(dout0_18) AT=1840.05n

.meas tran vdout0_19ck1830 FIND v(dout0_19) AT=1840.05n

.meas tran vdout0_20ck1830 FIND v(dout0_20) AT=1840.05n

.meas tran vdout0_21ck1830 FIND v(dout0_21) AT=1840.05n

.meas tran vdout0_22ck1830 FIND v(dout0_22) AT=1840.05n

.meas tran vdout0_23ck1830 FIND v(dout0_23) AT=1840.05n

.meas tran vdout0_24ck1830 FIND v(dout0_24) AT=1840.05n

.meas tran vdout0_25ck1830 FIND v(dout0_25) AT=1840.05n

.meas tran vdout0_26ck1830 FIND v(dout0_26) AT=1840.05n

.meas tran vdout0_27ck1830 FIND v(dout0_27) AT=1840.05n

.meas tran vdout0_28ck1830 FIND v(dout0_28) AT=1840.05n

.meas tran vdout0_29ck1830 FIND v(dout0_29) AT=1840.05n

.meas tran vdout0_30ck1830 FIND v(dout0_30) AT=1840.05n

.meas tran vdout0_31ck1830 FIND v(dout0_31) AT=1840.05n

.meas tran vdout0_32ck1830 FIND v(dout0_32) AT=1840.05n

.meas tran vdout0_0ck1850 FIND v(dout0_0) AT=1860.05n

.meas tran vdout0_1ck1850 FIND v(dout0_1) AT=1860.05n

.meas tran vdout0_2ck1850 FIND v(dout0_2) AT=1860.05n

.meas tran vdout0_3ck1850 FIND v(dout0_3) AT=1860.05n

.meas tran vdout0_4ck1850 FIND v(dout0_4) AT=1860.05n

.meas tran vdout0_5ck1850 FIND v(dout0_5) AT=1860.05n

.meas tran vdout0_6ck1850 FIND v(dout0_6) AT=1860.05n

.meas tran vdout0_7ck1850 FIND v(dout0_7) AT=1860.05n

.meas tran vdout0_8ck1850 FIND v(dout0_8) AT=1860.05n

.meas tran vdout0_9ck1850 FIND v(dout0_9) AT=1860.05n

.meas tran vdout0_10ck1850 FIND v(dout0_10) AT=1860.05n

.meas tran vdout0_11ck1850 FIND v(dout0_11) AT=1860.05n

.meas tran vdout0_12ck1850 FIND v(dout0_12) AT=1860.05n

.meas tran vdout0_13ck1850 FIND v(dout0_13) AT=1860.05n

.meas tran vdout0_14ck1850 FIND v(dout0_14) AT=1860.05n

.meas tran vdout0_15ck1850 FIND v(dout0_15) AT=1860.05n

.meas tran vdout0_16ck1850 FIND v(dout0_16) AT=1860.05n

.meas tran vdout0_17ck1850 FIND v(dout0_17) AT=1860.05n

.meas tran vdout0_18ck1850 FIND v(dout0_18) AT=1860.05n

.meas tran vdout0_19ck1850 FIND v(dout0_19) AT=1860.05n

.meas tran vdout0_20ck1850 FIND v(dout0_20) AT=1860.05n

.meas tran vdout0_21ck1850 FIND v(dout0_21) AT=1860.05n

.meas tran vdout0_22ck1850 FIND v(dout0_22) AT=1860.05n

.meas tran vdout0_23ck1850 FIND v(dout0_23) AT=1860.05n

.meas tran vdout0_24ck1850 FIND v(dout0_24) AT=1860.05n

.meas tran vdout0_25ck1850 FIND v(dout0_25) AT=1860.05n

.meas tran vdout0_26ck1850 FIND v(dout0_26) AT=1860.05n

.meas tran vdout0_27ck1850 FIND v(dout0_27) AT=1860.05n

.meas tran vdout0_28ck1850 FIND v(dout0_28) AT=1860.05n

.meas tran vdout0_29ck1850 FIND v(dout0_29) AT=1860.05n

.meas tran vdout0_30ck1850 FIND v(dout0_30) AT=1860.05n

.meas tran vdout0_31ck1850 FIND v(dout0_31) AT=1860.05n

.meas tran vdout0_32ck1850 FIND v(dout0_32) AT=1860.05n

.meas tran vdout0_0ck1870 FIND v(dout0_0) AT=1880.05n

.meas tran vdout0_1ck1870 FIND v(dout0_1) AT=1880.05n

.meas tran vdout0_2ck1870 FIND v(dout0_2) AT=1880.05n

.meas tran vdout0_3ck1870 FIND v(dout0_3) AT=1880.05n

.meas tran vdout0_4ck1870 FIND v(dout0_4) AT=1880.05n

.meas tran vdout0_5ck1870 FIND v(dout0_5) AT=1880.05n

.meas tran vdout0_6ck1870 FIND v(dout0_6) AT=1880.05n

.meas tran vdout0_7ck1870 FIND v(dout0_7) AT=1880.05n

.meas tran vdout0_8ck1870 FIND v(dout0_8) AT=1880.05n

.meas tran vdout0_9ck1870 FIND v(dout0_9) AT=1880.05n

.meas tran vdout0_10ck1870 FIND v(dout0_10) AT=1880.05n

.meas tran vdout0_11ck1870 FIND v(dout0_11) AT=1880.05n

.meas tran vdout0_12ck1870 FIND v(dout0_12) AT=1880.05n

.meas tran vdout0_13ck1870 FIND v(dout0_13) AT=1880.05n

.meas tran vdout0_14ck1870 FIND v(dout0_14) AT=1880.05n

.meas tran vdout0_15ck1870 FIND v(dout0_15) AT=1880.05n

.meas tran vdout0_16ck1870 FIND v(dout0_16) AT=1880.05n

.meas tran vdout0_17ck1870 FIND v(dout0_17) AT=1880.05n

.meas tran vdout0_18ck1870 FIND v(dout0_18) AT=1880.05n

.meas tran vdout0_19ck1870 FIND v(dout0_19) AT=1880.05n

.meas tran vdout0_20ck1870 FIND v(dout0_20) AT=1880.05n

.meas tran vdout0_21ck1870 FIND v(dout0_21) AT=1880.05n

.meas tran vdout0_22ck1870 FIND v(dout0_22) AT=1880.05n

.meas tran vdout0_23ck1870 FIND v(dout0_23) AT=1880.05n

.meas tran vdout0_24ck1870 FIND v(dout0_24) AT=1880.05n

.meas tran vdout0_25ck1870 FIND v(dout0_25) AT=1880.05n

.meas tran vdout0_26ck1870 FIND v(dout0_26) AT=1880.05n

.meas tran vdout0_27ck1870 FIND v(dout0_27) AT=1880.05n

.meas tran vdout0_28ck1870 FIND v(dout0_28) AT=1880.05n

.meas tran vdout0_29ck1870 FIND v(dout0_29) AT=1880.05n

.meas tran vdout0_30ck1870 FIND v(dout0_30) AT=1880.05n

.meas tran vdout0_31ck1870 FIND v(dout0_31) AT=1880.05n

.meas tran vdout0_32ck1870 FIND v(dout0_32) AT=1880.05n

.meas tran vdout0_0ck1890 FIND v(dout0_0) AT=1900.05n

.meas tran vdout0_1ck1890 FIND v(dout0_1) AT=1900.05n

.meas tran vdout0_2ck1890 FIND v(dout0_2) AT=1900.05n

.meas tran vdout0_3ck1890 FIND v(dout0_3) AT=1900.05n

.meas tran vdout0_4ck1890 FIND v(dout0_4) AT=1900.05n

.meas tran vdout0_5ck1890 FIND v(dout0_5) AT=1900.05n

.meas tran vdout0_6ck1890 FIND v(dout0_6) AT=1900.05n

.meas tran vdout0_7ck1890 FIND v(dout0_7) AT=1900.05n

.meas tran vdout0_8ck1890 FIND v(dout0_8) AT=1900.05n

.meas tran vdout0_9ck1890 FIND v(dout0_9) AT=1900.05n

.meas tran vdout0_10ck1890 FIND v(dout0_10) AT=1900.05n

.meas tran vdout0_11ck1890 FIND v(dout0_11) AT=1900.05n

.meas tran vdout0_12ck1890 FIND v(dout0_12) AT=1900.05n

.meas tran vdout0_13ck1890 FIND v(dout0_13) AT=1900.05n

.meas tran vdout0_14ck1890 FIND v(dout0_14) AT=1900.05n

.meas tran vdout0_15ck1890 FIND v(dout0_15) AT=1900.05n

.meas tran vdout0_16ck1890 FIND v(dout0_16) AT=1900.05n

.meas tran vdout0_17ck1890 FIND v(dout0_17) AT=1900.05n

.meas tran vdout0_18ck1890 FIND v(dout0_18) AT=1900.05n

.meas tran vdout0_19ck1890 FIND v(dout0_19) AT=1900.05n

.meas tran vdout0_20ck1890 FIND v(dout0_20) AT=1900.05n

.meas tran vdout0_21ck1890 FIND v(dout0_21) AT=1900.05n

.meas tran vdout0_22ck1890 FIND v(dout0_22) AT=1900.05n

.meas tran vdout0_23ck1890 FIND v(dout0_23) AT=1900.05n

.meas tran vdout0_24ck1890 FIND v(dout0_24) AT=1900.05n

.meas tran vdout0_25ck1890 FIND v(dout0_25) AT=1900.05n

.meas tran vdout0_26ck1890 FIND v(dout0_26) AT=1900.05n

.meas tran vdout0_27ck1890 FIND v(dout0_27) AT=1900.05n

.meas tran vdout0_28ck1890 FIND v(dout0_28) AT=1900.05n

.meas tran vdout0_29ck1890 FIND v(dout0_29) AT=1900.05n

.meas tran vdout0_30ck1890 FIND v(dout0_30) AT=1900.05n

.meas tran vdout0_31ck1890 FIND v(dout0_31) AT=1900.05n

.meas tran vdout0_32ck1890 FIND v(dout0_32) AT=1900.05n

.meas tran vdout0_0ck1900 FIND v(dout0_0) AT=1910.05n

.meas tran vdout0_1ck1900 FIND v(dout0_1) AT=1910.05n

.meas tran vdout0_2ck1900 FIND v(dout0_2) AT=1910.05n

.meas tran vdout0_3ck1900 FIND v(dout0_3) AT=1910.05n

.meas tran vdout0_4ck1900 FIND v(dout0_4) AT=1910.05n

.meas tran vdout0_5ck1900 FIND v(dout0_5) AT=1910.05n

.meas tran vdout0_6ck1900 FIND v(dout0_6) AT=1910.05n

.meas tran vdout0_7ck1900 FIND v(dout0_7) AT=1910.05n

.meas tran vdout0_8ck1900 FIND v(dout0_8) AT=1910.05n

.meas tran vdout0_9ck1900 FIND v(dout0_9) AT=1910.05n

.meas tran vdout0_10ck1900 FIND v(dout0_10) AT=1910.05n

.meas tran vdout0_11ck1900 FIND v(dout0_11) AT=1910.05n

.meas tran vdout0_12ck1900 FIND v(dout0_12) AT=1910.05n

.meas tran vdout0_13ck1900 FIND v(dout0_13) AT=1910.05n

.meas tran vdout0_14ck1900 FIND v(dout0_14) AT=1910.05n

.meas tran vdout0_15ck1900 FIND v(dout0_15) AT=1910.05n

.meas tran vdout0_16ck1900 FIND v(dout0_16) AT=1910.05n

.meas tran vdout0_17ck1900 FIND v(dout0_17) AT=1910.05n

.meas tran vdout0_18ck1900 FIND v(dout0_18) AT=1910.05n

.meas tran vdout0_19ck1900 FIND v(dout0_19) AT=1910.05n

.meas tran vdout0_20ck1900 FIND v(dout0_20) AT=1910.05n

.meas tran vdout0_21ck1900 FIND v(dout0_21) AT=1910.05n

.meas tran vdout0_22ck1900 FIND v(dout0_22) AT=1910.05n

.meas tran vdout0_23ck1900 FIND v(dout0_23) AT=1910.05n

.meas tran vdout0_24ck1900 FIND v(dout0_24) AT=1910.05n

.meas tran vdout0_25ck1900 FIND v(dout0_25) AT=1910.05n

.meas tran vdout0_26ck1900 FIND v(dout0_26) AT=1910.05n

.meas tran vdout0_27ck1900 FIND v(dout0_27) AT=1910.05n

.meas tran vdout0_28ck1900 FIND v(dout0_28) AT=1910.05n

.meas tran vdout0_29ck1900 FIND v(dout0_29) AT=1910.05n

.meas tran vdout0_30ck1900 FIND v(dout0_30) AT=1910.05n

.meas tran vdout0_31ck1900 FIND v(dout0_31) AT=1910.05n

.meas tran vdout0_32ck1900 FIND v(dout0_32) AT=1910.05n

.meas tran vdout0_0ck1910 FIND v(dout0_0) AT=1920.05n

.meas tran vdout0_1ck1910 FIND v(dout0_1) AT=1920.05n

.meas tran vdout0_2ck1910 FIND v(dout0_2) AT=1920.05n

.meas tran vdout0_3ck1910 FIND v(dout0_3) AT=1920.05n

.meas tran vdout0_4ck1910 FIND v(dout0_4) AT=1920.05n

.meas tran vdout0_5ck1910 FIND v(dout0_5) AT=1920.05n

.meas tran vdout0_6ck1910 FIND v(dout0_6) AT=1920.05n

.meas tran vdout0_7ck1910 FIND v(dout0_7) AT=1920.05n

.meas tran vdout0_8ck1910 FIND v(dout0_8) AT=1920.05n

.meas tran vdout0_9ck1910 FIND v(dout0_9) AT=1920.05n

.meas tran vdout0_10ck1910 FIND v(dout0_10) AT=1920.05n

.meas tran vdout0_11ck1910 FIND v(dout0_11) AT=1920.05n

.meas tran vdout0_12ck1910 FIND v(dout0_12) AT=1920.05n

.meas tran vdout0_13ck1910 FIND v(dout0_13) AT=1920.05n

.meas tran vdout0_14ck1910 FIND v(dout0_14) AT=1920.05n

.meas tran vdout0_15ck1910 FIND v(dout0_15) AT=1920.05n

.meas tran vdout0_16ck1910 FIND v(dout0_16) AT=1920.05n

.meas tran vdout0_17ck1910 FIND v(dout0_17) AT=1920.05n

.meas tran vdout0_18ck1910 FIND v(dout0_18) AT=1920.05n

.meas tran vdout0_19ck1910 FIND v(dout0_19) AT=1920.05n

.meas tran vdout0_20ck1910 FIND v(dout0_20) AT=1920.05n

.meas tran vdout0_21ck1910 FIND v(dout0_21) AT=1920.05n

.meas tran vdout0_22ck1910 FIND v(dout0_22) AT=1920.05n

.meas tran vdout0_23ck1910 FIND v(dout0_23) AT=1920.05n

.meas tran vdout0_24ck1910 FIND v(dout0_24) AT=1920.05n

.meas tran vdout0_25ck1910 FIND v(dout0_25) AT=1920.05n

.meas tran vdout0_26ck1910 FIND v(dout0_26) AT=1920.05n

.meas tran vdout0_27ck1910 FIND v(dout0_27) AT=1920.05n

.meas tran vdout0_28ck1910 FIND v(dout0_28) AT=1920.05n

.meas tran vdout0_29ck1910 FIND v(dout0_29) AT=1920.05n

.meas tran vdout0_30ck1910 FIND v(dout0_30) AT=1920.05n

.meas tran vdout0_31ck1910 FIND v(dout0_31) AT=1920.05n

.meas tran vdout0_32ck1910 FIND v(dout0_32) AT=1920.05n

.meas tran vdout0_0ck1920 FIND v(dout0_0) AT=1930.05n

.meas tran vdout0_1ck1920 FIND v(dout0_1) AT=1930.05n

.meas tran vdout0_2ck1920 FIND v(dout0_2) AT=1930.05n

.meas tran vdout0_3ck1920 FIND v(dout0_3) AT=1930.05n

.meas tran vdout0_4ck1920 FIND v(dout0_4) AT=1930.05n

.meas tran vdout0_5ck1920 FIND v(dout0_5) AT=1930.05n

.meas tran vdout0_6ck1920 FIND v(dout0_6) AT=1930.05n

.meas tran vdout0_7ck1920 FIND v(dout0_7) AT=1930.05n

.meas tran vdout0_8ck1920 FIND v(dout0_8) AT=1930.05n

.meas tran vdout0_9ck1920 FIND v(dout0_9) AT=1930.05n

.meas tran vdout0_10ck1920 FIND v(dout0_10) AT=1930.05n

.meas tran vdout0_11ck1920 FIND v(dout0_11) AT=1930.05n

.meas tran vdout0_12ck1920 FIND v(dout0_12) AT=1930.05n

.meas tran vdout0_13ck1920 FIND v(dout0_13) AT=1930.05n

.meas tran vdout0_14ck1920 FIND v(dout0_14) AT=1930.05n

.meas tran vdout0_15ck1920 FIND v(dout0_15) AT=1930.05n

.meas tran vdout0_16ck1920 FIND v(dout0_16) AT=1930.05n

.meas tran vdout0_17ck1920 FIND v(dout0_17) AT=1930.05n

.meas tran vdout0_18ck1920 FIND v(dout0_18) AT=1930.05n

.meas tran vdout0_19ck1920 FIND v(dout0_19) AT=1930.05n

.meas tran vdout0_20ck1920 FIND v(dout0_20) AT=1930.05n

.meas tran vdout0_21ck1920 FIND v(dout0_21) AT=1930.05n

.meas tran vdout0_22ck1920 FIND v(dout0_22) AT=1930.05n

.meas tran vdout0_23ck1920 FIND v(dout0_23) AT=1930.05n

.meas tran vdout0_24ck1920 FIND v(dout0_24) AT=1930.05n

.meas tran vdout0_25ck1920 FIND v(dout0_25) AT=1930.05n

.meas tran vdout0_26ck1920 FIND v(dout0_26) AT=1930.05n

.meas tran vdout0_27ck1920 FIND v(dout0_27) AT=1930.05n

.meas tran vdout0_28ck1920 FIND v(dout0_28) AT=1930.05n

.meas tran vdout0_29ck1920 FIND v(dout0_29) AT=1930.05n

.meas tran vdout0_30ck1920 FIND v(dout0_30) AT=1930.05n

.meas tran vdout0_31ck1920 FIND v(dout0_31) AT=1930.05n

.meas tran vdout0_32ck1920 FIND v(dout0_32) AT=1930.05n
